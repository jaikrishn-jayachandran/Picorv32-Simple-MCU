* NGSPICE file created from peripherals_macro.ext - technology: ihp-sg13g2

* Black-box entry subcircuit for sg13g2_decap_8 abstract view
.subckt sg13g2_decap_8 VDD VSS
.ends

* Black-box entry subcircuit for sg13g2_dlygate4sd3_1 abstract view
.subckt sg13g2_dlygate4sd3_1 X A VDD VSS
.ends

* Black-box entry subcircuit for sg13g2_o21ai_1 abstract view
.subckt sg13g2_o21ai_1 Y A1 A2 B1 VDD VSS
.ends

* Black-box entry subcircuit for sg13g2_fill_2 abstract view
.subckt sg13g2_fill_2 VDD VSS
.ends

* Black-box entry subcircuit for sg13g2_nand4_1 abstract view
.subckt sg13g2_nand4_1 Y A B C D VDD VSS
.ends

* Black-box entry subcircuit for sg13g2_nor2_1 abstract view
.subckt sg13g2_nor2_1 Y A B VDD VSS
.ends

* Black-box entry subcircuit for sg13g2_fill_1 abstract view
.subckt sg13g2_fill_1 VDD VSS
.ends

* Black-box entry subcircuit for sg13g2_a21oi_1 abstract view
.subckt sg13g2_a21oi_1 Y A1 A2 B1 VDD VSS
.ends

* Black-box entry subcircuit for sg13g2_dfrbpq_1 abstract view
.subckt sg13g2_dfrbpq_1 Q CLK D RESET_B VDD VSS
.ends

* Black-box entry subcircuit for sg13g2_decap_4 abstract view
.subckt sg13g2_decap_4 VDD VSS
.ends

* Black-box entry subcircuit for sg13g2_a22oi_1 abstract view
.subckt sg13g2_a22oi_1 Y A1 A2 B1 B2 VDD VSS
.ends

* Black-box entry subcircuit for sg13g2_tiehi abstract view
.subckt sg13g2_tiehi L_HI VDD VSS
.ends

* Black-box entry subcircuit for sg13g2_buf_1 abstract view
.subckt sg13g2_buf_1 X A VDD VSS
.ends

* Black-box entry subcircuit for sg13g2_buf_8 abstract view
.subckt sg13g2_buf_8 X A VDD VSS
.ends

* Black-box entry subcircuit for sg13g2_nor3_1 abstract view
.subckt sg13g2_nor3_1 Y A B C VDD VSS
.ends

* Black-box entry subcircuit for sg13g2_nor2b_1 abstract view
.subckt sg13g2_nor2b_1 Y A B_N VDD VSS
.ends

* Black-box entry subcircuit for sg13g2_and3_1 abstract view
.subckt sg13g2_and3_1 X A B C VDD VSS
.ends

* Black-box entry subcircuit for sg13g2_inv_1 abstract view
.subckt sg13g2_inv_1 Y A VDD VSS
.ends

* Black-box entry subcircuit for sg13g2_nand2_1 abstract view
.subckt sg13g2_nand2_1 Y A B VDD VSS
.ends

* Black-box entry subcircuit for sg13g2_a21o_1 abstract view
.subckt sg13g2_a21o_1 X A1 A2 B1 VDD VSS
.ends

* Black-box entry subcircuit for sg13g2_nand3_1 abstract view
.subckt sg13g2_nand3_1 Y A B C VDD VSS
.ends

* Black-box entry subcircuit for sg13g2_and2_1 abstract view
.subckt sg13g2_and2_1 X A B VDD VSS
.ends

* Black-box entry subcircuit for sg13g2_nand2b_1 abstract view
.subckt sg13g2_nand2b_1 Y A_N B VDD VSS
.ends

* Black-box entry subcircuit for sg13g2_buf_16 abstract view
.subckt sg13g2_buf_16 X A VDD VSS
.ends

* Black-box entry subcircuit for sg13g2_tielo abstract view
.subckt sg13g2_tielo L_LO VDD VSS
.ends

* Black-box entry subcircuit for sg13g2_nand3b_1 abstract view
.subckt sg13g2_nand3b_1 Y A_N B C VDD VSS
.ends

.subckt peripherals_macro VDD VSS clk_i gpio_dir[0] gpio_dir[10] gpio_dir[11] gpio_dir[12]
+ gpio_dir[13] gpio_dir[14] gpio_dir[15] gpio_dir[16] gpio_dir[17] gpio_dir[18] gpio_dir[19]
+ gpio_dir[1] gpio_dir[20] gpio_dir[21] gpio_dir[22] gpio_dir[23] gpio_dir[24] gpio_dir[25]
+ gpio_dir[26] gpio_dir[27] gpio_dir[28] gpio_dir[29] gpio_dir[2] gpio_dir[30] gpio_dir[31]
+ gpio_dir[3] gpio_dir[4] gpio_dir[5] gpio_dir[6] gpio_dir[7] gpio_dir[8] gpio_dir[9]
+ gpio_in[0] gpio_in[10] gpio_in[11] gpio_in[12] gpio_in[13] gpio_in[14] gpio_in[15]
+ gpio_in[16] gpio_in[17] gpio_in[18] gpio_in[19] gpio_in[1] gpio_in[20] gpio_in[21]
+ gpio_in[22] gpio_in[23] gpio_in[24] gpio_in[25] gpio_in[26] gpio_in[27] gpio_in[28]
+ gpio_in[29] gpio_in[2] gpio_in[30] gpio_in[31] gpio_in[3] gpio_in[4] gpio_in[5]
+ gpio_in[6] gpio_in[7] gpio_in[8] gpio_in[9] gpio_out[0] gpio_out[10] gpio_out[11]
+ gpio_out[12] gpio_out[13] gpio_out[14] gpio_out[15] gpio_out[16] gpio_out[17] gpio_out[18]
+ gpio_out[19] gpio_out[1] gpio_out[20] gpio_out[21] gpio_out[22] gpio_out[23] gpio_out[24]
+ gpio_out[25] gpio_out[26] gpio_out[27] gpio_out[28] gpio_out[29] gpio_out[2] gpio_out[30]
+ gpio_out[31] gpio_out[3] gpio_out[4] gpio_out[5] gpio_out[6] gpio_out[7] gpio_out[8]
+ gpio_out[9] rst_ni s_axil_araddr[0] s_axil_araddr[10] s_axil_araddr[11] s_axil_araddr[12]
+ s_axil_araddr[13] s_axil_araddr[14] s_axil_araddr[15] s_axil_araddr[16] s_axil_araddr[17]
+ s_axil_araddr[18] s_axil_araddr[19] s_axil_araddr[1] s_axil_araddr[20] s_axil_araddr[21]
+ s_axil_araddr[22] s_axil_araddr[23] s_axil_araddr[24] s_axil_araddr[25] s_axil_araddr[26]
+ s_axil_araddr[27] s_axil_araddr[28] s_axil_araddr[29] s_axil_araddr[2] s_axil_araddr[30]
+ s_axil_araddr[31] s_axil_araddr[3] s_axil_araddr[4] s_axil_araddr[5] s_axil_araddr[6]
+ s_axil_araddr[7] s_axil_araddr[8] s_axil_araddr[9] s_axil_arready s_axil_arvalid
+ s_axil_awaddr[0] s_axil_awaddr[10] s_axil_awaddr[11] s_axil_awaddr[12] s_axil_awaddr[13]
+ s_axil_awaddr[14] s_axil_awaddr[15] s_axil_awaddr[16] s_axil_awaddr[17] s_axil_awaddr[18]
+ s_axil_awaddr[19] s_axil_awaddr[1] s_axil_awaddr[20] s_axil_awaddr[21] s_axil_awaddr[22]
+ s_axil_awaddr[23] s_axil_awaddr[24] s_axil_awaddr[25] s_axil_awaddr[26] s_axil_awaddr[27]
+ s_axil_awaddr[28] s_axil_awaddr[29] s_axil_awaddr[2] s_axil_awaddr[30] s_axil_awaddr[31]
+ s_axil_awaddr[3] s_axil_awaddr[4] s_axil_awaddr[5] s_axil_awaddr[6] s_axil_awaddr[7]
+ s_axil_awaddr[8] s_axil_awaddr[9] s_axil_awready s_axil_awvalid s_axil_bready s_axil_bresp[0]
+ s_axil_bresp[1] s_axil_bvalid s_axil_rdata[0] s_axil_rdata[10] s_axil_rdata[11]
+ s_axil_rdata[12] s_axil_rdata[13] s_axil_rdata[14] s_axil_rdata[15] s_axil_rdata[16]
+ s_axil_rdata[17] s_axil_rdata[18] s_axil_rdata[19] s_axil_rdata[1] s_axil_rdata[20]
+ s_axil_rdata[21] s_axil_rdata[22] s_axil_rdata[23] s_axil_rdata[24] s_axil_rdata[25]
+ s_axil_rdata[26] s_axil_rdata[27] s_axil_rdata[28] s_axil_rdata[29] s_axil_rdata[2]
+ s_axil_rdata[30] s_axil_rdata[31] s_axil_rdata[3] s_axil_rdata[4] s_axil_rdata[5]
+ s_axil_rdata[6] s_axil_rdata[7] s_axil_rdata[8] s_axil_rdata[9] s_axil_rready s_axil_rresp[0]
+ s_axil_rresp[1] s_axil_rvalid s_axil_wdata[0] s_axil_wdata[10] s_axil_wdata[11]
+ s_axil_wdata[12] s_axil_wdata[13] s_axil_wdata[14] s_axil_wdata[15] s_axil_wdata[16]
+ s_axil_wdata[17] s_axil_wdata[18] s_axil_wdata[19] s_axil_wdata[1] s_axil_wdata[20]
+ s_axil_wdata[21] s_axil_wdata[22] s_axil_wdata[23] s_axil_wdata[24] s_axil_wdata[25]
+ s_axil_wdata[26] s_axil_wdata[27] s_axil_wdata[28] s_axil_wdata[29] s_axil_wdata[2]
+ s_axil_wdata[30] s_axil_wdata[31] s_axil_wdata[3] s_axil_wdata[4] s_axil_wdata[5]
+ s_axil_wdata[6] s_axil_wdata[7] s_axil_wdata[8] s_axil_wdata[9] s_axil_wready s_axil_wstrb[0]
+ s_axil_wstrb[1] s_axil_wstrb[2] s_axil_wstrb[3] s_axil_wvalid
XFILLER_39_277 VDD VSS sg13g2_decap_8
XFILLER_22_133 VDD VSS sg13g2_decap_8
XFILLER_7_7 VDD VSS sg13g2_decap_8
Xhold384 _1077_/D _0904_/Y VDD VSS sg13g2_dlygate4sd3_1
Xhold395 hold395/X _0926_/Y VDD VSS sg13g2_dlygate4sd3_1
XFILLER_9_115 VDD VSS sg13g2_decap_8
XFILLER_5_332 VDD VSS sg13g2_decap_8
X_0985_ _0986_/B _0985_/A1 hold424/X _0985_/B1 VDD VSS sg13g2_o21ai_1
XFILLER_10_125 VDD VSS sg13g2_fill_2
XFILLER_10_158 VDD VSS sg13g2_decap_8
XFILLER_12_21 VDD VSS sg13g2_decap_8
XFILLER_33_228 VDD VSS sg13g2_fill_2
X_0770_ _0770_/Y _0902_/A _0910_/B _0798_/C _0914_/D VDD VSS sg13g2_nand4_1
XFILLER_5_184 VDD VSS sg13g2_decap_8
XFILLER_24_206 VDD VSS sg13g2_fill_2
X_0968_ _0968_/Y _0968_/A _0988_/B _0992_/C _0984_/D VDD VSS sg13g2_nand4_1
X_0899_ _1076_/D _0899_/A _0899_/B VDD VSS sg13g2_nor2_1
XFILLER_23_42 VDD VSS sg13g2_decap_8
XFILLER_38_309 VDD VSS sg13g2_decap_8
XFILLER_0_46 VDD VSS sg13g2_decap_8
XFILLER_14_250 VDD VSS sg13g2_fill_1
X_0822_ _0825_/A _0958_/A1 _0801_/Y _1058_/Q VDD VSS sg13g2_a21oi_1
XFILLER_9_77 VDD VSS sg13g2_decap_8
X_0753_ _0753_/Y _0885_/A _0897_/B _0867_/B _0897_/D VDD VSS sg13g2_nand4_1
X_0684_ _0684_/Y _1023_/Q _0593_/B _0704_/B1 VDD VSS sg13g2_o21ai_1
XFILLER_29_0 VDD VSS sg13g2_decap_8
XFILLER_37_331 VDD VSS sg13g2_decap_8
XFILLER_37_320 VDD VSS sg13g2_fill_2
X_1098_ _1098_/Q _1100_/CLK _1098_/D _1098_/RESET_B VDD VSS sg13g2_dfrbpq_1
XFILLER_20_231 VDD VSS sg13g2_decap_8
XFILLER_18_42 VDD VSS sg13g2_decap_8
XFILLER_43_334 VDD VSS sg13g2_fill_1
XFILLER_11_264 VDD VSS sg13g2_decap_8
XFILLER_34_63 VDD VSS sg13g2_decap_8
XFILLER_7_202 VDD VSS sg13g2_decap_4
XFILLER_22_7 VDD VSS sg13g2_decap_8
XFILLER_38_117 VDD VSS sg13g2_fill_1
XFILLER_38_106 VDD VSS sg13g2_decap_8
XFILLER_34_301 VDD VSS sg13g2_decap_8
X_1021_ _1021_/Q _1070_/CLK _1021_/D _1021_/RESET_B VDD VSS sg13g2_dfrbpq_1
X_0805_ _1053_/D _0805_/A _0805_/B VDD VSS sg13g2_nor2_1
X_0736_ _0739_/A _0942_/A1 _0735_/Y _1037_/Q VDD VSS sg13g2_a21oi_1
X_0667_ _0667_/Y _1046_/Q _0695_/A2 _0699_/B1 input9/X VDD VSS sg13g2_a22oi_1
X_0598_ _0598_/Y input1/X _0647_/B1 _0654_/B1 VDD VSS sg13g2_a21oi_1
XFILLER_37_150 VDD VSS sg13g2_decap_8
XFILLER_20_21 VDD VSS sg13g2_decap_8
XFILLER_20_32 VDD VSS sg13g2_fill_2
XFILLER_28_194 VDD VSS sg13g2_fill_1
XFILLER_6_56 VDD VSS sg13g2_decap_8
XFILLER_3_282 VDD VSS sg13g2_fill_2
XFILLER_34_175 VDD VSS sg13g2_fill_2
X_1004_ _1004_/Q clkload6/A _1004_/D _1004_/RESET_B VDD VSS sg13g2_dfrbpq_1
X_1029__295 _1029_/RESET_B VDD VSS sg13g2_tiehi
X_0719_ _0719_/Y _1043_/Q _0723_/A2 _0723_/B1 input24/X VDD VSS sg13g2_a22oi_1
XFILLER_15_21 VDD VSS sg13g2_decap_8
XFILLER_25_164 VDD VSS sg13g2_decap_8
XFILLER_13_326 VDD VSS sg13g2_decap_8
XFILLER_15_98 VDD VSS sg13g2_fill_1
XFILLER_31_42 VDD VSS sg13g2_decap_4
XFILLER_40_178 VDD VSS sg13g2_decap_8
XFILLER_40_134 VDD VSS sg13g2_decap_8
Xoutput97 gpio_dir[27] _1072_/Q VDD VSS sg13g2_buf_1
Xoutput86 gpio_dir[17] _1078_/Q VDD VSS sg13g2_buf_1
X_1054__344 _1054_/RESET_B VDD VSS sg13g2_tiehi
XFILLER_16_142 VDD VSS sg13g2_decap_4
XFILLER_31_101 VDD VSS sg13g2_decap_8
XFILLER_8_330 VDD VSS sg13g2_decap_8
XFILLER_11_0 VDD VSS sg13g2_decap_8
Xclkbuf_4_12_0_clk_i _1070_/CLK clkbuf_0_clk_i/X VDD VSS sg13g2_buf_8
XFILLER_39_245 VDD VSS sg13g2_decap_8
XFILLER_10_329 VDD VSS sg13g2_decap_8
Xhold385 input49/A s_axil_wdata[17] VDD VSS sg13g2_dlygate4sd3_1
Xhold396 _1083_/D _0928_/Y VDD VSS sg13g2_dlygate4sd3_1
XFILLER_13_156 VDD VSS sg13g2_fill_2
XFILLER_26_42 VDD VSS sg13g2_fill_2
XFILLER_13_189 VDD VSS sg13g2_decap_8
XFILLER_9_127 VDD VSS sg13g2_fill_1
XFILLER_42_63 VDD VSS sg13g2_decap_4
XFILLER_3_35 VDD VSS sg13g2_decap_8
XFILLER_36_215 VDD VSS sg13g2_decap_8
X_0984_ _0984_/Y _0984_/A _0984_/B _0984_/C _0984_/D VDD VSS sg13g2_nand4_1
XFILLER_8_193 VDD VSS sg13g2_fill_1
XFILLER_42_229 VDD VSS sg13g2_fill_1
XFILLER_35_292 VDD VSS sg13g2_fill_2
XFILLER_10_104 VDD VSS sg13g2_decap_8
XFILLER_6_119 VDD VSS sg13g2_decap_8
XFILLER_33_207 VDD VSS sg13g2_decap_8
XFILLER_37_96 VDD VSS sg13g2_fill_1
XFILLER_41_284 VDD VSS sg13g2_fill_1
XFILLER_5_163 VDD VSS sg13g2_decap_8
XFILLER_32_251 VDD VSS sg13g2_decap_8
X_0967_ _0970_/A _0987_/A1 _0966_/Y _1093_/Q VDD VSS sg13g2_a21oi_1
X_0898_ _0899_/B _0898_/A1 _0897_/Y _0898_/B1 VDD VSS sg13g2_o21ai_1
XFILLER_15_218 VDD VSS sg13g2_decap_8
XFILLER_15_229 VDD VSS sg13g2_fill_1
XFILLER_23_21 VDD VSS sg13g2_decap_8
XFILLER_23_251 VDD VSS sg13g2_fill_1
XFILLER_23_284 VDD VSS sg13g2_decap_8
X_1011__331 _1011_/RESET_B VDD VSS sg13g2_tiehi
XFILLER_0_14 VDD VSS sg13g2_decap_8
X_0821_ _1057_/D _0821_/A _0821_/B VDD VSS sg13g2_nor2_1
X_0752_ _0755_/A _0942_/A1 _0735_/Y _1041_/Q VDD VSS sg13g2_a21oi_1
XFILLER_9_89 VDD VSS sg13g2_decap_8
X_0683_ _0683_/Y _1050_/Q _0695_/A2 _0699_/B1 input14/X VDD VSS sg13g2_a22oi_1
XFILLER_37_310 VDD VSS sg13g2_fill_1
X_1097_ _1097_/Q _1097_/CLK _1097_/D _1097_/RESET_B VDD VSS sg13g2_dfrbpq_1
XFILLER_20_287 VDD VSS sg13g2_decap_8
XFILLER_18_21 VDD VSS sg13g2_decap_8
XFILLER_11_210 VDD VSS sg13g2_fill_1
XFILLER_11_243 VDD VSS sg13g2_decap_8
XFILLER_34_42 VDD VSS sg13g2_decap_8
XFILLER_7_214 VDD VSS sg13g2_fill_2
XFILLER_15_7 VDD VSS sg13g2_decap_8
X_1020_ _1020_/Q clkload9/A _1020_/D _1020_/RESET_B VDD VSS sg13g2_dfrbpq_1
XFILLER_34_335 VDD VSS sg13g2_decap_4
X_0804_ _0805_/B _0940_/A1 _0803_/Y _0985_/B1 VDD VSS sg13g2_o21ai_1
X_0735_ _0735_/Y _0966_/A _0897_/C _0867_/C VDD VSS sg13g2_nor3_1
X_0666_ _0666_/Y _1078_/Q _0702_/A2 _0702_/B1 VDD VSS sg13g2_a21oi_1
X_0597_ _0597_/Y _0597_/A _0596_/A VDD VSS sg13g2_nor2b_1
XFILLER_41_0 VDD VSS sg13g2_decap_8
XFILLER_25_346 VDD VSS sg13g2_fill_1
XFILLER_20_88 VDD VSS sg13g2_decap_8
XFILLER_4_239 VDD VSS sg13g2_fill_2
XFILLER_29_75 VDD VSS sg13g2_decap_8
XFILLER_29_86 VDD VSS sg13g2_fill_1
XFILLER_16_346 VDD VSS sg13g2_fill_1
XFILLER_28_173 VDD VSS sg13g2_fill_2
XFILLER_6_35 VDD VSS sg13g2_decap_8
XFILLER_3_261 VDD VSS sg13g2_fill_2
XFILLER_19_173 VDD VSS sg13g2_decap_8
X_1003_ _1003_/Q clkload6/A _1003_/D _1003_/RESET_B VDD VSS sg13g2_dfrbpq_1
XFILLER_22_338 VDD VSS sg13g2_fill_1
X_0718_ _0718_/Y _1075_/Q _0722_/A2 _0722_/B1 VDD VSS sg13g2_a21oi_1
X_0649_ _1014_/D _0646_/Y _0647_/Y _0648_/Y VDD VSS sg13g2_a21oi_1
XFILLER_13_305 VDD VSS sg13g2_decap_8
XFILLER_25_132 VDD VSS sg13g2_decap_4
XFILLER_31_21 VDD VSS sg13g2_decap_8
Xoutput98 gpio_dir[28] _1073_/Q VDD VSS sg13g2_buf_1
Xoutput87 gpio_dir[18] _1079_/Q VDD VSS sg13g2_buf_1
XFILLER_16_110 VDD VSS sg13g2_decap_8
XFILLER_16_187 VDD VSS sg13g2_fill_2
XFILLER_31_179 VDD VSS sg13g2_decap_8
X_1061__316 _1061_/RESET_B VDD VSS sg13g2_tiehi
X_1098__294 _1098_/RESET_B VDD VSS sg13g2_tiehi
XFILLER_39_224 VDD VSS sg13g2_decap_8
XFILLER_22_102 VDD VSS sg13g2_decap_8
XFILLER_10_308 VDD VSS sg13g2_decap_8
XFILLER_22_168 VDD VSS sg13g2_decap_8
Xhold386 _1078_/D _0908_/Y VDD VSS sg13g2_dlygate4sd3_1
Xhold397 input53/A s_axil_wdata[20] VDD VSS sg13g2_dlygate4sd3_1
XFILLER_26_21 VDD VSS sg13g2_decap_8
XFILLER_26_76 VDD VSS sg13g2_fill_2
XFILLER_42_42 VDD VSS sg13g2_decap_8
X_1021__311 _1021_/RESET_B VDD VSS sg13g2_tiehi
XFILLER_3_14 VDD VSS sg13g2_decap_8
X_0983_ _0986_/A _0983_/A1 _0966_/Y _1097_/Q VDD VSS sg13g2_a21oi_1
XFILLER_27_216 VDD VSS sg13g2_decap_8
XFILLER_27_238 VDD VSS sg13g2_decap_8
XFILLER_27_249 VDD VSS sg13g2_fill_1
XFILLER_35_271 VDD VSS sg13g2_decap_8
XFILLER_18_216 VDD VSS sg13g2_fill_2
XFILLER_41_252 VDD VSS sg13g2_fill_1
XFILLER_24_219 VDD VSS sg13g2_decap_8
XFILLER_32_230 VDD VSS sg13g2_decap_8
XFILLER_32_296 VDD VSS sg13g2_fill_1
X_0966_ _0966_/Y _0966_/A _0966_/B _0966_/C VDD VSS sg13g2_nor3_1
X_0897_ _0897_/Y _0897_/A _0897_/B _0897_/C _0897_/D VDD VSS sg13g2_nand4_1
XFILLER_23_230 VDD VSS sg13g2_decap_8
XFILLER_23_274 VDD VSS sg13g2_decap_4
XFILLER_23_88 VDD VSS sg13g2_decap_8
XFILLER_14_274 VDD VSS sg13g2_fill_2
XFILLER_9_35 VDD VSS sg13g2_decap_4
XFILLER_14_296 VDD VSS sg13g2_decap_8
X_0820_ _0821_/B _0985_/A1 _0819_/Y _0960_/B1 VDD VSS sg13g2_o21ai_1
X_0751_ _1040_/D _0751_/A _0751_/B VDD VSS sg13g2_nor2_1
X_1097__326 _1097_/RESET_B VDD VSS sg13g2_tiehi
X_0682_ _0682_/Y _1082_/Q _0702_/A2 _0702_/B1 VDD VSS sg13g2_a21oi_1
X_1096_ _1096_/Q clkload1/A _1096_/D _1096_/RESET_B VDD VSS sg13g2_dfrbpq_1
XFILLER_20_255 VDD VSS sg13g2_fill_2
X_1080__330 _1080_/RESET_B VDD VSS sg13g2_tiehi
X_0949_ _1088_/D _0949_/A _0949_/B VDD VSS sg13g2_nor2_1
XFILLER_28_300 VDD VSS sg13g2_decap_8
XFILLER_34_21 VDD VSS sg13g2_decap_8
XFILLER_43_325 VDD VSS sg13g2_decap_8
XFILLER_34_98 VDD VSS sg13g2_fill_2
XFILLER_1_0 VDD VSS sg13g2_decap_8
X_1057__332 _1057_/RESET_B VDD VSS sg13g2_tiehi
XFILLER_34_314 VDD VSS sg13g2_fill_1
X_0803_ _0803_/Y _0935_/A _0939_/B _0933_/B _0943_/D VDD VSS sg13g2_nand4_1
X_0734_ _1036_/D _0734_/A _1000_/C _1000_/B VDD VSS sg13g2_and3_1
X_0665_ _1018_/D _0662_/Y _0663_/Y _0664_/Y VDD VSS sg13g2_a21oi_1
XFILLER_29_108 VDD VSS sg13g2_fill_1
XFILLER_34_0 VDD VSS sg13g2_decap_8
X_0596_ _0596_/Y _0596_/A _0597_/A VDD VSS sg13g2_nor2b_1
XFILLER_1_80 VDD VSS sg13g2_decap_4
X_1079_ _1079_/Q _1083_/CLK _1079_/D _1079_/RESET_B VDD VSS sg13g2_dfrbpq_1
XFILLER_40_317 VDD VSS sg13g2_fill_1
XFILLER_28_141 VDD VSS sg13g2_decap_8
XFILLER_29_21 VDD VSS sg13g2_decap_8
XFILLER_28_185 VDD VSS sg13g2_decap_8
XFILLER_31_306 VDD VSS sg13g2_fill_1
XFILLER_6_14 VDD VSS sg13g2_decap_8
XFILLER_19_163 VDD VSS sg13g2_decap_4
XFILLER_22_306 VDD VSS sg13g2_fill_2
X_1002_ _1002_/Q clkload6/A _1002_/D _1002_/RESET_B VDD VSS sg13g2_dfrbpq_1
X_0717_ _1031_/D _0714_/Y _0715_/Y _0716_/Y VDD VSS sg13g2_a21oi_1
X_0648_ _0648_/Y _1014_/Q _0656_/A2 _0648_/B1 VDD VSS sg13g2_o21ai_1
X_0579_ _0881_/A _0579_/A VDD VSS sg13g2_inv_1
XFILLER_15_67 VDD VSS sg13g2_decap_8
XFILLER_15_89 VDD VSS sg13g2_decap_8
XFILLER_25_111 VDD VSS sg13g2_decap_8
X_1008__337 _1008_/RESET_B VDD VSS sg13g2_tiehi
Xoutput99 gpio_dir[29] _1074_/Q VDD VSS sg13g2_buf_1
Xoutput88 gpio_dir[19] _1080_/Q VDD VSS sg13g2_buf_1
XFILLER_16_166 VDD VSS sg13g2_decap_8
XFILLER_31_158 VDD VSS sg13g2_decap_8
XFILLER_22_147 VDD VSS sg13g2_decap_8
Xhold387 input51/A s_axil_wdata[19] VDD VSS sg13g2_dlygate4sd3_1
Xhold398 hold398/X _0918_/Y VDD VSS sg13g2_dlygate4sd3_1
Xclkbuf_4_6_0_clk_i clkload3/A clkbuf_0_clk_i/X VDD VSS sg13g2_buf_8
XFILLER_42_21 VDD VSS sg13g2_decap_8
XFILLER_21_191 VDD VSS sg13g2_fill_2
XFILLER_5_346 VDD VSS sg13g2_fill_1
X_0982_ _1096_/D _0982_/A _0982_/B VDD VSS sg13g2_nor2_1
XFILLER_35_294 VDD VSS sg13g2_fill_1
XFILLER_12_35 VDD VSS sg13g2_decap_4
X_1044__367 _1044_/RESET_B VDD VSS sg13g2_tiehi
XFILLER_5_7 VDD VSS sg13g2_decap_8
XFILLER_37_21 VDD VSS sg13g2_decap_8
XFILLER_41_297 VDD VSS sg13g2_decap_8
XFILLER_5_198 VDD VSS sg13g2_decap_8
XFILLER_5_143 VDD VSS sg13g2_decap_8
XFILLER_38_7 VDD VSS sg13g2_decap_8
XFILLER_17_250 VDD VSS sg13g2_fill_1
X_0965_ _1092_/D _0965_/A _0965_/B VDD VSS sg13g2_nor2_1
X_0896_ _0899_/A _0896_/A1 _0867_/Y _1076_/Q VDD VSS sg13g2_a21oi_1
XFILLER_23_56 VDD VSS sg13g2_decap_8
XFILLER_23_67 VDD VSS sg13g2_fill_2
XFILLER_2_146 VDD VSS sg13g2_fill_2
XFILLER_14_220 VDD VSS sg13g2_decap_8
XFILLER_9_14 VDD VSS sg13g2_decap_8
X_0750_ _0751_/B _0890_/A1 _0749_/Y _0878_/B1 VDD VSS sg13g2_o21ai_1
X_0681_ _1022_/D _0678_/Y _0679_/Y _0680_/Y VDD VSS sg13g2_a21oi_1
X_1095_ _1095_/Q _1100_/CLK _1095_/D _1095_/RESET_B VDD VSS sg13g2_dfrbpq_1
XFILLER_20_245 VDD VSS sg13g2_decap_4
X_0948_ _0949_/B _0985_/A1 _0947_/Y _0960_/B1 VDD VSS sg13g2_o21ai_1
X_0879_ _1071_/D _0879_/A _0879_/B VDD VSS sg13g2_nor2_1
XFILLER_28_334 VDD VSS sg13g2_decap_4
XFILLER_34_77 VDD VSS sg13g2_decap_8
XFILLER_43_304 VDD VSS sg13g2_decap_8
XFILLER_7_216 VDD VSS sg13g2_fill_1
X_1018__317 _1018_/RESET_B VDD VSS sg13g2_tiehi
XFILLER_19_345 VDD VSS sg13g2_fill_2
X_1064__304 _1064_/RESET_B VDD VSS sg13g2_tiehi
X_0802_ _0805_/A _0958_/A1 _0801_/Y _1053_/Q VDD VSS sg13g2_a21oi_1
X_0733_ _1000_/C _1036_/Q _0733_/B VDD VSS sg13g2_nand2_1
X_0664_ _0664_/Y _1018_/Q _0593_/B _0704_/B1 VDD VSS sg13g2_o21ai_1
XFILLER_27_0 VDD VSS sg13g2_decap_8
X_0595_ _0595_/Y _0596_/A _0597_/A VDD VSS sg13g2_nor2_1
X_1078_ _1078_/Q _1083_/CLK _1078_/D _1078_/RESET_B VDD VSS sg13g2_dfrbpq_1
XFILLER_37_164 VDD VSS sg13g2_fill_2
XFILLER_16_337 VDD VSS sg13g2_decap_8
XFILLER_28_153 VDD VSS sg13g2_fill_2
XFILLER_28_175 VDD VSS sg13g2_fill_1
XFILLER_10_90 VDD VSS sg13g2_decap_8
XFILLER_20_7 VDD VSS sg13g2_decap_8
XFILLER_34_134 VDD VSS sg13g2_decap_8
X_1001_ _1001_/Q clkload8/A _1001_/D _1001_/RESET_B VDD VSS sg13g2_dfrbpq_1
X_0716_ _0716_/Y _1031_/Q _0724_/A2 _0724_/B1 VDD VSS sg13g2_o21ai_1
X_0647_ _0647_/Y _1057_/Q _0647_/A2 _0647_/B1 input4/X VDD VSS sg13g2_a22oi_1
X_0578_ _0885_/A _0578_/A VDD VSS sg13g2_inv_1
XFILLER_15_35 VDD VSS sg13g2_decap_8
XFILLER_25_178 VDD VSS sg13g2_fill_1
XFILLER_40_159 VDD VSS sg13g2_decap_8
Xclkbuf_4_2_0_clk_i _1097_/CLK clkbuf_0_clk_i/X VDD VSS sg13g2_buf_8
Xoutput89 gpio_dir[1] _1094_/Q VDD VSS sg13g2_buf_1
Xoutput78 gpio_dir[0] _1093_/Q VDD VSS sg13g2_buf_1
XFILLER_16_189 VDD VSS sg13g2_fill_1
XFILLER_31_115 VDD VSS sg13g2_decap_8
XFILLER_31_137 VDD VSS sg13g2_decap_8
XFILLER_8_344 VDD VSS sg13g2_fill_2
XFILLER_39_259 VDD VSS sg13g2_fill_1
XFILLER_22_126 VDD VSS sg13g2_decap_8
XFILLER_30_181 VDD VSS sg13g2_decap_8
XFILLER_7_91 VDD VSS sg13g2_decap_8
XFILLER_7_80 VDD VSS sg13g2_fill_2
Xhold388 _1080_/D _0916_/Y VDD VSS sg13g2_dlygate4sd3_1
Xhold399 _1081_/D _0920_/Y VDD VSS sg13g2_dlygate4sd3_1
XFILLER_26_78 VDD VSS sg13g2_fill_1
XFILLER_38_281 VDD VSS sg13g2_decap_8
XFILLER_5_325 VDD VSS sg13g2_decap_8
XFILLER_29_281 VDD VSS sg13g2_decap_8
XFILLER_3_49 VDD VSS sg13g2_decap_4
XFILLER_36_229 VDD VSS sg13g2_fill_2
X_0981_ _0982_/B _0997_/A1 _0980_/Y _0985_/B1 VDD VSS sg13g2_o21ai_1
XFILLER_12_192 VDD VSS sg13g2_decap_8
XFILLER_35_240 VDD VSS sg13g2_decap_8
XFILLER_10_118 VDD VSS sg13g2_decap_8
XFILLER_12_14 VDD VSS sg13g2_decap_8
XFILLER_18_218 VDD VSS sg13g2_fill_1
XFILLER_26_262 VDD VSS sg13g2_decap_8
XFILLER_5_122 VDD VSS sg13g2_fill_2
XFILLER_17_295 VDD VSS sg13g2_decap_4
X_0964_ _0965_/B _0964_/A1 _0963_/Y _0964_/B1 VDD VSS sg13g2_o21ai_1
X_0895_ _1075_/D _0895_/A _0895_/B VDD VSS sg13g2_nor2_1
XFILLER_23_298 VDD VSS sg13g2_decap_8
XFILLER_23_35 VDD VSS sg13g2_decap_8
XFILLER_0_28 VDD VSS sg13g2_fill_2
XFILLER_0_39 VDD VSS sg13g2_decap_8
XFILLER_14_276 VDD VSS sg13g2_fill_1
XFILLER_13_90 VDD VSS sg13g2_decap_8
X_0680_ _0680_/Y _1022_/Q _0593_/B _0704_/B1 VDD VSS sg13g2_o21ai_1
X_1094_ _1094_/Q _1097_/CLK _1094_/D _1094_/RESET_B VDD VSS sg13g2_dfrbpq_1
XFILLER_20_224 VDD VSS sg13g2_decap_8
XFILLER_20_279 VDD VSS sg13g2_fill_2
X_0947_ _0947_/Y _0947_/A _0984_/B _0996_/C _0959_/D VDD VSS sg13g2_nand4_1
XFILLER_9_291 VDD VSS sg13g2_fill_1
X_0878_ _0879_/B _0890_/A1 _0877_/Y _0878_/B1 VDD VSS sg13g2_o21ai_1
XFILLER_18_35 VDD VSS sg13g2_decap_8
XFILLER_11_257 VDD VSS sg13g2_decap_8
XFILLER_34_56 VDD VSS sg13g2_decap_8
Xclkload0 clkload0/Y clkload0/A VDD VSS sg13g2_inv_1
XFILLER_7_206 VDD VSS sg13g2_fill_2
Xfanout270 _0704_/B1 _0712_/B1 VDD VSS sg13g2_buf_1
X_0801_ _0801_/Y _0966_/A _0996_/C _0933_/C VDD VSS sg13g2_nor3_1
X_0732_ _0732_/X _0730_/C _0730_/D _1036_/Q VDD VSS sg13g2_a21o_1
X_0663_ _0663_/Y _1045_/Q _0695_/A2 _0714_/A2 input8/X VDD VSS sg13g2_a22oi_1
X_0594_ _1001_/D _0727_/A VDD VSS sg13g2_inv_1
XFILLER_6_261 VDD VSS sg13g2_decap_8
XFILLER_37_143 VDD VSS sg13g2_decap_8
XFILLER_1_93 VDD VSS sg13g2_decap_8
X_1077_ _1077_/Q _1083_/CLK _1077_/D _1077_/RESET_B VDD VSS sg13g2_dfrbpq_1
XFILLER_37_198 VDD VSS sg13g2_decap_8
XFILLER_20_14 VDD VSS sg13g2_decap_8
XFILLER_28_132 VDD VSS sg13g2_decap_4
XFILLER_28_165 VDD VSS sg13g2_decap_4
XFILLER_6_49 VDD VSS sg13g2_decap_8
XFILLER_13_7 VDD VSS sg13g2_decap_8
XFILLER_19_143 VDD VSS sg13g2_fill_2
X_1000_ _1000_/Y _1000_/A _1000_/B _1000_/C VDD VSS sg13g2_nand3_1
XFILLER_19_187 VDD VSS sg13g2_fill_2
XFILLER_22_308 VDD VSS sg13g2_fill_1
XFILLER_34_168 VDD VSS sg13g2_decap_8
X_0715_ _0715_/Y _1042_/Q _0715_/A2 _0722_/A2 _1074_/Q VDD VSS sg13g2_a22oi_1
X_0646_ _0646_/Y _1089_/Q _0654_/A2 _0654_/B1 VDD VSS sg13g2_a21oi_1
X_0577_ _0889_/A _0577_/A VDD VSS sg13g2_inv_1
XFILLER_15_14 VDD VSS sg13g2_decap_8
XFILLER_25_157 VDD VSS sg13g2_decap_8
XFILLER_13_319 VDD VSS sg13g2_decap_8
XFILLER_31_35 VDD VSS sg13g2_decap_8
XFILLER_40_149 VDD VSS sg13g2_decap_4
XFILLER_40_127 VDD VSS sg13g2_decap_8
XFILLER_40_105 VDD VSS sg13g2_decap_4
XFILLER_31_46 VDD VSS sg13g2_fill_1
Xoutput79 gpio_dir[10] _1087_/Q VDD VSS sg13g2_buf_1
XFILLER_16_124 VDD VSS sg13g2_decap_4
XFILLER_16_146 VDD VSS sg13g2_fill_1
XFILLER_8_323 VDD VSS sg13g2_decap_8
XFILLER_21_90 VDD VSS sg13g2_decap_8
XFILLER_39_238 VDD VSS sg13g2_decap_8
XFILLER_15_190 VDD VSS sg13g2_decap_8
Xhold389 input68/A s_axil_wdata[5] VDD VSS sg13g2_dlygate4sd3_1
X_0629_ _1009_/D _0626_/Y _0627_/Y _0628_/Y VDD VSS sg13g2_a21oi_1
XFILLER_26_35 VDD VSS sg13g2_decap_8
XFILLER_38_260 VDD VSS sg13g2_decap_8
XFILLER_21_160 VDD VSS sg13g2_decap_8
XFILLER_42_78 VDD VSS sg13g2_fill_1
XFILLER_42_56 VDD VSS sg13g2_decap_8
XFILLER_3_28 VDD VSS sg13g2_decap_8
XFILLER_29_260 VDD VSS sg13g2_decap_8
XFILLER_36_208 VDD VSS sg13g2_decap_8
X_0980_ _0980_/Y _0980_/A _0988_/B _0992_/C _0980_/D VDD VSS sg13g2_nand4_1
XFILLER_35_285 VDD VSS sg13g2_decap_8
XFILLER_37_67 VDD VSS sg13g2_fill_2
XFILLER_5_178 VDD VSS sg13g2_fill_2
XFILLER_5_112 VDD VSS sg13g2_fill_1
XFILLER_5_101 VDD VSS sg13g2_decap_8
XFILLER_32_244 VDD VSS sg13g2_decap_8
X_0963_ _0963_/Y _0963_/A _0963_/B _0963_/C _0963_/D VDD VSS sg13g2_nand4_1
X_0894_ _0895_/B _0898_/A1 _0893_/Y _0898_/B1 VDD VSS sg13g2_o21ai_1
XFILLER_4_82 VDD VSS sg13g2_fill_2
XFILLER_23_14 VDD VSS sg13g2_decap_8
XFILLER_23_244 VDD VSS sg13g2_decap_8
XFILLER_2_148 VDD VSS sg13g2_fill_1
XFILLER_14_266 VDD VSS sg13g2_fill_2
XFILLER_43_7 VDD VSS sg13g2_decap_8
X_1093_ _1093_/Q _1100_/CLK _1093_/D _1093_/RESET_B VDD VSS sg13g2_dfrbpq_1
X_0946_ _0949_/A _0958_/A1 _0933_/Y _1088_/Q VDD VSS sg13g2_a21oi_1
X_0877_ _0877_/Y _0877_/A _0889_/B _0897_/C _0881_/D VDD VSS sg13g2_nand4_1
XFILLER_18_14 VDD VSS sg13g2_decap_8
XFILLER_28_314 VDD VSS sg13g2_fill_2
XFILLER_34_35 VDD VSS sg13g2_decap_8
Xclkload1 clkload1/Y clkload1/A VDD VSS sg13g2_inv_1
Xfanout260 _0911_/B1 _1000_/B VDD VSS sg13g2_buf_1
Xfanout271 _0724_/B1 _0712_/B1 VDD VSS sg13g2_buf_1
XFILLER_34_328 VDD VSS sg13g2_decap_8
X_0800_ _1052_/D _0800_/A _0800_/B VDD VSS sg13g2_nor2_1
X_0731_ _1035_/D _0731_/A _0731_/B VDD VSS sg13g2_and2_1
X_1001__378 _1001_/RESET_B VDD VSS sg13g2_tiehi
X_0662_ _0662_/Y _1077_/Q _0702_/A2 _0702_/B1 VDD VSS sg13g2_a21oi_1
X_0593_ _0727_/A _0726_/B _0593_/B VDD VSS sg13g2_nand2_1
XFILLER_25_317 VDD VSS sg13g2_fill_2
XFILLER_37_166 VDD VSS sg13g2_fill_1
XFILLER_37_111 VDD VSS sg13g2_decap_8
X_1076_ _1076_/Q clkload8/A _1076_/D _1076_/RESET_B VDD VSS sg13g2_dfrbpq_1
X_0929_ _0932_/A _0929_/A1 _0900_/Y _1084_/Q VDD VSS sg13g2_a21oi_1
XFILLER_29_35 VDD VSS sg13g2_decap_4
XFILLER_29_68 VDD VSS sg13g2_decap_8
XFILLER_16_306 VDD VSS sg13g2_decap_4
XFILLER_28_155 VDD VSS sg13g2_fill_1
XFILLER_6_28 VDD VSS sg13g2_decap_8
XFILLER_3_243 VDD VSS sg13g2_fill_1
XFILLER_19_122 VDD VSS sg13g2_decap_8
X_0714_ _0714_/Y input22/X _0714_/A2 _0714_/B1 VDD VSS sg13g2_a21oi_1
X_0645_ _1013_/D _0642_/Y _0643_/Y _0644_/Y VDD VSS sg13g2_a21oi_1
XFILLER_32_0 VDD VSS sg13g2_decap_8
X_0576_ _0893_/A _0576_/A VDD VSS sg13g2_inv_1
XFILLER_25_125 VDD VSS sg13g2_decap_8
XFILLER_25_136 VDD VSS sg13g2_fill_1
X_1059_ _1059_/Q clkload1/A _1059_/D _1059_/RESET_B VDD VSS sg13g2_dfrbpq_1
XFILLER_21_342 VDD VSS sg13g2_fill_1
XFILLER_31_14 VDD VSS sg13g2_decap_8
XFILLER_31_58 VDD VSS sg13g2_decap_4
XFILLER_16_103 VDD VSS sg13g2_decap_8
XFILLER_16_136 VDD VSS sg13g2_fill_1
XFILLER_8_346 VDD VSS sg13g2_fill_1
Xhold379 input40/A s_axil_bready VDD VSS sg13g2_dlygate4sd3_1
X_0628_ _0628_/Y _1009_/Q _0644_/A2 _0648_/B1 VDD VSS sg13g2_o21ai_1
XFILLER_26_14 VDD VSS sg13g2_decap_8
X_0559_ _0963_/A _0559_/A VDD VSS sg13g2_inv_1
XFILLER_42_35 VDD VSS sg13g2_decap_8
X_1060__320 _1060_/RESET_B VDD VSS sg13g2_tiehi
XFILLER_8_154 VDD VSS sg13g2_fill_2
XFILLER_27_209 VDD VSS sg13g2_decap_8
XFILLER_35_264 VDD VSS sg13g2_decap_8
XFILLER_35_220 VDD VSS sg13g2_decap_4
XFILLER_37_35 VDD VSS sg13g2_decap_4
XFILLER_5_157 VDD VSS sg13g2_fill_2
XFILLER_5_124 VDD VSS sg13g2_fill_1
XFILLER_32_223 VDD VSS sg13g2_decap_8
X_0962_ _0965_/A _0962_/A1 _0933_/Y _1092_/Q VDD VSS sg13g2_a21oi_1
X_0893_ _0893_/Y _0893_/A _0963_/B _0963_/C _0893_/D VDD VSS sg13g2_nand4_1
XFILLER_4_190 VDD VSS sg13g2_fill_1
XFILLER_2_105 VDD VSS sg13g2_decap_8
XFILLER_3_7 VDD VSS sg13g2_decap_8
XFILLER_14_234 VDD VSS sg13g2_fill_1
XFILLER_14_289 VDD VSS sg13g2_decap_8
XFILLER_9_39 VDD VSS sg13g2_fill_2
XFILLER_9_28 VDD VSS sg13g2_decap_8
XFILLER_36_7 VDD VSS sg13g2_decap_8
X_1092_ _1092_/Q clkload5/A _1092_/D _1092_/RESET_B VDD VSS sg13g2_dfrbpq_1
X_0945_ _1087_/D _0945_/A _0945_/B VDD VSS sg13g2_nor2_1
X_0876_ _0879_/A _0896_/A1 _0867_/Y _1071_/Q VDD VSS sg13g2_a21oi_1
XFILLER_34_14 VDD VSS sg13g2_decap_8
XFILLER_43_318 VDD VSS sg13g2_decap_8
Xclkload2 clkload2/Y clkload2/A VDD VSS sg13g2_inv_1
Xfanout250 _0966_/A _0900_/A VDD VSS sg13g2_buf_1
Xfanout261 _1000_/B _0936_/B1 VDD VSS sg13g2_buf_1
Xfanout272 _0712_/B1 fanout274/X VDD VSS sg13g2_buf_1
X_0730_ _0730_/Y _0730_/A _1101_/Q _0730_/C _0730_/D VDD VSS sg13g2_nand4_1
X_0661_ _0661_/Y _0658_/Y _0659_/Y _0660_/Y VDD VSS sg13g2_a21oi_1
X_0592_ _0592_/Y _1001_/Q _0592_/B VDD VSS sg13g2_nand2b_1
X_1075_ _1075_/Q clkload8/A _1075_/D _1075_/RESET_B VDD VSS sg13g2_dfrbpq_1
XFILLER_37_178 VDD VSS sg13g2_decap_4
X_0928_ _0928_/Y _0928_/A _0928_/B VDD VSS sg13g2_nor2_1
X_0859_ _0862_/A _0987_/A1 _0834_/Y _1067_/Q VDD VSS sg13g2_a21oi_1
XFILLER_29_14 VDD VSS sg13g2_decap_8
XFILLER_3_222 VDD VSS sg13g2_fill_2
XFILLER_19_80 VDD VSS sg13g2_decap_8
XFILLER_15_340 VDD VSS sg13g2_decap_8
XFILLER_30_321 VDD VSS sg13g2_decap_8
XFILLER_42_192 VDD VSS sg13g2_fill_1
XFILLER_42_181 VDD VSS sg13g2_decap_8
X_0713_ _1030_/D _0710_/Y _0711_/Y _0712_/Y VDD VSS sg13g2_a21oi_1
X_0644_ _0644_/Y _1013_/Q _0644_/A2 _0960_/B1 VDD VSS sg13g2_o21ai_1
XFILLER_25_0 VDD VSS sg13g2_decap_8
X_0575_ _0897_/A _0575_/A VDD VSS sg13g2_inv_1
XFILLER_25_104 VDD VSS sg13g2_decap_8
X_1058_ _1058_/Q clkload1/A _1058_/D _1058_/RESET_B VDD VSS sg13g2_dfrbpq_1
XFILLER_33_192 VDD VSS sg13g2_fill_2
XFILLER_12_343 VDD VSS sg13g2_decap_4
X_1035__283 _1035_/RESET_B VDD VSS sg13g2_tiehi
XFILLER_30_195 VDD VSS sg13g2_decap_8
X_0627_ _0627_/Y _1068_/Q _0655_/A2 _0651_/B1 _1100_/Q VDD VSS sg13g2_a22oi_1
X_0558_ _0968_/A _0558_/A VDD VSS sg13g2_inv_1
XFILLER_38_295 VDD VSS sg13g2_decap_8
XFILLER_13_118 VDD VSS sg13g2_decap_8
XFILLER_42_14 VDD VSS sg13g2_decap_8
XFILLER_21_184 VDD VSS sg13g2_decap_8
XFILLER_5_339 VDD VSS sg13g2_decap_8
XFILLER_29_295 VDD VSS sg13g2_decap_8
XFILLER_8_199 VDD VSS sg13g2_decap_8
XFILLER_12_28 VDD VSS sg13g2_decap_8
XFILLER_12_39 VDD VSS sg13g2_fill_2
XFILLER_37_14 VDD VSS sg13g2_decap_8
XFILLER_26_298 VDD VSS sg13g2_decap_8
XFILLER_5_136 VDD VSS sg13g2_decap_8
XFILLER_17_221 VDD VSS sg13g2_decap_8
XFILLER_32_202 VDD VSS sg13g2_decap_8
XFILLER_32_268 VDD VSS sg13g2_fill_1
X_0961_ _1091_/D _0961_/A _0961_/B VDD VSS sg13g2_nor2_1
X_0892_ _0895_/A _0962_/A1 _0867_/Y _1075_/Q VDD VSS sg13g2_a21oi_1
XFILLER_23_49 VDD VSS sg13g2_decap_8
XFILLER_2_139 VDD VSS sg13g2_decap_8
XFILLER_14_213 VDD VSS sg13g2_decap_8
XFILLER_14_246 VDD VSS sg13g2_decap_4
XFILLER_13_60 VDD VSS sg13g2_fill_2
XFILLER_29_7 VDD VSS sg13g2_decap_8
X_1091_ _1091_/Q _1091_/CLK _1091_/D _1091_/RESET_B VDD VSS sg13g2_dfrbpq_1
XFILLER_37_338 VDD VSS sg13g2_fill_1
XFILLER_37_316 VDD VSS sg13g2_decap_4
XFILLER_20_238 VDD VSS sg13g2_decap_8
XFILLER_20_249 VDD VSS sg13g2_fill_1
X_0944_ _0945_/B _0964_/A1 _0943_/Y _0726_/B VDD VSS sg13g2_o21ai_1
X_0875_ _1070_/D _0875_/A _0875_/B VDD VSS sg13g2_nor2_1
XFILLER_9_272 VDD VSS sg13g2_fill_2
XFILLER_18_49 VDD VSS sg13g2_fill_1
XFILLER_28_338 VDD VSS sg13g2_fill_1
XFILLER_11_216 VDD VSS sg13g2_decap_4
Xclkload3 clkload3/Y clkload3/A VDD VSS sg13g2_inv_1
Xfanout240 _0963_/B _0930_/B VDD VSS sg13g2_buf_1
XFILLER_19_316 VDD VSS sg13g2_fill_2
XFILLER_34_308 VDD VSS sg13g2_fill_2
Xfanout251 _0992_/C _0996_/C VDD VSS sg13g2_buf_1
Xfanout262 _0878_/B1 _0936_/B1 VDD VSS sg13g2_buf_1
Xfanout273 _0726_/B fanout274/X VDD VSS sg13g2_buf_1
X_0660_ _0660_/Y _1017_/Q _0712_/A2 _0712_/B1 VDD VSS sg13g2_o21ai_1
X_0591_ _0591_/Y _1001_/Q _0592_/B VDD VSS sg13g2_nor2b_1
XFILLER_40_91 VDD VSS sg13g2_decap_8
XFILLER_1_63 VDD VSS sg13g2_fill_1
X_1074_ _1074_/Q clkload4/A _1074_/D _1074_/RESET_B VDD VSS sg13g2_dfrbpq_1
XFILLER_37_157 VDD VSS sg13g2_decap_8
X_0927_ _0928_/B _0927_/A1 hold395/X _1000_/B VDD VSS sg13g2_o21ai_1
XFILLER_20_28 VDD VSS sg13g2_decap_4
X_0858_ _1066_/D _0858_/A _0858_/B VDD VSS sg13g2_nor2_1
X_0789_ _0792_/A _0731_/B _0768_/Y _1050_/Q VDD VSS sg13g2_a21oi_1
XFILLER_10_50 VDD VSS sg13g2_decap_8
XFILLER_10_61 VDD VSS sg13g2_fill_2
XFILLER_10_83 VDD VSS sg13g2_decap_8
XFILLER_34_127 VDD VSS sg13g2_decap_8
X_0712_ _0712_/Y _1030_/Q _0712_/A2 _0712_/B1 VDD VSS sg13g2_o21ai_1
X_0643_ _0643_/Y _1056_/Q _0647_/A2 _0686_/A2 input3/X VDD VSS sg13g2_a22oi_1
X_0574_ _0902_/A _0574_/A VDD VSS sg13g2_inv_1
XFILLER_18_0 VDD VSS sg13g2_decap_8
XFILLER_15_28 VDD VSS sg13g2_decap_8
X_1057_ _1057_/Q _1091_/CLK _1057_/D _1057_/RESET_B VDD VSS sg13g2_dfrbpq_1
XFILLER_12_322 VDD VSS sg13g2_decap_8
XFILLER_24_182 VDD VSS sg13g2_decap_8
XFILLER_24_193 VDD VSS sg13g2_fill_2
XFILLER_31_108 VDD VSS sg13g2_decap_8
XFILLER_8_337 VDD VSS sg13g2_decap_8
XFILLER_11_7 VDD VSS sg13g2_decap_8
XFILLER_30_174 VDD VSS sg13g2_decap_8
XFILLER_7_73 VDD VSS sg13g2_decap_8
X_0626_ _0626_/Y input30/X _0647_/B1 _0686_/B1 VDD VSS sg13g2_a21oi_1
X_0557_ _0972_/A _0557_/A VDD VSS sg13g2_inv_1
XFILLER_38_274 VDD VSS sg13g2_decap_8
XFILLER_21_174 VDD VSS sg13g2_decap_4
XFILLER_5_318 VDD VSS sg13g2_decap_8
XFILLER_16_82 VDD VSS sg13g2_decap_8
XFILLER_29_274 VDD VSS sg13g2_decap_8
XFILLER_12_141 VDD VSS sg13g2_decap_8
XFILLER_8_156 VDD VSS sg13g2_fill_1
X_0609_ _1004_/D _0606_/Y _0607_/Y _0608_/Y VDD VSS sg13g2_a21oi_1
XFILLER_26_255 VDD VSS sg13g2_decap_8
X_1099__362 _1099_/RESET_B VDD VSS sg13g2_tiehi
XFILLER_27_81 VDD VSS sg13g2_decap_8
XFILLER_17_288 VDD VSS sg13g2_decap_8
XFILLER_17_299 VDD VSS sg13g2_fill_2
X_0960_ _0961_/B _0960_/A1 _0959_/Y _0960_/B1 VDD VSS sg13g2_o21ai_1
X_1004__345 _1004_/RESET_B VDD VSS sg13g2_tiehi
X_0891_ _1074_/D _0891_/A _0891_/B VDD VSS sg13g2_nor2_1
XFILLER_23_258 VDD VSS sg13g2_decap_4
XFILLER_23_28 VDD VSS sg13g2_decap_8
XFILLER_13_83 VDD VSS sg13g2_decap_8
XFILLER_37_306 VDD VSS sg13g2_decap_4
X_1090_ _1090_/Q clkload3/A _1090_/D _1090_/RESET_B VDD VSS sg13g2_dfrbpq_1
XFILLER_13_291 VDD VSS sg13g2_fill_2
Xclkload10 clkload10/Y _1033_/CLK VDD VSS sg13g2_inv_1
X_0943_ _0943_/Y _0943_/A _0963_/B _0963_/C _0943_/D VDD VSS sg13g2_nand4_1
X_0874_ _0875_/B _0898_/A1 _0873_/Y _0726_/B VDD VSS sg13g2_o21ai_1
XFILLER_18_28 VDD VSS sg13g2_decap_8
XFILLER_34_49 VDD VSS sg13g2_decap_8
Xclkload4 clkload4/Y clkload4/A VDD VSS sg13g2_inv_1
X_1096__354 _1096_/RESET_B VDD VSS sg13g2_tiehi
Xfanout230 _0900_/B _0587_/Y VDD VSS sg13g2_buf_1
Xfanout241 _0930_/B _0586_/Y VDD VSS sg13g2_buf_1
Xfanout252 _0996_/C _0984_/C VDD VSS sg13g2_buf_1
Xfanout263 _0898_/B1 _0936_/B1 VDD VSS sg13g2_buf_1
Xfanout274 fanout274/X input33/X VDD VSS sg13g2_buf_1
XFILLER_24_60 VDD VSS sg13g2_fill_2
X_1040__375 _1040_/RESET_B VDD VSS sg13g2_tiehi
X_0590_ _0966_/C _0984_/D VDD VSS sg13g2_inv_1
XFILLER_6_254 VDD VSS sg13g2_decap_8
XFILLER_41_7 VDD VSS sg13g2_decap_8
XFILLER_1_42 VDD VSS sg13g2_decap_8
XFILLER_37_125 VDD VSS sg13g2_fill_2
X_1073_ _1073_/Q clkload8/A _1073_/D _1073_/RESET_B VDD VSS sg13g2_dfrbpq_1
X_0926_ _0926_/Y _0926_/A _0926_/B _0926_/C _0930_/D VDD VSS sg13g2_nand4_1
X_0857_ _0858_/B _0989_/A1 _0856_/Y _0731_/A VDD VSS sg13g2_o21ai_1
X_0788_ _1049_/D _0788_/A _0788_/B VDD VSS sg13g2_nor2_1
XFILLER_28_103 VDD VSS sg13g2_fill_2
XFILLER_28_125 VDD VSS sg13g2_decap_8
XFILLER_28_136 VDD VSS sg13g2_fill_1
XFILLER_19_136 VDD VSS sg13g2_decap_8
XFILLER_27_180 VDD VSS sg13g2_decap_8
XFILLER_35_81 VDD VSS sg13g2_decap_8
X_0711_ _0711_/Y _1041_/Q _0715_/A2 _0711_/B1 _1073_/Q VDD VSS sg13g2_a22oi_1
X_0642_ _0642_/Y _1088_/Q _0654_/A2 _0654_/B1 VDD VSS sg13g2_a21oi_1
X_0573_ _0906_/A _0573_/A VDD VSS sg13g2_inv_1
XFILLER_33_194 VDD VSS sg13g2_fill_1
X_1056_ _1056_/Q _1091_/CLK _1056_/D _1056_/RESET_B VDD VSS sg13g2_dfrbpq_1
XFILLER_40_109 VDD VSS sg13g2_fill_2
XFILLER_31_28 VDD VSS sg13g2_decap_8
X_0909_ _0912_/A _0925_/A1 _0900_/Y _1079_/Q VDD VSS sg13g2_a21oi_1
X_1093__302 _1093_/RESET_B VDD VSS sg13g2_tiehi
XFILLER_16_117 VDD VSS sg13g2_decap_8
XFILLER_8_316 VDD VSS sg13g2_decap_8
XFILLER_21_83 VDD VSS sg13g2_decap_8
XFILLER_15_150 VDD VSS sg13g2_fill_2
XFILLER_15_183 VDD VSS sg13g2_decap_8
XFILLER_22_109 VDD VSS sg13g2_fill_2
X_0625_ _1008_/D _0622_/Y _0623_/Y _0624_/Y VDD VSS sg13g2_a21oi_1
XFILLER_7_63 VDD VSS sg13g2_fill_2
XFILLER_30_0 VDD VSS sg13g2_decap_8
X_0556_ _0976_/A _0556_/A VDD VSS sg13g2_inv_1
XFILLER_26_28 VDD VSS sg13g2_decap_8
X_1039_ _1039_/Q clkload4/A _1039_/D _1039_/RESET_B VDD VSS sg13g2_dfrbpq_1
X_1014__325 _1014_/RESET_B VDD VSS sg13g2_tiehi
XFILLER_38_253 VDD VSS sg13g2_decap_8
XFILLER_42_49 VDD VSS sg13g2_decap_8
X_1101__342 _1101_/RESET_B VDD VSS sg13g2_tiehi
XFILLER_35_278 VDD VSS sg13g2_decap_8
XFILLER_35_234 VDD VSS sg13g2_fill_1
X_0608_ _0608_/Y _1004_/Q _0644_/A2 _0648_/B1 VDD VSS sg13g2_o21ai_1
XFILLER_27_60 VDD VSS sg13g2_decap_8
XFILLER_32_237 VDD VSS sg13g2_decap_8
X_0890_ _0891_/B _0890_/A1 _0889_/Y _0898_/B1 VDD VSS sg13g2_o21ai_1
XFILLER_4_42 VDD VSS sg13g2_decap_4
XFILLER_23_237 VDD VSS sg13g2_decap_8
Xclkbuf_4_15_0_clk_i _1033_/CLK clkbuf_0_clk_i/X VDD VSS sg13g2_buf_8
X_1050__355 _1050_/RESET_B VDD VSS sg13g2_tiehi
XFILLER_31_270 VDD VSS sg13g2_fill_2
XFILLER_8_0 VDD VSS sg13g2_decap_8
XFILLER_38_92 VDD VSS sg13g2_decap_8
X_0942_ _0945_/A _0942_/A1 _0933_/Y _1087_/Q VDD VSS sg13g2_a21oi_1
X_0873_ _0873_/Y _0873_/A _0897_/B _0897_/C _0897_/D VDD VSS sg13g2_nand4_1
XFILLER_9_296 VDD VSS sg13g2_decap_8
XFILLER_9_252 VDD VSS sg13g2_decap_8
XFILLER_28_307 VDD VSS sg13g2_decap_8
XFILLER_34_28 VDD VSS sg13g2_decap_8
Xclkload5 clkload5/Y clkload5/A VDD VSS sg13g2_inv_1
XFILLER_1_7 VDD VSS sg13g2_decap_8
Xfanout220 _0647_/A2 _0655_/A2 VDD VSS sg13g2_buf_1
Xfanout231 _0988_/B _0959_/B VDD VSS sg13g2_buf_1
Xfanout242 _0881_/D _0897_/D VDD VSS sg13g2_buf_1
Xfanout253 _0926_/C _0984_/C VDD VSS sg13g2_buf_1
Xfanout264 _0936_/B1 fanout274/X VDD VSS sg13g2_buf_1
XFILLER_42_321 VDD VSS sg13g2_fill_1
XFILLER_34_7 VDD VSS sg13g2_decap_8
XFILLER_1_21 VDD VSS sg13g2_decap_8
X_1072_ _1072_/Q clkload4/A _1072_/D _1072_/RESET_B VDD VSS sg13g2_dfrbpq_1
XFILLER_37_137 VDD VSS sg13g2_fill_1
X_0925_ _0928_/A _0925_/A1 _0900_/Y _1083_/Q VDD VSS sg13g2_a21oi_1
X_0856_ _0856_/Y _0988_/A _0988_/B _0966_/B _0996_/D VDD VSS sg13g2_nand4_1
X_0787_ _0788_/B _0911_/A1 _0786_/Y _0997_/B1 VDD VSS sg13g2_o21ai_1
XFILLER_29_28 VDD VSS sg13g2_decap_8
XFILLER_29_39 VDD VSS sg13g2_fill_2
X_1024__305 _1024_/RESET_B VDD VSS sg13g2_tiehi
XFILLER_19_115 VDD VSS sg13g2_decap_8
XFILLER_30_335 VDD VSS sg13g2_decap_4
XFILLER_35_60 VDD VSS sg13g2_decap_8
X_0710_ _0710_/Y input21/X _0714_/A2 _0714_/B1 VDD VSS sg13g2_a21oi_1
X_0641_ _1012_/D _0638_/Y _0639_/Y _0640_/Y VDD VSS sg13g2_a21oi_1
X_0572_ _0910_/A _0572_/A VDD VSS sg13g2_inv_1
XFILLER_25_118 VDD VSS sg13g2_decap_8
X_1055_ _1055_/Q clkload5/A _1055_/D _1055_/RESET_B VDD VSS sg13g2_dfrbpq_1
XFILLER_21_335 VDD VSS sg13g2_decap_8
XFILLER_33_151 VDD VSS sg13g2_fill_1
X_0908_ _0908_/Y _0908_/A _0908_/B VDD VSS sg13g2_nor2_1
X_0839_ _0842_/A _0983_/A1 _0834_/Y _1062_/Q VDD VSS sg13g2_a21oi_1
XFILLER_24_140 VDD VSS sg13g2_decap_8
XFILLER_15_162 VDD VSS sg13g2_decap_8
XFILLER_30_110 VDD VSS sg13g2_decap_4
XFILLER_30_132 VDD VSS sg13g2_decap_8
X_0624_ _0624_/Y _1008_/Q _0656_/A2 _0648_/B1 VDD VSS sg13g2_o21ai_1
XFILLER_7_42 VDD VSS sg13g2_decap_8
XFILLER_23_0 VDD VSS sg13g2_decap_8
X_0555_ _0980_/A _0555_/A VDD VSS sg13g2_inv_1
XFILLER_38_232 VDD VSS sg13g2_decap_8
XFILLER_38_221 VDD VSS sg13g2_fill_2
X_1038_ _1038_/Q _1070_/CLK _1038_/D _1038_/RESET_B VDD VSS sg13g2_dfrbpq_1
XFILLER_21_143 VDD VSS sg13g2_decap_8
XFILLER_21_154 VDD VSS sg13g2_fill_2
XFILLER_21_198 VDD VSS sg13g2_decap_8
XFILLER_42_28 VDD VSS sg13g2_decap_8
XFILLER_12_110 VDD VSS sg13g2_decap_8
XFILLER_32_94 VDD VSS sg13g2_decap_8
XFILLER_35_257 VDD VSS sg13g2_decap_8
XFILLER_35_224 VDD VSS sg13g2_fill_1
XFILLER_35_213 VDD VSS sg13g2_decap_8
Xclkbuf_4_11_0_clk_i clkload7/A clkbuf_0_clk_i/X VDD VSS sg13g2_buf_8
X_0607_ _0607_/Y _1063_/Q _0647_/A2 _0647_/B1 input23/X VDD VSS sg13g2_a22oi_1
XFILLER_37_39 VDD VSS sg13g2_fill_1
XFILLER_37_28 VDD VSS sg13g2_decap_8
XFILLER_17_235 VDD VSS sg13g2_decap_4
XFILLER_17_257 VDD VSS sg13g2_decap_8
X_1032__289 _1032_/RESET_B VDD VSS sg13g2_tiehi
XFILLER_4_21 VDD VSS sg13g2_decap_8
XFILLER_31_282 VDD VSS sg13g2_decap_8
XFILLER_14_227 VDD VSS sg13g2_decap_8
XFILLER_22_282 VDD VSS sg13g2_decap_8
XFILLER_1_120 VDD VSS sg13g2_decap_4
X_0941_ _1086_/D _0941_/A _0941_/B VDD VSS sg13g2_nor2_1
XFILLER_13_293 VDD VSS sg13g2_fill_1
X_0872_ _0875_/A _0896_/A1 _0867_/Y _1070_/Q VDD VSS sg13g2_a21oi_1
XFILLER_9_231 VDD VSS sg13g2_decap_8
Xclkload6 clkload6/Y clkload6/A VDD VSS sg13g2_inv_1
Xfanout210 _0654_/A2 _0651_/B1 VDD VSS sg13g2_buf_1
Xfanout221 _0655_/A2 _0595_/Y VDD VSS sg13g2_buf_1
Xfanout232 _0996_/B _0959_/B VDD VSS sg13g2_buf_1
Xfanout243 _0897_/D _0893_/D VDD VSS sg13g2_buf_1
Xfanout254 _0897_/C _0963_/C VDD VSS sg13g2_buf_1
Xfanout265 _0960_/B1 fanout269/X VDD VSS sg13g2_buf_1
XFILLER_27_7 VDD VSS sg13g2_decap_8
XFILLER_6_289 VDD VSS sg13g2_fill_2
XFILLER_40_83 VDD VSS sg13g2_fill_2
X_1071_ _1071_/Q clkload4/A _1071_/D _1071_/RESET_B VDD VSS sg13g2_dfrbpq_1
XFILLER_37_127 VDD VSS sg13g2_fill_1
X_0924_ _0924_/Y _0924_/A _0924_/B VDD VSS sg13g2_nor2_1
X_0855_ _0858_/A _0987_/A1 _0834_/Y _1066_/Q VDD VSS sg13g2_a21oi_1
X_0786_ _0786_/Y _0918_/A _0926_/B _0798_/C _0914_/D VDD VSS sg13g2_nand4_1
XFILLER_28_105 VDD VSS sg13g2_fill_1
XFILLER_24_333 VDD VSS sg13g2_decap_4
XFILLER_36_171 VDD VSS sg13g2_decap_8
XFILLER_10_42 VDD VSS sg13g2_decap_4
XFILLER_10_97 VDD VSS sg13g2_decap_8
XFILLER_19_149 VDD VSS sg13g2_decap_4
XFILLER_19_73 VDD VSS sg13g2_decap_8
X_1068__288 _1068_/RESET_B VDD VSS sg13g2_tiehi
X_0640_ _0640_/Y _1012_/Q _0712_/A2 _0726_/B VDD VSS sg13g2_o21ai_1
X_0571_ _0914_/A _0571_/A VDD VSS sg13g2_inv_1
XFILLER_18_171 VDD VSS sg13g2_decap_8
XFILLER_18_182 VDD VSS sg13g2_fill_2
X_1054_ _1054_/Q clkload5/A _1054_/D _1054_/RESET_B VDD VSS sg13g2_dfrbpq_1
XFILLER_33_185 VDD VSS sg13g2_fill_2
X_0907_ _0908_/B _0911_/A1 _0906_/Y _0911_/B1 VDD VSS sg13g2_o21ai_1
X_0838_ _1061_/D _0838_/A _0838_/B VDD VSS sg13g2_nor2_1
X_0769_ _0772_/A _0731_/B _0768_/Y _1045_/Q VDD VSS sg13g2_a21oi_1
XFILLER_12_336 VDD VSS sg13g2_decap_8
XFILLER_30_188 VDD VSS sg13g2_decap_8
XFILLER_7_340 VDD VSS sg13g2_decap_8
XFILLER_7_21 VDD VSS sg13g2_decap_8
X_0623_ _0623_/Y _1067_/Q _0655_/A2 _0686_/A2 input29/X VDD VSS sg13g2_a22oi_1
X_0554_ _0984_/A _0554_/A VDD VSS sg13g2_inv_1
XFILLER_7_98 VDD VSS sg13g2_decap_8
XFILLER_16_0 VDD VSS sg13g2_decap_8
XFILLER_38_288 VDD VSS sg13g2_decap_8
XFILLER_21_111 VDD VSS sg13g2_decap_4
XFILLER_21_122 VDD VSS sg13g2_decap_8
X_1037_ _1037_/Q clkload3/A _1037_/D _1037_/RESET_B VDD VSS sg13g2_dfrbpq_1
XFILLER_29_288 VDD VSS sg13g2_decap_8
XFILLER_12_155 VDD VSS sg13g2_decap_4
XFILLER_16_96 VDD VSS sg13g2_decap_8
XFILLER_4_343 VDD VSS sg13g2_decap_4
XFILLER_35_247 VDD VSS sg13g2_decap_8
X_0606_ _0606_/Y _1095_/Q _0654_/A2 _0654_/B1 VDD VSS sg13g2_a21oi_1
XFILLER_26_225 VDD VSS sg13g2_fill_2
XFILLER_26_269 VDD VSS sg13g2_fill_2
XFILLER_5_129 VDD VSS sg13g2_decap_8
XFILLER_1_346 VDD VSS sg13g2_fill_1
XFILLER_17_214 VDD VSS sg13g2_fill_2
XFILLER_27_95 VDD VSS sg13g2_decap_8
XFILLER_32_217 VDD VSS sg13g2_fill_2
XFILLER_31_272 VDD VSS sg13g2_fill_1
XFILLER_14_206 VDD VSS sg13g2_decap_8
XFILLER_14_239 VDD VSS sg13g2_decap_8
Xclkbuf_4_9_0_clk_i clkload5/A clkbuf_0_clk_i/X VDD VSS sg13g2_buf_8
XFILLER_13_42 VDD VSS sg13g2_decap_8
XFILLER_13_97 VDD VSS sg13g2_fill_1
XFILLER_22_261 VDD VSS sg13g2_decap_8
X_1073__368 _1073_/RESET_B VDD VSS sg13g2_tiehi
X_0940_ _0941_/B _0940_/A1 _0939_/Y _0964_/B1 VDD VSS sg13g2_o21ai_1
X_0871_ _1069_/D _0871_/A _0871_/B VDD VSS sg13g2_nor2_1
XFILLER_9_265 VDD VSS sg13g2_fill_1
Xclkload7 clkload7/Y clkload7/A VDD VSS sg13g2_inv_1
Xfanout200 _0654_/B1 _0714_/B1 VDD VSS sg13g2_buf_1
Xfanout211 _0651_/B1 _0597_/Y VDD VSS sg13g2_buf_1
Xfanout222 _0695_/A2 _0715_/A2 VDD VSS sg13g2_buf_1
XFILLER_19_309 VDD VSS sg13g2_decap_8
Xfanout233 _0939_/B _0959_/B VDD VSS sg13g2_buf_1
Xfanout244 _0914_/D _0922_/D VDD VSS sg13g2_buf_1
Xfanout255 _0963_/C _0984_/C VDD VSS sg13g2_buf_1
Xfanout266 _0964_/B1 fanout269/X VDD VSS sg13g2_buf_1
XFILLER_24_74 VDD VSS sg13g2_decap_4
XFILLER_42_301 VDD VSS sg13g2_decap_8
XFILLER_6_202 VDD VSS sg13g2_decap_8
XFILLER_18_342 VDD VSS sg13g2_decap_4
XFILLER_1_56 VDD VSS sg13g2_decap_8
XFILLER_1_67 VDD VSS sg13g2_decap_4
X_1070_ _1070_/Q _1070_/CLK _1070_/D _1070_/RESET_B VDD VSS sg13g2_dfrbpq_1
X_0923_ _0924_/B _0931_/A1 _0922_/Y _1000_/B VDD VSS sg13g2_o21ai_1
X_0854_ _1065_/D _0854_/A _0854_/B VDD VSS sg13g2_nor2_1
X_0785_ _0788_/A _0731_/B _0768_/Y _1049_/Q VDD VSS sg13g2_a21oi_1
XFILLER_24_312 VDD VSS sg13g2_decap_8
XFILLER_36_194 VDD VSS sg13g2_decap_8
XFILLER_10_21 VDD VSS sg13g2_decap_8
XFILLER_10_76 VDD VSS sg13g2_decap_8
XFILLER_19_63 VDD VSS sg13g2_fill_1
XFILLER_27_194 VDD VSS sg13g2_fill_2
X_0570_ _0918_/A _0570_/A VDD VSS sg13g2_inv_1
XFILLER_18_150 VDD VSS sg13g2_decap_8
XFILLER_33_164 VDD VSS sg13g2_decap_8
X_1053_ _1053_/Q clkload1/A _1053_/D _1053_/RESET_B VDD VSS sg13g2_dfrbpq_1
X_0906_ _0906_/Y _0906_/A _0910_/B _0926_/C _0914_/D VDD VSS sg13g2_nand4_1
X_0837_ _0838_/B _0989_/A1 _0836_/Y _0731_/A VDD VSS sg13g2_o21ai_1
X_0768_ _0768_/Y _0966_/A _0926_/C _0900_/C VDD VSS sg13g2_nor3_1
X_0699_ _0699_/Y _1038_/Q _0723_/A2 _0699_/B1 input18/X VDD VSS sg13g2_a22oi_1
XFILLER_12_315 VDD VSS sg13g2_decap_8
XFILLER_24_175 VDD VSS sg13g2_decap_8
XFILLER_21_97 VDD VSS sg13g2_decap_8
XFILLER_15_131 VDD VSS sg13g2_decap_8
XFILLER_15_197 VDD VSS sg13g2_decap_4
X_0622_ _0622_/Y _1099_/Q _0651_/B1 _0714_/B1 VDD VSS sg13g2_a21oi_1
X_0553_ _0988_/A _0553_/A VDD VSS sg13g2_inv_1
XFILLER_38_267 VDD VSS sg13g2_decap_8
XFILLER_21_167 VDD VSS sg13g2_decap_8
X_1036_ _1036_/Q clkload2/A _1036_/D _1036_/RESET_B VDD VSS sg13g2_dfrbpq_1
XFILLER_29_212 VDD VSS sg13g2_decap_8
XFILLER_16_75 VDD VSS sg13g2_decap_8
XFILLER_29_267 VDD VSS sg13g2_decap_8
XFILLER_12_134 VDD VSS sg13g2_decap_8
XFILLER_32_74 VDD VSS sg13g2_fill_1
X_0605_ _1003_/D _0602_/Y _0603_/Y _0604_/Y VDD VSS sg13g2_a21oi_1
X_1019_ _1019_/Q _1070_/CLK _1019_/D _1019_/RESET_B VDD VSS sg13g2_dfrbpq_1
XFILLER_41_218 VDD VSS sg13g2_decap_8
XFILLER_5_108 VDD VSS sg13g2_decap_4
Xclkbuf_4_5_0_clk_i clkload2/A clkbuf_0_clk_i/X VDD VSS sg13g2_buf_8
XFILLER_27_74 VDD VSS sg13g2_decap_8
XFILLER_4_89 VDD VSS sg13g2_fill_2
XFILLER_16_281 VDD VSS sg13g2_decap_8
X_1031__291 _1031_/RESET_B VDD VSS sg13g2_tiehi
XFILLER_13_21 VDD VSS sg13g2_decap_8
XFILLER_13_76 VDD VSS sg13g2_fill_2
XFILLER_1_100 VDD VSS sg13g2_fill_2
XFILLER_13_284 VDD VSS sg13g2_decap_8
X_0870_ _0871_/B _0890_/A1 _0869_/Y _0878_/B1 VDD VSS sg13g2_o21ai_1
Xclkbuf_0_clk_i clkbuf_0_clk_i/X clk_i VDD VSS sg13g2_buf_16
Xclkload8 clkload8/Y clkload8/A VDD VSS sg13g2_inv_1
X_0999_ _1000_/A _1207_/A _0729_/C _1101_/Q VDD VSS sg13g2_o21ai_1
Xfanout201 _0686_/B1 _0714_/B1 VDD VSS sg13g2_buf_1
Xfanout212 _0702_/A2 _0711_/B1 VDD VSS sg13g2_buf_1
Xfanout223 _0723_/A2 _0715_/A2 VDD VSS sg13g2_buf_1
Xfanout234 _0984_/B _0959_/B VDD VSS sg13g2_buf_1
Xfanout245 _0922_/D _0930_/D VDD VSS sg13g2_buf_1
Xfanout256 _0984_/C input37/X VDD VSS sg13g2_buf_1
Xfanout267 _0648_/B1 fanout269/X VDD VSS sg13g2_buf_1
XFILLER_39_192 VDD VSS sg13g2_decap_4
XFILLER_24_42 VDD VSS sg13g2_decap_8
XFILLER_6_0 VDD VSS sg13g2_decap_8
XFILLER_18_310 VDD VSS sg13g2_decap_8
XFILLER_1_35 VDD VSS sg13g2_decap_8
XFILLER_37_118 VDD VSS sg13g2_decap_8
XFILLER_33_302 VDD VSS sg13g2_decap_4
XFILLER_33_346 VDD VSS sg13g2_fill_1
X_0922_ _0922_/Y _0922_/A _0926_/B _0926_/C _0922_/D VDD VSS sg13g2_nand4_1
X_0853_ _0854_/B _0985_/A1 _0852_/Y _0985_/B1 VDD VSS sg13g2_o21ai_1
X_0784_ _1048_/D _0784_/A _0784_/B VDD VSS sg13g2_nor2_1
XFILLER_39_0 VDD VSS sg13g2_decap_8
Xinput1 input1/X gpio_in[0] VDD VSS sg13g2_buf_1
XFILLER_36_151 VDD VSS sg13g2_decap_8
XFILLER_19_129 VDD VSS sg13g2_decap_8
XFILLER_19_42 VDD VSS sg13g2_decap_8
XFILLER_27_173 VDD VSS sg13g2_decap_8
XFILLER_35_74 VDD VSS sg13g2_decap_8
XFILLER_32_7 VDD VSS sg13g2_decap_8
X_1052_ _1052_/Q _1083_/CLK _1052_/D _1052_/RESET_B VDD VSS sg13g2_dfrbpq_1
XFILLER_21_305 VDD VSS sg13g2_fill_2
XFILLER_33_187 VDD VSS sg13g2_fill_1
X_0905_ _0908_/A _0925_/A1 _0900_/Y _1078_/Q VDD VSS sg13g2_a21oi_1
X_0836_ _0836_/Y _0968_/A _0988_/B _0966_/B _0984_/D VDD VSS sg13g2_nand4_1
X_0767_ _1044_/D _0767_/A _0767_/B VDD VSS sg13g2_nor2_1
X_0698_ _0698_/Y _1070_/Q _0711_/B1 _0722_/B1 VDD VSS sg13g2_a21oi_1
XFILLER_21_21 VDD VSS sg13g2_decap_8
XFILLER_21_76 VDD VSS sg13g2_decap_8
XFILLER_15_176 VDD VSS sg13g2_decap_8
XFILLER_30_146 VDD VSS sg13g2_fill_1
X_1046__363 _1046_/RESET_B VDD VSS sg13g2_tiehi
X_0621_ _1007_/D _0618_/Y _0619_/Y _0620_/Y VDD VSS sg13g2_a21oi_1
XFILLER_7_56 VDD VSS sg13g2_decap_8
X_0552_ _0992_/A _0552_/A VDD VSS sg13g2_inv_1
X_1035_ _1207_/A clkload0/A _1035_/D _1035_/RESET_B VDD VSS sg13g2_dfrbpq_1
XFILLER_38_246 VDD VSS sg13g2_decap_8
Xinput70 _0551_/A input70/A VDD VSS sg13g2_buf_1
X_0819_ _0819_/Y _0951_/A _0984_/B _0933_/B _0959_/D VDD VSS sg13g2_nand4_1
XFILLER_16_21 VDD VSS sg13g2_decap_8
Xclkbuf_4_1_0_clk_i clkload0/A clkbuf_0_clk_i/X VDD VSS sg13g2_buf_8
XFILLER_8_139 VDD VSS sg13g2_fill_2
X_1076__356 _1076_/RESET_B VDD VSS sg13g2_tiehi
X_0604_ _0604_/Y _1003_/Q _0644_/A2 _0648_/B1 VDD VSS sg13g2_o21ai_1
XFILLER_21_0 VDD VSS sg13g2_decap_8
XFILLER_26_227 VDD VSS sg13g2_fill_1
X_1018_ _1018_/Q _1070_/CLK _1018_/D _1018_/RESET_B VDD VSS sg13g2_dfrbpq_1
XFILLER_27_42 VDD VSS sg13g2_decap_8
XFILLER_27_53 VDD VSS sg13g2_fill_2
XFILLER_25_282 VDD VSS sg13g2_decap_4
XFILLER_4_46 VDD VSS sg13g2_fill_1
XFILLER_4_35 VDD VSS sg13g2_decap_8
XFILLER_16_260 VDD VSS sg13g2_decap_8
XFILLER_31_263 VDD VSS sg13g2_decap_8
X_1094__286 _1094_/RESET_B VDD VSS sg13g2_tiehi
XFILLER_22_296 VDD VSS sg13g2_fill_1
XFILLER_38_85 VDD VSS sg13g2_decap_8
XFILLER_13_252 VDD VSS sg13g2_decap_8
XFILLER_9_245 VDD VSS sg13g2_decap_8
Xclkload9 clkload9/Y clkload9/A VDD VSS sg13g2_inv_1
X_0998_ _1100_/D _0998_/A _0998_/B VDD VSS sg13g2_nor2_1
Xfanout202 _0714_/B1 _0592_/Y VDD VSS sg13g2_buf_1
Xfanout213 _0722_/A2 _0711_/B1 VDD VSS sg13g2_buf_1
Xfanout224 _0715_/A2 _0595_/Y VDD VSS sg13g2_buf_1
Xfanout235 _0959_/B _0930_/B VDD VSS sg13g2_buf_1
Xfanout246 _0943_/D _0959_/D VDD VSS sg13g2_buf_1
Xfanout257 _0731_/A _0997_/B1 VDD VSS sg13g2_buf_1
Xfanout268 _0656_/B1 fanout269/X VDD VSS sg13g2_buf_1
XFILLER_10_200 VDD VSS sg13g2_fill_2
XFILLER_24_21 VDD VSS sg13g2_decap_8
XFILLER_40_64 VDD VSS sg13g2_fill_2
XFILLER_40_42 VDD VSS sg13g2_decap_8
XFILLER_18_300 VDD VSS sg13g2_decap_4
XFILLER_1_14 VDD VSS sg13g2_decap_8
X_0921_ _0924_/A _0929_/A1 _0900_/Y _1082_/Q VDD VSS sg13g2_a21oi_1
X_0852_ _0852_/Y _0984_/A _0984_/B _0933_/B _0984_/D VDD VSS sg13g2_nand4_1
X_0783_ _0784_/B _0911_/A1 _0782_/Y _0911_/B1 VDD VSS sg13g2_o21ai_1
X_1095__370 _1095_/RESET_B VDD VSS sg13g2_tiehi
XFILLER_28_119 VDD VSS sg13g2_fill_1
Xinput2 input2/X gpio_in[10] VDD VSS sg13g2_buf_1
XFILLER_36_130 VDD VSS sg13g2_decap_8
XFILLER_19_108 VDD VSS sg13g2_decap_8
XFILLER_19_21 VDD VSS sg13g2_decap_8
XFILLER_19_87 VDD VSS sg13g2_decap_8
XFILLER_30_328 VDD VSS sg13g2_decap_8
XFILLER_42_188 VDD VSS sg13g2_decap_4
XFILLER_35_53 VDD VSS sg13g2_decap_8
XFILLER_25_7 VDD VSS sg13g2_decap_8
X_1051_ _1051_/Q _1083_/CLK _1051_/D _1051_/RESET_B VDD VSS sg13g2_dfrbpq_1
XFILLER_33_122 VDD VSS sg13g2_fill_2
XFILLER_33_133 VDD VSS sg13g2_fill_2
X_0904_ _0904_/Y _0904_/A _0904_/B VDD VSS sg13g2_nor2_1
X_0835_ _0838_/A _0987_/A1 _0834_/Y _1061_/Q VDD VSS sg13g2_a21oi_1
X_0766_ _0767_/B _0890_/A1 _0765_/Y _0878_/B1 VDD VSS sg13g2_o21ai_1
X_0697_ _1026_/D _0694_/Y _0695_/Y _0696_/Y VDD VSS sg13g2_a21oi_1
XFILLER_24_133 VDD VSS sg13g2_decap_8
XFILLER_24_166 VDD VSS sg13g2_decap_4
XFILLER_24_199 VDD VSS sg13g2_decap_8
X_1028__297 _1028_/RESET_B VDD VSS sg13g2_tiehi
XFILLER_30_125 VDD VSS sg13g2_decap_8
X_0620_ _0620_/Y _1007_/Q _0644_/A2 _0960_/B1 VDD VSS sg13g2_o21ai_1
X_0551_ _0996_/A _0551_/A VDD VSS sg13g2_inv_1
XFILLER_7_35 VDD VSS sg13g2_decap_8
XFILLER_38_214 VDD VSS sg13g2_decap_8
X_1034_ _1034_/Q clkload8/A _1034_/D _1034_/RESET_B VDD VSS sg13g2_dfrbpq_1
XFILLER_21_136 VDD VSS sg13g2_decap_8
Xinput60 _0579_/A input60/A VDD VSS sg13g2_buf_1
Xinput71 _0566_/A input71/A VDD VSS sg13g2_buf_1
X_0818_ _0821_/A _0983_/A1 _0801_/Y _1057_/Q VDD VSS sg13g2_a21oi_1
X_0749_ _0749_/Y _0881_/A _0889_/B _0867_/B _0881_/D VDD VSS sg13g2_nand4_1
XFILLER_32_21 VDD VSS sg13g2_decap_8
XFILLER_20_180 VDD VSS sg13g2_decap_8
XFILLER_35_206 VDD VSS sg13g2_decap_8
XFILLER_11_191 VDD VSS sg13g2_decap_8
X_1083__306 _1083_/RESET_B VDD VSS sg13g2_tiehi
XFILLER_7_140 VDD VSS sg13g2_decap_8
X_0603_ _0603_/Y _1062_/Q _0647_/A2 _0647_/B1 input12/X VDD VSS sg13g2_a22oi_1
XFILLER_7_195 VDD VSS sg13g2_decap_8
XFILLER_14_0 VDD VSS sg13g2_decap_8
XFILLER_34_272 VDD VSS sg13g2_decap_4
XFILLER_34_294 VDD VSS sg13g2_decap_8
X_1017_ _1017_/Q clkload7/A _1017_/D _1017_/RESET_B VDD VSS sg13g2_dfrbpq_1
XFILLER_17_228 VDD VSS sg13g2_decap_8
XFILLER_27_21 VDD VSS sg13g2_decap_8
XFILLER_32_209 VDD VSS sg13g2_decap_4
XFILLER_43_42 VDD VSS sg13g2_decap_8
XFILLER_4_14 VDD VSS sg13g2_decap_8
XFILLER_31_242 VDD VSS sg13g2_decap_8
XFILLER_39_331 VDD VSS sg13g2_decap_4
XFILLER_13_56 VDD VSS sg13g2_decap_4
XFILLER_22_275 VDD VSS sg13g2_decap_8
XFILLER_1_102 VDD VSS sg13g2_fill_1
XFILLER_1_113 VDD VSS sg13g2_decap_4
XFILLER_1_157 VDD VSS sg13g2_fill_1
XFILLER_38_42 VDD VSS sg13g2_fill_2
X_1010__333 _1010_/RESET_B VDD VSS sg13g2_tiehi
XFILLER_13_275 VDD VSS sg13g2_decap_4
XFILLER_9_213 VDD VSS sg13g2_decap_4
XFILLER_36_312 VDD VSS sg13g2_decap_8
X_0997_ _0998_/B _0997_/A1 _0996_/Y _0997_/B1 VDD VSS sg13g2_o21ai_1
Xfanout203 _0702_/B1 _0722_/B1 VDD VSS sg13g2_buf_1
Xfanout214 _0711_/B1 _0597_/Y VDD VSS sg13g2_buf_1
Xfanout225 _0933_/B _0966_/B VDD VSS sg13g2_buf_1
Xfanout236 _0910_/B _0926_/B VDD VSS sg13g2_buf_1
Xfanout247 _0959_/D _0963_/D VDD VSS sg13g2_buf_1
Xfanout258 _0997_/B1 _0936_/B1 VDD VSS sg13g2_buf_1
Xfanout269 fanout269/X fanout274/X VDD VSS sg13g2_buf_1
XFILLER_6_216 VDD VSS sg13g2_fill_2
XFILLER_40_21 VDD VSS sg13g2_decap_8
XFILLER_40_98 VDD VSS sg13g2_decap_8
X_0920_ _0920_/Y _0920_/A _0920_/B VDD VSS sg13g2_nor2_1
X_0851_ _0854_/A _0983_/A1 _0834_/Y _1065_/Q VDD VSS sg13g2_a21oi_1
X_0782_ _0782_/Y _0914_/A _0910_/B _0798_/C _0914_/D VDD VSS sg13g2_nand4_1
XFILLER_24_326 VDD VSS sg13g2_decap_8
XFILLER_24_337 VDD VSS sg13g2_fill_2
Xinput3 input3/X gpio_in[11] VDD VSS sg13g2_buf_1
XFILLER_10_35 VDD VSS sg13g2_decap_8
XFILLER_10_57 VDD VSS sg13g2_decap_4
XFILLER_19_99 VDD VSS sg13g2_fill_1
XFILLER_35_32 VDD VSS sg13g2_decap_8
XFILLER_18_164 VDD VSS sg13g2_decap_8
XFILLER_18_7 VDD VSS sg13g2_decap_8
X_1050_ _1050_/Q clkload0/A _1050_/D _1050_/RESET_B VDD VSS sg13g2_dfrbpq_1
XFILLER_21_307 VDD VSS sg13g2_fill_1
X_0903_ _0904_/B _0911_/A1 _0902_/Y _0911_/B1 VDD VSS sg13g2_o21ai_1
X_0834_ _0834_/Y _0966_/A _0992_/C _0966_/C VDD VSS sg13g2_nor3_1
X_0765_ _0765_/Y _0897_/A _0889_/B _0867_/B _0881_/D VDD VSS sg13g2_nand4_1
X_0696_ _0696_/Y _1026_/Q _0593_/B _0704_/B1 VDD VSS sg13g2_o21ai_1
XFILLER_12_329 VDD VSS sg13g2_decap_8
XFILLER_24_189 VDD VSS sg13g2_decap_4
X_1067__292 _1067_/RESET_B VDD VSS sg13g2_tiehi
Xoutput170 s_axil_rdata[3] _1005_/Q VDD VSS sg13g2_buf_1
XFILLER_15_112 VDD VSS sg13g2_fill_1
XFILLER_11_340 VDD VSS sg13g2_decap_8
XFILLER_7_333 VDD VSS sg13g2_decap_8
XFILLER_7_14 VDD VSS sg13g2_decap_8
XFILLER_21_104 VDD VSS sg13g2_decap_8
XFILLER_21_115 VDD VSS sg13g2_fill_1
X_1033_ _1033_/Q _1033_/CLK _1033_/D _1033_/RESET_B VDD VSS sg13g2_dfrbpq_1
Xinput50 _0572_/A input50/A VDD VSS sg13g2_buf_1
Xinput61 _0578_/A input61/A VDD VSS sg13g2_buf_1
Xinput72 _0565_/A input72/A VDD VSS sg13g2_buf_1
X_0817_ _1056_/D _0817_/A _0817_/B VDD VSS sg13g2_nor2_1
X_0748_ _0751_/A _0942_/A1 _0735_/Y _1040_/Q VDD VSS sg13g2_a21oi_1
X_0679_ _0679_/Y _1049_/Q _0695_/A2 _0699_/B1 input13/X VDD VSS sg13g2_a22oi_1
XFILLER_29_226 VDD VSS sg13g2_decap_8
Xperipherals_macro_275 s_axil_bresp[1] VDD VSS sg13g2_tielo
XFILLER_37_292 VDD VSS sg13g2_decap_8
XFILLER_12_148 VDD VSS sg13g2_decap_8
XFILLER_12_159 VDD VSS sg13g2_fill_1
XFILLER_16_89 VDD VSS sg13g2_decap_8
XFILLER_4_336 VDD VSS sg13g2_decap_8
X_1020__313 _1020_/RESET_B VDD VSS sg13g2_tiehi
X_0602_ _0602_/Y _1094_/Q _0654_/A2 _0654_/B1 VDD VSS sg13g2_a21oi_1
XFILLER_26_218 VDD VSS sg13g2_decap_8
X_1016_ _1016_/Q clkload5/A _1016_/D _1016_/RESET_B VDD VSS sg13g2_dfrbpq_1
XFILLER_17_207 VDD VSS sg13g2_decap_8
XFILLER_25_262 VDD VSS sg13g2_decap_8
XFILLER_27_55 VDD VSS sg13g2_fill_1
XFILLER_27_88 VDD VSS sg13g2_decap_8
XFILLER_43_21 VDD VSS sg13g2_decap_8
XFILLER_40_221 VDD VSS sg13g2_decap_8
XFILLER_4_199 VDD VSS sg13g2_decap_4
XFILLER_4_100 VDD VSS sg13g2_decap_8
XFILLER_13_35 VDD VSS sg13g2_decap_8
XFILLER_22_221 VDD VSS sg13g2_fill_1
XFILLER_38_21 VDD VSS sg13g2_decap_8
XFILLER_13_298 VDD VSS sg13g2_decap_8
XFILLER_36_346 VDD VSS sg13g2_fill_1
X_0996_ _0996_/Y _0996_/A _0996_/B _0996_/C _0996_/D VDD VSS sg13g2_nand4_1
Xfanout204 _0722_/B1 _0592_/Y VDD VSS sg13g2_buf_1
XFILLER_27_313 VDD VSS sg13g2_fill_2
Xfanout215 _0647_/B1 _0686_/A2 VDD VSS sg13g2_buf_1
Xfanout226 _0966_/B _0900_/B VDD VSS sg13g2_buf_1
Xfanout237 _0926_/B _0930_/B VDD VSS sg13g2_buf_1
Xfanout248 _0984_/D _0996_/D VDD VSS sg13g2_buf_1
Xfanout259 _0985_/B1 _0936_/B1 VDD VSS sg13g2_buf_1
X_1072__372 _1072_/RESET_B VDD VSS sg13g2_tiehi
XFILLER_24_56 VDD VSS sg13g2_decap_4
XFILLER_24_67 VDD VSS sg13g2_decap_8
XFILLER_27_346 VDD VSS sg13g2_fill_1
XFILLER_10_224 VDD VSS sg13g2_decap_4
XFILLER_40_66 VDD VSS sg13g2_fill_1
XFILLER_18_335 VDD VSS sg13g2_decap_8
XFILLER_18_346 VDD VSS sg13g2_fill_1
XFILLER_1_49 VDD VSS sg13g2_decap_8
X_1038__278 _1038_/RESET_B VDD VSS sg13g2_tiehi
X_1084__298 _1084_/RESET_B VDD VSS sg13g2_tiehi
X_0850_ _1064_/D _0850_/A _0850_/B VDD VSS sg13g2_nor2_1
X_0781_ _0784_/A _0925_/A1 _0768_/Y _1048_/Q VDD VSS sg13g2_a21oi_1
Xinput4 input4/X gpio_in[12] VDD VSS sg13g2_buf_1
XFILLER_24_305 VDD VSS sg13g2_decap_8
X_0979_ _0982_/A _0987_/A1 _0966_/Y _1096_/Q VDD VSS sg13g2_a21oi_1
XFILLER_10_14 VDD VSS sg13g2_decap_8
XFILLER_10_69 VDD VSS sg13g2_decap_8
XFILLER_35_11 VDD VSS sg13g2_decap_8
XFILLER_27_187 VDD VSS sg13g2_decap_8
XFILLER_42_124 VDD VSS sg13g2_fill_1
XFILLER_35_88 VDD VSS sg13g2_fill_2
XFILLER_4_0 VDD VSS sg13g2_decap_8
XFILLER_33_124 VDD VSS sg13g2_fill_1
XFILLER_33_157 VDD VSS sg13g2_decap_8
X_0902_ _0902_/Y _0902_/A _0910_/B _0926_/C _0914_/D VDD VSS sg13g2_nand4_1
X_0833_ _1060_/D _0833_/A _0833_/B VDD VSS sg13g2_nor2_1
XFILLER_41_190 VDD VSS sg13g2_decap_4
X_0764_ _0767_/A _0942_/A1 _0735_/Y _1044_/Q VDD VSS sg13g2_a21oi_1
X_0695_ _0695_/Y _1037_/Q _0695_/A2 _0699_/B1 input17/X VDD VSS sg13g2_a22oi_1
XFILLER_37_0 VDD VSS sg13g2_decap_8
XFILLER_21_35 VDD VSS sg13g2_fill_2
Xoutput171 s_axil_rdata[4] _1006_/Q VDD VSS sg13g2_buf_1
Xoutput160 s_axil_rdata[23] _1025_/Q VDD VSS sg13g2_buf_1
XFILLER_15_124 VDD VSS sg13g2_decap_8
X_1007__339 _1007_/RESET_B VDD VSS sg13g2_tiehi
XFILLER_7_312 VDD VSS sg13g2_decap_8
XFILLER_30_7 VDD VSS sg13g2_decap_8
X_1101_ _1101_/Q clkload2/A _1101_/D _1101_/RESET_B VDD VSS sg13g2_dfrbpq_1
X_1053__348 _1053_/RESET_B VDD VSS sg13g2_tiehi
X_1032_ _1032_/Q clkload9/A _1032_/D _1032_/RESET_B VDD VSS sg13g2_dfrbpq_1
XFILLER_38_205 VDD VSS sg13g2_decap_4
Xinput40 _0733_/B input40/A VDD VSS sg13g2_buf_1
Xinput51 _0571_/A input51/A VDD VSS sg13g2_buf_1
Xinput62 _0577_/A input62/A VDD VSS sg13g2_buf_1
Xinput73 _0980_/D input73/A VDD VSS sg13g2_buf_1
X_0816_ _0817_/B _0985_/A1 _0815_/Y _0960_/B1 VDD VSS sg13g2_o21ai_1
X_0747_ _1039_/D _0747_/A _0747_/B VDD VSS sg13g2_nor2_1
XFILLER_29_205 VDD VSS sg13g2_decap_8
X_0678_ _0678_/Y _1081_/Q _0702_/A2 _0702_/B1 VDD VSS sg13g2_a21oi_1
XFILLER_16_35 VDD VSS sg13g2_fill_1
XFILLER_16_68 VDD VSS sg13g2_decap_8
Xperipherals_macro_276 s_axil_rresp[0] VDD VSS sg13g2_tielo
XFILLER_4_315 VDD VSS sg13g2_fill_2
XFILLER_4_304 VDD VSS sg13g2_fill_1
XFILLER_28_293 VDD VSS sg13g2_decap_8
X_0601_ _1002_/D _0598_/Y _0599_/Y _0600_/Y VDD VSS sg13g2_a21oi_1
XFILLER_19_260 VDD VSS sg13g2_decap_4
XFILLER_19_271 VDD VSS sg13g2_decap_8
X_1015_ _1015_/Q clkload7/A _1015_/D _1015_/RESET_B VDD VSS sg13g2_dfrbpq_1
XFILLER_25_230 VDD VSS sg13g2_fill_2
XFILLER_27_67 VDD VSS sg13g2_decap_8
X_1043__369 _1043_/RESET_B VDD VSS sg13g2_tiehi
XFILLER_16_274 VDD VSS sg13g2_decap_8
XFILLER_13_14 VDD VSS sg13g2_decap_8
XFILLER_8_7 VDD VSS sg13g2_decap_8
XFILLER_38_99 VDD VSS sg13g2_fill_2
XFILLER_38_44 VDD VSS sg13g2_fill_1
X_1089__358 _1089_/RESET_B VDD VSS sg13g2_tiehi
X_0995_ _0998_/A _0995_/A1 _0966_/Y _1100_/Q VDD VSS sg13g2_a21oi_1
Xfanout205 _0644_/A2 _0656_/A2 VDD VSS sg13g2_buf_1
Xfanout216 _0686_/A2 _0596_/Y VDD VSS sg13g2_buf_1
Xfanout227 _0798_/C _0900_/B VDD VSS sg13g2_buf_1
Xfanout238 _0889_/B _0897_/B VDD VSS sg13g2_buf_1
Xfanout249 _0996_/D _0980_/D VDD VSS sg13g2_buf_1
XFILLER_39_196 VDD VSS sg13g2_fill_1
XFILLER_39_185 VDD VSS sg13g2_decap_8
XFILLER_10_214 VDD VSS sg13g2_decap_4
XFILLER_24_35 VDD VSS sg13g2_decap_8
XFILLER_1_28 VDD VSS sg13g2_decap_8
XFILLER_33_306 VDD VSS sg13g2_fill_2
X_0780_ _1047_/D _0780_/A _0780_/B VDD VSS sg13g2_nor2_1
Xinput5 input5/X gpio_in[13] VDD VSS sg13g2_buf_1
X_1017__319 _1017_/RESET_B VDD VSS sg13g2_tiehi
XFILLER_36_144 VDD VSS sg13g2_decap_8
XFILLER_36_188 VDD VSS sg13g2_fill_2
X_0978_ _1095_/D _0978_/A _0978_/B VDD VSS sg13g2_nor2_1
XFILLER_19_35 VDD VSS sg13g2_decap_8
XFILLER_27_166 VDD VSS sg13g2_decap_8
XFILLER_35_67 VDD VSS sg13g2_decap_8
XFILLER_18_122 VDD VSS sg13g2_fill_1
X_0901_ _0904_/A _0925_/A1 _0900_/Y _1077_/Q VDD VSS sg13g2_a21oi_1
X_0832_ _0833_/B _0940_/A1 _0831_/Y _0964_/B1 VDD VSS sg13g2_o21ai_1
X_0763_ _1043_/D _0763_/A _0763_/B VDD VSS sg13g2_nor2_1
X_0694_ _0694_/Y _1069_/Q _0702_/A2 _0702_/B1 VDD VSS sg13g2_a21oi_1
XFILLER_24_114 VDD VSS sg13g2_fill_2
XFILLER_20_331 VDD VSS sg13g2_fill_2
XFILLER_21_14 VDD VSS sg13g2_decap_8
XFILLER_21_69 VDD VSS sg13g2_decap_8
Xoutput161 s_axil_rdata[24] _1026_/Q VDD VSS sg13g2_buf_1
Xoutput150 s_axil_rdata[14] _1016_/Q VDD VSS sg13g2_buf_1
Xoutput172 s_axil_rdata[5] _1007_/Q VDD VSS sg13g2_buf_1
XFILLER_15_169 VDD VSS sg13g2_decap_8
XFILLER_30_139 VDD VSS sg13g2_decap_8
XFILLER_7_49 VDD VSS sg13g2_decap_8
XFILLER_23_7 VDD VSS sg13g2_decap_8
X_1100_ _1100_/Q _1100_/CLK _1100_/D _1100_/RESET_B VDD VSS sg13g2_dfrbpq_1
X_1031_ _1031_/Q clkload9/A _1031_/D _1031_/RESET_B VDD VSS sg13g2_dfrbpq_1
XFILLER_38_239 VDD VSS sg13g2_decap_8
Xinput30 input30/X gpio_in[7] VDD VSS sg13g2_buf_1
Xinput41 _0558_/A input41/A VDD VSS sg13g2_buf_1
Xinput52 _0557_/A input52/A VDD VSS sg13g2_buf_1
Xinput63 _0556_/A input63/A VDD VSS sg13g2_buf_1
Xinput74 _0963_/D input74/A VDD VSS sg13g2_buf_1
X_0815_ _0815_/Y _0947_/A _0984_/B _0933_/B _0959_/D VDD VSS sg13g2_nand4_1
X_0746_ _0747_/B _0890_/A1 _0745_/Y _0878_/B1 VDD VSS sg13g2_o21ai_1
Xperipherals_macro_277 s_axil_rresp[1] VDD VSS sg13g2_tielo
X_0677_ _1021_/D _0674_/Y _0675_/Y _0676_/Y VDD VSS sg13g2_a21oi_1
XFILLER_12_117 VDD VSS sg13g2_fill_2
XFILLER_16_14 VDD VSS sg13g2_decap_8
XFILLER_37_272 VDD VSS sg13g2_fill_1
XFILLER_12_128 VDD VSS sg13g2_fill_2
XFILLER_20_194 VDD VSS sg13g2_fill_2
XFILLER_32_35 VDD VSS sg13g2_decap_8
XFILLER_28_250 VDD VSS sg13g2_decap_8
XFILLER_43_297 VDD VSS sg13g2_decap_8
X_0600_ _0600_/Y _1002_/Q _0644_/A2 _0648_/B1 VDD VSS sg13g2_o21ai_1
XFILLER_7_154 VDD VSS sg13g2_decap_8
XFILLER_34_253 VDD VSS sg13g2_decap_4
X_1014_ _1014_/Q clkload7/A _1014_/D _1014_/RESET_B VDD VSS sg13g2_dfrbpq_1
X_0729_ _0729_/Y _1207_/A _0729_/B _0729_/C VDD VSS sg13g2_nor3_1
XFILLER_27_35 VDD VSS sg13g2_decap_8
X_1075__360 _1075_/RESET_B VDD VSS sg13g2_tiehi
XFILLER_25_242 VDD VSS sg13g2_decap_8
XFILLER_43_56 VDD VSS sg13g2_fill_1
XFILLER_40_245 VDD VSS sg13g2_decap_4
XFILLER_40_234 VDD VSS sg13g2_decap_4
XFILLER_4_28 VDD VSS sg13g2_decap_8
XFILLER_31_256 VDD VSS sg13g2_decap_8
XFILLER_31_289 VDD VSS sg13g2_decap_8
XFILLER_12_0 VDD VSS sg13g2_decap_8
XFILLER_39_301 VDD VSS sg13g2_decap_8
XFILLER_22_256 VDD VSS sg13g2_fill_1
XFILLER_22_289 VDD VSS sg13g2_decap_8
Xhold430 input61/A s_axil_wdata[28] VDD VSS sg13g2_dlygate4sd3_1
XFILLER_38_78 VDD VSS sg13g2_decap_8
XFILLER_38_56 VDD VSS sg13g2_fill_2
XFILLER_13_245 VDD VSS sg13g2_decap_8
XFILLER_9_238 VDD VSS sg13g2_decap_8
X_0994_ _1099_/D _0994_/A _0994_/B VDD VSS sg13g2_nor2_1
Xfanout206 _0656_/A2 _0591_/Y VDD VSS sg13g2_buf_1
Xfanout217 _0699_/B1 _0596_/Y VDD VSS sg13g2_buf_1
Xfanout228 _0867_/B _0831_/C VDD VSS sg13g2_buf_1
Xfanout239 _0897_/B _0963_/B VDD VSS sg13g2_buf_1
XFILLER_10_237 VDD VSS sg13g2_fill_2
XFILLER_10_259 VDD VSS sg13g2_decap_8
XFILLER_24_14 VDD VSS sg13g2_decap_8
XFILLER_40_57 VDD VSS sg13g2_decap_8
XFILLER_40_35 VDD VSS sg13g2_decap_8
XFILLER_18_304 VDD VSS sg13g2_fill_2
XFILLER_33_318 VDD VSS sg13g2_fill_1
X_1056__336 _1056_/RESET_B VDD VSS sg13g2_tiehi
XFILLER_5_263 VDD VSS sg13g2_fill_2
Xinput6 input6/X gpio_in[14] VDD VSS sg13g2_buf_1
XFILLER_36_178 VDD VSS sg13g2_decap_4
XFILLER_36_123 VDD VSS sg13g2_decap_8
X_0977_ _0978_/B _0989_/A1 _0976_/Y _0731_/A VDD VSS sg13g2_o21ai_1
XFILLER_19_14 VDD VSS sg13g2_decap_8
X_1037__280 _1037_/RESET_B VDD VSS sg13g2_tiehi
XFILLER_35_46 VDD VSS sg13g2_fill_2
XFILLER_18_178 VDD VSS sg13g2_decap_4
XFILLER_33_115 VDD VSS sg13g2_decap_8
X_0900_ _0900_/Y _0900_/A _0900_/B _0900_/C VDD VSS sg13g2_nor3_1
X_0831_ _0831_/Y _0963_/A _0939_/B _0831_/C _0943_/D VDD VSS sg13g2_nand4_1
X_0762_ _0763_/B _0898_/A1 _0761_/Y _0878_/B1 VDD VSS sg13g2_o21ai_1
X_0693_ _1025_/D _0690_/Y _0691_/Y _0692_/Y VDD VSS sg13g2_a21oi_1
XFILLER_24_126 VDD VSS sg13g2_decap_8
XFILLER_21_37 VDD VSS sg13g2_fill_1
Xoutput173 s_axil_rdata[6] _1008_/Q VDD VSS sg13g2_buf_1
Xoutput162 s_axil_rdata[25] _1027_/Q VDD VSS sg13g2_buf_1
Xoutput151 s_axil_rdata[15] _1017_/Q VDD VSS sg13g2_buf_1
Xoutput140 gpio_out[8] _1053_/Q VDD VSS sg13g2_buf_1
XFILLER_23_181 VDD VSS sg13g2_fill_2
XFILLER_30_118 VDD VSS sg13g2_decap_8
XFILLER_7_28 VDD VSS sg13g2_decap_8
XFILLER_16_7 VDD VSS sg13g2_decap_8
X_1030_ _1030_/Q clkload9/A _1030_/D _1030_/RESET_B VDD VSS sg13g2_dfrbpq_1
XFILLER_14_192 VDD VSS sg13g2_decap_8
XFILLER_21_129 VDD VSS sg13g2_decap_8
Xinput20 input20/X gpio_in[27] VDD VSS sg13g2_buf_1
Xinput31 input31/X gpio_in[8] VDD VSS sg13g2_buf_1
X_0814_ _0817_/A _0983_/A1 _0801_/Y _1056_/Q VDD VSS sg13g2_a21oi_1
Xinput42 _0564_/A input42/A VDD VSS sg13g2_buf_1
Xinput53 _0570_/A input53/A VDD VSS sg13g2_buf_1
Xinput64 _0576_/A input64/A VDD VSS sg13g2_buf_1
Xinput75 _0930_/D input75/A VDD VSS sg13g2_buf_1
X_0745_ _0745_/Y _0877_/A _0889_/B _0867_/B _0881_/D VDD VSS sg13g2_nand4_1
X_0676_ _0676_/Y _1021_/Q _0593_/B _0704_/B1 VDD VSS sg13g2_o21ai_1
XFILLER_42_0 VDD VSS sg13g2_decap_8
XFILLER_20_173 VDD VSS sg13g2_decap_8
XFILLER_32_14 VDD VSS sg13g2_decap_8
X_1006__341 _1006_/RESET_B VDD VSS sg13g2_tiehi
XFILLER_7_188 VDD VSS sg13g2_decap_8
XFILLER_7_133 VDD VSS sg13g2_decap_8
XFILLER_34_276 VDD VSS sg13g2_fill_2
XFILLER_34_287 VDD VSS sg13g2_decap_8
X_1013_ _1013_/Q _1091_/CLK _1013_/D _1013_/RESET_B VDD VSS sg13g2_dfrbpq_1
X_0728_ _0729_/C _0730_/C _0730_/D VDD VSS sg13g2_nand2_1
X_0659_ _0659_/Y _1060_/Q hold435/X _0714_/A2 input7/X VDD VSS sg13g2_a22oi_1
XFILLER_25_232 VDD VSS sg13g2_fill_1
XFILLER_27_14 VDD VSS sg13g2_decap_8
XFILLER_43_35 VDD VSS sg13g2_decap_8
XFILLER_40_213 VDD VSS sg13g2_fill_2
XFILLER_4_147 VDD VSS sg13g2_fill_2
XFILLER_4_114 VDD VSS sg13g2_fill_2
XFILLER_31_202 VDD VSS sg13g2_fill_1
XFILLER_31_235 VDD VSS sg13g2_decap_8
XFILLER_22_268 VDD VSS sg13g2_decap_8
XFILLER_13_49 VDD VSS sg13g2_decap_8
XFILLER_1_106 VDD VSS sg13g2_decap_8
Xhold420 input57/A s_axil_wdata[24] VDD VSS sg13g2_dlygate4sd3_1
Xhold431 input46/A s_axil_wdata[14] VDD VSS sg13g2_dlygate4sd3_1
X_1042__371 _1042_/RESET_B VDD VSS sg13g2_tiehi
XFILLER_38_35 VDD VSS sg13g2_decap_8
XFILLER_13_268 VDD VSS sg13g2_decap_8
XFILLER_13_279 VDD VSS sg13g2_fill_1
XFILLER_9_217 VDD VSS sg13g2_fill_2
XFILLER_9_206 VDD VSS sg13g2_decap_8
X_0993_ _0994_/B _0997_/A1 _0992_/Y _0731_/A VDD VSS sg13g2_o21ai_1
XFILLER_8_261 VDD VSS sg13g2_decap_8
Xclkbuf_4_14_0_clk_i clkload9/A clkbuf_0_clk_i/X VDD VSS sg13g2_buf_8
Xfanout207 _0593_/B _0712_/A2 VDD VSS sg13g2_buf_1
Xfanout218 _0723_/B1 _0714_/A2 VDD VSS sg13g2_buf_1
Xfanout229 _0831_/C _0900_/B VDD VSS sg13g2_buf_1
XFILLER_5_94 VDD VSS sg13g2_decap_8
XFILLER_39_132 VDD VSS sg13g2_decap_8
XFILLER_39_110 VDD VSS sg13g2_decap_8
XFILLER_42_308 VDD VSS sg13g2_decap_4
XFILLER_6_209 VDD VSS sg13g2_decap_8
XFILLER_40_14 VDD VSS sg13g2_decap_8
XFILLER_14_70 VDD VSS sg13g2_fill_1
XFILLER_24_319 VDD VSS sg13g2_decap_8
Xinput7 input7/X gpio_in[15] VDD VSS sg13g2_buf_1
X_1063__308 _1063_/RESET_B VDD VSS sg13g2_tiehi
X_0976_ _0976_/Y _0976_/A _0988_/B _0992_/C _0996_/D VDD VSS sg13g2_nand4_1
XFILLER_10_28 VDD VSS sg13g2_decap_8
XFILLER_27_102 VDD VSS sg13g2_decap_8
XFILLER_27_124 VDD VSS sg13g2_decap_4
XFILLER_42_116 VDD VSS sg13g2_fill_2
XFILLER_35_25 VDD VSS sg13g2_decap_8
XFILLER_2_234 VDD VSS sg13g2_fill_1
XFILLER_2_289 VDD VSS sg13g2_fill_2
XFILLER_18_157 VDD VSS sg13g2_fill_2
X_1016__321 _1016_/RESET_B VDD VSS sg13g2_tiehi
X_0830_ _0833_/A _0995_/A1 _0801_/Y _1060_/Q VDD VSS sg13g2_a21oi_1
XFILLER_41_160 VDD VSS sg13g2_decap_4
X_0761_ _0761_/Y _0893_/A _0897_/B _0831_/C _0897_/D VDD VSS sg13g2_nand4_1
X_0692_ _0692_/Y _1025_/Q _0593_/B _0704_/B1 VDD VSS sg13g2_o21ai_1
XFILLER_20_333 VDD VSS sg13g2_fill_1
XFILLER_32_171 VDD VSS sg13g2_decap_4
X_0959_ _0959_/Y _0959_/A _0959_/B _0996_/C _0959_/D VDD VSS sg13g2_nand4_1
Xoutput174 s_axil_rdata[7] _1009_/Q VDD VSS sg13g2_buf_1
Xoutput163 s_axil_rdata[26] _1028_/Q VDD VSS sg13g2_buf_1
Xoutput152 s_axil_rdata[16] _1018_/Q VDD VSS sg13g2_buf_1
Xoutput141 gpio_out[9] _1054_/Q VDD VSS sg13g2_buf_1
Xoutput130 gpio_out[28] _1041_/Q VDD VSS sg13g2_buf_1
XFILLER_11_333 VDD VSS sg13g2_decap_8
XFILLER_15_138 VDD VSS sg13g2_fill_2
XFILLER_11_82 VDD VSS sg13g2_decap_8
XFILLER_2_0 VDD VSS sg13g2_decap_8
XFILLER_7_326 VDD VSS sg13g2_decap_8
XFILLER_14_171 VDD VSS sg13g2_decap_8
Xinput10 input10/X gpio_in[18] VDD VSS sg13g2_buf_1
Xinput21 input21/X gpio_in[28] VDD VSS sg13g2_buf_1
Xinput32 input32/X gpio_in[9] VDD VSS sg13g2_buf_1
Xinput43 _0563_/A input43/A VDD VSS sg13g2_buf_1
Xinput54 _0569_/A input54/A VDD VSS sg13g2_buf_1
X_0813_ _1055_/D _0813_/A _0813_/B VDD VSS sg13g2_nor2_1
Xinput65 _0575_/A input65/A VDD VSS sg13g2_buf_1
Xinput76 _0893_/D input76/A VDD VSS sg13g2_buf_1
X_0744_ _0747_/A _0942_/A1 _0735_/Y _1039_/Q VDD VSS sg13g2_a21oi_1
X_0675_ _0675_/Y _1048_/Q _0695_/A2 _0699_/B1 input11/X VDD VSS sg13g2_a22oi_1
XFILLER_29_219 VDD VSS sg13g2_decap_8
XFILLER_37_285 VDD VSS sg13g2_decap_8
XFILLER_37_252 VDD VSS sg13g2_decap_4
XFILLER_20_130 VDD VSS sg13g2_decap_8
X_1089_ _1089_/Q _1091_/CLK _1089_/D _1089_/RESET_B VDD VSS sg13g2_dfrbpq_1
XFILLER_20_196 VDD VSS sg13g2_fill_1
XFILLER_4_329 VDD VSS sg13g2_decap_8
X_1052__351 _1052_/RESET_B VDD VSS sg13g2_tiehi
XFILLER_11_152 VDD VSS sg13g2_decap_8
X_1012_ _1012_/Q clkload5/A _1012_/D _1012_/RESET_B VDD VSS sg13g2_dfrbpq_1
XFILLER_19_285 VDD VSS sg13g2_decap_8
X_0727_ _1034_/D _0727_/A _0727_/B VDD VSS sg13g2_nand2_1
X_0658_ _0658_/Y _1092_/Q _0711_/B1 _0722_/B1 VDD VSS sg13g2_a21oi_1
X_0589_ _0933_/C _0959_/D VDD VSS sg13g2_inv_1
XFILLER_43_14 VDD VSS sg13g2_decap_8
X_1059__324 _1059_/RESET_B VDD VSS sg13g2_tiehi
XFILLER_13_28 VDD VSS sg13g2_decap_8
XFILLER_30_291 VDD VSS sg13g2_decap_8
Xclkbuf_4_10_0_clk_i clkload6/A clkbuf_0_clk_i/X VDD VSS sg13g2_buf_8
Xhold410 hold410/X _0930_/Y VDD VSS sg13g2_dlygate4sd3_1
Xhold421 input52/A s_axil_wdata[1] VDD VSS sg13g2_dlygate4sd3_1
Xhold432 input44/A s_axil_wdata[12] VDD VSS sg13g2_dlygate4sd3_1
XFILLER_38_14 VDD VSS sg13g2_decap_8
XFILLER_36_306 VDD VSS sg13g2_fill_1
X_1026__301 _1026_/RESET_B VDD VSS sg13g2_tiehi
X_0992_ _0992_/Y _0992_/A _0996_/B _0992_/C _0996_/D VDD VSS sg13g2_nand4_1
XFILLER_27_306 VDD VSS sg13g2_decap_8
Xfanout208 _0724_/A2 _0712_/A2 VDD VSS sg13g2_buf_1
Xfanout219 _0714_/A2 _0596_/Y VDD VSS sg13g2_buf_1
XFILLER_24_49 VDD VSS sg13g2_decap_8
XFILLER_10_239 VDD VSS sg13g2_fill_1
XFILLER_6_7 VDD VSS sg13g2_decap_8
XFILLER_18_317 VDD VSS sg13g2_decap_8
XFILLER_18_328 VDD VSS sg13g2_decap_8
XFILLER_30_70 VDD VSS sg13g2_decap_8
XFILLER_5_210 VDD VSS sg13g2_decap_4
Xinput8 input8/X gpio_in[16] VDD VSS sg13g2_buf_1
XFILLER_39_7 VDD VSS sg13g2_decap_8
XFILLER_32_320 VDD VSS sg13g2_fill_2
XFILLER_36_158 VDD VSS sg13g2_decap_8
X_0975_ _0978_/A _0987_/A1 _0966_/Y _1095_/Q VDD VSS sg13g2_a21oi_1
XFILLER_19_49 VDD VSS sg13g2_fill_2
XFILLER_15_309 VDD VSS sg13g2_decap_4
XFILLER_35_48 VDD VSS sg13g2_fill_1
X_1079__338 _1079_/RESET_B VDD VSS sg13g2_tiehi
XFILLER_14_331 VDD VSS sg13g2_decap_8
XFILLER_33_106 VDD VSS sg13g2_decap_4
XFILLER_33_139 VDD VSS sg13g2_decap_8
X_0760_ _0763_/A _0942_/A1 _0735_/Y _1043_/Q VDD VSS sg13g2_a21oi_1
X_0691_ _0691_/Y _1052_/Q _0695_/A2 _0699_/B1 input16/X VDD VSS sg13g2_a22oi_1
XFILLER_17_191 VDD VSS sg13g2_decap_4
XFILLER_20_312 VDD VSS sg13g2_fill_1
XFILLER_32_150 VDD VSS sg13g2_decap_8
XFILLER_21_28 VDD VSS sg13g2_decap_8
X_0958_ _0961_/A _0958_/A1 _0933_/Y _1091_/Q VDD VSS sg13g2_a21oi_1
X_0889_ _0889_/Y _0889_/A _0889_/B _0897_/C _0897_/D VDD VSS sg13g2_nand4_1
Xoutput175 s_axil_rdata[8] _1010_/Q VDD VSS sg13g2_buf_1
Xoutput164 s_axil_rdata[27] _1029_/Q VDD VSS sg13g2_buf_1
Xoutput153 s_axil_rdata[17] _1019_/Q VDD VSS sg13g2_buf_1
Xoutput142 s_axil_arready _1001_/Q VDD VSS sg13g2_buf_1
Xoutput131 gpio_out[29] _1042_/Q VDD VSS sg13g2_buf_1
Xoutput120 gpio_out[19] _1048_/Q VDD VSS sg13g2_buf_1
X_1039__377 _1039_/RESET_B VDD VSS sg13g2_tiehi
XFILLER_15_117 VDD VSS sg13g2_decap_8
XFILLER_11_312 VDD VSS sg13g2_decap_8
XFILLER_7_305 VDD VSS sg13g2_decap_8
XFILLER_11_50 VDD VSS sg13g2_decap_4
XFILLER_36_80 VDD VSS sg13g2_decap_4
Xinput11 input11/X gpio_in[19] VDD VSS sg13g2_buf_1
Xinput22 input22/X gpio_in[29] VDD VSS sg13g2_buf_1
Xinput33 input33/X rst_ni VDD VSS sg13g2_buf_1
Xinput44 _0562_/A input44/A VDD VSS sg13g2_buf_1
Xinput55 _0568_/A input55/A VDD VSS sg13g2_buf_1
Xinput66 _0555_/A input66/A VDD VSS sg13g2_buf_1
Xinput77 _0730_/C input77/A VDD VSS sg13g2_buf_1
X_0812_ _0813_/B _0940_/A1 _0811_/Y _0964_/B1 VDD VSS sg13g2_o21ai_1
X_0743_ _1038_/D _0743_/A _0743_/B VDD VSS sg13g2_nor2_1
XFILLER_28_0 VDD VSS sg13g2_decap_8
X_0674_ _0674_/Y _1080_/Q _0702_/A2 _0702_/B1 VDD VSS sg13g2_a21oi_1
XFILLER_16_28 VDD VSS sg13g2_decap_8
X_1034__285 _1034_/RESET_B VDD VSS sg13g2_tiehi
X_1088_ _1088_/Q _1091_/CLK _1088_/D _1088_/RESET_B VDD VSS sg13g2_dfrbpq_1
XFILLER_28_286 VDD VSS sg13g2_decap_8
XFILLER_11_131 VDD VSS sg13g2_decap_8
XFILLER_3_341 VDD VSS sg13g2_fill_2
XFILLER_19_253 VDD VSS sg13g2_decap_8
XFILLER_19_264 VDD VSS sg13g2_fill_2
XFILLER_19_297 VDD VSS sg13g2_decap_8
XFILLER_21_7 VDD VSS sg13g2_decap_8
XFILLER_34_212 VDD VSS sg13g2_decap_8
X_1011_ _1011_/Q clkload7/A _1011_/D _1011_/RESET_B VDD VSS sg13g2_dfrbpq_1
X_0726_ _0727_/B _1001_/Q _0726_/B _1034_/Q VDD VSS sg13g2_nand3b_1
X_0657_ _1016_/D _0654_/Y _0655_/Y _0656_/Y VDD VSS sg13g2_a21oi_1
X_0588_ _0900_/C _0914_/D VDD VSS sg13g2_inv_1
XFILLER_25_223 VDD VSS sg13g2_decap_8
XFILLER_25_256 VDD VSS sg13g2_fill_1
XFILLER_40_215 VDD VSS sg13g2_fill_1
XFILLER_4_149 VDD VSS sg13g2_fill_1
XFILLER_16_267 VDD VSS sg13g2_decap_8
XFILLER_17_71 VDD VSS sg13g2_decap_8
XFILLER_17_82 VDD VSS sg13g2_fill_2
XFILLER_33_92 VDD VSS sg13g2_decap_8
Xhold400 input69/A s_axil_wdata[6] VDD VSS sg13g2_dlygate4sd3_1
Xhold411 _1084_/D _0932_/Y VDD VSS sg13g2_dlygate4sd3_1
Xhold422 input58/A s_axil_wdata[25] VDD VSS sg13g2_dlygate4sd3_1
Xhold433 input43/A s_axil_wdata[11] VDD VSS sg13g2_dlygate4sd3_1
X_0709_ _1029_/D _0706_/Y _0707_/Y _0708_/Y VDD VSS sg13g2_a21oi_1
XFILLER_13_259 VDD VSS sg13g2_fill_1
XFILLER_0_130 VDD VSS sg13g2_decap_8
XFILLER_12_270 VDD VSS sg13g2_decap_8
X_0991_ _0994_/A _0731_/B _0966_/Y _1099_/Q VDD VSS sg13g2_a21oi_1
Xfanout209 _0712_/A2 _0591_/Y VDD VSS sg13g2_buf_1
XFILLER_5_85 VDD VSS sg13g2_decap_4
XFILLER_10_0 VDD VSS sg13g2_decap_8
XFILLER_39_178 VDD VSS sg13g2_decap_8
XFILLER_39_123 VDD VSS sg13g2_fill_1
XFILLER_10_207 VDD VSS sg13g2_decap_8
XFILLER_24_28 VDD VSS sg13g2_decap_8
XFILLER_40_49 VDD VSS sg13g2_decap_4
Xclkbuf_4_8_0_clk_i _1091_/CLK clkbuf_0_clk_i/X VDD VSS sg13g2_buf_8
X_1049__357 _1049_/RESET_B VDD VSS sg13g2_tiehi
Xinput9 input9/X gpio_in[17] VDD VSS sg13g2_buf_1
XFILLER_36_137 VDD VSS sg13g2_decap_8
X_0974_ _1094_/D _0974_/A _0974_/B VDD VSS sg13g2_nor2_1
XFILLER_19_28 VDD VSS sg13g2_decap_8
XFILLER_27_159 VDD VSS sg13g2_decap_8
XFILLER_23_332 VDD VSS sg13g2_decap_8
XFILLER_35_181 VDD VSS sg13g2_fill_2
XFILLER_14_310 VDD VSS sg13g2_decap_8
XFILLER_25_71 VDD VSS sg13g2_decap_8
XFILLER_26_170 VDD VSS sg13g2_decap_8
XFILLER_26_181 VDD VSS sg13g2_fill_1
X_0690_ _0690_/Y _1084_/Q _0702_/A2 _0702_/B1 VDD VSS sg13g2_a21oi_1
XFILLER_41_81 VDD VSS sg13g2_fill_2
XFILLER_2_42 VDD VSS sg13g2_decap_8
XFILLER_20_324 VDD VSS sg13g2_decap_8
Xoutput143 s_axil_awready _1207_/A VDD VSS sg13g2_buf_1
Xoutput132 gpio_out[2] _1063_/Q VDD VSS sg13g2_buf_1
Xoutput121 gpio_out[1] _1062_/Q VDD VSS sg13g2_buf_1
Xoutput110 gpio_out[0] _1061_/Q VDD VSS sg13g2_buf_1
X_0957_ _1090_/D _0957_/A _0957_/B VDD VSS sg13g2_nor2_1
X_0888_ _0891_/A _0896_/A1 _0867_/Y _1074_/Q VDD VSS sg13g2_a21oi_1
Xoutput176 s_axil_rdata[9] _1011_/Q VDD VSS sg13g2_buf_1
Xoutput165 s_axil_rdata[28] _1030_/Q VDD VSS sg13g2_buf_1
Xoutput154 s_axil_rdata[18] _1020_/Q VDD VSS sg13g2_buf_1
XFILLER_23_195 VDD VSS sg13g2_fill_2
Xinput12 input12/X gpio_in[1] VDD VSS sg13g2_buf_1
Xinput23 input23/X gpio_in[2] VDD VSS sg13g2_buf_1
Xinput34 _0596_/A s_axil_araddr[2] VDD VSS sg13g2_buf_1
Xinput45 _0561_/A input45/A VDD VSS sg13g2_buf_1
Xinput56 _0567_/A input56/A VDD VSS sg13g2_buf_1
Xinput67 _0554_/A input67/A VDD VSS sg13g2_buf_1
X_0811_ _0811_/Y _0943_/A _0939_/B _0900_/B _0943_/D VDD VSS sg13g2_nand4_1
X_0742_ _0743_/B _0898_/A1 _0741_/Y _0726_/B VDD VSS sg13g2_o21ai_1
X_0673_ _1020_/D _0670_/Y _0671_/Y _0672_/Y VDD VSS sg13g2_a21oi_1
X_1087_ _1087_/Q clkload3/A _1087_/D _1087_/RESET_B VDD VSS sg13g2_dfrbpq_1
XFILLER_20_187 VDD VSS sg13g2_decap_8
XFILLER_32_28 VDD VSS sg13g2_decap_8
XFILLER_11_110 VDD VSS sg13g2_decap_8
XFILLER_11_198 VDD VSS sg13g2_decap_4
XFILLER_22_72 VDD VSS sg13g2_decap_4
XFILLER_7_147 VDD VSS sg13g2_decap_8
XFILLER_7_125 VDD VSS sg13g2_fill_2
X_1100__310 _1100_/RESET_B VDD VSS sg13g2_tiehi
XFILLER_14_7 VDD VSS sg13g2_decap_8
XFILLER_19_232 VDD VSS sg13g2_decap_8
XFILLER_34_257 VDD VSS sg13g2_fill_2
X_1010_ _1010_/Q clkload7/A _1010_/D _1010_/RESET_B VDD VSS sg13g2_dfrbpq_1
X_0725_ _1033_/D _0722_/Y _0723_/Y _0724_/Y VDD VSS sg13g2_a21oi_1
X_0656_ _0656_/Y _1016_/Q _0656_/A2 _0656_/B1 VDD VSS sg13g2_o21ai_1
XFILLER_40_0 VDD VSS sg13g2_decap_8
XFILLER_27_28 VDD VSS sg13g2_decap_8
X_0587_ _0587_/Y _0992_/C VDD VSS sg13g2_inv_1
XFILLER_25_202 VDD VSS sg13g2_decap_8
XFILLER_43_49 VDD VSS sg13g2_decap_8
XFILLER_40_238 VDD VSS sg13g2_fill_1
XFILLER_16_224 VDD VSS sg13g2_fill_1
XFILLER_31_249 VDD VSS sg13g2_decap_8
XFILLER_22_249 VDD VSS sg13g2_decap_8
Xhold401 input73/A s_axil_wstrb[0] VDD VSS sg13g2_dlygate4sd3_1
Xhold412 input71/A s_axil_wdata[8] VDD VSS sg13g2_dlygate4sd3_1
Xhold423 input67/A s_axil_wdata[4] VDD VSS sg13g2_dlygate4sd3_1
Xhold434 input35/A s_axil_araddr[3] VDD VSS sg13g2_dlygate4sd3_1
X_1003__347 _1003_/RESET_B VDD VSS sg13g2_tiehi
X_0708_ _0708_/Y _1029_/Q _0724_/A2 _0724_/B1 VDD VSS sg13g2_o21ai_1
X_0639_ _0639_/Y _1055_/Q _0655_/A2 _0714_/A2 input2/X VDD VSS sg13g2_a22oi_1
XFILLER_38_49 VDD VSS sg13g2_decap_8
XFILLER_13_227 VDD VSS sg13g2_decap_8
XFILLER_13_238 VDD VSS sg13g2_decap_8
Xclkbuf_4_4_0_clk_i _1083_/CLK clkbuf_0_clk_i/X VDD VSS sg13g2_buf_8
XFILLER_28_82 VDD VSS sg13g2_decap_8
X_0990_ _1098_/D _0990_/A _0990_/B VDD VSS sg13g2_nor2_1
XFILLER_5_64 VDD VSS sg13g2_fill_1
XFILLER_5_53 VDD VSS sg13g2_fill_2
XFILLER_5_42 VDD VSS sg13g2_decap_8
XFILLER_39_146 VDD VSS sg13g2_fill_1
XFILLER_40_28 VDD VSS sg13g2_decap_8
XFILLER_38_190 VDD VSS sg13g2_fill_2
XFILLER_41_344 VDD VSS sg13g2_fill_2
XFILLER_17_330 VDD VSS sg13g2_decap_8
XFILLER_36_116 VDD VSS sg13g2_decap_8
XFILLER_32_322 VDD VSS sg13g2_fill_1
X_0973_ _0974_/B _0989_/A1 _0972_/Y _0985_/B1 VDD VSS sg13g2_o21ai_1
XFILLER_35_39 VDD VSS sg13g2_decap_8
X_1055__340 _1055_/RESET_B VDD VSS sg13g2_tiehi
XFILLER_2_21 VDD VSS sg13g2_decap_8
XFILLER_2_65 VDD VSS sg13g2_fill_1
X_0956_ _0957_/B _0964_/A1 _0955_/Y _0964_/B1 VDD VSS sg13g2_o21ai_1
Xoutput100 gpio_dir[2] _1095_/Q VDD VSS sg13g2_buf_1
Xoutput177 s_axil_rvalid _1034_/Q VDD VSS sg13g2_buf_1
Xoutput166 s_axil_rdata[29] _1031_/Q VDD VSS sg13g2_buf_1
Xoutput155 s_axil_rdata[19] _1021_/Q VDD VSS sg13g2_buf_1
Xoutput144 s_axil_bvalid _1036_/Q VDD VSS sg13g2_buf_1
Xoutput133 gpio_out[30] _1043_/Q VDD VSS sg13g2_buf_1
Xoutput122 gpio_out[20] _1049_/Q VDD VSS sg13g2_buf_1
Xoutput111 gpio_out[10] _1055_/Q VDD VSS sg13g2_buf_1
X_0887_ _1073_/D _0887_/A _0887_/B VDD VSS sg13g2_nor2_1
XFILLER_15_108 VDD VSS sg13g2_decap_4
XFILLER_23_174 VDD VSS sg13g2_decap_8
XFILLER_11_96 VDD VSS sg13g2_decap_8
XFILLER_14_163 VDD VSS sg13g2_decap_4
XFILLER_14_185 VDD VSS sg13g2_decap_8
Xinput13 input13/X gpio_in[20] VDD VSS sg13g2_buf_1
X_0810_ _0813_/A _0958_/A1 _0801_/Y _1055_/Q VDD VSS sg13g2_a21oi_1
Xinput24 input24/X gpio_in[30] VDD VSS sg13g2_buf_1
Xinput35 _0597_/A input35/A VDD VSS sg13g2_buf_1
Xinput46 _0560_/A input46/A VDD VSS sg13g2_buf_1
Xinput57 _0582_/A input57/A VDD VSS sg13g2_buf_1
Xinput68 _0553_/A input68/A VDD VSS sg13g2_buf_1
X_0741_ _0741_/Y _0873_/A _0897_/B _0867_/B _0897_/D VDD VSS sg13g2_nand4_1
X_0672_ _0672_/Y _1020_/Q _0712_/A2 _0712_/B1 VDD VSS sg13g2_o21ai_1
X_1086_ _1086_/Q clkload3/A _1086_/D _1086_/RESET_B VDD VSS sg13g2_dfrbpq_1
XFILLER_37_299 VDD VSS sg13g2_decap_8
X_0939_ _0939_/Y _0939_/A _0939_/B _0996_/C _0943_/D VDD VSS sg13g2_nand4_1
X_1013__327 _1013_/RESET_B VDD VSS sg13g2_tiehi
XFILLER_11_166 VDD VSS sg13g2_decap_8
XFILLER_22_51 VDD VSS sg13g2_decap_8
XFILLER_22_95 VDD VSS sg13g2_decap_8
XFILLER_0_0 VDD VSS sg13g2_decap_8
XFILLER_19_200 VDD VSS sg13g2_fill_2
Xfanout190 _0731_/B _0995_/A1 VDD VSS sg13g2_buf_1
XFILLER_8_42 VDD VSS sg13g2_decap_8
XFILLER_33_0 VDD VSS sg13g2_decap_8
X_0724_ _0724_/Y _1033_/Q _0724_/A2 _0724_/B1 VDD VSS sg13g2_o21ai_1
X_0655_ _0655_/Y _1059_/Q _0655_/A2 _0686_/A2 input6/X VDD VSS sg13g2_a22oi_1
X_0586_ _0586_/Y _0966_/A VDD VSS sg13g2_inv_1
X_1207_ _1207_/X _1207_/A VDD VSS sg13g2_buf_1
XFILLER_25_269 VDD VSS sg13g2_decap_4
X_1082__314 _1082_/RESET_B VDD VSS sg13g2_tiehi
X_1069_ _1069_/Q clkload4/A _1069_/D _1069_/RESET_B VDD VSS sg13g2_dfrbpq_1
XFILLER_43_28 VDD VSS sg13g2_decap_8
XFILLER_40_228 VDD VSS sg13g2_fill_1
XFILLER_4_107 VDD VSS sg13g2_decap_8
Xclkbuf_4_0_0_clk_i _1100_/CLK clkbuf_0_clk_i/X VDD VSS sg13g2_buf_8
XFILLER_17_62 VDD VSS sg13g2_decap_4
XFILLER_39_317 VDD VSS sg13g2_fill_1
XFILLER_22_217 VDD VSS sg13g2_decap_4
Xhold402 input75/A s_axil_wstrb[2] VDD VSS sg13g2_dlygate4sd3_1
Xhold413 input41/A s_axil_wdata[0] VDD VSS sg13g2_dlygate4sd3_1
Xhold424 hold424/X _0984_/Y VDD VSS sg13g2_dlygate4sd3_1
Xhold435 hold435/X _0595_/Y VDD VSS sg13g2_dlygate4sd3_1
X_0707_ _0707_/Y _1040_/Q _0723_/A2 _0723_/B1 input20/X VDD VSS sg13g2_a22oi_1
X_0638_ _0638_/Y _1087_/Q _0711_/B1 _0722_/B1 VDD VSS sg13g2_a21oi_1
X_0569_ _0922_/A _0569_/A VDD VSS sg13g2_inv_1
XFILLER_38_28 VDD VSS sg13g2_decap_8
XFILLER_28_50 VDD VSS sg13g2_decap_4
XFILLER_12_283 VDD VSS sg13g2_decap_4
XFILLER_8_254 VDD VSS sg13g2_decap_8
XFILLER_5_21 VDD VSS sg13g2_decap_8
XFILLER_39_103 VDD VSS sg13g2_decap_8
XFILLER_39_82 VDD VSS sg13g2_decap_8
X_0972_ _0972_/Y _0972_/A _0988_/B _0992_/C _0984_/D VDD VSS sg13g2_nand4_1
XFILLER_27_117 VDD VSS sg13g2_decap_8
XFILLER_23_312 VDD VSS sg13g2_fill_2
XFILLER_35_18 VDD VSS sg13g2_decap_8
XFILLER_4_7 VDD VSS sg13g2_decap_8
XFILLER_14_345 VDD VSS sg13g2_fill_2
XFILLER_41_164 VDD VSS sg13g2_fill_2
X_1062__312 _1062_/RESET_B VDD VSS sg13g2_tiehi
X_1023__307 _1023_/RESET_B VDD VSS sg13g2_tiehi
XFILLER_2_77 VDD VSS sg13g2_fill_2
XFILLER_37_7 VDD VSS sg13g2_decap_8
XFILLER_32_164 VDD VSS sg13g2_decap_8
X_0955_ _0955_/Y _0955_/A _0963_/B _0963_/C _0963_/D VDD VSS sg13g2_nand4_1
X_0886_ _0887_/B _0898_/A1 hold415/X _0726_/B VDD VSS sg13g2_o21ai_1
Xoutput101 gpio_dir[30] _1075_/Q VDD VSS sg13g2_buf_1
Xoutput178 s_axil_wready _1207_/X VDD VSS sg13g2_buf_1
Xoutput167 s_axil_rdata[2] _1004_/Q VDD VSS sg13g2_buf_1
Xoutput156 s_axil_rdata[1] _1003_/Q VDD VSS sg13g2_buf_1
Xoutput145 s_axil_rdata[0] _1002_/Q VDD VSS sg13g2_buf_1
Xoutput134 gpio_out[31] _1044_/Q VDD VSS sg13g2_buf_1
Xoutput123 gpio_out[21] _1050_/Q VDD VSS sg13g2_buf_1
Xoutput112 gpio_out[11] _1056_/Q VDD VSS sg13g2_buf_1
XFILLER_11_326 VDD VSS sg13g2_decap_8
XFILLER_23_197 VDD VSS sg13g2_fill_1
XFILLER_11_42 VDD VSS sg13g2_decap_4
XFILLER_11_75 VDD VSS sg13g2_decap_8
XFILLER_7_319 VDD VSS sg13g2_decap_8
XFILLER_14_142 VDD VSS sg13g2_decap_8
Xinput14 input14/X gpio_in[21] VDD VSS sg13g2_buf_1
Xinput25 input25/X gpio_in[31] VDD VSS sg13g2_buf_1
Xinput36 _0592_/B input36/A VDD VSS sg13g2_buf_1
X_0740_ _0743_/A _0942_/A1 _0735_/Y _1038_/Q VDD VSS sg13g2_a21oi_1
Xinput47 _0559_/A input47/A VDD VSS sg13g2_buf_1
Xinput58 _0581_/A input58/A VDD VSS sg13g2_buf_1
Xinput69 _0552_/A input69/A VDD VSS sg13g2_buf_1
X_0671_ _0671_/Y _1047_/Q _0695_/A2 _0699_/B1 input10/X VDD VSS sg13g2_a22oi_1
XFILLER_6_341 VDD VSS sg13g2_decap_4
XFILLER_35_4 VDD VSS sg13g2_decap_8
XFILLER_37_256 VDD VSS sg13g2_fill_1
XFILLER_37_245 VDD VSS sg13g2_decap_8
XFILLER_37_212 VDD VSS sg13g2_fill_1
XFILLER_20_123 VDD VSS sg13g2_decap_8
X_1085_ _1085_/Q clkload1/A _1085_/D _1085_/RESET_B VDD VSS sg13g2_dfrbpq_1
XFILLER_37_278 VDD VSS sg13g2_decap_8
XFILLER_37_267 VDD VSS sg13g2_fill_1
XFILLER_20_167 VDD VSS sg13g2_fill_2
X_0938_ _0941_/A _0995_/A1 _0933_/Y _1086_/Q VDD VSS sg13g2_a21oi_1
X_0869_ _0869_/Y _0869_/A _0889_/B _0897_/C _0897_/D VDD VSS sg13g2_nand4_1
XFILLER_28_234 VDD VSS sg13g2_decap_8
XFILLER_11_145 VDD VSS sg13g2_decap_8
XFILLER_7_127 VDD VSS sg13g2_fill_1
Xfanout180 _0997_/A1 _0960_/A1 VDD VSS sg13g2_buf_1
Xfanout191 _0987_/A1 _0995_/A1 VDD VSS sg13g2_buf_1
XFILLER_19_278 VDD VSS sg13g2_decap_8
X_0723_ _0723_/Y _1044_/Q _0723_/A2 _0723_/B1 input25/X VDD VSS sg13g2_a22oi_1
XFILLER_8_21 VDD VSS sg13g2_decap_8
XFILLER_26_0 VDD VSS sg13g2_decap_8
X_0654_ _0654_/Y _1091_/Q _0654_/A2 _0654_/B1 VDD VSS sg13g2_a21oi_1
X_0585_ _0867_/C _0881_/D VDD VSS sg13g2_inv_1
XFILLER_33_281 VDD VSS sg13g2_decap_8
X_1068_ _1068_/Q clkload1/A _1068_/D _1068_/RESET_B VDD VSS sg13g2_dfrbpq_1
XFILLER_17_52 VDD VSS sg13g2_decap_4
XFILLER_24_292 VDD VSS sg13g2_fill_1
XFILLER_33_73 VDD VSS sg13g2_fill_1
XFILLER_30_284 VDD VSS sg13g2_decap_8
Xhold403 input63/A s_axil_wdata[2] VDD VSS sg13g2_dlygate4sd3_1
Xhold414 input76/A s_axil_wstrb[3] VDD VSS sg13g2_dlygate4sd3_1
Xhold425 input45/A s_axil_wdata[13] VDD VSS sg13g2_dlygate4sd3_1
Xhold436 _1017_/D _0661_/Y VDD VSS sg13g2_dlygate4sd3_1
X_0706_ _0706_/Y _1072_/Q _0722_/A2 _0722_/B1 VDD VSS sg13g2_a21oi_1
X_0637_ _1011_/D _0634_/Y _0635_/Y _0636_/Y VDD VSS sg13g2_a21oi_1
X_0568_ _0926_/A _0568_/A VDD VSS sg13g2_inv_1
XFILLER_21_251 VDD VSS sg13g2_fill_1
X_1086__281 _1086_/RESET_B VDD VSS sg13g2_tiehi
XFILLER_28_62 VDD VSS sg13g2_fill_1
XFILLER_8_222 VDD VSS sg13g2_fill_1
XFILLER_35_332 VDD VSS sg13g2_decap_8
XFILLER_14_42 VDD VSS sg13g2_decap_8
XFILLER_41_346 VDD VSS sg13g2_fill_1
XFILLER_30_63 VDD VSS sg13g2_decap_8
XFILLER_5_214 VDD VSS sg13g2_fill_2
XFILLER_32_313 VDD VSS sg13g2_decap_8
XFILLER_32_335 VDD VSS sg13g2_decap_4
X_0971_ _0974_/A _0987_/A1 _0966_/Y _1094_/Q VDD VSS sg13g2_a21oi_1
XFILLER_35_162 VDD VSS sg13g2_decap_8
XFILLER_35_173 VDD VSS sg13g2_fill_2
XFILLER_14_324 VDD VSS sg13g2_decap_8
XFILLER_41_95 VDD VSS sg13g2_fill_2
XFILLER_2_56 VDD VSS sg13g2_decap_4
XFILLER_17_184 VDD VSS sg13g2_decap_8
XFILLER_20_305 VDD VSS sg13g2_decap_8
X_0954_ _0957_/A _0962_/A1 _0933_/Y _1090_/Q VDD VSS sg13g2_a21oi_1
X_0885_ _0885_/Y _0885_/A _0897_/B _0897_/C _0893_/D VDD VSS sg13g2_nand4_1
Xoutput102 gpio_dir[31] _1076_/Q VDD VSS sg13g2_buf_1
Xoutput168 s_axil_rdata[30] _1032_/Q VDD VSS sg13g2_buf_1
Xoutput157 s_axil_rdata[20] _1022_/Q VDD VSS sg13g2_buf_1
Xoutput146 s_axil_rdata[10] _1012_/Q VDD VSS sg13g2_buf_1
Xoutput135 gpio_out[3] _1064_/Q VDD VSS sg13g2_buf_1
Xoutput124 gpio_out[22] _1051_/Q VDD VSS sg13g2_buf_1
Xoutput113 gpio_out[12] _1057_/Q VDD VSS sg13g2_buf_1
XFILLER_11_21 VDD VSS sg13g2_decap_8
XFILLER_36_84 VDD VSS sg13g2_fill_1
Xinput15 input15/X gpio_in[22] VDD VSS sg13g2_buf_1
Xinput26 input26/X gpio_in[3] VDD VSS sg13g2_buf_1
Xinput37 input37/X s_axil_awaddr[2] VDD VSS sg13g2_buf_1
Xinput48 _0574_/A input48/A VDD VSS sg13g2_buf_1
Xinput59 _0580_/A input59/A VDD VSS sg13g2_buf_1
X_0670_ _0670_/Y _1079_/Q _0711_/B1 _0722_/B1 VDD VSS sg13g2_a21oi_1
XFILLER_6_320 VDD VSS sg13g2_decap_8
X_1084_ _1084_/Q clkload2/A _1084_/D _1084_/RESET_B VDD VSS sg13g2_dfrbpq_1
XFILLER_20_102 VDD VSS sg13g2_decap_8
X_0937_ _1085_/D _0937_/A _0937_/B VDD VSS sg13g2_nor2_1
X_0868_ _0871_/A _0896_/A1 _0867_/Y _1069_/Q VDD VSS sg13g2_a21oi_1
X_0799_ _0800_/B _0927_/A1 _0798_/Y _0997_/B1 VDD VSS sg13g2_o21ai_1
XFILLER_28_257 VDD VSS sg13g2_fill_2
XFILLER_11_124 VDD VSS sg13g2_decap_8
XFILLER_22_42 VDD VSS sg13g2_decap_4
XFILLER_19_246 VDD VSS sg13g2_decap_8
Xfanout181 _0940_/A1 _0960_/A1 VDD VSS sg13g2_buf_1
Xfanout192 _0983_/A1 _0958_/A1 VDD VSS sg13g2_buf_1
X_0722_ _0722_/Y _1076_/Q _0722_/A2 _0722_/B1 VDD VSS sg13g2_a21oi_1
X_0653_ _1015_/D _0650_/Y _0651_/Y _0652_/Y VDD VSS sg13g2_a21oi_1
XFILLER_6_183 VDD VSS sg13g2_decap_8
XFILLER_6_172 VDD VSS sg13g2_decap_8
X_0584_ _0729_/B _1101_/Q VDD VSS sg13g2_inv_1
XFILLER_19_0 VDD VSS sg13g2_decap_8
XFILLER_25_216 VDD VSS sg13g2_decap_8
XFILLER_25_249 VDD VSS sg13g2_decap_8
X_1067_ _1067_/Q _1100_/CLK _1067_/D _1067_/RESET_B VDD VSS sg13g2_dfrbpq_1
XFILLER_0_337 VDD VSS sg13g2_fill_1
XFILLER_33_63 VDD VSS sg13g2_decap_4
XFILLER_33_85 VDD VSS sg13g2_decap_8
XFILLER_39_308 VDD VSS sg13g2_decap_4
XFILLER_12_7 VDD VSS sg13g2_decap_8
XFILLER_30_263 VDD VSS sg13g2_fill_1
Xhold404 input70/A s_axil_wdata[7] VDD VSS sg13g2_dlygate4sd3_1
Xhold415 hold415/X _0885_/Y VDD VSS sg13g2_dlygate4sd3_1
Xhold426 input72/A s_axil_wdata[9] VDD VSS sg13g2_dlygate4sd3_1
Xhold437 input36/A s_axil_arvalid VDD VSS sg13g2_dlygate4sd3_1
X_0705_ _1028_/D _0702_/Y _0703_/Y _0704_/Y VDD VSS sg13g2_a21oi_1
X_0636_ _0636_/Y _1011_/Q _0656_/A2 _0656_/B1 VDD VSS sg13g2_o21ai_1
X_0567_ _0930_/A _0567_/A VDD VSS sg13g2_inv_1
XFILLER_38_330 VDD VSS sg13g2_decap_8
XFILLER_0_123 VDD VSS sg13g2_decap_8
XFILLER_28_96 VDD VSS sg13g2_decap_8
XFILLER_12_263 VDD VSS sg13g2_decap_8
X_1065__300 _1065_/RESET_B VDD VSS sg13g2_tiehi
XFILLER_5_89 VDD VSS sg13g2_fill_1
XFILLER_5_78 VDD VSS sg13g2_decap_8
X_0619_ _0619_/Y _1066_/Q _0647_/A2 _0647_/B1 input28/X VDD VSS sg13g2_a22oi_1
XFILLER_14_21 VDD VSS sg13g2_decap_8
X_1088__366 _1088_/RESET_B VDD VSS sg13g2_tiehi
XFILLER_30_42 VDD VSS sg13g2_decap_8
XFILLER_5_237 VDD VSS sg13g2_fill_2
XFILLER_17_344 VDD VSS sg13g2_fill_2
X_0970_ _1093_/D _0970_/A _0970_/B VDD VSS sg13g2_nor2_1
XFILLER_23_325 VDD VSS sg13g2_decap_8
XFILLER_14_303 VDD VSS sg13g2_decap_8
XFILLER_25_42 VDD VSS sg13g2_decap_8
XFILLER_26_163 VDD VSS sg13g2_decap_8
XFILLER_25_64 VDD VSS sg13g2_decap_8
XFILLER_25_97 VDD VSS sg13g2_decap_8
XFILLER_2_35 VDD VSS sg13g2_decap_8
XFILLER_17_141 VDD VSS sg13g2_decap_8
XFILLER_20_317 VDD VSS sg13g2_decap_8
Xoutput103 gpio_dir[3] _1096_/Q VDD VSS sg13g2_buf_1
Xoutput125 gpio_out[23] _1052_/Q VDD VSS sg13g2_buf_1
Xoutput114 gpio_out[13] _1058_/Q VDD VSS sg13g2_buf_1
X_0953_ _1089_/D _0953_/A _0953_/B VDD VSS sg13g2_nor2_1
X_0884_ _0887_/A _0896_/A1 _0867_/Y _1073_/Q VDD VSS sg13g2_a21oi_1
Xoutput169 s_axil_rdata[31] _1033_/Q VDD VSS sg13g2_buf_1
Xoutput158 s_axil_rdata[21] _1023_/Q VDD VSS sg13g2_buf_1
Xoutput147 s_axil_rdata[11] _1013_/Q VDD VSS sg13g2_buf_1
Xoutput136 gpio_out[4] _1065_/Q VDD VSS sg13g2_buf_1
XFILLER_23_188 VDD VSS sg13g2_fill_1
X_1092__318 _1092_/RESET_B VDD VSS sg13g2_tiehi
XFILLER_14_199 VDD VSS sg13g2_decap_8
Xinput16 input16/X gpio_in[23] VDD VSS sg13g2_buf_1
Xinput27 input27/X gpio_in[4] VDD VSS sg13g2_buf_1
Xinput38 _0900_/A s_axil_awaddr[3] VDD VSS sg13g2_buf_1
Xinput49 _0573_/A input49/A VDD VSS sg13g2_buf_1
XFILLER_42_7 VDD VSS sg13g2_decap_8
X_1083_ _1083_/Q _1083_/CLK _1083_/D _1083_/RESET_B VDD VSS sg13g2_dfrbpq_1
X_0936_ _0937_/B _0940_/A1 _0935_/Y _0936_/B1 VDD VSS sg13g2_o21ai_1
X_0867_ _0867_/Y _0966_/A _0867_/B _0867_/C VDD VSS sg13g2_nor3_1
X_0798_ _0798_/Y _0930_/A _0926_/B _0798_/C _0922_/D VDD VSS sg13g2_nand4_1
XFILLER_9_192 VDD VSS sg13g2_decap_8
XFILLER_11_103 VDD VSS sg13g2_decap_8
XFILLER_22_21 VDD VSS sg13g2_decap_8
XFILLER_22_65 VDD VSS sg13g2_decap_8
XFILLER_7_118 VDD VSS sg13g2_decap_8
XFILLER_19_225 VDD VSS sg13g2_decap_8
XFILLER_27_280 VDD VSS sg13g2_decap_8
Xfanout182 _0985_/A1 _0960_/A1 VDD VSS sg13g2_buf_1
Xfanout193 _0958_/A1 _0995_/A1 VDD VSS sg13g2_buf_1
XFILLER_42_294 VDD VSS sg13g2_decap_8
XFILLER_42_261 VDD VSS sg13g2_fill_1
X_0721_ _1032_/D _0718_/Y _0719_/Y _0720_/Y VDD VSS sg13g2_a21oi_1
X_0652_ _0652_/Y _1015_/Q _0656_/A2 _0656_/B1 VDD VSS sg13g2_o21ai_1
X_0583_ _0730_/A _1207_/A VDD VSS sg13g2_inv_1
XFILLER_6_195 VDD VSS sg13g2_decap_8
XFILLER_6_151 VDD VSS sg13g2_decap_8
XFILLER_6_140 VDD VSS sg13g2_decap_8
XFILLER_18_280 VDD VSS sg13g2_decap_8
X_1066_ _1066_/Q _1100_/CLK _1066_/D _1066_/RESET_B VDD VSS sg13g2_dfrbpq_1
X_0919_ _0920_/B _0931_/A1 hold398/X _1000_/B VDD VSS sg13g2_o21ai_1
XFILLER_16_217 VDD VSS sg13g2_decap_8
XFILLER_17_21 VDD VSS sg13g2_decap_8
XFILLER_24_250 VDD VSS sg13g2_decap_8
XFILLER_24_272 VDD VSS sg13g2_decap_4
XFILLER_33_42 VDD VSS sg13g2_decap_8
XFILLER_30_242 VDD VSS sg13g2_decap_8
XFILLER_31_0 VDD VSS sg13g2_decap_8
Xhold405 input54/A s_axil_wdata[21] VDD VSS sg13g2_dlygate4sd3_1
Xhold416 input64/A s_axil_wdata[30] VDD VSS sg13g2_dlygate4sd3_1
Xhold427 input74/A s_axil_wstrb[1] VDD VSS sg13g2_dlygate4sd3_1
X_0704_ _0704_/Y _1028_/Q _0724_/A2 _0704_/B1 VDD VSS sg13g2_o21ai_1
X_0635_ _0635_/Y _1054_/Q _0655_/A2 _0714_/A2 input32/X VDD VSS sg13g2_a22oi_1
X_0566_ _0935_/A _0566_/A VDD VSS sg13g2_inv_1
XFILLER_21_242 VDD VSS sg13g2_decap_8
X_1049_ _1049_/Q clkload0/A _1049_/D _1049_/RESET_B VDD VSS sg13g2_dfrbpq_1
XFILLER_21_286 VDD VSS sg13g2_fill_2
Xperipherals_macro s_axil_bresp[0] VDD VSS sg13g2_tielo
XFILLER_0_102 VDD VSS sg13g2_decap_8
XFILLER_28_42 VDD VSS sg13g2_decap_4
XFILLER_28_75 VDD VSS sg13g2_decap_8
XFILLER_12_220 VDD VSS sg13g2_decap_4
X_1030__293 _1030_/RESET_B VDD VSS sg13g2_tiehi
XFILLER_8_268 VDD VSS sg13g2_decap_8
XFILLER_8_213 VDD VSS sg13g2_decap_4
XFILLER_5_35 VDD VSS sg13g2_decap_8
XFILLER_39_139 VDD VSS sg13g2_decap_8
XFILLER_39_117 VDD VSS sg13g2_fill_1
X_0618_ _0618_/Y _1098_/Q _0654_/A2 _0654_/B1 VDD VSS sg13g2_a21oi_1
XFILLER_26_312 VDD VSS sg13g2_decap_4
XFILLER_41_304 VDD VSS sg13g2_fill_2
XFILLER_30_21 VDD VSS sg13g2_decap_8
XFILLER_39_96 VDD VSS sg13g2_decap_8
XFILLER_39_63 VDD VSS sg13g2_decap_8
XFILLER_17_323 VDD VSS sg13g2_decap_8
XFILLER_27_109 VDD VSS sg13g2_decap_4
X_1009__335 _1009_/RESET_B VDD VSS sg13g2_tiehi
XFILLER_25_21 VDD VSS sg13g2_decap_8
XFILLER_26_120 VDD VSS sg13g2_decap_8
XFILLER_41_134 VDD VSS sg13g2_fill_1
XFILLER_41_42 VDD VSS sg13g2_decap_4
XFILLER_2_14 VDD VSS sg13g2_decap_8
XFILLER_9_0 VDD VSS sg13g2_decap_8
XFILLER_32_101 VDD VSS sg13g2_decap_8
X_0952_ _0953_/B _0985_/A1 _0951_/Y _0960_/B1 VDD VSS sg13g2_o21ai_1
Xoutput104 gpio_dir[4] _1097_/Q VDD VSS sg13g2_buf_1
Xoutput159 s_axil_rdata[22] _1024_/Q VDD VSS sg13g2_buf_1
Xoutput148 s_axil_rdata[12] _1014_/Q VDD VSS sg13g2_buf_1
Xoutput137 gpio_out[5] _1066_/Q VDD VSS sg13g2_buf_1
Xoutput126 gpio_out[24] _1037_/Q VDD VSS sg13g2_buf_1
Xoutput115 gpio_out[14] _1059_/Q VDD VSS sg13g2_buf_1
X_0883_ _1072_/D _0883_/A _0883_/B VDD VSS sg13g2_nor2_1
XFILLER_11_89 VDD VSS sg13g2_decap_8
XFILLER_2_7 VDD VSS sg13g2_decap_8
XFILLER_36_42 VDD VSS sg13g2_fill_2
XFILLER_14_156 VDD VSS sg13g2_decap_8
XFILLER_14_178 VDD VSS sg13g2_decap_8
Xinput17 input17/X gpio_in[24] VDD VSS sg13g2_buf_1
Xinput28 input28/X gpio_in[5] VDD VSS sg13g2_buf_1
Xinput39 _0730_/D s_axil_awvalid VDD VSS sg13g2_buf_1
X_1082_ _1082_/Q clkload2/A _1082_/D _1082_/RESET_B VDD VSS sg13g2_dfrbpq_1
XFILLER_20_137 VDD VSS sg13g2_fill_2
X_1045__365 _1045_/RESET_B VDD VSS sg13g2_tiehi
X_0935_ _0935_/Y _0935_/A _0939_/B _0996_/C _0943_/D VDD VSS sg13g2_nand4_1
X_0866_ _1068_/D _0866_/A _0866_/B VDD VSS sg13g2_nor2_1
XFILLER_9_171 VDD VSS sg13g2_decap_4
X_0797_ _0800_/A _0731_/B _0768_/Y _1052_/Q VDD VSS sg13g2_a21oi_1
XFILLER_11_159 VDD VSS sg13g2_decap_8
XFILLER_22_88 VDD VSS sg13g2_decap_8
Xfanout183 _0960_/A1 _0730_/Y VDD VSS sg13g2_buf_1
Xfanout194 _0995_/A1 _0729_/Y VDD VSS sg13g2_buf_1
X_0720_ _0720_/Y _1032_/Q _0724_/A2 _0724_/B1 VDD VSS sg13g2_o21ai_1
XFILLER_8_35 VDD VSS sg13g2_decap_8
X_0651_ _0651_/Y _1058_/Q _0655_/A2 _0651_/B1 _1090_/Q VDD VSS sg13g2_a22oi_1
X_0582_ _0869_/A _0582_/A VDD VSS sg13g2_inv_1
XFILLER_33_295 VDD VSS sg13g2_decap_8
X_1065_ _1065_/Q _1097_/CLK _1065_/D _1065_/RESET_B VDD VSS sg13g2_dfrbpq_1
X_0918_ _0918_/Y _0918_/A _0926_/B _0926_/C _0922_/D VDD VSS sg13g2_nand4_1
X_0849_ _0850_/B _0985_/A1 _0848_/Y _0985_/B1 VDD VSS sg13g2_o21ai_1
XFILLER_24_240 VDD VSS sg13g2_decap_4
XFILLER_33_21 VDD VSS sg13g2_decap_8
XFILLER_15_251 VDD VSS sg13g2_decap_8
XFILLER_15_262 VDD VSS sg13g2_fill_1
XFILLER_30_221 VDD VSS sg13g2_decap_8
Xhold406 _1082_/D _0924_/Y VDD VSS sg13g2_dlygate4sd3_1
Xhold417 input62/A s_axil_wdata[29] VDD VSS sg13g2_dlygate4sd3_1
X_0703_ _0703_/Y _1039_/Q _0723_/A2 _0723_/B1 input19/X VDD VSS sg13g2_a22oi_1
XFILLER_24_0 VDD VSS sg13g2_decap_8
Xhold428 input47/A s_axil_wdata[15] VDD VSS sg13g2_dlygate4sd3_1
X_0634_ _0634_/Y _1086_/Q _0651_/B1 _0714_/B1 VDD VSS sg13g2_a21oi_1
X_0565_ _0939_/A _0565_/A VDD VSS sg13g2_inv_1
XFILLER_21_232 VDD VSS sg13g2_fill_1
X_1048_ _1048_/Q _1083_/CLK _1048_/D _1048_/RESET_B VDD VSS sg13g2_dfrbpq_1
XFILLER_21_298 VDD VSS sg13g2_fill_2
XFILLER_28_21 VDD VSS sg13g2_decap_8
XFILLER_29_310 VDD VSS sg13g2_fill_1
X_1019__315 _1019_/RESET_B VDD VSS sg13g2_tiehi
XFILLER_12_287 VDD VSS sg13g2_fill_1
XFILLER_5_14 VDD VSS sg13g2_decap_8
XFILLER_7_280 VDD VSS sg13g2_fill_2
X_0617_ _1006_/D _0614_/Y _0615_/Y _0616_/Y VDD VSS sg13g2_a21oi_1
XFILLER_26_335 VDD VSS sg13g2_decap_4
XFILLER_30_77 VDD VSS sg13g2_fill_2
XFILLER_39_42 VDD VSS sg13g2_decap_8
XFILLER_17_313 VDD VSS sg13g2_fill_2
XFILLER_17_346 VDD VSS sg13g2_fill_1
XFILLER_29_140 VDD VSS sg13g2_fill_2
XFILLER_29_162 VDD VSS sg13g2_decap_8
XFILLER_39_75 VDD VSS sg13g2_decap_8
XFILLER_23_305 VDD VSS sg13g2_decap_8
XFILLER_14_338 VDD VSS sg13g2_decap_8
XFILLER_26_187 VDD VSS sg13g2_decap_4
XFILLER_41_146 VDD VSS sg13g2_fill_2
XFILLER_41_21 VDD VSS sg13g2_decap_8
XFILLER_32_157 VDD VSS sg13g2_decap_8
X_0951_ _0951_/Y _0951_/A _0984_/B _0996_/C _0959_/D VDD VSS sg13g2_nand4_1
X_0882_ _0883_/B _0890_/A1 _0881_/Y _0898_/B1 VDD VSS sg13g2_o21ai_1
XFILLER_9_331 VDD VSS sg13g2_decap_8
Xoutput105 gpio_dir[5] _1098_/Q VDD VSS sg13g2_buf_1
Xoutput149 s_axil_rdata[13] _1015_/Q VDD VSS sg13g2_buf_1
Xoutput138 gpio_out[6] _1067_/Q VDD VSS sg13g2_buf_1
Xoutput127 gpio_out[25] _1038_/Q VDD VSS sg13g2_buf_1
Xoutput116 gpio_out[15] _1060_/Q VDD VSS sg13g2_buf_1
XFILLER_11_319 VDD VSS sg13g2_decap_8
XFILLER_23_102 VDD VSS sg13g2_decap_4
XFILLER_23_146 VDD VSS sg13g2_decap_4
XFILLER_11_35 VDD VSS sg13g2_decap_8
XFILLER_11_68 VDD VSS sg13g2_decap_8
XFILLER_36_21 VDD VSS sg13g2_decap_8
XFILLER_14_135 VDD VSS sg13g2_decap_8
XFILLER_22_190 VDD VSS sg13g2_fill_2
Xinput18 input18/X gpio_in[25] VDD VSS sg13g2_buf_1
Xinput29 input29/X gpio_in[6] VDD VSS sg13g2_buf_1
X_1027__299 _1027_/RESET_B VDD VSS sg13g2_tiehi
XFILLER_6_345 VDD VSS sg13g2_fill_2
XFILLER_6_334 VDD VSS sg13g2_decap_8
XFILLER_28_7 VDD VSS sg13g2_decap_8
XFILLER_37_205 VDD VSS sg13g2_decap_8
X_1081_ _1081_/Q clkload2/A _1081_/D _1081_/RESET_B VDD VSS sg13g2_dfrbpq_1
XFILLER_20_116 VDD VSS sg13g2_decap_8
X_0934_ _0937_/A _0995_/A1 _0933_/Y _1085_/Q VDD VSS sg13g2_a21oi_1
X_0865_ _0866_/B _0997_/A1 _0864_/Y _0997_/B1 VDD VSS sg13g2_o21ai_1
X_0796_ _1051_/D _0796_/A _0796_/B VDD VSS sg13g2_nor2_1
XFILLER_28_227 VDD VSS sg13g2_decap_8
XFILLER_11_138 VDD VSS sg13g2_decap_8
XFILLER_3_337 VDD VSS sg13g2_decap_4
Xfanout184 _0911_/A1 _0931_/A1 VDD VSS sg13g2_buf_1
Xfanout195 _0925_/A1 _0929_/A1 VDD VSS sg13g2_buf_1
XFILLER_34_219 VDD VSS sg13g2_fill_2
XFILLER_10_193 VDD VSS sg13g2_decap_8
XFILLER_8_14 VDD VSS sg13g2_decap_8
X_0650_ _0650_/Y input5/X _0686_/A2 _0686_/B1 VDD VSS sg13g2_a21oi_1
X_0581_ _0873_/A _0581_/A VDD VSS sg13g2_inv_1
X_1064_ _1064_/Q _1097_/CLK _1064_/D _1064_/RESET_B VDD VSS sg13g2_dfrbpq_1
XFILLER_33_230 VDD VSS sg13g2_fill_1
X_0917_ _0920_/A _0925_/A1 _0900_/Y _1081_/Q VDD VSS sg13g2_a21oi_1
X_0848_ _0848_/Y _0980_/A _0984_/B _0933_/B _0984_/D VDD VSS sg13g2_nand4_1
X_0779_ _0780_/B _0911_/A1 _0778_/Y _0911_/B1 VDD VSS sg13g2_o21ai_1
XFILLER_17_45 VDD VSS sg13g2_decap_8
XFILLER_17_56 VDD VSS sg13g2_fill_2
XFILLER_17_78 VDD VSS sg13g2_decap_4
XFILLER_33_99 VDD VSS sg13g2_decap_8
XFILLER_3_145 VDD VSS sg13g2_decap_4
XFILLER_3_123 VDD VSS sg13g2_fill_1
XFILLER_3_112 VDD VSS sg13g2_fill_1
XFILLER_15_285 VDD VSS sg13g2_fill_2
XFILLER_30_277 VDD VSS sg13g2_decap_8
Xhold407 input59/A s_axil_wdata[26] VDD VSS sg13g2_dlygate4sd3_1
Xhold418 input65/A s_axil_wdata[31] VDD VSS sg13g2_dlygate4sd3_1
Xhold429 input42/A s_axil_wdata[10] VDD VSS sg13g2_dlygate4sd3_1
X_0702_ _0702_/Y _1071_/Q _0702_/A2 _0702_/B1 VDD VSS sg13g2_a21oi_1
X_0633_ _1010_/D _0630_/Y _0631_/Y _0632_/Y VDD VSS sg13g2_a21oi_1
X_0564_ _0943_/A _0564_/A VDD VSS sg13g2_inv_1
XFILLER_0_81 VDD VSS sg13g2_decap_8
XFILLER_17_0 VDD VSS sg13g2_decap_8
X_1047_ _1047_/Q clkload0/A _1047_/D _1047_/RESET_B VDD VSS sg13g2_dfrbpq_1
XFILLER_21_288 VDD VSS sg13g2_fill_1
XFILLER_29_322 VDD VSS sg13g2_fill_2
XFILLER_12_277 VDD VSS sg13g2_fill_1
XFILLER_10_7 VDD VSS sg13g2_decap_8
X_0616_ _0616_/Y _1006_/Q _0644_/A2 _0648_/B1 VDD VSS sg13g2_o21ai_1
XFILLER_14_35 VDD VSS sg13g2_decap_8
XFILLER_41_306 VDD VSS sg13g2_fill_1
XFILLER_14_68 VDD VSS sg13g2_fill_2
XFILLER_30_56 VDD VSS sg13g2_decap_8
XFILLER_39_21 VDD VSS sg13g2_decap_8
XFILLER_32_328 VDD VSS sg13g2_decap_8
XFILLER_35_122 VDD VSS sg13g2_decap_8
Xclkbuf_4_13_0_clk_i clkload8/A clkbuf_0_clk_i/X VDD VSS sg13g2_buf_8
XFILLER_6_91 VDD VSS sg13g2_decap_8
XFILLER_14_317 VDD VSS sg13g2_decap_8
XFILLER_25_56 VDD VSS sg13g2_fill_2
XFILLER_25_78 VDD VSS sg13g2_fill_2
XFILLER_26_177 VDD VSS sg13g2_decap_4
XFILLER_2_49 VDD VSS sg13g2_decap_8
XFILLER_17_199 VDD VSS sg13g2_decap_4
X_0950_ _0953_/A _0958_/A1 _0933_/Y _1089_/Q VDD VSS sg13g2_a21oi_1
X_0881_ _0881_/Y _0881_/A _0889_/B _0897_/C _0881_/D VDD VSS sg13g2_nand4_1
XFILLER_9_310 VDD VSS sg13g2_decap_8
Xoutput106 gpio_dir[6] _1099_/Q VDD VSS sg13g2_buf_1
Xoutput139 gpio_out[7] _1068_/Q VDD VSS sg13g2_buf_1
Xoutput128 gpio_out[26] _1039_/Q VDD VSS sg13g2_buf_1
Xoutput117 gpio_out[16] _1045_/Q VDD VSS sg13g2_buf_1
X_1078__346 _1078_/RESET_B VDD VSS sg13g2_tiehi
XFILLER_11_14 VDD VSS sg13g2_decap_8
XFILLER_11_58 VDD VSS sg13g2_fill_1
XFILLER_31_191 VDD VSS sg13g2_decap_8
XFILLER_39_291 VDD VSS sg13g2_fill_1
Xinput19 input19/X gpio_in[26] VDD VSS sg13g2_buf_1
XFILLER_6_313 VDD VSS sg13g2_decap_8
X_1080_ _1080_/Q clkload2/A _1080_/D _1080_/RESET_B VDD VSS sg13g2_dfrbpq_1
XFILLER_20_139 VDD VSS sg13g2_fill_1
X_0933_ _0933_/Y _0966_/A _0933_/B _0933_/C VDD VSS sg13g2_nor3_1
X_0864_ _0864_/Y _0996_/A _0996_/B _0966_/B _0980_/D VDD VSS sg13g2_nand4_1
X_0795_ _0796_/B _0927_/A1 _0794_/Y _0911_/B1 VDD VSS sg13g2_o21ai_1
XFILLER_9_162 VDD VSS sg13g2_decap_4
XFILLER_11_117 VDD VSS sg13g2_decap_8
XFILLER_22_35 VDD VSS sg13g2_decap_8
XFILLER_22_46 VDD VSS sg13g2_fill_1
XFILLER_19_206 VDD VSS sg13g2_fill_2
XFILLER_19_239 VDD VSS sg13g2_decap_8
Xfanout185 _0927_/A1 _0931_/A1 VDD VSS sg13g2_buf_1
Xfanout196 _0942_/A1 _0962_/A1 VDD VSS sg13g2_buf_1
XFILLER_27_294 VDD VSS sg13g2_fill_1
XFILLER_42_253 VDD VSS sg13g2_fill_1
XFILLER_10_172 VDD VSS sg13g2_decap_8
XFILLER_12_90 VDD VSS sg13g2_decap_8
XFILLER_6_165 VDD VSS sg13g2_decap_8
X_0580_ _0877_/A _0580_/A VDD VSS sg13g2_inv_1
XFILLER_40_7 VDD VSS sg13g2_decap_8
XFILLER_18_250 VDD VSS sg13g2_fill_2
XFILLER_18_294 VDD VSS sg13g2_fill_1
XFILLER_25_209 VDD VSS sg13g2_decap_8
X_1063_ _1063_/Q _1097_/CLK _1063_/D _1063_/RESET_B VDD VSS sg13g2_dfrbpq_1
X_0916_ _0916_/Y _0916_/A _0916_/B VDD VSS sg13g2_nor2_1
X_0847_ _0850_/A _0983_/A1 _0834_/Y _1064_/Q VDD VSS sg13g2_a21oi_1
X_0778_ _0778_/Y _0910_/A _0910_/B _0798_/C _0922_/D VDD VSS sg13g2_nand4_1
XFILLER_17_35 VDD VSS sg13g2_decap_4
XFILLER_24_264 VDD VSS sg13g2_fill_2
XFILLER_33_56 VDD VSS sg13g2_decap_8
XFILLER_33_67 VDD VSS sg13g2_fill_1
XFILLER_33_78 VDD VSS sg13g2_decap_8
X_1070__279 _1070_/RESET_B VDD VSS sg13g2_tiehi
XFILLER_15_275 VDD VSS sg13g2_decap_4
XFILLER_30_256 VDD VSS sg13g2_decap_8
Xhold408 input60/A s_axil_wdata[27] VDD VSS sg13g2_dlygate4sd3_1
Xhold419 input66/A s_axil_wdata[3] VDD VSS sg13g2_dlygate4sd3_1
X_0701_ _1027_/D _0698_/Y _0699_/Y _0700_/Y VDD VSS sg13g2_a21oi_1
X_0632_ _0632_/Y _1010_/Q _0656_/A2 _0656_/B1 VDD VSS sg13g2_o21ai_1
X_0563_ _0947_/A _0563_/A VDD VSS sg13g2_inv_1
XFILLER_38_323 VDD VSS sg13g2_decap_8
XFILLER_0_60 VDD VSS sg13g2_decap_8
XFILLER_21_212 VDD VSS sg13g2_decap_8
X_1046_ _1046_/Q clkload0/A _1046_/D _1046_/RESET_B VDD VSS sg13g2_dfrbpq_1
XFILLER_0_116 VDD VSS sg13g2_decap_8
XFILLER_28_89 VDD VSS sg13g2_decap_8
XFILLER_12_256 VDD VSS sg13g2_decap_8
XFILLER_5_49 VDD VSS sg13g2_decap_4
X_0615_ _0615_/Y _1065_/Q _0647_/A2 _0647_/B1 input27/X VDD VSS sg13g2_a22oi_1
XFILLER_38_186 VDD VSS sg13g2_decap_4
XFILLER_38_175 VDD VSS sg13g2_decap_4
XFILLER_14_14 VDD VSS sg13g2_decap_8
X_1029_ _1029_/Q _1033_/CLK _1029_/D _1029_/RESET_B VDD VSS sg13g2_dfrbpq_1
XFILLER_30_35 VDD VSS sg13g2_decap_8
XFILLER_5_219 VDD VSS sg13g2_fill_2
XFILLER_17_337 VDD VSS sg13g2_decap_8
XFILLER_23_318 VDD VSS sg13g2_decap_8
XFILLER_6_70 VDD VSS sg13g2_decap_8
XFILLER_25_35 VDD VSS sg13g2_decap_8
XFILLER_26_156 VDD VSS sg13g2_decap_8
XFILLER_2_28 VDD VSS sg13g2_decap_8
XFILLER_13_340 VDD VSS sg13g2_decap_8
XFILLER_17_156 VDD VSS sg13g2_fill_1
XFILLER_32_115 VDD VSS sg13g2_fill_2
Xoutput107 gpio_dir[7] _1100_/Q VDD VSS sg13g2_buf_1
X_0880_ _0883_/A _0896_/A1 _0867_/Y _1072_/Q VDD VSS sg13g2_a21oi_1
XFILLER_40_192 VDD VSS sg13g2_decap_4
Xoutput129 gpio_out[27] _1040_/Q VDD VSS sg13g2_buf_1
Xoutput118 gpio_out[17] _1046_/Q VDD VSS sg13g2_buf_1
XFILLER_39_270 VDD VSS sg13g2_fill_2
XFILLER_10_343 VDD VSS sg13g2_decap_4
XFILLER_7_0 VDD VSS sg13g2_decap_8
X_0932_ _0932_/Y _0932_/A _0932_/B VDD VSS sg13g2_nor2_1
X_0863_ _0866_/A _0995_/A1 _0834_/Y _1068_/Q VDD VSS sg13g2_a21oi_1
X_0794_ _0794_/Y _0926_/A _0926_/B _0798_/C _0922_/D VDD VSS sg13g2_nand4_1
XFILLER_9_185 VDD VSS sg13g2_decap_8
XFILLER_22_14 VDD VSS sg13g2_decap_8
XFILLER_22_58 VDD VSS sg13g2_decap_8
XFILLER_0_7 VDD VSS sg13g2_decap_8
XFILLER_19_218 VDD VSS sg13g2_decap_8
XFILLER_27_262 VDD VSS sg13g2_fill_2
Xfanout186 _0931_/A1 _0730_/Y VDD VSS sg13g2_buf_1
Xfanout197 _0896_/A1 _0962_/A1 VDD VSS sg13g2_buf_1
XFILLER_8_49 VDD VSS sg13g2_decap_4
XFILLER_42_287 VDD VSS sg13g2_decap_8
XFILLER_10_140 VDD VSS sg13g2_fill_1
XFILLER_10_151 VDD VSS sg13g2_decap_8
XFILLER_6_133 VDD VSS sg13g2_decap_8
XFILLER_33_7 VDD VSS sg13g2_decap_8
XFILLER_33_221 VDD VSS sg13g2_decap_8
XFILLER_33_243 VDD VSS sg13g2_fill_1
X_1062_ _1062_/Q _1097_/CLK _1062_/D _1062_/RESET_B VDD VSS sg13g2_dfrbpq_1
X_0915_ _0916_/B _0931_/A1 _0914_/Y _1000_/B VDD VSS sg13g2_o21ai_1
X_0846_ _1063_/D _0846_/A _0846_/B VDD VSS sg13g2_nor2_1
X_0777_ _0780_/A _0731_/B _0768_/Y _1047_/Q VDD VSS sg13g2_a21oi_1
XFILLER_17_14 VDD VSS sg13g2_decap_8
XFILLER_24_276 VDD VSS sg13g2_fill_2
XFILLER_24_298 VDD VSS sg13g2_decap_8
XFILLER_33_35 VDD VSS sg13g2_decap_8
XFILLER_30_202 VDD VSS sg13g2_decap_8
XFILLER_30_235 VDD VSS sg13g2_fill_2
X_0700_ _0700_/Y _1027_/Q _0712_/A2 _0712_/B1 VDD VSS sg13g2_o21ai_1
Xhold409 input56/A s_axil_wdata[23] VDD VSS sg13g2_dlygate4sd3_1
X_0631_ _0631_/Y _1053_/Q _0655_/A2 _0714_/A2 input31/X VDD VSS sg13g2_a22oi_1
X_0562_ _0951_/A _0562_/A VDD VSS sg13g2_inv_1
XFILLER_38_302 VDD VSS sg13g2_decap_8
X_1045_ _1045_/Q clkload0/A _1045_/D _1045_/RESET_B VDD VSS sg13g2_dfrbpq_1
XFILLER_21_279 VDD VSS sg13g2_decap_8
X_0829_ _1059_/D _0829_/A _0829_/B VDD VSS sg13g2_nor2_1
XFILLER_29_302 VDD VSS sg13g2_fill_1
XFILLER_28_35 VDD VSS sg13g2_decap_8
XFILLER_28_68 VDD VSS sg13g2_decap_8
XFILLER_29_335 VDD VSS sg13g2_decap_4
XFILLER_12_213 VDD VSS sg13g2_decap_8
XFILLER_12_224 VDD VSS sg13g2_fill_1
XFILLER_8_217 VDD VSS sg13g2_fill_1
XFILLER_8_206 VDD VSS sg13g2_decap_8
XFILLER_5_28 VDD VSS sg13g2_decap_8
XFILLER_22_0 VDD VSS sg13g2_decap_8
X_0614_ _0614_/Y _1097_/Q _0654_/A2 _0654_/B1 VDD VSS sg13g2_a21oi_1
XFILLER_26_305 VDD VSS sg13g2_decap_8
XFILLER_26_316 VDD VSS sg13g2_fill_1
XFILLER_38_198 VDD VSS sg13g2_decap_8
X_1028_ _1028_/Q _1033_/CLK _1028_/D _1028_/RESET_B VDD VSS sg13g2_dfrbpq_1
XFILLER_30_14 VDD VSS sg13g2_decap_8
XFILLER_39_89 VDD VSS sg13g2_decap_8
XFILLER_39_56 VDD VSS sg13g2_decap_8
XFILLER_29_198 VDD VSS sg13g2_decap_8
XFILLER_4_253 VDD VSS sg13g2_fill_2
XFILLER_31_341 VDD VSS sg13g2_fill_2
XFILLER_25_14 VDD VSS sg13g2_decap_8
XFILLER_25_58 VDD VSS sg13g2_fill_1
XFILLER_26_113 VDD VSS sg13g2_decap_8
Xclkbuf_4_7_0_clk_i clkload4/A clkbuf_0_clk_i/X VDD VSS sg13g2_buf_8
XFILLER_41_46 VDD VSS sg13g2_fill_2
XFILLER_41_35 VDD VSS sg13g2_decap_8
XFILLER_17_113 VDD VSS sg13g2_decap_8
XFILLER_40_171 VDD VSS sg13g2_decap_8
Xoutput108 gpio_dir[8] _1085_/Q VDD VSS sg13g2_buf_1
Xoutput119 gpio_out[18] _1047_/Q VDD VSS sg13g2_buf_1
XFILLER_9_345 VDD VSS sg13g2_fill_2
Xoutput90 gpio_dir[20] _1081_/Q VDD VSS sg13g2_buf_1
XFILLER_36_35 VDD VSS sg13g2_decap_8
XFILLER_14_149 VDD VSS sg13g2_decap_8
XFILLER_10_322 VDD VSS sg13g2_decap_8
X_1066__296 _1066_/RESET_B VDD VSS sg13g2_tiehi
X_0931_ _0932_/B _0931_/A1 hold410/X _1000_/B VDD VSS sg13g2_o21ai_1
X_0862_ _1067_/D _0862_/A _0862_/B VDD VSS sg13g2_nor2_1
XFILLER_9_175 VDD VSS sg13g2_fill_1
X_0793_ _0796_/A _0925_/A1 _0768_/Y _1051_/Q VDD VSS sg13g2_a21oi_1
X_1091__334 _1091_/RESET_B VDD VSS sg13g2_tiehi
XFILLER_19_208 VDD VSS sg13g2_fill_1
XFILLER_27_230 VDD VSS sg13g2_decap_4
Xfanout187 _0890_/A1 _0898_/A1 VDD VSS sg13g2_buf_1
Xfanout198 _0962_/A1 _0929_/A1 VDD VSS sg13g2_buf_1
XFILLER_8_28 VDD VSS sg13g2_decap_8
XFILLER_6_112 VDD VSS sg13g2_decap_8
XFILLER_26_7 VDD VSS sg13g2_decap_8
XFILLER_18_241 VDD VSS sg13g2_decap_4
XFILLER_33_200 VDD VSS sg13g2_decap_8
XFILLER_33_288 VDD VSS sg13g2_decap_8
X_1061_ _1061_/Q _1097_/CLK _1061_/D _1061_/RESET_B VDD VSS sg13g2_dfrbpq_1
X_0914_ _0914_/Y _0914_/A _0926_/B _0926_/C _0914_/D VDD VSS sg13g2_nand4_1
X_0845_ _0846_/B _0989_/A1 _0844_/Y _0731_/A VDD VSS sg13g2_o21ai_1
X_0776_ _1046_/D _0776_/A _0776_/B VDD VSS sg13g2_nor2_1
XFILLER_24_233 VDD VSS sg13g2_decap_8
XFILLER_24_244 VDD VSS sg13g2_fill_1
XFILLER_24_266 VDD VSS sg13g2_fill_1
XFILLER_33_14 VDD VSS sg13g2_decap_8
XFILLER_15_211 VDD VSS sg13g2_decap_8
XFILLER_15_244 VDD VSS sg13g2_decap_8
XFILLER_30_214 VDD VSS sg13g2_fill_2
X_1081__322 _1081_/RESET_B VDD VSS sg13g2_tiehi
X_0630_ _0630_/Y _1085_/Q _0651_/B1 _0714_/B1 VDD VSS sg13g2_a21oi_1
X_0561_ _0955_/A _0561_/A VDD VSS sg13g2_inv_1
X_1044_ _1044_/Q clkload3/A _1044_/D _1044_/RESET_B VDD VSS sg13g2_dfrbpq_1
XFILLER_0_95 VDD VSS sg13g2_decap_8
X_0828_ _0829_/B _0940_/A1 _0827_/Y _0960_/B1 VDD VSS sg13g2_o21ai_1
X_0759_ _1042_/D _0759_/A _0759_/B VDD VSS sg13g2_nor2_1
XFILLER_28_14 VDD VSS sg13g2_decap_8
XFILLER_28_58 VDD VSS sg13g2_decap_4
X_0613_ _1005_/D _0610_/Y _0611_/Y _0612_/Y VDD VSS sg13g2_a21oi_1
XFILLER_15_0 VDD VSS sg13g2_decap_8
X_1027_ _1027_/Q clkload9/A _1027_/D _1027_/RESET_B VDD VSS sg13g2_dfrbpq_1
XFILLER_38_155 VDD VSS sg13g2_fill_2
XFILLER_14_49 VDD VSS sg13g2_decap_8
Xclkbuf_4_3_0_clk_i clkload1/A clkbuf_0_clk_i/X VDD VSS sg13g2_buf_8
X_1071__376 _1071_/RESET_B VDD VSS sg13g2_tiehi
XFILLER_39_35 VDD VSS sg13g2_decap_8
XFILLER_20_81 VDD VSS sg13g2_decap_8
XFILLER_35_136 VDD VSS sg13g2_fill_1
XFILLER_35_169 VDD VSS sg13g2_decap_4
XFILLER_41_14 VDD VSS sg13g2_decap_8
X_1036__282 _1036_/RESET_B VDD VSS sg13g2_tiehi
XFILLER_32_117 VDD VSS sg13g2_fill_1
XFILLER_9_324 VDD VSS sg13g2_decap_8
Xoutput109 gpio_dir[9] _1086_/Q VDD VSS sg13g2_buf_1
Xoutput91 gpio_dir[21] _1082_/Q VDD VSS sg13g2_buf_1
Xoutput80 gpio_dir[11] _1088_/Q VDD VSS sg13g2_buf_1
XFILLER_16_180 VDD VSS sg13g2_decap_8
XFILLER_23_106 VDD VSS sg13g2_fill_2
XFILLER_23_139 VDD VSS sg13g2_decap_8
XFILLER_11_28 VDD VSS sg13g2_decap_8
XFILLER_31_172 VDD VSS sg13g2_decap_8
XFILLER_36_14 VDD VSS sg13g2_decap_8
XFILLER_10_301 VDD VSS sg13g2_decap_8
XFILLER_22_161 VDD VSS sg13g2_decap_8
XFILLER_6_327 VDD VSS sg13g2_decap_8
Xhold390 hold390/X _0988_/Y VDD VSS sg13g2_dlygate4sd3_1
XFILLER_20_109 VDD VSS sg13g2_decap_8
X_0930_ _0930_/Y _0930_/A _0930_/B _0984_/C _0930_/D VDD VSS sg13g2_nand4_1
X_0861_ _0862_/B _0989_/A1 _0860_/Y _0731_/A VDD VSS sg13g2_o21ai_1
X_0792_ _1050_/D _0792_/A _0792_/B VDD VSS sg13g2_nor2_1
XFILLER_36_242 VDD VSS sg13g2_decap_8
Xfanout188 _0898_/A1 _0964_/A1 VDD VSS sg13g2_buf_1
Xfanout199 _0929_/A1 _0729_/Y VDD VSS sg13g2_buf_1
XFILLER_27_275 VDD VSS sg13g2_fill_1
XFILLER_42_234 VDD VSS sg13g2_fill_2
XFILLER_10_186 VDD VSS sg13g2_decap_8
X_1005__343 _1005_/RESET_B VDD VSS sg13g2_tiehi
XFILLER_19_7 VDD VSS sg13g2_decap_8
X_1060_ _1060_/Q clkload5/A _1060_/D _1060_/RESET_B VDD VSS sg13g2_dfrbpq_1
X_0913_ _0916_/A _0925_/A1 _0900_/Y _1080_/Q VDD VSS sg13g2_a21oi_1
X_0844_ _0844_/Y _0976_/A _0988_/B _0966_/B _0996_/D VDD VSS sg13g2_nand4_1
X_0775_ _0776_/B _0911_/A1 _0774_/Y _0911_/B1 VDD VSS sg13g2_o21ai_1
XFILLER_24_212 VDD VSS sg13g2_decap_8
XFILLER_3_138 VDD VSS sg13g2_decap_8
XFILLER_15_201 VDD VSS sg13g2_fill_1
XFILLER_15_234 VDD VSS sg13g2_fill_1
XFILLER_30_237 VDD VSS sg13g2_fill_1
XFILLER_23_81 VDD VSS sg13g2_fill_2
X_0560_ _0959_/A _0560_/A VDD VSS sg13g2_inv_1
XFILLER_0_30 VDD VSS sg13g2_fill_1
XFILLER_0_74 VDD VSS sg13g2_decap_8
X_1043_ _1043_/Q clkload4/A _1043_/D _1043_/RESET_B VDD VSS sg13g2_dfrbpq_1
XFILLER_38_337 VDD VSS sg13g2_fill_2
XFILLER_21_226 VDD VSS sg13g2_fill_2
X_0827_ _0827_/Y _0959_/A _0939_/B _0966_/B _0959_/D VDD VSS sg13g2_nand4_1
X_0758_ _0759_/B _0890_/A1 _0757_/Y _0878_/B1 VDD VSS sg13g2_o21ai_1
XFILLER_29_315 VDD VSS sg13g2_decap_8
X_0689_ _1024_/D _0686_/Y _0687_/Y _0688_/Y VDD VSS sg13g2_a21oi_1
XFILLER_12_204 VDD VSS sg13g2_fill_1
X_1041__373 _1041_/RESET_B VDD VSS sg13g2_tiehi
XFILLER_18_81 VDD VSS sg13g2_decap_4
XFILLER_34_91 VDD VSS sg13g2_decap_8
X_0612_ _0612_/Y _1005_/Q _0644_/A2 _0648_/B1 VDD VSS sg13g2_o21ai_1
XFILLER_7_274 VDD VSS sg13g2_fill_2
XFILLER_38_101 VDD VSS sg13g2_fill_1
X_1026_ _1026_/Q _1033_/CLK _1026_/D _1026_/RESET_B VDD VSS sg13g2_dfrbpq_1
XFILLER_14_28 VDD VSS sg13g2_decap_8
XFILLER_30_49 VDD VSS sg13g2_decap_8
XFILLER_39_14 VDD VSS sg13g2_decap_8
XFILLER_29_101 VDD VSS sg13g2_decap_8
X_1069__284 _1069_/RESET_B VDD VSS sg13g2_tiehi
XFILLER_6_84 VDD VSS sg13g2_decap_8
XFILLER_25_49 VDD VSS sg13g2_decap_8
X_1009_ _1009_/Q clkload6/A _1009_/D _1009_/RESET_B VDD VSS sg13g2_dfrbpq_1
XFILLER_17_148 VDD VSS sg13g2_decap_4
XFILLER_9_303 VDD VSS sg13g2_decap_8
Xoutput92 gpio_dir[22] _1083_/Q VDD VSS sg13g2_buf_1
Xoutput81 gpio_dir[12] _1089_/Q VDD VSS sg13g2_buf_1
X_1015__323 _1015_/RESET_B VDD VSS sg13g2_tiehi
XFILLER_31_151 VDD VSS sg13g2_decap_8
XFILLER_14_107 VDD VSS sg13g2_fill_1
XFILLER_39_284 VDD VSS sg13g2_fill_2
XFILLER_22_140 VDD VSS sg13g2_decap_8
XFILLER_6_306 VDD VSS sg13g2_decap_8
Xhold380 _1101_/D _1000_/Y VDD VSS sg13g2_dlygate4sd3_1
Xhold391 input50/A s_axil_wdata[18] VDD VSS sg13g2_dlygate4sd3_1
XFILLER_9_100 VDD VSS sg13g2_fill_2
X_0860_ _0860_/Y _0992_/A _0996_/B _0966_/B _0996_/D VDD VSS sg13g2_nand4_1
X_0791_ _0792_/B _0927_/A1 _0790_/Y _0911_/B1 VDD VSS sg13g2_o21ai_1
XFILLER_9_199 VDD VSS sg13g2_decap_8
XFILLER_9_166 VDD VSS sg13g2_fill_1
XFILLER_9_155 VDD VSS sg13g2_decap_8
XFILLER_22_28 VDD VSS sg13g2_decap_8
X_0989_ _0990_/B _0989_/A1 hold390/X _0731_/A VDD VSS sg13g2_o21ai_1
Xfanout189 _0964_/A1 _0730_/Y VDD VSS sg13g2_buf_1
XFILLER_27_287 VDD VSS sg13g2_decap_8
XFILLER_10_165 VDD VSS sg13g2_decap_8
XFILLER_6_158 VDD VSS sg13g2_decap_8
XFILLER_6_147 VDD VSS sg13g2_fill_1
XFILLER_12_83 VDD VSS sg13g2_decap_8
XFILLER_5_0 VDD VSS sg13g2_decap_8
XFILLER_18_265 VDD VSS sg13g2_fill_2
X_1051__353 _1051_/RESET_B VDD VSS sg13g2_tiehi
XFILLER_18_287 VDD VSS sg13g2_decap_8
X_0912_ _0912_/Y _0912_/A _0912_/B VDD VSS sg13g2_nor2_1
XFILLER_41_290 VDD VSS sg13g2_decap_8
X_0843_ _0846_/A _0983_/A1 _0834_/Y _1063_/Q VDD VSS sg13g2_a21oi_1
X_0774_ _0774_/Y _0906_/A _0910_/B _0798_/C _0914_/D VDD VSS sg13g2_nand4_1
XFILLER_5_191 VDD VSS sg13g2_decap_8
XFILLER_38_0 VDD VSS sg13g2_decap_8
XFILLER_17_28 VDD VSS sg13g2_decap_8
XFILLER_17_39 VDD VSS sg13g2_fill_2
XFILLER_24_257 VDD VSS sg13g2_decap_8
XFILLER_33_49 VDD VSS sg13g2_decap_8
X_1074__364 _1074_/RESET_B VDD VSS sg13g2_tiehi
XFILLER_15_268 VDD VSS sg13g2_decap_8
XFILLER_15_279 VDD VSS sg13g2_fill_2
XFILLER_30_249 VDD VSS sg13g2_decap_8
XFILLER_31_7 VDD VSS sg13g2_decap_8
XFILLER_38_316 VDD VSS sg13g2_decap_8
XFILLER_0_53 VDD VSS sg13g2_decap_8
X_1042_ _1042_/Q _1070_/CLK _1042_/D _1042_/RESET_B VDD VSS sg13g2_dfrbpq_1
XFILLER_21_205 VDD VSS sg13g2_decap_8
XFILLER_21_249 VDD VSS sg13g2_fill_2
XFILLER_9_84 VDD VSS sg13g2_fill_1
XFILLER_0_109 VDD VSS sg13g2_decap_8
X_0826_ _0829_/A _0983_/A1 _0801_/Y _1059_/Q VDD VSS sg13g2_a21oi_1
X_0757_ _0757_/Y _0889_/A _0897_/B _0867_/B _0881_/D VDD VSS sg13g2_nand4_1
X_0688_ _0688_/Y _1024_/Q _0712_/A2 _0712_/B1 VDD VSS sg13g2_o21ai_1
XFILLER_34_70 VDD VSS sg13g2_decap_8
X_1085__290 _1085_/RESET_B VDD VSS sg13g2_tiehi
X_0611_ _0611_/Y _1064_/Q _0647_/A2 _0647_/B1 input26/X VDD VSS sg13g2_a22oi_1
XFILLER_38_179 VDD VSS sg13g2_fill_1
XFILLER_38_168 VDD VSS sg13g2_decap_8
XFILLER_38_113 VDD VSS sg13g2_decap_4
X_1025_ _1025_/Q _1033_/CLK _1025_/D _1025_/RESET_B VDD VSS sg13g2_dfrbpq_1
XFILLER_30_28 VDD VSS sg13g2_decap_8
X_1025__303 _1025_/RESET_B VDD VSS sg13g2_tiehi
X_0809_ _1054_/D _0809_/A _0809_/B VDD VSS sg13g2_nor2_1
XFILLER_20_61 VDD VSS sg13g2_fill_2
X_1087__374 _1087_/RESET_B VDD VSS sg13g2_tiehi
XFILLER_6_63 VDD VSS sg13g2_decap_8
XFILLER_20_0 VDD VSS sg13g2_decap_8
XFILLER_26_127 VDD VSS sg13g2_fill_2
XFILLER_25_28 VDD VSS sg13g2_decap_8
X_1008_ _1008_/Q clkload7/A _1008_/D _1008_/RESET_B VDD VSS sg13g2_dfrbpq_1
XFILLER_9_7 VDD VSS sg13g2_decap_8
XFILLER_13_333 VDD VSS sg13g2_decap_8
XFILLER_25_171 VDD VSS sg13g2_decap_8
XFILLER_32_108 VDD VSS sg13g2_decap_8
XFILLER_40_196 VDD VSS sg13g2_fill_2
XFILLER_40_185 VDD VSS sg13g2_decap_8
XFILLER_40_141 VDD VSS sg13g2_fill_2
Xoutput93 gpio_dir[23] _1084_/Q VDD VSS sg13g2_buf_1
Xoutput82 gpio_dir[13] _1090_/Q VDD VSS sg13g2_buf_1
XFILLER_16_160 VDD VSS sg13g2_fill_2
XFILLER_39_252 VDD VSS sg13g2_decap_8
XFILLER_10_336 VDD VSS sg13g2_decap_8
Xhold381 input77/A s_axil_wvalid VDD VSS sg13g2_dlygate4sd3_1
Xhold392 hold392/X _0910_/Y VDD VSS sg13g2_dlygate4sd3_1
XFILLER_13_152 VDD VSS sg13g2_decap_4
XFILLER_13_196 VDD VSS sg13g2_decap_4
X_0790_ _0790_/Y _0922_/A _0910_/B _0798_/C _0922_/D VDD VSS sg13g2_nand4_1
XFILLER_3_42 VDD VSS sg13g2_decap_8
XFILLER_36_222 VDD VSS sg13g2_fill_1
X_0988_ _0988_/Y _0988_/A _0988_/B _0992_/C _0996_/D VDD VSS sg13g2_nand4_1
XFILLER_27_200 VDD VSS sg13g2_fill_1
Xfanout179 _0989_/A1 _0997_/A1 VDD VSS sg13g2_buf_1
XFILLER_27_255 VDD VSS sg13g2_fill_2
XFILLER_27_299 VDD VSS sg13g2_decap_8
X_1033__287 _1033_/RESET_B VDD VSS sg13g2_tiehi
XFILLER_10_111 VDD VSS sg13g2_decap_8
XFILLER_10_144 VDD VSS sg13g2_decap_8
XFILLER_12_73 VDD VSS sg13g2_decap_4
XFILLER_6_126 VDD VSS sg13g2_decap_8
XFILLER_33_214 VDD VSS sg13g2_decap_8
XFILLER_33_236 VDD VSS sg13g2_decap_8
X_0911_ _0912_/B _0911_/A1 hold392/X _0911_/B1 VDD VSS sg13g2_o21ai_1
X_0842_ _1062_/D _0842_/A _0842_/B VDD VSS sg13g2_nor2_1
X_0773_ _0776_/A _0731_/B _0768_/Y _1046_/Q VDD VSS sg13g2_a21oi_1
XFILLER_5_170 VDD VSS sg13g2_fill_2
XFILLER_33_28 VDD VSS sg13g2_decap_8
XFILLER_15_225 VDD VSS sg13g2_decap_4
XFILLER_15_258 VDD VSS sg13g2_decap_4
XFILLER_23_291 VDD VSS sg13g2_decap_8
XFILLER_30_228 VDD VSS sg13g2_decap_8
XFILLER_24_7 VDD VSS sg13g2_decap_8
XFILLER_0_21 VDD VSS sg13g2_decap_8
X_1041_ _1041_/Q _1070_/CLK _1041_/D _1041_/RESET_B VDD VSS sg13g2_dfrbpq_1
X_0825_ _1058_/D _0825_/A _0825_/B VDD VSS sg13g2_nor2_1
XFILLER_9_96 VDD VSS sg13g2_decap_4
X_0756_ _0759_/A _0896_/A1 _0735_/Y _1042_/Q VDD VSS sg13g2_a21oi_1
X_0687_ _0687_/Y _1051_/Q _0715_/A2 _0711_/B1 _1083_/Q VDD VSS sg13g2_a22oi_1
XFILLER_28_28 VDD VSS sg13g2_decap_8
XFILLER_29_306 VDD VSS sg13g2_decap_4
XFILLER_29_328 VDD VSS sg13g2_decap_8
XFILLER_20_272 VDD VSS sg13g2_decap_8
XFILLER_20_294 VDD VSS sg13g2_decap_8
XFILLER_11_250 VDD VSS sg13g2_decap_8
X_0610_ _0610_/Y _1096_/Q _0651_/B1 _0686_/B1 VDD VSS sg13g2_a21oi_1
XFILLER_7_298 VDD VSS sg13g2_decap_8
XFILLER_7_276 VDD VSS sg13g2_fill_1
X_1024_ _1024_/Q clkload9/A _1024_/D _1024_/RESET_B VDD VSS sg13g2_dfrbpq_1
XFILLER_34_320 VDD VSS sg13g2_decap_4
X_0808_ _0809_/B _0940_/A1 _0807_/Y _0964_/B1 VDD VSS sg13g2_o21ai_1
XFILLER_29_136 VDD VSS sg13g2_decap_4
X_0739_ _1037_/D _0739_/A _0739_/B VDD VSS sg13g2_nor2_1
XFILLER_39_49 VDD VSS sg13g2_decap_8
XFILLER_17_309 VDD VSS sg13g2_decap_4
XFILLER_29_169 VDD VSS sg13g2_fill_2
XFILLER_37_191 VDD VSS sg13g2_decap_8
XFILLER_40_345 VDD VSS sg13g2_fill_2
XFILLER_20_95 VDD VSS sg13g2_decap_8
XFILLER_29_82 VDD VSS sg13g2_decap_4
XFILLER_31_334 VDD VSS sg13g2_decap_8
X_1048__359 _1048_/RESET_B VDD VSS sg13g2_tiehi
XFILLER_6_42 VDD VSS sg13g2_decap_8
XFILLER_13_0 VDD VSS sg13g2_decap_8
XFILLER_19_180 VDD VSS sg13g2_decap_8
XFILLER_26_106 VDD VSS sg13g2_decap_8
X_1007_ _1007_/Q _1091_/CLK _1007_/D _1007_/RESET_B VDD VSS sg13g2_dfrbpq_1
XFILLER_41_28 VDD VSS sg13g2_decap_8
XFILLER_17_106 VDD VSS sg13g2_decap_8
XFILLER_13_312 VDD VSS sg13g2_decap_8
XFILLER_25_150 VDD VSS sg13g2_decap_8
XFILLER_25_183 VDD VSS sg13g2_decap_8
XFILLER_40_153 VDD VSS sg13g2_fill_1
XFILLER_9_338 VDD VSS sg13g2_decap_8
Xoutput94 gpio_dir[24] _1069_/Q VDD VSS sg13g2_buf_1
Xoutput83 gpio_dir[14] _1091_/Q VDD VSS sg13g2_buf_1
XFILLER_39_231 VDD VSS sg13g2_decap_8
XFILLER_36_28 VDD VSS sg13g2_decap_8
XFILLER_10_315 VDD VSS sg13g2_decap_8
XFILLER_22_175 VDD VSS sg13g2_fill_1
Xhold382 _0734_/A _0732_/X VDD VSS sg13g2_dlygate4sd3_1
Xhold393 _1079_/D _0912_/Y VDD VSS sg13g2_dlygate4sd3_1
X_1077__352 _1077_/RESET_B VDD VSS sg13g2_tiehi
XFILLER_3_21 VDD VSS sg13g2_decap_8
XFILLER_36_201 VDD VSS sg13g2_decap_8
XFILLER_36_289 VDD VSS sg13g2_fill_1
X_0987_ _0990_/A _0987_/A1 _0966_/Y _1098_/Q VDD VSS sg13g2_a21oi_1
XFILLER_27_223 VDD VSS sg13g2_decap_8
XFILLER_27_245 VDD VSS sg13g2_decap_4
XFILLER_42_259 VDD VSS sg13g2_fill_2
XFILLER_6_105 VDD VSS sg13g2_decap_8
XFILLER_18_223 VDD VSS sg13g2_fill_2
XFILLER_18_245 VDD VSS sg13g2_fill_1
X_0910_ _0910_/Y _0910_/A _0910_/B _0926_/C _0922_/D VDD VSS sg13g2_nand4_1
X_0841_ _0842_/B _0985_/A1 _0840_/Y _0985_/B1 VDD VSS sg13g2_o21ai_1
X_0772_ _1045_/D _0772_/A _0772_/B VDD VSS sg13g2_nor2_1
XFILLER_24_226 VDD VSS sg13g2_decap_8
XFILLER_23_95 VDD VSS sg13g2_fill_2
XFILLER_17_7 VDD VSS sg13g2_decap_8
X_1040_ _1040_/Q clkload3/A _1040_/D _1040_/RESET_B VDD VSS sg13g2_dfrbpq_1
XFILLER_0_88 VDD VSS sg13g2_decap_8
X_0824_ _0825_/B _0940_/A1 _0823_/Y _0985_/B1 VDD VSS sg13g2_o21ai_1
X_0755_ _1041_/D _0755_/A _0755_/B VDD VSS sg13g2_nor2_1
X_1058__328 _1058_/RESET_B VDD VSS sg13g2_tiehi
X_0686_ _0686_/Y input15/X _0686_/A2 _0686_/B1 VDD VSS sg13g2_a21oi_1
XFILLER_43_0 VDD VSS sg13g2_decap_8
X_1002__349 _1002_/RESET_B VDD VSS sg13g2_tiehi
XFILLER_43_332 VDD VSS sg13g2_fill_2
X_1023_ _1023_/Q _1033_/CLK _1023_/D _1023_/RESET_B VDD VSS sg13g2_dfrbpq_1
X_0807_ _0807_/Y _0939_/A _0939_/B _0933_/B _0943_/D VDD VSS sg13g2_nand4_1
X_0738_ _0739_/B _0964_/A1 _0737_/Y _0878_/B1 VDD VSS sg13g2_o21ai_1
X_0669_ _1019_/D _0666_/Y _0667_/Y _0668_/Y VDD VSS sg13g2_a21oi_1
XFILLER_39_28 VDD VSS sg13g2_decap_8
XFILLER_20_63 VDD VSS sg13g2_fill_1
XFILLER_20_74 VDD VSS sg13g2_decap_8
XFILLER_28_192 VDD VSS sg13g2_fill_2
XFILLER_35_129 VDD VSS sg13g2_decap_8
XFILLER_6_98 VDD VSS sg13g2_decap_8
XFILLER_6_21 VDD VSS sg13g2_decap_8
X_1006_ _1006_/Q clkload6/A _1006_/D _1006_/RESET_B VDD VSS sg13g2_dfrbpq_1
XFILLER_15_74 VDD VSS sg13g2_decap_8
XFILLER_15_96 VDD VSS sg13g2_fill_2
XFILLER_25_195 VDD VSS sg13g2_decap_8
XFILLER_9_317 VDD VSS sg13g2_decap_8
XFILLER_40_143 VDD VSS sg13g2_fill_1
XFILLER_31_51 VDD VSS sg13g2_decap_8
XFILLER_31_62 VDD VSS sg13g2_fill_2
Xoutput95 gpio_dir[25] _1070_/Q VDD VSS sg13g2_buf_1
Xoutput84 gpio_dir[15] _1092_/Q VDD VSS sg13g2_buf_1
XFILLER_16_173 VDD VSS sg13g2_decap_8
XFILLER_31_165 VDD VSS sg13g2_decap_8
XFILLER_31_198 VDD VSS sg13g2_decap_4
XFILLER_22_154 VDD VSS sg13g2_decap_8
Xhold383 input48/A s_axil_wdata[16] VDD VSS sg13g2_dlygate4sd3_1
Xhold394 input55/A s_axil_wdata[22] VDD VSS sg13g2_dlygate4sd3_1
XFILLER_36_235 VDD VSS sg13g2_decap_8
X_0986_ _1097_/D _0986_/A _0986_/B VDD VSS sg13g2_nor2_1
XFILLER_27_257 VDD VSS sg13g2_fill_1
XFILLER_27_268 VDD VSS sg13g2_decap_8
XFILLER_10_179 VDD VSS sg13g2_decap_8
XFILLER_12_97 VDD VSS sg13g2_decap_8
X_1090__350 _1090_/RESET_B VDD VSS sg13g2_tiehi
X_1012__329 _1012_/RESET_B VDD VSS sg13g2_tiehi
XFILLER_37_83 VDD VSS sg13g2_decap_4
X_0840_ _0840_/Y _0972_/A _0984_/B _0933_/B _0984_/D VDD VSS sg13g2_nand4_1
X_0771_ _0772_/B _0911_/A1 _0770_/Y _0997_/B1 VDD VSS sg13g2_o21ai_1
XFILLER_5_172 VDD VSS sg13g2_fill_1
XFILLER_5_150 VDD VSS sg13g2_decap_8
X_0969_ _0970_/B _0989_/A1 _0968_/Y _0997_/B1 VDD VSS sg13g2_o21ai_1
XFILLER_23_63 VDD VSS sg13g2_decap_4
XFILLER_2_131 VDD VSS sg13g2_decap_4
XFILLER_3_0 VDD VSS sg13g2_decap_8
XFILLER_0_67 VDD VSS sg13g2_decap_8
XFILLER_21_219 VDD VSS sg13g2_decap_8
XFILLER_9_21 VDD VSS sg13g2_decap_8
X_0823_ _0823_/Y _0955_/A _0939_/B _0831_/C _0943_/D VDD VSS sg13g2_nand4_1
X_0754_ _0755_/B _0898_/A1 _0753_/Y _0726_/B VDD VSS sg13g2_o21ai_1
X_0685_ _1023_/D _0682_/Y _0683_/Y _0684_/Y VDD VSS sg13g2_a21oi_1
XFILLER_36_0 VDD VSS sg13g2_decap_8
X_1099_ _1099_/Q _1100_/CLK _1099_/D _1099_/RESET_B VDD VSS sg13g2_dfrbpq_1
XFILLER_18_85 VDD VSS sg13g2_fill_2
XFILLER_34_84 VDD VSS sg13g2_decap_8
XFILLER_43_311 VDD VSS sg13g2_decap_8
XFILLER_7_289 VDD VSS sg13g2_fill_2
XFILLER_7_267 VDD VSS sg13g2_decap_8
X_1022_ _1022_/Q clkload8/A _1022_/D _1022_/RESET_B VDD VSS sg13g2_dfrbpq_1
X_0806_ _0809_/A _0958_/A1 _0801_/Y _1054_/Q VDD VSS sg13g2_a21oi_1
X_0737_ _0737_/Y _0869_/A _0889_/B _0867_/B _0881_/D VDD VSS sg13g2_nand4_1
X_0668_ _0668_/Y _1019_/Q _0593_/B _0704_/B1 VDD VSS sg13g2_o21ai_1
X_0599_ _0599_/Y _1061_/Q _0647_/A2 _0654_/A2 _1093_/Q VDD VSS sg13g2_a22oi_1
XFILLER_37_182 VDD VSS sg13g2_fill_1
XFILLER_37_171 VDD VSS sg13g2_decap_8
XFILLER_4_215 VDD VSS sg13g2_decap_4
XFILLER_16_344 VDD VSS sg13g2_fill_2
XFILLER_6_77 VDD VSS sg13g2_decap_8
XFILLER_19_193 VDD VSS sg13g2_decap_8
XFILLER_22_336 VDD VSS sg13g2_fill_2
X_1005_ _1005_/Q clkload6/A _1005_/D _1005_/RESET_B VDD VSS sg13g2_dfrbpq_1
XFILLER_15_42 VDD VSS sg13g2_fill_2
X_1047__361 _1047_/RESET_B VDD VSS sg13g2_tiehi
XFILLER_40_166 VDD VSS sg13g2_fill_1
Xoutput96 gpio_dir[26] _1071_/Q VDD VSS sg13g2_buf_1
Xoutput85 gpio_dir[16] _1077_/Q VDD VSS sg13g2_buf_1
XFILLER_31_122 VDD VSS sg13g2_fill_1
XFILLER_31_144 VDD VSS sg13g2_decap_8
X_1022__309 _1022_/RESET_B VDD VSS sg13g2_tiehi
.ends
