* NGSPICE file created from picorv32_macro.ext - technology: ihp-sg13g2

* Black-box entry subcircuit for sg13g2_decap_4 abstract view
.subckt sg13g2_decap_4 VDD VSS
.ends

* Black-box entry subcircuit for sg13g2_decap_8 abstract view
.subckt sg13g2_decap_8 VDD VSS
.ends

* Black-box entry subcircuit for sg13g2_mux2_1 abstract view
.subckt sg13g2_mux2_1 X A0 A1 S VDD VSS
.ends

* Black-box entry subcircuit for sg13g2_nor3_1 abstract view
.subckt sg13g2_nor3_1 Y A B C VDD VSS
.ends

* Black-box entry subcircuit for sg13g2_fill_1 abstract view
.subckt sg13g2_fill_1 VDD VSS
.ends

* Black-box entry subcircuit for sg13g2_nor2_1 abstract view
.subckt sg13g2_nor2_1 Y A B VDD VSS
.ends

* Black-box entry subcircuit for sg13g2_tiehi abstract view
.subckt sg13g2_tiehi L_HI VDD VSS
.ends

* Black-box entry subcircuit for sg13g2_fill_2 abstract view
.subckt sg13g2_fill_2 VDD VSS
.ends

* Black-box entry subcircuit for sg13g2_o21ai_1 abstract view
.subckt sg13g2_o21ai_1 Y A1 A2 B1 VDD VSS
.ends

* Black-box entry subcircuit for sg13g2_a21oi_1 abstract view
.subckt sg13g2_a21oi_1 Y A1 A2 B1 VDD VSS
.ends

* Black-box entry subcircuit for sg13g2_buf_1 abstract view
.subckt sg13g2_buf_1 X A VDD VSS
.ends

* Black-box entry subcircuit for sg13g2_nor4_1 abstract view
.subckt sg13g2_nor4_1 Y A B C D VDD VSS
.ends

* Black-box entry subcircuit for sg13g2_nand2_1 abstract view
.subckt sg13g2_nand2_1 Y A B VDD VSS
.ends

* Black-box entry subcircuit for sg13g2_a221oi_1 abstract view
.subckt sg13g2_a221oi_1 Y A1 A2 B1 B2 C1 VDD VSS
.ends

* Black-box entry subcircuit for sg13g2_dfrbpq_1 abstract view
.subckt sg13g2_dfrbpq_1 Q CLK D RESET_B VDD VSS
.ends

* Black-box entry subcircuit for sg13g2_mux4_1 abstract view
.subckt sg13g2_mux4_1 X A0 A1 A2 A3 S0 S1 VDD VSS
.ends

* Black-box entry subcircuit for sg13g2_inv_1 abstract view
.subckt sg13g2_inv_1 Y A VDD VSS
.ends

* Black-box entry subcircuit for sg13g2_nand3_1 abstract view
.subckt sg13g2_nand3_1 Y A B C VDD VSS
.ends

* Black-box entry subcircuit for sg13g2_a21o_1 abstract view
.subckt sg13g2_a21o_1 X A1 A2 B1 VDD VSS
.ends

* Black-box entry subcircuit for sg13g2_and4_1 abstract view
.subckt sg13g2_and4_1 X A B C D VDD VSS
.ends

* Black-box entry subcircuit for sg13g2_nand3b_1 abstract view
.subckt sg13g2_nand3b_1 Y A_N B C VDD VSS
.ends

* Black-box entry subcircuit for sg13g2_a22oi_1 abstract view
.subckt sg13g2_a22oi_1 Y A1 A2 B1 B2 VDD VSS
.ends

* Black-box entry subcircuit for sg13g2_and2_1 abstract view
.subckt sg13g2_and2_1 X A B VDD VSS
.ends

* Black-box entry subcircuit for sg13g2_buf_16 abstract view
.subckt sg13g2_buf_16 X A VDD VSS
.ends

* Black-box entry subcircuit for sg13g2_nand2b_1 abstract view
.subckt sg13g2_nand2b_1 Y A_N B VDD VSS
.ends

* Black-box entry subcircuit for sg13g2_or2_1 abstract view
.subckt sg13g2_or2_1 X A B VDD VSS
.ends

* Black-box entry subcircuit for sg13g2_nand4_1 abstract view
.subckt sg13g2_nand4_1 Y A B C D VDD VSS
.ends

* Black-box entry subcircuit for sg13g2_xnor2_1 abstract view
.subckt sg13g2_xnor2_1 Y A B VDD VSS
.ends

* Black-box entry subcircuit for sg13g2_and3_1 abstract view
.subckt sg13g2_and3_1 X A B C VDD VSS
.ends

* Black-box entry subcircuit for sg13g2_inv_2 abstract view
.subckt sg13g2_inv_2 Y A VDD VSS
.ends

* Black-box entry subcircuit for sg13g2_or4_1 abstract view
.subckt sg13g2_or4_1 X A B C D VDD VSS
.ends

* Black-box entry subcircuit for sg13g2_antennanp abstract view
.subckt sg13g2_antennanp A VDD VSS
.ends

* Black-box entry subcircuit for sg13g2_buf_8 abstract view
.subckt sg13g2_buf_8 X A VDD VSS
.ends

* Black-box entry subcircuit for sg13g2_nor2b_1 abstract view
.subckt sg13g2_nor2b_1 Y A B_N VDD VSS
.ends

* Black-box entry subcircuit for sg13g2_inv_4 abstract view
.subckt sg13g2_inv_4 Y A VDD VSS
.ends

* Black-box entry subcircuit for sg13g2_dlygate4sd3_1 abstract view
.subckt sg13g2_dlygate4sd3_1 X A VDD VSS
.ends

* Black-box entry subcircuit for sg13g2_xor2_1 abstract view
.subckt sg13g2_xor2_1 X A B VDD VSS
.ends

* Black-box entry subcircuit for sg13g2_or3_1 abstract view
.subckt sg13g2_or3_1 X A B C VDD VSS
.ends

* Black-box entry subcircuit for sg13g2_inv_8 abstract view
.subckt sg13g2_inv_8 Y A VDD VSS
.ends

* Black-box entry subcircuit for sg13g2_tielo abstract view
.subckt sg13g2_tielo L_LO VDD VSS
.ends

.subckt picorv32_macro VDD VSS clk_i mem_axi_araddr[0] mem_axi_araddr[10] mem_axi_araddr[11]
+ mem_axi_araddr[12] mem_axi_araddr[13] mem_axi_araddr[14] mem_axi_araddr[15] mem_axi_araddr[16]
+ mem_axi_araddr[17] mem_axi_araddr[18] mem_axi_araddr[19] mem_axi_araddr[1] mem_axi_araddr[20]
+ mem_axi_araddr[21] mem_axi_araddr[22] mem_axi_araddr[23] mem_axi_araddr[24] mem_axi_araddr[25]
+ mem_axi_araddr[26] mem_axi_araddr[27] mem_axi_araddr[28] mem_axi_araddr[29] mem_axi_araddr[2]
+ mem_axi_araddr[30] mem_axi_araddr[31] mem_axi_araddr[3] mem_axi_araddr[4] mem_axi_araddr[5]
+ mem_axi_araddr[6] mem_axi_araddr[7] mem_axi_araddr[8] mem_axi_araddr[9] mem_axi_arprot[0]
+ mem_axi_arprot[1] mem_axi_arprot[2] mem_axi_arready mem_axi_arvalid mem_axi_awaddr[0]
+ mem_axi_awaddr[10] mem_axi_awaddr[11] mem_axi_awaddr[12] mem_axi_awaddr[13] mem_axi_awaddr[14]
+ mem_axi_awaddr[15] mem_axi_awaddr[16] mem_axi_awaddr[17] mem_axi_awaddr[18] mem_axi_awaddr[19]
+ mem_axi_awaddr[1] mem_axi_awaddr[20] mem_axi_awaddr[21] mem_axi_awaddr[22] mem_axi_awaddr[23]
+ mem_axi_awaddr[24] mem_axi_awaddr[25] mem_axi_awaddr[26] mem_axi_awaddr[27] mem_axi_awaddr[28]
+ mem_axi_awaddr[29] mem_axi_awaddr[2] mem_axi_awaddr[30] mem_axi_awaddr[31] mem_axi_awaddr[3]
+ mem_axi_awaddr[4] mem_axi_awaddr[5] mem_axi_awaddr[6] mem_axi_awaddr[7] mem_axi_awaddr[8]
+ mem_axi_awaddr[9] mem_axi_awprot[0] mem_axi_awprot[1] mem_axi_awprot[2] mem_axi_awready
+ mem_axi_awvalid mem_axi_bready mem_axi_bresp[0] mem_axi_bresp[1] mem_axi_bvalid
+ mem_axi_rdata[0] mem_axi_rdata[10] mem_axi_rdata[11] mem_axi_rdata[12] mem_axi_rdata[13]
+ mem_axi_rdata[14] mem_axi_rdata[15] mem_axi_rdata[16] mem_axi_rdata[17] mem_axi_rdata[18]
+ mem_axi_rdata[19] mem_axi_rdata[1] mem_axi_rdata[20] mem_axi_rdata[21] mem_axi_rdata[22]
+ mem_axi_rdata[23] mem_axi_rdata[24] mem_axi_rdata[25] mem_axi_rdata[26] mem_axi_rdata[27]
+ mem_axi_rdata[28] mem_axi_rdata[29] mem_axi_rdata[2] mem_axi_rdata[30] mem_axi_rdata[31]
+ mem_axi_rdata[3] mem_axi_rdata[4] mem_axi_rdata[5] mem_axi_rdata[6] mem_axi_rdata[7]
+ mem_axi_rdata[8] mem_axi_rdata[9] mem_axi_rready mem_axi_rresp[0] mem_axi_rresp[1]
+ mem_axi_rvalid mem_axi_wdata[0] mem_axi_wdata[10] mem_axi_wdata[11] mem_axi_wdata[12]
+ mem_axi_wdata[13] mem_axi_wdata[14] mem_axi_wdata[15] mem_axi_wdata[16] mem_axi_wdata[17]
+ mem_axi_wdata[18] mem_axi_wdata[19] mem_axi_wdata[1] mem_axi_wdata[20] mem_axi_wdata[21]
+ mem_axi_wdata[22] mem_axi_wdata[23] mem_axi_wdata[24] mem_axi_wdata[25] mem_axi_wdata[26]
+ mem_axi_wdata[27] mem_axi_wdata[28] mem_axi_wdata[29] mem_axi_wdata[2] mem_axi_wdata[30]
+ mem_axi_wdata[31] mem_axi_wdata[3] mem_axi_wdata[4] mem_axi_wdata[5] mem_axi_wdata[6]
+ mem_axi_wdata[7] mem_axi_wdata[8] mem_axi_wdata[9] mem_axi_wready mem_axi_wstrb[0]
+ mem_axi_wstrb[1] mem_axi_wstrb[2] mem_axi_wstrb[3] mem_axi_wvalid rst_ni trap
XFILLER_100_127 VDD VSS sg13g2_decap_4
XFILLER_171_1371 VDD VSS sg13g2_decap_8
XFILLER_45_1396 VDD VSS sg13g2_decap_8
X_09671_ _14264_/D _09770_/A1 _14264_/Q _09672_/S VDD VSS sg13g2_mux2_1
XFILLER_95_862 VDD VSS sg13g2_decap_8
XFILLER_80_1298 VDD VSS sg13g2_decap_8
XFILLER_94_361 VDD VSS sg13g2_decap_4
XFILLER_39_266 VDD VSS sg13g2_decap_8
X_08622_ _08622_/Y _08622_/A _08622_/B _08622_/C VDD VSS sg13g2_nor3_1
XFILLER_94_383 VDD VSS sg13g2_fill_1
X_08553_ _08553_/Y _08553_/A _08553_/B VDD VSS sg13g2_nor2_1
XFILLER_23_601 VDD VSS sg13g2_decap_8
XFILLER_70_729 VDD VSS sg13g2_decap_8
XFILLER_74_1014 VDD VSS sg13g2_decap_8
X_08484_ _08484_/Y _08625_/A _08484_/B _08484_/C VDD VSS sg13g2_nor3_1
XFILLER_35_483 VDD VSS sg13g2_fill_1
XFILLER_51_943 VDD VSS sg13g2_decap_8
XFILLER_168_606 VDD VSS sg13g2_decap_8
XFILLER_126_1126 VDD VSS sg13g2_decap_4
XFILLER_165_1175 VDD VSS sg13g2_decap_8
XFILLER_23_656 VDD VSS sg13g2_decap_4
X_14052__2150 _14052_/RESET_B VDD VSS sg13g2_tiehi
XFILLER_161_1017 VDD VSS sg13g2_fill_2
XFILLER_39_1189 VDD VSS sg13g2_decap_8
XFILLER_22_144 VDD VSS sg13g2_decap_8
XFILLER_11_818 VDD VSS sg13g2_decap_8
XFILLER_167_116 VDD VSS sg13g2_decap_8
XFILLER_52_1312 VDD VSS sg13g2_decap_8
XFILLER_51_998 VDD VSS sg13g2_decap_8
XFILLER_109_706 VDD VSS sg13g2_fill_2
XFILLER_17_1476 VDD VSS sg13g2_fill_2
X_14656__1546 _14656_/RESET_B VDD VSS sg13g2_tiehi
X_09105_ _09105_/Y _09158_/A _10752_/B _09104_/X VDD VSS sg13g2_o21ai_1
XFILLER_163_300 VDD VSS sg13g2_decap_4
XFILLER_52_1389 VDD VSS sg13g2_decap_8
XFILLER_136_536 VDD VSS sg13g2_decap_4
XFILLER_87_1419 VDD VSS sg13g2_decap_8
X_09036_ _09036_/Y _14906_/Q _09031_/C _09035_/Y VDD VSS sg13g2_a21oi_1
XFILLER_108_249 VDD VSS sg13g2_fill_1
XFILLER_102_1170 VDD VSS sg13g2_decap_8
XFILLER_117_761 VDD VSS sg13g2_decap_8
X_14800__2936 _14800_/RESET_B VDD VSS sg13g2_tiehi
XFILLER_151_528 VDD VSS sg13g2_decap_8
XFILLER_11_1086 VDD VSS sg13g2_decap_8
XFILLER_137_1211 VDD VSS sg13g2_decap_8
XFILLER_89_100 VDD VSS sg13g2_decap_8
XFILLER_105_945 VDD VSS sg13g2_decap_8
XFILLER_117_44 VDD VSS sg13g2_fill_1
XFILLER_172_1102 VDD VSS sg13g2_decap_8
XFILLER_7_7 VDD VSS sg13g2_decap_8
XFILLER_104_433 VDD VSS sg13g2_fill_1
XFILLER_116_293 VDD VSS sg13g2_fill_1
XFILLER_117_55 VDD VSS sg13g2_decap_8
XFILLER_176_1282 VDD VSS sg13g2_decap_8
XFILLER_85_1176 VDD VSS sg13g2_decap_8
XFILLER_78_807 VDD VSS sg13g2_fill_2
XFILLER_120_904 VDD VSS sg13g2_decap_8
XFILLER_105_989 VDD VSS sg13g2_decap_8
Xfanout820 _12450_/S1 fanout829/X VDD VSS sg13g2_buf_1
XFILLER_117_99 VDD VSS sg13g2_decap_8
X_15024__2586 _15024_/RESET_B VDD VSS sg13g2_tiehi
Xfanout831 _12699_/S1 _12701_/S1 VDD VSS sg13g2_buf_1
XFILLER_137_1299 VDD VSS sg13g2_decap_4
XFILLER_172_1179 VDD VSS sg13g2_decap_8
Xfanout842 _12506_/S1 fanout846/X VDD VSS sg13g2_buf_1
X_09938_ _09938_/Y _09938_/A _09938_/B _09938_/C _09938_/D VDD VSS sg13g2_nor4_1
XFILLER_24_1403 VDD VSS sg13g2_decap_8
XFILLER_131_285 VDD VSS sg13g2_decap_8
Xfanout853 _12711_/S1 _12716_/S1 VDD VSS sg13g2_buf_1
XFILLER_63_1463 VDD VSS sg13g2_decap_8
XFILLER_58_520 VDD VSS sg13g2_decap_8
Xfanout864 _12787_/S1 _12786_/S1 VDD VSS sg13g2_buf_1
XFILLER_86_840 VDD VSS sg13g2_decap_8
XFILLER_133_21 VDD VSS sg13g2_decap_8
XFILLER_150_1433 VDD VSS sg13g2_decap_8
Xfanout875 _12605_/S0 fanout876/X VDD VSS sg13g2_buf_1
Xfanout886 _12480_/S0 fanout889/X VDD VSS sg13g2_buf_1
Xfanout897 _12661_/S0 _12674_/S0 VDD VSS sg13g2_buf_1
X_09869_ _14456_/D _14456_/Q _10100_/A0 _09871_/S VDD VSS sg13g2_mux2_1
XFILLER_85_350 VDD VSS sg13g2_decap_4
XFILLER_19_929 VDD VSS sg13g2_decap_8
XFILLER_73_501 VDD VSS sg13g2_fill_2
XFILLER_93_14 VDD VSS sg13g2_decap_8
X_11900_ _11900_/Y _11900_/A _11900_/B VDD VSS sg13g2_nand2_1
XFILLER_46_737 VDD VSS sg13g2_decap_8
X_14262__1940 _14262_/RESET_B VDD VSS sg13g2_tiehi
XFILLER_100_694 VDD VSS sg13g2_decap_8
X_12880_ _12880_/Y _14804_/Q _12851_/B _12895_/B _14868_/Q _12930_/C1 VDD VSS sg13g2_a221oi_1
XFILLER_6_1390 VDD VSS sg13g2_decap_8
XFILLER_22_1160 VDD VSS sg13g2_decap_8
XFILLER_2_1232 VDD VSS sg13g2_decap_8
XFILLER_45_247 VDD VSS sg13g2_decap_8
X_11831_ _11832_/B _11820_/Y _11822_/X _11834_/A2 VDD VSS sg13g2_o21ai_1
XFILLER_57_1212 VDD VSS sg13g2_decap_8
XFILLER_26_63 VDD VSS sg13g2_decap_8
X_15246__3037 _15246_/RESET_B VDD VSS sg13g2_tiehi
XFILLER_42_921 VDD VSS sg13g2_fill_1
XFILLER_26_472 VDD VSS sg13g2_decap_4
X_14550_ _14550_/Q clkload75/A _14550_/D _14550_/RESET_B VDD VSS sg13g2_dfrbpq_1
X_11762_ _11763_/A _14698_/Q _14730_/Q _13770_/Q _13802_/Q _11759_/A _11742_/C VDD
+ VSS sg13g2_mux4_1
XFILLER_183_1253 VDD VSS sg13g2_decap_8
XFILLER_144_1215 VDD VSS sg13g2_decap_8
XFILLER_148_1384 VDD VSS sg13g2_decap_8
X_13501_ _13501_/Y _13648_/S _15129_/Q VDD VSS sg13g2_nand2_1
XFILLER_13_144 VDD VSS sg13g2_decap_8
X_10713_ _10936_/B _10954_/B VDD VSS sg13g2_inv_1
XFILLER_92_1169 VDD VSS sg13g2_decap_8
XFILLER_57_1289 VDD VSS sg13g2_decap_8
XFILLER_41_453 VDD VSS sg13g2_decap_8
XFILLER_144_1248 VDD VSS sg13g2_decap_4
X_14481_ _14481_/Q clkload29/A _14481_/D _14481_/RESET_B VDD VSS sg13g2_dfrbpq_1
XFILLER_109_1368 VDD VSS sg13g2_fill_1
X_11693_ _11694_/B _11693_/A _11693_/B _11693_/C VDD VSS sg13g2_nand3_1
XFILLER_9_126 VDD VSS sg13g2_decap_8
X_13432_ _15098_/D _15098_/Q _13353_/Y _13431_/Y VDD VSS sg13g2_a21o_1
XFILLER_70_1434 VDD VSS sg13g2_decap_8
XFILLER_186_469 VDD VSS sg13g2_decap_8
X_10644_ _10644_/Y _14889_/Q _10643_/C _10423_/C VDD VSS sg13g2_o21ai_1
XFILLER_139_341 VDD VSS sg13g2_decap_8
XFILLER_10_840 VDD VSS sg13g2_decap_8
XFILLER_167_661 VDD VSS sg13g2_decap_8
XFILLER_155_812 VDD VSS sg13g2_decap_8
XFILLER_127_514 VDD VSS sg13g2_decap_8
XFILLER_173_119 VDD VSS sg13g2_decap_8
XFILLER_70_1478 VDD VSS sg13g2_fill_1
X_13363_ _13363_/Y _13437_/A _13407_/B _15074_/Q VDD VSS sg13g2_nand3_1
X_10575_ _10586_/D _14870_/Q _12895_/A _10575_/C _10653_/A VDD VSS sg13g2_and4_1
XFILLER_182_620 VDD VSS sg13g2_decap_8
XFILLER_158_84 VDD VSS sg13g2_fill_1
XFILLER_166_182 VDD VSS sg13g2_decap_8
X_15102_ _15102_/Q clkload70/A _15102_/D _15102_/RESET_B VDD VSS sg13g2_dfrbpq_1
XFILLER_6_844 VDD VSS sg13g2_decap_8
XFILLER_154_344 VDD VSS sg13g2_decap_8
X_12314_ _12314_/Y _12306_/A _14682_/Q _12184_/B VDD VSS sg13g2_a21oi_1
XFILLER_115_709 VDD VSS sg13g2_decap_8
XFILLER_155_889 VDD VSS sg13g2_fill_1
X_13294_ _13294_/Y _15204_/Q _13294_/B _13294_/C VDD VSS sg13g2_nand3b_1
XFILLER_5_343 VDD VSS sg13g2_decap_8
X_13750__2452 _13750_/RESET_B VDD VSS sg13g2_tiehi
XFILLER_114_219 VDD VSS sg13g2_decap_8
XFILLER_177_1068 VDD VSS sg13g2_decap_8
XFILLER_182_697 VDD VSS sg13g2_decap_8
X_15033_ _15033_/Q clkload55/A _15033_/D _15033_/RESET_B VDD VSS sg13g2_dfrbpq_1
XFILLER_142_539 VDD VSS sg13g2_decap_8
X_12245_ _12246_/A _13752_/Q _14104_/Q _14456_/Q _14552_/Q _12259_/S0 _12236_/C VDD
+ VSS sg13g2_mux4_1
XFILLER_29_1303 VDD VSS sg13g2_decap_8
XFILLER_68_1363 VDD VSS sg13g2_decap_8
XFILLER_181_196 VDD VSS sg13g2_decap_8
XFILLER_155_1333 VDD VSS sg13g2_decap_8
XFILLER_123_753 VDD VSS sg13g2_decap_8
X_14701__1501 _14701_/RESET_B VDD VSS sg13g2_tiehi
X_12176_ _12176_/Y _11277_/S _14422_/Q _12169_/C VDD VSS sg13g2_a21oi_1
XFILLER_111_915 VDD VSS sg13g2_decap_8
XFILLER_69_829 VDD VSS sg13g2_decap_4
XFILLER_116_1328 VDD VSS sg13g2_fill_2
XFILLER_1_560 VDD VSS sg13g2_decap_8
X_14094__2108 _14094_/RESET_B VDD VSS sg13g2_tiehi
X_11127_ _11127_/Y _11127_/A _11127_/B _11146_/A VDD VSS sg13g2_nand3_1
XFILLER_111_959 VDD VSS sg13g2_decap_8
XFILLER_122_285 VDD VSS sg13g2_decap_8
XFILLER_3_67 VDD VSS sg13g2_decap_8
XFILLER_110_458 VDD VSS sg13g2_decap_8
X_14130__2072 _14130_/RESET_B VDD VSS sg13g2_tiehi
X_11058_ _11058_/Y _11185_/A _11078_/B VDD VSS sg13g2_nor2_1
XFILLER_7_1176 VDD VSS sg13g2_decap_8
XFILLER_97_1003 VDD VSS sg13g2_decap_8
X_10009_ _14591_/D _10142_/A1 _14591_/Q _10030_/S VDD VSS sg13g2_mux2_1
XFILLER_92_821 VDD VSS sg13g2_decap_8
XFILLER_36_214 VDD VSS sg13g2_decap_8
XFILLER_37_759 VDD VSS sg13g2_decap_8
X_14734__1468 _14734_/RESET_B VDD VSS sg13g2_tiehi
XFILLER_18_951 VDD VSS sg13g2_decap_8
XFILLER_184_1017 VDD VSS sg13g2_decap_8
X_14817_ _14817_/Q clkload88/A _14817_/D _14817_/RESET_B VDD VSS sg13g2_dfrbpq_1
XFILLER_92_898 VDD VSS sg13g2_decap_8
XFILLER_91_364 VDD VSS sg13g2_decap_8
XFILLER_51_206 VDD VSS sg13g2_decap_8
XFILLER_166_1451 VDD VSS sg13g2_decap_8
X_14748_ _14748_/Q clkload86/A _14748_/D _14748_/RESET_B VDD VSS sg13g2_dfrbpq_1
XFILLER_162_1304 VDD VSS sg13g2_decap_8
XFILLER_17_494 VDD VSS sg13g2_decap_8
XFILLER_75_1356 VDD VSS sg13g2_decap_8
XFILLER_177_403 VDD VSS sg13g2_decap_8
XFILLER_178_948 VDD VSS sg13g2_decap_8
X_14679_ _14679_/Q clkload41/A _14679_/D _14679_/RESET_B VDD VSS sg13g2_dfrbpq_1
XFILLER_34_1020 VDD VSS sg13g2_decap_8
XFILLER_177_469 VDD VSS sg13g2_decap_8
X_13675__2545 _13675_/RESET_B VDD VSS sg13g2_tiehi
XFILLER_164_119 VDD VSS sg13g2_decap_4
XFILLER_121_1034 VDD VSS sg13g2_decap_4
XFILLER_173_620 VDD VSS sg13g2_fill_2
XFILLER_118_536 VDD VSS sg13g2_decap_8
XFILLER_9_693 VDD VSS sg13g2_decap_8
XFILLER_66_0 VDD VSS sg13g2_decap_8
XFILLER_106_709 VDD VSS sg13g2_fill_1
XFILLER_172_130 VDD VSS sg13g2_decap_8
XFILLER_12_1362 VDD VSS sg13g2_decap_8
X_14926__2715 _14926_/RESET_B VDD VSS sg13g2_tiehi
X_14340__1862 _14340_/RESET_B VDD VSS sg13g2_tiehi
XFILLER_173_1400 VDD VSS sg13g2_decap_8
XFILLER_47_1403 VDD VSS sg13g2_decap_8
XFILLER_160_347 VDD VSS sg13g2_decap_8
XFILLER_160_358 VDD VSS sg13g2_fill_1
XFILLER_82_1316 VDD VSS sg13g2_decap_8
XFILLER_101_403 VDD VSS sg13g2_decap_8
XFILLER_173_1477 VDD VSS sg13g2_fill_2
XFILLER_99_486 VDD VSS sg13g2_decap_8
XFILLER_134_1439 VDD VSS sg13g2_fill_2
XFILLER_99_497 VDD VSS sg13g2_fill_1
Xfanout149 _10101_/A0 _09936_/A1 VDD VSS sg13g2_buf_1
X_07984_ _07985_/D _07908_/A _15073_/Q _15215_/Q _07977_/Y VDD VSS sg13g2_a22oi_1
XFILLER_68_840 VDD VSS sg13g2_decap_8
XFILLER_47_18 VDD VSS sg13g2_fill_1
XFILLER_80_1051 VDD VSS sg13g2_fill_2
X_09723_ _14314_/D _09723_/A0 _14314_/Q _09729_/S VDD VSS sg13g2_mux2_1
XFILLER_80_1062 VDD VSS sg13g2_fill_1
XFILLER_47_29 VDD VSS sg13g2_fill_1
XFILLER_45_1193 VDD VSS sg13g2_decap_8
XFILLER_132_1152 VDD VSS sg13g2_decap_8
XFILLER_68_873 VDD VSS sg13g2_decap_8
XFILLER_41_1046 VDD VSS sg13g2_decap_4
XFILLER_27_214 VDD VSS sg13g2_decap_8
X_09654_ _14247_/D _09654_/A0 _14247_/Q _09663_/S VDD VSS sg13g2_mux2_1
XFILLER_27_236 VDD VSS sg13g2_decap_8
XFILLER_55_556 VDD VSS sg13g2_decap_8
X_15009__2601 _15009_/RESET_B VDD VSS sg13g2_tiehi
X_08605_ _08605_/X _08605_/A _08605_/B VDD VSS sg13g2_and2_1
XFILLER_82_353 VDD VSS sg13g2_decap_8
XFILLER_167_1248 VDD VSS sg13g2_decap_8
X_09585_ _14182_/D _14182_/Q _09917_/A1 _09589_/S VDD VSS sg13g2_mux2_1
XFILLER_55_578 VDD VSS sg13g2_decap_8
XFILLER_93_1412 VDD VSS sg13g2_decap_8
X_08536_ _08545_/A _13533_/A _08214_/X _08652_/B1 VDD VSS sg13g2_o21ai_1
XFILLER_36_792 VDD VSS sg13g2_decap_8
XFILLER_24_932 VDD VSS sg13g2_decap_8
XFILLER_179_39 VDD VSS sg13g2_decap_8
X_14818__2918 _14818_/RESET_B VDD VSS sg13g2_tiehi
XFILLER_24_976 VDD VSS sg13g2_decap_8
XFILLER_23_464 VDD VSS sg13g2_decap_8
X_08467_ _08469_/A _08484_/B _08617_/B VDD VSS sg13g2_nor2_1
XFILLER_168_436 VDD VSS sg13g2_decap_8
XFILLER_180_1448 VDD VSS sg13g2_decap_8
XFILLER_50_272 VDD VSS sg13g2_decap_8
XFILLER_11_648 VDD VSS sg13g2_decap_8
X_08398_ _08398_/Y _08483_/A1 _08201_/B _08242_/A VDD VSS sg13g2_o21ai_1
XFILLER_17_1273 VDD VSS sg13g2_decap_8
XFILLER_183_417 VDD VSS sg13g2_decap_8
XFILLER_10_147 VDD VSS sg13g2_decap_8
XFILLER_12_21 VDD VSS sg13g2_decap_8
Xclkbuf_5_6__f_clk_i clkbuf_5_6__f_clk_i/X clkbuf_4_3_0_clk_i/X VDD VSS sg13g2_buf_16
XFILLER_143_1292 VDD VSS sg13g2_decap_8
XFILLER_148_171 VDD VSS sg13g2_decap_8
XFILLER_137_845 VDD VSS sg13g2_decap_8
XFILLER_52_1186 VDD VSS sg13g2_decap_8
XFILLER_13_1159 VDD VSS sg13g2_decap_8
X_10360_ _14811_/D _10364_/C _10490_/A _10360_/C VDD VSS sg13g2_nor3_1
XFILLER_30_1440 VDD VSS sg13g2_decap_8
XFILLER_87_1227 VDD VSS sg13g2_decap_8
XFILLER_137_889 VDD VSS sg13g2_fill_1
XFILLER_178_1355 VDD VSS sg13g2_decap_8
XFILLER_12_98 VDD VSS sg13g2_decap_8
XFILLER_163_163 VDD VSS sg13g2_decap_4
XFILLER_88_14 VDD VSS sg13g2_decap_8
X_09019_ _09019_/Y _09019_/A _09019_/B VDD VSS sg13g2_nand2_1
X_10291_ _10292_/C _14791_/Q _10294_/C VDD VSS sg13g2_and2_1
XFILLER_152_859 VDD VSS sg13g2_decap_8
XFILLER_117_591 VDD VSS sg13g2_fill_1
X_12030_ _12030_/Y _12235_/A _14386_/Q VDD VSS sg13g2_nand2b_1
XFILLER_3_858 VDD VSS sg13g2_decap_8
XFILLER_105_753 VDD VSS sg13g2_decap_8
XFILLER_137_1041 VDD VSS sg13g2_decap_8
XFILLER_2_357 VDD VSS sg13g2_decap_8
XFILLER_104_241 VDD VSS sg13g2_decap_4
XFILLER_160_881 VDD VSS sg13g2_decap_4
XFILLER_78_637 VDD VSS sg13g2_decap_8
XFILLER_137_1085 VDD VSS sg13g2_decap_8
XFILLER_77_114 VDD VSS sg13g2_decap_8
XFILLER_24_1200 VDD VSS sg13g2_decap_8
XFILLER_63_1260 VDD VSS sg13g2_decap_8
XFILLER_120_756 VDD VSS sg13g2_decap_8
Xfanout650 _08001_/C _08654_/B VDD VSS sg13g2_buf_1
XFILLER_120_767 VDD VSS sg13g2_fill_2
Xfanout661 _12624_/C1 _12777_/C1 VDD VSS sg13g2_buf_1
Xfanout672 _12930_/C1 _13069_/C1 VDD VSS sg13g2_buf_1
XFILLER_8_1474 VDD VSS sg13g2_fill_1
XFILLER_115_1361 VDD VSS sg13g2_fill_2
X_13981_ _13981_/Q clkload29/A _13981_/D _13981_/RESET_B VDD VSS sg13g2_dfrbpq_1
Xfanout683 _13279_/D _07703_/Y VDD VSS sg13g2_buf_1
XFILLER_4_1316 VDD VSS sg13g2_decap_8
Xfanout694 _11860_/B1 _07684_/B VDD VSS sg13g2_buf_1
XFILLER_74_810 VDD VSS sg13g2_decap_8
XFILLER_111_1214 VDD VSS sg13g2_decap_8
X_14203__1999 _14203_/RESET_B VDD VSS sg13g2_tiehi
XFILLER_92_117 VDD VSS sg13g2_decap_4
XFILLER_150_1274 VDD VSS sg13g2_decap_4
X_12932_ _12932_/Y _12929_/Y _12930_/Y _12931_/Y VDD VSS sg13g2_a21oi_1
XFILLER_24_1277 VDD VSS sg13g2_decap_8
XFILLER_19_759 VDD VSS sg13g2_decap_8
XFILLER_98_1367 VDD VSS sg13g2_fill_2
XFILLER_74_876 VDD VSS sg13g2_decap_8
X_12863_ _12863_/Y _14803_/Q _12851_/B _12879_/B _14835_/Q _12930_/C1 VDD VSS sg13g2_a221oi_1
XFILLER_98_1389 VDD VSS sg13g2_decap_8
XFILLER_46_578 VDD VSS sg13g2_fill_2
XFILLER_160_74 VDD VSS sg13g2_decap_8
XFILLER_185_1348 VDD VSS sg13g2_decap_8
X_14602_ _14602_/Q _14602_/CLK _14602_/D _14602_/RESET_B VDD VSS sg13g2_dfrbpq_1
X_11814_ _11815_/A _13740_/Q _14092_/Q _14444_/Q _14540_/Q _11814_/S0 _11805_/C VDD
+ VSS sg13g2_mux4_1
X_12794_ _12794_/X _12997_/B _12936_/B VDD VSS sg13g2_or2_1
X_13768__2434 _13768_/RESET_B VDD VSS sg13g2_tiehi
X_14533_ _14533_/Q _14725_/CLK _14533_/D _14533_/RESET_B VDD VSS sg13g2_dfrbpq_1
XFILLER_42_762 VDD VSS sg13g2_decap_8
XFILLER_109_1143 VDD VSS sg13g2_decap_8
XFILLER_144_1023 VDD VSS sg13g2_decap_8
X_11745_ _11745_/Y _11745_/A _11875_/B VDD VSS sg13g2_nand2_1
XFILLER_15_998 VDD VSS sg13g2_decap_8
X_15078__2860 _15078_/RESET_B VDD VSS sg13g2_tiehi
XFILLER_144_1056 VDD VSS sg13g2_decap_4
X_14464_ _14464_/Q clkload25/A _14464_/D _14464_/RESET_B VDD VSS sg13g2_dfrbpq_1
XFILLER_70_1231 VDD VSS sg13g2_decap_8
X_11676_ _11676_/Y _11678_/S0 _14664_/Q _11967_/B VDD VSS sg13g2_a21oi_1
XFILLER_30_968 VDD VSS sg13g2_decap_8
XFILLER_186_266 VDD VSS sg13g2_decap_8
XFILLER_35_1373 VDD VSS sg13g2_decap_8
XFILLER_122_1332 VDD VSS sg13g2_fill_2
X_13415_ _15092_/D _15129_/Q _13414_/Y _13409_/Y VDD VSS sg13g2_a21o_1
X_10627_ _10630_/A _14883_/Q _10632_/D _14884_/Q VDD VSS sg13g2_a21o_1
X_14395_ _14395_/Q _14491_/CLK _14395_/D _14395_/RESET_B VDD VSS sg13g2_dfrbpq_1
XFILLER_31_1237 VDD VSS sg13g2_decap_8
XFILLER_122_1354 VDD VSS sg13g2_decap_8
X_14148__2054 _14148_/RESET_B VDD VSS sg13g2_tiehi
XFILLER_139_193 VDD VSS sg13g2_decap_8
XFILLER_183_951 VDD VSS sg13g2_decap_8
X_13346_ _13347_/A _13652_/S _15173_/D VDD VSS sg13g2_nor2_1
XFILLER_6_641 VDD VSS sg13g2_decap_8
X_10558_ _10561_/B _14859_/Q _13218_/A _10564_/D _14856_/Q VDD VSS sg13g2_nand4_1
XFILLER_157_1406 VDD VSS sg13g2_decap_8
XFILLER_5_140 VDD VSS sg13g2_decap_8
XFILLER_155_686 VDD VSS sg13g2_fill_2
XFILLER_154_174 VDD VSS sg13g2_fill_2
XFILLER_170_623 VDD VSS sg13g2_decap_8
XFILLER_182_483 VDD VSS sg13g2_decap_8
XFILLER_115_539 VDD VSS sg13g2_decap_4
XFILLER_143_848 VDD VSS sg13g2_decap_8
XFILLER_170_634 VDD VSS sg13g2_fill_2
X_13277_ _13277_/Y _13048_/X _13272_/X _13276_/Y VDD VSS sg13g2_a21oi_1
XFILLER_108_591 VDD VSS sg13g2_decap_8
XFILLER_154_196 VDD VSS sg13g2_decap_8
X_10489_ _10498_/D _14850_/Q _14849_/Q _14848_/Q _10489_/D VDD VSS sg13g2_and4_1
XFILLER_68_1160 VDD VSS sg13g2_decap_8
X_15016_ _15016_/Q clkload48/A _15016_/D _15016_/RESET_B VDD VSS sg13g2_dfrbpq_1
X_12228_ _12274_/B _12229_/A _13664_/Q VDD VSS sg13g2_nor2_1
XFILLER_9_1227 VDD VSS sg13g2_decap_8
XFILLER_68_103 VDD VSS sg13g2_decap_8
XFILLER_38_4 VDD VSS sg13g2_decap_8
XFILLER_29_1177 VDD VSS sg13g2_decap_8
XFILLER_123_594 VDD VSS sg13g2_decap_8
X_12159_ _12159_/Y _12168_/A _14198_/Q VDD VSS sg13g2_nand2b_1
XFILLER_69_648 VDD VSS sg13g2_decap_8
XFILLER_68_147 VDD VSS sg13g2_decap_8
XFILLER_49_350 VDD VSS sg13g2_decap_8
XFILLER_65_810 VDD VSS sg13g2_decap_8
XFILLER_42_1366 VDD VSS sg13g2_decap_8
XFILLER_49_383 VDD VSS sg13g2_decap_8
XFILLER_92_640 VDD VSS sg13g2_decap_8
XFILLER_77_1418 VDD VSS sg13g2_decap_8
XFILLER_65_898 VDD VSS sg13g2_decap_8
XFILLER_64_364 VDD VSS sg13g2_decap_8
XFILLER_52_515 VDD VSS sg13g2_decap_8
XFILLER_24_217 VDD VSS sg13g2_decap_8
X_09370_ _13974_/D _10098_/A0 _13974_/Q _09374_/S VDD VSS sg13g2_mux2_1
X_14358__1844 _14358_/RESET_B VDD VSS sg13g2_tiehi
XFILLER_75_1153 VDD VSS sg13g2_decap_8
X_08321_ _08321_/Y _08369_/B _08350_/B VDD VSS sg13g2_nand2_1
XFILLER_33_762 VDD VSS sg13g2_decap_4
XFILLER_178_734 VDD VSS sg13g2_decap_8
XFILLER_177_233 VDD VSS sg13g2_fill_1
XFILLER_166_907 VDD VSS sg13g2_decap_8
X_08252_ _08252_/Y _08244_/B _08057_/Y _08241_/Y VDD VSS sg13g2_o21ai_1
XFILLER_36_1159 VDD VSS sg13g2_decap_8
XFILLER_123_1118 VDD VSS sg13g2_decap_8
XFILLER_53_1440 VDD VSS sg13g2_decap_8
XFILLER_162_1178 VDD VSS sg13g2_decap_8
XFILLER_159_992 VDD VSS sg13g2_fill_2
X_08183_ _08183_/Y _08190_/A _08183_/B _08183_/C VDD VSS sg13g2_nor3_1
XFILLER_14_1457 VDD VSS sg13g2_decap_8
XFILLER_118_333 VDD VSS sg13g2_fill_2
XFILLER_119_867 VDD VSS sg13g2_fill_2
X_15133__2714 _15133_/RESET_B VDD VSS sg13g2_tiehi
XFILLER_9_490 VDD VSS sg13g2_decap_8
XFILLER_145_174 VDD VSS sg13g2_fill_2
XFILLER_133_325 VDD VSS sg13g2_decap_8
XFILLER_47_1200 VDD VSS sg13g2_decap_8
XFILLER_86_1260 VDD VSS sg13g2_decap_4
XFILLER_160_144 VDD VSS sg13g2_decap_8
X_15245__3036 _15245_/RESET_B VDD VSS sg13g2_tiehi
XFILLER_88_902 VDD VSS sg13g2_decap_8
XFILLER_0_806 VDD VSS sg13g2_decap_8
XFILLER_102_723 VDD VSS sg13g2_decap_8
XFILLER_88_946 VDD VSS sg13g2_decap_8
XFILLER_102_734 VDD VSS sg13g2_fill_2
XFILLER_173_1274 VDD VSS sg13g2_decap_8
XFILLER_47_1277 VDD VSS sg13g2_decap_8
X_13846__2356 _13846_/RESET_B VDD VSS sg13g2_tiehi
X_07967_ _07967_/Y _07964_/Y _07856_/Y _07965_/Y VDD VSS sg13g2_o21ai_1
XFILLER_75_629 VDD VSS sg13g2_decap_8
XFILLER_68_681 VDD VSS sg13g2_decap_8
XFILLER_60_1455 VDD VSS sg13g2_decap_8
XFILLER_56_821 VDD VSS sg13g2_decap_8
X_09706_ _14298_/D _10169_/A1 _14298_/Q _09706_/S VDD VSS sg13g2_mux2_1
XFILLER_21_1428 VDD VSS sg13g2_decap_8
XFILLER_114_78 VDD VSS sg13g2_fill_1
X_07898_ _07905_/B _08183_/B _08188_/A _07879_/Y VDD VSS sg13g2_o21ai_1
XFILLER_55_331 VDD VSS sg13g2_decap_8
XFILLER_28_556 VDD VSS sg13g2_fill_1
X_09637_ _14233_/D _09969_/A1 _14233_/Q _09637_/S VDD VSS sg13g2_mux2_1
XFILLER_56_887 VDD VSS sg13g2_decap_8
XFILLER_15_217 VDD VSS sg13g2_decap_8
XFILLER_83_695 VDD VSS sg13g2_decap_8
XFILLER_71_835 VDD VSS sg13g2_fill_2
XFILLER_15_228 VDD VSS sg13g2_fill_1
XFILLER_167_1067 VDD VSS sg13g2_decap_8
X_09568_ _14166_/D _09966_/A1 _14166_/Q _09572_/S VDD VSS sg13g2_mux2_1
XFILLER_169_701 VDD VSS sg13g2_decap_8
XFILLER_19_1324 VDD VSS sg13g2_decap_8
XFILLER_145_1332 VDD VSS sg13g2_decap_8
X_08519_ _08597_/C _08922_/A1 _08919_/A1 _08915_/A1 _08470_/B _08686_/S0 _08669_/B1
+ VDD VSS sg13g2_mux4_1
XFILLER_130_88 VDD VSS sg13g2_decap_8
XFILLER_93_1275 VDD VSS sg13g2_decap_8
X_09499_ _14099_/D _10162_/A1 _14099_/Q _09505_/S VDD VSS sg13g2_mux2_1
XFILLER_169_756 VDD VSS sg13g2_decap_8
XFILLER_12_946 VDD VSS sg13g2_decap_8
XFILLER_180_1245 VDD VSS sg13g2_decap_8
XFILLER_54_1248 VDD VSS sg13g2_decap_8
X_11530_ _11532_/A _11531_/A _14180_/Q VDD VSS sg13g2_nand2b_1
XFILLER_168_255 VDD VSS sg13g2_decap_4
XFILLER_11_445 VDD VSS sg13g2_decap_8
XFILLER_145_1398 VDD VSS sg13g2_fill_2
XFILLER_8_928 VDD VSS sg13g2_decap_8
XFILLER_17_1070 VDD VSS sg13g2_decap_8
XFILLER_183_214 VDD VSS sg13g2_decap_8
X_11461_ _11463_/B _11461_/A _13687_/Q VDD VSS sg13g2_xnor2_1
XFILLER_7_427 VDD VSS sg13g2_decap_8
X_13200_ _13224_/A _14920_/Q _13667_/Q VDD VSS sg13g2_xnor2_1
X_10412_ _10415_/C _10413_/B _10414_/D _14827_/Q VDD VSS sg13g2_a21oi_1
XFILLER_137_664 VDD VSS sg13g2_decap_8
X_14180_ _14180_/Q _14510_/CLK _14180_/D _14180_/RESET_B VDD VSS sg13g2_dfrbpq_1
X_11392_ _11392_/Y _11403_/S0 _13919_/Q _11391_/Y VDD VSS sg13g2_a21oi_1
XFILLER_178_1152 VDD VSS sg13g2_decap_8
XFILLER_125_837 VDD VSS sg13g2_decap_8
XFILLER_136_163 VDD VSS sg13g2_decap_8
XFILLER_180_921 VDD VSS sg13g2_decap_8
XFILLER_87_1046 VDD VSS sg13g2_decap_8
XFILLER_109_388 VDD VSS sg13g2_decap_8
XFILLER_180_932 VDD VSS sg13g2_fill_1
X_13131_ _13131_/Y _14914_/Q _13673_/Q _13132_/A VDD VSS sg13g2_a21oi_1
XFILLER_99_79 VDD VSS sg13g2_decap_8
XFILLER_174_1005 VDD VSS sg13g2_decap_8
XFILLER_180_943 VDD VSS sg13g2_fill_2
X_10343_ _14807_/D _10343_/A _10343_/B _10343_/C VDD VSS sg13g2_and3_1
XFILLER_136_196 VDD VSS sg13g2_decap_8
X_15099__2798 _15099_/RESET_B VDD VSS sg13g2_tiehi
XFILLER_3_655 VDD VSS sg13g2_decap_8
XFILLER_112_509 VDD VSS sg13g2_decap_8
X_13062_ _13066_/A _13063_/B VDD VSS sg13g2_inv_1
X_10274_ _10274_/Y _14786_/Q _10305_/A _10365_/C VDD VSS sg13g2_o21ai_1
XFILLER_105_550 VDD VSS sg13g2_fill_2
XFILLER_65_1333 VDD VSS sg13g2_decap_8
XFILLER_79_924 VDD VSS sg13g2_fill_1
XFILLER_2_154 VDD VSS sg13g2_decap_8
XFILLER_117_1423 VDD VSS sg13g2_decap_8
XFILLER_155_85 VDD VSS sg13g2_decap_4
X_12013_ _12013_/Y _11988_/Y _12012_/X _11458_/A VDD VSS sg13g2_a21oi_1
Xfanout1401 _13087_/A fanout1413/X VDD VSS sg13g2_buf_1
Xfanout1412 _10599_/A fanout1413/X VDD VSS sg13g2_buf_1
Xfanout1423 _10441_/C _10444_/C VDD VSS sg13g2_buf_1
X_14436__1766 _14436_/RESET_B VDD VSS sg13g2_tiehi
Xfanout1434 _10626_/B _10630_/C VDD VSS sg13g2_buf_1
XFILLER_93_404 VDD VSS sg13g2_decap_8
XFILLER_19_501 VDD VSS sg13g2_decap_4
XFILLER_94_938 VDD VSS sg13g2_decap_8
XFILLER_8_1271 VDD VSS sg13g2_decap_8
XFILLER_48_72 VDD VSS sg13g2_decap_8
Xfanout480 fanout480/X _09375_/Y VDD VSS sg13g2_buf_1
XFILLER_4_1113 VDD VSS sg13g2_decap_8
X_14910__2747 _14910_/RESET_B VDD VSS sg13g2_tiehi
Xfanout491 _09239_/S _09227_/S VDD VSS sg13g2_buf_1
XFILLER_47_821 VDD VSS sg13g2_decap_4
XFILLER_111_1011 VDD VSS sg13g2_decap_4
XFILLER_115_1180 VDD VSS sg13g2_fill_1
XFILLER_59_692 VDD VSS sg13g2_decap_8
X_13964_ _13964_/Q clkload50/A _13964_/D _13964_/RESET_B VDD VSS sg13g2_dfrbpq_1
XFILLER_171_84 VDD VSS sg13g2_decap_8
XFILLER_98_1131 VDD VSS sg13g2_decap_4
XFILLER_0_35 VDD VSS sg13g2_decap_8
X_12915_ _12933_/A input33/X _12841_/B _12914_/Y VDD VSS sg13g2_a21o_1
XFILLER_19_578 VDD VSS sg13g2_fill_1
XFILLER_94_1006 VDD VSS sg13g2_decap_4
X_13895_ _13895_/Q clkload5/A _13895_/D _13895_/RESET_B VDD VSS sg13g2_dfrbpq_1
XFILLER_34_515 VDD VSS sg13g2_decap_4
XFILLER_73_161 VDD VSS sg13g2_decap_8
XFILLER_185_1145 VDD VSS sg13g2_decap_8
XFILLER_74_695 VDD VSS sg13g2_decap_8
X_14651__1551 _14651_/RESET_B VDD VSS sg13g2_tiehi
XFILLER_62_846 VDD VSS sg13g2_decap_8
XFILLER_46_397 VDD VSS sg13g2_decap_8
X_12846_ _12846_/Y _12821_/Y _12834_/Y _12833_/Y VDD VSS sg13g2_o21ai_1
XFILLER_37_1413 VDD VSS sg13g2_decap_8
XFILLER_61_367 VDD VSS sg13g2_fill_2
XFILLER_163_1443 VDD VSS sg13g2_decap_8
X_12777_ _12778_/B _13663_/Q _12777_/A2 _12776_/X _12777_/B2 _12777_/C1 VDD VSS sg13g2_a221oi_1
X_14516_ _14516_/Q _14528_/CLK _14516_/D _14516_/RESET_B VDD VSS sg13g2_dfrbpq_1
X_11728_ _11728_/Y _11773_/D _11728_/B VDD VSS sg13g2_xnor2_1
XFILLER_124_1438 VDD VSS sg13g2_decap_8
XFILLER_148_929 VDD VSS sg13g2_decap_8
XFILLER_9_77 VDD VSS sg13g2_decap_8
XFILLER_80_70 VDD VSS sg13g2_fill_2
XFILLER_35_1170 VDD VSS sg13g2_decap_8
X_14447_ _14447_/Q _15162_/CLK _14447_/D _14447_/RESET_B VDD VSS sg13g2_dfrbpq_1
XFILLER_175_759 VDD VSS sg13g2_decap_4
X_13924__2278 _13924_/RESET_B VDD VSS sg13g2_tiehi
X_11659_ _11702_/A _11659_/A _11934_/B VDD VSS sg13g2_nor2_1
XFILLER_70_1094 VDD VSS sg13g2_decap_8
XFILLER_116_804 VDD VSS sg13g2_decap_8
XFILLER_122_1173 VDD VSS sg13g2_decap_8
XFILLER_155_450 VDD VSS sg13g2_decap_8
X_14378_ _14378_/Q clkload20/A _14378_/D _14378_/RESET_B VDD VSS sg13g2_dfrbpq_1
XFILLER_155_461 VDD VSS sg13g2_fill_2
XFILLER_183_770 VDD VSS sg13g2_decap_8
XFILLER_7_994 VDD VSS sg13g2_decap_8
X_13329_ _13329_/Y _15173_/Q _13340_/S VDD VSS sg13g2_nand2b_1
XFILLER_157_1225 VDD VSS sg13g2_fill_2
XFILLER_182_291 VDD VSS sg13g2_decap_8
XFILLER_170_442 VDD VSS sg13g2_decap_4
XFILLER_100_1471 VDD VSS sg13g2_decap_4
XFILLER_118_1209 VDD VSS sg13g2_decap_8
XFILLER_143_678 VDD VSS sg13g2_fill_2
XFILLER_130_317 VDD VSS sg13g2_decap_4
XFILLER_170_1403 VDD VSS sg13g2_decap_8
XFILLER_124_892 VDD VSS sg13g2_decap_4
XFILLER_83_1466 VDD VSS sg13g2_decap_8
XFILLER_44_1417 VDD VSS sg13g2_decap_8
XFILLER_142_199 VDD VSS sg13g2_decap_8
X_08870_ _08870_/X _15031_/Q _08873_/A _08869_/Y VDD VSS sg13g2_a21o_1
XFILLER_83_1477 VDD VSS sg13g2_fill_2
XFILLER_9_1057 VDD VSS sg13g2_decap_8
XFILLER_111_553 VDD VSS sg13g2_decap_8
X_07821_ _07822_/B _15009_/Q _11914_/A VDD VSS sg13g2_and2_1
XFILLER_85_916 VDD VSS sg13g2_fill_2
XFILLER_29_0 VDD VSS sg13g2_decap_8
XFILLER_97_787 VDD VSS sg13g2_decap_8
XFILLER_69_489 VDD VSS sg13g2_decap_8
XFILLER_96_275 VDD VSS sg13g2_fill_2
XFILLER_78_990 VDD VSS sg13g2_decap_8
X_07752_ _07752_/Y _07753_/D _10647_/D _13300_/B _13596_/B VDD VSS sg13g2_nand4_1
XFILLER_42_1163 VDD VSS sg13g2_decap_8
XFILLER_168_1321 VDD VSS sg13g2_decap_8
XFILLER_93_982 VDD VSS sg13g2_decap_8
XFILLER_77_1215 VDD VSS sg13g2_decap_8
XFILLER_71_109 VDD VSS sg13g2_decap_8
X_07683_ _07683_/X _13289_/B _11243_/C VDD VSS sg13g2_or2_1
XFILLER_25_515 VDD VSS sg13g2_decap_8
XFILLER_92_470 VDD VSS sg13g2_fill_1
XFILLER_53_824 VDD VSS sg13g2_decap_4
X_09422_ _14024_/D _09620_/A0 _14024_/Q _09428_/S VDD VSS sg13g2_mux2_1
XFILLER_37_397 VDD VSS sg13g2_decap_8
XFILLER_92_492 VDD VSS sg13g2_decap_8
XFILLER_168_1398 VDD VSS sg13g2_decap_8
XFILLER_80_654 VDD VSS sg13g2_decap_8
X_09353_ _13957_/D _09617_/A0 _13957_/Q _09364_/S VDD VSS sg13g2_mux2_1
XFILLER_100_14 VDD VSS sg13g2_decap_8
XFILLER_40_529 VDD VSS sg13g2_decap_8
XFILLER_127_1040 VDD VSS sg13g2_fill_1
XFILLER_178_553 VDD VSS sg13g2_decap_8
X_08304_ _08304_/Y _08306_/C _08306_/B VDD VSS sg13g2_nand2_1
XFILLER_90_1459 VDD VSS sg13g2_fill_1
X_09284_ _13892_/D _13892_/Q _10080_/A0 _09292_/S VDD VSS sg13g2_mux2_1
XFILLER_166_715 VDD VSS sg13g2_decap_4
Xclkbuf_5_24__f_clk_i clkbuf_leaf_52_clk_i/A clkbuf_4_12_0_clk_i/X VDD VSS sg13g2_buf_16
XFILLER_60_18 VDD VSS sg13g2_decap_8
X_08235_ _08235_/X _08278_/A3 _07910_/B _07768_/A _08253_/A1 _08337_/S1 _13550_/A1
+ VDD VSS sg13g2_mux4_1
XFILLER_140_1240 VDD VSS sg13g2_decap_8
XFILLER_20_286 VDD VSS sg13g2_decap_8
XFILLER_14_1254 VDD VSS sg13g2_decap_8
X_14514__1688 _14514_/RESET_B VDD VSS sg13g2_tiehi
XFILLER_140_1273 VDD VSS sg13g2_decap_8
X_08166_ _15222_/D _08166_/A _08166_/B _08166_/C VDD VSS sg13g2_nand3_1
XFILLER_180_217 VDD VSS sg13g2_decap_8
XFILLER_101_1246 VDD VSS sg13g2_decap_8
XFILLER_88_1355 VDD VSS sg13g2_decap_8
XFILLER_101_1257 VDD VSS sg13g2_fill_2
XFILLER_106_314 VDD VSS sg13g2_fill_2
XFILLER_134_623 VDD VSS sg13g2_decap_8
XFILLER_175_1314 VDD VSS sg13g2_decap_8
XFILLER_49_1317 VDD VSS sg13g2_decap_8
XFILLER_109_67 VDD VSS sg13g2_decap_4
XFILLER_146_494 VDD VSS sg13g2_fill_1
X_08097_ _08098_/B _08200_/B _08094_/X _08096_/X VDD VSS sg13g2_a21oi_1
XFILLER_106_336 VDD VSS sg13g2_decap_8
XFILLER_107_7 VDD VSS sg13g2_decap_4
XFILLER_161_431 VDD VSS sg13g2_decap_8
X_14768__2968 _14768_/RESET_B VDD VSS sg13g2_tiehi
XFILLER_134_656 VDD VSS sg13g2_fill_2
XFILLER_84_1219 VDD VSS sg13g2_decap_8
Xclkload90 clkload90/Y clkload90/A VDD VSS sg13g2_inv_2
X_14693__1509 _14693_/RESET_B VDD VSS sg13g2_tiehi
XFILLER_115_892 VDD VSS sg13g2_decap_8
XFILLER_133_199 VDD VSS sg13g2_decap_4
XFILLER_134_1011 VDD VSS sg13g2_decap_8
XFILLER_47_1063 VDD VSS sg13g2_fill_2
XFILLER_87_220 VDD VSS sg13g2_decap_8
XFILLER_0_658 VDD VSS sg13g2_decap_8
XFILLER_88_754 VDD VSS sg13g2_decap_8
XFILLER_130_862 VDD VSS sg13g2_decap_8
XFILLER_130_873 VDD VSS sg13g2_fill_2
XFILLER_5_1400 VDD VSS sg13g2_decap_8
X_08999_ _08999_/Y _14900_/Q _08993_/X _09024_/A VDD VSS sg13g2_o21ai_1
XFILLER_85_59 VDD VSS sg13g2_fill_1
XFILLER_60_1252 VDD VSS sg13g2_decap_8
XFILLER_29_832 VDD VSS sg13g2_decap_8
XFILLER_91_908 VDD VSS sg13g2_decap_8
XFILLER_29_843 VDD VSS sg13g2_fill_1
XFILLER_25_1383 VDD VSS sg13g2_decap_8
XFILLER_21_1225 VDD VSS sg13g2_decap_8
XFILLER_99_1451 VDD VSS sg13g2_decap_8
XFILLER_18_53 VDD VSS sg13g2_decap_8
XFILLER_112_1375 VDD VSS sg13g2_decap_8
X_10961_ _11009_/A _14759_/Q _10965_/B VDD VSS sg13g2_nand2b_1
XFILLER_141_54 VDD VSS sg13g2_decap_8
XFILLER_16_526 VDD VSS sg13g2_fill_2
XFILLER_95_1337 VDD VSS sg13g2_decap_8
XFILLER_71_621 VDD VSS sg13g2_decap_8
XFILLER_43_312 VDD VSS sg13g2_fill_2
X_12700_ _12700_/X _14708_/Q _14740_/Q _13780_/Q _13812_/Q _12701_/S0 _12701_/S1 VDD
+ VSS sg13g2_mux4_1
XFILLER_55_172 VDD VSS sg13g2_decap_8
XFILLER_55_183 VDD VSS sg13g2_fill_1
XFILLER_44_857 VDD VSS sg13g2_decap_8
X_13680_ _13680_/Q clkload57/A _13680_/D _13680_/RESET_B VDD VSS sg13g2_dfrbpq_1
XFILLER_141_98 VDD VSS sg13g2_fill_1
X_10892_ _10893_/B _10879_/Y _10863_/X _10880_/Y VDD VSS sg13g2_a21oi_1
XFILLER_19_1121 VDD VSS sg13g2_decap_8
X_12631_ _12631_/X _13743_/Q _14095_/Q _14447_/Q _14543_/Q _12686_/S0 _12686_/S1 VDD
+ VSS sg13g2_mux4_1
XFILLER_34_41 VDD VSS sg13g2_fill_2
XFILLER_12_710 VDD VSS sg13g2_decap_8
XFILLER_169_553 VDD VSS sg13g2_decap_4
X_12562_ _12562_/X _13738_/Q _14090_/Q _14442_/Q _14538_/Q _12614_/S0 _12614_/S1 VDD
+ VSS sg13g2_mux4_1
XFILLER_11_242 VDD VSS sg13g2_decap_8
XFILLER_129_428 VDD VSS sg13g2_decap_8
XFILLER_19_1198 VDD VSS sg13g2_decap_8
X_14301_ _14301_/Q clkload28/A _14301_/D _14301_/RESET_B VDD VSS sg13g2_dfrbpq_1
X_11513_ _11513_/X _14115_/Q _14147_/Q _14179_/Q _14211_/Q _11514_/S0 _11514_/S1 VDD
+ VSS sg13g2_mux4_1
XFILLER_8_725 VDD VSS sg13g2_decap_8
XFILLER_184_545 VDD VSS sg13g2_decap_8
X_12493_ _12493_/X _14117_/Q _14149_/Q _14181_/Q _14213_/Q _12494_/S0 _12494_/S1 VDD
+ VSS sg13g2_mux4_1
XFILLER_106_1179 VDD VSS sg13g2_decap_8
XFILLER_7_224 VDD VSS sg13g2_decap_8
XFILLER_123_1460 VDD VSS sg13g2_decap_8
X_14232_ _14232_/Q clkload47/A _14232_/D _14232_/RESET_B VDD VSS sg13g2_dfrbpq_1
X_11444_ _11444_/X _14688_/Q _14720_/Q _13760_/Q _13792_/Q _12105_/A1 _11444_/S1 VDD
+ VSS sg13g2_mux4_1
XFILLER_32_1365 VDD VSS sg13g2_decap_8
XFILLER_138_984 VDD VSS sg13g2_decap_8
XFILLER_137_461 VDD VSS sg13g2_decap_8
XFILLER_124_100 VDD VSS sg13g2_fill_1
XFILLER_124_111 VDD VSS sg13g2_decap_4
X_14163_ _14163_/Q clkload37/A _14163_/D _14163_/RESET_B VDD VSS sg13g2_dfrbpq_1
XFILLER_4_931 VDD VSS sg13g2_decap_8
X_11375_ _11375_/Y _11370_/Y _11371_/Y _11822_/B VDD VSS sg13g2_a21oi_1
XFILLER_166_84 VDD VSS sg13g2_decap_8
XFILLER_124_144 VDD VSS sg13g2_fill_1
X_13114_ _13116_/B _13092_/C _13172_/C VDD VSS sg13g2_nand2b_1
X_10326_ _10345_/C _14799_/Q _14800_/Q _14801_/Q _14802_/Q VDD VSS sg13g2_and4_1
XFILLER_112_306 VDD VSS sg13g2_decap_8
X_14094_ _14094_/Q _14602_/CLK _14094_/D _14094_/RESET_B VDD VSS sg13g2_dfrbpq_1
XFILLER_3_452 VDD VSS sg13g2_decap_8
XFILLER_124_177 VDD VSS sg13g2_decap_4
X_14669__1533 _14669_/RESET_B VDD VSS sg13g2_tiehi
XFILLER_112_328 VDD VSS sg13g2_fill_1
X_13045_ _13050_/C _13600_/B _13044_/Y _12914_/C VDD VSS sg13g2_a21oi_1
XFILLER_156_1280 VDD VSS sg13g2_decap_8
X_10257_ _10268_/D _14779_/Q _14780_/Q _14781_/Q _10258_/D VDD VSS sg13g2_and4_1
XFILLER_78_220 VDD VSS sg13g2_fill_2
XFILLER_117_1242 VDD VSS sg13g2_fill_1
XFILLER_117_1253 VDD VSS sg13g2_decap_8
Xfanout1220 _13273_/A _14862_/Q VDD VSS sg13g2_buf_1
XFILLER_6_1208 VDD VSS sg13g2_decap_8
XFILLER_59_93 VDD VSS sg13g2_decap_8
XFILLER_22_7 VDD VSS sg13g2_decap_8
Xfanout1231 _11171_/B _11202_/A VDD VSS sg13g2_buf_1
XFILLER_78_253 VDD VSS sg13g2_decap_4
Xfanout1242 _13189_/B _13669_/Q VDD VSS sg13g2_buf_1
X_10188_ _14751_/D _15194_/D _14751_/Q _13651_/S VDD VSS sg13g2_mux2_1
XFILLER_26_1158 VDD VSS sg13g2_decap_8
Xfanout1253 _11231_/S fanout1255/X VDD VSS sg13g2_buf_1
XFILLER_79_798 VDD VSS sg13g2_decap_8
Xfanout1264 _12336_/A2 _13660_/Q VDD VSS sg13g2_buf_1
XFILLER_120_383 VDD VSS sg13g2_decap_8
X_14813__2923 _14813_/RESET_B VDD VSS sg13g2_tiehi
Xfanout1275 _11970_/C fanout1281/X VDD VSS sg13g2_buf_1
XFILLER_78_297 VDD VSS sg13g2_fill_2
XFILLER_19_320 VDD VSS sg13g2_decap_8
Xfanout1286 _12114_/S1 _11444_/S1 VDD VSS sg13g2_buf_1
X_14996_ _14996_/Q clkload22/A _14996_/D _14996_/RESET_B VDD VSS sg13g2_dfrbpq_1
Xfanout1297 _11805_/C fanout1298/X VDD VSS sg13g2_buf_1
XFILLER_81_407 VDD VSS sg13g2_decap_8
X_13947_ _13947_/Q clkload79/A _13947_/D _13947_/RESET_B VDD VSS sg13g2_dfrbpq_1
XFILLER_46_150 VDD VSS sg13g2_decap_4
XFILLER_35_824 VDD VSS sg13g2_decap_8
XFILLER_75_92 VDD VSS sg13g2_decap_4
XFILLER_19_397 VDD VSS sg13g2_decap_8
X_15037__2573 _15037_/RESET_B VDD VSS sg13g2_tiehi
XFILLER_74_492 VDD VSS sg13g2_decap_8
X_13878_ _13878_/Q clkload68/A _13878_/D _13878_/RESET_B VDD VSS sg13g2_dfrbpq_1
XFILLER_35_879 VDD VSS sg13g2_decap_8
XFILLER_61_142 VDD VSS sg13g2_decap_8
XFILLER_50_816 VDD VSS sg13g2_decap_8
XFILLER_37_1210 VDD VSS sg13g2_decap_8
X_12829_ _12829_/Y _14865_/Q _12895_/B VDD VSS sg13g2_nand2_1
X_15244__3035 _15244_/RESET_B VDD VSS sg13g2_tiehi
XFILLER_163_1240 VDD VSS sg13g2_decap_8
XFILLER_124_1202 VDD VSS sg13g2_decap_8
XFILLER_124_1213 VDD VSS sg13g2_fill_2
XFILLER_33_1107 VDD VSS sg13g2_fill_2
XFILLER_72_1167 VDD VSS sg13g2_decap_8
XFILLER_37_1287 VDD VSS sg13g2_decap_8
XFILLER_124_1257 VDD VSS sg13g2_decap_4
XFILLER_148_759 VDD VSS sg13g2_decap_8
XFILLER_50_1421 VDD VSS sg13g2_decap_8
XFILLER_30_584 VDD VSS sg13g2_decap_8
X_08020_ _08021_/A _08200_/B _08018_/X _08019_/X VDD VSS sg13g2_a21oi_1
X_14887__2793 _14887_/RESET_B VDD VSS sg13g2_tiehi
XFILLER_128_450 VDD VSS sg13g2_fill_2
XFILLER_116_601 VDD VSS sg13g2_decap_4
XFILLER_129_984 VDD VSS sg13g2_decap_4
XFILLER_129_995 VDD VSS sg13g2_fill_2
XFILLER_7_791 VDD VSS sg13g2_decap_8
XFILLER_143_431 VDD VSS sg13g2_decap_8
XFILLER_104_807 VDD VSS sg13g2_decap_8
X_15062__1454 _15062_/RESET_B VDD VSS sg13g2_tiehi
XFILLER_104_818 VDD VSS sg13g2_fill_1
XFILLER_104_829 VDD VSS sg13g2_decap_8
X_09971_ _09971_/Y _10037_/A _10105_/B _10070_/C VDD VSS sg13g2_nand3_1
XFILLER_115_166 VDD VSS sg13g2_decap_8
XFILLER_157_1066 VDD VSS sg13g2_decap_8
XFILLER_170_261 VDD VSS sg13g2_decap_8
XFILLER_115_177 VDD VSS sg13g2_fill_2
XFILLER_157_1077 VDD VSS sg13g2_fill_1
XFILLER_170_1200 VDD VSS sg13g2_decap_8
X_08922_ _08922_/X _08921_/X _08922_/A1 _08922_/S VDD VSS sg13g2_mux2_1
XFILLER_83_1263 VDD VSS sg13g2_decap_8
XFILLER_44_1214 VDD VSS sg13g2_decap_8
XFILLER_135_1342 VDD VSS sg13g2_fill_1
XFILLER_130_158 VDD VSS sg13g2_decap_8
X_08853_ _08853_/X _15026_/Q _08852_/A _08852_/Y VDD VSS sg13g2_a21o_1
XFILLER_170_1277 VDD VSS sg13g2_decap_8
XFILLER_85_735 VDD VSS sg13g2_decap_8
X_07804_ _07807_/C _13555_/A _07949_/C VDD VSS sg13g2_nand2b_1
X_08784_ _08784_/Y _13680_/Q _08787_/B VDD VSS sg13g2_nor2_1
XFILLER_57_459 VDD VSS sg13g2_decap_8
XFILLER_55_18 VDD VSS sg13g2_decap_8
X_07735_ _07744_/B _15217_/D _07735_/B _07735_/C _07735_/D VDD VSS sg13g2_or4_1
XFILLER_44_109 VDD VSS sg13g2_decap_8
XFILLER_53_610 VDD VSS sg13g2_decap_8
XFILLER_53_621 VDD VSS sg13g2_fill_2
XFILLER_25_312 VDD VSS sg13g2_decap_8
XFILLER_129_1102 VDD VSS sg13g2_decap_8
X_07666_ _07708_/A _13293_/A _15055_/Q VDD VSS sg13g2_nor2_1
XFILLER_53_654 VDD VSS sg13g2_decap_4
XFILLER_0_1352 VDD VSS sg13g2_decap_8
XFILLER_20_1291 VDD VSS sg13g2_decap_8
XFILLER_41_805 VDD VSS sg13g2_decap_8
XFILLER_168_1195 VDD VSS sg13g2_decap_8
X_09405_ _14008_/D _09737_/A0 _14008_/Q _09405_/S VDD VSS sg13g2_mux2_1
XFILLER_80_462 VDD VSS sg13g2_decap_8
XFILLER_111_57 VDD VSS sg13g2_decap_8
XFILLER_41_827 VDD VSS sg13g2_decap_8
XFILLER_25_378 VDD VSS sg13g2_decap_8
XFILLER_13_529 VDD VSS sg13g2_decap_8
XFILLER_55_1321 VDD VSS sg13g2_decap_8
XFILLER_52_164 VDD VSS sg13g2_decap_8
XFILLER_40_304 VDD VSS sg13g2_fill_1
XFILLER_40_315 VDD VSS sg13g2_fill_2
XFILLER_71_28 VDD VSS sg13g2_decap_8
XFILLER_181_1351 VDD VSS sg13g2_decap_8
X_09336_ _13943_/D _10166_/A1 _13943_/Q _09337_/S VDD VSS sg13g2_mux2_1
XFILLER_139_715 VDD VSS sg13g2_fill_2
XFILLER_16_1316 VDD VSS sg13g2_decap_8
XFILLER_51_1207 VDD VSS sg13g2_decap_8
XFILLER_139_726 VDD VSS sg13g2_fill_1
X_14747__1455 _14747_/RESET_B VDD VSS sg13g2_tiehi
XFILLER_107_1466 VDD VSS sg13g2_decap_8
XFILLER_55_1398 VDD VSS sg13g2_decap_8
XFILLER_107_1477 VDD VSS sg13g2_fill_2
XFILLER_166_534 VDD VSS sg13g2_decap_8
XFILLER_178_394 VDD VSS sg13g2_decap_8
X_09267_ _13876_/D _13876_/Q _09931_/A1 _09267_/S VDD VSS sg13g2_mux2_1
XFILLER_142_1368 VDD VSS sg13g2_decap_8
XFILLER_138_269 VDD VSS sg13g2_fill_2
XFILLER_14_1051 VDD VSS sg13g2_decap_8
X_08218_ _08319_/A _08219_/A _13545_/A VDD VSS sg13g2_nor2_1
X_09198_ _13814_/D _13814_/Q _10165_/A1 _09202_/S VDD VSS sg13g2_mux2_1
XFILLER_181_526 VDD VSS sg13g2_fill_1
XFILLER_5_728 VDD VSS sg13g2_decap_8
XFILLER_153_228 VDD VSS sg13g2_decap_8
XFILLER_20_21 VDD VSS sg13g2_decap_8
X_08149_ _08149_/Y _08196_/A1 _08011_/X _08688_/A VDD VSS sg13g2_o21ai_1
XFILLER_135_954 VDD VSS sg13g2_decap_8
XFILLER_175_1111 VDD VSS sg13g2_decap_8
XFILLER_181_559 VDD VSS sg13g2_decap_8
XFILLER_4_238 VDD VSS sg13g2_decap_8
XFILLER_88_1174 VDD VSS sg13g2_fill_2
XFILLER_107_667 VDD VSS sg13g2_decap_8
XFILLER_136_21 VDD VSS sg13g2_decap_8
X_11160_ _11161_/A _11150_/B _11150_/A _11159_/Y VDD VSS sg13g2_o21ai_1
XFILLER_136_1106 VDD VSS sg13g2_decap_8
XFILLER_162_784 VDD VSS sg13g2_decap_8
XFILLER_136_65 VDD VSS sg13g2_decap_8
XFILLER_20_98 VDD VSS sg13g2_decap_8
XFILLER_121_114 VDD VSS sg13g2_decap_8
XFILLER_175_1188 VDD VSS sg13g2_decap_8
X_10111_ _14689_/D _10144_/A1 _14689_/Q _10123_/S VDD VSS sg13g2_mux2_1
XFILLER_1_945 VDD VSS sg13g2_decap_8
X_11091_ _11094_/B _11091_/A _11091_/B VDD VSS sg13g2_nand2_1
XFILLER_103_840 VDD VSS sg13g2_decap_8
XFILLER_153_1442 VDD VSS sg13g2_decap_8
XFILLER_0_455 VDD VSS sg13g2_decap_8
X_10042_ _14623_/D _10075_/A0 _14623_/Q _10063_/S VDD VSS sg13g2_mux2_1
XFILLER_27_1467 VDD VSS sg13g2_decap_8
XFILLER_27_1478 VDD VSS sg13g2_fill_1
XFILLER_152_20 VDD VSS sg13g2_fill_1
XFILLER_76_735 VDD VSS sg13g2_fill_1
XFILLER_75_212 VDD VSS sg13g2_decap_8
XFILLER_62_1369 VDD VSS sg13g2_decap_8
X_14850_ _14850_/Q clkload84/A _14850_/D _14850_/RESET_B VDD VSS sg13g2_dfrbpq_1
XFILLER_152_64 VDD VSS sg13g2_decap_4
XFILLER_75_245 VDD VSS sg13g2_decap_8
XFILLER_64_919 VDD VSS sg13g2_fill_2
XFILLER_25_1180 VDD VSS sg13g2_decap_8
XFILLER_91_705 VDD VSS sg13g2_decap_8
XFILLER_60_1071 VDD VSS sg13g2_decap_8
XFILLER_57_960 VDD VSS sg13g2_decap_8
X_13801_ _13801_/Q _14729_/CLK _13801_/D _13801_/RESET_B VDD VSS sg13g2_dfrbpq_1
XFILLER_60_1082 VDD VSS sg13g2_fill_1
XFILLER_5_1274 VDD VSS sg13g2_decap_8
XFILLER_17_813 VDD VSS sg13g2_decap_8
X_14781_ _14781_/Q clkload87/A _14781_/D _14781_/RESET_B VDD VSS sg13g2_dfrbpq_1
XFILLER_28_150 VDD VSS sg13g2_decap_8
XFILLER_1_1127 VDD VSS sg13g2_decap_8
X_11993_ _11993_/X _14257_/Q _14289_/Q _14321_/Q _14353_/Q _11997_/S0 _11997_/S1 VDD
+ VSS sg13g2_mux4_1
X_13732_ _13732_/Q _14724_/CLK _13732_/D _13732_/RESET_B VDD VSS sg13g2_dfrbpq_1
XFILLER_95_1134 VDD VSS sg13g2_decap_8
XFILLER_56_492 VDD VSS sg13g2_fill_1
XFILLER_45_40 VDD VSS sg13g2_fill_1
XFILLER_44_632 VDD VSS sg13g2_decap_8
XFILLER_147_1213 VDD VSS sg13g2_fill_1
X_10944_ _10944_/Y _10948_/C _10948_/D VDD VSS sg13g2_nor2_1
XFILLER_72_952 VDD VSS sg13g2_decap_8
XFILLER_44_643 VDD VSS sg13g2_fill_2
XFILLER_186_1273 VDD VSS sg13g2_decap_8
XFILLER_43_131 VDD VSS sg13g2_decap_8
XFILLER_17_879 VDD VSS sg13g2_decap_8
XFILLER_71_462 VDD VSS sg13g2_fill_1
XFILLER_147_1257 VDD VSS sg13g2_decap_8
X_13663_ _13663_/Q clkload74/A _13663_/D _13663_/RESET_B VDD VSS sg13g2_dfrbpq_1
XFILLER_147_1268 VDD VSS sg13g2_fill_1
X_10875_ _10875_/Y _10875_/A _10875_/B VDD VSS sg13g2_nand2_1
XFILLER_182_1159 VDD VSS sg13g2_decap_8
X_12614_ _12614_/X _13966_/Q _13998_/Q _14030_/Q _14062_/Q _12614_/S0 _12614_/S1 VDD
+ VSS sg13g2_mux4_1
XFILLER_160_1402 VDD VSS sg13g2_decap_8
X_13594_ _15163_/D _13593_/B _13592_/Y _13593_/Y VDD VSS sg13g2_a21oi_1
XFILLER_73_1465 VDD VSS sg13g2_decap_8
XFILLER_84_9 VDD VSS sg13g2_decap_8
XFILLER_157_534 VDD VSS sg13g2_decap_8
XFILLER_185_843 VDD VSS sg13g2_decap_8
X_12545_ _12545_/X _14377_/Q _14409_/Q _14473_/Q _14505_/Q _12703_/S0 _12703_/S1 VDD
+ VSS sg13g2_mux4_1
XFILLER_8_522 VDD VSS sg13g2_decap_8
XFILLER_129_236 VDD VSS sg13g2_decap_8
XFILLER_12_584 VDD VSS sg13g2_decap_8
XFILLER_184_331 VDD VSS sg13g2_decap_8
XFILLER_129_247 VDD VSS sg13g2_fill_1
XFILLER_145_707 VDD VSS sg13g2_fill_2
XFILLER_61_94 VDD VSS sg13g2_decap_8
XFILLER_172_515 VDD VSS sg13g2_decap_8
X_12476_ _12476_/X _14244_/Q _14276_/Q _14308_/Q _14340_/Q _12480_/S0 _12480_/S1 VDD
+ VSS sg13g2_mux4_1
XFILLER_32_1162 VDD VSS sg13g2_decap_8
X_13841__2361 _13841_/RESET_B VDD VSS sg13g2_tiehi
X_14006__2196 _14006_/RESET_B VDD VSS sg13g2_tiehi
X_14215_ _14215_/Q clkload5/A _14215_/D _14215_/RESET_B VDD VSS sg13g2_dfrbpq_1
XFILLER_8_599 VDD VSS sg13g2_decap_8
XANTENNA_5 _09001_/X VDD VSS sg13g2_antennanp
XFILLER_125_420 VDD VSS sg13g2_fill_1
X_11427_ _11427_/X _11428_/A _13689_/Q VDD VSS sg13g2_and2_1
X_15195_ _15195_/Q _15196_/CLK _15195_/D _15195_/RESET_B VDD VSS sg13g2_dfrbpq_1
XFILLER_6_67 VDD VSS sg13g2_decap_8
XFILLER_113_604 VDD VSS sg13g2_decap_8
XFILLER_141_913 VDD VSS sg13g2_decap_8
X_14146_ _14146_/Q _14722_/CLK _14146_/D _14146_/RESET_B VDD VSS sg13g2_dfrbpq_1
XFILLER_126_998 VDD VSS sg13g2_decap_8
XFILLER_152_250 VDD VSS sg13g2_decap_8
XFILLER_153_784 VDD VSS sg13g2_decap_4
X_11358_ _11359_/A _13726_/Q _14078_/Q _14430_/Q _14526_/Q _11365_/A _11366_/C VDD
+ VSS sg13g2_mux4_1
XFILLER_158_1375 VDD VSS sg13g2_decap_8
XFILLER_125_486 VDD VSS sg13g2_decap_8
XFILLER_67_1269 VDD VSS sg13g2_decap_8
XFILLER_125_497 VDD VSS sg13g2_fill_1
X_14185__2017 _14185_/RESET_B VDD VSS sg13g2_tiehi
X_10309_ _10312_/B _14796_/Q _10327_/B _14797_/Q VDD VSS sg13g2_a21oi_1
XFILLER_113_659 VDD VSS sg13g2_decap_8
X_14077_ _14077_/Q clkload29/A _14077_/D _14077_/RESET_B VDD VSS sg13g2_dfrbpq_1
X_11289_ _11289_/Y _14895_/Q _12338_/A2 _07684_/B VDD VSS sg13g2_a21oi_1
XFILLER_140_467 VDD VSS sg13g2_fill_1
X_13028_ _13028_/Y _14877_/Q _13028_/B VDD VSS sg13g2_nand2_1
XFILLER_79_562 VDD VSS sg13g2_fill_2
XFILLER_6_1005 VDD VSS sg13g2_decap_8
XFILLER_80_1447 VDD VSS sg13g2_decap_8
XFILLER_79_573 VDD VSS sg13g2_fill_1
XFILLER_117_1083 VDD VSS sg13g2_decap_8
Xfanout1050 _13545_/A _14996_/Q VDD VSS sg13g2_buf_1
XFILLER_117_1094 VDD VSS sg13g2_fill_1
Xfanout1061 _07629_/A _14992_/Q VDD VSS sg13g2_buf_1
Xfanout1072 _08621_/B _13525_/A VDD VSS sg13g2_buf_1
Xfanout1083 _07884_/A _08402_/A VDD VSS sg13g2_buf_1
XFILLER_94_565 VDD VSS sg13g2_decap_8
XFILLER_43_1280 VDD VSS sg13g2_decap_8
Xfanout1094 _08635_/S0 fanout1103/X VDD VSS sg13g2_buf_1
XFILLER_82_727 VDD VSS sg13g2_fill_2
XFILLER_78_1310 VDD VSS sg13g2_decap_8
XFILLER_66_278 VDD VSS sg13g2_decap_8
XFILLER_54_418 VDD VSS sg13g2_decap_8
X_14979_ _14979_/Q clkload32/A _14979_/D _14979_/RESET_B VDD VSS sg13g2_dfrbpq_1
XFILLER_47_470 VDD VSS sg13g2_decap_8
XFILLER_78_1387 VDD VSS sg13g2_decap_8
XFILLER_35_676 VDD VSS sg13g2_decap_8
XFILLER_23_827 VDD VSS sg13g2_decap_8
XFILLER_90_782 VDD VSS sg13g2_decap_8
XFILLER_165_1357 VDD VSS sg13g2_decap_8
XFILLER_16_890 VDD VSS sg13g2_fill_1
XFILLER_179_158 VDD VSS sg13g2_decap_8
X_14216__1986 _14216_/RESET_B VDD VSS sg13g2_tiehi
X_14992__2618 _14992_/RESET_B VDD VSS sg13g2_tiehi
XFILLER_148_512 VDD VSS sg13g2_fill_1
X_09121_ _10767_/B _09147_/B _15046_/Q _09120_/Y VDD VSS sg13g2_o21ai_1
XFILLER_124_1054 VDD VSS sg13g2_decap_8
X_09052_ _13769_/D _13769_/Q _10152_/A1 _09077_/S VDD VSS sg13g2_mux2_1
XFILLER_124_1098 VDD VSS sg13g2_fill_1
X_14395__1807 _14395_/RESET_B VDD VSS sg13g2_tiehi
X_08003_ _08003_/Y _13290_/B _15131_/Q _13290_/A VDD VSS sg13g2_nand3_1
X_14431__1771 _14431_/RESET_B VDD VSS sg13g2_tiehi
XFILLER_116_420 VDD VSS sg13g2_decap_4
XFILLER_117_954 VDD VSS sg13g2_decap_4
XFILLER_50_1295 VDD VSS sg13g2_decap_8
XFILLER_11_1268 VDD VSS sg13g2_decap_8
XFILLER_132_902 VDD VSS sg13g2_fill_1
XFILLER_102_1396 VDD VSS sg13g2_decap_8
XFILLER_117_987 VDD VSS sg13g2_fill_1
XFILLER_176_1464 VDD VSS sg13g2_decap_8
XFILLER_144_784 VDD VSS sg13g2_decap_8
XFILLER_46_1309 VDD VSS sg13g2_decap_8
XFILLER_143_272 VDD VSS sg13g2_fill_2
XFILLER_171_581 VDD VSS sg13g2_decap_8
XFILLER_85_1369 VDD VSS sg13g2_decap_8
XFILLER_106_13 VDD VSS sg13g2_fill_1
XFILLER_143_294 VDD VSS sg13g2_decap_8
X_09954_ _14538_/D _14538_/Q _10153_/A1 _09958_/S VDD VSS sg13g2_mux2_1
XFILLER_89_359 VDD VSS sg13g2_fill_2
XFILLER_44_1000 VDD VSS sg13g2_decap_8
XFILLER_103_147 VDD VSS sg13g2_fill_1
XFILLER_83_1071 VDD VSS sg13g2_decap_8
X_08905_ _13709_/D _16871_/A _08904_/X _08932_/S VDD VSS sg13g2_mux2_1
X_09885_ _14471_/D _09918_/A1 _14471_/Q _09894_/S VDD VSS sg13g2_mux2_1
XFILLER_131_1003 VDD VSS sg13g2_fill_1
XFILLER_140_990 VDD VSS sg13g2_fill_2
X_13704__2498 _13704_/RESET_B VDD VSS sg13g2_tiehi
XFILLER_97_370 VDD VSS sg13g2_fill_2
XFILLER_66_28 VDD VSS sg13g2_decap_8
XFILLER_97_392 VDD VSS sg13g2_decap_4
XFILLER_135_1194 VDD VSS sg13g2_decap_8
X_08836_ _08836_/Y _11335_/A _08843_/B VDD VSS sg13g2_nand2_1
XFILLER_57_245 VDD VSS sg13g2_fill_2
XFILLER_131_1069 VDD VSS sg13g2_decap_8
XFILLER_22_1342 VDD VSS sg13g2_decap_8
XFILLER_2_1414 VDD VSS sg13g2_decap_8
X_08767_ _08767_/Y _13345_/B _14760_/Q _15188_/Q _07719_/X VDD VSS sg13g2_a22oi_1
XFILLER_85_598 VDD VSS sg13g2_decap_4
XFILLER_174_7 VDD VSS sg13g2_decap_8
XFILLER_72_215 VDD VSS sg13g2_decap_8
XFILLER_54_930 VDD VSS sg13g2_decap_8
XFILLER_122_56 VDD VSS sg13g2_decap_8
XFILLER_72_237 VDD VSS sg13g2_fill_1
X_13883__2319 _13883_/RESET_B VDD VSS sg13g2_tiehi
X_07718_ _08027_/B _15102_/Q _15101_/Q _15094_/Q _15093_/Q VDD VSS sg13g2_or4_1
XFILLER_25_120 VDD VSS sg13g2_decap_8
X_08698_ _08698_/X _08698_/A _08698_/B VDD VSS sg13g2_and2_1
XFILLER_54_963 VDD VSS sg13g2_decap_8
XFILLER_183_1435 VDD VSS sg13g2_decap_8
XFILLER_41_613 VDD VSS sg13g2_decap_8
XFILLER_15_21 VDD VSS sg13g2_decap_8
X_07649_ _07649_/Y _07649_/A VDD VSS sg13g2_inv_1
XFILLER_25_175 VDD VSS sg13g2_decap_4
XFILLER_13_326 VDD VSS sg13g2_decap_8
X_10660_ _10661_/C _14892_/Q _14891_/Q _10663_/D VDD VSS sg13g2_and3_1
XFILLER_16_1113 VDD VSS sg13g2_decap_8
XFILLER_9_308 VDD VSS sg13g2_decap_8
XFILLER_179_681 VDD VSS sg13g2_decap_8
XFILLER_139_523 VDD VSS sg13g2_decap_8
XFILLER_15_98 VDD VSS sg13g2_decap_8
X_14968__2642 _14968_/RESET_B VDD VSS sg13g2_tiehi
XFILLER_167_843 VDD VSS sg13g2_decap_8
X_09319_ _13926_/D _10149_/A1 _13926_/Q _09325_/S VDD VSS sg13g2_mux2_1
XFILLER_55_1195 VDD VSS sg13g2_decap_8
XFILLER_51_1026 VDD VSS sg13g2_decap_8
XFILLER_40_178 VDD VSS sg13g2_decap_4
XFILLER_178_191 VDD VSS sg13g2_decap_8
X_10591_ _10607_/C _14874_/Q _12963_/A _10591_/C _10591_/D VDD VSS sg13g2_and4_1
XFILLER_90_1097 VDD VSS sg13g2_decap_8
X_12330_ _12330_/X _14714_/Q _14746_/Q _13786_/Q _13818_/Q _12330_/S0 _12307_/C VDD
+ VSS sg13g2_mux4_1
XFILLER_142_1187 VDD VSS sg13g2_decap_8
XFILLER_166_364 VDD VSS sg13g2_decap_8
XFILLER_167_898 VDD VSS sg13g2_decap_4
XFILLER_181_301 VDD VSS sg13g2_decap_8
XFILLER_33_1471 VDD VSS sg13g2_decap_4
XFILLER_31_42 VDD VSS sg13g2_decap_8
XFILLER_120_1430 VDD VSS sg13g2_decap_8
XFILLER_31_53 VDD VSS sg13g2_fill_1
XFILLER_5_525 VDD VSS sg13g2_decap_8
XFILLER_107_420 VDD VSS sg13g2_decap_4
XFILLER_108_943 VDD VSS sg13g2_fill_2
X_12261_ _12261_/Y _12237_/Y _12239_/Y _12143_/A VDD VSS sg13g2_a21oi_1
XFILLER_181_345 VDD VSS sg13g2_fill_2
X_14000_ _14000_/Q _14704_/CLK _14000_/D _14000_/RESET_B VDD VSS sg13g2_dfrbpq_1
XFILLER_108_987 VDD VSS sg13g2_decap_8
X_11212_ _11212_/X _14171_/Q _14203_/Q _11218_/S VDD VSS sg13g2_mux2_1
XFILLER_108_998 VDD VSS sg13g2_fill_1
XFILLER_147_97 VDD VSS sg13g2_decap_8
XFILLER_181_389 VDD VSS sg13g2_decap_4
X_12192_ _12192_/Y _12192_/A _12192_/B VDD VSS sg13g2_nor2_1
XFILLER_123_957 VDD VSS sg13g2_decap_4
XFILLER_134_283 VDD VSS sg13g2_decap_8
XFILLER_150_732 VDD VSS sg13g2_decap_8
Xoutput42 mem_axi_araddr[13] _16866_/A VDD VSS sg13g2_buf_1
Xoutput53 mem_axi_araddr[24] _16877_/A VDD VSS sg13g2_buf_1
X_11143_ _11143_/Y _14952_/Q _11170_/B VDD VSS sg13g2_nand2_1
XFILLER_150_754 VDD VSS sg13g2_decap_8
Xoutput64 mem_axi_araddr[5] _16858_/A VDD VSS sg13g2_buf_1
XFILLER_1_742 VDD VSS sg13g2_decap_8
XFILLER_110_607 VDD VSS sg13g2_fill_1
X_15243__3034 _15243_/RESET_B VDD VSS sg13g2_tiehi
Xoutput75 mem_axi_awaddr[14] _16867_/X VDD VSS sg13g2_buf_1
XFILLER_62_1111 VDD VSS sg13g2_decap_8
Xoutput86 mem_axi_awaddr[25] _16878_/X VDD VSS sg13g2_buf_1
XFILLER_66_1291 VDD VSS sg13g2_decap_8
XFILLER_62_1122 VDD VSS sg13g2_fill_1
Xoutput97 mem_axi_awaddr[6] _16859_/X VDD VSS sg13g2_buf_1
XFILLER_0_252 VDD VSS sg13g2_decap_8
XFILLER_122_489 VDD VSS sg13g2_decap_8
XFILLER_163_63 VDD VSS sg13g2_decap_8
X_11074_ _11074_/Y _14947_/Q _11102_/B VDD VSS sg13g2_nand2_1
XFILLER_153_1261 VDD VSS sg13g2_decap_8
XFILLER_27_1264 VDD VSS sg13g2_decap_8
XFILLER_114_1223 VDD VSS sg13g2_fill_1
XFILLER_153_1272 VDD VSS sg13g2_fill_1
XFILLER_62_1166 VDD VSS sg13g2_decap_8
X_14902_ _14902_/Q clkload62/A _14902_/D _14902_/RESET_B VDD VSS sg13g2_dfrbpq_1
X_10025_ _14607_/D _10125_/A0 _14607_/Q _10035_/S VDD VSS sg13g2_mux2_1
XFILLER_7_1358 VDD VSS sg13g2_decap_8
XFILLER_102_180 VDD VSS sg13g2_decap_8
XFILLER_102_191 VDD VSS sg13g2_fill_2
XFILLER_37_919 VDD VSS sg13g2_decap_8
XFILLER_76_565 VDD VSS sg13g2_decap_8
XFILLER_64_705 VDD VSS sg13g2_decap_8
XFILLER_110_1109 VDD VSS sg13g2_fill_1
XFILLER_40_1431 VDD VSS sg13g2_decap_8
XFILLER_114_1289 VDD VSS sg13g2_fill_2
X_14833_ _14833_/Q clkload66/A _14833_/D _14833_/RESET_B VDD VSS sg13g2_dfrbpq_1
XFILLER_63_204 VDD VSS sg13g2_decap_8
XFILLER_149_1308 VDD VSS sg13g2_decap_8
XFILLER_17_610 VDD VSS sg13g2_decap_8
XFILLER_91_524 VDD VSS sg13g2_decap_8
XFILLER_5_1071 VDD VSS sg13g2_decap_8
X_14764_ _14764_/Q clkload22/A _14764_/D _14764_/RESET_B VDD VSS sg13g2_dfrbpq_1
X_14473__1729 _14473_/RESET_B VDD VSS sg13g2_tiehi
X_11976_ _11976_/Y _11975_/Y _11965_/Y _11957_/Y _11947_/Y _11858_/A VDD VSS sg13g2_a221oi_1
X_13859__2343 _13859_/RESET_B VDD VSS sg13g2_tiehi
XFILLER_91_579 VDD VSS sg13g2_decap_8
XFILLER_60_900 VDD VSS sg13g2_decap_8
X_13715_ _16877_/A clkload56/A _13715_/D _13715_/RESET_B VDD VSS sg13g2_dfrbpq_1
XFILLER_186_1092 VDD VSS sg13g2_decap_8
X_10927_ _10927_/Y _10969_/B _10936_/C _11056_/B1 VDD VSS sg13g2_o21ai_1
X_14695_ _14695_/Q _14727_/CLK _14695_/D _14695_/RESET_B VDD VSS sg13g2_dfrbpq_1
XFILLER_72_793 VDD VSS sg13g2_decap_8
XFILLER_44_484 VDD VSS sg13g2_decap_4
XFILLER_32_624 VDD VSS sg13g2_fill_1
XFILLER_60_944 VDD VSS sg13g2_decap_8
XFILLER_177_607 VDD VSS sg13g2_decap_8
XFILLER_31_112 VDD VSS sg13g2_decap_8
XFILLER_71_292 VDD VSS sg13g2_fill_2
X_13646_ _13754_/D _13646_/A VDD VSS sg13g2_buf_1
XFILLER_32_657 VDD VSS sg13g2_decap_8
XFILLER_177_629 VDD VSS sg13g2_decap_8
X_10858_ _10858_/Y _10898_/B1 _10852_/X _10797_/C VDD VSS sg13g2_o21ai_1
XFILLER_73_1262 VDD VSS sg13g2_decap_8
XFILLER_72_82 VDD VSS sg13g2_decap_8
XFILLER_72_93 VDD VSS sg13g2_fill_1
XFILLER_13_893 VDD VSS sg13g2_decap_8
XFILLER_158_854 VDD VSS sg13g2_fill_1
X_13577_ _13577_/Y _14999_/Q _13592_/A2 _13569_/S _15015_/Q _13525_/X VDD VSS sg13g2_a221oi_1
X_10789_ _11185_/B _08954_/S _09155_/Y _08949_/Y VDD VSS sg13g2_o21ai_1
XFILLER_34_1257 VDD VSS sg13g2_decap_8
XFILLER_185_651 VDD VSS sg13g2_decap_8
XFILLER_12_392 VDD VSS sg13g2_decap_8
XFILLER_145_504 VDD VSS sg13g2_decap_8
XFILLER_160_1276 VDD VSS sg13g2_decap_8
X_12528_ _12541_/A _12639_/A1 _12639_/A2 _15002_/Q VDD VSS sg13g2_a21oi_1
XFILLER_9_875 VDD VSS sg13g2_decap_8
XFILLER_157_386 VDD VSS sg13g2_decap_8
X_15247_ _15247_/Q clkload46/A _15247_/D _15247_/RESET_B VDD VSS sg13g2_dfrbpq_1
XFILLER_8_396 VDD VSS sg13g2_decap_8
XFILLER_172_345 VDD VSS sg13g2_decap_8
XFILLER_173_868 VDD VSS sg13g2_fill_1
X_12459_ _12459_/X _13827_/Q _13859_/Q _13891_/Q _13923_/Q _12466_/S0 _12466_/S1 VDD
+ VSS sg13g2_mux4_1
XFILLER_132_209 VDD VSS sg13g2_fill_1
XFILLER_114_924 VDD VSS sg13g2_decap_8
XFILLER_119_1101 VDD VSS sg13g2_fill_2
X_15178_ _15178_/Q clkload87/A _15178_/D _15178_/RESET_B VDD VSS sg13g2_dfrbpq_1
XFILLER_114_935 VDD VSS sg13g2_fill_1
XFILLER_126_795 VDD VSS sg13g2_decap_8
XFILLER_154_1003 VDD VSS sg13g2_fill_1
XFILLER_158_1172 VDD VSS sg13g2_decap_8
X_14129_ _14129_/Q clkload33/A _14129_/D _14129_/RESET_B VDD VSS sg13g2_dfrbpq_1
XFILLER_87_808 VDD VSS sg13g2_decap_8
XFILLER_119_1156 VDD VSS sg13g2_decap_4
Xfanout309 _10157_/S _10137_/Y VDD VSS sg13g2_buf_1
XFILLER_28_1039 VDD VSS sg13g2_decap_8
XFILLER_141_765 VDD VSS sg13g2_decap_4
XFILLER_80_1200 VDD VSS sg13g2_decap_8
XFILLER_115_1009 VDD VSS sg13g2_decap_8
XFILLER_101_618 VDD VSS sg13g2_fill_1
XFILLER_113_489 VDD VSS sg13g2_decap_8
XFILLER_171_1350 VDD VSS sg13g2_decap_8
XFILLER_122_990 VDD VSS sg13g2_fill_2
XFILLER_132_1323 VDD VSS sg13g2_decap_8
XFILLER_45_1375 VDD VSS sg13g2_decap_8
X_09670_ _14263_/D _10066_/A0 _14263_/Q _09672_/S VDD VSS sg13g2_mux2_1
XFILLER_80_1277 VDD VSS sg13g2_decap_8
XFILLER_67_554 VDD VSS sg13g2_fill_1
XFILLER_39_245 VDD VSS sg13g2_decap_8
XFILLER_94_340 VDD VSS sg13g2_decap_8
XFILLER_67_565 VDD VSS sg13g2_fill_1
XFILLER_28_919 VDD VSS sg13g2_fill_1
X_08621_ _08622_/B _08621_/A _08621_/B _08621_/C VDD VSS sg13g2_nor3_1
XFILLER_94_395 VDD VSS sg13g2_fill_1
X_08552_ _08553_/B _08497_/A _08551_/X _08547_/Y _08546_/Y VDD VSS sg13g2_a22oi_1
XFILLER_82_557 VDD VSS sg13g2_decap_8
XFILLER_82_568 VDD VSS sg13g2_fill_1
X_14449__1753 _14449_/RESET_B VDD VSS sg13g2_tiehi
Xclkbuf_4_12_0_clk_i clkbuf_4_12_0_clk_i/X clkbuf_0_clk_i/X VDD VSS sg13g2_buf_8
XFILLER_35_462 VDD VSS sg13g2_decap_8
XFILLER_165_1132 VDD VSS sg13g2_fill_1
XFILLER_78_1184 VDD VSS sg13g2_decap_8
X_08483_ _08501_/A _08483_/A1 _08150_/X _08688_/C VDD VSS sg13g2_o21ai_1
XFILLER_165_1154 VDD VSS sg13g2_decap_8
XFILLER_23_635 VDD VSS sg13g2_decap_8
XFILLER_35_495 VDD VSS sg13g2_decap_8
XFILLER_22_123 VDD VSS sg13g2_decap_8
XFILLER_39_1168 VDD VSS sg13g2_decap_8
XFILLER_51_977 VDD VSS sg13g2_decap_8
XFILLER_149_843 VDD VSS sg13g2_decap_8
XFILLER_22_178 VDD VSS sg13g2_decap_4
XFILLER_10_329 VDD VSS sg13g2_decap_8
XFILLER_17_1455 VDD VSS sg13g2_decap_8
XFILLER_50_498 VDD VSS sg13g2_decap_8
XFILLER_91_1395 VDD VSS sg13g2_decap_8
XFILLER_176_651 VDD VSS sg13g2_fill_1
X_09104_ _09104_/X _13142_/A _09136_/B _09102_/Y VDD VSS sg13g2_a21o_1
XFILLER_52_1368 VDD VSS sg13g2_decap_8
XFILLER_149_887 VDD VSS sg13g2_decap_8
XFILLER_176_673 VDD VSS sg13g2_decap_8
XFILLER_182_109 VDD VSS sg13g2_decap_8
XFILLER_148_375 VDD VSS sg13g2_decap_8
XFILLER_104_1469 VDD VSS sg13g2_fill_1
X_09035_ _09035_/Y _14906_/Q _09031_/C _09074_/B1 VDD VSS sg13g2_o21ai_1
XFILLER_50_1070 VDD VSS sg13g2_decap_8
XFILLER_85_1100 VDD VSS sg13g2_decap_4
XFILLER_11_1065 VDD VSS sg13g2_decap_8
XFILLER_105_924 VDD VSS sg13g2_decap_8
XFILLER_132_710 VDD VSS sg13g2_decap_8
XFILLER_176_1261 VDD VSS sg13g2_decap_8
XFILLER_144_592 VDD VSS sg13g2_decap_8
XFILLER_2_539 VDD VSS sg13g2_decap_8
XFILLER_105_968 VDD VSS sg13g2_decap_8
XFILLER_89_134 VDD VSS sg13g2_fill_2
XFILLER_81_1008 VDD VSS sg13g2_fill_2
XFILLER_131_242 VDD VSS sg13g2_decap_8
X_13937__2265 _13937_/RESET_B VDD VSS sg13g2_tiehi
XFILLER_104_467 VDD VSS sg13g2_fill_1
Xfanout810 _12705_/S0 _12427_/S0 VDD VSS sg13g2_buf_1
XFILLER_131_253 VDD VSS sg13g2_fill_1
XFILLER_172_1158 VDD VSS sg13g2_decap_8
Xfanout821 _12438_/S1 fanout829/X VDD VSS sg13g2_buf_1
Xfanout832 _12550_/S1 _12701_/S1 VDD VSS sg13g2_buf_1
X_09937_ _14522_/D _14522_/Q _09937_/A1 _09937_/S VDD VSS sg13g2_mux2_1
XFILLER_63_1442 VDD VSS sg13g2_decap_8
XFILLER_132_798 VDD VSS sg13g2_decap_8
Xfanout843 _12411_/S1 fanout846/X VDD VSS sg13g2_buf_1
Xfanout854 _12675_/S1 _12716_/S1 VDD VSS sg13g2_buf_1
Xfanout865 _12352_/S1 _12786_/S1 VDD VSS sg13g2_buf_1
Xfanout876 fanout876/X fanout877/X VDD VSS sg13g2_buf_1
XFILLER_19_908 VDD VSS sg13g2_decap_8
Xfanout887 _12616_/S0 fanout889/X VDD VSS sg13g2_buf_1
X_09868_ _14455_/D _14455_/Q _10099_/A0 _09870_/S VDD VSS sg13g2_mux2_1
Xfanout898 _12380_/S0 _12674_/S0 VDD VSS sg13g2_buf_1
XFILLER_24_1459 VDD VSS sg13g2_decap_8
XFILLER_86_885 VDD VSS sg13g2_fill_1
X_08819_ _13690_/D _08817_/Y _08816_/Y _08818_/Y VDD VSS sg13g2_a21oi_1
XFILLER_2_1211 VDD VSS sg13g2_decap_8
X_09799_ _14388_/D _10096_/A0 _14388_/Q _09799_/S VDD VSS sg13g2_mux2_1
XFILLER_85_384 VDD VSS sg13g2_decap_8
XFILLER_172_4 VDD VSS sg13g2_decap_8
XFILLER_45_226 VDD VSS sg13g2_fill_1
XFILLER_73_546 VDD VSS sg13g2_decap_8
X_11830_ _11830_/Y _11806_/Y _11808_/Y _11830_/B1 VDD VSS sg13g2_a21oi_1
XFILLER_96_1251 VDD VSS sg13g2_decap_8
XFILLER_26_42 VDD VSS sg13g2_decap_8
XFILLER_148_1330 VDD VSS sg13g2_decap_8
XFILLER_148_1341 VDD VSS sg13g2_fill_1
XFILLER_2_1288 VDD VSS sg13g2_decap_8
XFILLER_109_1303 VDD VSS sg13g2_decap_8
XFILLER_183_1232 VDD VSS sg13g2_decap_8
X_11761_ _11761_/Y _11761_/A _11761_/B _11898_/C VDD VSS sg13g2_nand3_1
XFILLER_54_782 VDD VSS sg13g2_decap_4
XFILLER_109_1314 VDD VSS sg13g2_fill_1
XFILLER_13_123 VDD VSS sg13g2_decap_8
X_13500_ _15128_/D _13351_/C _13502_/D _13499_/Y VDD VSS sg13g2_o21ai_1
XFILLER_57_1268 VDD VSS sg13g2_decap_8
XFILLER_41_432 VDD VSS sg13g2_decap_8
X_10712_ _10954_/B _09034_/X _08877_/A _08877_/Y VDD VSS sg13g2_a21oi_1
XFILLER_159_629 VDD VSS sg13g2_decap_8
X_14480_ _14480_/Q _14528_/CLK _14480_/D _14480_/RESET_B VDD VSS sg13g2_dfrbpq_1
XFILLER_42_977 VDD VSS sg13g2_decap_8
X_11692_ _11693_/B _11692_/A _14216_/Q VDD VSS sg13g2_nand2_1
XFILLER_9_105 VDD VSS sg13g2_decap_8
XFILLER_70_1413 VDD VSS sg13g2_decap_8
XFILLER_158_139 VDD VSS sg13g2_fill_2
XFILLER_186_448 VDD VSS sg13g2_decap_8
X_13431_ _13431_/Y _13455_/A _13444_/B _13444_/C VDD VSS sg13g2_nor3_1
X_10643_ _14888_/D _10655_/B _10643_/B _10643_/C VDD VSS sg13g2_nor3_1
XFILLER_42_63 VDD VSS sg13g2_decap_4
XFILLER_107_1082 VDD VSS sg13g2_decap_8
XFILLER_31_1419 VDD VSS sg13g2_decap_8
X_13362_ _15073_/D _15073_/Q _13353_/Y _13361_/Y VDD VSS sg13g2_a21o_1
XFILLER_42_85 VDD VSS sg13g2_decap_8
XFILLER_158_63 VDD VSS sg13g2_decap_8
XFILLER_166_161 VDD VSS sg13g2_decap_8
X_10574_ _10583_/D _14870_/Q _12895_/A VDD VSS sg13g2_and2_1
XFILLER_42_96 VDD VSS sg13g2_fill_2
XFILLER_6_823 VDD VSS sg13g2_decap_8
X_14751__2988 _14751_/RESET_B VDD VSS sg13g2_tiehi
X_15101_ _15101_/Q clkload70/A _15101_/D _15101_/RESET_B VDD VSS sg13g2_dfrbpq_1
X_12313_ _12313_/Y _12306_/A _14650_/Q VDD VSS sg13g2_nand2b_1
XFILLER_10_896 VDD VSS sg13g2_decap_8
XFILLER_5_322 VDD VSS sg13g2_decap_8
X_13293_ _13294_/C _13293_/A _13303_/A _13297_/S _13312_/A VDD VSS sg13g2_nor4_1
XFILLER_120_1260 VDD VSS sg13g2_decap_4
XFILLER_142_507 VDD VSS sg13g2_fill_1
XFILLER_177_1047 VDD VSS sg13g2_decap_8
XFILLER_182_676 VDD VSS sg13g2_decap_8
X_15032_ _15032_/Q _15196_/CLK _15032_/D _15032_/RESET_B VDD VSS sg13g2_dfrbpq_1
X_12244_ _12244_/Y _12240_/Y _12241_/Y _12243_/Y _12242_/Y _12253_/B VDD VSS sg13g2_a221oi_1
XFILLER_68_1342 VDD VSS sg13g2_decap_8
XFILLER_108_784 VDD VSS sg13g2_fill_1
XFILLER_181_175 VDD VSS sg13g2_decap_8
XFILLER_108_795 VDD VSS sg13g2_decap_8
XFILLER_155_1312 VDD VSS sg13g2_decap_8
XFILLER_107_283 VDD VSS sg13g2_fill_1
XFILLER_5_399 VDD VSS sg13g2_decap_8
XFILLER_9_1409 VDD VSS sg13g2_decap_8
X_12175_ _12175_/Y _12189_/S0 _14390_/Q VDD VSS sg13g2_nand2b_1
XFILLER_69_808 VDD VSS sg13g2_decap_8
XFILLER_64_1239 VDD VSS sg13g2_decap_8
XFILLER_174_84 VDD VSS sg13g2_decap_8
XFILLER_29_1359 VDD VSS sg13g2_decap_8
XFILLER_116_1318 VDD VSS sg13g2_fill_2
X_14527__1675 _14527_/RESET_B VDD VSS sg13g2_tiehi
XFILLER_122_264 VDD VSS sg13g2_decap_8
XFILLER_150_573 VDD VSS sg13g2_fill_2
X_11126_ _11146_/A _11172_/A _11147_/A VDD VSS sg13g2_xnor2_1
XFILLER_96_627 VDD VSS sg13g2_decap_8
XFILLER_155_1389 VDD VSS sg13g2_decap_8
Xclkbuf_leaf_110_clk_i _15228_/CLK clkbuf_leaf_18_clk_i/A VDD VSS sg13g2_buf_8
XFILLER_3_46 VDD VSS sg13g2_decap_8
X_11057_ _14945_/D _11056_/Y _11055_/Y _11048_/Y VDD VSS sg13g2_o21ai_1
XFILLER_7_1155 VDD VSS sg13g2_decap_8
XFILLER_27_1083 VDD VSS sg13g2_decap_8
X_10008_ _14590_/D _10141_/A1 _14590_/Q _10030_/S VDD VSS sg13g2_mux2_1
XFILLER_3_1019 VDD VSS sg13g2_decap_8
XFILLER_37_738 VDD VSS sg13g2_decap_8
X_14742__1460 _14742_/RESET_B VDD VSS sg13g2_tiehi
XFILLER_149_1127 VDD VSS sg13g2_fill_2
X_14816_ _14816_/Q clkload88/A _14816_/D _14816_/RESET_B VDD VSS sg13g2_dfrbpq_1
Xclkbuf_leaf_125_clk_i clkload18/A clkbuf_5_4__f_clk_i/X VDD VSS sg13g2_buf_8
XFILLER_92_877 VDD VSS sg13g2_fill_2
XFILLER_91_354 VDD VSS sg13g2_fill_2
XFILLER_33_900 VDD VSS sg13g2_decap_8
XFILLER_166_1430 VDD VSS sg13g2_decap_8
XFILLER_33_911 VDD VSS sg13g2_fill_1
XFILLER_17_473 VDD VSS sg13g2_decap_8
X_14747_ _14747_/Q clkload86/A _14747_/D _14747_/RESET_B VDD VSS sg13g2_dfrbpq_1
X_11959_ _11959_/Y _11963_/S0 _14416_/Q _11963_/S1 VDD VSS sg13g2_a21oi_1
XFILLER_75_1335 VDD VSS sg13g2_decap_8
XFILLER_127_1425 VDD VSS sg13g2_decap_8
XFILLER_166_1474 VDD VSS sg13g2_fill_1
XFILLER_127_1436 VDD VSS sg13g2_fill_1
XFILLER_178_927 VDD VSS sg13g2_decap_8
X_14678_ _14678_/Q _14742_/CLK _14678_/D _14678_/RESET_B VDD VSS sg13g2_dfrbpq_1
XFILLER_33_999 VDD VSS sg13g2_fill_1
XFILLER_177_448 VDD VSS sg13g2_decap_8
X_13629_ _13737_/D _13629_/A VDD VSS sg13g2_buf_1
XFILLER_20_649 VDD VSS sg13g2_decap_8
XFILLER_146_802 VDD VSS sg13g2_decap_8
XFILLER_121_1013 VDD VSS sg13g2_fill_1
XFILLER_146_813 VDD VSS sg13g2_fill_1
XFILLER_9_672 VDD VSS sg13g2_decap_8
XFILLER_12_1341 VDD VSS sg13g2_decap_8
XFILLER_145_356 VDD VSS sg13g2_fill_2
XFILLER_146_879 VDD VSS sg13g2_decap_8
XFILLER_173_665 VDD VSS sg13g2_decap_8
XFILLER_8_193 VDD VSS sg13g2_decap_8
XFILLER_161_816 VDD VSS sg13g2_fill_1
XFILLER_145_378 VDD VSS sg13g2_decap_8
XFILLER_59_0 VDD VSS sg13g2_decap_8
XFILLER_145_389 VDD VSS sg13g2_fill_1
XFILLER_160_326 VDD VSS sg13g2_decap_8
XFILLER_161_849 VDD VSS sg13g2_fill_2
XFILLER_172_186 VDD VSS sg13g2_decap_8
X_14952__2663 _14952_/RESET_B VDD VSS sg13g2_tiehi
XFILLER_86_1475 VDD VSS sg13g2_decap_4
XFILLER_113_220 VDD VSS sg13g2_decap_8
XFILLER_173_1456 VDD VSS sg13g2_decap_8
XFILLER_99_465 VDD VSS sg13g2_decap_8
XFILLER_47_1459 VDD VSS sg13g2_decap_8
XFILLER_102_916 VDD VSS sg13g2_decap_8
XFILLER_87_616 VDD VSS sg13g2_decap_8
XFILLER_87_627 VDD VSS sg13g2_fill_2
X_07983_ _07985_/C _07978_/Y _15077_/Q _07908_/B VDD VSS sg13g2_a21oi_1
XFILLER_86_126 VDD VSS sg13g2_decap_8
XFILLER_86_137 VDD VSS sg13g2_fill_1
X_09722_ _14313_/D _09755_/A1 _14313_/Q _09733_/S VDD VSS sg13g2_mux2_1
XFILLER_45_1172 VDD VSS sg13g2_decap_8
XFILLER_68_852 VDD VSS sg13g2_decap_8
XFILLER_41_1025 VDD VSS sg13g2_decap_8
XFILLER_28_705 VDD VSS sg13g2_decap_4
X_09653_ _14246_/D _09686_/A0 _14246_/Q _09659_/S VDD VSS sg13g2_mux2_1
XFILLER_83_822 VDD VSS sg13g2_decap_4
XFILLER_95_693 VDD VSS sg13g2_decap_8
XFILLER_94_170 VDD VSS sg13g2_fill_2
X_08604_ _08605_/B _08541_/A _07855_/B _08522_/C _08643_/D VDD VSS sg13g2_a22oi_1
XFILLER_82_332 VDD VSS sg13g2_fill_2
XFILLER_103_47 VDD VSS sg13g2_decap_8
XFILLER_167_1227 VDD VSS sg13g2_decap_8
X_09584_ _14181_/D _14181_/Q _09617_/A0 _09599_/S VDD VSS sg13g2_mux2_1
XFILLER_63_18 VDD VSS sg13g2_fill_2
XFILLER_70_516 VDD VSS sg13g2_decap_8
X_08535_ _15240_/D _08535_/A _08535_/B VDD VSS sg13g2_nand2_1
XFILLER_42_218 VDD VSS sg13g2_decap_4
XFILLER_24_922 VDD VSS sg13g2_decap_4
XFILLER_179_18 VDD VSS sg13g2_decap_8
X_14826__2910 _14826_/RESET_B VDD VSS sg13g2_tiehi
XFILLER_23_443 VDD VSS sg13g2_decap_8
XFILLER_93_1468 VDD VSS sg13g2_decap_8
XFILLER_180_1427 VDD VSS sg13g2_decap_8
X_08466_ _08617_/B _08376_/X _08465_/X _08511_/S VDD VSS sg13g2_mux2_1
XFILLER_50_251 VDD VSS sg13g2_decap_8
X_15242__3033 _15242_/RESET_B VDD VSS sg13g2_tiehi
XFILLER_11_627 VDD VSS sg13g2_decap_8
XFILLER_56_1290 VDD VSS sg13g2_decap_8
XFILLER_17_1252 VDD VSS sg13g2_decap_8
X_08397_ _08397_/Y _08397_/A _08397_/B VDD VSS sg13g2_nor2_1
XFILLER_10_126 VDD VSS sg13g2_decap_8
XFILLER_137_7 VDD VSS sg13g2_decap_4
XFILLER_91_1192 VDD VSS sg13g2_fill_1
XFILLER_149_662 VDD VSS sg13g2_decap_8
X_14605__1597 _14605_/RESET_B VDD VSS sg13g2_tiehi
XFILLER_7_609 VDD VSS sg13g2_decap_8
XFILLER_104_1222 VDD VSS sg13g2_decap_8
XFILLER_143_1271 VDD VSS sg13g2_decap_8
XFILLER_177_982 VDD VSS sg13g2_decap_8
XFILLER_52_1165 VDD VSS sg13g2_decap_8
X_14180__2022 _14180_/RESET_B VDD VSS sg13g2_tiehi
XFILLER_136_312 VDD VSS sg13g2_fill_2
XFILLER_13_1138 VDD VSS sg13g2_decap_8
XFILLER_149_695 VDD VSS sg13g2_fill_2
XFILLER_136_334 VDD VSS sg13g2_decap_8
XFILLER_87_1206 VDD VSS sg13g2_decap_8
XFILLER_137_868 VDD VSS sg13g2_fill_1
XFILLER_178_1334 VDD VSS sg13g2_decap_8
XFILLER_12_77 VDD VSS sg13g2_decap_8
XFILLER_164_665 VDD VSS sg13g2_fill_1
XFILLER_128_55 VDD VSS sg13g2_fill_2
X_09018_ _09019_/B _10702_/A _09030_/D _09017_/Y VDD VSS sg13g2_o21ai_1
X_10290_ _10292_/B _10281_/D _10298_/D _14791_/Q VDD VSS sg13g2_a21oi_1
XFILLER_3_837 VDD VSS sg13g2_decap_8
XFILLER_104_220 VDD VSS sg13g2_decap_8
XFILLER_137_1020 VDD VSS sg13g2_decap_8
XFILLER_2_336 VDD VSS sg13g2_decap_8
XFILLER_132_540 VDD VSS sg13g2_decap_8
XFILLER_120_724 VDD VSS sg13g2_decap_4
Xfanout640 _13508_/C _08828_/Y VDD VSS sg13g2_buf_1
Xfanout651 _08654_/B _07997_/Y VDD VSS sg13g2_buf_1
Xfanout662 _12749_/C1 _12777_/C1 VDD VSS sg13g2_buf_1
XFILLER_8_1453 VDD VSS sg13g2_decap_8
XFILLER_28_1392 VDD VSS sg13g2_decap_8
X_13980_ _13980_/Q clkload77/A _13980_/D _13980_/RESET_B VDD VSS sg13g2_dfrbpq_1
XFILLER_59_863 VDD VSS sg13g2_decap_4
Xfanout673 _13069_/C1 _13082_/B VDD VSS sg13g2_buf_1
Xfanout684 _11056_/B1 _07702_/X VDD VSS sg13g2_buf_1
Xclkbuf_leaf_42_clk_i clkload45/A clkbuf_leaf_42_clk_i/A VDD VSS sg13g2_buf_8
Xfanout695 _07684_/B _07683_/X VDD VSS sg13g2_buf_1
XFILLER_46_502 VDD VSS sg13g2_decap_4
XFILLER_24_1256 VDD VSS sg13g2_decap_8
X_12931_ _12931_/Y _14775_/Q _13030_/A2 _13030_/B1 VDD VSS sg13g2_o21ai_1
XFILLER_19_738 VDD VSS sg13g2_decap_8
XFILLER_20_1109 VDD VSS sg13g2_decap_8
X_14211__1991 _14211_/RESET_B VDD VSS sg13g2_tiehi
XFILLER_46_524 VDD VSS sg13g2_decap_8
XFILLER_98_1335 VDD VSS sg13g2_decap_8
XFILLER_85_170 VDD VSS sg13g2_decap_8
XFILLER_18_226 VDD VSS sg13g2_decap_4
XFILLER_85_181 VDD VSS sg13g2_fill_1
XFILLER_46_535 VDD VSS sg13g2_fill_2
XFILLER_37_63 VDD VSS sg13g2_fill_2
XFILLER_160_53 VDD VSS sg13g2_decap_8
XFILLER_185_1327 VDD VSS sg13g2_decap_8
X_12862_ _12862_/Y _14867_/Q _12895_/B VDD VSS sg13g2_nand2_1
XFILLER_27_760 VDD VSS sg13g2_decap_8
XFILLER_15_911 VDD VSS sg13g2_decap_8
XFILLER_15_922 VDD VSS sg13g2_fill_2
XFILLER_163_0 VDD VSS sg13g2_decap_8
X_14601_ _14601_/Q _14665_/CLK _14601_/D _14601_/RESET_B VDD VSS sg13g2_dfrbpq_1
X_11813_ _11813_/Y _11809_/Y _11810_/Y _11812_/Y _11811_/Y _11822_/B VDD VSS sg13g2_a221oi_1
XFILLER_73_387 VDD VSS sg13g2_fill_2
XFILLER_57_1010 VDD VSS sg13g2_fill_2
XFILLER_2_1085 VDD VSS sg13g2_decap_8
X_12793_ _12793_/Y _12997_/B _12936_/B VDD VSS sg13g2_nor2_1
XFILLER_26_270 VDD VSS sg13g2_decap_8
Xclkbuf_leaf_57_clk_i clkload74/A clkload4/A VDD VSS sg13g2_buf_8
XFILLER_183_1040 VDD VSS sg13g2_decap_8
X_14390__1812 _14390_/RESET_B VDD VSS sg13g2_tiehi
X_14532_ _14532_/Q _14724_/CLK _14532_/D _14532_/RESET_B VDD VSS sg13g2_dfrbpq_1
XFILLER_57_1054 VDD VSS sg13g2_decap_4
XFILLER_144_1013 VDD VSS sg13g2_fill_1
XFILLER_14_443 VDD VSS sg13g2_decap_8
X_11744_ _11745_/A _13738_/Q _14090_/Q _14442_/Q _14538_/Q _11899_/S0 _11366_/C VDD
+ VSS sg13g2_mux4_1
XFILLER_148_1193 VDD VSS sg13g2_decap_8
XFILLER_159_426 VDD VSS sg13g2_fill_2
XFILLER_109_1177 VDD VSS sg13g2_decap_8
XFILLER_159_459 VDD VSS sg13g2_fill_1
X_14463_ _14463_/Q _14495_/CLK _14463_/D _14463_/RESET_B VDD VSS sg13g2_dfrbpq_1
XFILLER_70_1210 VDD VSS sg13g2_decap_8
XFILLER_30_947 VDD VSS sg13g2_decap_8
XFILLER_109_1188 VDD VSS sg13g2_fill_2
XFILLER_186_245 VDD VSS sg13g2_decap_8
X_11675_ _11675_/Y _11678_/S0 _14632_/Q VDD VSS sg13g2_nand2b_1
XFILLER_35_1352 VDD VSS sg13g2_decap_8
XFILLER_128_802 VDD VSS sg13g2_decap_8
XFILLER_169_84 VDD VSS sg13g2_decap_8
X_13414_ _13414_/Y _13438_/B _13494_/B _13444_/B VDD VSS sg13g2_nor3_1
X_10626_ _14883_/D _10626_/A _10626_/B _10626_/C VDD VSS sg13g2_and3_1
XFILLER_167_470 VDD VSS sg13g2_decap_8
X_14394_ _14394_/Q clkload80/A _14394_/D _14394_/RESET_B VDD VSS sg13g2_dfrbpq_1
XFILLER_31_1216 VDD VSS sg13g2_decap_8
XFILLER_70_1287 VDD VSS sg13g2_decap_8
XFILLER_6_620 VDD VSS sg13g2_decap_8
X_13345_ _13345_/Y _13652_/S _13345_/B VDD VSS sg13g2_nand2_1
XFILLER_10_693 VDD VSS sg13g2_decap_8
X_10557_ _14867_/D _10557_/A _10557_/B _10557_/C VDD VSS sg13g2_and3_1
XFILLER_127_356 VDD VSS sg13g2_decap_8
XFILLER_128_879 VDD VSS sg13g2_decap_8
XFILLER_155_665 VDD VSS sg13g2_decap_8
XFILLER_143_827 VDD VSS sg13g2_decap_8
XFILLER_154_153 VDD VSS sg13g2_decap_8
XFILLER_182_462 VDD VSS sg13g2_decap_8
X_13276_ _13276_/Y _13273_/Y _13274_/Y _13275_/Y VDD VSS sg13g2_a21oi_1
X_10488_ _10490_/B _10492_/C _10508_/C _14850_/Q VDD VSS sg13g2_a21oi_1
XFILLER_6_697 VDD VSS sg13g2_decap_8
X_15015_ _15015_/Q clkload40/A _15015_/D _15015_/RESET_B VDD VSS sg13g2_dfrbpq_1
X_12227_ _12270_/A _12229_/A _12298_/B VDD VSS sg13g2_nor2_1
XFILLER_5_196 VDD VSS sg13g2_decap_8
XFILLER_170_668 VDD VSS sg13g2_fill_1
XFILLER_97_903 VDD VSS sg13g2_decap_4
XFILLER_155_1131 VDD VSS sg13g2_fill_1
XFILLER_9_1206 VDD VSS sg13g2_decap_8
XFILLER_123_551 VDD VSS sg13g2_fill_2
XFILLER_151_871 VDD VSS sg13g2_decap_8
X_13678__2539 _13678_/RESET_B VDD VSS sg13g2_tiehi
XFILLER_96_402 VDD VSS sg13g2_decap_8
XFILLER_69_616 VDD VSS sg13g2_decap_8
XFILLER_29_1156 VDD VSS sg13g2_decap_8
XFILLER_69_627 VDD VSS sg13g2_decap_8
X_14043__2159 _14043_/RESET_B VDD VSS sg13g2_tiehi
X_12158_ _12158_/Y _12168_/A _14166_/Q _12169_/C VDD VSS sg13g2_a21oi_1
XFILLER_151_1017 VDD VSS sg13g2_fill_1
XFILLER_97_958 VDD VSS sg13g2_decap_4
XFILLER_46_1470 VDD VSS sg13g2_decap_8
X_11109_ _11109_/Y _11109_/A _11109_/B VDD VSS sg13g2_nand2_1
XFILLER_110_245 VDD VSS sg13g2_decap_8
XFILLER_111_779 VDD VSS sg13g2_decap_8
X_12089_ _12091_/A _12090_/A _14196_/Q VDD VSS sg13g2_nand2b_1
XFILLER_42_1345 VDD VSS sg13g2_decap_8
XFILLER_110_278 VDD VSS sg13g2_decap_8
XFILLER_110_289 VDD VSS sg13g2_fill_1
X_14929__2709 _14929_/RESET_B VDD VSS sg13g2_tiehi
XFILLER_80_814 VDD VSS sg13g2_decap_8
XFILLER_25_719 VDD VSS sg13g2_decap_8
XFILLER_91_151 VDD VSS sg13g2_fill_2
XFILLER_127_1211 VDD VSS sg13g2_fill_2
X_08320_ _08366_/D _08420_/A _08418_/A VDD VSS sg13g2_nor2b_1
XFILLER_33_741 VDD VSS sg13g2_decap_8
XFILLER_178_713 VDD VSS sg13g2_decap_8
XFILLER_36_1105 VDD VSS sg13g2_fill_2
XFILLER_162_1113 VDD VSS sg13g2_decap_8
XFILLER_177_201 VDD VSS sg13g2_fill_1
XFILLER_162_1124 VDD VSS sg13g2_fill_2
XFILLER_177_212 VDD VSS sg13g2_decap_8
XFILLER_36_1138 VDD VSS sg13g2_decap_8
X_08251_ _15226_/D _08395_/A _08250_/X _08246_/Y VDD VSS sg13g2_o21ai_1
XFILLER_127_1277 VDD VSS sg13g2_fill_2
XFILLER_162_1157 VDD VSS sg13g2_decap_8
XFILLER_165_407 VDD VSS sg13g2_decap_8
XFILLER_32_295 VDD VSS sg13g2_fill_1
XFILLER_159_971 VDD VSS sg13g2_decap_8
XFILLER_20_446 VDD VSS sg13g2_fill_2
XFILLER_119_824 VDD VSS sg13g2_decap_8
XFILLER_177_289 VDD VSS sg13g2_decap_8
X_08182_ _08188_/C _08183_/B _08182_/B _08182_/C VDD VSS sg13g2_nor3_1
XFILLER_118_312 VDD VSS sg13g2_decap_8
XFILLER_119_835 VDD VSS sg13g2_fill_2
XFILLER_14_1436 VDD VSS sg13g2_decap_8
XFILLER_119_846 VDD VSS sg13g2_decap_8
XFILLER_140_1444 VDD VSS sg13g2_decap_8
XFILLER_146_665 VDD VSS sg13g2_fill_1
XFILLER_174_974 VDD VSS sg13g2_fill_1
X_14253__1949 _14253_/RESET_B VDD VSS sg13g2_tiehi
XFILLER_101_1439 VDD VSS sg13g2_decap_8
XFILLER_134_816 VDD VSS sg13g2_decap_8
XFILLER_118_367 VDD VSS sg13g2_fill_2
XFILLER_133_304 VDD VSS sg13g2_decap_8
XFILLER_145_164 VDD VSS sg13g2_fill_2
XFILLER_146_698 VDD VSS sg13g2_decap_4
XFILLER_160_123 VDD VSS sg13g2_decap_8
XFILLER_133_359 VDD VSS sg13g2_decap_8
XFILLER_161_679 VDD VSS sg13g2_decap_8
XFILLER_114_551 VDD VSS sg13g2_decap_8
XFILLER_114_562 VDD VSS sg13g2_fill_1
XFILLER_58_18 VDD VSS sg13g2_fill_1
XFILLER_173_1253 VDD VSS sg13g2_decap_8
XFILLER_99_262 VDD VSS sg13g2_fill_2
XFILLER_47_1256 VDD VSS sg13g2_decap_8
XFILLER_114_584 VDD VSS sg13g2_decap_4
XFILLER_141_370 VDD VSS sg13g2_decap_4
XFILLER_87_424 VDD VSS sg13g2_fill_1
XFILLER_114_595 VDD VSS sg13g2_decap_8
XFILLER_134_1237 VDD VSS sg13g2_fill_2
X_14019__2183 _14019_/RESET_B VDD VSS sg13g2_tiehi
XFILLER_88_969 VDD VSS sg13g2_fill_1
XFILLER_87_446 VDD VSS sg13g2_decap_8
XFILLER_134_1259 VDD VSS sg13g2_decap_8
X_07966_ _07966_/Y _15015_/Q _07853_/B VDD VSS sg13g2_nor2b_1
XFILLER_75_608 VDD VSS sg13g2_decap_8
XFILLER_60_1434 VDD VSS sg13g2_decap_8
XFILLER_68_660 VDD VSS sg13g2_decap_8
XFILLER_101_278 VDD VSS sg13g2_fill_1
XFILLER_21_1407 VDD VSS sg13g2_decap_8
X_09705_ _14297_/D _09903_/A0 _14297_/Q _09706_/S VDD VSS sg13g2_mux2_1
XFILLER_96_991 VDD VSS sg13g2_decap_8
X_07897_ _08037_/B _08009_/S _13601_/A VDD VSS sg13g2_nand2_1
XFILLER_67_181 VDD VSS sg13g2_decap_8
X_09636_ _14232_/D _09935_/A1 _14232_/Q _09637_/S VDD VSS sg13g2_mux2_1
XFILLER_56_866 VDD VSS sg13g2_decap_8
X_14198__2004 _14198_/RESET_B VDD VSS sg13g2_tiehi
XFILLER_71_803 VDD VSS sg13g2_decap_4
XFILLER_28_568 VDD VSS sg13g2_decap_8
XFILLER_167_1046 VDD VSS sg13g2_decap_8
XFILLER_82_173 VDD VSS sg13g2_decap_8
XFILLER_55_387 VDD VSS sg13g2_decap_8
XFILLER_3_1383 VDD VSS sg13g2_decap_8
X_09567_ _14165_/D _10164_/A1 _14165_/Q _09571_/S VDD VSS sg13g2_mux2_1
XFILLER_19_1303 VDD VSS sg13g2_decap_8
XFILLER_24_730 VDD VSS sg13g2_decap_4
X_08518_ _08526_/C _08659_/A _08197_/X _08652_/B1 VDD VSS sg13g2_o21ai_1
XFILLER_93_1254 VDD VSS sg13g2_decap_4
XFILLER_130_67 VDD VSS sg13g2_decap_8
X_09498_ _14098_/D _10094_/A0 _14098_/Q _09505_/S VDD VSS sg13g2_mux2_1
XFILLER_58_1385 VDD VSS sg13g2_decap_8
XFILLER_180_1224 VDD VSS sg13g2_decap_8
XFILLER_54_1227 VDD VSS sg13g2_decap_8
XFILLER_12_925 VDD VSS sg13g2_decap_8
XFILLER_24_785 VDD VSS sg13g2_fill_1
XFILLER_168_234 VDD VSS sg13g2_decap_8
XFILLER_51_582 VDD VSS sg13g2_fill_1
XFILLER_11_424 VDD VSS sg13g2_decap_8
XFILLER_141_1208 VDD VSS sg13g2_fill_2
X_08449_ _08449_/Y _08448_/Y _07948_/A _08039_/A VDD VSS sg13g2_a21oi_1
XFILLER_23_32 VDD VSS sg13g2_decap_8
XFILLER_8_907 VDD VSS sg13g2_decap_8
XFILLER_51_593 VDD VSS sg13g2_fill_1
XFILLER_135_4 VDD VSS sg13g2_decap_4
XFILLER_7_406 VDD VSS sg13g2_decap_8
X_11460_ _14962_/D _07909_/B _11978_/B1 _11459_/Y VDD VSS sg13g2_a21oi_1
XFILLER_137_610 VDD VSS sg13g2_decap_8
XFILLER_184_749 VDD VSS sg13g2_decap_8
XFILLER_109_312 VDD VSS sg13g2_fill_1
XFILLER_104_1041 VDD VSS sg13g2_decap_8
XFILLER_143_1090 VDD VSS sg13g2_fill_2
X_10411_ _14826_/D _10413_/B _10414_/D _10407_/Y _07648_/Y _10623_/A VDD VSS sg13g2_a221oi_1
X_11391_ _11391_/Y _11391_/A _11391_/B VDD VSS sg13g2_nand2_1
XFILLER_136_142 VDD VSS sg13g2_decap_8
XFILLER_178_1131 VDD VSS sg13g2_decap_8
XFILLER_87_1025 VDD VSS sg13g2_decap_8
X_13130_ _13170_/B _14915_/Q _13672_/Q VDD VSS sg13g2_xnor2_1
X_14229__1973 _14229_/RESET_B VDD VSS sg13g2_tiehi
XFILLER_99_58 VDD VSS sg13g2_decap_8
X_10342_ _10343_/B _10342_/A _14807_/Q _10342_/C _10357_/D VDD VSS sg13g2_nand4_1
XFILLER_118_890 VDD VSS sg13g2_decap_8
XFILLER_152_635 VDD VSS sg13g2_decap_8
XFILLER_164_495 VDD VSS sg13g2_fill_1
XFILLER_124_337 VDD VSS sg13g2_fill_1
XFILLER_3_634 VDD VSS sg13g2_decap_8
XFILLER_30_1293 VDD VSS sg13g2_decap_8
XFILLER_152_657 VDD VSS sg13g2_decap_8
XFILLER_151_134 VDD VSS sg13g2_decap_8
X_13061_ _13063_/B _13026_/A _13058_/B _13060_/Y VDD VSS sg13g2_a21oi_1
XFILLER_65_1312 VDD VSS sg13g2_decap_8
XFILLER_155_53 VDD VSS sg13g2_decap_8
X_10273_ _14785_/D _10299_/A _10299_/B _10271_/Y VDD VSS sg13g2_a21oi_1
XFILLER_2_133 VDD VSS sg13g2_decap_8
XFILLER_133_860 VDD VSS sg13g2_fill_1
XFILLER_180_988 VDD VSS sg13g2_decap_8
XFILLER_156_1462 VDD VSS sg13g2_decap_8
X_12012_ _12012_/X _12012_/A _12055_/D VDD VSS sg13g2_and2_1
XFILLER_156_1473 VDD VSS sg13g2_fill_2
Xfanout1402 _10487_/A _10490_/A VDD VSS sg13g2_buf_1
Xfanout1413 fanout1413/X _07625_/Y VDD VSS sg13g2_buf_1
XFILLER_65_1389 VDD VSS sg13g2_decap_8
Xfanout1424 _10444_/C _13499_/B VDD VSS sg13g2_buf_1
Xfanout1435 _10630_/C _10423_/C VDD VSS sg13g2_buf_1
XFILLER_94_917 VDD VSS sg13g2_decap_8
XFILLER_8_1250 VDD VSS sg13g2_decap_8
XFILLER_78_479 VDD VSS sg13g2_decap_4
Xfanout470 _09467_/S fanout474/X VDD VSS sg13g2_buf_1
Xfanout481 _09364_/S _09368_/S VDD VSS sg13g2_buf_1
XFILLER_63_1091 VDD VSS sg13g2_fill_1
XFILLER_24_1042 VDD VSS sg13g2_fill_1
XFILLER_24_1053 VDD VSS sg13g2_decap_8
XFILLER_171_63 VDD VSS sg13g2_decap_8
Xfanout492 _09227_/S _09206_/X VDD VSS sg13g2_buf_1
X_13963_ _13963_/Q clkload13/A _13963_/D _13963_/RESET_B VDD VSS sg13g2_dfrbpq_1
XFILLER_0_14 VDD VSS sg13g2_decap_8
XFILLER_46_321 VDD VSS sg13g2_decap_8
XFILLER_19_557 VDD VSS sg13g2_decap_8
X_12914_ _12914_/Y _12914_/A _12914_/B _12914_/C VDD VSS sg13g2_nor3_1
XFILLER_4_1169 VDD VSS sg13g2_decap_8
XFILLER_47_877 VDD VSS sg13g2_fill_1
X_13894_ _13894_/Q clkload51/A _13894_/D _13894_/RESET_B VDD VSS sg13g2_dfrbpq_1
XFILLER_73_140 VDD VSS sg13g2_decap_8
XFILLER_185_1124 VDD VSS sg13g2_decap_8
XFILLER_46_365 VDD VSS sg13g2_fill_1
XFILLER_74_685 VDD VSS sg13g2_fill_1
XFILLER_62_825 VDD VSS sg13g2_decap_8
X_12845_ _12845_/Y _12845_/A _12845_/B _12845_/C _12845_/D VDD VSS sg13g2_nand4_1
X_13717__2485 _13717_/RESET_B VDD VSS sg13g2_tiehi
XFILLER_61_346 VDD VSS sg13g2_decap_8
XFILLER_163_1422 VDD VSS sg13g2_decap_8
X_12776_ _12776_/X _12774_/X _12775_/X _12776_/S VDD VSS sg13g2_mux2_1
XFILLER_30_700 VDD VSS sg13g2_decap_8
XFILLER_42_571 VDD VSS sg13g2_decap_8
X_14515_ _14515_/Q _14546_/CLK _14515_/D _14515_/RESET_B VDD VSS sg13g2_dfrbpq_1
X_11727_ _11728_/B _11707_/A _11773_/C _11705_/Y VDD VSS sg13g2_o21ai_1
XFILLER_72_1349 VDD VSS sg13g2_decap_8
XFILLER_37_1469 VDD VSS sg13g2_decap_8
XFILLER_30_722 VDD VSS sg13g2_decap_8
XFILLER_14_284 VDD VSS sg13g2_decap_8
XFILLER_9_56 VDD VSS sg13g2_decap_8
X_13896__2306 _13896_/RESET_B VDD VSS sg13g2_tiehi
X_14446_ _14446_/Q clkload55/A _14446_/D _14446_/RESET_B VDD VSS sg13g2_dfrbpq_1
X_11658_ _14969_/D _11635_/A _11723_/A2 _11657_/Y VDD VSS sg13g2_a21o_1
XFILLER_122_1130 VDD VSS sg13g2_decap_8
XFILLER_168_790 VDD VSS sg13g2_fill_1
XFILLER_122_1141 VDD VSS sg13g2_fill_1
X_13932__2270 _13932_/RESET_B VDD VSS sg13g2_tiehi
X_10609_ _10611_/C _14879_/Q _10614_/A VDD VSS sg13g2_nand2b_1
X_14377_ _14377_/Q clkload30/A _14377_/D _14377_/RESET_B VDD VSS sg13g2_dfrbpq_1
X_11589_ _11632_/A _11591_/A _11934_/B VDD VSS sg13g2_nor2_1
XFILLER_10_490 VDD VSS sg13g2_decap_8
XFILLER_156_985 VDD VSS sg13g2_fill_2
XFILLER_171_911 VDD VSS sg13g2_decap_4
XFILLER_7_973 VDD VSS sg13g2_decap_8
XFILLER_31_1079 VDD VSS sg13g2_decap_4
XFILLER_157_1204 VDD VSS sg13g2_decap_8
X_13328_ _15067_/D _13328_/A _13328_/B VDD VSS sg13g2_nor2_1
XFILLER_143_624 VDD VSS sg13g2_fill_2
XFILLER_171_933 VDD VSS sg13g2_decap_8
XFILLER_182_270 VDD VSS sg13g2_decap_8
XFILLER_155_495 VDD VSS sg13g2_decap_8
XFILLER_50_4 VDD VSS sg13g2_decap_8
XFILLER_100_1450 VDD VSS sg13g2_decap_8
XFILLER_6_494 VDD VSS sg13g2_decap_8
XFILLER_157_1259 VDD VSS sg13g2_decap_8
X_13259_ _13259_/Y _13259_/A _13259_/B VDD VSS sg13g2_xnor2_1
XFILLER_124_871 VDD VSS sg13g2_decap_8
XFILLER_83_1445 VDD VSS sg13g2_decap_8
XFILLER_69_402 VDD VSS sg13g2_fill_2
XFILLER_142_178 VDD VSS sg13g2_decap_8
XFILLER_9_1036 VDD VSS sg13g2_decap_8
XFILLER_97_733 VDD VSS sg13g2_decap_8
XFILLER_123_381 VDD VSS sg13g2_fill_1
X_07820_ _07820_/X _15009_/Q _07820_/B VDD VSS sg13g2_or2_1
XFILLER_97_766 VDD VSS sg13g2_decap_8
X_15241__3032 _15241_/RESET_B VDD VSS sg13g2_tiehi
XFILLER_69_468 VDD VSS sg13g2_decap_8
XFILLER_170_1459 VDD VSS sg13g2_decap_8
X_15136__2708 _15136_/RESET_B VDD VSS sg13g2_tiehi
XFILLER_42_1142 VDD VSS sg13g2_decap_8
X_07751_ _07751_/Y _07753_/D _07751_/B VDD VSS sg13g2_nand2_1
XFILLER_133_1292 VDD VSS sg13g2_decap_4
XFILLER_168_1300 VDD VSS sg13g2_decap_8
X_07682_ _07682_/Y _13289_/B _13289_/C VDD VSS sg13g2_nor2_1
XFILLER_65_674 VDD VSS sg13g2_fill_1
XFILLER_37_376 VDD VSS sg13g2_decap_8
X_09421_ _14023_/D _10150_/A1 _14023_/Q _09430_/S VDD VSS sg13g2_mux2_1
XFILLER_80_611 VDD VSS sg13g2_decap_8
XFILLER_20_1473 VDD VSS sg13g2_decap_4
XFILLER_129_1328 VDD VSS sg13g2_fill_1
XFILLER_168_1377 VDD VSS sg13g2_decap_8
XFILLER_18_590 VDD VSS sg13g2_decap_8
XFILLER_53_869 VDD VSS sg13g2_fill_1
X_14307__1895 _14307_/RESET_B VDD VSS sg13g2_tiehi
X_09352_ _13956_/D _09583_/A1 _13956_/Q _09368_/S VDD VSS sg13g2_mux2_1
XFILLER_40_508 VDD VSS sg13g2_decap_8
XFILLER_178_521 VDD VSS sg13g2_decap_8
XFILLER_21_700 VDD VSS sg13g2_fill_1
XFILLER_166_1090 VDD VSS sg13g2_decap_8
X_08303_ _08303_/Y _08306_/C _08306_/B VDD VSS sg13g2_nor2_1
XFILLER_127_1052 VDD VSS sg13g2_decap_8
X_09283_ _13891_/D _13891_/Q _10146_/A1 _09296_/S VDD VSS sg13g2_mux2_1
X_08234_ _08234_/Y _08377_/B _08234_/B VDD VSS sg13g2_nor2_1
XFILLER_138_429 VDD VSS sg13g2_decap_8
XFILLER_21_788 VDD VSS sg13g2_decap_8
X_14486__1716 _14486_/RESET_B VDD VSS sg13g2_tiehi
XFILLER_14_1233 VDD VSS sg13g2_decap_8
XFILLER_21_799 VDD VSS sg13g2_fill_1
XFILLER_119_632 VDD VSS sg13g2_decap_8
XFILLER_147_941 VDD VSS sg13g2_fill_2
XFILLER_53_1293 VDD VSS sg13g2_decap_8
XFILLER_181_708 VDD VSS sg13g2_fill_2
X_14522__1680 _14522_/RESET_B VDD VSS sg13g2_tiehi
X_08165_ _08166_/A _07871_/X _08163_/Y _08164_/Y VDD VSS sg13g2_o21ai_1
XFILLER_88_1312 VDD VSS sg13g2_decap_8
XFILLER_109_13 VDD VSS sg13g2_fill_1
XFILLER_119_665 VDD VSS sg13g2_decap_8
XFILLER_162_900 VDD VSS sg13g2_decap_4
XFILLER_105_1394 VDD VSS sg13g2_decap_8
XFILLER_109_46 VDD VSS sg13g2_decap_8
XFILLER_107_849 VDD VSS sg13g2_decap_8
XFILLER_161_410 VDD VSS sg13g2_decap_8
X_08096_ _08096_/X _08199_/C _08198_/S VDD VSS sg13g2_and2_1
XFILLER_118_186 VDD VSS sg13g2_decap_8
XFILLER_162_955 VDD VSS sg13g2_decap_8
X_14776__2960 _14776_/RESET_B VDD VSS sg13g2_tiehi
Xclkload80 clkload80/Y clkload80/A VDD VSS sg13g2_inv_4
XFILLER_115_871 VDD VSS sg13g2_decap_8
XFILLER_133_178 VDD VSS sg13g2_decap_8
XFILLER_161_487 VDD VSS sg13g2_decap_8
XFILLER_88_733 VDD VSS sg13g2_decap_8
XFILLER_0_637 VDD VSS sg13g2_decap_8
XFILLER_130_841 VDD VSS sg13g2_decap_8
XFILLER_138_1192 VDD VSS sg13g2_decap_8
XFILLER_47_1086 VDD VSS sg13g2_decap_8
X_08998_ _08998_/X _15027_/Q _15224_/Q _09027_/S VDD VSS sg13g2_mux2_1
XFILLER_60_1231 VDD VSS sg13g2_decap_8
XFILLER_87_287 VDD VSS sg13g2_decap_8
XFILLER_25_1362 VDD VSS sg13g2_decap_8
XFILLER_21_1204 VDD VSS sg13g2_decap_8
X_07949_ _07950_/C _13555_/A _07949_/B _07949_/C VDD VSS sg13g2_nand3b_1
XFILLER_151_1381 VDD VSS sg13g2_decap_8
XFILLER_99_1430 VDD VSS sg13g2_decap_8
XFILLER_75_449 VDD VSS sg13g2_decap_4
XFILLER_18_32 VDD VSS sg13g2_decap_8
XFILLER_5_1456 VDD VSS sg13g2_decap_8
XFILLER_84_950 VDD VSS sg13g2_decap_8
XFILLER_56_641 VDD VSS sg13g2_decap_8
XFILLER_112_1354 VDD VSS sg13g2_decap_8
XFILLER_1_1309 VDD VSS sg13g2_decap_8
X_13974__2228 _13974_/RESET_B VDD VSS sg13g2_tiehi
X_10960_ _10978_/A _14759_/Q _11015_/C VDD VSS sg13g2_nor2_1
XFILLER_99_1474 VDD VSS sg13g2_fill_1
XFILLER_29_877 VDD VSS sg13g2_decap_8
XFILLER_71_600 VDD VSS sg13g2_decap_8
XFILLER_55_151 VDD VSS sg13g2_decap_8
XFILLER_56_685 VDD VSS sg13g2_decap_8
XFILLER_186_1455 VDD VSS sg13g2_decap_8
X_09619_ _14215_/D _09720_/A0 _14215_/Q _09632_/S VDD VSS sg13g2_mux2_1
XFILLER_3_1180 VDD VSS sg13g2_decap_8
X_10891_ _10893_/A _10865_/Y _10841_/Y _10890_/Y VDD VSS sg13g2_o21ai_1
XFILLER_19_1100 VDD VSS sg13g2_decap_8
X_12630_ _12630_/X _14575_/Q _14607_/Q _14639_/Q _14671_/Q _12686_/S0 _12686_/S1 VDD
+ VSS sg13g2_mux4_1
XFILLER_71_666 VDD VSS sg13g2_decap_4
XFILLER_43_368 VDD VSS sg13g2_decap_8
XFILLER_93_1051 VDD VSS sg13g2_decap_4
XFILLER_58_1182 VDD VSS sg13g2_decap_8
XFILLER_12_733 VDD VSS sg13g2_fill_1
X_12561_ _12561_/X _14570_/Q _14602_/Q _14634_/Q _14666_/Q _12616_/S0 _12616_/S1 VDD
+ VSS sg13g2_mux4_1
XFILLER_24_593 VDD VSS sg13g2_decap_8
XFILLER_11_221 VDD VSS sg13g2_decap_8
XFILLER_19_1177 VDD VSS sg13g2_decap_8
XFILLER_15_1019 VDD VSS sg13g2_decap_8
XFILLER_8_704 VDD VSS sg13g2_decap_8
XFILLER_54_1068 VDD VSS sg13g2_decap_8
XFILLER_129_418 VDD VSS sg13g2_fill_1
XFILLER_184_513 VDD VSS sg13g2_decap_8
X_14300_ _14300_/Q _14588_/CLK _14300_/D _14300_/RESET_B VDD VSS sg13g2_dfrbpq_1
X_11512_ _11512_/X _13731_/Q _14083_/Q _14435_/Q _14531_/Q _11514_/S0 _11514_/S1 VDD
+ VSS sg13g2_mux4_1
XFILLER_54_1079 VDD VSS sg13g2_decap_8
XFILLER_184_524 VDD VSS sg13g2_decap_8
X_12492_ _12492_/X _13733_/Q _14085_/Q _14437_/Q _14533_/Q _12494_/S0 _12494_/S1 VDD
+ VSS sg13g2_mux4_1
XFILLER_7_203 VDD VSS sg13g2_decap_8
XFILLER_180_1098 VDD VSS sg13g2_decap_8
X_14231_ _14231_/Q clkload43/A _14231_/D _14231_/RESET_B VDD VSS sg13g2_dfrbpq_1
XFILLER_32_1344 VDD VSS sg13g2_decap_8
XFILLER_11_298 VDD VSS sg13g2_decap_8
X_11443_ _11446_/B _11443_/A _11443_/B VDD VSS sg13g2_nor2_1
X_14162_ _14162_/Q clkload40/A _14162_/D _14162_/RESET_B VDD VSS sg13g2_dfrbpq_1
XFILLER_4_910 VDD VSS sg13g2_decap_8
XFILLER_166_63 VDD VSS sg13g2_decap_8
X_11374_ _11374_/Y _11374_/A _11374_/B _11374_/C VDD VSS sg13g2_nand3_1
XFILLER_125_646 VDD VSS sg13g2_decap_8
X_13113_ _13113_/X _13172_/A _13172_/B _13172_/C VDD VSS sg13g2_and3_1
X_10325_ _14801_/D _10325_/A _10325_/B _10337_/C VDD VSS sg13g2_and3_1
XFILLER_3_431 VDD VSS sg13g2_decap_8
X_14093_ _14093_/Q clkload18/A _14093_/D _14093_/RESET_B VDD VSS sg13g2_dfrbpq_1
XFILLER_124_156 VDD VSS sg13g2_decap_8
XFILLER_152_465 VDD VSS sg13g2_fill_2
XFILLER_180_774 VDD VSS sg13g2_decap_8
XFILLER_153_999 VDD VSS sg13g2_fill_2
XFILLER_4_987 VDD VSS sg13g2_decap_8
X_13044_ _13044_/Y input28/X _13609_/A _12997_/B VDD VSS sg13g2_o21ai_1
XFILLER_106_893 VDD VSS sg13g2_decap_8
XFILLER_117_1221 VDD VSS sg13g2_decap_4
X_10256_ _14780_/D _10256_/A _10265_/D _10343_/C VDD VSS sg13g2_and3_1
XFILLER_26_1104 VDD VSS sg13g2_fill_1
Xfanout1210 _13064_/A _14910_/Q VDD VSS sg13g2_buf_1
Xfanout1221 _13218_/A _14858_/Q VDD VSS sg13g2_buf_1
XFILLER_65_1186 VDD VSS sg13g2_decap_8
XFILLER_26_1137 VDD VSS sg13g2_decap_8
Xfanout1232 _11202_/A _10206_/A1 VDD VSS sg13g2_buf_1
XFILLER_79_777 VDD VSS sg13g2_decap_8
XFILLER_67_917 VDD VSS sg13g2_decap_4
X_10187_ _15194_/D input21/X _15194_/Q _10195_/S VDD VSS sg13g2_mux2_1
Xfanout1243 _11956_/B1 _11974_/B1 VDD VSS sg13g2_buf_1
XFILLER_120_362 VDD VSS sg13g2_decap_8
XFILLER_121_896 VDD VSS sg13g2_decap_8
XFILLER_182_95 VDD VSS sg13g2_decap_8
Xfanout1254 _12334_/C fanout1255/X VDD VSS sg13g2_buf_1
Xfanout1265 _11971_/C _11351_/C1 VDD VSS sg13g2_buf_1
Xfanout1276 _11514_/S1 fanout1280/X VDD VSS sg13g2_buf_1
XFILLER_66_438 VDD VSS sg13g2_fill_2
XFILLER_43_1462 VDD VSS sg13g2_decap_8
XFILLER_15_7 VDD VSS sg13g2_decap_8
Xfanout1287 _12103_/B1 _11444_/S1 VDD VSS sg13g2_buf_1
XFILLER_43_1473 VDD VSS sg13g2_fill_2
X_14995_ _14995_/Q clkload31/A _14995_/D _14995_/RESET_B VDD VSS sg13g2_dfrbpq_1
XFILLER_93_235 VDD VSS sg13g2_decap_8
XFILLER_59_490 VDD VSS sg13g2_decap_8
Xfanout1298 fanout1298/X _11368_/S1 VDD VSS sg13g2_buf_1
XFILLER_130_1454 VDD VSS sg13g2_decap_8
X_13946_ _13946_/Q clkload80/A _13946_/D _13946_/RESET_B VDD VSS sg13g2_dfrbpq_1
X_14564__1638 _14564_/RESET_B VDD VSS sg13g2_tiehi
XFILLER_19_376 VDD VSS sg13g2_decap_8
XFILLER_74_471 VDD VSS sg13g2_decap_8
XFILLER_62_611 VDD VSS sg13g2_decap_8
X_13877_ _13877_/Q clkload36/A _13877_/D _13877_/RESET_B VDD VSS sg13g2_dfrbpq_1
XFILLER_179_307 VDD VSS sg13g2_decap_8
X_12828_ _12828_/Y _12828_/A _12828_/B VDD VSS sg13g2_nand2_1
XFILLER_90_997 VDD VSS sg13g2_decap_8
XFILLER_76_1282 VDD VSS sg13g2_decap_8
XFILLER_128_1361 VDD VSS sg13g2_decap_8
XFILLER_61_198 VDD VSS sg13g2_decap_8
X_12759_ _12759_/X _13976_/Q _14008_/Q _14040_/Q _14072_/Q _12759_/S0 _12759_/S1 VDD
+ VSS sg13g2_mux4_1
XFILLER_72_1146 VDD VSS sg13g2_decap_8
XFILLER_37_1266 VDD VSS sg13g2_decap_8
XFILLER_128_1394 VDD VSS sg13g2_decap_8
XFILLER_124_1247 VDD VSS sg13g2_decap_4
XFILLER_163_1296 VDD VSS sg13g2_decap_8
XFILLER_50_1400 VDD VSS sg13g2_decap_8
XFILLER_129_941 VDD VSS sg13g2_fill_2
X_14429_ _14429_/Q clkload29/A _14429_/D _14429_/RESET_B VDD VSS sg13g2_dfrbpq_1
XFILLER_175_579 VDD VSS sg13g2_decap_8
XFILLER_7_770 VDD VSS sg13g2_decap_8
XFILLER_156_793 VDD VSS sg13g2_decap_8
XFILLER_6_291 VDD VSS sg13g2_decap_8
X_09970_ _14554_/D _14554_/Q _10102_/A0 _09970_/S VDD VSS sg13g2_mux2_1
XFILLER_144_999 VDD VSS sg13g2_decap_8
XFILLER_41_0 VDD VSS sg13g2_decap_8
XFILLER_118_1029 VDD VSS sg13g2_decap_8
X_08921_ _08921_/X _15043_/Q _14947_/Q _10752_/A VDD VSS sg13g2_mux2_1
XFILLER_83_1242 VDD VSS sg13g2_decap_8
XFILLER_135_1321 VDD VSS sg13g2_decap_8
XFILLER_130_137 VDD VSS sg13g2_decap_8
XFILLER_48_1384 VDD VSS sg13g2_decap_8
XFILLER_174_1392 VDD VSS sg13g2_decap_8
XFILLER_112_863 VDD VSS sg13g2_fill_2
X_08852_ _08852_/Y _08852_/A _14930_/Q VDD VSS sg13g2_nor2b_1
XFILLER_111_351 VDD VSS sg13g2_decap_4
XFILLER_170_1256 VDD VSS sg13g2_decap_8
XFILLER_97_574 VDD VSS sg13g2_fill_2
XFILLER_85_714 VDD VSS sg13g2_decap_8
XFILLER_135_1387 VDD VSS sg13g2_decap_4
X_07803_ _08481_/A _07950_/A _07949_/B VDD VSS sg13g2_and2_1
XFILLER_111_384 VDD VSS sg13g2_decap_8
X_08783_ _13679_/D _08728_/Y _08782_/Y _08781_/Y VDD VSS sg13g2_a21oi_1
X_07734_ _07735_/D _07742_/B _07734_/B _07734_/C VDD VSS sg13g2_nand3_1
XFILLER_66_983 VDD VSS sg13g2_decap_4
XFILLER_38_696 VDD VSS sg13g2_fill_1
XFILLER_81_931 VDD VSS sg13g2_decap_8
X_07665_ _07665_/X _13508_/B _13477_/S VDD VSS sg13g2_or2_1
XFILLER_0_1331 VDD VSS sg13g2_decap_8
XFILLER_168_1174 VDD VSS sg13g2_decap_8
XFILLER_20_1270 VDD VSS sg13g2_decap_8
XFILLER_25_346 VDD VSS sg13g2_decap_8
XFILLER_111_36 VDD VSS sg13g2_decap_8
X_09404_ _14007_/D _09635_/A0 _14007_/Q _09405_/S VDD VSS sg13g2_mux2_1
XFILLER_80_441 VDD VSS sg13g2_decap_8
XFILLER_55_1300 VDD VSS sg13g2_decap_8
XFILLER_13_508 VDD VSS sg13g2_decap_8
XFILLER_179_830 VDD VSS sg13g2_fill_2
XFILLER_94_1371 VDD VSS sg13g2_decap_8
XFILLER_90_1202 VDD VSS sg13g2_decap_4
XFILLER_181_1330 VDD VSS sg13g2_decap_8
X_09335_ _13942_/D _09933_/A1 _13942_/Q _09339_/S VDD VSS sg13g2_mux2_1
XFILLER_34_891 VDD VSS sg13g2_decap_8
XFILLER_179_874 VDD VSS sg13g2_decap_4
XFILLER_21_530 VDD VSS sg13g2_fill_2
XFILLER_107_1445 VDD VSS sg13g2_decap_8
XFILLER_55_1377 VDD VSS sg13g2_decap_8
XFILLER_138_204 VDD VSS sg13g2_decap_8
XFILLER_166_513 VDD VSS sg13g2_decap_8
XFILLER_142_1347 VDD VSS sg13g2_decap_8
X_09266_ _13875_/D _13875_/Q _09963_/A1 _09272_/S VDD VSS sg13g2_mux2_1
XFILLER_138_248 VDD VSS sg13g2_decap_8
XFILLER_14_1030 VDD VSS sg13g2_decap_8
X_08217_ _08217_/X _08544_/A _08234_/B VDD VSS sg13g2_and2_1
X_09197_ _13813_/D _13813_/Q _09899_/A0 _09200_/S VDD VSS sg13g2_mux2_1
XFILLER_5_707 VDD VSS sg13g2_decap_8
XFILLER_105_1180 VDD VSS sg13g2_fill_2
XFILLER_147_760 VDD VSS sg13g2_fill_1
XFILLER_135_911 VDD VSS sg13g2_decap_8
XFILLER_88_1120 VDD VSS sg13g2_decap_8
XFILLER_135_922 VDD VSS sg13g2_fill_2
XFILLER_147_782 VDD VSS sg13g2_decap_8
XFILLER_119_484 VDD VSS sg13g2_decap_8
X_08148_ _08688_/A _08242_/A _08599_/B VDD VSS sg13g2_nand2_1
XFILLER_4_217 VDD VSS sg13g2_decap_8
XFILLER_140_1093 VDD VSS sg13g2_fill_1
XFILLER_49_1104 VDD VSS sg13g2_fill_1
XFILLER_179_1281 VDD VSS sg13g2_decap_8
XFILLER_106_145 VDD VSS sg13g2_decap_4
XFILLER_162_763 VDD VSS sg13g2_decap_8
X_08079_ _08079_/X _08397_/B _08009_/X _08079_/S VDD VSS sg13g2_mux2_1
XFILLER_84_1028 VDD VSS sg13g2_decap_8
XFILLER_20_77 VDD VSS sg13g2_decap_8
XFILLER_150_925 VDD VSS sg13g2_decap_8
XFILLER_134_487 VDD VSS sg13g2_decap_8
XFILLER_150_936 VDD VSS sg13g2_fill_1
XFILLER_175_1167 VDD VSS sg13g2_decap_8
XFILLER_1_924 VDD VSS sg13g2_decap_8
X_10110_ _14688_/D _10110_/A0 _14688_/Q _10123_/S VDD VSS sg13g2_mux2_1
XFILLER_122_649 VDD VSS sg13g2_fill_2
X_11090_ _11092_/A _11086_/A _10754_/X _11088_/A _11087_/X _11058_/Y VDD VSS sg13g2_a221oi_1
XFILLER_115_690 VDD VSS sg13g2_fill_1
XFILLER_153_1421 VDD VSS sg13g2_decap_8
XFILLER_66_1473 VDD VSS sg13g2_decap_4
XFILLER_0_434 VDD VSS sg13g2_decap_8
XFILLER_27_1446 VDD VSS sg13g2_decap_8
X_10041_ _14622_/D _10074_/A0 _14622_/Q _10063_/S VDD VSS sg13g2_mux2_1
XFILLER_114_1405 VDD VSS sg13g2_decap_8
XFILLER_76_714 VDD VSS sg13g2_decap_8
XFILLER_62_1348 VDD VSS sg13g2_decap_8
XFILLER_103_885 VDD VSS sg13g2_decap_8
XFILLER_76_747 VDD VSS sg13g2_decap_8
XFILLER_5_1253 VDD VSS sg13g2_decap_8
X_13800_ _13800_/Q clkload21/A _13800_/D _13800_/RESET_B VDD VSS sg13g2_dfrbpq_1
XFILLER_152_87 VDD VSS sg13g2_decap_8
XFILLER_1_1106 VDD VSS sg13g2_decap_8
X_14780_ _14780_/Q _15185_/CLK _14780_/D _14780_/RESET_B VDD VSS sg13g2_dfrbpq_1
X_11992_ _11992_/X _14385_/Q _14417_/Q _14481_/Q _14513_/Q _11997_/S0 _11997_/S1 VDD
+ VSS sg13g2_mux4_1
XFILLER_112_1173 VDD VSS sg13g2_decap_8
XFILLER_95_1113 VDD VSS sg13g2_decap_8
XFILLER_44_611 VDD VSS sg13g2_decap_8
XFILLER_72_931 VDD VSS sg13g2_decap_8
X_13731_ _13731_/Q _14723_/CLK _13731_/D _13731_/RESET_B VDD VSS sg13g2_dfrbpq_1
X_10943_ _11004_/A _14758_/Q _10954_/C VDD VSS sg13g2_xnor2_1
XFILLER_186_1252 VDD VSS sg13g2_decap_8
XFILLER_43_110 VDD VSS sg13g2_decap_8
XFILLER_17_869 VDD VSS sg13g2_decap_4
XFILLER_83_290 VDD VSS sg13g2_decap_4
XFILLER_182_1138 VDD VSS sg13g2_decap_8
X_13662_ _13662_/Q _15052_/CLK _13662_/D _13662_/RESET_B VDD VSS sg13g2_dfrbpq_1
X_10874_ _14932_/D _10873_/Y _10872_/Y _10862_/Y VDD VSS sg13g2_o21ai_1
XFILLER_44_699 VDD VSS sg13g2_fill_2
XFILLER_31_316 VDD VSS sg13g2_decap_8
X_12613_ _12613_/X _14126_/Q _14158_/Q _14190_/Q _14222_/Q _12616_/S0 _12616_/S1 VDD
+ VSS sg13g2_mux4_1
XFILLER_73_1444 VDD VSS sg13g2_decap_8
X_13593_ _13593_/Y _15163_/Q _13593_/B VDD VSS sg13g2_nor2_1
XFILLER_31_349 VDD VSS sg13g2_decap_8
XFILLER_24_390 VDD VSS sg13g2_decap_8
XFILLER_40_850 VDD VSS sg13g2_decap_8
XFILLER_185_822 VDD VSS sg13g2_decap_8
XFILLER_8_501 VDD VSS sg13g2_decap_8
XFILLER_129_215 VDD VSS sg13g2_decap_8
X_12544_ _12544_/X _14697_/Q _14729_/Q _13769_/Q _13801_/Q _12550_/S0 _12550_/S1 VDD
+ VSS sg13g2_mux4_1
XFILLER_34_1439 VDD VSS sg13g2_decap_8
XFILLER_12_563 VDD VSS sg13g2_decap_8
XFILLER_184_310 VDD VSS sg13g2_decap_8
XFILLER_121_1409 VDD VSS sg13g2_decap_8
XFILLER_160_1458 VDD VSS sg13g2_decap_8
X_15240__3031 _15240_/RESET_B VDD VSS sg13g2_tiehi
XFILLER_160_1469 VDD VSS sg13g2_fill_1
XFILLER_61_73 VDD VSS sg13g2_decap_8
X_12475_ _12475_/X _14372_/Q _14404_/Q _14468_/Q _14500_/Q _12506_/S0 _12506_/S1 VDD
+ VSS sg13g2_mux4_1
XFILLER_32_1141 VDD VSS sg13g2_decap_8
XFILLER_8_578 VDD VSS sg13g2_decap_8
XFILLER_177_95 VDD VSS sg13g2_decap_8
XFILLER_184_387 VDD VSS sg13g2_decap_8
X_14214_ _14214_/Q clkload50/A _14214_/D _14214_/RESET_B VDD VSS sg13g2_dfrbpq_1
X_11426_ _11426_/Y _12859_/A _11433_/B _11837_/A1 VDD VSS sg13g2_a21oi_1
XANTENNA_6 _09063_/X VDD VSS sg13g2_antennanp
X_15194_ _15194_/Q _15196_/CLK _15194_/D _15194_/RESET_B VDD VSS sg13g2_dfrbpq_1
XFILLER_6_46 VDD VSS sg13g2_decap_8
XFILLER_137_292 VDD VSS sg13g2_decap_8
X_14857__2853 _14857_/RESET_B VDD VSS sg13g2_tiehi
X_14145_ _14145_/Q clkload6/A _14145_/D _14145_/RESET_B VDD VSS sg13g2_dfrbpq_1
XFILLER_158_1354 VDD VSS sg13g2_decap_8
X_11357_ _11357_/Y _11366_/C _11353_/X _11356_/Y VDD VSS sg13g2_o21ai_1
XFILLER_67_1248 VDD VSS sg13g2_decap_8
XFILLER_140_402 VDD VSS sg13g2_decap_8
XFILLER_154_1218 VDD VSS sg13g2_decap_4
XFILLER_113_638 VDD VSS sg13g2_decap_8
X_14618__1584 _14618_/RESET_B VDD VSS sg13g2_tiehi
X_10308_ _14796_/D _14796_/Q _10327_/B _10307_/Y VDD VSS sg13g2_a21oi_1
XFILLER_4_784 VDD VSS sg13g2_decap_8
XFILLER_140_424 VDD VSS sg13g2_decap_8
X_14076_ _14076_/Q clkload77/A _14076_/D _14076_/RESET_B VDD VSS sg13g2_dfrbpq_1
XFILLER_112_126 VDD VSS sg13g2_decap_8
X_11288_ _11288_/Y _11288_/A _15217_/Q VDD VSS sg13g2_nor2b_1
XFILLER_98_349 VDD VSS sg13g2_decap_8
XFILLER_112_137 VDD VSS sg13g2_fill_1
X_13027_ _13027_/Y _13026_/Y _13079_/C _13042_/B VDD VSS sg13g2_nand3b_1
XFILLER_80_1426 VDD VSS sg13g2_decap_8
X_10239_ _14774_/D _10237_/B _10234_/Y _10238_/Y VDD VSS sg13g2_a21oi_1
XFILLER_117_1062 VDD VSS sg13g2_decap_8
XFILLER_121_671 VDD VSS sg13g2_fill_1
Xfanout1040 _08832_/D _15053_/Q VDD VSS sg13g2_buf_1
XFILLER_121_682 VDD VSS sg13g2_decap_4
Xfanout1051 _08174_/A _12403_/B1 VDD VSS sg13g2_buf_1
XFILLER_67_736 VDD VSS sg13g2_fill_1
XFILLER_39_427 VDD VSS sg13g2_decap_4
Xfanout1062 _08270_/B _08200_/A VDD VSS sg13g2_buf_1
XFILLER_13_4 VDD VSS sg13g2_decap_8
Xfanout1073 _08200_/B _08196_/A1 VDD VSS sg13g2_buf_1
XFILLER_94_544 VDD VSS sg13g2_decap_8
Xfanout1084 _08137_/S1 _08402_/A VDD VSS sg13g2_buf_1
XFILLER_66_246 VDD VSS sg13g2_decap_8
Xfanout1095 _08023_/A _08151_/S1 VDD VSS sg13g2_buf_1
XFILLER_48_972 VDD VSS sg13g2_fill_2
XFILLER_19_140 VDD VSS sg13g2_decap_8
XFILLER_19_151 VDD VSS sg13g2_fill_1
X_14978_ _14978_/Q clkload32/A _14978_/D _14978_/RESET_B VDD VSS sg13g2_dfrbpq_1
XFILLER_82_739 VDD VSS sg13g2_decap_8
XFILLER_63_931 VDD VSS sg13g2_decap_8
XFILLER_63_942 VDD VSS sg13g2_fill_2
XFILLER_19_184 VDD VSS sg13g2_decap_8
X_13929_ _13929_/Q clkload28/A _13929_/D _13929_/RESET_B VDD VSS sg13g2_dfrbpq_1
XFILLER_78_1366 VDD VSS sg13g2_decap_8
XFILLER_35_655 VDD VSS sg13g2_decap_8
XFILLER_23_806 VDD VSS sg13g2_decap_8
XFILLER_165_1336 VDD VSS sg13g2_decap_8
XFILLER_74_1219 VDD VSS sg13g2_decap_8
XFILLER_179_137 VDD VSS sg13g2_decap_8
XFILLER_50_669 VDD VSS sg13g2_decap_4
X_09120_ _09120_/Y _15243_/Q _09147_/B VDD VSS sg13g2_nand2b_1
XFILLER_128_1191 VDD VSS sg13g2_decap_8
XFILLER_163_1093 VDD VSS sg13g2_decap_8
X_09051_ _09051_/Y _09074_/B1 _10720_/B _09050_/X VDD VSS sg13g2_o21ai_1
XFILLER_176_899 VDD VSS sg13g2_fill_2
XFILLER_15_1383 VDD VSS sg13g2_decap_8
X_08002_ _08002_/Y _08037_/A _08037_/B _08039_/A VDD VSS sg13g2_a21oi_1
XFILLER_50_1274 VDD VSS sg13g2_decap_8
XFILLER_117_933 VDD VSS sg13g2_decap_8
X_15060__2516 _15060_/RESET_B VDD VSS sg13g2_tiehi
XFILLER_102_1353 VDD VSS sg13g2_decap_8
XFILLER_11_1247 VDD VSS sg13g2_decap_8
XFILLER_102_1375 VDD VSS sg13g2_decap_8
XFILLER_144_763 VDD VSS sg13g2_decap_8
XFILLER_176_1443 VDD VSS sg13g2_decap_8
XFILLER_116_465 VDD VSS sg13g2_fill_2
XFILLER_137_1416 VDD VSS sg13g2_decap_8
XFILLER_171_560 VDD VSS sg13g2_decap_8
XFILLER_85_1348 VDD VSS sg13g2_decap_8
XFILLER_131_413 VDD VSS sg13g2_fill_2
XFILLER_103_115 VDD VSS sg13g2_decap_4
X_09953_ _14537_/D _14537_/Q _09953_/A1 _09957_/S VDD VSS sg13g2_mux2_1
XFILLER_106_25 VDD VSS sg13g2_decap_8
XFILLER_106_36 VDD VSS sg13g2_fill_2
XFILLER_48_1181 VDD VSS sg13g2_decap_8
X_08904_ _08904_/X _08903_/X _11843_/A _08904_/S VDD VSS sg13g2_mux2_1
XFILLER_58_703 VDD VSS sg13g2_decap_8
XFILLER_170_1042 VDD VSS sg13g2_fill_1
X_09884_ _14470_/D _09917_/A1 _14470_/Q _09890_/S VDD VSS sg13g2_mux2_1
XFILLER_135_1173 VDD VSS sg13g2_decap_8
X_13712__2490 _13712_/RESET_B VDD VSS sg13g2_tiehi
XFILLER_58_736 VDD VSS sg13g2_decap_8
XFILLER_100_833 VDD VSS sg13g2_decap_8
X_08835_ _08842_/S _08835_/A _08835_/B VDD VSS sg13g2_nand2_1
XFILLER_170_1086 VDD VSS sg13g2_fill_2
XFILLER_22_1321 VDD VSS sg13g2_decap_8
XFILLER_58_769 VDD VSS sg13g2_decap_8
X_08766_ _08766_/Y _13674_/Q _13469_/B VDD VSS sg13g2_nor2_1
XFILLER_85_577 VDD VSS sg13g2_decap_8
XFILLER_57_268 VDD VSS sg13g2_decap_4
XFILLER_39_983 VDD VSS sg13g2_fill_2
XFILLER_122_35 VDD VSS sg13g2_decap_8
X_07717_ _08201_/B _15102_/Q _15101_/Q _15094_/Q _15093_/Q VDD VSS sg13g2_nor4_1
X_14056__2146 _14056_/RESET_B VDD VSS sg13g2_tiehi
XFILLER_22_1398 VDD VSS sg13g2_decap_8
X_13891__2311 _13891_/RESET_B VDD VSS sg13g2_tiehi
X_08697_ _08697_/Y _08697_/A _08697_/B VDD VSS sg13g2_nand2_1
XFILLER_96_1455 VDD VSS sg13g2_decap_8
XFILLER_26_644 VDD VSS sg13g2_fill_1
XFILLER_183_1414 VDD VSS sg13g2_decap_8
XFILLER_82_39 VDD VSS sg13g2_decap_8
X_07648_ _07648_/Y _14826_/Q VDD VSS sg13g2_inv_1
XFILLER_13_305 VDD VSS sg13g2_decap_8
XFILLER_53_485 VDD VSS sg13g2_decap_8
XFILLER_139_502 VDD VSS sg13g2_decap_8
XFILLER_15_77 VDD VSS sg13g2_decap_8
XFILLER_22_850 VDD VSS sg13g2_decap_4
XFILLER_167_822 VDD VSS sg13g2_fill_2
X_09318_ _13925_/D _10148_/A1 _13925_/Q _09329_/S VDD VSS sg13g2_mux2_1
XFILLER_55_1174 VDD VSS sg13g2_decap_8
XFILLER_51_1005 VDD VSS sg13g2_decap_8
XFILLER_40_157 VDD VSS sg13g2_decap_8
X_10590_ _10606_/B _14874_/Q _12963_/A VDD VSS sg13g2_nand2_1
XFILLER_90_1076 VDD VSS sg13g2_decap_8
XFILLER_107_1286 VDD VSS sg13g2_fill_2
XFILLER_139_557 VDD VSS sg13g2_decap_8
XFILLER_166_343 VDD VSS sg13g2_decap_8
XFILLER_16_1169 VDD VSS sg13g2_decap_8
XFILLER_167_877 VDD VSS sg13g2_decap_8
X_09249_ _13858_/D _13858_/Q _09814_/A0 _09263_/S VDD VSS sg13g2_mux2_1
XFILLER_33_1450 VDD VSS sg13g2_decap_8
XFILLER_31_21 VDD VSS sg13g2_decap_8
XFILLER_103_1139 VDD VSS sg13g2_fill_2
XFILLER_108_911 VDD VSS sg13g2_fill_1
XFILLER_5_504 VDD VSS sg13g2_decap_8
XFILLER_147_21 VDD VSS sg13g2_fill_1
X_12260_ _12260_/X _12253_/B _12259_/X _12258_/Y VDD VSS sg13g2_a21o_1
XFILLER_182_858 VDD VSS sg13g2_decap_8
XFILLER_182_869 VDD VSS sg13g2_fill_1
X_11211_ _11211_/X _14107_/Q _14139_/Q _11218_/S VDD VSS sg13g2_mux2_1
XFILLER_31_98 VDD VSS sg13g2_decap_8
XFILLER_108_977 VDD VSS sg13g2_decap_4
XFILLER_123_903 VDD VSS sg13g2_decap_4
XFILLER_147_76 VDD VSS sg13g2_decap_8
XFILLER_181_368 VDD VSS sg13g2_decap_8
XFILLER_135_774 VDD VSS sg13g2_decap_8
X_12191_ _12192_/B _12188_/Y _12190_/Y _11231_/S VDD VSS sg13g2_a21oi_1
XFILLER_135_785 VDD VSS sg13g2_decap_8
XFILLER_150_711 VDD VSS sg13g2_fill_1
XFILLER_107_487 VDD VSS sg13g2_fill_2
XFILLER_123_936 VDD VSS sg13g2_decap_8
XFILLER_135_796 VDD VSS sg13g2_fill_1
XFILLER_107_498 VDD VSS sg13g2_decap_8
Xoutput43 mem_axi_araddr[14] _16867_/A VDD VSS sg13g2_buf_1
X_11142_ _14951_/D _11141_/X _11140_/Y _11133_/Y VDD VSS sg13g2_o21ai_1
XFILLER_1_721 VDD VSS sg13g2_decap_8
Xoutput54 mem_axi_araddr[25] _16878_/A VDD VSS sg13g2_buf_1
Xoutput65 mem_axi_araddr[6] _16859_/A VDD VSS sg13g2_buf_1
Xoutput76 mem_axi_awaddr[15] _16868_/X VDD VSS sg13g2_buf_1
XFILLER_66_1270 VDD VSS sg13g2_decap_8
XFILLER_0_231 VDD VSS sg13g2_decap_8
XFILLER_122_468 VDD VSS sg13g2_decap_8
XFILLER_163_42 VDD VSS sg13g2_decap_8
Xoutput87 mem_axi_awaddr[26] _16879_/X VDD VSS sg13g2_buf_1
XFILLER_118_1360 VDD VSS sg13g2_decap_8
X_11073_ _14946_/D _14946_/Q _11102_/B _11072_/Y VDD VSS sg13g2_a21o_1
XFILLER_27_1243 VDD VSS sg13g2_decap_8
XFILLER_114_1202 VDD VSS sg13g2_decap_8
XFILLER_118_1371 VDD VSS sg13g2_fill_2
Xoutput98 mem_axi_awaddr[7] _16860_/X VDD VSS sg13g2_buf_1
X_14266__1936 _14266_/RESET_B VDD VSS sg13g2_tiehi
XFILLER_88_360 VDD VSS sg13g2_fill_2
XFILLER_62_1145 VDD VSS sg13g2_decap_8
XFILLER_103_682 VDD VSS sg13g2_decap_4
XFILLER_1_798 VDD VSS sg13g2_decap_8
Xhold3170 _10929_/A _14937_/Q VDD VSS sg13g2_dlygate4sd3_1
XFILLER_88_371 VDD VSS sg13g2_fill_2
XFILLER_7_1337 VDD VSS sg13g2_decap_8
X_14901_ _14901_/Q clkload60/A _14901_/D _14901_/RESET_B VDD VSS sg13g2_dfrbpq_1
X_10024_ _14606_/D _10057_/A0 _14606_/Q _10024_/S VDD VSS sg13g2_mux2_1
XFILLER_40_1410 VDD VSS sg13g2_decap_8
XFILLER_114_1268 VDD VSS sg13g2_fill_2
X_14832_ _14832_/Q clkload85/A _14832_/D _14832_/RESET_B VDD VSS sg13g2_dfrbpq_1
XFILLER_5_1050 VDD VSS sg13g2_decap_8
XFILLER_57_780 VDD VSS sg13g2_fill_2
XFILLER_45_931 VDD VSS sg13g2_decap_8
XFILLER_29_482 VDD VSS sg13g2_decap_8
X_14763_ _14763_/Q clkload67/A _14763_/D _14763_/RESET_B VDD VSS sg13g2_dfrbpq_1
X_11975_ _11975_/Y _11975_/A _11975_/B VDD VSS sg13g2_nor2_1
XFILLER_91_569 VDD VSS sg13g2_fill_2
X_14481__1721 _14481_/RESET_B VDD VSS sg13g2_tiehi
XFILLER_45_964 VDD VSS sg13g2_fill_2
XFILLER_186_1071 VDD VSS sg13g2_decap_8
X_13714_ _16876_/A clkload56/A _13714_/D _13714_/RESET_B VDD VSS sg13g2_dfrbpq_1
XFILLER_72_772 VDD VSS sg13g2_decap_8
X_10926_ _10926_/X _10926_/A _10926_/B _10969_/B VDD VSS sg13g2_and3_1
XFILLER_60_923 VDD VSS sg13g2_decap_8
X_14694_ _14694_/Q clkload51/A _14694_/D _14694_/RESET_B VDD VSS sg13g2_dfrbpq_1
X_13645_ _13753_/D _13645_/A VDD VSS sg13g2_buf_1
X_10857_ _10857_/Y _10857_/A _10857_/B VDD VSS sg13g2_xnor2_1
XFILLER_20_809 VDD VSS sg13g2_fill_2
XFILLER_73_1241 VDD VSS sg13g2_decap_8
XFILLER_158_811 VDD VSS sg13g2_fill_2
XFILLER_60_989 VDD VSS sg13g2_decap_4
XFILLER_34_1236 VDD VSS sg13g2_decap_8
XFILLER_185_630 VDD VSS sg13g2_decap_8
X_13576_ _15157_/D _13593_/B _13574_/Y _13575_/Y VDD VSS sg13g2_a21oi_1
X_10788_ _11199_/B _07614_/Y _09155_/Y _10788_/S VDD VSS sg13g2_mux2_1
XFILLER_12_371 VDD VSS sg13g2_decap_8
X_14101__2101 _14101_/RESET_B VDD VSS sg13g2_tiehi
XFILLER_160_1255 VDD VSS sg13g2_decap_8
XFILLER_9_854 VDD VSS sg13g2_decap_8
XFILLER_121_1217 VDD VSS sg13g2_decap_4
XFILLER_125_1386 VDD VSS sg13g2_decap_8
XFILLER_173_803 VDD VSS sg13g2_decap_8
X_13754__2448 _13754_/RESET_B VDD VSS sg13g2_tiehi
X_12527_ _15001_/D _12527_/A _12527_/B VDD VSS sg13g2_nor2_1
XFILLER_121_1239 VDD VSS sg13g2_decap_8
XFILLER_173_825 VDD VSS sg13g2_decap_8
XFILLER_185_696 VDD VSS sg13g2_decap_8
XFILLER_8_375 VDD VSS sg13g2_decap_8
XFILLER_172_324 VDD VSS sg13g2_decap_8
XFILLER_145_549 VDD VSS sg13g2_decap_8
XFILLER_184_184 VDD VSS sg13g2_decap_8
X_15246_ _15246_/Q clkload47/A _15246_/D _15246_/RESET_B VDD VSS sg13g2_dfrbpq_1
X_12458_ _12471_/A _12570_/A1 _12570_/A2 _08263_/B VDD VSS sg13g2_a21oi_1
XFILLER_126_752 VDD VSS sg13g2_decap_8
XFILLER_160_519 VDD VSS sg13g2_decap_8
X_11409_ _11409_/Y _11826_/A1 _14463_/Q VDD VSS sg13g2_nand2b_1
XFILLER_99_603 VDD VSS sg13g2_decap_8
XFILLER_158_1151 VDD VSS sg13g2_decap_8
X_15177_ _15177_/Q clkload87/A _15177_/D _15177_/RESET_B VDD VSS sg13g2_dfrbpq_1
X_12389_ _12389_/X _14686_/Q _14718_/Q _13758_/Q _13790_/Q _12614_/S0 _12614_/S1 VDD
+ VSS sg13g2_mux4_1
XFILLER_67_1045 VDD VSS sg13g2_decap_4
X_15107__2770 _15107_/RESET_B VDD VSS sg13g2_tiehi
XFILLER_99_636 VDD VSS sg13g2_decap_8
XFILLER_28_1007 VDD VSS sg13g2_fill_1
XFILLER_119_1135 VDD VSS sg13g2_decap_8
X_14128_ _14128_/Q _14637_/CLK _14128_/D _14128_/RESET_B VDD VSS sg13g2_dfrbpq_1
X_14134__2068 _14134_/RESET_B VDD VSS sg13g2_tiehi
XFILLER_99_647 VDD VSS sg13g2_fill_2
XFILLER_4_581 VDD VSS sg13g2_decap_8
XFILLER_141_744 VDD VSS sg13g2_decap_8
XFILLER_67_1089 VDD VSS sg13g2_decap_8
XFILLER_98_146 VDD VSS sg13g2_decap_8
XFILLER_119_1179 VDD VSS sg13g2_fill_1
XFILLER_154_1059 VDD VSS sg13g2_decap_8
XFILLER_141_788 VDD VSS sg13g2_decap_4
X_14059_ _14059_/Q clkload13/A _14059_/D _14059_/RESET_B VDD VSS sg13g2_dfrbpq_1
XFILLER_97_91 VDD VSS sg13g2_decap_8
XFILLER_132_1302 VDD VSS sg13g2_decap_8
XFILLER_45_1354 VDD VSS sg13g2_decap_8
XFILLER_80_1256 VDD VSS sg13g2_decap_8
XFILLER_41_1229 VDD VSS sg13g2_decap_8
X_08620_ _08621_/C _07850_/B _07853_/B _12129_/B2 _07861_/B _08635_/S0 _08635_/S1
+ VDD VSS sg13g2_mux4_1
XFILLER_82_514 VDD VSS sg13g2_fill_2
XFILLER_167_1409 VDD VSS sg13g2_decap_8
XFILLER_82_536 VDD VSS sg13g2_decap_8
X_08551_ _08551_/X _08567_/B _08531_/B _07956_/Y VDD VSS sg13g2_a21o_1
XFILLER_70_709 VDD VSS sg13g2_fill_2
XFILLER_35_430 VDD VSS sg13g2_decap_8
XFILLER_169_1280 VDD VSS sg13g2_decap_8
XFILLER_78_1163 VDD VSS sg13g2_decap_8
X_08482_ _15237_/D _08685_/A1 _08481_/X _08475_/Y VDD VSS sg13g2_o21ai_1
XFILLER_1_1470 VDD VSS sg13g2_decap_8
XFILLER_50_400 VDD VSS sg13g2_decap_8
XFILLER_90_580 VDD VSS sg13g2_decap_8
XFILLER_63_794 VDD VSS sg13g2_decap_8
XFILLER_39_1147 VDD VSS sg13g2_decap_8
X_13687__2521 _13687_/RESET_B VDD VSS sg13g2_tiehi
XFILLER_74_1049 VDD VSS sg13g2_decap_8
XFILLER_161_1019 VDD VSS sg13g2_fill_1
XFILLER_22_157 VDD VSS sg13g2_decap_8
XFILLER_56_1472 VDD VSS sg13g2_decap_8
XFILLER_10_308 VDD VSS sg13g2_decap_8
XFILLER_17_1434 VDD VSS sg13g2_decap_8
XFILLER_91_1374 VDD VSS sg13g2_decap_8
XFILLER_52_1347 VDD VSS sg13g2_decap_8
X_09103_ _09150_/B _13142_/A _14915_/Q _09103_/C _09103_/D VDD VSS sg13g2_and4_1
XFILLER_109_708 VDD VSS sg13g2_fill_1
XFILLER_17_1478 VDD VSS sg13g2_fill_1
XFILLER_104_1448 VDD VSS sg13g2_decap_8
XFILLER_175_151 VDD VSS sg13g2_decap_8
X_14344__1858 _14344_/RESET_B VDD VSS sg13g2_tiehi
XFILLER_164_836 VDD VSS sg13g2_fill_2
XFILLER_175_162 VDD VSS sg13g2_fill_2
XFILLER_176_696 VDD VSS sg13g2_decap_8
X_09034_ _09034_/X _15033_/Q _15230_/Q _09060_/S VDD VSS sg13g2_mux2_1
XFILLER_15_1180 VDD VSS sg13g2_decap_8
XFILLER_136_549 VDD VSS sg13g2_fill_2
XFILLER_175_195 VDD VSS sg13g2_fill_2
XFILLER_11_1044 VDD VSS sg13g2_decap_8
XFILLER_176_1240 VDD VSS sg13g2_decap_8
XFILLER_2_518 VDD VSS sg13g2_decap_8
XFILLER_117_796 VDD VSS sg13g2_decap_8
XFILLER_117_35 VDD VSS sg13g2_decap_8
XFILLER_144_582 VDD VSS sg13g2_fill_1
XFILLER_116_284 VDD VSS sg13g2_decap_8
XFILLER_137_1224 VDD VSS sg13g2_decap_8
XFILLER_172_1137 VDD VSS sg13g2_decap_8
Xfanout800 _12455_/S _12706_/S VDD VSS sg13g2_buf_1
Xfanout811 _12427_/S0 _12789_/S0 VDD VSS sg13g2_buf_1
XFILLER_63_1421 VDD VSS sg13g2_decap_8
XFILLER_89_168 VDD VSS sg13g2_fill_1
XFILLER_77_39 VDD VSS sg13g2_decap_8
XFILLER_104_479 VDD VSS sg13g2_decap_8
Xfanout822 _12520_/S1 _12647_/S1 VDD VSS sg13g2_buf_1
X_09936_ _14521_/D _14521_/Q _09936_/A1 _09936_/S VDD VSS sg13g2_mux2_1
XFILLER_77_319 VDD VSS sg13g2_decap_8
XFILLER_120_939 VDD VSS sg13g2_fill_2
Xfanout833 _12703_/S1 _12701_/S1 VDD VSS sg13g2_buf_1
XFILLER_113_980 VDD VSS sg13g2_decap_8
Xfanout844 _12590_/S1 fanout846/X VDD VSS sg13g2_buf_1
XFILLER_98_680 VDD VSS sg13g2_decap_8
Xfanout855 _12716_/S1 _12717_/S1 VDD VSS sg13g2_buf_1
Xfanout866 _12786_/S1 fanout867/X VDD VSS sg13g2_buf_1
XFILLER_24_1438 VDD VSS sg13g2_decap_8
Xfanout877 fanout877/X _12425_/S0 VDD VSS sg13g2_buf_1
X_09867_ _14454_/D _14454_/Q _09966_/A1 _09871_/S VDD VSS sg13g2_mux2_1
Xfanout888 _12620_/S0 fanout889/X VDD VSS sg13g2_buf_1
XFILLER_58_555 VDD VSS sg13g2_decap_8
X_14841__2885 _14841_/RESET_B VDD VSS sg13g2_tiehi
Xfanout899 _12686_/S0 _12674_/S0 VDD VSS sg13g2_buf_1
XFILLER_150_1468 VDD VSS sg13g2_fill_2
X_08818_ _08818_/Y _13690_/Q _13482_/B VDD VSS sg13g2_nor2_1
XFILLER_73_503 VDD VSS sg13g2_fill_1
XFILLER_85_374 VDD VSS sg13g2_fill_2
XFILLER_73_514 VDD VSS sg13g2_decap_8
X_09798_ _14387_/D _09963_/A1 _14387_/Q _09804_/S VDD VSS sg13g2_mux2_1
XFILLER_73_525 VDD VSS sg13g2_fill_1
XFILLER_93_49 VDD VSS sg13g2_decap_8
XFILLER_26_21 VDD VSS sg13g2_decap_8
X_08749_ _08749_/Y _13668_/Q _08752_/B VDD VSS sg13g2_nor2_1
XFILLER_22_1195 VDD VSS sg13g2_decap_8
XFILLER_38_290 VDD VSS sg13g2_decap_8
XFILLER_2_1267 VDD VSS sg13g2_decap_8
XFILLER_165_4 VDD VSS sg13g2_decap_8
XFILLER_183_1211 VDD VSS sg13g2_decap_8
XFILLER_54_761 VDD VSS sg13g2_decap_8
X_11760_ _11761_/B _11760_/A _11760_/B _11760_/C VDD VSS sg13g2_nand3_1
XFILLER_13_102 VDD VSS sg13g2_decap_8
XFILLER_96_1296 VDD VSS sg13g2_decap_8
XFILLER_57_1247 VDD VSS sg13g2_decap_8
XFILLER_41_411 VDD VSS sg13g2_decap_8
X_10711_ _14905_/D _10985_/B1 _10954_/A _10708_/Y VDD VSS sg13g2_o21ai_1
XFILLER_26_98 VDD VSS sg13g2_decap_8
XFILLER_14_658 VDD VSS sg13g2_decap_8
X_11691_ _11693_/A _11692_/A _14184_/Q VDD VSS sg13g2_nand2b_1
XFILLER_158_107 VDD VSS sg13g2_fill_2
XFILLER_183_1288 VDD VSS sg13g2_decap_8
XFILLER_109_1359 VDD VSS sg13g2_decap_8
XFILLER_186_427 VDD VSS sg13g2_decap_8
XFILLER_139_310 VDD VSS sg13g2_decap_8
X_13430_ _15097_/D _15097_/Q _13470_/A2 _13429_/Y VDD VSS sg13g2_a21o_1
X_10642_ _10643_/C _14888_/Q _14887_/Q _10642_/C VDD VSS sg13g2_and3_1
XFILLER_13_179 VDD VSS sg13g2_decap_8
XFILLER_41_488 VDD VSS sg13g2_decap_4
XFILLER_42_42 VDD VSS sg13g2_decap_8
XFILLER_158_42 VDD VSS sg13g2_decap_8
XFILLER_166_140 VDD VSS sg13g2_decap_8
X_13361_ _13361_/Y _13494_/B _13429_/A _13361_/C VDD VSS sg13g2_nor3_1
X_10573_ _10577_/C _12895_/A _10591_/C _14870_/Q VDD VSS sg13g2_a21oi_1
XFILLER_70_1469 VDD VSS sg13g2_decap_8
XFILLER_6_802 VDD VSS sg13g2_decap_8
XFILLER_10_875 VDD VSS sg13g2_decap_8
X_15100_ _15100_/Q clkload70/A _15100_/D _15100_/RESET_B VDD VSS sg13g2_dfrbpq_1
XFILLER_5_301 VDD VSS sg13g2_decap_8
XFILLER_139_398 VDD VSS sg13g2_fill_2
XFILLER_154_324 VDD VSS sg13g2_fill_1
X_12312_ _12312_/Y _12306_/A _14618_/Q _12307_/C VDD VSS sg13g2_a21oi_1
X_13292_ _15055_/D _15055_/Q _07710_/Y _07694_/Y VDD VSS sg13g2_a21o_1
XFILLER_177_1026 VDD VSS sg13g2_decap_8
XFILLER_182_655 VDD VSS sg13g2_decap_8
XFILLER_68_1321 VDD VSS sg13g2_decap_8
XFILLER_181_154 VDD VSS sg13g2_decap_8
X_15031_ _15031_/Q clkload64/A _15031_/D _15031_/RESET_B VDD VSS sg13g2_dfrbpq_1
X_12243_ _12243_/Y _12288_/S0 _14680_/Q _12233_/B VDD VSS sg13g2_a21oi_1
XFILLER_6_879 VDD VSS sg13g2_decap_8
XFILLER_154_379 VDD VSS sg13g2_decap_8
XFILLER_120_1294 VDD VSS sg13g2_fill_2
XFILLER_5_378 VDD VSS sg13g2_decap_8
X_12174_ _12174_/Y _12174_/A _12174_/B VDD VSS sg13g2_nor2_1
XFILLER_174_63 VDD VSS sg13g2_decap_8
XFILLER_64_1218 VDD VSS sg13g2_decap_8
XFILLER_29_1338 VDD VSS sg13g2_decap_8
X_14499__1703 _14499_/RESET_B VDD VSS sg13g2_tiehi
XFILLER_68_1398 VDD VSS sg13g2_decap_8
XFILLER_122_243 VDD VSS sg13g2_decap_8
XFILLER_150_552 VDD VSS sg13g2_decap_8
XFILLER_155_1368 VDD VSS sg13g2_decap_8
X_11125_ _11128_/B _11171_/B _11147_/A VDD VSS sg13g2_xnor2_1
XFILLER_3_25 VDD VSS sg13g2_decap_8
XFILLER_27_1040 VDD VSS sg13g2_fill_1
XFILLER_150_596 VDD VSS sg13g2_decap_8
XFILLER_89_680 VDD VSS sg13g2_decap_8
XFILLER_7_1134 VDD VSS sg13g2_decap_8
XFILLER_27_1062 VDD VSS sg13g2_decap_8
XFILLER_110_449 VDD VSS sg13g2_decap_4
XFILLER_1_595 VDD VSS sg13g2_decap_8
X_11056_ _11056_/Y _11044_/C _11068_/C _11056_/B1 VDD VSS sg13g2_o21ai_1
XFILLER_77_842 VDD VSS sg13g2_decap_8
XFILLER_114_1032 VDD VSS sg13g2_decap_4
XFILLER_114_1054 VDD VSS sg13g2_fill_2
X_10007_ _14589_/D _10073_/A0 _14589_/Q _10035_/S VDD VSS sg13g2_mux2_1
XFILLER_76_363 VDD VSS sg13g2_decap_8
XFILLER_37_717 VDD VSS sg13g2_decap_8
XFILLER_77_897 VDD VSS sg13g2_decap_8
XFILLER_18_931 VDD VSS sg13g2_fill_2
XFILLER_97_1038 VDD VSS sg13g2_decap_4
XFILLER_64_536 VDD VSS sg13g2_fill_1
X_14815_ _14815_/Q _14893_/CLK _14815_/D _14815_/RESET_B VDD VSS sg13g2_dfrbpq_1
XFILLER_64_558 VDD VSS sg13g2_decap_8
XFILLER_40_1284 VDD VSS sg13g2_decap_8
X_13808__2394 _13808_/RESET_B VDD VSS sg13g2_tiehi
XFILLER_79_1472 VDD VSS sg13g2_fill_2
XFILLER_75_1314 VDD VSS sg13g2_decap_8
X_14746_ _14746_/Q clkload76/A _14746_/D _14746_/RESET_B VDD VSS sg13g2_dfrbpq_1
XFILLER_127_1404 VDD VSS sg13g2_decap_8
X_11958_ _11958_/Y _11963_/S0 _14384_/Q VDD VSS sg13g2_nand2b_1
XFILLER_32_400 VDD VSS sg13g2_fill_1
XFILLER_178_906 VDD VSS sg13g2_decap_8
XFILLER_83_93 VDD VSS sg13g2_decap_4
XFILLER_44_282 VDD VSS sg13g2_decap_8
X_10909_ _10954_/D _10936_/A _10936_/D VDD VSS sg13g2_nand2_1
X_14677_ _14677_/Q _14677_/CLK _14677_/D _14677_/RESET_B VDD VSS sg13g2_dfrbpq_1
XFILLER_33_978 VDD VSS sg13g2_decap_8
XFILLER_162_1339 VDD VSS sg13g2_decap_8
X_11889_ _11889_/Y _11885_/Y _11886_/Y _11888_/Y _11887_/Y _11900_/B VDD VSS sg13g2_a221oi_1
XFILLER_177_427 VDD VSS sg13g2_decap_8
XFILLER_60_775 VDD VSS sg13g2_fill_1
XFILLER_33_989 VDD VSS sg13g2_fill_2
X_13628_ _13736_/D _13628_/A VDD VSS sg13g2_buf_1
X_13987__2215 _13987_/RESET_B VDD VSS sg13g2_tiehi
XFILLER_125_1150 VDD VSS sg13g2_decap_8
XFILLER_158_641 VDD VSS sg13g2_decap_8
XFILLER_73_1082 VDD VSS sg13g2_decap_8
XFILLER_73_1093 VDD VSS sg13g2_decap_4
XFILLER_9_651 VDD VSS sg13g2_decap_8
X_13559_ _13559_/Y _08544_/C _13567_/A2 _13558_/Y VDD VSS sg13g2_a21oi_1
XFILLER_34_1066 VDD VSS sg13g2_fill_2
XFILLER_186_994 VDD VSS sg13g2_decap_8
XFILLER_12_1320 VDD VSS sg13g2_decap_8
XFILLER_146_858 VDD VSS sg13g2_decap_8
XFILLER_8_172 VDD VSS sg13g2_decap_8
XFILLER_103_1470 VDD VSS sg13g2_decap_4
X_15229_ _15229_/Q _15230_/CLK _15229_/D _15229_/RESET_B VDD VSS sg13g2_dfrbpq_1
XFILLER_114_700 VDD VSS sg13g2_decap_8
XFILLER_160_305 VDD VSS sg13g2_decap_8
XFILLER_172_165 VDD VSS sg13g2_decap_8
XFILLER_12_1397 VDD VSS sg13g2_decap_8
XFILLER_86_1454 VDD VSS sg13g2_decap_8
XFILLER_114_733 VDD VSS sg13g2_decap_8
XFILLER_126_593 VDD VSS sg13g2_fill_2
XFILLER_153_390 VDD VSS sg13g2_fill_1
XFILLER_99_444 VDD VSS sg13g2_decap_8
XFILLER_114_755 VDD VSS sg13g2_decap_8
XFILLER_173_1435 VDD VSS sg13g2_decap_8
XFILLER_47_1438 VDD VSS sg13g2_decap_8
XFILLER_113_254 VDD VSS sg13g2_fill_2
X_07982_ _07985_/B _07834_/B _07980_/Y _15216_/Q VDD VSS sg13g2_o21ai_1
XFILLER_87_639 VDD VSS sg13g2_decap_4
XFILLER_68_831 VDD VSS sg13g2_decap_4
XFILLER_113_298 VDD VSS sg13g2_decap_8
XFILLER_132_1110 VDD VSS sg13g2_decap_8
X_09721_ _14312_/D _09919_/A1 _14312_/Q _09725_/S VDD VSS sg13g2_mux2_1
XFILLER_67_341 VDD VSS sg13g2_decap_8
X_09652_ _14245_/D _09916_/A1 _14245_/Q _09663_/S VDD VSS sg13g2_mux2_1
XFILLER_80_1097 VDD VSS sg13g2_fill_2
Xclkbuf_5_18__f_clk_i clkbuf_leaf_18_clk_i/A clkbuf_4_9_0_clk_i/X VDD VSS sg13g2_buf_16
XFILLER_167_1206 VDD VSS sg13g2_decap_8
X_08603_ _08603_/Y _08668_/A _08603_/B VDD VSS sg13g2_nand2b_1
X_09583_ _14180_/D _14180_/Q _09583_/A1 _09589_/S VDD VSS sg13g2_mux2_1
X_08534_ _08535_/A _08567_/B _08532_/Y _08533_/Y VDD VSS sg13g2_o21ai_1
XFILLER_82_388 VDD VSS sg13g2_decap_8
XFILLER_36_783 VDD VSS sg13g2_decap_4
XFILLER_93_1447 VDD VSS sg13g2_decap_8
XFILLER_180_1406 VDD VSS sg13g2_decap_8
XFILLER_54_1409 VDD VSS sg13g2_decap_8
X_08465_ _08465_/X _08471_/B _07949_/C _07945_/B _08465_/A3 _13517_/A _13521_/A VDD
+ VSS sg13g2_mux4_1
XFILLER_50_230 VDD VSS sg13g2_decap_8
XFILLER_11_606 VDD VSS sg13g2_decap_8
XFILLER_51_786 VDD VSS sg13g2_decap_8
XFILLER_17_1231 VDD VSS sg13g2_decap_8
XFILLER_10_105 VDD VSS sg13g2_decap_8
X_08396_ _15233_/D _08395_/Y _08393_/Y _08388_/Y VDD VSS sg13g2_a21o_1
XFILLER_23_499 VDD VSS sg13g2_decap_8
X_14577__1625 _14577_/RESET_B VDD VSS sg13g2_tiehi
XFILLER_91_1182 VDD VSS sg13g2_decap_4
XFILLER_52_1144 VDD VSS sg13g2_decap_8
XFILLER_13_1117 VDD VSS sg13g2_decap_8
XFILLER_149_674 VDD VSS sg13g2_decap_8
XFILLER_6_109 VDD VSS sg13g2_decap_8
XFILLER_178_1313 VDD VSS sg13g2_decap_8
XFILLER_104_1267 VDD VSS sg13g2_fill_2
XFILLER_100_1109 VDD VSS sg13g2_decap_8
XFILLER_12_56 VDD VSS sg13g2_decap_8
XFILLER_164_644 VDD VSS sg13g2_decap_8
XFILLER_128_34 VDD VSS sg13g2_decap_8
X_09017_ _09017_/Y _09141_/A _10697_/B _10702_/A _09030_/D VDD VSS sg13g2_a22oi_1
XFILLER_105_700 VDD VSS sg13g2_fill_2
XFILLER_136_379 VDD VSS sg13g2_decap_8
XFILLER_3_816 VDD VSS sg13g2_decap_8
XFILLER_105_722 VDD VSS sg13g2_decap_8
XFILLER_128_89 VDD VSS sg13g2_decap_8
XFILLER_2_315 VDD VSS sg13g2_decap_8
XFILLER_88_49 VDD VSS sg13g2_decap_8
XFILLER_104_254 VDD VSS sg13g2_decap_8
XFILLER_120_703 VDD VSS sg13g2_decap_8
XFILLER_132_563 VDD VSS sg13g2_fill_1
XFILLER_78_628 VDD VSS sg13g2_fill_1
XFILLER_132_585 VDD VSS sg13g2_decap_8
Xfanout630 _10669_/S _10788_/S VDD VSS sg13g2_buf_1
XFILLER_104_287 VDD VSS sg13g2_decap_8
XFILLER_132_596 VDD VSS sg13g2_fill_2
XFILLER_8_1432 VDD VSS sg13g2_decap_8
Xfanout641 _08835_/B _08828_/Y VDD VSS sg13g2_buf_1
XFILLER_28_1371 VDD VSS sg13g2_decap_8
Xfanout652 _08306_/A _07996_/X VDD VSS sg13g2_buf_1
X_09919_ _14504_/D _14504_/Q _09919_/A1 _09921_/S VDD VSS sg13g2_mux2_1
Xfanout663 _12777_/C1 _07737_/Y VDD VSS sg13g2_buf_1
XFILLER_150_1232 VDD VSS sg13g2_decap_8
Xfanout674 _13248_/B _13138_/B1 VDD VSS sg13g2_buf_1
XFILLER_24_1235 VDD VSS sg13g2_decap_8
XFILLER_115_1363 VDD VSS sg13g2_fill_1
Xfanout685 _10912_/B1 _07702_/X VDD VSS sg13g2_buf_1
XFILLER_63_1295 VDD VSS sg13g2_decap_8
XFILLER_19_717 VDD VSS sg13g2_decap_8
X_12930_ _12930_/Y _14807_/Q _12851_/B _12879_/B _14839_/Q _12930_/C1 VDD VSS sg13g2_a221oi_1
Xfanout696 _11458_/A _11664_/A VDD VSS sg13g2_buf_1
XFILLER_18_205 VDD VSS sg13g2_decap_8
XFILLER_37_42 VDD VSS sg13g2_decap_8
XFILLER_74_845 VDD VSS sg13g2_fill_2
XFILLER_160_32 VDD VSS sg13g2_decap_8
XFILLER_185_1306 VDD VSS sg13g2_decap_8
X_12861_ _12861_/X _12861_/A _12861_/B VDD VSS sg13g2_xor2_1
XFILLER_37_97 VDD VSS sg13g2_decap_8
X_14600_ _14600_/Q _14728_/CLK _14600_/D _14600_/RESET_B VDD VSS sg13g2_dfrbpq_1
XFILLER_2_1064 VDD VSS sg13g2_decap_8
X_11812_ _11812_/Y _11812_/A1 _14668_/Q _11802_/B VDD VSS sg13g2_a21oi_1
X_12792_ _15020_/D _12792_/A _12792_/B VDD VSS sg13g2_nor2_1
XFILLER_57_1033 VDD VSS sg13g2_fill_2
XFILLER_14_422 VDD VSS sg13g2_decap_8
XFILLER_54_591 VDD VSS sg13g2_decap_4
XFILLER_156_0 VDD VSS sg13g2_decap_8
X_14531_ _14531_/Q _14723_/CLK _14531_/D _14531_/RESET_B VDD VSS sg13g2_dfrbpq_1
XFILLER_42_742 VDD VSS sg13g2_decap_8
XFILLER_148_1172 VDD VSS sg13g2_decap_8
X_11743_ _11743_/Y _11743_/A _11743_/B _11898_/C VDD VSS sg13g2_nand3_1
XFILLER_183_1085 VDD VSS sg13g2_decap_8
XFILLER_186_224 VDD VSS sg13g2_decap_8
X_14462_ _14462_/Q clkload67/A _14462_/D _14462_/RESET_B VDD VSS sg13g2_dfrbpq_1
XFILLER_74_1380 VDD VSS sg13g2_decap_8
XFILLER_35_1331 VDD VSS sg13g2_decap_8
XFILLER_169_63 VDD VSS sg13g2_decap_8
XFILLER_175_909 VDD VSS sg13g2_fill_2
X_11674_ _11674_/Y _11678_/S0 _14600_/Q _11693_/C VDD VSS sg13g2_a21oi_1
XFILLER_168_972 VDD VSS sg13g2_decap_8
X_13413_ _13442_/B _15198_/Q _15199_/Q _13490_/B _13490_/C VDD VSS sg13g2_or4_1
X_10625_ _10626_/A _14883_/Q _14882_/Q _14881_/Q _10625_/D VDD VSS sg13g2_nand4_1
XFILLER_122_1334 VDD VSS sg13g2_fill_1
X_14393_ _14393_/Q _14745_/CLK _14393_/D _14393_/RESET_B VDD VSS sg13g2_dfrbpq_1
XFILLER_70_1266 VDD VSS sg13g2_decap_8
XFILLER_161_1394 VDD VSS sg13g2_decap_8
XFILLER_10_672 VDD VSS sg13g2_decap_8
XFILLER_127_335 VDD VSS sg13g2_decap_8
X_13344_ _15069_/D _13341_/A _15174_/D _13343_/Y VDD VSS sg13g2_o21ai_1
X_10556_ _10557_/B _14867_/Q _14866_/Q _14865_/Q _10556_/D VDD VSS sg13g2_nand4_1
XFILLER_122_1389 VDD VSS sg13g2_decap_8
XFILLER_143_806 VDD VSS sg13g2_decap_8
XFILLER_154_132 VDD VSS sg13g2_decap_8
XFILLER_182_441 VDD VSS sg13g2_decap_8
XFILLER_170_603 VDD VSS sg13g2_fill_2
XFILLER_183_986 VDD VSS sg13g2_decap_8
X_13671__2553 _13671_/RESET_B VDD VSS sg13g2_tiehi
XFILLER_108_560 VDD VSS sg13g2_fill_1
X_13275_ _13275_/Y _14798_/Q _13275_/A2 _13275_/B1 VDD VSS sg13g2_o21ai_1
X_10487_ _14849_/D _10487_/A _10487_/B _10495_/D VDD VSS sg13g2_nor3_1
XFILLER_6_676 VDD VSS sg13g2_decap_8
XFILLER_185_84 VDD VSS sg13g2_decap_8
XFILLER_5_175 VDD VSS sg13g2_decap_8
XFILLER_170_647 VDD VSS sg13g2_decap_8
X_15014_ _15014_/Q clkload38/A _15014_/D _15014_/RESET_B VDD VSS sg13g2_dfrbpq_1
XFILLER_142_349 VDD VSS sg13g2_decap_8
X_12226_ _14985_/D hold3177/X _12271_/A _12225_/Y VDD VSS sg13g2_a21o_1
XFILLER_123_530 VDD VSS sg13g2_decap_8
XFILLER_159_1290 VDD VSS sg13g2_decap_8
XFILLER_151_850 VDD VSS sg13g2_decap_8
XFILLER_68_1195 VDD VSS sg13g2_decap_8
XFILLER_111_703 VDD VSS sg13g2_fill_2
XFILLER_64_1037 VDD VSS sg13g2_decap_4
X_12157_ _12157_/Y _12168_/A _14134_/Q VDD VSS sg13g2_nand2b_1
XFILLER_151_883 VDD VSS sg13g2_decap_8
X_14922__2723 _14922_/RESET_B VDD VSS sg13g2_tiehi
X_14051__2151 _14051_/RESET_B VDD VSS sg13g2_tiehi
XFILLER_2_882 VDD VSS sg13g2_decap_8
XFILLER_155_1187 VDD VSS sg13g2_decap_8
XFILLER_110_224 VDD VSS sg13g2_decap_8
X_11108_ _11109_/A _10764_/X _11097_/Y _11107_/Y VDD VSS sg13g2_o21ai_1
XFILLER_111_758 VDD VSS sg13g2_decap_8
XFILLER_96_447 VDD VSS sg13g2_decap_8
XFILLER_1_392 VDD VSS sg13g2_decap_8
X_12088_ _12092_/A _12087_/X _12088_/B VDD VSS sg13g2_nand2b_1
XFILLER_42_1324 VDD VSS sg13g2_decap_8
XFILLER_81_1384 VDD VSS sg13g2_decap_8
X_11039_ _11043_/B _11052_/A _11052_/D _11052_/B VDD VSS sg13g2_o21ai_1
XFILLER_83_119 VDD VSS sg13g2_decap_8
XFILLER_37_514 VDD VSS sg13g2_decap_8
X_14655__1547 _14655_/RESET_B VDD VSS sg13g2_tiehi
XFILLER_92_620 VDD VSS sg13g2_decap_8
X_14955__2657 _14955_/RESET_B VDD VSS sg13g2_tiehi
XFILLER_37_558 VDD VSS sg13g2_decap_8
XFILLER_75_1111 VDD VSS sg13g2_fill_1
XFILLER_64_388 VDD VSS sg13g2_decap_4
XFILLER_91_174 VDD VSS sg13g2_decap_8
XFILLER_45_580 VDD VSS sg13g2_fill_2
X_14729_ _14729_/Q _14729_/CLK _14729_/D _14729_/RESET_B VDD VSS sg13g2_dfrbpq_1
XFILLER_166_1283 VDD VSS sg13g2_decap_8
XFILLER_32_252 VDD VSS sg13g2_fill_2
XFILLER_127_1256 VDD VSS sg13g2_decap_8
XFILLER_162_1136 VDD VSS sg13g2_decap_8
XFILLER_20_403 VDD VSS sg13g2_fill_1
X_08250_ _08250_/X _08318_/A _08250_/B VDD VSS sg13g2_xor2_1
XFILLER_75_1188 VDD VSS sg13g2_decap_8
XFILLER_20_425 VDD VSS sg13g2_decap_8
X_15023__2587 _15023_/RESET_B VDD VSS sg13g2_tiehi
XFILLER_119_803 VDD VSS sg13g2_fill_2
XFILLER_14_1415 VDD VSS sg13g2_decap_8
X_08181_ _08183_/C _07912_/B _08174_/A _08162_/Y VDD VSS sg13g2_a21oi_1
XFILLER_53_1475 VDD VSS sg13g2_decap_4
XFILLER_118_302 VDD VSS sg13g2_decap_4
XFILLER_174_920 VDD VSS sg13g2_decap_8
XFILLER_186_791 VDD VSS sg13g2_decap_8
XFILLER_71_0 VDD VSS sg13g2_decap_8
XFILLER_145_110 VDD VSS sg13g2_fill_2
XFILLER_101_1418 VDD VSS sg13g2_decap_8
XFILLER_118_335 VDD VSS sg13g2_fill_1
X_14261__1941 _14261_/RESET_B VDD VSS sg13g2_tiehi
XFILLER_106_519 VDD VSS sg13g2_decap_8
XFILLER_145_154 VDD VSS sg13g2_fill_2
XFILLER_161_614 VDD VSS sg13g2_decap_4
XFILLER_160_102 VDD VSS sg13g2_decap_8
XFILLER_12_1194 VDD VSS sg13g2_decap_8
XFILLER_161_647 VDD VSS sg13g2_decap_4
XFILLER_114_530 VDD VSS sg13g2_decap_8
XFILLER_173_1232 VDD VSS sg13g2_decap_8
XFILLER_47_1235 VDD VSS sg13g2_decap_8
XFILLER_138_1374 VDD VSS sg13g2_decap_8
XFILLER_141_360 VDD VSS sg13g2_decap_4
XFILLER_160_179 VDD VSS sg13g2_decap_8
XFILLER_134_1216 VDD VSS sg13g2_fill_2
XFILLER_138_1385 VDD VSS sg13g2_fill_2
XFILLER_102_747 VDD VSS sg13g2_fill_1
XFILLER_141_382 VDD VSS sg13g2_decap_8
XFILLER_99_296 VDD VSS sg13g2_decap_8
XFILLER_60_1413 VDD VSS sg13g2_decap_8
X_07965_ _07965_/Y _15016_/Q _12152_/A VDD VSS sg13g2_nand2b_1
XFILLER_114_36 VDD VSS sg13g2_decap_8
X_09704_ _14296_/D _09770_/A1 _14296_/Q _09704_/S VDD VSS sg13g2_mux2_1
XFILLER_67_160 VDD VSS sg13g2_decap_8
X_07896_ _07896_/X _08009_/S _13601_/A VDD VSS sg13g2_and2_1
XFILLER_74_18 VDD VSS sg13g2_decap_4
X_09635_ _14231_/D _09635_/A0 _14231_/Q _09637_/S VDD VSS sg13g2_mux2_1
XFILLER_83_653 VDD VSS sg13g2_decap_8
XFILLER_82_130 VDD VSS sg13g2_fill_1
XFILLER_23_1290 VDD VSS sg13g2_decap_8
X_15063__1446 _15063_/RESET_B VDD VSS sg13g2_tiehi
XFILLER_55_366 VDD VSS sg13g2_decap_8
XFILLER_3_1362 VDD VSS sg13g2_decap_8
XFILLER_71_837 VDD VSS sg13g2_fill_1
X_09566_ _14164_/D _10163_/A1 _14164_/Q _09566_/S VDD VSS sg13g2_mux2_1
XFILLER_110_1282 VDD VSS sg13g2_fill_2
XFILLER_43_539 VDD VSS sg13g2_decap_8
XFILLER_97_1391 VDD VSS sg13g2_fill_1
XFILLER_130_46 VDD VSS sg13g2_decap_8
X_08517_ _15239_/D _08517_/A _08517_/B _08517_/C _08517_/D VDD VSS sg13g2_nand4_1
XFILLER_58_1364 VDD VSS sg13g2_decap_8
XFILLER_180_1203 VDD VSS sg13g2_decap_8
XFILLER_54_1206 VDD VSS sg13g2_decap_8
XFILLER_24_753 VDD VSS sg13g2_decap_8
XFILLER_12_904 VDD VSS sg13g2_decap_8
X_09497_ _14097_/D _09961_/A1 _14097_/Q _09505_/S VDD VSS sg13g2_mux2_1
XFILLER_168_213 VDD VSS sg13g2_decap_8
X_14700__1502 _14700_/RESET_B VDD VSS sg13g2_tiehi
XFILLER_184_1394 VDD VSS sg13g2_decap_8
XFILLER_51_561 VDD VSS sg13g2_decap_8
XFILLER_106_1307 VDD VSS sg13g2_decap_8
XFILLER_11_403 VDD VSS sg13g2_decap_8
XFILLER_19_1359 VDD VSS sg13g2_decap_8
XFILLER_23_11 VDD VSS sg13g2_decap_8
XFILLER_23_263 VDD VSS sg13g2_fill_1
X_08448_ _08448_/Y _08391_/A _08443_/Y _08447_/X VDD VSS sg13g2_a21oi_1
XFILLER_145_1378 VDD VSS sg13g2_decap_8
XFILLER_23_296 VDD VSS sg13g2_decap_4
XFILLER_139_11 VDD VSS sg13g2_fill_1
X_14093__2109 _14093_/RESET_B VDD VSS sg13g2_tiehi
XFILLER_184_728 VDD VSS sg13g2_decap_8
X_08379_ _08379_/Y _08484_/B _08544_/A VDD VSS sg13g2_nand2_1
XFILLER_104_1020 VDD VSS sg13g2_decap_8
XFILLER_149_471 VDD VSS sg13g2_decap_8
X_10410_ _10414_/D _14823_/Q _14824_/Q _14825_/Q _14826_/Q VDD VSS sg13g2_and4_1
XFILLER_128_4 VDD VSS sg13g2_decap_4
XFILLER_149_493 VDD VSS sg13g2_decap_8
XFILLER_136_121 VDD VSS sg13g2_decap_8
XFILLER_178_1110 VDD VSS sg13g2_decap_8
XFILLER_183_249 VDD VSS sg13g2_decap_8
X_11390_ _11391_/A _11403_/S0 _13887_/Q VDD VSS sg13g2_nand2b_1
XFILLER_109_346 VDD VSS sg13g2_decap_8
XFILLER_87_1004 VDD VSS sg13g2_decap_8
XFILLER_99_37 VDD VSS sg13g2_decap_8
X_10341_ _10343_/A _10405_/C _10357_/D _14807_/Q VDD VSS sg13g2_a21o_1
XFILLER_152_614 VDD VSS sg13g2_decap_8
XFILLER_139_1116 VDD VSS sg13g2_decap_8
X_14733__1469 _14733_/RESET_B VDD VSS sg13g2_tiehi
XFILLER_30_1272 VDD VSS sg13g2_decap_8
XFILLER_180_945 VDD VSS sg13g2_fill_1
Xclkbuf_leaf_124_clk_i clkload17/A clkbuf_5_4__f_clk_i/X VDD VSS sg13g2_buf_8
XFILLER_3_613 VDD VSS sg13g2_decap_8
XFILLER_178_1187 VDD VSS sg13g2_decap_8
XFILLER_155_32 VDD VSS sg13g2_decap_8
X_13060_ _13060_/Y _13042_/A _13037_/Y _13057_/C VDD VSS sg13g2_o21ai_1
XFILLER_2_112 VDD VSS sg13g2_decap_8
X_10272_ _10281_/D _10299_/A _10299_/B VDD VSS sg13g2_nor2_1
XFILLER_156_1441 VDD VSS sg13g2_decap_8
X_12011_ _12011_/X _12012_/A _11988_/Y _12055_/D VDD VSS sg13g2_a21o_1
XFILLER_79_937 VDD VSS sg13g2_decap_8
XFILLER_133_894 VDD VSS sg13g2_decap_8
XFILLER_26_1319 VDD VSS sg13g2_decap_8
Xfanout1403 _10490_/A _10435_/A VDD VSS sg13g2_buf_1
XFILLER_65_1368 VDD VSS sg13g2_decap_8
XFILLER_160_691 VDD VSS sg13g2_fill_1
Xfanout1414 _12570_/A1 _12639_/A1 VDD VSS sg13g2_buf_1
XFILLER_2_189 VDD VSS sg13g2_decap_8
Xfanout1425 _10365_/C _10343_/C VDD VSS sg13g2_buf_1
Xfanout1436 _10423_/C _13405_/B VDD VSS sg13g2_buf_1
XFILLER_120_555 VDD VSS sg13g2_decap_8
XFILLER_59_650 VDD VSS sg13g2_decap_4
Xfanout460 _09571_/S _09560_/S VDD VSS sg13g2_buf_1
XFILLER_171_42 VDD VSS sg13g2_decap_8
Xfanout471 _09461_/S fanout474/X VDD VSS sg13g2_buf_1
Xfanout482 _09368_/S fanout486/X VDD VSS sg13g2_buf_1
XFILLER_115_1171 VDD VSS sg13g2_decap_8
XFILLER_120_599 VDD VSS sg13g2_fill_2
X_13962_ _13962_/Q clkload26/A _13962_/D _13962_/RESET_B VDD VSS sg13g2_dfrbpq_1
Xfanout493 _10142_/A1 fanout497/X VDD VSS sg13g2_buf_1
XFILLER_101_780 VDD VSS sg13g2_fill_1
XFILLER_93_439 VDD VSS sg13g2_decap_8
XFILLER_19_536 VDD VSS sg13g2_decap_8
XFILLER_115_1193 VDD VSS sg13g2_decap_8
XFILLER_74_631 VDD VSS sg13g2_decap_8
XFILLER_4_1148 VDD VSS sg13g2_decap_8
XFILLER_150_1084 VDD VSS sg13g2_fill_1
X_12913_ _12914_/C _13600_/B _12911_/B input10/X VDD VSS sg13g2_a21oi_1
XFILLER_185_1103 VDD VSS sg13g2_decap_8
XFILLER_46_344 VDD VSS sg13g2_decap_8
X_13893_ _13893_/Q clkload16/A _13893_/D _13893_/RESET_B VDD VSS sg13g2_dfrbpq_1
XFILLER_62_804 VDD VSS sg13g2_decap_8
XFILLER_41_1390 VDD VSS sg13g2_decap_8
XFILLER_104_91 VDD VSS sg13g2_decap_8
XFILLER_94_1019 VDD VSS sg13g2_decap_4
X_12844_ _12845_/D _12866_/A _12866_/B _12899_/C input23/X VDD VSS sg13g2_nand4_1
XFILLER_61_325 VDD VSS sg13g2_decap_8
XFILLER_73_196 VDD VSS sg13g2_decap_8
XFILLER_15_742 VDD VSS sg13g2_decap_8
XFILLER_163_1401 VDD VSS sg13g2_decap_8
XFILLER_15_753 VDD VSS sg13g2_fill_2
XFILLER_76_1464 VDD VSS sg13g2_decap_8
X_12775_ _12775_/X _12769_/X _12773_/X _12768_/X _12772_/X _12664_/S _12775_/S1 VDD
+ VSS sg13g2_mux4_1
XFILLER_61_369 VDD VSS sg13g2_fill_1
XFILLER_159_213 VDD VSS sg13g2_decap_8
XFILLER_72_1328 VDD VSS sg13g2_decap_8
XFILLER_37_1448 VDD VSS sg13g2_decap_8
XFILLER_14_263 VDD VSS sg13g2_decap_8
X_14514_ _14514_/Q _14514_/CLK _14514_/D _14514_/RESET_B VDD VSS sg13g2_dfrbpq_1
XFILLER_9_35 VDD VSS sg13g2_decap_8
X_11726_ _11773_/D _11726_/A _13678_/Q VDD VSS sg13g2_xnor2_1
XFILLER_163_1478 VDD VSS sg13g2_fill_1
XFILLER_159_268 VDD VSS sg13g2_fill_2
X_14445_ _14445_/Q clkload18/A _14445_/D _14445_/RESET_B VDD VSS sg13g2_dfrbpq_1
X_14069__2133 _14069_/RESET_B VDD VSS sg13g2_tiehi
X_11657_ _11657_/Y _11656_/Y _11655_/Y _11643_/Y _11868_/A _11723_/A2 VDD VSS sg13g2_a221oi_1
XFILLER_80_72 VDD VSS sg13g2_fill_1
XFILLER_80_83 VDD VSS sg13g2_decap_8
XFILLER_30_789 VDD VSS sg13g2_decap_8
XFILLER_70_1063 VDD VSS sg13g2_fill_1
XFILLER_11_981 VDD VSS sg13g2_decap_8
XFILLER_161_1191 VDD VSS sg13g2_decap_8
X_10608_ _14878_/D _10629_/C _10608_/B _10608_/C VDD VSS sg13g2_nor3_1
XFILLER_156_964 VDD VSS sg13g2_decap_8
X_14376_ _14376_/Q clkload21/A _14376_/D _14376_/RESET_B VDD VSS sg13g2_dfrbpq_1
XFILLER_122_1164 VDD VSS sg13g2_fill_2
X_11588_ _14967_/D _11570_/A _11768_/B1 _11587_/Y VDD VSS sg13g2_a21o_1
XFILLER_7_952 VDD VSS sg13g2_decap_8
XFILLER_128_677 VDD VSS sg13g2_decap_8
XFILLER_143_603 VDD VSS sg13g2_decap_8
XFILLER_127_165 VDD VSS sg13g2_fill_2
XFILLER_128_688 VDD VSS sg13g2_fill_1
X_13327_ _13328_/B _15114_/Q _13306_/B _13309_/Y _15067_/Q VDD VSS sg13g2_a22oi_1
XFILLER_116_839 VDD VSS sg13g2_decap_4
X_10539_ _14861_/D _10543_/C _10543_/D _10535_/B _07622_/Y _10608_/B VDD VSS sg13g2_a221oi_1
XFILLER_142_102 VDD VSS sg13g2_decap_8
XFILLER_6_473 VDD VSS sg13g2_decap_8
XFILLER_142_113 VDD VSS sg13g2_fill_2
X_15008__2602 _15008_/RESET_B VDD VSS sg13g2_tiehi
XFILLER_157_1238 VDD VSS sg13g2_decap_8
X_14709__1493 _14709_/RESET_B VDD VSS sg13g2_tiehi
XFILLER_143_658 VDD VSS sg13g2_fill_2
XFILLER_131_809 VDD VSS sg13g2_fill_1
X_13258_ _13259_/B _14924_/Q _13663_/Q VDD VSS sg13g2_xnor2_1
XFILLER_142_157 VDD VSS sg13g2_decap_4
XFILLER_83_1424 VDD VSS sg13g2_decap_8
XFILLER_43_4 VDD VSS sg13g2_decap_8
X_12209_ _12210_/B _14711_/Q _14743_/Q _13783_/Q _13815_/Q _12215_/S0 _12241_/B1 VDD
+ VSS sg13g2_mux4_1
XFILLER_9_1015 VDD VSS sg13g2_decap_8
XFILLER_123_360 VDD VSS sg13g2_decap_8
X_14817__2919 _14817_/RESET_B VDD VSS sg13g2_tiehi
X_13189_ _13189_/X _13189_/A _13189_/B _13225_/B VDD VSS sg13g2_and3_1
XFILLER_170_1438 VDD VSS sg13g2_decap_8
XFILLER_69_447 VDD VSS sg13g2_decap_8
XFILLER_81_1170 VDD VSS sg13g2_decap_8
XFILLER_42_1121 VDD VSS sg13g2_decap_8
XFILLER_111_588 VDD VSS sg13g2_decap_8
XFILLER_96_277 VDD VSS sg13g2_fill_1
XFILLER_84_417 VDD VSS sg13g2_fill_2
XFILLER_133_1260 VDD VSS sg13g2_decap_8
X_15162__2656 _15162_/RESET_B VDD VSS sg13g2_tiehi
X_07750_ _15207_/D _07750_/A _07750_/B VDD VSS sg13g2_or2_1
XFILLER_133_1271 VDD VSS sg13g2_fill_2
X_07681_ _07687_/A _07677_/Y _07680_/Y _11241_/C _11241_/A VDD VSS sg13g2_a22oi_1
XFILLER_93_962 VDD VSS sg13g2_decap_8
XFILLER_65_653 VDD VSS sg13g2_decap_8
XFILLER_37_344 VDD VSS sg13g2_fill_1
X_16879_ _16879_/X _16879_/A VDD VSS sg13g2_buf_1
XFILLER_42_1198 VDD VSS sg13g2_decap_8
XFILLER_92_461 VDD VSS sg13g2_decap_8
XFILLER_20_1452 VDD VSS sg13g2_decap_8
X_09420_ _14022_/D _09686_/A0 _14022_/Q _09434_/S VDD VSS sg13g2_mux2_1
XFILLER_168_1356 VDD VSS sg13g2_decap_8
XFILLER_92_483 VDD VSS sg13g2_fill_2
X_14279__1923 _14279_/RESET_B VDD VSS sg13g2_tiehi
X_09351_ _13955_/D _09914_/A1 _13955_/Q _09364_/S VDD VSS sg13g2_mux2_1
X_08302_ _08625_/B _08138_/A _08234_/Y _08234_/B _08301_/X VDD VSS sg13g2_a22oi_1
X_09282_ _13890_/D _13890_/Q _09814_/A0 _09296_/S VDD VSS sg13g2_mux2_1
XFILLER_100_49 VDD VSS sg13g2_decap_8
XFILLER_21_734 VDD VSS sg13g2_decap_8
X_08233_ _15225_/D _08232_/Y _08233_/B _08233_/C VDD VSS sg13g2_nand3b_1
XFILLER_21_767 VDD VSS sg13g2_fill_2
XFILLER_14_1212 VDD VSS sg13g2_decap_8
XFILLER_119_611 VDD VSS sg13g2_decap_8
XFILLER_147_920 VDD VSS sg13g2_decap_8
XFILLER_18_1392 VDD VSS sg13g2_decap_8
XFILLER_53_1272 VDD VSS sg13g2_decap_8
XFILLER_165_238 VDD VSS sg13g2_decap_8
XFILLER_118_110 VDD VSS sg13g2_decap_8
X_08164_ _08164_/Y _08163_/Y _07871_/X _08395_/A VDD VSS sg13g2_a21oi_1
Xclkbuf_leaf_41_clk_i clkload44/A clkbuf_leaf_42_clk_i/A VDD VSS sg13g2_buf_8
XFILLER_109_25 VDD VSS sg13g2_decap_8
XFILLER_14_1289 VDD VSS sg13g2_decap_8
XFILLER_179_1463 VDD VSS sg13g2_decap_8
XFILLER_118_165 VDD VSS sg13g2_decap_8
X_08095_ _08199_/C _07778_/A _08362_/A3 _14969_/Q _11659_/A _07900_/B _07883_/A VDD
+ VSS sg13g2_mux4_1
XFILLER_119_699 VDD VSS sg13g2_decap_8
XFILLER_162_934 VDD VSS sg13g2_decap_8
Xclkload70 clkload70/Y clkload70/A VDD VSS sg13g2_inv_1
XFILLER_69_18 VDD VSS sg13g2_fill_1
XFILLER_134_658 VDD VSS sg13g2_fill_1
XFILLER_175_1349 VDD VSS sg13g2_decap_8
Xclkload81 clkload81/X clkload81/A VDD VSS sg13g2_buf_8
XFILLER_115_850 VDD VSS sg13g2_decap_8
XFILLER_161_466 VDD VSS sg13g2_decap_8
Xclkbuf_leaf_56_clk_i _15052_/CLK clkload4/A VDD VSS sg13g2_buf_8
XFILLER_0_616 VDD VSS sg13g2_decap_8
XFILLER_138_1160 VDD VSS sg13g2_decap_8
X_13767__2435 _13767_/RESET_B VDD VSS sg13g2_tiehi
XFILLER_142_680 VDD VSS sg13g2_fill_1
X_15209__3000 _15209_/RESET_B VDD VSS sg13g2_tiehi
XFILLER_125_57 VDD VSS sg13g2_fill_2
XFILLER_134_1057 VDD VSS sg13g2_fill_2
X_08997_ _13760_/D _13760_/Q _10143_/A1 _09077_/S VDD VSS sg13g2_mux2_1
XFILLER_60_1210 VDD VSS sg13g2_decap_8
XFILLER_87_266 VDD VSS sg13g2_decap_8
XFILLER_25_1341 VDD VSS sg13g2_decap_8
XFILLER_102_577 VDD VSS sg13g2_decap_8
XFILLER_75_428 VDD VSS sg13g2_decap_8
XFILLER_102_599 VDD VSS sg13g2_decap_8
XFILLER_18_11 VDD VSS sg13g2_decap_8
X_07948_ _07950_/B _07948_/A _08443_/A _07950_/A _07949_/B VDD VSS sg13g2_nand4_1
XFILLER_5_1435 VDD VSS sg13g2_decap_8
XFILLER_29_856 VDD VSS sg13g2_decap_8
XFILLER_60_1287 VDD VSS sg13g2_decap_8
X_14147__2055 _14147_/RESET_B VDD VSS sg13g2_tiehi
XFILLER_55_130 VDD VSS sg13g2_decap_8
X_13982__2220 _13982_/RESET_B VDD VSS sg13g2_tiehi
X_07879_ _07879_/Y _07879_/A _08200_/B VDD VSS sg13g2_xnor2_1
XFILLER_44_804 VDD VSS sg13g2_decap_8
XFILLER_16_506 VDD VSS sg13g2_fill_2
XFILLER_186_1434 VDD VSS sg13g2_decap_8
XFILLER_95_1317 VDD VSS sg13g2_fill_1
XFILLER_18_88 VDD VSS sg13g2_decap_8
XFILLER_44_826 VDD VSS sg13g2_decap_4
X_09618_ _14214_/D _09917_/A1 _14214_/Q _09622_/S VDD VSS sg13g2_mux2_1
X_10890_ _10890_/Y _10890_/A _10890_/B _10890_/C VDD VSS sg13g2_nor3_1
XFILLER_141_89 VDD VSS sg13g2_decap_8
XFILLER_71_656 VDD VSS sg13g2_fill_2
XFILLER_93_1030 VDD VSS sg13g2_decap_8
X_09549_ _14147_/D _09914_/A1 _14147_/Q _09562_/S VDD VSS sg13g2_mux2_1
XFILLER_58_1161 VDD VSS sg13g2_decap_8
XFILLER_34_32 VDD VSS sg13g2_decap_4
XFILLER_184_1191 VDD VSS sg13g2_decap_8
XFILLER_24_572 VDD VSS sg13g2_decap_8
XFILLER_11_200 VDD VSS sg13g2_decap_8
XFILLER_19_1156 VDD VSS sg13g2_decap_8
X_12560_ _12560_/X _14250_/Q _14282_/Q _14314_/Q _14346_/Q _12616_/S0 _12616_/S1 VDD
+ VSS sg13g2_mux4_1
XFILLER_70_188 VDD VSS sg13g2_fill_1
XFILLER_54_1047 VDD VSS sg13g2_decap_8
XFILLER_106_1115 VDD VSS sg13g2_decap_8
XFILLER_157_706 VDD VSS sg13g2_fill_2
X_11511_ _11511_/X _14563_/Q _14595_/Q _14627_/Q _14659_/Q _11514_/S0 _11514_/S1 VDD
+ VSS sg13g2_mux4_1
XFILLER_156_205 VDD VSS sg13g2_decap_8
XFILLER_156_216 VDD VSS sg13g2_fill_2
XFILLER_157_739 VDD VSS sg13g2_decap_8
X_12491_ _12491_/X _14565_/Q _14597_/Q _14629_/Q _14661_/Q _12494_/S0 _12494_/S1 VDD
+ VSS sg13g2_mux4_1
XFILLER_12_789 VDD VSS sg13g2_decap_8
XFILLER_32_1323 VDD VSS sg13g2_decap_8
XFILLER_11_277 VDD VSS sg13g2_decap_8
XFILLER_138_942 VDD VSS sg13g2_fill_2
X_14230_ _14230_/Q clkload75/A _14230_/D _14230_/RESET_B VDD VSS sg13g2_dfrbpq_1
XFILLER_71_1383 VDD VSS sg13g2_decap_8
X_11442_ _11443_/B _13824_/Q _13856_/Q _13888_/Q _13920_/Q _12105_/A1 _12103_/B1 VDD
+ VSS sg13g2_mux4_1
XFILLER_7_259 VDD VSS sg13g2_decap_8
XFILLER_119_0 VDD VSS sg13g2_decap_8
XFILLER_166_42 VDD VSS sg13g2_decap_8
X_14161_ _14161_/Q clkload33/A _14161_/D _14161_/RESET_B VDD VSS sg13g2_dfrbpq_1
X_11373_ _11374_/B _11373_/A _14206_/Q VDD VSS sg13g2_nand2_1
XFILLER_125_625 VDD VSS sg13g2_decap_8
XFILLER_50_86 VDD VSS sg13g2_decap_8
XFILLER_137_496 VDD VSS sg13g2_fill_1
XFILLER_153_956 VDD VSS sg13g2_fill_1
XFILLER_164_282 VDD VSS sg13g2_fill_1
XFILLER_3_410 VDD VSS sg13g2_decap_8
XFILLER_152_433 VDD VSS sg13g2_decap_8
X_13112_ _13172_/C _13112_/A _13104_/A VDD VSS sg13g2_nor2b_1
X_10324_ _10325_/B _14799_/Q _14800_/Q _14801_/Q _10405_/C VDD VSS sg13g2_nand4_1
XFILLER_152_444 VDD VSS sg13g2_fill_2
XFILLER_30_1091 VDD VSS sg13g2_fill_2
XFILLER_153_978 VDD VSS sg13g2_decap_8
X_14092_ _14092_/Q _14670_/CLK _14092_/D _14092_/RESET_B VDD VSS sg13g2_dfrbpq_1
XFILLER_98_509 VDD VSS sg13g2_decap_8
XFILLER_4_966 VDD VSS sg13g2_decap_8
XFILLER_69_1290 VDD VSS sg13g2_decap_8
XFILLER_106_872 VDD VSS sg13g2_decap_8
XFILLER_1_0 VDD VSS sg13g2_decap_8
XFILLER_117_1200 VDD VSS sg13g2_decap_8
X_13043_ _13043_/Y _13041_/Y _13043_/B _13079_/C VDD VSS sg13g2_nand3b_1
X_10255_ _10265_/D _14778_/Q _14779_/Q _14780_/Q _10255_/D VDD VSS sg13g2_nand4_1
XFILLER_156_1260 VDD VSS sg13g2_decap_8
XFILLER_79_723 VDD VSS sg13g2_decap_4
XFILLER_105_371 VDD VSS sg13g2_fill_2
X_14357__1845 _14357_/RESET_B VDD VSS sg13g2_tiehi
XFILLER_3_487 VDD VSS sg13g2_decap_8
XFILLER_152_1113 VDD VSS sg13g2_decap_8
Xfanout1200 _12899_/A _12799_/A VDD VSS sg13g2_buf_1
XFILLER_65_1165 VDD VSS sg13g2_decap_8
XFILLER_26_1116 VDD VSS sg13g2_decap_8
Xfanout1211 _12957_/A _14904_/Q VDD VSS sg13g2_buf_1
Xfanout1222 _10564_/D _14857_/Q VDD VSS sg13g2_buf_1
X_10186_ _14749_/D _10185_/Y _14749_/Q _08861_/S VDD VSS sg13g2_a21o_1
XFILLER_39_609 VDD VSS sg13g2_fill_2
XFILLER_152_1146 VDD VSS sg13g2_decap_8
XFILLER_182_74 VDD VSS sg13g2_decap_8
Xfanout1233 _10206_/A1 _14761_/Q VDD VSS sg13g2_buf_1
XFILLER_120_352 VDD VSS sg13g2_fill_1
Xfanout1244 _11974_/B1 _11446_/A VDD VSS sg13g2_buf_1
Xfanout1255 fanout1255/X _13661_/Q VDD VSS sg13g2_buf_1
XFILLER_43_1441 VDD VSS sg13g2_decap_8
XFILLER_38_108 VDD VSS sg13g2_decap_8
Xfanout1266 _12092_/C _11351_/C1 VDD VSS sg13g2_buf_1
XFILLER_93_214 VDD VSS sg13g2_decap_8
X_14994_ _14994_/Q _15230_/CLK _14994_/D _14994_/RESET_B VDD VSS sg13g2_dfrbpq_1
Xfanout1277 _11580_/S1 fanout1280/X VDD VSS sg13g2_buf_1
XFILLER_78_299 VDD VSS sg13g2_fill_1
Xfanout290 _10147_/A1 _10080_/A0 VDD VSS sg13g2_buf_1
Xfanout1288 _11444_/S1 _11368_/S1 VDD VSS sg13g2_buf_1
XFILLER_94_759 VDD VSS sg13g2_fill_2
XFILLER_130_1433 VDD VSS sg13g2_decap_8
Xfanout1299 _11366_/C _11368_/S1 VDD VSS sg13g2_buf_1
X_13945_ _13945_/Q _14745_/CLK _13945_/D _13945_/RESET_B VDD VSS sg13g2_dfrbpq_1
XFILLER_75_962 VDD VSS sg13g2_decap_8
XFILLER_19_355 VDD VSS sg13g2_decap_8
X_14572__1630 _14572_/RESET_B VDD VSS sg13g2_tiehi
XFILLER_62_623 VDD VSS sg13g2_decap_8
X_13876_ _13876_/Q clkload15/A _13876_/D _13876_/RESET_B VDD VSS sg13g2_dfrbpq_1
XFILLER_61_122 VDD VSS sg13g2_fill_2
XFILLER_46_196 VDD VSS sg13g2_decap_8
XFILLER_90_965 VDD VSS sg13g2_decap_8
X_12827_ _12828_/A input26/X _12841_/B _12803_/X input5/X _12826_/X VDD VSS sg13g2_a221oi_1
XFILLER_62_667 VDD VSS sg13g2_decap_8
XFILLER_76_1261 VDD VSS sg13g2_decap_8
XFILLER_62_678 VDD VSS sg13g2_fill_2
XFILLER_43_870 VDD VSS sg13g2_fill_1
XFILLER_61_177 VDD VSS sg13g2_decap_8
XFILLER_37_1245 VDD VSS sg13g2_decap_8
X_12758_ _12758_/X _14136_/Q _14168_/Q _14200_/Q _14232_/Q _12759_/S0 _12759_/S1 VDD
+ VSS sg13g2_mux4_1
XFILLER_163_1275 VDD VSS sg13g2_decap_8
X_13845__2357 _13845_/RESET_B VDD VSS sg13g2_tiehi
X_11709_ _11709_/X _13737_/Q _14089_/Q _14441_/Q _14537_/Q _11715_/S0 _11715_/S1 VDD
+ VSS sg13g2_mux4_1
XFILLER_129_920 VDD VSS sg13g2_decap_8
XFILLER_147_216 VDD VSS sg13g2_decap_8
XFILLER_148_739 VDD VSS sg13g2_decap_4
XFILLER_147_227 VDD VSS sg13g2_fill_2
X_12689_ _12689_/X _14259_/Q _14291_/Q _14323_/Q _14355_/Q _12711_/S0 _12711_/S1 VDD
+ VSS sg13g2_mux4_1
X_14428_ _14428_/Q clkload77/A _14428_/D _14428_/RESET_B VDD VSS sg13g2_dfrbpq_1
XFILLER_50_1456 VDD VSS sg13g2_decap_8
XFILLER_128_452 VDD VSS sg13g2_fill_1
XFILLER_11_1429 VDD VSS sg13g2_decap_8
X_14359_ _14359_/Q clkload41/A _14359_/D _14359_/RESET_B VDD VSS sg13g2_dfrbpq_1
XFILLER_144_945 VDD VSS sg13g2_decap_8
XFILLER_144_956 VDD VSS sg13g2_fill_2
XFILLER_6_270 VDD VSS sg13g2_decap_8
XFILLER_170_230 VDD VSS sg13g2_decap_8
XFILLER_157_1046 VDD VSS sg13g2_fill_2
XFILLER_83_1221 VDD VSS sg13g2_decap_8
XFILLER_100_1292 VDD VSS sg13g2_decap_8
XFILLER_171_797 VDD VSS sg13g2_decap_8
X_08920_ _13712_/D _16874_/A _08919_/X _08932_/S VDD VSS sg13g2_mux2_1
XFILLER_143_499 VDD VSS sg13g2_decap_8
XFILLER_124_680 VDD VSS sg13g2_decap_8
XFILLER_130_116 VDD VSS sg13g2_decap_8
XFILLER_48_1363 VDD VSS sg13g2_decap_8
XFILLER_174_1371 VDD VSS sg13g2_decap_8
XFILLER_97_531 VDD VSS sg13g2_fill_1
XFILLER_34_0 VDD VSS sg13g2_decap_8
XFILLER_111_330 VDD VSS sg13g2_decap_8
XFILLER_123_190 VDD VSS sg13g2_fill_1
XFILLER_170_1235 VDD VSS sg13g2_decap_8
X_08851_ _13695_/D _16857_/A _08850_/X _08861_/S VDD VSS sg13g2_mux2_1
XFILLER_97_553 VDD VSS sg13g2_decap_8
XFILLER_69_244 VDD VSS sg13g2_fill_2
XFILLER_83_1298 VDD VSS sg13g2_decap_8
XFILLER_44_1249 VDD VSS sg13g2_decap_8
X_07802_ _07949_/B _08471_/B _15008_/Q VDD VSS sg13g2_nand2b_1
XFILLER_97_586 VDD VSS sg13g2_decap_8
XFILLER_69_277 VDD VSS sg13g2_fill_1
X_08782_ _08782_/Y _07649_/A _14759_/Q _13391_/A _07719_/X VDD VSS sg13g2_a22oi_1
XFILLER_66_951 VDD VSS sg13g2_decap_4
XFILLER_133_1090 VDD VSS sg13g2_decap_8
X_07733_ _07734_/C _15097_/Q _15077_/Q _15075_/Q _15092_/Q VDD VSS sg13g2_nor4_1
XFILLER_26_804 VDD VSS sg13g2_decap_4
XFILLER_65_461 VDD VSS sg13g2_fill_2
XFILLER_37_152 VDD VSS sg13g2_decap_4
X_14402__1800 _14402_/RESET_B VDD VSS sg13g2_tiehi
XFILLER_0_1310 VDD VSS sg13g2_decap_8
XFILLER_1_91 VDD VSS sg13g2_decap_8
XFILLER_168_1153 VDD VSS sg13g2_decap_8
X_07664_ _13508_/B _13613_/B _13613_/C VDD VSS sg13g2_nor2_1
XFILLER_25_325 VDD VSS sg13g2_decap_8
XFILLER_80_420 VDD VSS sg13g2_decap_8
XFILLER_65_494 VDD VSS sg13g2_decap_4
XFILLER_164_1006 VDD VSS sg13g2_decap_8
X_09403_ _14006_/D _10098_/A0 _14006_/Q _09407_/S VDD VSS sg13g2_mux2_1
XFILLER_0_1387 VDD VSS sg13g2_decap_8
XFILLER_34_870 VDD VSS sg13g2_decap_8
XFILLER_40_317 VDD VSS sg13g2_fill_1
XFILLER_179_853 VDD VSS sg13g2_decap_8
X_09334_ _13941_/D _09899_/A0 _13941_/Q _09337_/S VDD VSS sg13g2_mux2_1
XFILLER_80_497 VDD VSS sg13g2_decap_8
XFILLER_107_1424 VDD VSS sg13g2_decap_8
XFILLER_146_1473 VDD VSS sg13g2_fill_2
XFILLER_178_341 VDD VSS sg13g2_decap_8
XFILLER_55_1356 VDD VSS sg13g2_decap_8
XFILLER_90_1269 VDD VSS sg13g2_fill_1
XFILLER_139_739 VDD VSS sg13g2_decap_8
XFILLER_181_1386 VDD VSS sg13g2_decap_8
X_09265_ _13874_/D _13874_/Q _10161_/A1 _09272_/S VDD VSS sg13g2_mux2_1
X_14435__1767 _14435_/RESET_B VDD VSS sg13g2_tiehi
X_08216_ _08544_/A _08138_/A _08215_/X _08301_/S VDD VSS sg13g2_mux2_1
X_09196_ _13812_/D _13812_/Q _09931_/A1 _09196_/S VDD VSS sg13g2_mux2_1
XFILLER_135_901 VDD VSS sg13g2_fill_1
XFILLER_101_1023 VDD VSS sg13g2_fill_2
XFILLER_140_1072 VDD VSS sg13g2_decap_8
XFILLER_112_7 VDD VSS sg13g2_decap_4
XFILLER_140_1083 VDD VSS sg13g2_fill_1
XFILLER_146_260 VDD VSS sg13g2_fill_1
XFILLER_14_1086 VDD VSS sg13g2_decap_8
X_08147_ _08147_/Y _08599_/B _08013_/X _08146_/X VDD VSS sg13g2_a21oi_1
XFILLER_134_411 VDD VSS sg13g2_decap_8
XFILLER_179_1260 VDD VSS sg13g2_decap_8
XFILLER_106_113 VDD VSS sg13g2_decap_8
XFILLER_162_742 VDD VSS sg13g2_decap_8
XFILLER_88_1165 VDD VSS sg13g2_fill_2
XFILLER_88_1176 VDD VSS sg13g2_fill_1
XFILLER_84_1007 VDD VSS sg13g2_fill_1
XFILLER_20_56 VDD VSS sg13g2_decap_8
X_08078_ _15219_/D _08068_/Y _08078_/B _08078_/C VDD VSS sg13g2_nand3b_1
XFILLER_134_466 VDD VSS sg13g2_decap_8
XFILLER_135_989 VDD VSS sg13g2_decap_8
XFILLER_175_1146 VDD VSS sg13g2_decap_8
XFILLER_1_903 VDD VSS sg13g2_decap_8
XFILLER_106_168 VDD VSS sg13g2_decap_8
X_14650__1552 _14650_/RESET_B VDD VSS sg13g2_tiehi
XFILLER_122_628 VDD VSS sg13g2_decap_8
XFILLER_161_263 VDD VSS sg13g2_decap_8
XFILLER_153_1400 VDD VSS sg13g2_decap_8
XFILLER_66_1452 VDD VSS sg13g2_decap_8
XFILLER_0_413 VDD VSS sg13g2_decap_8
XFILLER_103_820 VDD VSS sg13g2_fill_1
XFILLER_88_520 VDD VSS sg13g2_fill_1
XFILLER_27_1425 VDD VSS sg13g2_decap_8
X_10040_ _14621_/D _10040_/A0 _14621_/Q _10068_/S VDD VSS sg13g2_mux2_1
XFILLER_88_553 VDD VSS sg13g2_decap_4
XFILLER_62_1327 VDD VSS sg13g2_decap_8
XFILLER_29_21 VDD VSS sg13g2_decap_8
XFILLER_49_929 VDD VSS sg13g2_decap_8
XFILLER_102_363 VDD VSS sg13g2_fill_2
XFILLER_5_1232 VDD VSS sg13g2_decap_8
XFILLER_29_642 VDD VSS sg13g2_fill_1
X_13923__2279 _13923_/RESET_B VDD VSS sg13g2_tiehi
X_11991_ _11991_/X _13969_/Q _14001_/Q _14033_/Q _14065_/Q _11997_/S0 _11997_/S1 VDD
+ VSS sg13g2_mux4_1
XFILLER_29_664 VDD VSS sg13g2_decap_8
XFILLER_72_910 VDD VSS sg13g2_decap_8
XFILLER_57_995 VDD VSS sg13g2_decap_4
XFILLER_186_1231 VDD VSS sg13g2_decap_8
XFILLER_21_1068 VDD VSS sg13g2_decap_8
X_13730_ _13730_/Q clkload7/A _13730_/D _13730_/RESET_B VDD VSS sg13g2_dfrbpq_1
XFILLER_84_781 VDD VSS sg13g2_decap_8
XFILLER_17_848 VDD VSS sg13g2_decap_8
X_10942_ _10942_/Y _10954_/C _14758_/Q VDD VSS sg13g2_nor2b_1
XFILLER_147_1204 VDD VSS sg13g2_fill_2
XFILLER_28_196 VDD VSS sg13g2_decap_8
XFILLER_182_1117 VDD VSS sg13g2_decap_8
X_13661_ _13661_/Q _15188_/CLK _13661_/D _13661_/RESET_B VDD VSS sg13g2_dfrbpq_1
XFILLER_95_1169 VDD VSS sg13g2_fill_2
XFILLER_147_1248 VDD VSS sg13g2_fill_1
X_10873_ _10873_/Y _10797_/C _10871_/A _10912_/B1 VDD VSS sg13g2_o21ai_1
XFILLER_44_678 VDD VSS sg13g2_decap_8
XFILLER_72_998 VDD VSS sg13g2_decap_4
XFILLER_43_166 VDD VSS sg13g2_fill_2
XFILLER_73_1423 VDD VSS sg13g2_decap_8
X_12612_ _12625_/A _12639_/A1 _12639_/A2 _15008_/Q VDD VSS sg13g2_a21oi_1
X_13592_ _13592_/Y _15004_/Q _13592_/A2 _13561_/S _08692_/C _13545_/X VDD VSS sg13g2_a221oi_1
XFILLER_185_801 VDD VSS sg13g2_decap_8
XFILLER_34_1418 VDD VSS sg13g2_decap_8
XFILLER_12_542 VDD VSS sg13g2_decap_8
XFILLER_160_1437 VDD VSS sg13g2_decap_8
X_12543_ _12543_/X _13833_/Q _13865_/Q _13897_/Q _13929_/Q _12550_/S0 _12550_/S1 VDD
+ VSS sg13g2_mux4_1
XFILLER_61_63 VDD VSS sg13g2_decap_4
XFILLER_40_884 VDD VSS sg13g2_decap_8
XFILLER_32_1120 VDD VSS sg13g2_decap_8
XFILLER_71_1180 VDD VSS sg13g2_decap_8
XFILLER_138_750 VDD VSS sg13g2_fill_1
XFILLER_157_569 VDD VSS sg13g2_decap_8
XFILLER_185_878 VDD VSS sg13g2_decap_8
X_12474_ _12474_/X _13956_/Q _13988_/Q _14020_/Q _14052_/Q _12480_/S0 _12480_/S1 VDD
+ VSS sg13g2_mux4_1
XFILLER_8_557 VDD VSS sg13g2_decap_8
XFILLER_126_901 VDD VSS sg13g2_decap_4
XFILLER_177_74 VDD VSS sg13g2_decap_8
XFILLER_184_366 VDD VSS sg13g2_decap_8
XFILLER_185_889 VDD VSS sg13g2_fill_2
XFILLER_123_1270 VDD VSS sg13g2_fill_1
X_14213_ _14213_/Q clkload17/A _14213_/D _14213_/RESET_B VDD VSS sg13g2_dfrbpq_1
XFILLER_6_25 VDD VSS sg13g2_decap_8
X_11425_ _11425_/Y _11425_/A _11425_/B _11425_/C VDD VSS sg13g2_nand3_1
XFILLER_126_934 VDD VSS sg13g2_fill_2
X_15193_ _15193_/Q _15214_/CLK _15193_/D _15193_/RESET_B VDD VSS sg13g2_dfrbpq_1
XANTENNA_7 _09294_/S VDD VSS sg13g2_antennanp
XFILLER_32_1197 VDD VSS sg13g2_decap_8
XFILLER_158_1333 VDD VSS sg13g2_decap_8
X_14144_ _14144_/Q _15230_/CLK _14144_/D _14144_/RESET_B VDD VSS sg13g2_dfrbpq_1
XFILLER_67_1227 VDD VSS sg13g2_decap_8
XFILLER_119_1306 VDD VSS sg13g2_decap_4
XFILLER_125_455 VDD VSS sg13g2_decap_4
X_11356_ _11356_/Y _11355_/Y _11354_/Y _11359_/B VDD VSS sg13g2_a21oi_1
XFILLER_119_1317 VDD VSS sg13g2_fill_2
XFILLER_4_763 VDD VSS sg13g2_decap_8
X_10307_ _10307_/Y _14796_/Q _10327_/B _10544_/C VDD VSS sg13g2_o21ai_1
XFILLER_98_328 VDD VSS sg13g2_decap_8
XFILLER_180_594 VDD VSS sg13g2_decap_8
X_14075_ _14075_/Q clkload78/A _14075_/D _14075_/RESET_B VDD VSS sg13g2_dfrbpq_1
XFILLER_106_680 VDD VSS sg13g2_fill_1
X_11287_ _11287_/Y _11287_/A _11287_/B _11425_/B VDD VSS sg13g2_nand3_1
XFILLER_80_1405 VDD VSS sg13g2_decap_8
XFILLER_3_284 VDD VSS sg13g2_decap_8
XFILLER_140_458 VDD VSS sg13g2_decap_8
X_13026_ _13026_/Y _13026_/A _13057_/A _13026_/C VDD VSS sg13g2_nor3_1
X_10238_ _10238_/Y _10237_/B _10234_/Y _10322_/C VDD VSS sg13g2_o21ai_1
Xfanout1030 _08969_/C fanout1031/X VDD VSS sg13g2_buf_1
XFILLER_67_715 VDD VSS sg13g2_decap_8
XFILLER_39_406 VDD VSS sg13g2_fill_1
XFILLER_79_586 VDD VSS sg13g2_decap_8
Xfanout1041 _08692_/C _15020_/Q VDD VSS sg13g2_buf_1
Xfanout1052 _08201_/A _12403_/B1 VDD VSS sg13g2_buf_1
X_10169_ _14746_/D _14746_/Q _10169_/A1 _10169_/S VDD VSS sg13g2_mux2_1
XFILLER_94_523 VDD VSS sg13g2_decap_8
Xfanout1063 _08200_/A _08360_/A1 VDD VSS sg13g2_buf_1
Xfanout1074 _08194_/B _08196_/A1 VDD VSS sg13g2_buf_1
XFILLER_130_1230 VDD VSS sg13g2_decap_4
Xfanout1085 _08402_/A _08084_/S1 VDD VSS sg13g2_buf_1
Xfanout1096 _08151_/S1 _08083_/S0 VDD VSS sg13g2_buf_1
XFILLER_48_962 VDD VSS sg13g2_fill_1
X_14513__1689 _14513_/RESET_B VDD VSS sg13g2_tiehi
X_14977_ _14977_/Q clkload32/A _14977_/D _14977_/RESET_B VDD VSS sg13g2_dfrbpq_1
XFILLER_81_217 VDD VSS sg13g2_decap_8
XFILLER_19_163 VDD VSS sg13g2_decap_8
XFILLER_130_1285 VDD VSS sg13g2_decap_8
X_13928_ _13928_/Q clkload21/A _13928_/D _13928_/RESET_B VDD VSS sg13g2_dfrbpq_1
XFILLER_169_1462 VDD VSS sg13g2_decap_8
XFILLER_78_1345 VDD VSS sg13g2_decap_8
XFILLER_35_634 VDD VSS sg13g2_decap_8
XFILLER_169_1473 VDD VSS sg13g2_fill_2
XFILLER_63_954 VDD VSS sg13g2_fill_2
XFILLER_165_1315 VDD VSS sg13g2_decap_8
XFILLER_39_1329 VDD VSS sg13g2_decap_8
X_14767__2969 _14767_/RESET_B VDD VSS sg13g2_tiehi
XFILLER_179_116 VDD VSS sg13g2_decap_8
X_13859_ _13859_/Q _14725_/CLK _13859_/D _13859_/RESET_B VDD VSS sg13g2_dfrbpq_1
XFILLER_22_306 VDD VSS sg13g2_fill_1
XFILLER_63_998 VDD VSS sg13g2_decap_8
XFILLER_50_626 VDD VSS sg13g2_decap_4
XFILLER_50_648 VDD VSS sg13g2_decap_8
XFILLER_37_1053 VDD VSS sg13g2_fill_2
XFILLER_37_1097 VDD VSS sg13g2_decap_8
X_09050_ _09050_/X _14908_/Q _09056_/C _09049_/Y VDD VSS sg13g2_a21o_1
XFILLER_15_1362 VDD VSS sg13g2_decap_8
XFILLER_30_394 VDD VSS sg13g2_decap_8
XFILLER_175_366 VDD VSS sg13g2_decap_8
XFILLER_50_1253 VDD VSS sg13g2_decap_8
XFILLER_117_912 VDD VSS sg13g2_decap_8
X_08001_ _08001_/Y _08001_/A _08275_/B _08001_/C _08001_/D VDD VSS sg13g2_nand4_1
XFILLER_102_1332 VDD VSS sg13g2_decap_8
XFILLER_135_219 VDD VSS sg13g2_decap_8
XFILLER_141_1381 VDD VSS sg13g2_decap_4
XFILLER_11_1226 VDD VSS sg13g2_decap_8
XFILLER_116_433 VDD VSS sg13g2_fill_2
XFILLER_144_742 VDD VSS sg13g2_decap_8
XFILLER_176_1422 VDD VSS sg13g2_decap_8
XFILLER_117_978 VDD VSS sg13g2_decap_8
XFILLER_85_1327 VDD VSS sg13g2_decap_8
XFILLER_89_306 VDD VSS sg13g2_decap_8
XFILLER_104_628 VDD VSS sg13g2_decap_8
XFILLER_132_937 VDD VSS sg13g2_decap_8
XFILLER_143_274 VDD VSS sg13g2_fill_1
XFILLER_172_1319 VDD VSS sg13g2_decap_8
X_09952_ _14536_/D _14536_/Q _10084_/A0 _09958_/S VDD VSS sg13g2_mux2_1
XFILLER_48_1160 VDD VSS sg13g2_decap_8
XFILLER_98_840 VDD VSS sg13g2_decap_4
X_08903_ _08903_/X _15039_/Q _14943_/Q _10735_/A VDD VSS sg13g2_mux2_1
X_09883_ _14469_/D _09916_/A1 _14469_/Q _09894_/S VDD VSS sg13g2_mux2_1
XFILLER_98_873 VDD VSS sg13g2_fill_2
XFILLER_100_801 VDD VSS sg13g2_decap_8
XFILLER_112_661 VDD VSS sg13g2_decap_8
XFILLER_97_350 VDD VSS sg13g2_fill_2
XFILLER_58_715 VDD VSS sg13g2_decap_8
XFILLER_97_372 VDD VSS sg13g2_fill_1
X_08834_ _08834_/X _08835_/A _08835_/B VDD VSS sg13g2_and2_1
XFILLER_111_182 VDD VSS sg13g2_decap_4
XFILLER_22_1300 VDD VSS sg13g2_decap_8
XFILLER_100_856 VDD VSS sg13g2_fill_2
XFILLER_131_1038 VDD VSS sg13g2_decap_8
XFILLER_85_556 VDD VSS sg13g2_decap_8
XFILLER_57_247 VDD VSS sg13g2_fill_1
XFILLER_73_707 VDD VSS sg13g2_decap_8
XFILLER_57_258 VDD VSS sg13g2_fill_1
XFILLER_39_962 VDD VSS sg13g2_decap_8
X_08765_ _13673_/D _08765_/A1 _08763_/Y _08764_/Y VDD VSS sg13g2_a21oi_1
XFILLER_61_1393 VDD VSS sg13g2_decap_8
XFILLER_45_409 VDD VSS sg13g2_decap_8
XFILLER_100_889 VDD VSS sg13g2_decap_8
XFILLER_22_1377 VDD VSS sg13g2_decap_8
X_07716_ _08049_/A _15102_/Q _15094_/Q VDD VSS sg13g2_nor2_1
XFILLER_96_1434 VDD VSS sg13g2_decap_8
XFILLER_2_1449 VDD VSS sg13g2_decap_8
X_08696_ _08696_/Y _15019_/Q _12278_/A _08698_/B VDD VSS sg13g2_a21oi_1
XFILLER_82_18 VDD VSS sg13g2_decap_8
XFILLER_81_762 VDD VSS sg13g2_decap_8
XFILLER_57_1429 VDD VSS sg13g2_decap_8
X_07647_ _07647_/Y _14806_/Q VDD VSS sg13g2_inv_1
XFILLER_0_1184 VDD VSS sg13g2_decap_8
XFILLER_55_1120 VDD VSS sg13g2_fill_1
XFILLER_186_609 VDD VSS sg13g2_decap_8
XFILLER_107_1210 VDD VSS sg13g2_decap_8
XFILLER_15_56 VDD VSS sg13g2_decap_8
X_14668__1534 _14668_/RESET_B VDD VSS sg13g2_tiehi
XFILLER_146_1270 VDD VSS sg13g2_decap_8
XFILLER_55_1153 VDD VSS sg13g2_decap_8
XFILLER_146_1281 VDD VSS sg13g2_decap_8
XFILLER_185_119 VDD VSS sg13g2_decap_8
X_09317_ _13924_/D _10080_/A0 _13924_/Q _09325_/S VDD VSS sg13g2_mux2_1
XFILLER_142_1134 VDD VSS sg13g2_fill_2
XFILLER_181_1183 VDD VSS sg13g2_decap_8
XFILLER_166_322 VDD VSS sg13g2_decap_8
XFILLER_16_1148 VDD VSS sg13g2_decap_8
XFILLER_22_884 VDD VSS sg13g2_fill_1
XFILLER_107_1265 VDD VSS sg13g2_decap_8
XFILLER_127_709 VDD VSS sg13g2_fill_2
X_09248_ _13857_/D _13857_/Q _09978_/A0 _09263_/S VDD VSS sg13g2_mux2_1
XFILLER_142_1178 VDD VSS sg13g2_decap_4
XFILLER_154_506 VDD VSS sg13g2_decap_8
X_14812__2924 _14812_/RESET_B VDD VSS sg13g2_tiehi
XFILLER_177_1219 VDD VSS sg13g2_decap_8
X_09179_ _13795_/D _13795_/Q _10146_/A1 _09189_/S VDD VSS sg13g2_mux2_1
XFILLER_108_945 VDD VSS sg13g2_fill_1
XFILLER_31_77 VDD VSS sg13g2_decap_8
XFILLER_147_55 VDD VSS sg13g2_decap_8
X_11210_ _11210_/X _13947_/Q _13979_/Q _14011_/Q _14043_/Q _11218_/S _12307_/C VDD
+ VSS sg13g2_mux4_1
XFILLER_135_753 VDD VSS sg13g2_decap_8
X_12190_ _12190_/Y _12190_/A _12190_/B VDD VSS sg13g2_nand2_1
XFILLER_134_241 VDD VSS sg13g2_decap_8
XFILLER_107_466 VDD VSS sg13g2_decap_8
XFILLER_150_701 VDD VSS sg13g2_fill_1
X_15036__2574 _15036_/RESET_B VDD VSS sg13g2_tiehi
XFILLER_1_700 VDD VSS sg13g2_decap_8
X_11141_ _11141_/X _11163_/A _11193_/A2 _11168_/B1 VDD VSS sg13g2_a21o_1
Xoutput44 mem_axi_araddr[15] _16868_/A VDD VSS sg13g2_buf_1
Xoutput55 mem_axi_araddr[26] _16879_/A VDD VSS sg13g2_buf_1
XFILLER_0_210 VDD VSS sg13g2_decap_8
XFILLER_163_21 VDD VSS sg13g2_decap_8
Xoutput66 mem_axi_araddr[7] _16860_/A VDD VSS sg13g2_buf_1
XFILLER_27_1222 VDD VSS sg13g2_decap_8
Xoutput77 mem_axi_awaddr[16] _16869_/X VDD VSS sg13g2_buf_1
X_11072_ _11072_/Y _11109_/B _11070_/Y _11071_/Y VDD VSS sg13g2_a21oi_1
XFILLER_150_778 VDD VSS sg13g2_fill_1
Xoutput88 mem_axi_awaddr[27] _16880_/X VDD VSS sg13g2_buf_1
XFILLER_1_777 VDD VSS sg13g2_decap_8
Xoutput99 mem_axi_awaddr[8] _16861_/X VDD VSS sg13g2_buf_1
XFILLER_7_1316 VDD VSS sg13g2_decap_8
Xhold3160 _11170_/A _14954_/Q VDD VSS sg13g2_dlygate4sd3_1
X_14900_ _14900_/Q _14930_/CLK _14900_/D _14900_/RESET_B VDD VSS sg13g2_dfrbpq_1
Xhold3171 _10973_/A _14940_/Q VDD VSS sg13g2_dlygate4sd3_1
X_10023_ _14605_/D _10023_/A0 _14605_/Q _10023_/S VDD VSS sg13g2_mux2_1
XFILLER_0_287 VDD VSS sg13g2_decap_8
XFILLER_163_98 VDD VSS sg13g2_decap_8
XFILLER_48_236 VDD VSS sg13g2_fill_2
XFILLER_27_1299 VDD VSS sg13g2_decap_8
XFILLER_186_0 VDD VSS sg13g2_decap_8
X_14831_ _14831_/Q _14848_/CLK _14831_/D _14831_/RESET_B VDD VSS sg13g2_dfrbpq_1
XFILLER_97_1209 VDD VSS sg13g2_decap_8
XFILLER_56_63 VDD VSS sg13g2_fill_1
XFILLER_40_1466 VDD VSS sg13g2_decap_8
X_14762_ _14762_/Q clkload22/A _14762_/D _14762_/RESET_B VDD VSS sg13g2_dfrbpq_1
XFILLER_57_792 VDD VSS sg13g2_fill_2
XFILLER_56_85 VDD VSS sg13g2_decap_8
X_11974_ _11975_/B _11971_/Y _11973_/Y _11974_/B1 VDD VSS sg13g2_a21oi_1
XFILLER_44_420 VDD VSS sg13g2_fill_2
XFILLER_91_559 VDD VSS sg13g2_decap_4
XFILLER_186_1050 VDD VSS sg13g2_decap_8
X_13713_ _16875_/A _14602_/CLK _13713_/D _13713_/RESET_B VDD VSS sg13g2_dfrbpq_1
XFILLER_72_751 VDD VSS sg13g2_decap_8
X_10925_ _10926_/B _10954_/A _10954_/D _10924_/Y VDD VSS sg13g2_o21ai_1
X_14693_ _14693_/Q _14725_/CLK _14693_/D _14693_/RESET_B VDD VSS sg13g2_dfrbpq_1
XFILLER_71_250 VDD VSS sg13g2_fill_1
XFILLER_16_177 VDD VSS sg13g2_decap_8
XFILLER_71_272 VDD VSS sg13g2_decap_8
X_13644_ _13752_/D _13644_/A VDD VSS sg13g2_buf_1
XFILLER_73_1220 VDD VSS sg13g2_decap_8
X_10856_ _10857_/B _14752_/Q _10870_/A VDD VSS sg13g2_xnor2_1
XFILLER_176_119 VDD VSS sg13g2_decap_8
XFILLER_38_1384 VDD VSS sg13g2_decap_8
XFILLER_34_1215 VDD VSS sg13g2_decap_8
XFILLER_31_158 VDD VSS sg13g2_decap_8
XFILLER_12_350 VDD VSS sg13g2_decap_8
XFILLER_164_1392 VDD VSS sg13g2_decap_8
X_13575_ _13575_/Y _15157_/Q _13593_/B VDD VSS sg13g2_nor2_1
X_14763__2975 _14763_/RESET_B VDD VSS sg13g2_tiehi
XFILLER_125_1354 VDD VSS sg13g2_fill_2
XFILLER_160_1234 VDD VSS sg13g2_decap_8
X_10787_ _14923_/D _10787_/A VDD VSS sg13g2_inv_1
XFILLER_9_833 VDD VSS sg13g2_decap_8
XFILLER_125_1365 VDD VSS sg13g2_decap_8
XFILLER_73_1297 VDD VSS sg13g2_decap_8
XFILLER_40_681 VDD VSS sg13g2_fill_1
X_12526_ _12527_/B _13681_/Q _12651_/A2 _12525_/X _12386_/A _12651_/C1 VDD VSS sg13g2_a221oi_1
XFILLER_40_692 VDD VSS sg13g2_decap_8
XFILLER_158_878 VDD VSS sg13g2_decap_8
X_13762__2440 _13762_/RESET_B VDD VSS sg13g2_tiehi
XFILLER_75_7 VDD VSS sg13g2_decap_8
XFILLER_8_354 VDD VSS sg13g2_decap_8
XFILLER_172_303 VDD VSS sg13g2_decap_8
XFILLER_184_163 VDD VSS sg13g2_decap_8
X_15245_ _15245_/Q clkload48/A _15245_/D _15245_/RESET_B VDD VSS sg13g2_dfrbpq_1
XFILLER_145_539 VDD VSS sg13g2_fill_2
X_12457_ _14996_/D _12457_/A _12457_/B VDD VSS sg13g2_nor2_1
XFILLER_173_859 VDD VSS sg13g2_decap_8
XFILLER_126_731 VDD VSS sg13g2_decap_8
XFILLER_138_591 VDD VSS sg13g2_decap_8
XFILLER_67_1002 VDD VSS sg13g2_decap_8
X_11408_ _11408_/Y _11826_/A1 _14399_/Q _11374_/C VDD VSS sg13g2_a21oi_1
X_15176_ _15176_/Q clkload87/A _15176_/D _15176_/RESET_B VDD VSS sg13g2_dfrbpq_1
X_12388_ _14991_/D _08199_/B _12624_/C1 _12387_/Y _12386_/Y VDD VSS sg13g2_a22oi_1
XFILLER_67_1024 VDD VSS sg13g2_decap_4
XFILLER_113_403 VDD VSS sg13g2_decap_8
XFILLER_4_560 VDD VSS sg13g2_decap_8
X_14127_ _14127_/Q clkload39/A _14127_/D _14127_/RESET_B VDD VSS sg13g2_dfrbpq_1
XFILLER_10_1281 VDD VSS sg13g2_decap_8
X_11339_ _11339_/Y _11339_/A _11339_/B VDD VSS sg13g2_xnor2_1
XFILLER_67_1068 VDD VSS sg13g2_decap_8
XFILLER_28_1019 VDD VSS sg13g2_fill_2
XFILLER_180_380 VDD VSS sg13g2_decap_8
XFILLER_125_296 VDD VSS sg13g2_fill_2
X_14142__2060 _14142_/RESET_B VDD VSS sg13g2_tiehi
X_14058_ _14058_/Q clkload26/A _14058_/D _14058_/RESET_B VDD VSS sg13g2_dfrbpq_1
XFILLER_86_309 VDD VSS sg13g2_fill_2
XFILLER_45_1333 VDD VSS sg13g2_decap_8
XFILLER_84_1393 VDD VSS sg13g2_decap_8
XFILLER_80_1235 VDD VSS sg13g2_decap_8
XFILLER_136_1472 VDD VSS sg13g2_fill_2
XFILLER_140_277 VDD VSS sg13g2_decap_8
XFILLER_95_821 VDD VSS sg13g2_decap_8
X_13009_ _13009_/Y _13009_/A _13010_/A _13010_/B VDD VSS sg13g2_nand3_1
XFILLER_41_1208 VDD VSS sg13g2_decap_8
XFILLER_121_480 VDD VSS sg13g2_fill_1
XFILLER_171_1385 VDD VSS sg13g2_decap_8
X_14746__1456 _14746_/RESET_B VDD VSS sg13g2_tiehi
XFILLER_36_921 VDD VSS sg13g2_decap_8
XFILLER_130_1060 VDD VSS sg13g2_decap_4
X_14880__2807 _14880_/RESET_B VDD VSS sg13g2_tiehi
X_08550_ _08550_/Y _08567_/B _08531_/B _07956_/Y VDD VSS sg13g2_a21oi_1
XFILLER_78_1120 VDD VSS sg13g2_decap_8
XFILLER_51_902 VDD VSS sg13g2_fill_2
X_08481_ _08481_/X _08481_/A _08481_/B VDD VSS sg13g2_xor2_1
XFILLER_63_773 VDD VSS sg13g2_decap_8
XFILLER_23_615 VDD VSS sg13g2_fill_1
XFILLER_74_1028 VDD VSS sg13g2_decap_8
XFILLER_62_283 VDD VSS sg13g2_decap_8
XFILLER_50_434 VDD VSS sg13g2_fill_2
XFILLER_56_1451 VDD VSS sg13g2_decap_8
XFILLER_165_1189 VDD VSS sg13g2_decap_8
XFILLER_17_1413 VDD VSS sg13g2_decap_8
XFILLER_91_1353 VDD VSS sg13g2_decap_8
XFILLER_50_467 VDD VSS sg13g2_decap_4
XFILLER_52_1326 VDD VSS sg13g2_decap_8
XFILLER_148_333 VDD VSS sg13g2_decap_8
X_09102_ _09102_/Y _13142_/A _09136_/B _09158_/A VDD VSS sg13g2_o21ai_1
XFILLER_31_681 VDD VSS sg13g2_decap_8
XFILLER_175_130 VDD VSS sg13g2_decap_8
X_14352__1850 _14352_/RESET_B VDD VSS sg13g2_tiehi
X_09033_ _13766_/D _13766_/Q _10149_/A1 _09127_/S VDD VSS sg13g2_mux2_1
XFILLER_11_1023 VDD VSS sg13g2_decap_8
XFILLER_117_731 VDD VSS sg13g2_fill_1
XFILLER_151_509 VDD VSS sg13g2_decap_8
XFILLER_102_1184 VDD VSS sg13g2_fill_2
XFILLER_144_550 VDD VSS sg13g2_decap_8
X_15186__2830 _15186_/RESET_B VDD VSS sg13g2_tiehi
XFILLER_117_775 VDD VSS sg13g2_decap_8
XFILLER_116_263 VDD VSS sg13g2_decap_8
XFILLER_172_892 VDD VSS sg13g2_decap_8
XFILLER_172_1116 VDD VSS sg13g2_decap_8
XFILLER_89_136 VDD VSS sg13g2_fill_1
XFILLER_63_1400 VDD VSS sg13g2_decap_8
XFILLER_117_69 VDD VSS sg13g2_decap_8
XFILLER_137_1247 VDD VSS sg13g2_decap_8
XFILLER_176_1296 VDD VSS sg13g2_decap_8
XFILLER_77_18 VDD VSS sg13g2_decap_8
XFILLER_132_767 VDD VSS sg13g2_decap_8
Xfanout801 _12608_/S0 _12706_/S VDD VSS sg13g2_buf_1
XFILLER_120_918 VDD VSS sg13g2_decap_8
Xfanout812 _12622_/S0 _12398_/S0 VDD VSS sg13g2_buf_1
X_09935_ _14520_/D _14520_/Q _09935_/A1 _09936_/S VDD VSS sg13g2_mux2_1
Xfanout823 _12647_/S1 fanout829/X VDD VSS sg13g2_buf_1
Xfanout834 _12701_/S1 _12425_/S1 VDD VSS sg13g2_buf_1
XFILLER_98_670 VDD VSS sg13g2_decap_4
Xfanout845 _12592_/S1 fanout846/X VDD VSS sg13g2_buf_1
Xfanout856 _12759_/S1 _12768_/S1 VDD VSS sg13g2_buf_1
XFILLER_24_1417 VDD VSS sg13g2_decap_8
Xfanout867 fanout867/X _15211_/Q VDD VSS sg13g2_buf_1
X_09866_ _14453_/D _14453_/Q _10097_/A0 _09870_/S VDD VSS sg13g2_mux2_1
XFILLER_63_1477 VDD VSS sg13g2_fill_2
XFILLER_58_534 VDD VSS sg13g2_decap_8
Xfanout878 _12576_/S0 _12699_/S0 VDD VSS sg13g2_buf_1
XFILLER_85_320 VDD VSS sg13g2_decap_4
XFILLER_150_1447 VDD VSS sg13g2_decap_8
Xfanout889 fanout889/X _12589_/S0 VDD VSS sg13g2_buf_1
XFILLER_111_1409 VDD VSS sg13g2_decap_8
X_08817_ _08817_/Y _07720_/C _15122_/Q _13482_/A _15192_/Q _13390_/A2 VDD VSS sg13g2_a221oi_1
Xclkbuf_4_6_0_clk_i clkbuf_4_6_0_clk_i/X clkbuf_0_clk_i/X VDD VSS sg13g2_buf_8
X_09797_ _14386_/D _09929_/A1 _14386_/Q _09804_/S VDD VSS sg13g2_mux2_1
XFILLER_45_206 VDD VSS sg13g2_decap_8
XFILLER_93_28 VDD VSS sg13g2_decap_8
XFILLER_61_1190 VDD VSS sg13g2_decap_8
XFILLER_73_537 VDD VSS sg13g2_decap_4
X_08748_ _08748_/Y _08751_/A1 _07720_/B _15194_/Q VDD VSS sg13g2_o21ai_1
XFILLER_22_1174 VDD VSS sg13g2_decap_8
X_13840__2362 _13840_/RESET_B VDD VSS sg13g2_tiehi
X_14005__2197 _14005_/RESET_B VDD VSS sg13g2_tiehi
XFILLER_2_1246 VDD VSS sg13g2_decap_8
XFILLER_27_965 VDD VSS sg13g2_decap_4
X_08679_ _08679_/Y _08642_/Y _08645_/X _08678_/Y VDD VSS sg13g2_a21oi_1
XFILLER_57_1226 VDD VSS sg13g2_decap_8
XFILLER_27_998 VDD VSS sg13g2_decap_4
XFILLER_81_570 VDD VSS sg13g2_decap_4
XFILLER_26_77 VDD VSS sg13g2_decap_8
XFILLER_14_637 VDD VSS sg13g2_decap_8
X_10710_ _10936_/C _09027_/X _10710_/A2 _08873_/Y VDD VSS sg13g2_a21o_1
XFILLER_81_592 VDD VSS sg13g2_decap_8
XFILLER_183_1267 VDD VSS sg13g2_decap_8
X_11690_ _11694_/A _11689_/X _11967_/B VDD VSS sg13g2_nand2b_1
XFILLER_144_1229 VDD VSS sg13g2_fill_1
XFILLER_186_406 VDD VSS sg13g2_decap_8
X_14184__2018 _14184_/RESET_B VDD VSS sg13g2_tiehi
XFILLER_13_158 VDD VSS sg13g2_decap_8
XFILLER_41_467 VDD VSS sg13g2_decap_8
X_10641_ _10643_/B _14887_/Q _10642_/C _14888_/Q VDD VSS sg13g2_a21oi_1
XFILLER_42_21 VDD VSS sg13g2_decap_8
XFILLER_107_1040 VDD VSS sg13g2_decap_8
XFILLER_158_21 VDD VSS sg13g2_decap_8
XFILLER_70_1448 VDD VSS sg13g2_decap_8
X_13360_ _13494_/B _13389_/B _13389_/A VDD VSS sg13g2_nand2b_1
XFILLER_139_355 VDD VSS sg13g2_decap_4
X_10572_ _14869_/D _10572_/A _10595_/B _10572_/C VDD VSS sg13g2_nor3_1
XFILLER_10_854 VDD VSS sg13g2_decap_8
XFILLER_154_303 VDD VSS sg13g2_decap_8
XFILLER_127_528 VDD VSS sg13g2_decap_4
XFILLER_167_697 VDD VSS sg13g2_decap_8
X_12311_ _12311_/Y _12306_/A _14586_/Q VDD VSS sg13g2_nand2b_1
XFILLER_177_1005 VDD VSS sg13g2_fill_1
XFILLER_182_634 VDD VSS sg13g2_decap_4
X_13291_ _15054_/D _13291_/A _13291_/B _13291_/C VDD VSS sg13g2_nand3_1
XFILLER_108_731 VDD VSS sg13g2_decap_8
XFILLER_108_742 VDD VSS sg13g2_fill_1
XFILLER_6_858 VDD VSS sg13g2_decap_8
XFILLER_68_1300 VDD VSS sg13g2_decap_8
XFILLER_154_358 VDD VSS sg13g2_decap_8
XFILLER_181_133 VDD VSS sg13g2_decap_8
X_15030_ _15030_/Q clkload59/A _15030_/D _15030_/RESET_B VDD VSS sg13g2_dfrbpq_1
X_12242_ _12242_/Y _12288_/S0 _14648_/Q VDD VSS sg13g2_nand2b_1
XFILLER_108_764 VDD VSS sg13g2_decap_8
XFILLER_5_357 VDD VSS sg13g2_decap_8
XFILLER_123_701 VDD VSS sg13g2_decap_8
XFILLER_135_572 VDD VSS sg13g2_fill_1
XFILLER_159_1472 VDD VSS sg13g2_fill_2
XFILLER_174_42 VDD VSS sg13g2_decap_8
XFILLER_29_1317 VDD VSS sg13g2_decap_8
XFILLER_162_380 VDD VSS sg13g2_decap_8
X_12173_ _12174_/B _12170_/Y _12172_/Y _11231_/S VDD VSS sg13g2_a21oi_1
XFILLER_68_1377 VDD VSS sg13g2_decap_8
XFILLER_107_296 VDD VSS sg13g2_decap_8
XFILLER_150_531 VDD VSS sg13g2_decap_8
XFILLER_155_1347 VDD VSS sg13g2_decap_8
X_11124_ _11128_/A _11127_/A _11127_/B VDD VSS sg13g2_nand2_1
XFILLER_110_406 VDD VSS sg13g2_decap_8
XFILLER_111_929 VDD VSS sg13g2_decap_8
XFILLER_150_575 VDD VSS sg13g2_fill_1
X_14215__1987 _14215_/RESET_B VDD VSS sg13g2_tiehi
XFILLER_1_574 VDD VSS sg13g2_decap_8
XFILLER_7_1113 VDD VSS sg13g2_decap_8
X_14991__2619 _14991_/RESET_B VDD VSS sg13g2_tiehi
XFILLER_114_1011 VDD VSS sg13g2_decap_8
XFILLER_122_299 VDD VSS sg13g2_decap_8
X_11055_ _11055_/Y _13279_/B _11051_/Y _11054_/Y VDD VSS sg13g2_a21oi_1
XFILLER_89_692 VDD VSS sg13g2_decap_8
XFILLER_153_1071 VDD VSS sg13g2_fill_1
XFILLER_88_180 VDD VSS sg13g2_decap_8
XFILLER_103_491 VDD VSS sg13g2_decap_8
XFILLER_76_342 VDD VSS sg13g2_decap_8
X_10006_ _14588_/D _10072_/A0 _14588_/Q _10036_/S VDD VSS sg13g2_mux2_1
XFILLER_49_567 VDD VSS sg13g2_decap_8
XFILLER_49_578 VDD VSS sg13g2_fill_2
XFILLER_18_910 VDD VSS sg13g2_decap_8
XFILLER_97_1017 VDD VSS sg13g2_decap_8
XFILLER_76_375 VDD VSS sg13g2_decap_8
XFILLER_64_515 VDD VSS sg13g2_decap_8
XFILLER_92_835 VDD VSS sg13g2_decap_8
X_14814_ _14814_/Q clkload84/A _14814_/D _14814_/RESET_B VDD VSS sg13g2_dfrbpq_1
XFILLER_92_846 VDD VSS sg13g2_fill_2
XFILLER_76_397 VDD VSS sg13g2_decap_8
XFILLER_36_228 VDD VSS sg13g2_fill_1
XFILLER_131_1380 VDD VSS sg13g2_fill_1
X_14394__1808 _14394_/RESET_B VDD VSS sg13g2_tiehi
XFILLER_92_857 VDD VSS sg13g2_fill_2
XFILLER_40_1263 VDD VSS sg13g2_decap_8
XFILLER_79_1451 VDD VSS sg13g2_decap_8
XFILLER_18_965 VDD VSS sg13g2_decap_4
X_14430__1772 _14430_/RESET_B VDD VSS sg13g2_tiehi
XFILLER_83_50 VDD VSS sg13g2_fill_1
X_14745_ _14745_/Q _14745_/CLK _14745_/D _14745_/RESET_B VDD VSS sg13g2_dfrbpq_1
X_11957_ _11957_/Y _11957_/A _11957_/B VDD VSS sg13g2_nor2_1
XFILLER_91_378 VDD VSS sg13g2_fill_2
XFILLER_44_261 VDD VSS sg13g2_fill_2
XFILLER_166_1465 VDD VSS sg13g2_decap_8
XFILLER_33_946 VDD VSS sg13g2_decap_4
X_10908_ _10908_/Y _10923_/A _10923_/D _10923_/B VDD VSS sg13g2_o21ai_1
XFILLER_162_1318 VDD VSS sg13g2_decap_8
X_14676_ _14676_/Q clkload31/A _14676_/D _14676_/RESET_B VDD VSS sg13g2_dfrbpq_1
XFILLER_33_957 VDD VSS sg13g2_fill_2
X_11888_ _11888_/Y _11890_/S0 _14510_/Q _11894_/B VDD VSS sg13g2_a21oi_1
X_13627_ _13735_/D _13627_/A VDD VSS sg13g2_buf_1
XFILLER_158_620 VDD VSS sg13g2_decap_8
X_10839_ _10841_/B _14751_/Q _10876_/A VDD VSS sg13g2_xor2_1
XFILLER_38_1181 VDD VSS sg13g2_decap_8
XFILLER_160_1020 VDD VSS sg13g2_decap_8
XFILLER_20_629 VDD VSS sg13g2_fill_2
XFILLER_9_630 VDD VSS sg13g2_decap_8
XFILLER_34_1034 VDD VSS sg13g2_decap_8
XFILLER_160_1053 VDD VSS sg13g2_decap_8
XFILLER_186_973 VDD VSS sg13g2_decap_8
X_13558_ _13558_/Y _15008_/Q _13558_/B _13558_/C VDD VSS sg13g2_nor3_1
X_13703__2499 _13703_/RESET_B VDD VSS sg13g2_tiehi
XFILLER_118_506 VDD VSS sg13g2_decap_8
XFILLER_173_601 VDD VSS sg13g2_fill_1
XFILLER_8_151 VDD VSS sg13g2_decap_8
XFILLER_145_314 VDD VSS sg13g2_decap_8
XFILLER_185_483 VDD VSS sg13g2_decap_8
X_12509_ _12509_/X _12508_/X _12507_/X _12501_/X _12502_/X _12594_/S0 _12623_/S VDD
+ VSS sg13g2_mux4_1
X_13489_ _15124_/D _15124_/Q _13656_/S _13488_/Y VDD VSS sg13g2_a21o_1
XFILLER_145_358 VDD VSS sg13g2_fill_1
XFILLER_172_144 VDD VSS sg13g2_decap_8
X_15228_ _15228_/Q _15228_/CLK _15228_/D _15228_/RESET_B VDD VSS sg13g2_dfrbpq_1
XFILLER_133_509 VDD VSS sg13g2_fill_2
XFILLER_12_1376 VDD VSS sg13g2_decap_8
XFILLER_86_1433 VDD VSS sg13g2_decap_8
XFILLER_173_1414 VDD VSS sg13g2_decap_8
X_15159_ _15159_/Q _15160_/CLK _15159_/D _15159_/RESET_B VDD VSS sg13g2_dfrbpq_1
XFILLER_47_1417 VDD VSS sg13g2_decap_8
X_07981_ _07985_/A _07980_/Y _15075_/Q _07981_/C VDD VSS sg13g2_nand3b_1
XFILLER_141_575 VDD VSS sg13g2_fill_2
XFILLER_68_810 VDD VSS sg13g2_decap_8
XFILLER_101_417 VDD VSS sg13g2_decap_4
X_09720_ _14311_/D _09720_/A0 _14311_/Q _09729_/S VDD VSS sg13g2_mux2_1
X_14967__2643 _14967_/RESET_B VDD VSS sg13g2_tiehi
XFILLER_95_640 VDD VSS sg13g2_decap_8
XFILLER_171_1182 VDD VSS sg13g2_decap_8
XFILLER_79_191 VDD VSS sg13g2_decap_8
XFILLER_110_973 VDD VSS sg13g2_fill_1
X_09651_ _14244_/D _09882_/A0 _14244_/Q _09659_/S VDD VSS sg13g2_mux2_1
XFILLER_132_1166 VDD VSS sg13g2_decap_8
X_15189__2812 _15189_/RESET_B VDD VSS sg13g2_tiehi
XFILLER_68_887 VDD VSS sg13g2_decap_8
XFILLER_55_526 VDD VSS sg13g2_fill_2
X_08602_ _08615_/A _15015_/Q _07853_/B _08674_/B1 VDD VSS sg13g2_o21ai_1
XFILLER_94_172 VDD VSS sg13g2_fill_1
XFILLER_23_1472 VDD VSS sg13g2_fill_2
XFILLER_27_228 VDD VSS sg13g2_decap_4
X_09582_ _14179_/D _14179_/Q _09749_/A1 _09599_/S VDD VSS sg13g2_mux2_1
XFILLER_83_857 VDD VSS sg13g2_decap_4
XFILLER_82_334 VDD VSS sg13g2_fill_1
X_08533_ _08533_/Y _08567_/B _08532_/Y _08039_/A VDD VSS sg13g2_a21oi_1
XFILLER_82_367 VDD VSS sg13g2_decap_8
XFILLER_36_762 VDD VSS sg13g2_decap_8
XFILLER_93_1426 VDD VSS sg13g2_decap_8
XFILLER_63_581 VDD VSS sg13g2_fill_1
XFILLER_51_732 VDD VSS sg13g2_decap_8
XFILLER_24_946 VDD VSS sg13g2_decap_8
X_08464_ _08475_/D _08027_/Y _08242_/A _08463_/Y VDD VSS sg13g2_a21oi_1
XFILLER_51_743 VDD VSS sg13g2_fill_1
XFILLER_35_294 VDD VSS sg13g2_decap_8
XFILLER_17_1210 VDD VSS sg13g2_decap_8
XFILLER_23_478 VDD VSS sg13g2_decap_8
X_14844__2879 _14844_/RESET_B VDD VSS sg13g2_tiehi
X_08395_ _08395_/Y _08395_/A _08395_/B VDD VSS sg13g2_nor2_1
XFILLER_52_1123 VDD VSS sg13g2_fill_2
XFILLER_108_1360 VDD VSS sg13g2_decap_8
XFILLER_50_286 VDD VSS sg13g2_decap_8
XFILLER_149_653 VDD VSS sg13g2_decap_4
XFILLER_177_962 VDD VSS sg13g2_fill_2
XFILLER_109_506 VDD VSS sg13g2_decap_8
XFILLER_176_450 VDD VSS sg13g2_decap_4
XFILLER_17_1287 VDD VSS sg13g2_decap_8
XFILLER_164_612 VDD VSS sg13g2_decap_8
XFILLER_12_35 VDD VSS sg13g2_decap_8
XFILLER_104_1257 VDD VSS sg13g2_decap_4
XFILLER_137_859 VDD VSS sg13g2_decap_8
XFILLER_148_185 VDD VSS sg13g2_decap_8
XFILLER_128_24 VDD VSS sg13g2_fill_1
X_09016_ _09019_/A _09141_/A _09016_/B _10697_/B VDD VSS sg13g2_nand3_1
XFILLER_30_1454 VDD VSS sg13g2_decap_8
XFILLER_124_509 VDD VSS sg13g2_decap_8
XFILLER_136_369 VDD VSS sg13g2_fill_2
XFILLER_128_57 VDD VSS sg13g2_fill_1
XFILLER_178_1369 VDD VSS sg13g2_decap_8
XFILLER_145_870 VDD VSS sg13g2_decap_4
XFILLER_88_28 VDD VSS sg13g2_decap_8
XFILLER_151_328 VDD VSS sg13g2_decap_4
X_13858__2344 _13858_/RESET_B VDD VSS sg13g2_tiehi
XFILLER_5_7 VDD VSS sg13g2_decap_8
XFILLER_105_767 VDD VSS sg13g2_decap_4
XFILLER_137_1055 VDD VSS sg13g2_decap_4
XFILLER_144_34 VDD VSS sg13g2_decap_8
XFILLER_8_1411 VDD VSS sg13g2_decap_8
Xfanout620 _08943_/A _08954_/S VDD VSS sg13g2_buf_1
XFILLER_28_1350 VDD VSS sg13g2_decap_8
Xfanout631 _10788_/S _08837_/X VDD VSS sg13g2_buf_1
XFILLER_137_1099 VDD VSS sg13g2_fill_1
Xfanout642 _13437_/A _13440_/A VDD VSS sg13g2_buf_1
X_09918_ _14503_/D _14503_/Q _09918_/A1 _09927_/S VDD VSS sg13g2_mux2_1
XFILLER_77_128 VDD VSS sg13g2_decap_8
XFILLER_154_1380 VDD VSS sg13g2_decap_8
Xfanout653 _08142_/A _07996_/X VDD VSS sg13g2_buf_1
XFILLER_24_1214 VDD VSS sg13g2_decap_8
XFILLER_63_1274 VDD VSS sg13g2_decap_8
Xfanout664 _12596_/C1 _07737_/Y VDD VSS sg13g2_buf_1
Xfanout675 _13219_/C1 _13138_/B1 VDD VSS sg13g2_buf_1
XFILLER_101_962 VDD VSS sg13g2_decap_4
Xfanout686 _11154_/B1 _07753_/B VDD VSS sg13g2_buf_1
Xfanout697 _11664_/A _07682_/Y VDD VSS sg13g2_buf_1
X_09849_ _14436_/D _14436_/Q _10147_/A1 _09865_/S VDD VSS sg13g2_mux2_1
XFILLER_37_21 VDD VSS sg13g2_decap_8
XFILLER_74_824 VDD VSS sg13g2_decap_8
XFILLER_111_1228 VDD VSS sg13g2_decap_8
XFILLER_160_11 VDD VSS sg13g2_decap_8
XFILLER_86_695 VDD VSS sg13g2_fill_2
XFILLER_73_312 VDD VSS sg13g2_fill_1
X_12860_ _12876_/A _12861_/B _12861_/A VDD VSS sg13g2_nor2_1
XFILLER_98_1359 VDD VSS sg13g2_fill_2
XFILLER_37_76 VDD VSS sg13g2_decap_8
XFILLER_2_1043 VDD VSS sg13g2_decap_8
X_11811_ _11811_/Y _11812_/A1 _14636_/Q VDD VSS sg13g2_nand2b_1
XFILLER_160_88 VDD VSS sg13g2_decap_8
X_12791_ _12792_/B _13662_/Q _12791_/A2 _12790_/X _12372_/A _13282_/A1 VDD VSS sg13g2_a221oi_1
XFILLER_61_529 VDD VSS sg13g2_decap_8
XFILLER_14_401 VDD VSS sg13g2_decap_8
XFILLER_42_721 VDD VSS sg13g2_decap_8
X_14530_ _14530_/Q _14722_/CLK _14530_/D _14530_/RESET_B VDD VSS sg13g2_dfrbpq_1
XFILLER_96_1083 VDD VSS sg13g2_decap_8
XFILLER_148_1162 VDD VSS sg13g2_fill_2
X_11742_ _11743_/B _11742_/A _11742_/B _11742_/C VDD VSS sg13g2_nand3_1
XFILLER_53_42 VDD VSS sg13g2_decap_4
XFILLER_183_1064 VDD VSS sg13g2_decap_8
XFILLER_41_231 VDD VSS sg13g2_decap_4
XFILLER_186_203 VDD VSS sg13g2_decap_8
XFILLER_14_467 VDD VSS sg13g2_decap_8
XFILLER_159_428 VDD VSS sg13g2_fill_1
XFILLER_42_776 VDD VSS sg13g2_decap_8
XFILLER_35_1310 VDD VSS sg13g2_decap_8
XFILLER_30_916 VDD VSS sg13g2_fill_2
XFILLER_109_1157 VDD VSS sg13g2_fill_1
XFILLER_144_1037 VDD VSS sg13g2_decap_4
XFILLER_149_0 VDD VSS sg13g2_decap_4
XFILLER_14_478 VDD VSS sg13g2_fill_2
XFILLER_169_42 VDD VSS sg13g2_decap_8
X_14461_ _14461_/Q clkload30/A _14461_/D _14461_/RESET_B VDD VSS sg13g2_dfrbpq_1
X_11673_ _11673_/Y _11678_/S0 _14568_/Q VDD VSS sg13g2_nand2b_1
X_13412_ _13448_/C _15198_/Q _13412_/B _13412_/C VDD VSS sg13g2_nor3_1
XFILLER_41_297 VDD VSS sg13g2_decap_4
X_10624_ _10626_/C _14883_/Q _10636_/A VDD VSS sg13g2_nand2b_1
XFILLER_70_1245 VDD VSS sg13g2_decap_8
X_14392_ _14392_/Q _14514_/CLK _14392_/D _14392_/RESET_B VDD VSS sg13g2_dfrbpq_1
XFILLER_161_1373 VDD VSS sg13g2_decap_8
XFILLER_10_651 VDD VSS sg13g2_decap_8
XFILLER_139_163 VDD VSS sg13g2_fill_1
XFILLER_35_1387 VDD VSS sg13g2_decap_8
XFILLER_127_314 VDD VSS sg13g2_decap_8
X_13343_ _13343_/Y _13648_/S _13343_/B VDD VSS sg13g2_nand2_1
XFILLER_182_420 VDD VSS sg13g2_decap_8
X_10555_ _10557_/A _14867_/Q _10555_/B VDD VSS sg13g2_nand2b_1
XFILLER_122_1368 VDD VSS sg13g2_decap_8
XFILLER_183_965 VDD VSS sg13g2_decap_8
XFILLER_6_655 VDD VSS sg13g2_decap_8
XFILLER_185_63 VDD VSS sg13g2_decap_8
X_13274_ _13274_/Y _14830_/Q _13068_/B _07728_/C _14894_/Q _13248_/B VDD VSS sg13g2_a221oi_1
XFILLER_142_306 VDD VSS sg13g2_decap_8
X_10486_ _10512_/B _14849_/Q _13084_/A _14847_/Q _10504_/C VDD VSS sg13g2_nand4_1
XFILLER_5_154 VDD VSS sg13g2_decap_8
XFILLER_136_881 VDD VSS sg13g2_decap_8
X_15013_ _15013_/Q clkload38/A _15013_/D _15013_/RESET_B VDD VSS sg13g2_dfrbpq_1
XFILLER_182_497 VDD VSS sg13g2_decap_8
X_12225_ _12225_/Y _12224_/Y _12223_/X _12204_/Y _12294_/B1 _12271_/A VDD VSS sg13g2_a221oi_1
X_14448__1754 _14448_/RESET_B VDD VSS sg13g2_tiehi
XFILLER_68_1174 VDD VSS sg13g2_decap_8
XFILLER_123_553 VDD VSS sg13g2_fill_1
XFILLER_123_564 VDD VSS sg13g2_fill_2
X_12156_ _12156_/Y _12156_/A _12156_/B _12156_/C VDD VSS sg13g2_nand3_1
XFILLER_2_861 VDD VSS sg13g2_decap_8
XFILLER_155_1166 VDD VSS sg13g2_decap_8
XFILLER_110_203 VDD VSS sg13g2_decap_8
XFILLER_116_1128 VDD VSS sg13g2_decap_8
XFILLER_1_371 VDD VSS sg13g2_decap_8
X_11107_ _11107_/Y _11097_/Y _10764_/X _11139_/B1 VDD VSS sg13g2_a21oi_1
XFILLER_133_1420 VDD VSS sg13g2_fill_1
XFILLER_42_1303 VDD VSS sg13g2_decap_8
X_12087_ _12087_/X _14132_/Q _14164_/Q _12087_/S VDD VSS sg13g2_mux2_1
XFILLER_81_1363 VDD VSS sg13g2_decap_8
X_11038_ _11044_/A _11064_/C _11036_/Y _11037_/Y VDD VSS sg13g2_o21ai_1
XFILLER_77_673 VDD VSS sg13g2_decap_4
XFILLER_49_364 VDD VSS sg13g2_decap_8
XFILLER_77_684 VDD VSS sg13g2_decap_8
XFILLER_49_397 VDD VSS sg13g2_decap_8
XFILLER_94_60 VDD VSS sg13g2_decap_8
XFILLER_92_654 VDD VSS sg13g2_decap_8
XFILLER_65_868 VDD VSS sg13g2_fill_2
XFILLER_92_665 VDD VSS sg13g2_decap_4
XFILLER_80_805 VDD VSS sg13g2_decap_4
XFILLER_40_1082 VDD VSS sg13g2_fill_2
XFILLER_64_378 VDD VSS sg13g2_fill_2
X_12989_ _12993_/B _12943_/A _12989_/B _12989_/C VDD VSS sg13g2_nand3b_1
XFILLER_79_1281 VDD VSS sg13g2_decap_8
XFILLER_52_529 VDD VSS sg13g2_decap_8
XFILLER_17_283 VDD VSS sg13g2_decap_8
XFILLER_166_1262 VDD VSS sg13g2_decap_8
X_14728_ _14728_/Q _14728_/CLK _14728_/D _14728_/RESET_B VDD VSS sg13g2_dfrbpq_1
XFILLER_127_1235 VDD VSS sg13g2_decap_8
XFILLER_75_1167 VDD VSS sg13g2_decap_8
XFILLER_36_1118 VDD VSS sg13g2_decap_8
X_13936__2266 _13936_/RESET_B VDD VSS sg13g2_tiehi
X_14659_ _14659_/Q _14723_/CLK _14659_/D _14659_/RESET_B VDD VSS sg13g2_dfrbpq_1
XFILLER_60_584 VDD VSS sg13g2_decap_8
XFILLER_140_1402 VDD VSS sg13g2_decap_8
XFILLER_53_1454 VDD VSS sg13g2_decap_8
X_08180_ _08187_/B _08334_/A1 _08170_/X _08397_/A _08179_/Y VDD VSS sg13g2_a22oi_1
XFILLER_186_770 VDD VSS sg13g2_decap_8
XFILLER_146_612 VDD VSS sg13g2_fill_1
XFILLER_185_280 VDD VSS sg13g2_decap_8
XFILLER_146_656 VDD VSS sg13g2_decap_8
XFILLER_174_965 VDD VSS sg13g2_decap_8
XFILLER_64_0 VDD VSS sg13g2_decap_8
XFILLER_173_453 VDD VSS sg13g2_decap_8
XFILLER_12_1173 VDD VSS sg13g2_decap_8
XFILLER_127_892 VDD VSS sg13g2_decap_8
XFILLER_133_339 VDD VSS sg13g2_decap_4
XFILLER_173_1211 VDD VSS sg13g2_decap_8
XFILLER_177_1380 VDD VSS sg13g2_decap_8
XFILLER_47_1214 VDD VSS sg13g2_decap_8
XFILLER_126_391 VDD VSS sg13g2_decap_8
XFILLER_99_231 VDD VSS sg13g2_decap_8
XFILLER_142_851 VDD VSS sg13g2_fill_2
XFILLER_160_158 VDD VSS sg13g2_decap_8
XFILLER_88_916 VDD VSS sg13g2_decap_8
XFILLER_82_1127 VDD VSS sg13g2_decap_8
XFILLER_99_264 VDD VSS sg13g2_fill_1
XFILLER_173_1288 VDD VSS sg13g2_decap_8
XFILLER_102_759 VDD VSS sg13g2_decap_8
X_07964_ _07964_/Y _08641_/C _07963_/Y _07962_/Y VDD VSS sg13g2_a21oi_1
XFILLER_4_91 VDD VSS sg13g2_decap_8
X_09703_ _14295_/D _10066_/A0 _14295_/Q _09704_/S VDD VSS sg13g2_mux2_1
XFILLER_101_269 VDD VSS sg13g2_decap_8
XFILLER_56_802 VDD VSS sg13g2_decap_8
X_07895_ _08037_/A _08009_/S _07903_/B VDD VSS sg13g2_or2_1
XFILLER_68_695 VDD VSS sg13g2_decap_8
XFILLER_60_1469 VDD VSS sg13g2_decap_4
XFILLER_56_835 VDD VSS sg13g2_fill_1
X_09634_ _14230_/D _09966_/A1 _14230_/Q _09638_/S VDD VSS sg13g2_mux2_1
XFILLER_83_632 VDD VSS sg13g2_decap_8
X_14750__2989 _14750_/RESET_B VDD VSS sg13g2_tiehi
XFILLER_55_345 VDD VSS sg13g2_decap_8
XFILLER_3_1341 VDD VSS sg13g2_decap_8
X_09565_ _14163_/D _10062_/A0 _14163_/Q _09571_/S VDD VSS sg13g2_mux2_1
XFILLER_97_1370 VDD VSS sg13g2_decap_8
XFILLER_130_25 VDD VSS sg13g2_decap_8
XFILLER_93_1212 VDD VSS sg13g2_decap_8
XFILLER_58_1343 VDD VSS sg13g2_decap_8
XFILLER_36_581 VDD VSS sg13g2_fill_2
X_08516_ _08517_/D _07816_/X _08541_/A _08515_/Y _07815_/X _08514_/Y VDD VSS sg13g2_a221oi_1
XFILLER_70_337 VDD VSS sg13g2_fill_2
X_09496_ _14096_/D _09960_/A1 _14096_/Q _09500_/S VDD VSS sg13g2_mux2_1
XFILLER_184_1373 VDD VSS sg13g2_decap_8
XFILLER_19_1338 VDD VSS sg13g2_decap_8
X_08447_ _08447_/X _08649_/S _08447_/B VDD VSS sg13g2_and2_1
XFILLER_93_1289 VDD VSS sg13g2_decap_8
XFILLER_142_7 VDD VSS sg13g2_decap_8
XFILLER_24_798 VDD VSS sg13g2_decap_8
X_14526__1676 _14526_/RESET_B VDD VSS sg13g2_tiehi
XFILLER_180_1259 VDD VSS sg13g2_decap_8
XFILLER_184_707 VDD VSS sg13g2_decap_8
XFILLER_11_459 VDD VSS sg13g2_fill_1
XFILLER_139_23 VDD VSS sg13g2_fill_2
XFILLER_149_450 VDD VSS sg13g2_decap_8
X_08378_ _08378_/Y _08377_/B _08376_/X _08377_/Y VDD VSS sg13g2_o21ai_1
XFILLER_139_45 VDD VSS sg13g2_decap_8
XFILLER_165_921 VDD VSS sg13g2_decap_8
XFILLER_177_781 VDD VSS sg13g2_decap_8
XFILLER_136_100 VDD VSS sg13g2_decap_8
XFILLER_17_1084 VDD VSS sg13g2_decap_8
XFILLER_183_228 VDD VSS sg13g2_decap_8
XFILLER_165_943 VDD VSS sg13g2_fill_1
XFILLER_20_982 VDD VSS sg13g2_fill_2
XFILLER_99_16 VDD VSS sg13g2_decap_8
XFILLER_165_965 VDD VSS sg13g2_fill_1
XFILLER_165_987 VDD VSS sg13g2_decap_8
X_10340_ _14806_/D _10405_/C _10357_/D _10337_/B _07647_/Y _10490_/A VDD VSS sg13g2_a221oi_1
XFILLER_30_1251 VDD VSS sg13g2_decap_8
XFILLER_178_1166 VDD VSS sg13g2_decap_8
X_14741__1461 _14741_/RESET_B VDD VSS sg13g2_tiehi
XFILLER_155_11 VDD VSS sg13g2_decap_8
XFILLER_174_1019 VDD VSS sg13g2_decap_4
XFILLER_117_380 VDD VSS sg13g2_decap_8
XFILLER_156_1420 VDD VSS sg13g2_decap_8
X_10271_ _10271_/Y _10305_/A _10544_/C VDD VSS sg13g2_nand2b_1
XFILLER_69_1472 VDD VSS sg13g2_fill_2
X_12010_ _12055_/D _12008_/Y _12010_/B VDD VSS sg13g2_nand2b_1
XFILLER_3_669 VDD VSS sg13g2_decap_8
XFILLER_3_4 VDD VSS sg13g2_decap_8
XFILLER_65_1347 VDD VSS sg13g2_decap_8
XFILLER_105_575 VDD VSS sg13g2_decap_8
XFILLER_2_168 VDD VSS sg13g2_decap_8
XFILLER_117_1437 VDD VSS sg13g2_fill_1
Xfanout1404 _10435_/A fanout1413/X VDD VSS sg13g2_buf_1
Xfanout1415 _12639_/A1 _13005_/C VDD VSS sg13g2_buf_1
XFILLER_78_437 VDD VSS sg13g2_decap_8
XFILLER_120_534 VDD VSS sg13g2_decap_8
Xfanout1426 _10343_/C _13499_/B VDD VSS sg13g2_buf_1
Xfanout1437 _13405_/B input38/X VDD VSS sg13g2_buf_1
Xfanout450 _09793_/S _09773_/Y VDD VSS sg13g2_buf_1
XFILLER_48_42 VDD VSS sg13g2_decap_8
XFILLER_171_21 VDD VSS sg13g2_decap_8
Xfanout461 _09572_/S _09560_/S VDD VSS sg13g2_buf_1
XFILLER_150_1030 VDD VSS sg13g2_decap_8
Xfanout472 _09471_/S fanout474/X VDD VSS sg13g2_buf_1
XFILLER_120_578 VDD VSS sg13g2_decap_8
X_13961_ _13961_/Q _14665_/CLK _13961_/D _13961_/RESET_B VDD VSS sg13g2_dfrbpq_1
XFILLER_93_418 VDD VSS sg13g2_decap_8
XFILLER_59_673 VDD VSS sg13g2_decap_8
XFILLER_19_515 VDD VSS sg13g2_decap_8
X_13674__2547 _13674_/RESET_B VDD VSS sg13g2_tiehi
Xfanout483 _09362_/S fanout486/X VDD VSS sg13g2_buf_1
XFILLER_8_1285 VDD VSS sg13g2_decap_8
XFILLER_48_86 VDD VSS sg13g2_decap_8
XFILLER_150_1052 VDD VSS sg13g2_fill_1
Xfanout494 _09745_/A1 fanout497/X VDD VSS sg13g2_buf_1
XFILLER_87_993 VDD VSS sg13g2_decap_8
XFILLER_4_1127 VDD VSS sg13g2_decap_8
XFILLER_101_792 VDD VSS sg13g2_decap_8
X_12912_ _12914_/B _12911_/Y _12799_/X input19/X _12801_/Y VDD VSS sg13g2_a22oi_1
XFILLER_171_98 VDD VSS sg13g2_decap_8
X_13892_ _13892_/Q _14724_/CLK _13892_/D _13892_/RESET_B VDD VSS sg13g2_dfrbpq_1
XFILLER_0_49 VDD VSS sg13g2_decap_8
XFILLER_104_70 VDD VSS sg13g2_decap_8
X_12843_ _12845_/C _13609_/A _12899_/C input6/X _12866_/A VDD VSS sg13g2_nand4_1
XFILLER_61_304 VDD VSS sg13g2_decap_8
XFILLER_73_175 VDD VSS sg13g2_decap_8
XFILLER_64_52 VDD VSS sg13g2_fill_1
XFILLER_15_721 VDD VSS sg13g2_decap_8
XFILLER_185_1159 VDD VSS sg13g2_decap_8
X_14925__2717 _14925_/RESET_B VDD VSS sg13g2_tiehi
XFILLER_76_1443 VDD VSS sg13g2_decap_8
X_12774_ _12774_/X _12767_/X _12771_/X _12766_/X _12770_/X _12762_/S _12775_/S1 VDD
+ VSS sg13g2_mux4_1
XFILLER_72_1307 VDD VSS sg13g2_decap_8
XFILLER_37_1427 VDD VSS sg13g2_decap_8
XFILLER_15_776 VDD VSS sg13g2_decap_8
X_14513_ _14513_/Q clkload29/A _14513_/D _14513_/RESET_B VDD VSS sg13g2_dfrbpq_1
XFILLER_9_14 VDD VSS sg13g2_decap_8
X_11725_ _11725_/Y _11726_/A _13678_/Q VDD VSS sg13g2_nor2_1
XFILLER_163_1457 VDD VSS sg13g2_decap_8
X_14444_ _14444_/Q _14670_/CLK _14444_/D _14444_/RESET_B VDD VSS sg13g2_dfrbpq_1
X_11656_ _11656_/Y _11425_/B _11654_/X _11868_/A VDD VSS sg13g2_a21oi_1
XFILLER_11_960 VDD VSS sg13g2_decap_8
XFILLER_161_1170 VDD VSS sg13g2_decap_8
XFILLER_174_217 VDD VSS sg13g2_decap_8
XFILLER_128_623 VDD VSS sg13g2_decap_8
XFILLER_174_239 VDD VSS sg13g2_decap_8
X_10607_ _10614_/A _14878_/Q _14877_/Q _10607_/C _10607_/D VDD VSS sg13g2_nand4_1
XFILLER_35_1184 VDD VSS sg13g2_decap_8
XFILLER_155_420 VDD VSS sg13g2_fill_2
XFILLER_156_943 VDD VSS sg13g2_decap_8
X_14375_ _14375_/Q clkload5/A _14375_/D _14375_/RESET_B VDD VSS sg13g2_dfrbpq_1
XFILLER_7_931 VDD VSS sg13g2_decap_8
X_11587_ _11587_/Y _11586_/Y _11585_/Y _11572_/X _11631_/A2 _11768_/B1 VDD VSS sg13g2_a221oi_1
X_15188__2822 _15188_/RESET_B VDD VSS sg13g2_tiehi
XFILLER_116_818 VDD VSS sg13g2_decap_8
XFILLER_13_1460 VDD VSS sg13g2_decap_8
XFILLER_156_987 VDD VSS sg13g2_fill_1
X_13326_ _15066_/D _13328_/A _13326_/B VDD VSS sg13g2_nor2_1
X_10538_ _10547_/D _10538_/A _10538_/B _10567_/A _10567_/B VDD VSS sg13g2_nor4_1
XFILLER_6_452 VDD VSS sg13g2_decap_8
XFILLER_183_784 VDD VSS sg13g2_decap_8
XFILLER_143_626 VDD VSS sg13g2_fill_1
XFILLER_115_328 VDD VSS sg13g2_fill_1
XFILLER_115_339 VDD VSS sg13g2_decap_8
XFILLER_171_957 VDD VSS sg13g2_decap_4
X_13257_ _13270_/A _14924_/Q _13663_/Q VDD VSS sg13g2_nand2_1
XFILLER_124_840 VDD VSS sg13g2_decap_8
XFILLER_142_136 VDD VSS sg13g2_decap_8
X_10469_ _10472_/C _10500_/A _10473_/D _14845_/Q VDD VSS sg13g2_a21oi_1
XFILLER_83_1403 VDD VSS sg13g2_decap_8
XFILLER_171_979 VDD VSS sg13g2_decap_8
XFILLER_89_93 VDD VSS sg13g2_decap_8
X_12208_ _12208_/Y _12207_/X _12219_/S VDD VSS sg13g2_nand2b_1
XFILLER_97_702 VDD VSS sg13g2_decap_8
XFILLER_170_478 VDD VSS sg13g2_decap_4
XFILLER_69_404 VDD VSS sg13g2_fill_1
X_13188_ _13202_/A _13188_/A _13225_/B _13225_/A VDD VSS sg13g2_nand3_1
XFILLER_151_670 VDD VSS sg13g2_fill_2
X_14825__2911 _14825_/RESET_B VDD VSS sg13g2_tiehi
XFILLER_170_1417 VDD VSS sg13g2_decap_8
XFILLER_69_426 VDD VSS sg13g2_decap_8
XFILLER_111_523 VDD VSS sg13g2_decap_8
X_12139_ _12139_/X _14133_/Q _14165_/Q _14197_/Q _14229_/Q _12139_/S0 _12139_/S1 VDD
+ VSS sg13g2_mux4_1
XFILLER_42_1100 VDD VSS sg13g2_decap_8
XFILLER_111_567 VDD VSS sg13g2_decap_8
X_14604__1598 _14604_/RESET_B VDD VSS sg13g2_tiehi
X_15049__2550 _15049_/RESET_B VDD VSS sg13g2_tiehi
XFILLER_77_481 VDD VSS sg13g2_decap_4
XFILLER_93_941 VDD VSS sg13g2_decap_8
XFILLER_42_1177 VDD VSS sg13g2_decap_8
X_07680_ _07680_/Y _13293_/A _13289_/C _07679_/Y VDD VSS sg13g2_a21oi_1
X_16878_ _16878_/X _16878_/A VDD VSS sg13g2_buf_1
XFILLER_20_1431 VDD VSS sg13g2_decap_8
XFILLER_168_1335 VDD VSS sg13g2_decap_8
XFILLER_77_1229 VDD VSS sg13g2_decap_8
XFILLER_25_529 VDD VSS sg13g2_decap_8
X_09350_ _13954_/D _09614_/A0 _13954_/Q _09364_/S VDD VSS sg13g2_mux2_1
XFILLER_80_668 VDD VSS sg13g2_fill_2
XFILLER_90_1407 VDD VSS sg13g2_decap_8
X_08301_ _08301_/X _08215_/X _08300_/X _08301_/S VDD VSS sg13g2_mux2_1
XFILLER_100_28 VDD VSS sg13g2_decap_8
X_09281_ _13889_/D _13889_/Q _09978_/A0 _09296_/S VDD VSS sg13g2_mux2_1
XFILLER_61_882 VDD VSS sg13g2_decap_8
XFILLER_33_573 VDD VSS sg13g2_decap_4
XFILLER_21_746 VDD VSS sg13g2_decap_8
X_08232_ _08232_/Y _07924_/C _08230_/Y _08231_/Y VDD VSS sg13g2_a21oi_1
XFILLER_18_1371 VDD VSS sg13g2_decap_8
XFILLER_20_245 VDD VSS sg13g2_decap_8
XFILLER_53_1251 VDD VSS sg13g2_decap_8
X_08163_ _08163_/Y _07612_/Y _08162_/Y _08160_/Y VDD VSS sg13g2_a21oi_1
XFILLER_140_1254 VDD VSS sg13g2_decap_4
XFILLER_147_965 VDD VSS sg13g2_decap_8
XFILLER_14_1268 VDD VSS sg13g2_decap_8
XFILLER_179_1442 VDD VSS sg13g2_decap_8
X_14210__1992 _14210_/RESET_B VDD VSS sg13g2_tiehi
XFILLER_119_678 VDD VSS sg13g2_decap_8
XFILLER_140_1287 VDD VSS sg13g2_decap_4
XFILLER_162_913 VDD VSS sg13g2_decap_8
X_08094_ _08094_/X _11726_/A _11798_/A _11705_/A _08465_/A3 _07883_/A _08063_/A VDD
+ VSS sg13g2_mux4_1
XFILLER_173_261 VDD VSS sg13g2_decap_8
XFILLER_88_1369 VDD VSS sg13g2_decap_8
XFILLER_134_637 VDD VSS sg13g2_decap_8
XFILLER_175_1328 VDD VSS sg13g2_decap_8
Xclkload60 clkload60/Y clkload60/A VDD VSS sg13g2_inv_2
Xclkload71 clkload71/Y clkload71/A VDD VSS sg13g2_inv_1
XFILLER_161_445 VDD VSS sg13g2_decap_8
Xclkload82 clkload82/Y clkload82/A VDD VSS sg13g2_inv_2
XFILLER_121_309 VDD VSS sg13g2_decap_8
XFILLER_102_501 VDD VSS sg13g2_decap_4
XFILLER_114_361 VDD VSS sg13g2_decap_4
XFILLER_114_372 VDD VSS sg13g2_decap_8
XFILLER_114_383 VDD VSS sg13g2_fill_1
XFILLER_134_1025 VDD VSS sg13g2_decap_8
XFILLER_87_234 VDD VSS sg13g2_fill_1
X_08996_ _08996_/Y _08993_/X _08995_/Y _08992_/Y VDD VSS sg13g2_o21ai_1
XFILLER_88_768 VDD VSS sg13g2_decap_8
XFILLER_87_245 VDD VSS sg13g2_decap_8
XFILLER_25_1320 VDD VSS sg13g2_decap_8
XFILLER_85_18 VDD VSS sg13g2_fill_2
XFILLER_75_407 VDD VSS sg13g2_decap_8
XFILLER_134_1069 VDD VSS sg13g2_decap_8
XFILLER_5_1414 VDD VSS sg13g2_decap_8
XFILLER_29_802 VDD VSS sg13g2_decap_8
X_07947_ _08443_/A _08435_/A _08574_/A _07945_/Y VDD VSS sg13g2_o21ai_1
XFILLER_112_1323 VDD VSS sg13g2_decap_8
XFILLER_60_1266 VDD VSS sg13g2_decap_8
XFILLER_25_1397 VDD VSS sg13g2_decap_8
XFILLER_186_1413 VDD VSS sg13g2_decap_8
XFILLER_21_1239 VDD VSS sg13g2_decap_8
X_07878_ _07878_/Y _08105_/A _08200_/B VDD VSS sg13g2_nand2_1
XFILLER_99_1465 VDD VSS sg13g2_decap_8
XFILLER_18_67 VDD VSS sg13g2_decap_8
XFILLER_84_974 VDD VSS sg13g2_decap_8
X_09617_ _14213_/D _09617_/A0 _14213_/Q _09632_/S VDD VSS sg13g2_mux2_1
XFILLER_112_1389 VDD VSS sg13g2_decap_8
XFILLER_84_996 VDD VSS sg13g2_decap_8
XFILLER_141_68 VDD VSS sg13g2_decap_8
XFILLER_71_635 VDD VSS sg13g2_decap_4
XFILLER_70_123 VDD VSS sg13g2_fill_1
X_09548_ _14146_/D _09614_/A0 _14146_/Q _09562_/S VDD VSS sg13g2_mux2_1
XFILLER_70_145 VDD VSS sg13g2_decap_8
XFILLER_184_1170 VDD VSS sg13g2_decap_8
XFILLER_70_156 VDD VSS sg13g2_fill_1
XFILLER_52_860 VDD VSS sg13g2_decap_8
XFILLER_24_551 VDD VSS sg13g2_decap_8
XFILLER_93_1064 VDD VSS sg13g2_fill_1
XFILLER_19_1135 VDD VSS sg13g2_decap_8
XFILLER_12_724 VDD VSS sg13g2_decap_8
X_09479_ _14079_/D _10142_/A1 _14079_/Q _09500_/S VDD VSS sg13g2_mux2_1
XFILLER_140_4 VDD VSS sg13g2_decap_8
XFILLER_145_1154 VDD VSS sg13g2_fill_1
XFILLER_54_1037 VDD VSS sg13g2_decap_4
XFILLER_51_381 VDD VSS sg13g2_decap_8
XFILLER_141_1007 VDD VSS sg13g2_fill_2
X_11510_ _11510_/X _14243_/Q _14275_/Q _14307_/Q _14339_/Q _11514_/S0 _11514_/S1 VDD
+ VSS sg13g2_mux4_1
XFILLER_157_718 VDD VSS sg13g2_decap_8
XFILLER_12_768 VDD VSS sg13g2_decap_8
X_12490_ _12490_/X _14245_/Q _14277_/Q _14309_/Q _14341_/Q _12494_/S0 _12494_/S1 VDD
+ VSS sg13g2_mux4_1
XFILLER_36_1460 VDD VSS sg13g2_decap_8
XFILLER_32_1302 VDD VSS sg13g2_decap_8
XFILLER_11_256 VDD VSS sg13g2_decap_8
XFILLER_138_921 VDD VSS sg13g2_decap_8
XFILLER_71_1362 VDD VSS sg13g2_decap_8
XFILLER_123_1441 VDD VSS sg13g2_decap_4
XFILLER_8_739 VDD VSS sg13g2_decap_8
XFILLER_156_239 VDD VSS sg13g2_decap_8
X_11441_ _11441_/X _13728_/Q _14080_/Q _14432_/Q _14528_/Q _12112_/A1 _12103_/B1 VDD
+ VSS sg13g2_mux4_1
XFILLER_184_559 VDD VSS sg13g2_decap_8
XFILLER_50_32 VDD VSS sg13g2_decap_8
XFILLER_7_238 VDD VSS sg13g2_decap_8
XFILLER_20_790 VDD VSS sg13g2_decap_8
XFILLER_166_21 VDD VSS sg13g2_decap_8
XFILLER_171_209 VDD VSS sg13g2_fill_1
X_14160_ _14160_/Q clkload14/A _14160_/D _14160_/RESET_B VDD VSS sg13g2_dfrbpq_1
XFILLER_32_1379 VDD VSS sg13g2_decap_8
XFILLER_164_250 VDD VSS sg13g2_decap_8
X_11372_ _11374_/A _11373_/A _14174_/Q VDD VSS sg13g2_nand2b_1
XFILLER_137_475 VDD VSS sg13g2_decap_8
XFILLER_67_1409 VDD VSS sg13g2_decap_8
XFILLER_109_188 VDD VSS sg13g2_fill_1
X_13111_ _15040_/D _13141_/A _13111_/B VDD VSS sg13g2_nor2_1
XFILLER_180_743 VDD VSS sg13g2_decap_4
X_10323_ _10325_/A _14801_/Q _10323_/B VDD VSS sg13g2_nand2b_1
XFILLER_164_294 VDD VSS sg13g2_decap_8
X_14091_ _14091_/Q clkload13/A _14091_/D _14091_/RESET_B VDD VSS sg13g2_dfrbpq_1
XFILLER_4_945 VDD VSS sg13g2_decap_8
XFILLER_124_136 VDD VSS sg13g2_decap_4
XFILLER_166_98 VDD VSS sg13g2_decap_8
XFILLER_152_456 VDD VSS sg13g2_fill_2
XFILLER_152_467 VDD VSS sg13g2_fill_1
XFILLER_65_1111 VDD VSS sg13g2_decap_4
X_13042_ _13043_/B _13042_/A _13042_/B _13042_/C VDD VSS sg13g2_nand3_1
XFILLER_105_350 VDD VSS sg13g2_decap_8
X_10254_ _10256_/A _14779_/Q _10258_/D _14780_/Q VDD VSS sg13g2_a21o_1
XFILLER_79_713 VDD VSS sg13g2_fill_1
XFILLER_3_466 VDD VSS sg13g2_decap_8
XFILLER_79_735 VDD VSS sg13g2_decap_4
Xfanout1201 _12799_/A _13601_/A VDD VSS sg13g2_buf_1
XFILLER_156_1294 VDD VSS sg13g2_decap_8
XFILLER_182_53 VDD VSS sg13g2_decap_8
Xfanout1212 _10702_/A _14903_/Q VDD VSS sg13g2_buf_1
Xfanout1223 _10513_/D _14851_/Q VDD VSS sg13g2_buf_1
X_10185_ _10185_/Y _10185_/A _10185_/B _10185_/C VDD VSS sg13g2_nand3_1
XFILLER_117_1267 VDD VSS sg13g2_fill_2
XFILLER_120_342 VDD VSS sg13g2_fill_2
XFILLER_43_1420 VDD VSS sg13g2_decap_8
Xfanout1234 _12347_/B _14750_/Q VDD VSS sg13g2_buf_1
XFILLER_117_1278 VDD VSS sg13g2_fill_2
Xfanout1245 _12118_/C _11446_/A VDD VSS sg13g2_buf_1
XFILLER_66_407 VDD VSS sg13g2_fill_2
Xfanout1256 _11957_/A _12336_/A2 VDD VSS sg13g2_buf_1
Xfanout1267 _11898_/C _11351_/C1 VDD VSS sg13g2_buf_1
XFILLER_94_738 VDD VSS sg13g2_decap_8
X_14993_ _14993_/Q clkload64/A _14993_/D _14993_/RESET_B VDD VSS sg13g2_dfrbpq_1
Xfanout280 _09434_/S fanout284/X VDD VSS sg13g2_buf_1
Xfanout1278 _11963_/S1 fanout1280/X VDD VSS sg13g2_buf_1
XFILLER_59_470 VDD VSS sg13g2_decap_8
XFILLER_120_397 VDD VSS sg13g2_decap_8
XFILLER_130_1423 VDD VSS sg13g2_fill_2
Xfanout291 _10080_/A0 _09019_/Y VDD VSS sg13g2_buf_1
XFILLER_8_1082 VDD VSS sg13g2_decap_8
XFILLER_59_481 VDD VSS sg13g2_fill_2
XFILLER_115_91 VDD VSS sg13g2_decap_8
Xfanout1289 _11693_/C fanout1293/X VDD VSS sg13g2_buf_1
XFILLER_19_334 VDD VSS sg13g2_decap_8
X_13944_ _13944_/Q clkload68/A _13944_/D _13944_/RESET_B VDD VSS sg13g2_dfrbpq_1
XFILLER_93_259 VDD VSS sg13g2_fill_2
XFILLER_75_51 VDD VSS sg13g2_fill_2
XFILLER_74_440 VDD VSS sg13g2_decap_8
X_15132__2716 _15132_/RESET_B VDD VSS sg13g2_tiehi
XFILLER_75_996 VDD VSS sg13g2_fill_2
XFILLER_34_304 VDD VSS sg13g2_fill_1
X_13875_ _13875_/Q clkload39/A _13875_/D _13875_/RESET_B VDD VSS sg13g2_dfrbpq_1
XFILLER_35_838 VDD VSS sg13g2_decap_8
XFILLER_61_101 VDD VSS sg13g2_decap_8
XFILLER_46_175 VDD VSS sg13g2_decap_8
XFILLER_28_890 VDD VSS sg13g2_decap_4
X_12826_ _12826_/X _12900_/A _12900_/B _12866_/B input13/X VDD VSS sg13g2_and4_1
XFILLER_76_1240 VDD VSS sg13g2_decap_8
XFILLER_61_156 VDD VSS sg13g2_decap_8
XFILLER_37_1224 VDD VSS sg13g2_decap_8
X_12757_ _12757_/X _13752_/Q _14104_/Q _14456_/Q _14552_/Q _12759_/S0 _12759_/S1 VDD
+ VSS sg13g2_mux4_1
XFILLER_163_1254 VDD VSS sg13g2_decap_8
XFILLER_30_521 VDD VSS sg13g2_decap_8
XFILLER_148_707 VDD VSS sg13g2_decap_4
XFILLER_148_718 VDD VSS sg13g2_decap_8
X_11708_ _11708_/X _14569_/Q _14601_/Q _14633_/Q _14665_/Q _11715_/S0 _11715_/S1 VDD
+ VSS sg13g2_mux4_1
XFILLER_30_532 VDD VSS sg13g2_fill_1
XFILLER_129_910 VDD VSS sg13g2_decap_4
X_12688_ _12688_/X _14387_/Q _14419_/Q _14483_/Q _14515_/Q _12711_/S0 _12711_/S1 VDD
+ VSS sg13g2_mux4_1
X_14018__2184 _14018_/RESET_B VDD VSS sg13g2_tiehi
XFILLER_175_537 VDD VSS sg13g2_fill_2
X_14427_ _14427_/Q clkload78/A _14427_/D _14427_/RESET_B VDD VSS sg13g2_dfrbpq_1
X_11639_ _11639_/Y _11570_/A _13683_/Q _13682_/Q _11591_/A VDD VSS sg13g2_a22oi_1
XFILLER_50_1435 VDD VSS sg13g2_decap_8
XFILLER_30_598 VDD VSS sg13g2_decap_8
XFILLER_11_1408 VDD VSS sg13g2_decap_8
XFILLER_11_790 VDD VSS sg13g2_decap_8
XFILLER_156_762 VDD VSS sg13g2_decap_4
XFILLER_128_464 VDD VSS sg13g2_decap_8
X_14358_ _14358_/Q clkload75/A _14358_/D _14358_/RESET_B VDD VSS sg13g2_dfrbpq_1
XFILLER_183_570 VDD VSS sg13g2_decap_8
XFILLER_183_581 VDD VSS sg13g2_decap_8
X_13309_ _13309_/Y _13506_/A _15207_/Q _13306_/B VDD VSS sg13g2_a21oi_1
X_14197__2005 _14197_/RESET_B VDD VSS sg13g2_tiehi
XFILLER_155_294 VDD VSS sg13g2_decap_8
XFILLER_157_1025 VDD VSS sg13g2_decap_8
XFILLER_143_445 VDD VSS sg13g2_decap_4
X_14289_ _14289_/Q _14417_/CLK _14289_/D _14289_/RESET_B VDD VSS sg13g2_dfrbpq_1
XFILLER_83_1200 VDD VSS sg13g2_decap_8
XFILLER_131_607 VDD VSS sg13g2_decap_8
XFILLER_103_309 VDD VSS sg13g2_decap_8
XFILLER_87_1391 VDD VSS sg13g2_decap_8
XFILLER_48_1342 VDD VSS sg13g2_decap_8
XFILLER_174_1350 VDD VSS sg13g2_decap_8
XFILLER_97_510 VDD VSS sg13g2_decap_8
XFILLER_69_212 VDD VSS sg13g2_decap_8
XFILLER_112_832 VDD VSS sg13g2_fill_2
XFILLER_170_1214 VDD VSS sg13g2_decap_8
XFILLER_112_843 VDD VSS sg13g2_decap_8
X_08850_ _08850_/X _08849_/X _11428_/A _08875_/S VDD VSS sg13g2_mux2_1
XFILLER_83_1277 VDD VSS sg13g2_decap_8
XFILLER_44_1228 VDD VSS sg13g2_decap_8
XFILLER_85_705 VDD VSS sg13g2_fill_2
XFILLER_69_256 VDD VSS sg13g2_decap_8
X_07801_ _07950_/A _15008_/Q _08471_/B VDD VSS sg13g2_nand2b_1
XFILLER_97_576 VDD VSS sg13g2_fill_1
XFILLER_27_0 VDD VSS sg13g2_decap_8
X_08781_ _08781_/Y _13679_/Q _08787_/B VDD VSS sg13g2_nor2_1
XFILLER_66_930 VDD VSS sg13g2_decap_4
XFILLER_84_237 VDD VSS sg13g2_decap_4
XFILLER_133_1080 VDD VSS sg13g2_fill_1
X_07732_ _08659_/B _15097_/Q _15092_/Q VDD VSS sg13g2_nor2_1
XFILLER_168_1110 VDD VSS sg13g2_fill_1
XFILLER_38_676 VDD VSS sg13g2_decap_8
XFILLER_1_70 VDD VSS sg13g2_decap_8
XFILLER_38_687 VDD VSS sg13g2_fill_1
XFILLER_168_1132 VDD VSS sg13g2_decap_8
X_07663_ _07663_/Y input36/X input3/X _14749_/Q VDD VSS sg13g2_o21ai_1
XFILLER_93_793 VDD VSS sg13g2_fill_2
XFILLER_92_270 VDD VSS sg13g2_fill_1
X_14228__1974 _14228_/RESET_B VDD VSS sg13g2_tiehi
XFILLER_129_1116 VDD VSS sg13g2_fill_2
X_09402_ _14005_/D _09767_/A1 _14005_/Q _09405_/S VDD VSS sg13g2_mux2_1
Xclkbuf_leaf_123_clk_i _14725_/CLK clkbuf_5_4__f_clk_i/X VDD VSS sg13g2_buf_8
XFILLER_0_1366 VDD VSS sg13g2_decap_8
XFILLER_164_1029 VDD VSS sg13g2_decap_8
XFILLER_59_1471 VDD VSS sg13g2_decap_8
X_09333_ _13940_/D _09931_/A1 _13940_/Q _09333_/S VDD VSS sg13g2_mux2_1
XFILLER_80_476 VDD VSS sg13g2_decap_8
XFILLER_107_1403 VDD VSS sg13g2_decap_8
XFILLER_146_1452 VDD VSS sg13g2_decap_8
XFILLER_90_1215 VDD VSS sg13g2_decap_8
XFILLER_55_1335 VDD VSS sg13g2_decap_8
XFILLER_52_189 VDD VSS sg13g2_decap_8
XFILLER_40_329 VDD VSS sg13g2_decap_8
XFILLER_107_1414 VDD VSS sg13g2_fill_2
XFILLER_181_1365 VDD VSS sg13g2_decap_8
X_09264_ _13873_/D _13873_/Q _09895_/A0 _09272_/S VDD VSS sg13g2_mux2_1
XFILLER_21_576 VDD VSS sg13g2_fill_1
X_08215_ _08215_/X _08219_/A _07888_/B _07910_/B _08215_/A3 _08023_/A _07884_/A VDD
+ VSS sg13g2_mux4_1
XFILLER_166_548 VDD VSS sg13g2_decap_4
X_09195_ _13811_/D _13811_/Q _10162_/A1 _09200_/S VDD VSS sg13g2_mux2_1
XFILLER_53_1092 VDD VSS sg13g2_decap_8
XFILLER_119_442 VDD VSS sg13g2_decap_8
XFILLER_147_751 VDD VSS sg13g2_fill_2
XFILLER_14_1065 VDD VSS sg13g2_decap_8
X_08146_ _08146_/X _08146_/A _08452_/D VDD VSS sg13g2_and2_1
XFILLER_107_637 VDD VSS sg13g2_decap_8
XFILLER_20_35 VDD VSS sg13g2_decap_8
XFILLER_135_968 VDD VSS sg13g2_decap_8
XFILLER_175_1125 VDD VSS sg13g2_decap_8
X_08077_ _08078_/C _08499_/B1 _08076_/Y _08359_/B2 _08058_/X VDD VSS sg13g2_a22oi_1
XFILLER_101_1079 VDD VSS sg13g2_decap_8
XFILLER_105_7 VDD VSS sg13g2_fill_2
XFILLER_150_905 VDD VSS sg13g2_fill_2
XFILLER_88_1188 VDD VSS sg13g2_decap_8
XFILLER_136_35 VDD VSS sg13g2_decap_8
XFILLER_161_242 VDD VSS sg13g2_decap_8
XFILLER_66_1431 VDD VSS sg13g2_decap_8
X_13716__2486 _13716_/RESET_B VDD VSS sg13g2_tiehi
XFILLER_27_1404 VDD VSS sg13g2_decap_8
XFILLER_136_79 VDD VSS sg13g2_decap_8
XFILLER_62_1306 VDD VSS sg13g2_decap_8
XFILLER_1_959 VDD VSS sg13g2_decap_8
XFILLER_103_854 VDD VSS sg13g2_decap_4
XFILLER_49_908 VDD VSS sg13g2_decap_8
XFILLER_153_1456 VDD VSS sg13g2_decap_8
XFILLER_0_469 VDD VSS sg13g2_decap_8
XFILLER_48_407 VDD VSS sg13g2_decap_8
XFILLER_130_673 VDD VSS sg13g2_decap_8
X_08979_ _13757_/D _13757_/Q _10140_/A1 _09153_/S VDD VSS sg13g2_mux2_1
XFILLER_88_598 VDD VSS sg13g2_fill_2
XFILLER_5_1211 VDD VSS sg13g2_decap_8
XFILLER_102_386 VDD VSS sg13g2_fill_1
XFILLER_75_226 VDD VSS sg13g2_fill_1
XFILLER_102_397 VDD VSS sg13g2_fill_2
X_13895__2307 _13895_/RESET_B VDD VSS sg13g2_tiehi
XFILLER_69_790 VDD VSS sg13g2_fill_2
X_11990_ _11990_/X _14129_/Q _14161_/Q _14193_/Q _14225_/Q _11997_/S0 _11997_/S1 VDD
+ VSS sg13g2_mux4_1
XFILLER_75_259 VDD VSS sg13g2_fill_2
XFILLER_25_1194 VDD VSS sg13g2_decap_8
X_13931__2271 _13931_/RESET_B VDD VSS sg13g2_tiehi
XFILLER_99_1251 VDD VSS sg13g2_decap_8
XFILLER_91_719 VDD VSS sg13g2_decap_8
XFILLER_57_974 VDD VSS sg13g2_decap_8
XFILLER_186_1210 VDD VSS sg13g2_decap_8
XFILLER_84_760 VDD VSS sg13g2_decap_8
XFILLER_21_1047 VDD VSS sg13g2_decap_8
XFILLER_5_1288 VDD VSS sg13g2_decap_8
XFILLER_17_827 VDD VSS sg13g2_decap_8
X_10941_ _10941_/X _14938_/Q _10973_/B VDD VSS sg13g2_and2_1
XFILLER_28_175 VDD VSS sg13g2_decap_8
XFILLER_95_1148 VDD VSS sg13g2_decap_8
XFILLER_16_348 VDD VSS sg13g2_fill_2
X_13660_ _13660_/Q clkload82/A _13660_/D _13660_/RESET_B VDD VSS sg13g2_dfrbpq_1
XFILLER_72_966 VDD VSS sg13g2_decap_4
XFILLER_44_657 VDD VSS sg13g2_decap_8
XFILLER_186_1287 VDD VSS sg13g2_decap_8
X_10872_ _10872_/Y _10871_/Y _07753_/D _10869_/Y _10867_/Y _10886_/A2 VDD VSS sg13g2_a221oi_1
XFILLER_43_145 VDD VSS sg13g2_decap_8
XFILLER_73_1402 VDD VSS sg13g2_decap_8
XFILLER_32_819 VDD VSS sg13g2_decap_4
XFILLER_25_860 VDD VSS sg13g2_fill_2
X_12611_ _15007_/D _12611_/A _12611_/B VDD VSS sg13g2_nor2_1
X_13591_ _15162_/D _13590_/B _13589_/Y _13590_/Y VDD VSS sg13g2_a21oi_1
XFILLER_25_893 VDD VSS sg13g2_fill_1
XFILLER_24_370 VDD VSS sg13g2_decap_8
XFILLER_12_521 VDD VSS sg13g2_decap_8
XFILLER_160_1416 VDD VSS sg13g2_decap_8
X_12542_ _12555_/A _12570_/A1 _12570_/A2 _15003_/Q VDD VSS sg13g2_a21oi_1
XFILLER_61_42 VDD VSS sg13g2_decap_8
XFILLER_40_863 VDD VSS sg13g2_decap_8
XFILLER_157_548 VDD VSS sg13g2_decap_8
XFILLER_185_857 VDD VSS sg13g2_decap_8
XFILLER_8_536 VDD VSS sg13g2_decap_8
XFILLER_12_598 VDD VSS sg13g2_decap_8
X_12473_ _12473_/X _14116_/Q _14148_/Q _14180_/Q _14212_/Q _12480_/S0 _12480_/S1 VDD
+ VSS sg13g2_mux4_1
XFILLER_177_53 VDD VSS sg13g2_decap_8
XFILLER_184_345 VDD VSS sg13g2_decap_8
X_14212_ _14212_/Q clkload49/A _14212_/D _14212_/RESET_B VDD VSS sg13g2_dfrbpq_1
X_11424_ _11425_/A _11423_/Y _11625_/C _11424_/C VDD VSS sg13g2_nand3b_1
XFILLER_172_529 VDD VSS sg13g2_decap_4
X_15192_ _15192_/Q clkload82/A _15192_/D _15192_/RESET_B VDD VSS sg13g2_dfrbpq_1
XFILLER_137_261 VDD VSS sg13g2_decap_4
XFILLER_153_710 VDD VSS sg13g2_decap_4
XFILLER_32_1176 VDD VSS sg13g2_decap_8
XFILLER_158_1312 VDD VSS sg13g2_decap_8
XANTENNA_8 _09294_/S VDD VSS sg13g2_antennanp
XFILLER_67_1206 VDD VSS sg13g2_decap_8
X_14143_ _14143_/Q clkload61/A _14143_/D _14143_/RESET_B VDD VSS sg13g2_dfrbpq_1
X_11355_ _11355_/Y _11365_/A _14654_/Q _11355_/B1 VDD VSS sg13g2_a21oi_1
XFILLER_4_742 VDD VSS sg13g2_decap_8
XFILLER_99_819 VDD VSS sg13g2_decap_8
XFILLER_10_1463 VDD VSS sg13g2_decap_8
XFILLER_98_307 VDD VSS sg13g2_fill_2
XFILLER_113_618 VDD VSS sg13g2_decap_4
X_10306_ _14795_/D _10327_/B _10623_/A _10306_/C VDD VSS sg13g2_nor3_1
XFILLER_119_1329 VDD VSS sg13g2_decap_8
XFILLER_152_264 VDD VSS sg13g2_decap_8
XFILLER_180_573 VDD VSS sg13g2_decap_8
X_14074_ _14074_/Q clkload78/A _14074_/D _14074_/RESET_B VDD VSS sg13g2_dfrbpq_1
XFILLER_141_949 VDD VSS sg13g2_decap_8
XFILLER_158_1389 VDD VSS sg13g2_decap_8
X_11286_ _11287_/B _12192_/A _11276_/Y _11285_/Y VDD VSS sg13g2_o21ai_1
XFILLER_79_510 VDD VSS sg13g2_decap_8
XFILLER_3_263 VDD VSS sg13g2_decap_8
X_14306__1896 _14306_/RESET_B VDD VSS sg13g2_tiehi
XFILLER_140_437 VDD VSS sg13g2_decap_8
X_13025_ _13042_/B _13026_/A _13026_/C _13057_/A VDD VSS sg13g2_o21ai_1
XFILLER_79_532 VDD VSS sg13g2_fill_1
XFILLER_156_1080 VDD VSS sg13g2_decap_4
X_10237_ _10247_/D _10237_/A _10237_/B _10237_/C _10237_/D VDD VSS sg13g2_nor4_1
Xfanout1020 _09027_/S _08991_/S VDD VSS sg13g2_buf_1
Xfanout1031 fanout1031/X _15058_/Q VDD VSS sg13g2_buf_1
XFILLER_94_502 VDD VSS sg13g2_decap_8
XFILLER_6_1019 VDD VSS sg13g2_decap_8
XFILLER_20_7 VDD VSS sg13g2_decap_8
Xfanout1042 _13566_/A _15011_/Q VDD VSS sg13g2_buf_1
XFILLER_86_50 VDD VSS sg13g2_decap_8
XFILLER_0_981 VDD VSS sg13g2_decap_8
Xfanout1053 _08659_/A _08668_/A VDD VSS sg13g2_buf_1
X_10168_ _14745_/D _14745_/Q _10168_/A1 _10169_/S VDD VSS sg13g2_mux2_1
XFILLER_66_215 VDD VSS sg13g2_fill_1
Xfanout1064 _08340_/A _08360_/A1 VDD VSS sg13g2_buf_1
Xfanout1075 _08363_/S1 _08196_/A1 VDD VSS sg13g2_buf_1
X_14485__1717 _14485_/RESET_B VDD VSS sg13g2_tiehi
Xfanout1086 _07883_/A _08102_/S0 VDD VSS sg13g2_buf_1
Xfanout1097 _07900_/B _08083_/S0 VDD VSS sg13g2_buf_1
X_14976_ _14976_/Q clkload56/A _14976_/D _14976_/RESET_B VDD VSS sg13g2_dfrbpq_1
X_10099_ _14679_/D _10099_/A0 _14679_/Q _10101_/S VDD VSS sg13g2_mux2_1
XFILLER_43_1294 VDD VSS sg13g2_decap_8
Xclkbuf_leaf_40_clk_i clkload43/A clkbuf_leaf_42_clk_i/A VDD VSS sg13g2_buf_8
XFILLER_48_974 VDD VSS sg13g2_fill_1
X_14521__1681 _14521_/RESET_B VDD VSS sg13g2_tiehi
XFILLER_169_1441 VDD VSS sg13g2_decap_8
XFILLER_78_1324 VDD VSS sg13g2_decap_8
XFILLER_35_613 VDD VSS sg13g2_decap_8
X_13927_ _13927_/Q _14704_/CLK _13927_/D _13927_/RESET_B VDD VSS sg13g2_dfrbpq_1
XFILLER_47_484 VDD VSS sg13g2_decap_8
XFILLER_34_112 VDD VSS sg13g2_decap_4
XFILLER_39_1308 VDD VSS sg13g2_decap_8
XFILLER_34_134 VDD VSS sg13g2_fill_2
X_13858_ _13858_/Q _14722_/CLK _13858_/D _13858_/RESET_B VDD VSS sg13g2_dfrbpq_1
XFILLER_90_763 VDD VSS sg13g2_fill_2
XFILLER_62_454 VDD VSS sg13g2_decap_8
X_14775__2961 _14775_/RESET_B VDD VSS sg13g2_tiehi
XFILLER_90_796 VDD VSS sg13g2_decap_8
X_12809_ _12809_/Y _14767_/Q _12918_/A2 _12918_/B1 VDD VSS sg13g2_o21ai_1
XFILLER_76_1070 VDD VSS sg13g2_fill_1
XFILLER_50_638 VDD VSS sg13g2_fill_2
X_13789_ _13789_/Q clkload30/A _13789_/D _13789_/RESET_B VDD VSS sg13g2_dfrbpq_1
Xclkbuf_leaf_55_clk_i clkload73/A clkload4/A VDD VSS sg13g2_buf_8
XFILLER_176_846 VDD VSS sg13g2_fill_2
XFILLER_15_1341 VDD VSS sg13g2_decap_8
XFILLER_30_373 VDD VSS sg13g2_decap_8
XFILLER_124_1068 VDD VSS sg13g2_decap_8
XFILLER_129_751 VDD VSS sg13g2_decap_8
XFILLER_50_1232 VDD VSS sg13g2_decap_8
XFILLER_129_762 VDD VSS sg13g2_fill_2
XFILLER_141_1360 VDD VSS sg13g2_decap_8
X_08000_ _08588_/B _08001_/A _08275_/B _08001_/C _08001_/D VDD VSS sg13g2_and4_1
XFILLER_11_1205 VDD VSS sg13g2_decap_8
XFILLER_128_250 VDD VSS sg13g2_fill_1
XFILLER_176_1401 VDD VSS sg13g2_decap_8
X_13973__2229 _13973_/RESET_B VDD VSS sg13g2_tiehi
XFILLER_89_1464 VDD VSS sg13g2_decap_8
XFILLER_128_283 VDD VSS sg13g2_decap_8
XFILLER_116_467 VDD VSS sg13g2_fill_1
X_09951_ _14535_/D _14535_/Q _10083_/A0 _09957_/S VDD VSS sg13g2_mux2_1
XFILLER_144_798 VDD VSS sg13g2_decap_8
XFILLER_171_595 VDD VSS sg13g2_fill_2
XFILLER_83_1030 VDD VSS sg13g2_decap_8
XFILLER_131_437 VDD VSS sg13g2_decap_8
X_08902_ _13708_/D _08935_/S _08900_/Y _08901_/Y VDD VSS sg13g2_a21oi_1
X_09882_ _14468_/D _09882_/A0 _14468_/Q _09890_/S VDD VSS sg13g2_mux2_1
XFILLER_83_1085 VDD VSS sg13g2_decap_8
XFILLER_135_1153 VDD VSS sg13g2_decap_8
XFILLER_140_971 VDD VSS sg13g2_decap_4
X_08833_ _08833_/Y _13613_/B _13613_/C _08833_/C VDD VSS sg13g2_nor3_1
XFILLER_57_204 VDD VSS sg13g2_decap_8
XFILLER_111_161 VDD VSS sg13g2_decap_8
XFILLER_131_1017 VDD VSS sg13g2_decap_8
XFILLER_44_1069 VDD VSS sg13g2_decap_8
XFILLER_85_535 VDD VSS sg13g2_decap_8
XFILLER_100_868 VDD VSS sg13g2_decap_8
X_08764_ _08764_/Y _13673_/Q _13469_/B VDD VSS sg13g2_nor2_1
XFILLER_61_1372 VDD VSS sg13g2_decap_8
XFILLER_38_440 VDD VSS sg13g2_decap_8
XFILLER_22_1356 VDD VSS sg13g2_decap_8
XFILLER_54_911 VDD VSS sg13g2_fill_1
X_07715_ _07721_/B _15099_/Q _15098_/Q _15088_/Q _15087_/Q VDD VSS sg13g2_nor4_1
XFILLER_96_1413 VDD VSS sg13g2_decap_8
XFILLER_2_1428 VDD VSS sg13g2_decap_8
X_08695_ _08695_/Y _08681_/B _08679_/Y _08673_/X VDD VSS sg13g2_o21ai_1
XFILLER_38_484 VDD VSS sg13g2_decap_8
XFILLER_38_495 VDD VSS sg13g2_fill_1
XFILLER_57_1408 VDD VSS sg13g2_decap_8
XFILLER_81_741 VDD VSS sg13g2_decap_8
X_07646_ _07646_/Y _14802_/Q VDD VSS sg13g2_inv_1
XFILLER_53_443 VDD VSS sg13g2_fill_2
XFILLER_25_134 VDD VSS sg13g2_fill_2
XFILLER_0_1163 VDD VSS sg13g2_decap_8
XFILLER_183_1449 VDD VSS sg13g2_decap_8
XFILLER_41_627 VDD VSS sg13g2_decap_8
XFILLER_15_35 VDD VSS sg13g2_decap_8
XFILLER_80_273 VDD VSS sg13g2_fill_2
XFILLER_94_1170 VDD VSS sg13g2_decap_8
XFILLER_41_638 VDD VSS sg13g2_fill_1
XFILLER_55_1132 VDD VSS sg13g2_decap_8
X_09316_ _13923_/D _10146_/A1 _13923_/Q _09329_/S VDD VSS sg13g2_mux2_1
XFILLER_142_1113 VDD VSS sg13g2_decap_8
XFILLER_181_1162 VDD VSS sg13g2_decap_8
XFILLER_178_161 VDD VSS sg13g2_decap_8
XFILLER_22_863 VDD VSS sg13g2_decap_8
XFILLER_107_1244 VDD VSS sg13g2_decap_8
XFILLER_16_1127 VDD VSS sg13g2_decap_8
XFILLER_139_537 VDD VSS sg13g2_decap_8
XFILLER_142_1146 VDD VSS sg13g2_decap_8
XFILLER_142_1157 VDD VSS sg13g2_fill_2
XFILLER_167_857 VDD VSS sg13g2_fill_2
X_09247_ _13856_/D _13856_/Q _09612_/A0 _09267_/S VDD VSS sg13g2_mux2_1
XFILLER_108_902 VDD VSS sg13g2_decap_8
Xclkbuf_4_2_0_clk_i clkbuf_4_2_0_clk_i/X clkbuf_0_clk_i/X VDD VSS sg13g2_buf_8
XFILLER_126_209 VDD VSS sg13g2_decap_8
XFILLER_166_378 VDD VSS sg13g2_decap_8
XFILLER_166_389 VDD VSS sg13g2_fill_1
XFILLER_181_315 VDD VSS sg13g2_decap_8
X_09178_ _13794_/D _13794_/Q _10045_/A0 _09189_/S VDD VSS sg13g2_mux2_1
XFILLER_120_1444 VDD VSS sg13g2_decap_8
XFILLER_147_34 VDD VSS sg13g2_decap_8
Xclkbuf_5_9__f_clk_i clkload2/A clkbuf_4_4_0_clk_i/X VDD VSS sg13g2_buf_16
XFILLER_5_539 VDD VSS sg13g2_decap_8
XFILLER_120_1466 VDD VSS sg13g2_decap_8
X_14563__1639 _14563_/RESET_B VDD VSS sg13g2_tiehi
X_08129_ _08129_/X _08306_/C _07786_/A _07782_/A _07790_/A _08337_/S0 _08337_/S1 VDD
+ VSS sg13g2_mux4_1
XFILLER_107_445 VDD VSS sg13g2_decap_8
X_13949__2253 _13949_/RESET_B VDD VSS sg13g2_tiehi
XFILLER_162_551 VDD VSS sg13g2_decap_8
XFILLER_162_562 VDD VSS sg13g2_fill_2
X_11140_ _11140_/Y _11139_/Y _11138_/Y _11136_/Y _11191_/A _11193_/A2 VDD VSS sg13g2_a221oi_1
XFILLER_122_426 VDD VSS sg13g2_decap_8
Xoutput45 mem_axi_araddr[16] _16869_/A VDD VSS sg13g2_buf_1
XFILLER_27_1201 VDD VSS sg13g2_decap_8
XFILLER_134_297 VDD VSS sg13g2_decap_8
Xoutput56 mem_axi_araddr[27] _16880_/A VDD VSS sg13g2_buf_1
X_14853__2861 _14853_/RESET_B VDD VSS sg13g2_tiehi
Xoutput67 mem_axi_araddr[8] _16861_/A VDD VSS sg13g2_buf_1
XFILLER_118_1340 VDD VSS sg13g2_fill_1
XFILLER_150_768 VDD VSS sg13g2_decap_4
Xoutput78 mem_axi_awaddr[17] _16870_/X VDD VSS sg13g2_buf_1
X_11071_ _11071_/Y _11109_/B _11068_/B _11154_/B1 VDD VSS sg13g2_o21ai_1
XFILLER_1_756 VDD VSS sg13g2_decap_8
XFILLER_89_863 VDD VSS sg13g2_decap_4
Xoutput89 mem_axi_awaddr[28] _16881_/X VDD VSS sg13g2_buf_1
XFILLER_49_705 VDD VSS sg13g2_decap_4
XFILLER_103_662 VDD VSS sg13g2_fill_2
Xhold3150 _10216_/B _14765_/Q VDD VSS sg13g2_dlygate4sd3_1
Xhold3161 _11133_/A _14951_/Q VDD VSS sg13g2_dlygate4sd3_1
X_10022_ _14604_/D _10088_/A0 _14604_/Q _10024_/S VDD VSS sg13g2_mux2_1
XFILLER_0_266 VDD VSS sg13g2_decap_8
XFILLER_163_77 VDD VSS sg13g2_decap_8
Xhold3172 hold3172/X _14890_/Q VDD VSS sg13g2_dlygate4sd3_1
XFILLER_76_513 VDD VSS sg13g2_decap_4
XFILLER_48_204 VDD VSS sg13g2_fill_1
XFILLER_49_738 VDD VSS sg13g2_decap_8
XFILLER_27_1278 VDD VSS sg13g2_decap_8
X_14830_ _14830_/Q _14893_/CLK _14830_/D _14830_/RESET_B VDD VSS sg13g2_dfrbpq_1
XFILLER_91_505 VDD VSS sg13g2_decap_8
XFILLER_76_579 VDD VSS sg13g2_decap_4
XFILLER_64_719 VDD VSS sg13g2_decap_8
XFILLER_56_42 VDD VSS sg13g2_decap_8
XFILLER_45_900 VDD VSS sg13g2_decap_8
XFILLER_40_1445 VDD VSS sg13g2_decap_8
X_14886__2795 _14886_/RESET_B VDD VSS sg13g2_tiehi
XFILLER_29_462 VDD VSS sg13g2_fill_2
XFILLER_63_218 VDD VSS sg13g2_decap_8
XFILLER_17_624 VDD VSS sg13g2_decap_8
X_14761_ _14761_/Q _15203_/CLK _14761_/D _14761_/RESET_B VDD VSS sg13g2_dfrbpq_1
X_11973_ _11973_/Y _11973_/A _11973_/B VDD VSS sg13g2_nand2_1
XFILLER_5_1085 VDD VSS sg13g2_decap_8
XFILLER_16_123 VDD VSS sg13g2_decap_8
X_13712_ _16874_/A _14602_/CLK _13712_/D _13712_/RESET_B VDD VSS sg13g2_dfrbpq_1
X_10924_ _10924_/Y _10954_/D _10954_/A _07649_/A VDD VSS sg13g2_a21oi_1
XFILLER_45_966 VDD VSS sg13g2_fill_1
XFILLER_147_1013 VDD VSS sg13g2_decap_4
X_14692_ _14692_/Q _14724_/CLK _14692_/D _14692_/RESET_B VDD VSS sg13g2_dfrbpq_1
XFILLER_60_914 VDD VSS sg13g2_fill_1
X_13643_ _13751_/D _13643_/A VDD VSS sg13g2_buf_1
X_10855_ _10890_/A _14752_/Q _10870_/A VDD VSS sg13g2_nor2_1
XFILLER_77_1390 VDD VSS sg13g2_decap_8
XFILLER_60_958 VDD VSS sg13g2_decap_8
XFILLER_125_1300 VDD VSS sg13g2_decap_8
XFILLER_31_126 VDD VSS sg13g2_decap_8
XFILLER_38_1363 VDD VSS sg13g2_decap_8
XFILLER_158_813 VDD VSS sg13g2_fill_1
XFILLER_164_1371 VDD VSS sg13g2_decap_8
XFILLER_13_863 VDD VSS sg13g2_decap_8
XFILLER_160_1213 VDD VSS sg13g2_decap_8
X_13574_ _13574_/Y _14998_/Q _13592_/A2 _13569_/S _15014_/Q _13521_/X VDD VSS sg13g2_a221oi_1
X_10786_ _10787_/A _14923_/Q _11170_/B _11154_/B1 _11181_/A VDD VSS sg13g2_a22oi_1
XFILLER_9_812 VDD VSS sg13g2_decap_8
XFILLER_73_1276 VDD VSS sg13g2_decap_8
X_12525_ _12525_/X _12524_/X _12523_/X _12650_/S VDD VSS sg13g2_mux2_1
XFILLER_8_333 VDD VSS sg13g2_decap_8
XFILLER_184_142 VDD VSS sg13g2_decap_8
XFILLER_185_665 VDD VSS sg13g2_decap_8
XFILLER_117_209 VDD VSS sg13g2_decap_8
XFILLER_9_889 VDD VSS sg13g2_decap_8
XFILLER_145_529 VDD VSS sg13g2_fill_1
XFILLER_173_838 VDD VSS sg13g2_decap_8
X_15244_ _15244_/Q clkload48/A _15244_/D _15244_/RESET_B VDD VSS sg13g2_dfrbpq_1
X_12456_ _12457_/B _13686_/Q _12651_/A2 _12455_/X _12386_/A _12651_/C1 VDD VSS sg13g2_a221oi_1
XFILLER_123_1090 VDD VSS sg13g2_decap_8
XFILLER_68_7 VDD VSS sg13g2_decap_8
X_11407_ _11407_/Y _11826_/A1 _14367_/Q VDD VSS sg13g2_nand2b_1
X_15175_ _15175_/Q clkload82/A _15175_/D _15175_/RESET_B VDD VSS sg13g2_dfrbpq_1
X_12387_ _12387_/Y _15121_/Q _12348_/A _12596_/A2 _13691_/Q _12596_/C1 VDD VSS sg13g2_a221oi_1
X_14539__1663 _14539_/RESET_B VDD VSS sg13g2_tiehi
XFILLER_10_1260 VDD VSS sg13g2_decap_8
X_14126_ _14126_/Q _14670_/CLK _14126_/D _14126_/RESET_B VDD VSS sg13g2_dfrbpq_1
X_11338_ _11339_/B _11338_/A _11338_/B VDD VSS sg13g2_nor2_1
XFILLER_99_627 VDD VSS sg13g2_decap_4
XFILLER_113_426 VDD VSS sg13g2_decap_4
XFILLER_153_595 VDD VSS sg13g2_decap_4
XFILLER_158_1186 VDD VSS sg13g2_decap_8
XFILLER_154_1028 VDD VSS sg13g2_decap_8
XFILLER_45_1312 VDD VSS sg13g2_decap_8
X_14057_ _14057_/Q _14665_/CLK _14057_/D _14057_/RESET_B VDD VSS sg13g2_dfrbpq_1
X_11269_ _11287_/A _12174_/A _11258_/Y _11268_/Y VDD VSS sg13g2_o21ai_1
XFILLER_84_1372 VDD VSS sg13g2_decap_8
XFILLER_136_1451 VDD VSS sg13g2_decap_8
XFILLER_80_1214 VDD VSS sg13g2_decap_8
X_13008_ _13010_/B _13058_/A _13058_/C VDD VSS sg13g2_nand2_1
XFILLER_171_1364 VDD VSS sg13g2_decap_8
XFILLER_132_1337 VDD VSS sg13g2_decap_4
XFILLER_45_1389 VDD VSS sg13g2_decap_8
XFILLER_95_855 VDD VSS sg13g2_decap_8
XFILLER_95_877 VDD VSS sg13g2_fill_1
XFILLER_39_259 VDD VSS sg13g2_decap_8
XFILLER_94_354 VDD VSS sg13g2_decap_8
XFILLER_82_516 VDD VSS sg13g2_fill_1
X_14959_ _14959_/Q clkload63/A _14959_/D _14959_/RESET_B VDD VSS sg13g2_dfrbpq_1
X_08480_ _08481_/B _08478_/Y _08479_/Y _08477_/Y VDD VSS sg13g2_a21oi_1
XFILLER_62_262 VDD VSS sg13g2_decap_8
XFILLER_35_476 VDD VSS sg13g2_decap_8
XFILLER_78_1198 VDD VSS sg13g2_decap_8
XFILLER_51_936 VDD VSS sg13g2_decap_8
XFILLER_56_1430 VDD VSS sg13g2_decap_8
XFILLER_165_1168 VDD VSS sg13g2_decap_8
XFILLER_23_649 VDD VSS sg13g2_decap_8
XFILLER_91_1332 VDD VSS sg13g2_decap_8
XFILLER_22_137 VDD VSS sg13g2_decap_8
XFILLER_143_1411 VDD VSS sg13g2_fill_2
XFILLER_167_109 VDD VSS sg13g2_decap_8
XFILLER_182_1460 VDD VSS sg13g2_decap_8
XFILLER_52_1305 VDD VSS sg13g2_decap_8
XFILLER_148_312 VDD VSS sg13g2_decap_8
XFILLER_31_660 VDD VSS sg13g2_decap_8
X_09101_ _10752_/B _09107_/B _15043_/Q _09100_/Y VDD VSS sg13g2_o21ai_1
XFILLER_149_857 VDD VSS sg13g2_fill_2
XFILLER_17_1469 VDD VSS sg13g2_decap_8
XFILLER_176_687 VDD VSS sg13g2_decap_4
X_09032_ _09032_/X _09031_/A _09027_/X _09031_/Y VDD VSS sg13g2_a21o_1
XFILLER_11_1002 VDD VSS sg13g2_decap_8
XFILLER_136_529 VDD VSS sg13g2_decap_8
XFILLER_163_304 VDD VSS sg13g2_fill_2
XFILLER_117_721 VDD VSS sg13g2_fill_1
XFILLER_141_1190 VDD VSS sg13g2_decap_8
XFILLER_175_197 VDD VSS sg13g2_fill_1
XFILLER_117_754 VDD VSS sg13g2_decap_8
XFILLER_144_540 VDD VSS sg13g2_decap_4
XFILLER_89_1272 VDD VSS sg13g2_decap_4
XFILLER_7_91 VDD VSS sg13g2_decap_8
XFILLER_116_242 VDD VSS sg13g2_decap_8
XFILLER_11_1079 VDD VSS sg13g2_decap_8
XFILLER_137_1204 VDD VSS sg13g2_decap_8
XFILLER_172_871 VDD VSS sg13g2_decap_8
XFILLER_105_938 VDD VSS sg13g2_decap_8
XFILLER_85_1147 VDD VSS sg13g2_fill_2
XFILLER_132_735 VDD VSS sg13g2_fill_1
XFILLER_176_1275 VDD VSS sg13g2_decap_8
XFILLER_85_1169 VDD VSS sg13g2_decap_8
Xfanout802 _12706_/S _12595_/S VDD VSS sg13g2_buf_1
XFILLER_137_1259 VDD VSS sg13g2_fill_1
X_09934_ _14519_/D _14519_/Q _09934_/A1 _09936_/S VDD VSS sg13g2_mux2_1
Xfanout813 _12594_/S0 _12398_/S0 VDD VSS sg13g2_buf_1
Xfanout824 _12466_/S1 fanout828/X VDD VSS sg13g2_buf_1
Xfanout835 _12698_/S1 _12425_/S1 VDD VSS sg13g2_buf_1
XFILLER_58_502 VDD VSS sg13g2_fill_1
Xfanout846 fanout846/X _12589_/S1 VDD VSS sg13g2_buf_1
XFILLER_63_1456 VDD VSS sg13g2_decap_8
XFILLER_58_513 VDD VSS sg13g2_decap_8
Xfanout857 _12756_/S1 _12768_/S1 VDD VSS sg13g2_buf_1
X_09865_ _14452_/D _14452_/Q _10063_/A0 _09865_/S VDD VSS sg13g2_mux2_1
XFILLER_86_833 VDD VSS sg13g2_decap_8
XFILLER_150_1426 VDD VSS sg13g2_decap_8
Xfanout868 _12450_/S0 fanout877/X VDD VSS sg13g2_buf_1
Xfanout879 _12699_/S0 _12701_/S0 VDD VSS sg13g2_buf_1
XFILLER_86_855 VDD VSS sg13g2_decap_4
X_08816_ _08816_/Y _13499_/C _13481_/A hold3174/X VDD VSS sg13g2_o21ai_1
XFILLER_85_343 VDD VSS sg13g2_decap_8
X_09796_ _14385_/D _09928_/A1 _14385_/Q _09804_/S VDD VSS sg13g2_mux2_1
XFILLER_85_354 VDD VSS sg13g2_fill_1
XFILLER_6_1383 VDD VSS sg13g2_decap_8
XFILLER_22_1153 VDD VSS sg13g2_decap_8
X_08747_ _13667_/D _08753_/A1 _08745_/Y _08746_/Y VDD VSS sg13g2_a21oi_1
XFILLER_39_782 VDD VSS sg13g2_decap_8
XFILLER_2_1225 VDD VSS sg13g2_decap_8
XFILLER_148_1300 VDD VSS sg13g2_fill_2
XFILLER_26_432 VDD VSS sg13g2_decap_8
XFILLER_57_1205 VDD VSS sg13g2_decap_8
X_08678_ _08678_/Y _08678_/A _08678_/B _08678_/C VDD VSS sg13g2_nand3_1
XFILLER_26_56 VDD VSS sg13g2_decap_8
XFILLER_26_476 VDD VSS sg13g2_fill_1
XFILLER_183_1246 VDD VSS sg13g2_decap_8
X_07629_ _07629_/Y _07629_/A VDD VSS sg13g2_inv_1
XFILLER_144_1208 VDD VSS sg13g2_decap_8
XFILLER_148_1377 VDD VSS sg13g2_decap_8
X_14617__1585 _14617_/RESET_B VDD VSS sg13g2_tiehi
XFILLER_13_137 VDD VSS sg13g2_decap_8
XFILLER_41_446 VDD VSS sg13g2_decap_8
X_10640_ _14887_/D _10640_/A _10639_/Y VDD VSS sg13g2_nor2b_1
X_14192__2010 _14192_/RESET_B VDD VSS sg13g2_tiehi
XFILLER_9_119 VDD VSS sg13g2_decap_8
XFILLER_179_481 VDD VSS sg13g2_decap_8
XFILLER_70_1427 VDD VSS sg13g2_decap_8
XFILLER_139_334 VDD VSS sg13g2_decap_8
XFILLER_50_991 VDD VSS sg13g2_fill_1
XFILLER_10_833 VDD VSS sg13g2_decap_8
X_10571_ _10572_/A _12895_/A _10579_/B _10579_/C VDD VSS sg13g2_and3_1
XFILLER_155_805 VDD VSS sg13g2_decap_8
XFILLER_127_507 VDD VSS sg13g2_decap_8
XFILLER_107_1096 VDD VSS sg13g2_decap_8
X_12310_ _12310_/Y _12310_/A _12324_/B VDD VSS sg13g2_nand2_1
XFILLER_182_613 VDD VSS sg13g2_decap_8
XFILLER_158_77 VDD VSS sg13g2_decap_8
XFILLER_166_175 VDD VSS sg13g2_decap_8
X_13290_ _13291_/C _13290_/A _13290_/B _13294_/B _13290_/D VDD VSS sg13g2_nand4_1
XFILLER_6_837 VDD VSS sg13g2_decap_8
XFILLER_181_112 VDD VSS sg13g2_decap_8
XFILLER_33_1282 VDD VSS sg13g2_decap_8
XFILLER_154_337 VDD VSS sg13g2_decap_8
X_12241_ _12241_/Y _12288_/S0 _14616_/Q _12241_/B1 VDD VSS sg13g2_a21oi_1
XFILLER_5_336 VDD VSS sg13g2_decap_8
XFILLER_159_1451 VDD VSS sg13g2_decap_8
XFILLER_174_21 VDD VSS sg13g2_decap_8
XFILLER_120_1296 VDD VSS sg13g2_fill_1
XFILLER_68_1356 VDD VSS sg13g2_decap_8
XFILLER_181_189 VDD VSS sg13g2_decap_8
X_12172_ _12172_/Y _12172_/A _12190_/B VDD VSS sg13g2_nand2_1
XFILLER_150_510 VDD VSS sg13g2_decap_8
XFILLER_155_1326 VDD VSS sg13g2_decap_8
XFILLER_123_746 VDD VSS sg13g2_fill_2
X_11123_ _11127_/B _11123_/A _11123_/B VDD VSS sg13g2_nor2_1
XFILLER_111_908 VDD VSS sg13g2_decap_8
XFILLER_27_1020 VDD VSS sg13g2_decap_4
XFILLER_174_98 VDD VSS sg13g2_decap_8
XFILLER_1_553 VDD VSS sg13g2_decap_8
XFILLER_89_660 VDD VSS sg13g2_fill_2
XFILLER_77_800 VDD VSS sg13g2_fill_1
XFILLER_122_278 VDD VSS sg13g2_decap_8
XFILLER_77_811 VDD VSS sg13g2_fill_2
X_11054_ _11054_/Y _11069_/B _11053_/Y _11044_/C VDD VSS sg13g2_o21ai_1
XFILLER_104_993 VDD VSS sg13g2_decap_4
XFILLER_67_41 VDD VSS sg13g2_decap_8
XFILLER_67_63 VDD VSS sg13g2_decap_4
X_10005_ _14587_/D _10005_/A0 _14587_/Q _10036_/S VDD VSS sg13g2_mux2_1
XFILLER_7_1169 VDD VSS sg13g2_decap_8
XFILLER_27_1097 VDD VSS sg13g2_decap_8
XFILLER_114_1056 VDD VSS sg13g2_fill_1
XFILLER_36_207 VDD VSS sg13g2_decap_8
XFILLER_40_1242 VDD VSS sg13g2_decap_8
X_14813_ _14813_/Q clkload84/A _14813_/D _14813_/RESET_B VDD VSS sg13g2_dfrbpq_1
XFILLER_149_1108 VDD VSS sg13g2_decap_4
XFILLER_18_933 VDD VSS sg13g2_fill_1
XFILLER_79_1430 VDD VSS sg13g2_decap_8
XFILLER_18_944 VDD VSS sg13g2_decap_8
X_14744_ _14744_/Q clkload46/A _14744_/D _14744_/RESET_B VDD VSS sg13g2_dfrbpq_1
XFILLER_79_1474 VDD VSS sg13g2_fill_1
X_11956_ _11957_/B _11953_/Y _11955_/Y _11956_/B1 VDD VSS sg13g2_a21oi_1
XFILLER_44_240 VDD VSS sg13g2_decap_8
XFILLER_166_1444 VDD VSS sg13g2_decap_8
XFILLER_72_560 VDD VSS sg13g2_decap_4
XFILLER_17_487 VDD VSS sg13g2_decap_8
X_10907_ _10907_/Y _10907_/A _10948_/B VDD VSS sg13g2_xnor2_1
XFILLER_75_1349 VDD VSS sg13g2_decap_8
X_14675_ _14675_/Q clkload37/A _14675_/D _14675_/RESET_B VDD VSS sg13g2_dfrbpq_1
X_11887_ _11887_/Y _11890_/S0 _14478_/Q VDD VSS sg13g2_nand2b_1
XFILLER_72_593 VDD VSS sg13g2_decap_8
XFILLER_149_109 VDD VSS sg13g2_decap_4
XFILLER_73_1040 VDD VSS sg13g2_decap_4
XFILLER_38_1160 VDD VSS sg13g2_decap_8
X_13626_ _13734_/D _13626_/A VDD VSS sg13g2_buf_1
X_10838_ _10865_/A _10851_/C _14751_/Q VDD VSS sg13g2_nand2_1
XFILLER_32_479 VDD VSS sg13g2_decap_4
XFILLER_34_1013 VDD VSS sg13g2_decap_8
XFILLER_186_952 VDD VSS sg13g2_decap_8
XFILLER_13_693 VDD VSS sg13g2_decap_8
X_13557_ _15150_/D _15150_/Q _13556_/Y _13590_/B VDD VSS sg13g2_mux2_1
X_10769_ _10769_/X _14950_/Q _10767_/A _10767_/Y VDD VSS sg13g2_a21o_1
X_13711__2491 _13711_/RESET_B VDD VSS sg13g2_tiehi
XFILLER_8_130 VDD VSS sg13g2_decap_8
XFILLER_185_462 VDD VSS sg13g2_decap_8
XFILLER_34_1068 VDD VSS sg13g2_fill_1
XFILLER_121_1027 VDD VSS sg13g2_decap_8
XFILLER_146_827 VDD VSS sg13g2_fill_2
X_12508_ _12508_/X _13958_/Q _13990_/Q _14022_/Q _14054_/Q _12590_/S0 _12590_/S1 VDD
+ VSS sg13g2_mux4_1
X_13488_ _13488_/Y _15174_/D _13487_/Y VDD VSS sg13g2_nor2b_1
XFILLER_9_686 VDD VSS sg13g2_decap_8
XFILLER_172_123 VDD VSS sg13g2_decap_8
XFILLER_51_1382 VDD VSS sg13g2_decap_8
XFILLER_145_348 VDD VSS sg13g2_fill_2
XFILLER_12_1355 VDD VSS sg13g2_decap_8
X_15227_ _15227_/Q clkload56/A _15227_/D _15227_/RESET_B VDD VSS sg13g2_dfrbpq_1
X_12439_ _12439_/X _12432_/X _12436_/X _12431_/X _12435_/X _12650_/S _12649_/S0 VDD
+ VSS sg13g2_mux4_1
XFILLER_86_1412 VDD VSS sg13g2_decap_8
XFILLER_173_679 VDD VSS sg13g2_decap_4
XFILLER_154_871 VDD VSS sg13g2_decap_8
X_14055__2147 _14055_/RESET_B VDD VSS sg13g2_tiehi
XFILLER_99_402 VDD VSS sg13g2_decap_8
X_13890__2312 _13890_/RESET_B VDD VSS sg13g2_tiehi
X_15158_ _15158_/Q _15162_/CLK _15158_/D _15158_/RESET_B VDD VSS sg13g2_dfrbpq_1
XFILLER_82_1309 VDD VSS sg13g2_decap_8
X_14109_ _14109_/Q clkload29/A _14109_/D _14109_/RESET_B VDD VSS sg13g2_dfrbpq_1
X_15089_ _15089_/Q clkload70/A _15089_/D _15089_/RESET_B VDD VSS sg13g2_dfrbpq_1
X_07980_ _07980_/Y _08577_/B _07866_/Y _07979_/Y VDD VSS sg13g2_a21oi_1
XFILLER_87_608 VDD VSS sg13g2_decap_4
XFILLER_99_479 VDD VSS sg13g2_decap_8
XFILLER_101_429 VDD VSS sg13g2_fill_1
XFILLER_84_1191 VDD VSS sg13g2_decap_8
XFILLER_171_1161 VDD VSS sg13g2_decap_8
XFILLER_80_1044 VDD VSS sg13g2_decap_8
XFILLER_79_170 VDD VSS sg13g2_decap_8
XFILLER_45_1186 VDD VSS sg13g2_decap_8
XFILLER_110_952 VDD VSS sg13g2_decap_8
X_09650_ _14243_/D _09749_/A1 _14243_/Q _09663_/S VDD VSS sg13g2_mux2_1
XFILLER_68_866 VDD VSS sg13g2_decap_8
XFILLER_132_1145 VDD VSS sg13g2_decap_8
XFILLER_41_1039 VDD VSS sg13g2_decap_8
XFILLER_132_1178 VDD VSS sg13g2_fill_1
XFILLER_23_1451 VDD VSS sg13g2_decap_8
X_08601_ _08605_/A _08617_/A _08458_/X _08600_/Y VDD VSS sg13g2_o21ai_1
XFILLER_82_302 VDD VSS sg13g2_decap_8
XFILLER_27_207 VDD VSS sg13g2_decap_8
XFILLER_110_996 VDD VSS sg13g2_decap_8
X_09581_ _14178_/D _14178_/Q _09614_/A0 _09599_/S VDD VSS sg13g2_mux2_1
XFILLER_110_1443 VDD VSS sg13g2_decap_4
XFILLER_82_346 VDD VSS sg13g2_decap_8
XFILLER_110_1454 VDD VSS sg13g2_fill_1
X_08532_ _08532_/Y _08612_/S _08529_/Y _08531_/Y VDD VSS sg13g2_a21oi_1
XFILLER_24_903 VDD VSS sg13g2_fill_1
XFILLER_93_1405 VDD VSS sg13g2_decap_8
X_08463_ _08463_/Y _08668_/A _08463_/B VDD VSS sg13g2_nor2_1
XFILLER_23_457 VDD VSS sg13g2_decap_8
XFILLER_168_429 VDD VSS sg13g2_decap_8
X_08394_ _08395_/B _08414_/C _08394_/B _08394_/C VDD VSS sg13g2_nor3_1
XFILLER_50_265 VDD VSS sg13g2_decap_8
XFILLER_143_1241 VDD VSS sg13g2_fill_2
XFILLER_149_643 VDD VSS sg13g2_decap_4
XFILLER_148_120 VDD VSS sg13g2_decap_4
XFILLER_17_1266 VDD VSS sg13g2_decap_8
X_14265__1937 _14265_/RESET_B VDD VSS sg13g2_tiehi
XFILLER_12_14 VDD VSS sg13g2_decap_8
XFILLER_143_1285 VDD VSS sg13g2_decap_8
XFILLER_177_996 VDD VSS sg13g2_decap_4
XFILLER_137_838 VDD VSS sg13g2_decap_8
Xclkbuf_5_27__f_clk_i clkbuf_leaf_64_clk_i/A clkbuf_4_13_0_clk_i/X VDD VSS sg13g2_buf_16
XFILLER_52_1179 VDD VSS sg13g2_decap_8
XFILLER_163_112 VDD VSS sg13g2_decap_8
XFILLER_30_1433 VDD VSS sg13g2_decap_8
XFILLER_136_348 VDD VSS sg13g2_decap_8
X_09015_ _09016_/B _15030_/Q _15227_/Q _09027_/S VDD VSS sg13g2_mux2_1
XFILLER_152_808 VDD VSS sg13g2_decap_4
XFILLER_178_1348 VDD VSS sg13g2_decap_8
XFILLER_136_359 VDD VSS sg13g2_fill_1
XFILLER_105_702 VDD VSS sg13g2_fill_1
XFILLER_163_167 VDD VSS sg13g2_fill_1
XFILLER_117_573 VDD VSS sg13g2_decap_8
XFILLER_132_510 VDD VSS sg13g2_decap_4
X_14480__1722 _14480_/RESET_B VDD VSS sg13g2_tiehi
XFILLER_144_392 VDD VSS sg13g2_decap_4
XFILLER_104_234 VDD VSS sg13g2_decap_8
XFILLER_137_1034 VDD VSS sg13g2_decap_8
XFILLER_104_245 VDD VSS sg13g2_fill_1
XFILLER_160_874 VDD VSS sg13g2_decap_8
Xfanout610 _09069_/A _09137_/A VDD VSS sg13g2_buf_1
XFILLER_160_885 VDD VSS sg13g2_fill_1
Xfanout621 _08954_/S fanout622/X VDD VSS sg13g2_buf_1
Xfanout632 _08904_/S _08900_/A2 VDD VSS sg13g2_buf_1
X_09917_ _14502_/D _14502_/Q _09917_/A1 _09921_/S VDD VSS sg13g2_mux2_1
XFILLER_99_991 VDD VSS sg13g2_decap_8
XFILLER_120_749 VDD VSS sg13g2_decap_8
Xfanout643 _13490_/B _13440_/A VDD VSS sg13g2_buf_1
XFILLER_63_1253 VDD VSS sg13g2_decap_8
Xfanout654 _08541_/A _08692_/A VDD VSS sg13g2_buf_1
Xfanout665 _13282_/A1 _07737_/Y VDD VSS sg13g2_buf_1
XFILLER_115_1354 VDD VSS sg13g2_decap_8
Xfanout676 _13138_/B1 _13082_/B VDD VSS sg13g2_buf_1
XFILLER_8_1467 VDD VSS sg13g2_decap_8
XFILLER_4_1309 VDD VSS sg13g2_decap_8
X_14100__2102 _14100_/RESET_B VDD VSS sg13g2_tiehi
Xfanout687 _07753_/B _07702_/X VDD VSS sg13g2_buf_1
X_09848_ _14435_/D _14435_/Q _10113_/A0 _09858_/S VDD VSS sg13g2_mux2_1
XFILLER_74_803 VDD VSS sg13g2_decap_8
XFILLER_111_1207 VDD VSS sg13g2_decap_8
Xfanout698 _13340_/S _10195_/S VDD VSS sg13g2_buf_1
X_13753__2449 _13753_/RESET_B VDD VSS sg13g2_tiehi
XFILLER_98_1349 VDD VSS sg13g2_decap_4
XFILLER_73_324 VDD VSS sg13g2_decap_8
XFILLER_6_1180 VDD VSS sg13g2_decap_8
X_09779_ _14368_/D _09911_/A1 _14368_/Q _09795_/S VDD VSS sg13g2_mux2_1
XFILLER_2_1022 VDD VSS sg13g2_decap_8
XFILLER_170_4 VDD VSS sg13g2_decap_8
XFILLER_74_869 VDD VSS sg13g2_decap_8
XFILLER_160_67 VDD VSS sg13g2_decap_8
X_11810_ _11810_/Y _11814_/S0 _14604_/Q _11805_/C VDD VSS sg13g2_a21oi_1
X_12790_ _12790_/X _12789_/X _12788_/X _12790_/S VDD VSS sg13g2_mux2_1
XFILLER_27_774 VDD VSS sg13g2_decap_4
XFILLER_96_1062 VDD VSS sg13g2_decap_8
XFILLER_109_1103 VDD VSS sg13g2_decap_4
X_11741_ _11742_/B _11741_/A _14666_/Q VDD VSS sg13g2_nand2_1
XFILLER_57_1035 VDD VSS sg13g2_fill_1
XFILLER_2_1099 VDD VSS sg13g2_decap_8
XFILLER_57_1046 VDD VSS sg13g2_fill_2
XFILLER_53_21 VDD VSS sg13g2_fill_2
XFILLER_18_1008 VDD VSS sg13g2_decap_4
XFILLER_42_755 VDD VSS sg13g2_decap_8
XFILLER_109_1136 VDD VSS sg13g2_decap_8
XFILLER_169_21 VDD VSS sg13g2_decap_8
X_14133__2069 _14133_/RESET_B VDD VSS sg13g2_tiehi
X_14460_ _14460_/Q clkload76/A _14460_/D _14460_/RESET_B VDD VSS sg13g2_dfrbpq_1
X_11672_ _11672_/Y _11669_/Y _11671_/X _11901_/B1 VDD VSS sg13g2_o21ai_1
XFILLER_144_1049 VDD VSS sg13g2_decap_8
X_13411_ _13490_/C _13459_/B _13421_/B VDD VSS sg13g2_nand2b_1
X_10623_ _14882_/D _10623_/A _10623_/B _10632_/D VDD VSS sg13g2_nor3_1
XFILLER_70_1224 VDD VSS sg13g2_decap_8
XFILLER_161_1352 VDD VSS sg13g2_decap_8
XFILLER_186_259 VDD VSS sg13g2_decap_8
X_14391_ _14391_/Q clkload43/A _14391_/D _14391_/RESET_B VDD VSS sg13g2_dfrbpq_1
XFILLER_35_1366 VDD VSS sg13g2_decap_8
XFILLER_10_630 VDD VSS sg13g2_decap_8
XFILLER_128_816 VDD VSS sg13g2_decap_4
XFILLER_169_98 VDD VSS sg13g2_decap_8
XFILLER_22_490 VDD VSS sg13g2_fill_1
X_13342_ _15068_/D _11288_/A _13648_/S _13341_/Y VDD VSS sg13g2_a21o_1
XFILLER_122_1347 VDD VSS sg13g2_decap_8
XFILLER_167_484 VDD VSS sg13g2_decap_4
XFILLER_183_933 VDD VSS sg13g2_fill_2
X_10554_ _14866_/D _10554_/A _10555_/B _10557_/C VDD VSS sg13g2_and3_1
XFILLER_6_634 VDD VSS sg13g2_decap_8
XFILLER_185_42 VDD VSS sg13g2_decap_8
X_13273_ _13273_/Y _13273_/A _13273_/B VDD VSS sg13g2_nand2_1
XFILLER_155_679 VDD VSS sg13g2_decap_8
XFILLER_170_605 VDD VSS sg13g2_fill_1
X_10485_ _10508_/C _14849_/Q _13084_/A _14847_/Q _14846_/Q VDD VSS sg13g2_and4_1
XFILLER_5_133 VDD VSS sg13g2_decap_8
XFILLER_136_860 VDD VSS sg13g2_decap_8
XFILLER_154_167 VDD VSS sg13g2_decap_8
XFILLER_170_616 VDD VSS sg13g2_decap_8
XFILLER_182_476 VDD VSS sg13g2_decap_8
X_15012_ _15012_/Q clkload38/A _15012_/D _15012_/RESET_B VDD VSS sg13g2_dfrbpq_1
X_12224_ _12224_/Y _13245_/A _12294_/A2 _12294_/B1 VDD VSS sg13g2_a21oi_1
XFILLER_68_1153 VDD VSS sg13g2_decap_8
XFILLER_155_1112 VDD VSS sg13g2_decap_8
X_12155_ _12156_/C _12155_/A _12155_/B _12198_/D VDD VSS sg13g2_nand3_1
XFILLER_2_840 VDD VSS sg13g2_decap_8
XFILLER_111_705 VDD VSS sg13g2_fill_1
XFILLER_150_362 VDD VSS sg13g2_decap_8
XFILLER_123_587 VDD VSS sg13g2_decap_8
XFILLER_1_350 VDD VSS sg13g2_decap_8
X_11106_ _11106_/Y _11093_/Y _11105_/Y _11151_/A VDD VSS sg13g2_a21oi_1
XFILLER_81_1342 VDD VSS sg13g2_decap_8
X_12086_ _12086_/X _12197_/B _12086_/B VDD VSS sg13g2_xor2_1
X_11037_ _11037_/Y _11036_/Y _11064_/C _11043_/A VDD VSS sg13g2_a21oi_1
XFILLER_77_652 VDD VSS sg13g2_decap_8
XFILLER_65_803 VDD VSS sg13g2_decap_8
XFILLER_42_1359 VDD VSS sg13g2_decap_8
X_14343__1859 _14343_/RESET_B VDD VSS sg13g2_tiehi
X_13729__2473 _13729_/RESET_B VDD VSS sg13g2_tiehi
XFILLER_40_1050 VDD VSS sg13g2_decap_8
XFILLER_40_1061 VDD VSS sg13g2_decap_8
XFILLER_64_357 VDD VSS sg13g2_decap_8
XFILLER_79_1260 VDD VSS sg13g2_decap_8
XFILLER_52_508 VDD VSS sg13g2_decap_8
XFILLER_80_828 VDD VSS sg13g2_fill_2
X_12988_ _12989_/C _12988_/A _12988_/B _12988_/C _12988_/D VDD VSS sg13g2_nor4_1
XFILLER_166_1241 VDD VSS sg13g2_decap_8
XFILLER_18_796 VDD VSS sg13g2_decap_8
XFILLER_45_582 VDD VSS sg13g2_fill_1
XFILLER_127_1203 VDD VSS sg13g2_decap_4
X_14727_ _14727_/Q _14727_/CLK _14727_/D _14727_/RESET_B VDD VSS sg13g2_dfrbpq_1
XFILLER_45_593 VDD VSS sg13g2_fill_2
X_11939_ _11939_/Y _12055_/B _11937_/Y _11938_/Y VDD VSS sg13g2_o21ai_1
XFILLER_75_1146 VDD VSS sg13g2_decap_8
XFILLER_33_755 VDD VSS sg13g2_decap_8
XFILLER_178_727 VDD VSS sg13g2_decap_8
XFILLER_33_766 VDD VSS sg13g2_fill_1
XFILLER_33_777 VDD VSS sg13g2_decap_8
XFILLER_177_226 VDD VSS sg13g2_decap_8
X_14658_ _14658_/Q clkload7/A _14658_/D _14658_/RESET_B VDD VSS sg13g2_dfrbpq_1
XFILLER_32_254 VDD VSS sg13g2_fill_1
X_14109__2093 _14109_/RESET_B VDD VSS sg13g2_tiehi
XFILLER_53_1433 VDD VSS sg13g2_decap_8
X_13609_ _13609_/Y _13609_/A _13609_/B VDD VSS sg13g2_nor2_1
X_14589_ _14589_/Q clkload38/A _14589_/D _14589_/RESET_B VDD VSS sg13g2_dfrbpq_1
XFILLER_119_816 VDD VSS sg13g2_fill_2
XFILLER_158_462 VDD VSS sg13g2_decap_4
XFILLER_159_985 VDD VSS sg13g2_decap_8
XFILLER_146_624 VDD VSS sg13g2_decap_4
XFILLER_118_326 VDD VSS sg13g2_decap_8
XFILLER_9_483 VDD VSS sg13g2_decap_8
XFILLER_12_1152 VDD VSS sg13g2_decap_8
XFILLER_174_988 VDD VSS sg13g2_decap_4
XFILLER_133_318 VDD VSS sg13g2_decap_8
XFILLER_126_370 VDD VSS sg13g2_fill_1
XFILLER_99_210 VDD VSS sg13g2_decap_8
XFILLER_142_830 VDD VSS sg13g2_decap_8
XFILLER_86_1253 VDD VSS sg13g2_decap_8
XFILLER_160_137 VDD VSS sg13g2_decap_8
XFILLER_86_1264 VDD VSS sg13g2_fill_1
XFILLER_82_1117 VDD VSS sg13g2_fill_2
XFILLER_102_716 VDD VSS sg13g2_decap_8
XFILLER_88_939 VDD VSS sg13g2_decap_8
XFILLER_173_1267 VDD VSS sg13g2_decap_8
XFILLER_138_1398 VDD VSS sg13g2_decap_8
XFILLER_4_70 VDD VSS sg13g2_decap_8
X_07963_ _07963_/Y _15013_/Q _07861_/B VDD VSS sg13g2_nor2b_1
XFILLER_101_226 VDD VSS sg13g2_decap_8
X_09702_ _14294_/D _10165_/A1 _14294_/Q _09706_/S VDD VSS sg13g2_mux2_1
XFILLER_96_961 VDD VSS sg13g2_decap_4
XFILLER_110_760 VDD VSS sg13g2_decap_8
X_07894_ _07904_/B _07917_/B _08160_/B VDD VSS sg13g2_nor2_1
XFILLER_60_1448 VDD VSS sg13g2_decap_8
XFILLER_68_674 VDD VSS sg13g2_decap_8
XFILLER_110_771 VDD VSS sg13g2_fill_2
XFILLER_95_482 VDD VSS sg13g2_decap_4
XFILLER_55_313 VDD VSS sg13g2_fill_2
X_09633_ _14229_/D _10097_/A0 _14229_/Q _09637_/S VDD VSS sg13g2_mux2_1
XFILLER_55_324 VDD VSS sg13g2_decap_8
XFILLER_3_1320 VDD VSS sg13g2_decap_8
XFILLER_95_493 VDD VSS sg13g2_decap_8
XFILLER_82_121 VDD VSS sg13g2_decap_8
XFILLER_67_195 VDD VSS sg13g2_decap_8
X_14319__1883 _14319_/RESET_B VDD VSS sg13g2_tiehi
X_09564_ _14162_/D _09630_/A0 _14162_/Q _09571_/S VDD VSS sg13g2_mux2_1
XFILLER_110_1262 VDD VSS sg13g2_decap_8
XFILLER_83_688 VDD VSS sg13g2_fill_2
XFILLER_58_1322 VDD VSS sg13g2_decap_8
XFILLER_36_560 VDD VSS sg13g2_decap_8
X_08515_ _08515_/Y _07816_/X _08001_/A _08001_/C VDD VSS sg13g2_o21ai_1
XFILLER_3_1397 VDD VSS sg13g2_decap_8
XFILLER_149_1472 VDD VSS sg13g2_fill_2
XFILLER_184_1352 VDD VSS sg13g2_decap_8
XFILLER_23_210 VDD VSS sg13g2_decap_8
X_09495_ _14095_/D _09860_/A1 _14095_/Q _09505_/S VDD VSS sg13g2_mux2_1
XFILLER_19_1317 VDD VSS sg13g2_decap_8
XFILLER_145_1325 VDD VSS sg13g2_decap_8
XFILLER_93_1268 VDD VSS sg13g2_decap_8
X_08446_ _08447_/B _08421_/Y _08444_/Y _08445_/Y VDD VSS sg13g2_o21ai_1
XFILLER_169_749 VDD VSS sg13g2_decap_8
X_14498__1704 _14498_/RESET_B VDD VSS sg13g2_tiehi
XFILLER_58_1399 VDD VSS sg13g2_decap_8
XFILLER_180_1238 VDD VSS sg13g2_decap_8
XFILLER_12_939 VDD VSS sg13g2_decap_8
XFILLER_168_248 VDD VSS sg13g2_decap_8
XFILLER_11_438 VDD VSS sg13g2_decap_8
XFILLER_23_46 VDD VSS sg13g2_fill_2
X_08377_ _08377_/Y _08300_/X _08377_/B VDD VSS sg13g2_nand2b_1
XFILLER_183_207 VDD VSS sg13g2_decap_8
XFILLER_20_950 VDD VSS sg13g2_decap_8
XFILLER_137_624 VDD VSS sg13g2_fill_1
XFILLER_137_657 VDD VSS sg13g2_decap_8
XFILLER_30_1230 VDD VSS sg13g2_decap_8
XFILLER_104_1088 VDD VSS sg13g2_fill_1
XFILLER_136_156 VDD VSS sg13g2_decap_8
XFILLER_137_679 VDD VSS sg13g2_fill_2
XFILLER_178_1145 VDD VSS sg13g2_decap_8
XFILLER_87_1039 VDD VSS sg13g2_decap_8
XFILLER_69_1451 VDD VSS sg13g2_decap_8
XFILLER_136_189 VDD VSS sg13g2_decap_8
X_10270_ _10305_/A _14784_/Q _14785_/Q _10278_/C VDD VSS sg13g2_and3_1
X_13807__2395 _13807_/RESET_B VDD VSS sg13g2_tiehi
XFILLER_3_648 VDD VSS sg13g2_decap_8
XFILLER_105_532 VDD VSS sg13g2_decap_8
XFILLER_65_1326 VDD VSS sg13g2_decap_8
XFILLER_2_147 VDD VSS sg13g2_decap_8
XFILLER_155_78 VDD VSS sg13g2_decap_8
XFILLER_155_89 VDD VSS sg13g2_fill_1
Xfanout1405 _13324_/A _13328_/A VDD VSS sg13g2_buf_1
XFILLER_132_384 VDD VSS sg13g2_decap_4
Xfanout1416 _13469_/A _13407_/B VDD VSS sg13g2_buf_1
Xfanout1427 _10557_/C _10499_/C VDD VSS sg13g2_buf_1
XFILLER_48_21 VDD VSS sg13g2_decap_8
Xfanout440 _09832_/S _09822_/S VDD VSS sg13g2_buf_1
X_13986__2216 _13986_/RESET_B VDD VSS sg13g2_tiehi
Xfanout451 _09663_/S _09659_/S VDD VSS sg13g2_buf_1
Xfanout462 _09560_/S _09540_/Y VDD VSS sg13g2_buf_1
XFILLER_8_1264 VDD VSS sg13g2_decap_8
X_13960_ _13960_/Q clkload16/A _13960_/D _13960_/RESET_B VDD VSS sg13g2_dfrbpq_1
Xfanout473 _09473_/S fanout474/X VDD VSS sg13g2_buf_1
XFILLER_4_1106 VDD VSS sg13g2_decap_8
Xfanout484 _09372_/S fanout486/X VDD VSS sg13g2_buf_1
Xfanout495 _10075_/A0 fanout497/X VDD VSS sg13g2_buf_1
XFILLER_47_825 VDD VSS sg13g2_fill_2
XFILLER_86_471 VDD VSS sg13g2_fill_2
XFILLER_171_77 VDD VSS sg13g2_decap_8
X_12911_ _12911_/Y input28/X _12911_/B VDD VSS sg13g2_nand2b_1
XFILLER_86_482 VDD VSS sg13g2_fill_1
XFILLER_58_173 VDD VSS sg13g2_fill_2
XFILLER_98_1135 VDD VSS sg13g2_fill_2
XFILLER_0_28 VDD VSS sg13g2_decap_8
X_13891_ _13891_/Q _14725_/CLK _13891_/D _13891_/RESET_B VDD VSS sg13g2_dfrbpq_1
XFILLER_46_335 VDD VSS sg13g2_decap_4
XFILLER_111_1059 VDD VSS sg13g2_decap_4
XFILLER_34_508 VDD VSS sg13g2_decap_8
X_12842_ _12845_/B _12900_/A _12900_/B _12866_/B input14/X VDD VSS sg13g2_nand4_1
XFILLER_73_154 VDD VSS sg13g2_decap_8
XFILLER_185_1138 VDD VSS sg13g2_decap_8
XFILLER_34_519 VDD VSS sg13g2_fill_1
XFILLER_76_1422 VDD VSS sg13g2_decap_8
XFILLER_62_839 VDD VSS sg13g2_decap_8
XFILLER_161_0 VDD VSS sg13g2_decap_8
X_12773_ _12773_/X _14265_/Q _14297_/Q _14329_/Q _14361_/Q _12773_/S0 _12773_/S1 VDD
+ VSS sg13g2_mux4_1
XFILLER_37_1406 VDD VSS sg13g2_decap_8
X_14951__2665 _14951_/RESET_B VDD VSS sg13g2_tiehi
XFILLER_54_390 VDD VSS sg13g2_decap_8
XFILLER_163_1436 VDD VSS sg13g2_decap_8
X_14512_ _14512_/Q _14637_/CLK _14512_/D _14512_/RESET_B VDD VSS sg13g2_dfrbpq_1
X_11724_ _11724_/Y _11726_/A _11724_/B VDD VSS sg13g2_nor2_1
XFILLER_70_894 VDD VSS sg13g2_fill_2
XFILLER_42_585 VDD VSS sg13g2_fill_2
XFILLER_30_736 VDD VSS sg13g2_decap_4
XFILLER_14_298 VDD VSS sg13g2_decap_8
X_14443_ _14443_/Q clkload13/A _14443_/D _14443_/RESET_B VDD VSS sg13g2_dfrbpq_1
X_11655_ _11655_/Y _14906_/Q _11792_/B VDD VSS sg13g2_nand2_1
XFILLER_122_1100 VDD VSS sg13g2_decap_8
XFILLER_80_63 VDD VSS sg13g2_decap_8
XFILLER_122_1111 VDD VSS sg13g2_fill_1
XFILLER_128_602 VDD VSS sg13g2_decap_8
XFILLER_35_1163 VDD VSS sg13g2_decap_8
XFILLER_156_922 VDD VSS sg13g2_decap_8
XFILLER_7_910 VDD VSS sg13g2_decap_8
X_10606_ _10629_/C _10606_/A _10606_/B _10652_/A VDD VSS sg13g2_nor3_1
X_14374_ _14374_/Q _14655_/CLK _14374_/D _14374_/RESET_B VDD VSS sg13g2_dfrbpq_1
X_11586_ _11586_/Y _12957_/A _11792_/B _11631_/A2 VDD VSS sg13g2_a21oi_1
XFILLER_127_112 VDD VSS sg13g2_fill_2
XFILLER_167_292 VDD VSS sg13g2_decap_8
XFILLER_6_431 VDD VSS sg13g2_decap_8
XFILLER_183_763 VDD VSS sg13g2_decap_8
X_13325_ _13326_/B _15113_/Q _13306_/B _13309_/Y _15066_/Q VDD VSS sg13g2_a22oi_1
X_10537_ _10567_/B _14861_/Q _14860_/Q _14859_/Q _13218_/A VDD VSS sg13g2_nand4_1
XFILLER_109_871 VDD VSS sg13g2_fill_1
XFILLER_7_987 VDD VSS sg13g2_decap_8
XFILLER_157_1218 VDD VSS sg13g2_decap_8
XFILLER_170_413 VDD VSS sg13g2_fill_2
XFILLER_171_947 VDD VSS sg13g2_fill_2
XFILLER_182_284 VDD VSS sg13g2_decap_8
XFILLER_170_435 VDD VSS sg13g2_decap_8
X_13256_ _13259_/A _13243_/Y _13232_/A _13255_/Y VDD VSS sg13g2_o21ai_1
X_10468_ _14844_/D _10487_/A _10468_/B _10468_/C VDD VSS sg13g2_nor3_1
XFILLER_100_1464 VDD VSS sg13g2_decap_8
XFILLER_170_446 VDD VSS sg13g2_fill_1
X_12207_ _12207_/X _13847_/Q _13879_/Q _13911_/Q _13943_/Q _12017_/A _12236_/C VDD
+ VSS sg13g2_mux4_1
X_13187_ _13191_/A _13188_/A _13225_/A _13186_/X VDD VSS sg13g2_a21o_1
X_10399_ _10414_/C _10400_/B _10400_/C _10400_/D VDD VSS sg13g2_nor3_1
XFILLER_111_502 VDD VSS sg13g2_decap_8
XFILLER_124_885 VDD VSS sg13g2_decap_8
XFILLER_83_1459 VDD VSS sg13g2_decap_8
XFILLER_124_896 VDD VSS sg13g2_fill_1
X_12138_ _12138_/X _14389_/Q _14421_/Q _14485_/Q _14517_/Q _12139_/S0 _12139_/S1 VDD
+ VSS sg13g2_mux4_1
XFILLER_97_747 VDD VSS sg13g2_fill_2
XFILLER_111_546 VDD VSS sg13g2_decap_8
XFILLER_85_909 VDD VSS sg13g2_decap_8
XFILLER_46_1281 VDD VSS sg13g2_decap_8
X_14576__1626 _14576_/RESET_B VDD VSS sg13g2_tiehi
X_12069_ _12069_/X _14259_/Q _14291_/Q _14323_/Q _14355_/Q _12135_/S0 _12135_/S1 VDD
+ VSS sg13g2_mux4_1
XFILLER_84_419 VDD VSS sg13g2_fill_1
XFILLER_78_983 VDD VSS sg13g2_decap_8
XFILLER_49_151 VDD VSS sg13g2_fill_1
X_14612__1590 _14612_/RESET_B VDD VSS sg13g2_tiehi
XFILLER_93_920 VDD VSS sg13g2_decap_8
XFILLER_77_471 VDD VSS sg13g2_fill_1
XFILLER_65_611 VDD VSS sg13g2_decap_8
XFILLER_42_1156 VDD VSS sg13g2_decap_8
X_16877_ _16877_/X _16877_/A VDD VSS sg13g2_buf_1
XFILLER_168_1314 VDD VSS sg13g2_decap_8
XFILLER_20_1410 VDD VSS sg13g2_decap_8
XFILLER_92_441 VDD VSS sg13g2_decap_4
XFILLER_77_1208 VDD VSS sg13g2_decap_8
XFILLER_53_817 VDD VSS sg13g2_decap_8
XFILLER_25_508 VDD VSS sg13g2_decap_8
XFILLER_93_997 VDD VSS sg13g2_decap_8
XFILLER_53_828 VDD VSS sg13g2_fill_1
XFILLER_92_485 VDD VSS sg13g2_fill_1
XFILLER_80_625 VDD VSS sg13g2_fill_2
XFILLER_52_327 VDD VSS sg13g2_decap_4
X_08300_ _08300_/X _08306_/C _08276_/A _08258_/C _07768_/A _08337_/S0 _08337_/S1 VDD
+ VSS sg13g2_mux4_1
X_09280_ _13888_/D _13888_/Q _10143_/A1 _09300_/S VDD VSS sg13g2_mux2_1
XFILLER_178_535 VDD VSS sg13g2_fill_1
XFILLER_178_546 VDD VSS sg13g2_decap_8
XFILLER_127_1066 VDD VSS sg13g2_fill_2
X_08231_ _08231_/Y _07924_/C _08230_/Y _08499_/B1 VDD VSS sg13g2_o21ai_1
XFILLER_166_708 VDD VSS sg13g2_decap_8
XFILLER_18_1350 VDD VSS sg13g2_decap_8
XFILLER_53_1230 VDD VSS sg13g2_decap_8
XFILLER_60_393 VDD VSS sg13g2_fill_2
X_08162_ _08162_/Y _08182_/B _08115_/B _08140_/Y VDD VSS sg13g2_o21ai_1
XFILLER_146_421 VDD VSS sg13g2_fill_1
XFILLER_14_1247 VDD VSS sg13g2_decap_8
XFILLER_20_279 VDD VSS sg13g2_decap_8
XFILLER_119_646 VDD VSS sg13g2_decap_8
XFILLER_179_1421 VDD VSS sg13g2_decap_8
XFILLER_174_752 VDD VSS sg13g2_decap_8
XFILLER_9_280 VDD VSS sg13g2_decap_8
XFILLER_88_1326 VDD VSS sg13g2_fill_2
XFILLER_107_819 VDD VSS sg13g2_fill_2
X_08093_ _08093_/Y _07879_/Y _08091_/Y _08092_/Y VDD VSS sg13g2_a21oi_1
XFILLER_134_616 VDD VSS sg13g2_decap_8
XFILLER_147_999 VDD VSS sg13g2_decap_8
XFILLER_146_487 VDD VSS sg13g2_decap_8
XFILLER_175_1307 VDD VSS sg13g2_decap_8
Xclkload50 clkload50/Y clkload50/A VDD VSS sg13g2_inv_1
XFILLER_134_649 VDD VSS sg13g2_decap_8
XFILLER_161_424 VDD VSS sg13g2_decap_8
Xclkload61 clkload61/Y clkload61/A VDD VSS sg13g2_inv_1
Xclkload72 clkload72/Y clkload72/A VDD VSS sg13g2_inv_2
Xclkload83 clkload83/Y clkload83/A VDD VSS sg13g2_inv_1
XFILLER_86_1061 VDD VSS sg13g2_decap_8
XFILLER_114_340 VDD VSS sg13g2_decap_8
XFILLER_86_1072 VDD VSS sg13g2_fill_2
XFILLER_115_885 VDD VSS sg13g2_decap_8
XFILLER_134_1004 VDD VSS sg13g2_decap_8
XFILLER_138_1173 VDD VSS sg13g2_decap_4
XFILLER_87_213 VDD VSS sg13g2_decap_8
XFILLER_88_747 VDD VSS sg13g2_decap_8
XFILLER_130_855 VDD VSS sg13g2_decap_8
X_08995_ _08995_/Y _14899_/Q _08988_/C _09024_/A VDD VSS sg13g2_o21ai_1
XFILLER_151_1340 VDD VSS sg13g2_decap_8
X_07946_ _08435_/A _15005_/Q _07946_/B VDD VSS sg13g2_nand2b_1
XFILLER_69_994 VDD VSS sg13g2_decap_8
XFILLER_60_1245 VDD VSS sg13g2_decap_8
XFILLER_29_825 VDD VSS sg13g2_decap_8
XFILLER_25_1376 VDD VSS sg13g2_decap_8
XFILLER_21_1218 VDD VSS sg13g2_decap_8
X_07877_ _07917_/A _07879_/A _08199_/B VDD VSS sg13g2_nor2_1
XFILLER_99_1444 VDD VSS sg13g2_decap_8
XFILLER_68_493 VDD VSS sg13g2_decap_8
XFILLER_151_1395 VDD VSS sg13g2_fill_2
XFILLER_18_46 VDD VSS sg13g2_decap_8
XFILLER_56_655 VDD VSS sg13g2_fill_2
XFILLER_112_1368 VDD VSS sg13g2_decap_8
XFILLER_141_47 VDD VSS sg13g2_decap_8
X_09616_ _14212_/D _09882_/A0 _14212_/Q _09622_/S VDD VSS sg13g2_mux2_1
XFILLER_55_165 VDD VSS sg13g2_decap_8
XFILLER_43_305 VDD VSS sg13g2_decap_8
XFILLER_186_1469 VDD VSS sg13g2_fill_2
XFILLER_110_1070 VDD VSS sg13g2_fill_1
XFILLER_3_1194 VDD VSS sg13g2_decap_8
XFILLER_110_1081 VDD VSS sg13g2_decap_8
X_09547_ _14145_/D _09714_/A0 _14145_/Q _09562_/S VDD VSS sg13g2_mux2_1
XFILLER_24_530 VDD VSS sg13g2_decap_8
XFILLER_19_1114 VDD VSS sg13g2_decap_8
XFILLER_12_703 VDD VSS sg13g2_decap_8
X_09478_ _14078_/D _09942_/A1 _14078_/Q _09500_/S VDD VSS sg13g2_mux2_1
XFILLER_58_1196 VDD VSS sg13g2_decap_8
XFILLER_169_546 VDD VSS sg13g2_decap_8
XFILLER_169_557 VDD VSS sg13g2_fill_2
X_14050__2152 _14050_/RESET_B VDD VSS sg13g2_tiehi
X_08429_ _08429_/Y _13533_/A _08600_/B _08429_/C VDD VSS sg13g2_nor3_1
XFILLER_11_235 VDD VSS sg13g2_decap_8
XFILLER_71_1341 VDD VSS sg13g2_decap_8
XFILLER_8_718 VDD VSS sg13g2_decap_8
XFILLER_133_4 VDD VSS sg13g2_decap_8
XFILLER_184_538 VDD VSS sg13g2_decap_8
Xclkload0 clkload0/X clkload0/A VDD VSS sg13g2_buf_8
X_11440_ _11440_/X _14560_/Q _14592_/Q _14624_/Q _14656_/Q _12112_/A1 _12103_/B1 VDD
+ VSS sg13g2_mux4_1
XFILLER_7_217 VDD VSS sg13g2_decap_8
XFILLER_50_11 VDD VSS sg13g2_decap_8
XFILLER_123_1453 VDD VSS sg13g2_decap_8
XFILLER_138_944 VDD VSS sg13g2_fill_1
XFILLER_137_432 VDD VSS sg13g2_decap_4
XFILLER_32_1358 VDD VSS sg13g2_decap_8
XFILLER_138_977 VDD VSS sg13g2_decap_8
XFILLER_50_55 VDD VSS sg13g2_fill_2
X_14654__1548 _14654_/RESET_B VDD VSS sg13g2_tiehi
X_11371_ _11371_/Y _11373_/A _14142_/Q _11374_/C VDD VSS sg13g2_a21oi_1
XFILLER_138_999 VDD VSS sg13g2_decap_8
XFILLER_109_178 VDD VSS sg13g2_fill_2
X_13110_ _13111_/B _13154_/A1 _13105_/X _13104_/Y _13134_/C _13109_/Y VDD VSS sg13g2_a221oi_1
X_10322_ _14800_/D _10322_/A _10323_/B _10322_/C VDD VSS sg13g2_and3_1
XFILLER_4_924 VDD VSS sg13g2_decap_8
X_14090_ _14090_/Q clkload25/A _14090_/D _14090_/RESET_B VDD VSS sg13g2_dfrbpq_1
XFILLER_166_77 VDD VSS sg13g2_decap_8
X_13041_ _13041_/Y _13042_/A _13042_/B _13042_/C VDD VSS sg13g2_a21oi_1
XFILLER_3_445 VDD VSS sg13g2_decap_8
X_10253_ _14779_/D _14779_/Q _10258_/D _10252_/Y VDD VSS sg13g2_a21oi_1
XFILLER_133_671 VDD VSS sg13g2_decap_8
XFILLER_78_202 VDD VSS sg13g2_decap_8
XFILLER_182_32 VDD VSS sg13g2_decap_8
XFILLER_133_693 VDD VSS sg13g2_decap_8
Xfanout1202 _13601_/A _14957_/Q VDD VSS sg13g2_buf_1
X_10184_ _10185_/C input36/X input3/X _10184_/C VDD VSS sg13g2_or3_1
XFILLER_117_1246 VDD VSS sg13g2_decap_8
XFILLER_120_321 VDD VSS sg13g2_decap_8
Xfanout1213 _12859_/A _14898_/Q VDD VSS sg13g2_buf_1
XFILLER_59_86 VDD VSS sg13g2_decap_8
Xfanout1224 _13084_/A _14848_/Q VDD VSS sg13g2_buf_1
Xfanout1235 _13613_/C _14748_/Q VDD VSS sg13g2_buf_1
XFILLER_82_1470 VDD VSS sg13g2_decap_4
XFILLER_78_257 VDD VSS sg13g2_fill_2
Xfanout1246 _11446_/A fanout1255/X VDD VSS sg13g2_buf_1
X_15022__2588 _15022_/RESET_B VDD VSS sg13g2_tiehi
X_14992_ _14992_/Q clkload54/A _14992_/D _14992_/RESET_B VDD VSS sg13g2_dfrbpq_1
Xfanout1257 _11717_/A _12336_/A2 VDD VSS sg13g2_buf_1
XFILLER_8_1061 VDD VSS sg13g2_decap_8
XFILLER_120_376 VDD VSS sg13g2_decap_8
Xfanout270 _09903_/S _09892_/S VDD VSS sg13g2_buf_1
Xfanout1268 _11351_/C1 _13659_/Q VDD VSS sg13g2_buf_1
XFILLER_115_70 VDD VSS sg13g2_decap_8
XFILLER_19_313 VDD VSS sg13g2_decap_8
Xfanout281 _09428_/S fanout284/X VDD VSS sg13g2_buf_1
Xfanout1279 _11760_/C fanout1280/X VDD VSS sg13g2_buf_1
Xfanout292 _09882_/A0 _09583_/A1 VDD VSS sg13g2_buf_1
X_13943_ _13943_/Q _14514_/CLK _13943_/D _13943_/RESET_B VDD VSS sg13g2_dfrbpq_1
XFILLER_47_644 VDD VSS sg13g2_fill_2
XFILLER_75_975 VDD VSS sg13g2_fill_2
XFILLER_130_1468 VDD VSS sg13g2_decap_8
XFILLER_46_143 VDD VSS sg13g2_decap_8
XFILLER_35_817 VDD VSS sg13g2_decap_8
XFILLER_75_986 VDD VSS sg13g2_decap_4
XFILLER_75_85 VDD VSS sg13g2_decap_8
X_13874_ _13874_/Q _14743_/CLK _13874_/D _13874_/RESET_B VDD VSS sg13g2_dfrbpq_1
X_14260__1942 _14260_/RESET_B VDD VSS sg13g2_tiehi
XFILLER_74_485 VDD VSS sg13g2_decap_8
XFILLER_47_699 VDD VSS sg13g2_decap_8
X_12825_ _12828_/B _12866_/A _12866_/B _12899_/C input22/X VDD VSS sg13g2_nand4_1
XFILLER_61_124 VDD VSS sg13g2_fill_1
XFILLER_50_809 VDD VSS sg13g2_decap_8
XFILLER_37_1203 VDD VSS sg13g2_decap_8
XFILLER_91_40 VDD VSS sg13g2_fill_1
XFILLER_15_574 VDD VSS sg13g2_decap_4
XFILLER_163_1233 VDD VSS sg13g2_decap_8
X_12756_ _12756_/X _14584_/Q _14616_/Q _14648_/Q _14680_/Q _12756_/S0 _12756_/S1 VDD
+ VSS sg13g2_mux4_1
XFILLER_30_500 VDD VSS sg13g2_decap_8
XFILLER_76_1296 VDD VSS sg13g2_decap_8
X_11707_ _11707_/Y _11707_/A _11773_/C VDD VSS sg13g2_xnor2_1
XFILLER_42_393 VDD VSS sg13g2_decap_8
X_12687_ _12687_/X _14707_/Q _14739_/Q _13779_/Q _13811_/Q _12711_/S0 _12711_/S1 VDD
+ VSS sg13g2_mux4_1
XFILLER_50_1414 VDD VSS sg13g2_decap_8
X_14426_ _14426_/Q clkload79/A _14426_/D _14426_/RESET_B VDD VSS sg13g2_dfrbpq_1
XFILLER_30_577 VDD VSS sg13g2_decap_8
X_11638_ _11638_/X _11638_/A _11638_/B _11638_/C VDD VSS sg13g2_or3_1
XFILLER_156_741 VDD VSS sg13g2_decap_8
XFILLER_128_443 VDD VSS sg13g2_decap_8
XFILLER_129_977 VDD VSS sg13g2_decap_8
XFILLER_116_605 VDD VSS sg13g2_fill_2
XFILLER_129_988 VDD VSS sg13g2_fill_2
X_14357_ _14357_/Q _14677_/CLK _14357_/D _14357_/RESET_B VDD VSS sg13g2_dfrbpq_1
X_11569_ _11572_/A _11638_/A _11571_/C VDD VSS sg13g2_nor2_1
XFILLER_7_784 VDD VSS sg13g2_decap_8
XFILLER_143_424 VDD VSS sg13g2_decap_8
X_13308_ _13308_/Y _13308_/A _13308_/B VDD VSS sg13g2_nor2_1
XFILLER_109_690 VDD VSS sg13g2_decap_4
X_14288_ _14288_/Q clkload8/A _14288_/D _14288_/RESET_B VDD VSS sg13g2_dfrbpq_1
XFILLER_157_1048 VDD VSS sg13g2_fill_1
XFILLER_87_1370 VDD VSS sg13g2_decap_8
XFILLER_48_1321 VDD VSS sg13g2_decap_8
XFILLER_115_159 VDD VSS sg13g2_decap_8
XFILLER_157_1059 VDD VSS sg13g2_decap_8
X_13239_ _15049_/D _13266_/A _13239_/B VDD VSS sg13g2_nor2_1
XFILLER_97_500 VDD VSS sg13g2_decap_4
XFILLER_83_1256 VDD VSS sg13g2_decap_8
XFILLER_44_1207 VDD VSS sg13g2_decap_8
XFILLER_135_1335 VDD VSS sg13g2_fill_2
XFILLER_48_1398 VDD VSS sg13g2_decap_8
X_07800_ _08574_/A _15006_/Q _07945_/B VDD VSS sg13g2_xor2_1
X_08780_ _13678_/D _08728_/Y _08779_/Y _08778_/Y VDD VSS sg13g2_a21oi_1
XFILLER_85_728 VDD VSS sg13g2_decap_8
XFILLER_78_780 VDD VSS sg13g2_decap_8
XFILLER_111_398 VDD VSS sg13g2_decap_8
X_07731_ _07907_/D _15077_/Q _15075_/Q VDD VSS sg13g2_or2_1
X_15073__2880 _15073_/RESET_B VDD VSS sg13g2_tiehi
XFILLER_93_761 VDD VSS sg13g2_decap_4
X_07662_ _07662_/Y _14764_/Q _07766_/B VDD VSS sg13g2_nor2_1
XFILLER_4_1470 VDD VSS sg13g2_decap_8
XFILLER_25_305 VDD VSS sg13g2_decap_8
XFILLER_80_411 VDD VSS sg13g2_fill_1
X_09401_ _14004_/D _10130_/A0 _14004_/Q _09401_/S VDD VSS sg13g2_mux2_1
XFILLER_81_945 VDD VSS sg13g2_decap_4
XFILLER_0_1345 VDD VSS sg13g2_decap_8
XFILLER_92_293 VDD VSS sg13g2_fill_1
XFILLER_59_1450 VDD VSS sg13g2_decap_8
XFILLER_168_1188 VDD VSS sg13g2_decap_8
XFILLER_20_1284 VDD VSS sg13g2_decap_8
XFILLER_94_1341 VDD VSS sg13g2_fill_1
XFILLER_94_1352 VDD VSS sg13g2_fill_2
XFILLER_80_455 VDD VSS sg13g2_decap_8
XFILLER_55_1314 VDD VSS sg13g2_decap_8
XFILLER_52_157 VDD VSS sg13g2_decap_8
XFILLER_146_1431 VDD VSS sg13g2_decap_8
X_09332_ _13939_/D _09963_/A1 _13939_/Q _09337_/S VDD VSS sg13g2_mux2_1
XFILLER_33_360 VDD VSS sg13g2_fill_1
XFILLER_178_332 VDD VSS sg13g2_decap_4
XFILLER_181_1344 VDD VSS sg13g2_decap_8
XFILLER_33_371 VDD VSS sg13g2_decap_4
XFILLER_16_1309 VDD VSS sg13g2_decap_8
XFILLER_139_708 VDD VSS sg13g2_decap_8
X_09263_ _13872_/D _13872_/Q _09463_/A0 _09263_/S VDD VSS sg13g2_mux2_1
XFILLER_107_1459 VDD VSS sg13g2_decap_8
XFILLER_166_527 VDD VSS sg13g2_decap_8
XFILLER_178_387 VDD VSS sg13g2_decap_8
X_08214_ _08214_/X _08374_/B _08544_/C _08212_/X VDD VSS sg13g2_a21o_1
X_09194_ _13810_/D _13810_/Q _10161_/A1 _09200_/S VDD VSS sg13g2_mux2_1
XFILLER_119_421 VDD VSS sg13g2_decap_8
XFILLER_147_730 VDD VSS sg13g2_decap_8
XFILLER_14_1044 VDD VSS sg13g2_decap_8
XFILLER_101_1003 VDD VSS sg13g2_fill_2
X_08145_ _15221_/D _08145_/A _08145_/B _08145_/C VDD VSS sg13g2_nand3_1
XFILLER_181_519 VDD VSS sg13g2_decap_8
XFILLER_146_251 VDD VSS sg13g2_decap_8
XFILLER_119_476 VDD VSS sg13g2_fill_1
XFILLER_88_1134 VDD VSS sg13g2_decap_4
XFILLER_147_796 VDD VSS sg13g2_decap_8
XFILLER_20_14 VDD VSS sg13g2_decap_8
XFILLER_135_947 VDD VSS sg13g2_decap_8
XFILLER_175_1104 VDD VSS sg13g2_decap_8
X_08076_ _08076_/Y _07900_/B _08074_/X _08075_/Y VDD VSS sg13g2_a21oi_1
XFILLER_31_1391 VDD VSS sg13g2_decap_8
XFILLER_179_1295 VDD VSS sg13g2_decap_8
XFILLER_66_1410 VDD VSS sg13g2_decap_8
XFILLER_162_777 VDD VSS sg13g2_decap_8
XFILLER_136_58 VDD VSS sg13g2_decap_8
XFILLER_121_107 VDD VSS sg13g2_decap_8
XFILLER_143_980 VDD VSS sg13g2_fill_1
XFILLER_1_938 VDD VSS sg13g2_decap_8
XFILLER_96_18 VDD VSS sg13g2_decap_4
XFILLER_102_321 VDD VSS sg13g2_fill_1
XFILLER_153_1435 VDD VSS sg13g2_decap_8
XFILLER_0_448 VDD VSS sg13g2_decap_8
XFILLER_76_728 VDD VSS sg13g2_decap_8
XFILLER_75_205 VDD VSS sg13g2_decap_8
X_08978_ _08978_/Y _10674_/A _08972_/S _08977_/Y VDD VSS sg13g2_o21ai_1
XFILLER_60_1020 VDD VSS sg13g2_decap_8
XFILLER_29_600 VDD VSS sg13g2_decap_8
XFILLER_9_1381 VDD VSS sg13g2_decap_8
XFILLER_152_57 VDD VSS sg13g2_decap_8
X_14068__2134 _14068_/RESET_B VDD VSS sg13g2_tiehi
XFILLER_75_238 VDD VSS sg13g2_decap_8
XFILLER_29_633 VDD VSS sg13g2_fill_1
XFILLER_152_68 VDD VSS sg13g2_fill_2
X_07929_ _07930_/A _08263_/B _07929_/B VDD VSS sg13g2_nand2b_1
XFILLER_25_1173 VDD VSS sg13g2_decap_8
XFILLER_60_1064 VDD VSS sg13g2_decap_8
XFILLER_57_953 VDD VSS sg13g2_decap_8
XFILLER_112_1143 VDD VSS sg13g2_decap_8
XFILLER_5_1267 VDD VSS sg13g2_decap_8
XFILLER_29_655 VDD VSS sg13g2_decap_4
XFILLER_17_806 VDD VSS sg13g2_decap_8
XFILLER_72_901 VDD VSS sg13g2_fill_1
XFILLER_28_143 VDD VSS sg13g2_decap_8
X_10940_ _14937_/D _10939_/Y _10938_/Y _10929_/Y VDD VSS sg13g2_o21ai_1
XFILLER_45_11 VDD VSS sg13g2_fill_2
XFILLER_95_1127 VDD VSS sg13g2_decap_8
XFILLER_72_945 VDD VSS sg13g2_decap_8
XFILLER_186_1266 VDD VSS sg13g2_decap_8
XFILLER_43_124 VDD VSS sg13g2_decap_8
X_15007__2603 _15007_/RESET_B VDD VSS sg13g2_tiehi
X_10871_ _10871_/Y _10871_/A _10871_/B VDD VSS sg13g2_xnor2_1
X_14708__1494 _14708_/RESET_B VDD VSS sg13g2_tiehi
X_12610_ _12611_/B _13675_/Q _12777_/A2 _12609_/X _12624_/B2 _12624_/C1 VDD VSS sg13g2_a221oi_1
XFILLER_43_168 VDD VSS sg13g2_fill_1
XFILLER_12_500 VDD VSS sg13g2_decap_8
X_13590_ _13590_/Y _15162_/Q _13590_/B VDD VSS sg13g2_nor2_1
XFILLER_73_1458 VDD VSS sg13g2_decap_8
X_12541_ _15002_/D _12541_/A _12541_/B VDD VSS sg13g2_nor2_1
XFILLER_61_21 VDD VSS sg13g2_decap_8
XFILLER_157_527 VDD VSS sg13g2_decap_8
XFILLER_185_836 VDD VSS sg13g2_decap_8
XFILLER_129_229 VDD VSS sg13g2_decap_8
XFILLER_8_515 VDD VSS sg13g2_decap_8
XFILLER_12_577 VDD VSS sg13g2_decap_8
XFILLER_177_32 VDD VSS sg13g2_decap_8
XFILLER_184_324 VDD VSS sg13g2_decap_8
X_12472_ _12485_/A _12570_/A1 _12570_/A2 _14998_/Q VDD VSS sg13g2_a21oi_1
XFILLER_61_87 VDD VSS sg13g2_decap_8
XFILLER_124_0 VDD VSS sg13g2_decap_8
XFILLER_172_508 VDD VSS sg13g2_decap_8
X_14211_ _14211_/Q clkload18/A _14211_/D _14211_/RESET_B VDD VSS sg13g2_dfrbpq_1
X_11423_ _11423_/Y _11420_/Y _11422_/Y _11830_/B1 VDD VSS sg13g2_a21oi_1
XFILLER_32_1155 VDD VSS sg13g2_decap_8
X_15191_ _15191_/Q _15212_/CLK _15191_/D _15191_/RESET_B VDD VSS sg13g2_dfrbpq_1
XFILLER_123_1294 VDD VSS sg13g2_decap_8
XFILLER_125_402 VDD VSS sg13g2_decap_8
XFILLER_138_785 VDD VSS sg13g2_fill_2
XFILLER_165_571 VDD VSS sg13g2_decap_8
XANTENNA_9 _16867_/A VDD VSS sg13g2_antennanp
X_14142_ _14142_/Q clkload53/A _14142_/D _14142_/RESET_B VDD VSS sg13g2_dfrbpq_1
X_11354_ _11354_/Y _11365_/A _14622_/Q VDD VSS sg13g2_nand2b_1
XFILLER_4_721 VDD VSS sg13g2_decap_8
XFILLER_10_1442 VDD VSS sg13g2_decap_8
XFILLER_141_906 VDD VSS sg13g2_decap_8
XFILLER_152_243 VDD VSS sg13g2_decap_8
X_10305_ _10327_/B _10305_/A _10305_/B _10311_/B _10311_/C VDD VSS sg13g2_and4_1
XFILLER_119_1319 VDD VSS sg13g2_fill_1
XFILLER_153_777 VDD VSS sg13g2_decap_8
XFILLER_158_1368 VDD VSS sg13g2_decap_8
XFILLER_3_242 VDD VSS sg13g2_decap_8
XFILLER_153_788 VDD VSS sg13g2_fill_2
X_14073_ _14073_/Q clkload45/A _14073_/D _14073_/RESET_B VDD VSS sg13g2_dfrbpq_1
X_14278__1924 _14278_/RESET_B VDD VSS sg13g2_tiehi
X_11285_ _11285_/Y _11285_/A _12334_/C VDD VSS sg13g2_nor2b_1
XFILLER_106_671 VDD VSS sg13g2_decap_8
XFILLER_4_798 VDD VSS sg13g2_decap_8
XFILLER_106_693 VDD VSS sg13g2_fill_2
X_13024_ _13026_/A _13009_/A _13010_/B _13058_/C VDD VSS sg13g2_o21ai_1
X_10236_ _14773_/D _07638_/Y _10232_/B _10235_/Y VDD VSS sg13g2_a21oi_1
XFILLER_10_91 VDD VSS sg13g2_decap_8
XFILLER_156_1092 VDD VSS sg13g2_decap_8
Xfanout1010 _10070_/A _09938_/C VDD VSS sg13g2_buf_1
XFILLER_121_652 VDD VSS sg13g2_decap_8
Xfanout1021 _08991_/S fanout1026/X VDD VSS sg13g2_buf_1
XFILLER_0_960 VDD VSS sg13g2_decap_8
Xfanout1032 _08723_/A _13446_/A1 VDD VSS sg13g2_buf_1
X_10167_ _14744_/D _14744_/Q _10167_/A1 _10167_/S VDD VSS sg13g2_mux2_1
XFILLER_117_1076 VDD VSS sg13g2_decap_8
Xfanout1043 _13555_/A _08456_/C VDD VSS sg13g2_buf_1
Xfanout1054 _08668_/A _08483_/A1 VDD VSS sg13g2_buf_1
XFILLER_120_173 VDD VSS sg13g2_fill_2
Xfanout1065 _08212_/A _08356_/A1 VDD VSS sg13g2_buf_1
XFILLER_48_931 VDD VSS sg13g2_decap_4
XFILLER_130_1210 VDD VSS sg13g2_decap_8
Xfanout1076 _08599_/B _08196_/A1 VDD VSS sg13g2_buf_1
XFILLER_86_95 VDD VSS sg13g2_decap_4
XFILLER_43_1273 VDD VSS sg13g2_decap_8
X_14975_ _14975_/Q clkload25/A _14975_/D _14975_/RESET_B VDD VSS sg13g2_dfrbpq_1
Xfanout1087 _08102_/S0 _08084_/S1 VDD VSS sg13g2_buf_1
X_10098_ _14678_/D _10098_/A0 _14678_/Q _10102_/S VDD VSS sg13g2_mux2_1
XFILLER_94_558 VDD VSS sg13g2_decap_8
Xfanout1098 _08083_/S0 fanout1103/X VDD VSS sg13g2_buf_1
XFILLER_169_1420 VDD VSS sg13g2_decap_8
XFILLER_78_1303 VDD VSS sg13g2_decap_8
X_13926_ _13926_/Q clkload51/A _13926_/D _13926_/RESET_B VDD VSS sg13g2_dfrbpq_1
XFILLER_47_463 VDD VSS sg13g2_decap_8
XFILLER_75_794 VDD VSS sg13g2_decap_4
XFILLER_19_198 VDD VSS sg13g2_fill_2
XFILLER_63_956 VDD VSS sg13g2_fill_1
X_13857_ _13857_/Q clkload10/A _13857_/D _13857_/RESET_B VDD VSS sg13g2_dfrbpq_1
XFILLER_63_978 VDD VSS sg13g2_decap_4
XFILLER_35_669 VDD VSS sg13g2_decap_8
X_12808_ _12808_/Y _13303_/A _13312_/A VDD VSS sg13g2_nor2_1
XFILLER_16_883 VDD VSS sg13g2_decap_8
X_13788_ _13788_/Q _15052_/CLK _13788_/D _13788_/RESET_B VDD VSS sg13g2_dfrbpq_1
XFILLER_76_1082 VDD VSS sg13g2_fill_1
X_13766__2436 _13766_/RESET_B VDD VSS sg13g2_tiehi
XFILLER_96_4 VDD VSS sg13g2_decap_8
XFILLER_43_691 VDD VSS sg13g2_fill_1
XFILLER_37_1055 VDD VSS sg13g2_fill_1
X_12739_ _12739_/X _13751_/Q _14103_/Q _14455_/Q _14551_/Q _12756_/S0 _12756_/S1 VDD
+ VSS sg13g2_mux4_1
XFILLER_30_352 VDD VSS sg13g2_decap_8
XFILLER_148_538 VDD VSS sg13g2_fill_1
XFILLER_15_1320 VDD VSS sg13g2_decap_8
XFILLER_50_1211 VDD VSS sg13g2_decap_8
XFILLER_31_897 VDD VSS sg13g2_fill_1
X_14409_ _14409_/Q clkload30/A _14409_/D _14409_/RESET_B VDD VSS sg13g2_dfrbpq_1
XFILLER_15_1397 VDD VSS sg13g2_decap_8
XFILLER_116_413 VDD VSS sg13g2_decap_8
XFILLER_50_1288 VDD VSS sg13g2_decap_8
XFILLER_117_947 VDD VSS sg13g2_decap_8
XFILLER_156_593 VDD VSS sg13g2_decap_4
X_14146__2056 _14146_/RESET_B VDD VSS sg13g2_tiehi
XFILLER_102_1367 VDD VSS sg13g2_fill_2
XFILLER_117_958 VDD VSS sg13g2_fill_2
XFILLER_143_210 VDD VSS sg13g2_decap_8
X_13981__2221 _13981_/RESET_B VDD VSS sg13g2_tiehi
XFILLER_7_581 VDD VSS sg13g2_decap_8
XFILLER_102_1389 VDD VSS sg13g2_decap_8
XFILLER_104_608 VDD VSS sg13g2_decap_4
XFILLER_144_777 VDD VSS sg13g2_decap_8
XFILLER_176_1457 VDD VSS sg13g2_decap_8
XFILLER_131_405 VDD VSS sg13g2_fill_2
X_09950_ _14534_/D _14534_/Q _10082_/A0 _09964_/S VDD VSS sg13g2_mux2_1
XFILLER_143_265 VDD VSS sg13g2_decap_8
XFILLER_171_574 VDD VSS sg13g2_decap_8
XFILLER_125_991 VDD VSS sg13g2_decap_8
X_08901_ _08901_/Y _08835_/A _08835_/B _16870_/A VDD VSS sg13g2_a21oi_1
XFILLER_124_490 VDD VSS sg13g2_decap_4
X_09881_ _14467_/D _09914_/A1 _14467_/Q _09894_/S VDD VSS sg13g2_mux2_1
XFILLER_83_1064 VDD VSS sg13g2_decap_8
XFILLER_48_1195 VDD VSS sg13g2_decap_8
X_08832_ _08833_/C _13293_/A _15055_/Q _10174_/B _08832_/D VDD VSS sg13g2_nor4_1
XFILLER_140_983 VDD VSS sg13g2_decap_8
XFILLER_135_1187 VDD VSS sg13g2_decap_8
XFILLER_97_385 VDD VSS sg13g2_decap_8
XFILLER_100_847 VDD VSS sg13g2_fill_2
XFILLER_97_396 VDD VSS sg13g2_fill_2
XFILLER_61_1351 VDD VSS sg13g2_decap_8
XFILLER_57_238 VDD VSS sg13g2_decap_8
XFILLER_39_942 VDD VSS sg13g2_fill_2
X_08763_ _08763_/Y _13343_/B _11288_/A _15189_/Q VDD VSS sg13g2_o21ai_1
XFILLER_22_1335 VDD VSS sg13g2_decap_8
XFILLER_2_1407 VDD VSS sg13g2_decap_8
X_07714_ _07714_/Y _07740_/A _11243_/B VDD VSS sg13g2_nand2_1
XFILLER_72_208 VDD VSS sg13g2_decap_8
XFILLER_66_772 VDD VSS sg13g2_fill_2
XFILLER_66_783 VDD VSS sg13g2_fill_1
XFILLER_54_923 VDD VSS sg13g2_decap_8
XFILLER_39_997 VDD VSS sg13g2_decap_8
XFILLER_122_49 VDD VSS sg13g2_decap_8
X_08694_ _08694_/Y _08380_/Y _08400_/Y _08687_/X _08637_/B _08693_/Y VDD VSS sg13g2_a221oi_1
XFILLER_81_720 VDD VSS sg13g2_decap_8
XFILLER_65_282 VDD VSS sg13g2_fill_1
XFILLER_53_422 VDD VSS sg13g2_decap_8
XFILLER_25_113 VDD VSS sg13g2_decap_8
XFILLER_54_956 VDD VSS sg13g2_decap_8
X_07645_ _10297_/B _14793_/Q VDD VSS sg13g2_inv_1
XFILLER_96_1469 VDD VSS sg13g2_decap_4
XFILLER_0_1142 VDD VSS sg13g2_decap_8
XFILLER_183_1428 VDD VSS sg13g2_decap_8
XFILLER_15_14 VDD VSS sg13g2_decap_8
XFILLER_41_606 VDD VSS sg13g2_decap_8
XFILLER_25_168 VDD VSS sg13g2_decap_8
XFILLER_13_319 VDD VSS sg13g2_decap_8
XFILLER_53_499 VDD VSS sg13g2_decap_8
XFILLER_179_652 VDD VSS sg13g2_fill_1
XFILLER_80_296 VDD VSS sg13g2_decap_8
XFILLER_181_1141 VDD VSS sg13g2_decap_8
XFILLER_22_842 VDD VSS sg13g2_decap_4
X_09315_ _13922_/D _09814_/A0 _13922_/Q _09329_/S VDD VSS sg13g2_mux2_1
XFILLER_16_1106 VDD VSS sg13g2_decap_8
XFILLER_178_140 VDD VSS sg13g2_decap_8
XFILLER_179_674 VDD VSS sg13g2_decap_8
X_14356__1846 _14356_/RESET_B VDD VSS sg13g2_tiehi
XFILLER_139_516 VDD VSS sg13g2_decap_8
XFILLER_33_190 VDD VSS sg13g2_decap_8
XFILLER_90_1057 VDD VSS sg13g2_fill_1
XFILLER_167_836 VDD VSS sg13g2_decap_8
XFILLER_55_1188 VDD VSS sg13g2_decap_8
XFILLER_51_1019 VDD VSS sg13g2_decap_8
XFILLER_178_184 VDD VSS sg13g2_decap_8
X_09246_ _13855_/D _13855_/Q _09745_/A1 _09259_/S VDD VSS sg13g2_mux2_1
XFILLER_166_357 VDD VSS sg13g2_decap_8
XFILLER_182_806 VDD VSS sg13g2_decap_8
XFILLER_21_396 VDD VSS sg13g2_fill_1
XFILLER_120_1412 VDD VSS sg13g2_fill_1
XFILLER_182_817 VDD VSS sg13g2_decap_4
XFILLER_33_1464 VDD VSS sg13g2_decap_8
XFILLER_31_35 VDD VSS sg13g2_decap_8
XFILLER_119_240 VDD VSS sg13g2_decap_8
X_09177_ _13793_/D _13793_/Q _09978_/A0 _09189_/S VDD VSS sg13g2_mux2_1
XFILLER_119_251 VDD VSS sg13g2_fill_2
XFILLER_120_1423 VDD VSS sg13g2_decap_8
XFILLER_147_571 VDD VSS sg13g2_fill_1
XFILLER_5_518 VDD VSS sg13g2_decap_8
XFILLER_107_413 VDD VSS sg13g2_fill_2
XFILLER_107_424 VDD VSS sg13g2_fill_2
X_08128_ _08128_/X _08383_/A _07945_/B _07946_/B _08493_/B2 _08337_/S1 _08337_/S0
+ VDD VSS sg13g2_mux4_1
X_14571__1631 _14571_/RESET_B VDD VSS sg13g2_tiehi
XFILLER_179_1092 VDD VSS sg13g2_decap_8
X_08059_ _08059_/X _11705_/A _08465_/A3 _11659_/A _11726_/A _08402_/A _08063_/A VDD
+ VSS sg13g2_mux4_1
Xoutput46 mem_axi_araddr[17] _16870_/A VDD VSS sg13g2_buf_1
XFILLER_150_747 VDD VSS sg13g2_fill_2
XFILLER_153_1210 VDD VSS sg13g2_decap_8
XFILLER_1_735 VDD VSS sg13g2_decap_8
Xoutput57 mem_axi_araddr[28] _16881_/A VDD VSS sg13g2_buf_1
X_11070_ _11070_/Y _11151_/A _11069_/Y _11067_/Y VDD VSS sg13g2_a21oi_1
XFILLER_115_490 VDD VSS sg13g2_decap_8
Xoutput68 mem_axi_araddr[9] _16862_/A VDD VSS sg13g2_buf_1
XFILLER_62_1104 VDD VSS sg13g2_decap_8
XFILLER_131_950 VDD VSS sg13g2_decap_8
Xoutput79 mem_axi_awaddr[18] _16871_/X VDD VSS sg13g2_buf_1
Xhold3140 _13627_/A _13735_/Q VDD VSS sg13g2_dlygate4sd3_1
XFILLER_66_1284 VDD VSS sg13g2_decap_8
XFILLER_0_245 VDD VSS sg13g2_decap_8
XFILLER_163_56 VDD VSS sg13g2_decap_8
Xhold3151 _11196_/A _14956_/Q VDD VSS sg13g2_dlygate4sd3_1
X_10021_ _14603_/D _10087_/A0 _14603_/Q _10030_/S VDD VSS sg13g2_mux2_1
XFILLER_153_1254 VDD VSS sg13g2_fill_2
Xhold3162 _13523_/A _15141_/Q VDD VSS sg13g2_dlygate4sd3_1
XFILLER_27_1257 VDD VSS sg13g2_decap_8
XFILLER_114_1216 VDD VSS sg13g2_decap_8
XFILLER_89_897 VDD VSS sg13g2_decap_8
Xhold3173 _13437_/C _15101_/Q VDD VSS sg13g2_dlygate4sd3_1
XFILLER_62_1159 VDD VSS sg13g2_decap_8
XFILLER_88_385 VDD VSS sg13g2_fill_1
XFILLER_102_173 VDD VSS sg13g2_decap_8
XFILLER_130_482 VDD VSS sg13g2_decap_8
X_13844__2358 _13844_/RESET_B VDD VSS sg13g2_tiehi
XFILLER_153_1298 VDD VSS sg13g2_decap_8
XFILLER_48_238 VDD VSS sg13g2_fill_1
XFILLER_76_558 VDD VSS sg13g2_decap_8
XFILLER_56_21 VDD VSS sg13g2_decap_8
XFILLER_40_1424 VDD VSS sg13g2_decap_8
XFILLER_5_1064 VDD VSS sg13g2_decap_8
X_14760_ _14760_/Q _15188_/CLK _14760_/D _14760_/RESET_B VDD VSS sg13g2_dfrbpq_1
X_11972_ _11973_/A _14704_/Q _14736_/Q _13776_/Q _13808_/Q _11972_/S0 _11970_/C VDD
+ VSS sg13g2_mux4_1
XFILLER_16_102 VDD VSS sg13g2_decap_8
XFILLER_56_271 VDD VSS sg13g2_decap_8
XFILLER_99_1082 VDD VSS sg13g2_decap_8
XFILLER_45_945 VDD VSS sg13g2_fill_2
XFILLER_44_422 VDD VSS sg13g2_fill_1
XFILLER_29_496 VDD VSS sg13g2_decap_8
X_13711_ _16873_/A _14602_/CLK _13711_/D _13711_/RESET_B VDD VSS sg13g2_dfrbpq_1
X_10923_ _10937_/B _10923_/A _10923_/B _10954_/A _10923_/D VDD VSS sg13g2_nor4_1
X_14691_ _14691_/Q _14723_/CLK _14691_/D _14691_/RESET_B VDD VSS sg13g2_dfrbpq_1
XFILLER_186_1085 VDD VSS sg13g2_decap_8
XFILLER_72_786 VDD VSS sg13g2_decap_8
X_13642_ _13750_/D _13642_/A VDD VSS sg13g2_buf_1
XFILLER_60_937 VDD VSS sg13g2_decap_8
X_10854_ _10865_/B _10870_/A _14752_/Q VDD VSS sg13g2_nand2_1
XFILLER_72_42 VDD VSS sg13g2_decap_8
XFILLER_44_488 VDD VSS sg13g2_fill_2
XFILLER_31_105 VDD VSS sg13g2_decap_8
XFILLER_38_1342 VDD VSS sg13g2_decap_8
XFILLER_164_1350 VDD VSS sg13g2_decap_8
XFILLER_72_75 VDD VSS sg13g2_decap_8
X_13573_ _15156_/D _13593_/B _13571_/Y _13572_/Y VDD VSS sg13g2_a21oi_1
XFILLER_73_1255 VDD VSS sg13g2_decap_8
X_10785_ _10785_/Y _08943_/A _09148_/Y _08943_/Y VDD VSS sg13g2_o21ai_1
XFILLER_125_1356 VDD VSS sg13g2_fill_1
XFILLER_40_661 VDD VSS sg13g2_decap_8
XFILLER_13_886 VDD VSS sg13g2_decap_8
X_12524_ _12524_/X _12520_/X _12519_/X _12516_/X _12515_/X _12649_/S0 _12455_/S VDD
+ VSS sg13g2_mux4_1
XFILLER_8_312 VDD VSS sg13g2_decap_8
XFILLER_184_121 VDD VSS sg13g2_decap_8
XFILLER_185_644 VDD VSS sg13g2_decap_8
XFILLER_12_385 VDD VSS sg13g2_decap_8
XFILLER_160_1269 VDD VSS sg13g2_decap_8
XFILLER_9_868 VDD VSS sg13g2_decap_8
XFILLER_173_817 VDD VSS sg13g2_fill_2
X_15243_ _15243_/Q clkload48/A _15243_/D _15243_/RESET_B VDD VSS sg13g2_dfrbpq_1
X_12455_ _12455_/X _12454_/X _12453_/X _12455_/S VDD VSS sg13g2_mux2_1
XFILLER_8_389 VDD VSS sg13g2_decap_8
XFILLER_172_338 VDD VSS sg13g2_decap_8
XFILLER_184_198 VDD VSS sg13g2_decap_8
X_11406_ _11425_/C _11830_/B1 _11404_/Y _11405_/Y VDD VSS sg13g2_o21ai_1
X_15174_ _15174_/Q clkload82/A _15174_/D _15174_/RESET_B VDD VSS sg13g2_dfrbpq_1
X_12386_ _12386_/Y _12386_/A _12386_/B VDD VSS sg13g2_nand2_1
X_14401__1801 _14401_/RESET_B VDD VSS sg13g2_tiehi
X_14125_ _14125_/Q _14637_/CLK _14125_/D _14125_/RESET_B VDD VSS sg13g2_dfrbpq_1
XFILLER_99_617 VDD VSS sg13g2_decap_4
XFILLER_126_788 VDD VSS sg13g2_decap_8
XFILLER_158_1165 VDD VSS sg13g2_decap_8
X_11337_ _11338_/B _12899_/A _15123_/Q _12836_/B _11290_/A VDD VSS sg13g2_a22oi_1
Xclkbuf_leaf_122_clk_i clkload16/A clkbuf_5_4__f_clk_i/X VDD VSS sg13g2_buf_8
XFILLER_98_105 VDD VSS sg13g2_decap_4
XFILLER_119_1149 VDD VSS sg13g2_decap_8
XFILLER_125_298 VDD VSS sg13g2_fill_1
XFILLER_84_1351 VDD VSS sg13g2_decap_8
XFILLER_4_595 VDD VSS sg13g2_decap_8
XFILLER_49_1471 VDD VSS sg13g2_decap_8
XFILLER_136_1430 VDD VSS sg13g2_decap_8
XFILLER_141_758 VDD VSS sg13g2_decap_8
X_14056_ _14056_/Q clkload21/A _14056_/D _14056_/RESET_B VDD VSS sg13g2_dfrbpq_1
XFILLER_141_769 VDD VSS sg13g2_fill_1
X_11268_ _11268_/Y _11267_/Y _12174_/A _12334_/C VDD VSS sg13g2_a21oi_1
XFILLER_122_961 VDD VSS sg13g2_fill_2
XFILLER_122_972 VDD VSS sg13g2_decap_8
XFILLER_171_1343 VDD VSS sg13g2_decap_8
X_13007_ _13058_/C _14907_/Q _13680_/Q VDD VSS sg13g2_nand2_1
XFILLER_136_1474 VDD VSS sg13g2_fill_1
X_10219_ _10219_/X _14767_/Q _14768_/Q VDD VSS sg13g2_and2_1
XFILLER_132_1316 VDD VSS sg13g2_decap_8
X_11199_ _11199_/Y _11181_/A _11199_/B VDD VSS sg13g2_nand2b_1
XFILLER_45_1368 VDD VSS sg13g2_decap_8
XFILLER_121_471 VDD VSS sg13g2_decap_8
XFILLER_67_536 VDD VSS sg13g2_decap_4
XFILLER_121_493 VDD VSS sg13g2_decap_8
XFILLER_39_238 VDD VSS sg13g2_decap_8
X_14434__1768 _14434_/RESET_B VDD VSS sg13g2_tiehi
XFILLER_94_333 VDD VSS sg13g2_decap_8
XFILLER_11_4 VDD VSS sg13g2_decap_8
XFILLER_48_750 VDD VSS sg13g2_decap_4
XFILLER_95_889 VDD VSS sg13g2_decap_8
XFILLER_43_1092 VDD VSS sg13g2_fill_2
XFILLER_78_1100 VDD VSS sg13g2_fill_1
XFILLER_48_772 VDD VSS sg13g2_decap_8
XFILLER_130_1051 VDD VSS sg13g2_decap_4
X_14958_ _14958_/Q clkload81/A _14958_/D _14958_/RESET_B VDD VSS sg13g2_dfrbpq_1
XFILLER_130_1073 VDD VSS sg13g2_decap_8
XFILLER_63_731 VDD VSS sg13g2_decap_4
X_13909_ _13909_/Q clkload36/A _13909_/D _13909_/RESET_B VDD VSS sg13g2_dfrbpq_1
XFILLER_39_1106 VDD VSS sg13g2_decap_4
XFILLER_35_444 VDD VSS sg13g2_decap_8
X_14889_ _14889_/Q clkload88/A _14889_/D _14889_/RESET_B VDD VSS sg13g2_dfrbpq_1
XFILLER_35_455 VDD VSS sg13g2_decap_8
XFILLER_169_1294 VDD VSS sg13g2_decap_8
XFILLER_78_1177 VDD VSS sg13g2_decap_8
XFILLER_62_241 VDD VSS sg13g2_decap_8
X_13999__2203 _13999_/RESET_B VDD VSS sg13g2_tiehi
XFILLER_91_1300 VDD VSS sg13g2_decap_4
XFILLER_23_628 VDD VSS sg13g2_decap_8
XFILLER_35_488 VDD VSS sg13g2_decap_8
XFILLER_90_594 VDD VSS sg13g2_fill_1
XFILLER_149_836 VDD VSS sg13g2_decap_8
XFILLER_17_1448 VDD VSS sg13g2_decap_8
X_09100_ _09100_/Y _15240_/Q _09107_/B VDD VSS sg13g2_nand2b_1
XFILLER_91_1388 VDD VSS sg13g2_decap_8
XFILLER_143_1467 VDD VSS sg13g2_fill_2
X_09031_ _09031_/Y _09031_/A _09031_/B _09031_/C VDD VSS sg13g2_nor3_1
XFILLER_148_368 VDD VSS sg13g2_decap_8
XFILLER_50_1063 VDD VSS sg13g2_decap_8
XFILLER_129_582 VDD VSS sg13g2_decap_4
XFILLER_157_891 VDD VSS sg13g2_decap_8
XFILLER_15_1194 VDD VSS sg13g2_decap_8
XFILLER_7_70 VDD VSS sg13g2_decap_8
XFILLER_117_744 VDD VSS sg13g2_decap_4
XFILLER_11_1058 VDD VSS sg13g2_decap_8
XFILLER_172_850 VDD VSS sg13g2_decap_8
XFILLER_132_703 VDD VSS sg13g2_fill_2
XFILLER_89_1295 VDD VSS sg13g2_decap_8
XFILLER_104_405 VDD VSS sg13g2_fill_2
XFILLER_176_1254 VDD VSS sg13g2_decap_8
XFILLER_171_382 VDD VSS sg13g2_decap_8
XFILLER_89_127 VDD VSS sg13g2_decap_8
XFILLER_137_1238 VDD VSS sg13g2_decap_4
XFILLER_104_449 VDD VSS sg13g2_decap_4
X_09933_ _14518_/D _14518_/Q _09933_/A1 _09937_/S VDD VSS sg13g2_mux2_1
Xfanout803 _12623_/S _12595_/S VDD VSS sg13g2_buf_1
Xfanout814 _12398_/S0 _12789_/S0 VDD VSS sg13g2_buf_1
Xfanout825 _12494_/S1 fanout828/X VDD VSS sg13g2_buf_1
XFILLER_63_1435 VDD VSS sg13g2_decap_8
Xfanout836 _12425_/S1 fanout867/X VDD VSS sg13g2_buf_1
XFILLER_112_460 VDD VSS sg13g2_fill_1
Xfanout847 _12614_/S1 _12589_/S1 VDD VSS sg13g2_buf_1
X_09864_ _14451_/D _14451_/Q _10162_/A1 _09870_/S VDD VSS sg13g2_mux2_1
XFILLER_100_611 VDD VSS sg13g2_fill_1
XFILLER_140_780 VDD VSS sg13g2_decap_8
Xfanout858 _12773_/S1 _12768_/S1 VDD VSS sg13g2_buf_1
XFILLER_98_694 VDD VSS sg13g2_decap_4
Xfanout869 _12438_/S0 fanout877/X VDD VSS sg13g2_buf_1
X_08815_ _13689_/D _08813_/Y _08812_/Y _08814_/Y VDD VSS sg13g2_a21oi_1
XFILLER_100_644 VDD VSS sg13g2_decap_4
XFILLER_86_867 VDD VSS sg13g2_fill_2
X_09795_ _14384_/D _09960_/A1 _14384_/Q _09795_/S VDD VSS sg13g2_mux2_1
XFILLER_6_1362 VDD VSS sg13g2_decap_8
XFILLER_100_677 VDD VSS sg13g2_fill_2
XFILLER_22_1132 VDD VSS sg13g2_decap_8
XFILLER_2_1204 VDD VSS sg13g2_decap_8
XFILLER_100_688 VDD VSS sg13g2_fill_1
X_08746_ _08746_/Y _13667_/Q _08752_/B VDD VSS sg13g2_nor2_1
XFILLER_38_260 VDD VSS sg13g2_decap_4
XFILLER_26_400 VDD VSS sg13g2_decap_4
XFILLER_26_35 VDD VSS sg13g2_decap_8
XFILLER_148_1323 VDD VSS sg13g2_decap_8
X_14856__2855 _14856_/RESET_B VDD VSS sg13g2_tiehi
X_08677_ _08697_/A _08662_/B _07847_/Y _07974_/C VDD VSS sg13g2_a21oi_1
XFILLER_183_1225 VDD VSS sg13g2_decap_8
XFILLER_54_775 VDD VSS sg13g2_decap_8
XFILLER_54_786 VDD VSS sg13g2_fill_1
X_14589__1613 _14589_/RESET_B VDD VSS sg13g2_tiehi
X_07628_ _13609_/A _12911_/B VDD VSS sg13g2_inv_1
XFILLER_54_797 VDD VSS sg13g2_decap_8
XFILLER_13_116 VDD VSS sg13g2_decap_8
XFILLER_41_425 VDD VSS sg13g2_decap_8
XFILLER_70_1406 VDD VSS sg13g2_decap_8
XFILLER_10_812 VDD VSS sg13g2_decap_8
X_10570_ _10572_/C _10579_/B _10579_/C _12895_/A VDD VSS sg13g2_a21oi_1
XFILLER_50_981 VDD VSS sg13g2_fill_2
X_14889__2789 _14889_/RESET_B VDD VSS sg13g2_tiehi
XFILLER_42_56 VDD VSS sg13g2_decap_8
XFILLER_42_78 VDD VSS sg13g2_decap_8
XFILLER_166_154 VDD VSS sg13g2_decap_8
XFILLER_158_56 VDD VSS sg13g2_decap_8
X_09229_ _13840_/D _09463_/A0 _13840_/Q _09229_/S VDD VSS sg13g2_mux2_1
XFILLER_6_816 VDD VSS sg13g2_decap_8
XFILLER_33_1261 VDD VSS sg13g2_decap_8
XFILLER_10_889 VDD VSS sg13g2_decap_8
XFILLER_148_891 VDD VSS sg13g2_decap_8
XFILLER_158_89 VDD VSS sg13g2_decap_8
XFILLER_5_315 VDD VSS sg13g2_decap_8
XFILLER_107_210 VDD VSS sg13g2_decap_4
X_12240_ _12240_/Y _12288_/S0 _14584_/Q VDD VSS sg13g2_nand2b_1
XFILLER_159_1430 VDD VSS sg13g2_decap_8
XFILLER_135_541 VDD VSS sg13g2_decap_4
XFILLER_182_669 VDD VSS sg13g2_decap_8
XFILLER_163_861 VDD VSS sg13g2_fill_1
XFILLER_68_1335 VDD VSS sg13g2_decap_8
XFILLER_181_168 VDD VSS sg13g2_decap_8
XFILLER_108_788 VDD VSS sg13g2_decap_8
X_12171_ _12172_/A _13750_/Q _14102_/Q _14454_/Q _14550_/Q _12189_/S0 _12169_/C VDD
+ VSS sg13g2_mux4_1
XFILLER_123_714 VDD VSS sg13g2_decap_8
XFILLER_155_1305 VDD VSS sg13g2_decap_8
XFILLER_159_1474 VDD VSS sg13g2_fill_1
XFILLER_135_596 VDD VSS sg13g2_decap_4
X_11122_ _11123_/B _11119_/B _11063_/Y _11091_/B VDD VSS sg13g2_o21ai_1
XFILLER_174_77 VDD VSS sg13g2_decap_8
XFILLER_1_532 VDD VSS sg13g2_decap_8
XFILLER_104_950 VDD VSS sg13g2_fill_2
XFILLER_122_257 VDD VSS sg13g2_decap_8
XFILLER_150_566 VDD VSS sg13g2_decap_8
XFILLER_3_39 VDD VSS sg13g2_decap_8
XFILLER_153_1040 VDD VSS sg13g2_fill_1
Xclkbuf_leaf_54_clk_i clkload81/A clkbuf_leaf_80_clk_i/A VDD VSS sg13g2_buf_8
X_11053_ _11053_/Y _11068_/C _11068_/A _11043_/A VDD VSS sg13g2_o21ai_1
XFILLER_76_300 VDD VSS sg13g2_decap_4
X_10004_ _10004_/Y _10037_/A _10004_/B _10004_/C _10070_/C VDD VSS sg13g2_nand4_1
XFILLER_7_1148 VDD VSS sg13g2_decap_8
XFILLER_27_1076 VDD VSS sg13g2_decap_8
X_15075__2872 _15075_/RESET_B VDD VSS sg13g2_tiehi
XFILLER_67_97 VDD VSS sg13g2_decap_8
XFILLER_40_1221 VDD VSS sg13g2_decap_8
X_14812_ _14812_/Q clkload84/A _14812_/D _14812_/RESET_B VDD VSS sg13g2_dfrbpq_1
Xclkbuf_leaf_69_clk_i clkload86/A clkbuf_leaf_78_clk_i/A VDD VSS sg13g2_buf_8
XFILLER_91_347 VDD VSS sg13g2_decap_8
X_14743_ _14743_/Q _14743_/CLK _14743_/D _14743_/RESET_B VDD VSS sg13g2_dfrbpq_1
X_11955_ _11955_/Y _11955_/A _11973_/B VDD VSS sg13g2_nand2_1
XFILLER_40_1298 VDD VSS sg13g2_decap_8
XFILLER_166_1423 VDD VSS sg13g2_decap_8
XFILLER_75_1328 VDD VSS sg13g2_decap_8
X_10906_ _10948_/B _14756_/Q _10923_/B VDD VSS sg13g2_xor2_1
XFILLER_44_263 VDD VSS sg13g2_fill_1
XFILLER_127_1418 VDD VSS sg13g2_decap_8
X_14674_ _14674_/Q _14743_/CLK _14674_/D _14674_/RESET_B VDD VSS sg13g2_dfrbpq_1
XFILLER_60_723 VDD VSS sg13g2_fill_1
XFILLER_45_797 VDD VSS sg13g2_decap_8
X_11886_ _11886_/Y _11890_/S0 _14414_/Q _11897_/C VDD VSS sg13g2_a21oi_1
XFILLER_44_296 VDD VSS sg13g2_fill_1
XFILLER_33_959 VDD VSS sg13g2_fill_1
X_13625_ _13733_/D _13625_/A VDD VSS sg13g2_buf_1
X_10837_ _10849_/A _10837_/A _10862_/B VDD VSS sg13g2_nand2_1
XFILLER_186_931 VDD VSS sg13g2_decap_8
XFILLER_13_672 VDD VSS sg13g2_decap_8
X_13556_ _13556_/Y _08056_/B _13567_/A2 _13555_/Y VDD VSS sg13g2_a21oi_1
XFILLER_80_7 VDD VSS sg13g2_decap_8
XFILLER_158_655 VDD VSS sg13g2_decap_4
XFILLER_185_441 VDD VSS sg13g2_decap_8
X_10768_ _11147_/A _14950_/Q _10767_/A _10767_/Y VDD VSS sg13g2_a21oi_1
XFILLER_40_480 VDD VSS sg13g2_decap_8
XFILLER_12_182 VDD VSS sg13g2_decap_8
XFILLER_157_143 VDD VSS sg13g2_decap_4
X_12507_ _12507_/X _14118_/Q _14150_/Q _14182_/Q _14214_/Q _12590_/S0 _12590_/S1 VDD
+ VSS sg13g2_mux4_1
XFILLER_9_665 VDD VSS sg13g2_decap_8
XFILLER_16_1470 VDD VSS sg13g2_decap_4
XFILLER_157_176 VDD VSS sg13g2_fill_1
XFILLER_160_1088 VDD VSS sg13g2_fill_2
XFILLER_172_102 VDD VSS sg13g2_decap_8
X_13487_ _13487_/Y _13652_/S _15173_/D _15175_/D _13502_/D VDD VSS sg13g2_nor4_1
XFILLER_51_1361 VDD VSS sg13g2_decap_8
X_10699_ _10699_/Y _14902_/Q _10875_/B VDD VSS sg13g2_nand2_1
XFILLER_12_1334 VDD VSS sg13g2_decap_8
XFILLER_139_891 VDD VSS sg13g2_decap_8
X_15226_ _15226_/Q clkload22/A _15226_/D _15226_/RESET_B VDD VSS sg13g2_dfrbpq_1
XFILLER_8_186 VDD VSS sg13g2_decap_8
XFILLER_173_658 VDD VSS sg13g2_decap_8
X_12438_ _12438_/X _14241_/Q _14273_/Q _14305_/Q _14337_/Q _12438_/S0 _12438_/S1 VDD
+ VSS sg13g2_mux4_1
XFILLER_161_809 VDD VSS sg13g2_decap_8
XFILLER_126_552 VDD VSS sg13g2_fill_2
XFILLER_114_714 VDD VSS sg13g2_decap_8
XFILLER_160_319 VDD VSS sg13g2_decap_8
XFILLER_172_179 VDD VSS sg13g2_decap_8
X_15157_ _15157_/Q _15160_/CLK _15157_/D _15157_/RESET_B VDD VSS sg13g2_dfrbpq_1
X_12369_ _12369_/X _12368_/X _12367_/X _12361_/X _12362_/X _12788_/S0 _12355_/S VDD
+ VSS sg13g2_mux4_1
XFILLER_86_1468 VDD VSS sg13g2_decap_8
XFILLER_5_882 VDD VSS sg13g2_decap_8
XFILLER_113_213 VDD VSS sg13g2_decap_8
XFILLER_114_747 VDD VSS sg13g2_decap_4
X_14108_ _14108_/Q _14588_/CLK _14108_/D _14108_/RESET_B VDD VSS sg13g2_dfrbpq_1
XFILLER_99_458 VDD VSS sg13g2_decap_8
XFILLER_114_769 VDD VSS sg13g2_fill_1
XFILLER_173_1449 VDD VSS sg13g2_decap_8
X_15088_ _15088_/Q clkload72/A _15088_/D _15088_/RESET_B VDD VSS sg13g2_dfrbpq_1
XFILLER_4_392 VDD VSS sg13g2_decap_8
XFILLER_84_1181 VDD VSS sg13g2_fill_2
X_14039_ _14039_/Q clkload44/A _14039_/D _14039_/RESET_B VDD VSS sg13g2_dfrbpq_1
X_14667__1535 _14667_/RESET_B VDD VSS sg13g2_tiehi
XFILLER_110_931 VDD VSS sg13g2_decap_8
XFILLER_136_1282 VDD VSS sg13g2_decap_8
XFILLER_45_1165 VDD VSS sg13g2_decap_8
XFILLER_23_1430 VDD VSS sg13g2_decap_8
XFILLER_67_355 VDD VSS sg13g2_fill_1
XFILLER_83_815 VDD VSS sg13g2_decap_8
X_08600_ _08600_/Y _08659_/A _08600_/B _08600_/C _08600_/D VDD VSS sg13g2_nor4_1
XFILLER_94_163 VDD VSS sg13g2_decap_8
X_14811__2925 _14811_/RESET_B VDD VSS sg13g2_tiehi
X_09580_ _14177_/D _14177_/Q _09714_/A0 _09599_/S VDD VSS sg13g2_mux2_1
XFILLER_55_528 VDD VSS sg13g2_fill_1
XFILLER_23_1474 VDD VSS sg13g2_fill_1
XFILLER_36_720 VDD VSS sg13g2_fill_1
XFILLER_48_591 VDD VSS sg13g2_fill_2
X_08531_ _08531_/Y _08612_/S _08531_/B VDD VSS sg13g2_nor2_1
XFILLER_70_509 VDD VSS sg13g2_decap_8
XFILLER_63_550 VDD VSS sg13g2_decap_4
XFILLER_24_915 VDD VSS sg13g2_decap_8
XFILLER_24_926 VDD VSS sg13g2_fill_2
X_15035__2575 _15035_/RESET_B VDD VSS sg13g2_tiehi
X_08462_ _15236_/D _08462_/A _08462_/B _08462_/C VDD VSS sg13g2_nand3_1
XFILLER_1_1281 VDD VSS sg13g2_decap_8
XFILLER_90_391 VDD VSS sg13g2_fill_1
X_08393_ _08393_/Y _08394_/B _08394_/C _08414_/C VDD VSS sg13g2_o21ai_1
XFILLER_91_1130 VDD VSS sg13g2_decap_8
XFILLER_50_244 VDD VSS sg13g2_decap_8
XFILLER_149_611 VDD VSS sg13g2_decap_8
XFILLER_143_1220 VDD VSS sg13g2_fill_2
XFILLER_56_1283 VDD VSS sg13g2_decap_8
XFILLER_177_942 VDD VSS sg13g2_decap_8
XFILLER_10_119 VDD VSS sg13g2_decap_8
XFILLER_17_1245 VDD VSS sg13g2_decap_8
XFILLER_52_1158 VDD VSS sg13g2_decap_8
XFILLER_149_688 VDD VSS sg13g2_decap_8
XFILLER_30_1412 VDD VSS sg13g2_decap_8
XFILLER_136_327 VDD VSS sg13g2_decap_8
XFILLER_178_1327 VDD VSS sg13g2_decap_8
X_09014_ _13763_/D _13763_/Q _10146_/A1 _09077_/S VDD VSS sg13g2_mux2_1
XFILLER_164_658 VDD VSS sg13g2_decap_8
XFILLER_129_390 VDD VSS sg13g2_decap_8
XFILLER_128_48 VDD VSS sg13g2_decap_8
XFILLER_117_552 VDD VSS sg13g2_decap_8
XFILLER_104_213 VDD VSS sg13g2_decap_8
XFILLER_105_736 VDD VSS sg13g2_fill_2
XFILLER_117_596 VDD VSS sg13g2_decap_4
XFILLER_137_1013 VDD VSS sg13g2_decap_8
XFILLER_172_691 VDD VSS sg13g2_decap_8
XFILLER_2_329 VDD VSS sg13g2_decap_8
XFILLER_132_533 VDD VSS sg13g2_decap_8
XFILLER_160_842 VDD VSS sg13g2_decap_4
Xfanout600 _10800_/B _11048_/B VDD VSS sg13g2_buf_1
XFILLER_104_268 VDD VSS sg13g2_fill_1
XFILLER_120_717 VDD VSS sg13g2_decap_8
Xfanout611 _09137_/A _08966_/Y VDD VSS sg13g2_buf_1
XFILLER_120_728 VDD VSS sg13g2_fill_2
Xfanout622 fanout622/X _08838_/Y VDD VSS sg13g2_buf_1
X_09916_ _14501_/D _14501_/Q _09916_/A1 _09927_/S VDD VSS sg13g2_mux2_1
XFILLER_63_1232 VDD VSS sg13g2_decap_8
Xfanout633 _08875_/S _08900_/A2 VDD VSS sg13g2_buf_1
Xfanout644 _13440_/A _08724_/Y VDD VSS sg13g2_buf_1
XFILLER_8_1446 VDD VSS sg13g2_decap_8
Xfanout655 _08692_/A _07996_/X VDD VSS sg13g2_buf_1
XFILLER_28_1385 VDD VSS sg13g2_decap_8
Xfanout666 _08600_/B _08659_/B VDD VSS sg13g2_buf_1
Xfanout677 _10985_/B1 _10824_/C1 VDD VSS sg13g2_buf_1
X_09847_ _14434_/D _14434_/Q _10045_/A0 _09858_/S VDD VSS sg13g2_mux2_1
XFILLER_59_867 VDD VSS sg13g2_fill_2
XFILLER_150_1246 VDD VSS sg13g2_fill_1
Xfanout688 _12156_/A _07683_/X VDD VSS sg13g2_buf_1
XFILLER_85_130 VDD VSS sg13g2_decap_8
XFILLER_24_1249 VDD VSS sg13g2_decap_8
Xfanout699 _10195_/S _13336_/S VDD VSS sg13g2_buf_1
XFILLER_85_141 VDD VSS sg13g2_fill_1
XFILLER_46_506 VDD VSS sg13g2_fill_1
XFILLER_85_152 VDD VSS sg13g2_decap_8
XFILLER_58_377 VDD VSS sg13g2_decap_8
XFILLER_46_517 VDD VSS sg13g2_decap_8
XFILLER_115_1399 VDD VSS sg13g2_decap_8
XFILLER_18_219 VDD VSS sg13g2_decap_8
X_13761__2441 _13761_/RESET_B VDD VSS sg13g2_tiehi
XFILLER_2_1001 VDD VSS sg13g2_decap_8
X_09778_ _14367_/D _09910_/A1 _14367_/Q _09789_/S VDD VSS sg13g2_mux2_1
XFILLER_37_56 VDD VSS sg13g2_decap_8
XFILLER_39_580 VDD VSS sg13g2_decap_4
XFILLER_160_46 VDD VSS sg13g2_decap_8
X_08729_ _08729_/Y _13345_/B _10206_/A1 _08727_/X _13459_/B _13440_/A VDD VSS sg13g2_a221oi_1
XFILLER_96_1030 VDD VSS sg13g2_fill_2
XFILLER_27_753 VDD VSS sg13g2_decap_8
XFILLER_183_1000 VDD VSS sg13g2_decap_8
XFILLER_96_1052 VDD VSS sg13g2_decap_4
XFILLER_57_1003 VDD VSS sg13g2_decap_8
XFILLER_2_1078 VDD VSS sg13g2_decap_8
XFILLER_26_263 VDD VSS sg13g2_decap_8
XFILLER_183_1022 VDD VSS sg13g2_decap_8
X_11740_ _11742_/A _11759_/A _14634_/Q VDD VSS sg13g2_nand2b_1
XFILLER_82_892 VDD VSS sg13g2_decap_8
XFILLER_15_959 VDD VSS sg13g2_fill_2
XFILLER_144_1006 VDD VSS sg13g2_decap_8
XFILLER_14_436 VDD VSS sg13g2_decap_8
X_15106__2772 _15106_/RESET_B VDD VSS sg13g2_tiehi
XFILLER_57_1058 VDD VSS sg13g2_fill_1
XFILLER_148_1186 VDD VSS sg13g2_decap_8
XFILLER_159_419 VDD VSS sg13g2_decap_8
X_14141__2061 _14141_/RESET_B VDD VSS sg13g2_tiehi
X_11671_ _11671_/X _11671_/A _11696_/B VDD VSS sg13g2_and2_1
XFILLER_30_918 VDD VSS sg13g2_fill_1
XFILLER_183_1099 VDD VSS sg13g2_decap_8
XFILLER_70_1203 VDD VSS sg13g2_decap_8
XFILLER_161_1331 VDD VSS sg13g2_decap_8
XFILLER_186_238 VDD VSS sg13g2_decap_8
X_13410_ _13421_/B _15194_/Q _15195_/Q _15196_/Q _15197_/Q VDD VSS sg13g2_nor4_1
XFILLER_23_981 VDD VSS sg13g2_decap_8
X_10622_ _10636_/A _14882_/Q _10651_/D _10622_/C VDD VSS sg13g2_nand3_1
XFILLER_74_1394 VDD VSS sg13g2_decap_8
XFILLER_35_1345 VDD VSS sg13g2_decap_8
XFILLER_169_77 VDD VSS sg13g2_decap_8
X_14390_ _14390_/Q _14588_/CLK _14390_/D _14390_/RESET_B VDD VSS sg13g2_dfrbpq_1
XFILLER_183_901 VDD VSS sg13g2_fill_2
XFILLER_167_463 VDD VSS sg13g2_decap_8
XFILLER_183_912 VDD VSS sg13g2_decap_8
XFILLER_31_1209 VDD VSS sg13g2_decap_8
X_13341_ _13341_/Y _13341_/A _15174_/D VDD VSS sg13g2_nor2b_1
X_14745__1457 _14745_/RESET_B VDD VSS sg13g2_tiehi
X_10553_ _10555_/B _14866_/Q _14865_/Q _10556_/D VDD VSS sg13g2_nand3_1
XFILLER_6_613 VDD VSS sg13g2_decap_8
XFILLER_183_945 VDD VSS sg13g2_fill_2
XFILLER_10_686 VDD VSS sg13g2_decap_8
XFILLER_185_21 VDD VSS sg13g2_decap_8
XFILLER_127_349 VDD VSS sg13g2_decap_8
XFILLER_155_658 VDD VSS sg13g2_decap_8
XFILLER_5_112 VDD VSS sg13g2_decap_8
X_13272_ _13272_/X input28/X _13272_/A2 _13272_/B1 VDD VSS sg13g2_a21o_1
XFILLER_154_146 VDD VSS sg13g2_decap_8
XFILLER_182_455 VDD VSS sg13g2_decap_8
X_10484_ _10495_/D _14849_/Q _13084_/A _14847_/Q _10484_/D VDD VSS sg13g2_and4_1
X_15011_ _15011_/Q clkload38/A _15011_/D _15011_/RESET_B VDD VSS sg13g2_dfrbpq_1
X_12223_ _12223_/X _12223_/A _12223_/B _12223_/C VDD VSS sg13g2_or3_1
XFILLER_68_1132 VDD VSS sg13g2_decap_8
XFILLER_185_98 VDD VSS sg13g2_decap_8
XFILLER_5_189 VDD VSS sg13g2_decap_8
XFILLER_135_382 VDD VSS sg13g2_decap_8
XFILLER_123_544 VDD VSS sg13g2_decap_8
X_12154_ _12156_/B _12155_/A _12155_/B _12198_/D VDD VSS sg13g2_a21o_1
XFILLER_151_864 VDD VSS sg13g2_decap_8
XFILLER_69_609 VDD VSS sg13g2_decap_8
XFILLER_29_1149 VDD VSS sg13g2_decap_8
X_13686__2523 _13686_/RESET_B VDD VSS sg13g2_tiehi
XFILLER_81_1321 VDD VSS sg13g2_decap_8
X_11105_ _11105_/Y _11086_/A _10759_/X _11118_/D VDD VSS sg13g2_a21oi_1
XFILLER_151_897 VDD VSS sg13g2_decap_8
XFILLER_133_1411 VDD VSS sg13g2_decap_8
X_12085_ _12086_/B _12061_/A _13189_/B _12063_/Y VDD VSS sg13g2_a21oi_1
XFILLER_49_300 VDD VSS sg13g2_fill_2
XFILLER_46_1463 VDD VSS sg13g2_decap_8
XFILLER_2_896 VDD VSS sg13g2_decap_8
XFILLER_110_238 VDD VSS sg13g2_decap_8
X_11036_ _11036_/Y _11023_/A _11024_/B _11034_/Y _11022_/B VDD VSS sg13g2_a22oi_1
XFILLER_42_1338 VDD VSS sg13g2_decap_8
XFILLER_81_1398 VDD VSS sg13g2_decap_8
XFILLER_37_528 VDD VSS sg13g2_fill_2
XFILLER_91_100 VDD VSS sg13g2_decap_8
X_14351__1851 _14351_/RESET_B VDD VSS sg13g2_tiehi
XFILLER_92_634 VDD VSS sg13g2_fill_2
XFILLER_40_1084 VDD VSS sg13g2_fill_1
X_12987_ _12987_/Y _12988_/C _12988_/D VDD VSS sg13g2_nor2_1
XFILLER_166_1220 VDD VSS sg13g2_decap_8
XFILLER_75_1103 VDD VSS sg13g2_fill_2
X_14726_ _14726_/Q clkload51/A _14726_/D _14726_/RESET_B VDD VSS sg13g2_dfrbpq_1
X_11938_ _11938_/Y _11937_/Y _12055_/B _11458_/A VDD VSS sg13g2_a21oi_1
XFILLER_91_188 VDD VSS sg13g2_fill_1
XFILLER_33_734 VDD VSS sg13g2_decap_8
XFILLER_162_1106 VDD VSS sg13g2_decap_8
X_14657_ _14657_/Q clkload10/A _14657_/D _14657_/RESET_B VDD VSS sg13g2_dfrbpq_1
XFILLER_166_1297 VDD VSS sg13g2_decap_8
X_11869_ _11869_/Y _11882_/S0 _13838_/Q VDD VSS sg13g2_nand2b_1
XFILLER_53_1412 VDD VSS sg13g2_decap_8
XFILLER_33_789 VDD VSS sg13g2_fill_2
XFILLER_32_266 VDD VSS sg13g2_fill_1
XFILLER_92_1472 VDD VSS sg13g2_decap_8
XFILLER_14_981 VDD VSS sg13g2_decap_8
X_13608_ _13608_/Y _13600_/A _13508_/C _15167_/Q VDD VSS sg13g2_a21oi_1
XFILLER_32_288 VDD VSS sg13g2_decap_8
XFILLER_20_439 VDD VSS sg13g2_decap_8
X_14588_ _14588_/Q _14588_/CLK _14588_/D _14588_/RESET_B VDD VSS sg13g2_dfrbpq_1
XFILLER_14_1429 VDD VSS sg13g2_decap_8
XFILLER_140_1437 VDD VSS sg13g2_decap_8
X_13539_ _13539_/Y _13539_/A _13554_/S VDD VSS sg13g2_nor2_1
XFILLER_9_462 VDD VSS sg13g2_decap_8
XFILLER_174_934 VDD VSS sg13g2_decap_4
X_14840__2887 _14840_/RESET_B VDD VSS sg13g2_tiehi
XFILLER_12_1131 VDD VSS sg13g2_decap_8
X_14004__2198 _14004_/RESET_B VDD VSS sg13g2_tiehi
X_14829__2907 _14829_/RESET_B VDD VSS sg13g2_tiehi
X_15209_ _15209_/Q clkload73/A _15209_/D _15209_/RESET_B VDD VSS sg13g2_dfrbpq_1
XFILLER_86_1232 VDD VSS sg13g2_decap_8
XFILLER_160_116 VDD VSS sg13g2_decap_8
XFILLER_114_544 VDD VSS sg13g2_fill_2
XFILLER_173_1246 VDD VSS sg13g2_decap_8
XFILLER_47_1249 VDD VSS sg13g2_decap_8
XFILLER_87_417 VDD VSS sg13g2_decap_8
XFILLER_114_588 VDD VSS sg13g2_fill_2
X_07962_ _07962_/Y _15014_/Q _12084_/A VDD VSS sg13g2_nor2b_1
X_14183__2019 _14183_/RESET_B VDD VSS sg13g2_tiehi
XFILLER_87_439 VDD VSS sg13g2_decap_8
XFILLER_141_396 VDD VSS sg13g2_decap_8
XFILLER_96_940 VDD VSS sg13g2_fill_2
X_09701_ _14293_/D _09767_/A1 _14293_/Q _09704_/S VDD VSS sg13g2_mux2_1
XFILLER_60_1427 VDD VSS sg13g2_decap_8
XFILLER_68_653 VDD VSS sg13g2_fill_2
X_07893_ _07893_/Y _08256_/B _07893_/B VDD VSS sg13g2_nand2_1
XFILLER_96_984 VDD VSS sg13g2_decap_8
XFILLER_28_506 VDD VSS sg13g2_decap_4
X_09632_ _14228_/D _10163_/A1 _14228_/Q _09632_/S VDD VSS sg13g2_mux2_1
XFILLER_67_174 VDD VSS sg13g2_decap_8
XFILLER_56_848 VDD VSS sg13g2_fill_2
X_09563_ _14161_/D _09928_/A1 _14161_/Q _09571_/S VDD VSS sg13g2_mux2_1
XFILLER_83_667 VDD VSS sg13g2_fill_2
XFILLER_71_807 VDD VSS sg13g2_fill_1
XFILLER_58_1301 VDD VSS sg13g2_decap_8
XFILLER_3_1376 VDD VSS sg13g2_decap_8
XFILLER_149_1451 VDD VSS sg13g2_decap_8
XFILLER_184_1331 VDD VSS sg13g2_decap_8
X_08514_ _08514_/Y _08514_/A _08625_/A VDD VSS sg13g2_nor2_1
XFILLER_24_723 VDD VSS sg13g2_decap_8
XFILLER_110_1296 VDD VSS sg13g2_decap_4
X_09494_ _14094_/D _10057_/A0 _14094_/Q _09494_/S VDD VSS sg13g2_mux2_1
XFILLER_70_339 VDD VSS sg13g2_fill_1
XFILLER_24_734 VDD VSS sg13g2_fill_1
XFILLER_51_520 VDD VSS sg13g2_fill_2
XFILLER_93_1247 VDD VSS sg13g2_decap_8
XFILLER_93_1258 VDD VSS sg13g2_fill_2
XFILLER_58_1378 VDD VSS sg13g2_decap_8
XFILLER_180_1217 VDD VSS sg13g2_decap_8
X_08445_ _08445_/Y _07798_/X _07826_/X _07799_/X VDD VSS sg13g2_a21oi_1
XFILLER_24_767 VDD VSS sg13g2_decap_4
XFILLER_12_918 VDD VSS sg13g2_decap_8
XFILLER_168_227 VDD VSS sg13g2_decap_8
XFILLER_51_575 VDD VSS sg13g2_decap_8
XFILLER_11_417 VDD VSS sg13g2_decap_8
XFILLER_23_25 VDD VSS sg13g2_decap_8
X_14214__1988 _14214_/RESET_B VDD VSS sg13g2_tiehi
X_08376_ _08376_/X _08383_/A _07790_/A _07782_/A _07786_/A _13509_/A1 _13510_/A1 VDD
+ VSS sg13g2_mux4_1
XFILLER_143_1050 VDD VSS sg13g2_decap_8
XFILLER_108_1181 VDD VSS sg13g2_decap_4
XFILLER_137_603 VDD VSS sg13g2_decap_8
XFILLER_104_1034 VDD VSS sg13g2_decap_8
XFILLER_136_135 VDD VSS sg13g2_decap_8
XFILLER_178_1124 VDD VSS sg13g2_decap_8
XFILLER_87_1018 VDD VSS sg13g2_decap_8
X_14393__1809 _14393_/RESET_B VDD VSS sg13g2_tiehi
XFILLER_69_1430 VDD VSS sg13g2_decap_8
XFILLER_121_1381 VDD VSS sg13g2_decap_8
X_13779__2423 _13779_/RESET_B VDD VSS sg13g2_tiehi
XFILLER_118_883 VDD VSS sg13g2_decap_8
XFILLER_152_628 VDD VSS sg13g2_decap_8
XFILLER_3_627 VDD VSS sg13g2_decap_8
XFILLER_30_1286 VDD VSS sg13g2_decap_8
XFILLER_69_1474 VDD VSS sg13g2_fill_1
XFILLER_65_1305 VDD VSS sg13g2_decap_8
XFILLER_155_46 VDD VSS sg13g2_decap_8
XFILLER_2_126 VDD VSS sg13g2_decap_8
XFILLER_133_853 VDD VSS sg13g2_decap_8
XFILLER_156_1455 VDD VSS sg13g2_decap_8
XFILLER_160_672 VDD VSS sg13g2_fill_1
XFILLER_105_599 VDD VSS sg13g2_decap_4
Xfanout1406 _13328_/A _12812_/A VDD VSS sg13g2_buf_1
Xfanout1417 _13407_/B _13005_/C VDD VSS sg13g2_buf_1
Xfanout430 _10035_/S fanout432/X VDD VSS sg13g2_buf_1
Xfanout1428 _10499_/C _13499_/B VDD VSS sg13g2_buf_1
Xfanout441 _09822_/S _09826_/S VDD VSS sg13g2_buf_1
XFILLER_8_1243 VDD VSS sg13g2_decap_8
X_14159__2043 _14159_/RESET_B VDD VSS sg13g2_tiehi
Xfanout452 _09667_/S _09659_/S VDD VSS sg13g2_buf_1
XFILLER_87_951 VDD VSS sg13g2_decap_8
XFILLER_28_1182 VDD VSS sg13g2_decap_8
XFILLER_154_1190 VDD VSS sg13g2_decap_8
Xfanout463 _09533_/S _09523_/S VDD VSS sg13g2_buf_1
XFILLER_87_973 VDD VSS sg13g2_decap_4
XFILLER_101_761 VDD VSS sg13g2_decap_8
Xfanout474 fanout474/X _09441_/Y VDD VSS sg13g2_buf_1
XFILLER_150_1043 VDD VSS sg13g2_decap_4
XFILLER_171_56 VDD VSS sg13g2_decap_8
Xfanout485 _09374_/S fanout486/X VDD VSS sg13g2_buf_1
XFILLER_86_461 VDD VSS sg13g2_fill_1
XFILLER_101_772 VDD VSS sg13g2_fill_2
X_12910_ _12910_/Y _12910_/A _12909_/Y VDD VSS sg13g2_nor2b_1
Xfanout496 _09910_/A1 fanout497/X VDD VSS sg13g2_buf_1
XFILLER_48_99 VDD VSS sg13g2_decap_8
X_13890_ _13890_/Q clkload9/A _13890_/D _13890_/RESET_B VDD VSS sg13g2_dfrbpq_1
XFILLER_74_645 VDD VSS sg13g2_fill_2
XFILLER_73_133 VDD VSS sg13g2_decap_8
XFILLER_185_1117 VDD VSS sg13g2_decap_8
X_12841_ _12845_/A input29/X _12841_/B VDD VSS sg13g2_nand2_1
XFILLER_46_358 VDD VSS sg13g2_decap_8
XFILLER_76_1401 VDD VSS sg13g2_decap_8
XFILLER_62_818 VDD VSS sg13g2_decap_8
XFILLER_27_572 VDD VSS sg13g2_decap_4
X_12772_ _12772_/X _14393_/Q _14425_/Q _14489_/Q _14521_/Q _12773_/S0 _12773_/S1 VDD
+ VSS sg13g2_mux4_1
XFILLER_61_339 VDD VSS sg13g2_decap_8
XFILLER_14_222 VDD VSS sg13g2_decap_8
XFILLER_154_0 VDD VSS sg13g2_decap_8
XFILLER_163_1415 VDD VSS sg13g2_decap_8
X_14511_ _14511_/Q clkload40/A _14511_/D _14511_/RESET_B VDD VSS sg13g2_dfrbpq_1
XFILLER_42_542 VDD VSS sg13g2_decap_8
X_11723_ _14971_/D _14971_/Q _11723_/A2 _11722_/Y VDD VSS sg13g2_a21o_1
XFILLER_76_1478 VDD VSS sg13g2_fill_1
XFILLER_159_227 VDD VSS sg13g2_decap_4
XFILLER_30_715 VDD VSS sg13g2_decap_8
XFILLER_14_277 VDD VSS sg13g2_decap_8
XFILLER_9_49 VDD VSS sg13g2_decap_8
X_14442_ _14442_/Q _14602_/CLK _14442_/D _14442_/RESET_B VDD VSS sg13g2_dfrbpq_1
X_11654_ _11654_/X _11652_/X _11653_/X _11975_/A VDD VSS sg13g2_mux2_1
XFILLER_80_42 VDD VSS sg13g2_decap_8
XFILLER_74_1191 VDD VSS sg13g2_decap_8
XFILLER_35_1142 VDD VSS sg13g2_decap_8
XFILLER_156_901 VDD VSS sg13g2_decap_8
XFILLER_70_1033 VDD VSS sg13g2_fill_2
X_10605_ _10652_/A _14878_/Q _14877_/Q _14876_/Q _14875_/Q VDD VSS sg13g2_nand4_1
XFILLER_122_1123 VDD VSS sg13g2_decap_8
XFILLER_126_1292 VDD VSS sg13g2_fill_1
XFILLER_168_783 VDD VSS sg13g2_decap_8
X_14373_ _14373_/Q clkload18/A _14373_/D _14373_/RESET_B VDD VSS sg13g2_dfrbpq_1
X_14966__2644 _14966_/RESET_B VDD VSS sg13g2_tiehi
XFILLER_167_271 VDD VSS sg13g2_decap_8
X_11585_ _11585_/Y _11975_/A _11583_/X _11584_/Y VDD VSS sg13g2_o21ai_1
XFILLER_80_97 VDD VSS sg13g2_fill_1
XFILLER_11_995 VDD VSS sg13g2_decap_8
XFILLER_183_742 VDD VSS sg13g2_decap_8
XFILLER_6_410 VDD VSS sg13g2_decap_8
X_13324_ _15065_/D _13324_/A _13324_/B VDD VSS sg13g2_nor2_1
XFILLER_10_483 VDD VSS sg13g2_decap_8
XFILLER_156_978 VDD VSS sg13g2_decap_8
X_10536_ _10543_/D _14861_/Q _14860_/Q _14859_/Q _13218_/A VDD VSS sg13g2_and4_1
XFILLER_171_904 VDD VSS sg13g2_decap_8
XFILLER_7_966 VDD VSS sg13g2_decap_8
XFILLER_143_617 VDD VSS sg13g2_decap_8
XFILLER_171_926 VDD VSS sg13g2_decap_8
XFILLER_155_488 VDD VSS sg13g2_decap_8
XFILLER_182_263 VDD VSS sg13g2_decap_8
XFILLER_100_1443 VDD VSS sg13g2_decap_8
XFILLER_108_360 VDD VSS sg13g2_decap_4
X_13255_ _13255_/Y _14923_/Q _13664_/Q _13245_/X VDD VSS sg13g2_a21oi_1
XFILLER_124_820 VDD VSS sg13g2_decap_8
XFILLER_170_425 VDD VSS sg13g2_decap_4
X_14369__1833 _14369_/RESET_B VDD VSS sg13g2_tiehi
X_10467_ _10468_/C _10500_/A _10471_/C _10471_/D VDD VSS sg13g2_and3_1
XFILLER_6_487 VDD VSS sg13g2_decap_8
XFILLER_108_382 VDD VSS sg13g2_decap_8
XFILLER_108_393 VDD VSS sg13g2_fill_1
X_12206_ _12206_/X _14391_/Q _14423_/Q _14487_/Q _14519_/Q _12215_/S0 _12241_/B1 VDD
+ VSS sg13g2_mux4_1
XFILLER_135_190 VDD VSS sg13g2_decap_4
XFILLER_124_864 VDD VSS sg13g2_decap_8
X_13186_ _13186_/X _13189_/A _13189_/B _13225_/B VDD VSS sg13g2_a21o_1
X_10398_ _10400_/D _14820_/Q _14821_/Q _14822_/Q _10398_/D VDD VSS sg13g2_nand4_1
XFILLER_83_1438 VDD VSS sg13g2_decap_8
XFILLER_9_1029 VDD VSS sg13g2_decap_8
XFILLER_97_726 VDD VSS sg13g2_decap_8
XFILLER_123_374 VDD VSS sg13g2_decap_8
X_12137_ _12137_/X _14261_/Q _14293_/Q _14325_/Q _14357_/Q _12139_/S0 _12139_/S1 VDD
+ VSS sg13g2_mux4_1
XFILLER_46_1260 VDD VSS sg13g2_decap_8
XFILLER_2_693 VDD VSS sg13g2_decap_8
XFILLER_96_247 VDD VSS sg13g2_fill_2
XFILLER_78_951 VDD VSS sg13g2_decap_8
XFILLER_78_962 VDD VSS sg13g2_decap_8
X_12068_ _12068_/X _14387_/Q _14419_/Q _14483_/Q _14515_/Q _12135_/S0 _12135_/S1 VDD
+ VSS sg13g2_mux4_1
XFILLER_42_1135 VDD VSS sg13g2_decap_8
XFILLER_37_303 VDD VSS sg13g2_fill_1
X_11019_ _11019_/Y _11044_/C _11042_/D _11056_/B1 VDD VSS sg13g2_o21ai_1
XFILLER_133_1285 VDD VSS sg13g2_decap_8
XFILLER_133_1296 VDD VSS sg13g2_fill_1
X_16876_ _16876_/X _16876_/A VDD VSS sg13g2_buf_1
XFILLER_65_667 VDD VSS sg13g2_decap_8
XFILLER_80_604 VDD VSS sg13g2_decap_8
XFILLER_20_1466 VDD VSS sg13g2_decap_8
XFILLER_20_1477 VDD VSS sg13g2_fill_2
XFILLER_18_583 VDD VSS sg13g2_decap_8
XFILLER_127_1012 VDD VSS sg13g2_decap_8
X_13857__2345 _13857_/RESET_B VDD VSS sg13g2_tiehi
XFILLER_127_1023 VDD VSS sg13g2_fill_2
XFILLER_178_514 VDD VSS sg13g2_decap_8
X_14709_ _14709_/Q clkload37/A _14709_/D _14709_/RESET_B VDD VSS sg13g2_dfrbpq_1
XFILLER_127_1045 VDD VSS sg13g2_decap_8
X_08230_ _08230_/Y _08229_/B _08227_/Y _08229_/Y VDD VSS sg13g2_o21ai_1
XFILLER_147_901 VDD VSS sg13g2_decap_8
XFILLER_140_1201 VDD VSS sg13g2_decap_4
XFILLER_14_1226 VDD VSS sg13g2_decap_8
X_08161_ _08182_/C _08142_/C _08340_/A _07630_/A _08363_/S1 _08113_/Y VDD VSS sg13g2_a221oi_1
XFILLER_119_625 VDD VSS sg13g2_decap_8
XFILLER_147_934 VDD VSS sg13g2_decap_8
XFILLER_158_271 VDD VSS sg13g2_decap_4
XFILLER_179_1400 VDD VSS sg13g2_decap_8
XFILLER_53_1286 VDD VSS sg13g2_decap_8
XFILLER_88_1305 VDD VSS sg13g2_decap_8
XFILLER_101_1218 VDD VSS sg13g2_fill_1
XFILLER_105_1387 VDD VSS sg13g2_decap_8
XFILLER_119_658 VDD VSS sg13g2_decap_8
X_08092_ _08092_/Y _07879_/Y _08091_/Y _08499_/B1 VDD VSS sg13g2_o21ai_1
XFILLER_162_904 VDD VSS sg13g2_fill_2
XFILLER_109_39 VDD VSS sg13g2_decap_8
XFILLER_161_403 VDD VSS sg13g2_decap_8
XFILLER_179_1477 VDD VSS sg13g2_fill_2
Xclkload40 clkload40/X clkload40/A VDD VSS sg13g2_buf_8
XFILLER_118_179 VDD VSS sg13g2_decap_8
Xclkload51 clkload51/Y clkload51/A VDD VSS sg13g2_inv_1
XFILLER_162_948 VDD VSS sg13g2_decap_8
Xclkload62 clkload62/Y clkload62/A VDD VSS sg13g2_inv_1
Xclkload73 clkload73/Y clkload73/A VDD VSS sg13g2_inv_1
XFILLER_86_1040 VDD VSS sg13g2_decap_8
Xclkload84 clkload84/Y clkload84/A VDD VSS sg13g2_inv_2
XFILLER_138_1130 VDD VSS sg13g2_fill_2
XFILLER_115_864 VDD VSS sg13g2_decap_8
XFILLER_138_1141 VDD VSS sg13g2_fill_1
XFILLER_47_1035 VDD VSS sg13g2_fill_2
XFILLER_88_715 VDD VSS sg13g2_decap_4
XFILLER_88_726 VDD VSS sg13g2_decap_8
XFILLER_130_834 VDD VSS sg13g2_decap_8
XFILLER_138_1185 VDD VSS sg13g2_decap_8
XFILLER_125_38 VDD VSS sg13g2_decap_8
XFILLER_142_694 VDD VSS sg13g2_decap_8
X_08994_ _09011_/D _14899_/Q _12859_/A _10681_/A _10674_/A VDD VSS sg13g2_nand4_1
XFILLER_102_536 VDD VSS sg13g2_decap_4
XFILLER_134_1038 VDD VSS sg13g2_fill_2
X_15077__2864 _15077_/RESET_B VDD VSS sg13g2_tiehi
X_07945_ _07945_/Y _15006_/Q _07945_/B VDD VSS sg13g2_nand2b_1
XFILLER_116_1461 VDD VSS sg13g2_decap_8
XFILLER_64_1393 VDD VSS sg13g2_decap_8
XFILLER_60_1224 VDD VSS sg13g2_decap_8
XFILLER_84_910 VDD VSS sg13g2_fill_2
XFILLER_25_1355 VDD VSS sg13g2_decap_8
XFILLER_99_1423 VDD VSS sg13g2_decap_8
XFILLER_68_472 VDD VSS sg13g2_decap_4
XFILLER_56_612 VDD VSS sg13g2_fill_1
XFILLER_18_25 VDD VSS sg13g2_decap_8
XFILLER_5_1449 VDD VSS sg13g2_decap_8
X_07876_ _07876_/Y _07876_/A _07876_/B VDD VSS sg13g2_nand2_1
XFILLER_84_943 VDD VSS sg13g2_decap_8
XFILLER_56_634 VDD VSS sg13g2_decap_8
X_09615_ _14211_/D _09749_/A1 _14211_/Q _09632_/S VDD VSS sg13g2_mux2_1
XFILLER_55_144 VDD VSS sg13g2_decap_8
XFILLER_44_818 VDD VSS sg13g2_fill_2
XFILLER_186_1448 VDD VSS sg13g2_decap_8
XFILLER_83_475 VDD VSS sg13g2_fill_2
XFILLER_3_1173 VDD VSS sg13g2_decap_8
XFILLER_37_870 VDD VSS sg13g2_decap_4
X_13670__2555 _13670_/RESET_B VDD VSS sg13g2_tiehi
X_09546_ _14144_/D _09612_/A0 _14144_/Q _09566_/S VDD VSS sg13g2_mux2_1
XFILLER_145_1101 VDD VSS sg13g2_decap_8
XFILLER_93_1044 VDD VSS sg13g2_decap_8
X_14447__1755 _14447_/RESET_B VDD VSS sg13g2_tiehi
X_09477_ _14077_/D _10040_/A0 _14077_/Q _09505_/S VDD VSS sg13g2_mux2_1
XFILLER_58_1175 VDD VSS sg13g2_decap_8
XFILLER_51_350 VDD VSS sg13g2_fill_1
XFILLER_34_57 VDD VSS sg13g2_fill_1
XFILLER_24_586 VDD VSS sg13g2_decap_8
XFILLER_11_214 VDD VSS sg13g2_decap_8
X_14921__2725 _14921_/RESET_B VDD VSS sg13g2_tiehi
X_08428_ _08428_/X _08337_/X _08427_/X _08428_/S VDD VSS sg13g2_mux2_1
XFILLER_93_1099 VDD VSS sg13g2_decap_4
XFILLER_71_1320 VDD VSS sg13g2_decap_8
XFILLER_141_1009 VDD VSS sg13g2_fill_1
XFILLER_106_1129 VDD VSS sg13g2_decap_4
XFILLER_184_506 VDD VSS sg13g2_decap_8
XFILLER_123_1410 VDD VSS sg13g2_fill_2
Xclkload1 clkload1/X clkload1/A VDD VSS sg13g2_buf_8
X_08359_ _08373_/C _08415_/A _08359_/A2 _08668_/B _08359_/B2 _08358_/Y VDD VSS sg13g2_a221oi_1
XFILLER_137_411 VDD VSS sg13g2_decap_8
XFILLER_32_1337 VDD VSS sg13g2_decap_8
XFILLER_126_4 VDD VSS sg13g2_decap_8
XFILLER_149_293 VDD VSS sg13g2_decap_8
XFILLER_71_1397 VDD VSS sg13g2_decap_8
Xclkbuf_5_11__f_clk_i clkbuf_leaf_34_clk_i/A clkbuf_4_5_0_clk_i/X VDD VSS sg13g2_buf_16
X_13902__2300 _13902_/RESET_B VDD VSS sg13g2_tiehi
X_11370_ _11370_/Y _11373_/A _14110_/Q VDD VSS sg13g2_nand2b_1
X_14662__1540 _14662_/RESET_B VDD VSS sg13g2_tiehi
XFILLER_4_903 VDD VSS sg13g2_decap_8
XFILLER_166_56 VDD VSS sg13g2_decap_8
X_14954__2659 _14954_/RESET_B VDD VSS sg13g2_tiehi
X_10321_ _10323_/B _10342_/A _14799_/Q _14800_/Q _10342_/C VDD VSS sg13g2_nand4_1
XFILLER_125_639 VDD VSS sg13g2_decap_8
XFILLER_3_424 VDD VSS sg13g2_decap_8
XFILLER_106_842 VDD VSS sg13g2_decap_8
XFILLER_124_149 VDD VSS sg13g2_decap_8
X_13040_ _13042_/C _13057_/B _13057_/C VDD VSS sg13g2_nand2_1
XFILLER_105_330 VDD VSS sg13g2_fill_2
X_10252_ _10252_/Y _14779_/Q _10258_/D _10343_/C VDD VSS sg13g2_o21ai_1
XFILLER_59_21 VDD VSS sg13g2_fill_2
XFILLER_156_1241 VDD VSS sg13g2_decap_8
XFILLER_106_886 VDD VSS sg13g2_decap_8
XFILLER_182_11 VDD VSS sg13g2_decap_8
XFILLER_117_1214 VDD VSS sg13g2_decap_8
XFILLER_59_54 VDD VSS sg13g2_fill_1
XFILLER_117_1225 VDD VSS sg13g2_fill_1
XFILLER_156_1274 VDD VSS sg13g2_fill_2
X_10183_ _14748_/D _10173_/Y _10181_/Y _10182_/Y VDD VSS sg13g2_o21ai_1
XFILLER_160_480 VDD VSS sg13g2_decap_8
Xfanout1203 _13245_/A _14922_/Q VDD VSS sg13g2_buf_1
XFILLER_105_396 VDD VSS sg13g2_decap_8
XFILLER_152_1127 VDD VSS sg13g2_decap_4
Xfanout1214 _10681_/A _14897_/Q VDD VSS sg13g2_buf_1
XFILLER_65_1179 VDD VSS sg13g2_decap_8
XFILLER_121_867 VDD VSS sg13g2_fill_1
X_13935__2267 _13935_/RESET_B VDD VSS sg13g2_tiehi
Xfanout1225 _10504_/C _14846_/Q VDD VSS sg13g2_buf_1
XFILLER_117_1269 VDD VSS sg13g2_fill_1
Xfanout1236 _13613_/B _10179_/B VDD VSS sg13g2_buf_1
XFILLER_8_1040 VDD VSS sg13g2_decap_8
XFILLER_182_88 VDD VSS sg13g2_decap_8
X_14991_ _14991_/Q clkload54/A _14991_/D _14991_/RESET_B VDD VSS sg13g2_dfrbpq_1
Xfanout1247 _11559_/C _11625_/C VDD VSS sg13g2_buf_1
XFILLER_66_409 VDD VSS sg13g2_fill_1
X_15030__2580 _15030_/RESET_B VDD VSS sg13g2_tiehi
Xfanout260 _09752_/A1 _09032_/X VDD VSS sg13g2_buf_1
Xfanout1258 _11830_/B1 _11834_/A2 VDD VSS sg13g2_buf_1
Xfanout271 _09904_/S _09892_/S VDD VSS sg13g2_buf_1
Xfanout1269 _12219_/S _12237_/C VDD VSS sg13g2_buf_1
XFILLER_43_1455 VDD VSS sg13g2_decap_8
Xfanout282 _09438_/S fanout284/X VDD VSS sg13g2_buf_1
X_13942_ _13942_/Q clkload68/A _13942_/D _13942_/RESET_B VDD VSS sg13g2_dfrbpq_1
XFILLER_93_228 VDD VSS sg13g2_decap_8
Xfanout293 _09583_/A1 _09019_/Y VDD VSS sg13g2_buf_1
XFILLER_130_1447 VDD VSS sg13g2_fill_2
XFILLER_90_902 VDD VSS sg13g2_decap_8
XFILLER_19_369 VDD VSS sg13g2_decap_8
X_13873_ _13873_/Q _14417_/CLK _13873_/D _13873_/RESET_B VDD VSS sg13g2_dfrbpq_1
XFILLER_75_998 VDD VSS sg13g2_fill_1
XFILLER_74_464 VDD VSS sg13g2_decap_8
X_12824_ _15022_/D _13087_/A _12824_/B VDD VSS sg13g2_nor2_1
XFILLER_128_1310 VDD VSS sg13g2_fill_2
XFILLER_131_81 VDD VSS sg13g2_fill_1
XFILLER_128_1332 VDD VSS sg13g2_decap_8
XFILLER_131_92 VDD VSS sg13g2_decap_8
XFILLER_163_1212 VDD VSS sg13g2_decap_8
XFILLER_167_1381 VDD VSS sg13g2_decap_8
X_12755_ _12755_/X _14264_/Q _14296_/Q _14328_/Q _14360_/Q _12759_/S0 _12759_/S1 VDD
+ VSS sg13g2_mux4_1
XFILLER_76_1275 VDD VSS sg13g2_decap_8
XFILLER_128_1354 VDD VSS sg13g2_decap_8
X_11706_ _11773_/C _14971_/Q _13679_/Q VDD VSS sg13g2_xnor2_1
XFILLER_72_1139 VDD VSS sg13g2_decap_8
XFILLER_70_681 VDD VSS sg13g2_decap_8
XFILLER_37_1259 VDD VSS sg13g2_decap_8
XFILLER_128_1387 VDD VSS sg13g2_decap_8
XFILLER_42_383 VDD VSS sg13g2_decap_4
X_12686_ _12686_/X _13843_/Q _13875_/Q _13907_/Q _13939_/Q _12686_/S0 _12686_/S1 VDD
+ VSS sg13g2_mux4_1
XFILLER_163_1289 VDD VSS sg13g2_decap_8
X_14425_ _14425_/Q clkload45/A _14425_/D _14425_/RESET_B VDD VSS sg13g2_dfrbpq_1
XFILLER_175_539 VDD VSS sg13g2_fill_1
X_11637_ _11776_/A _11638_/C _11637_/B VDD VSS sg13g2_nor2_1
XFILLER_129_934 VDD VSS sg13g2_decap_8
XFILLER_156_720 VDD VSS sg13g2_decap_8
XFILLER_128_422 VDD VSS sg13g2_decap_8
X_14356_ _14356_/Q clkload15/A _14356_/D _14356_/RESET_B VDD VSS sg13g2_dfrbpq_1
XFILLER_10_280 VDD VSS sg13g2_decap_8
X_11568_ _11571_/C _11502_/A _13685_/Q _12942_/B _14966_/Q _11505_/X VDD VSS sg13g2_a221oi_1
XFILLER_7_763 VDD VSS sg13g2_decap_8
X_13307_ _13307_/Y _13307_/A _13307_/B VDD VSS sg13g2_nor2_1
XFILLER_115_105 VDD VSS sg13g2_fill_2
XFILLER_171_723 VDD VSS sg13g2_fill_1
X_10519_ _14855_/D _10595_/B _10519_/B _10519_/C VDD VSS sg13g2_nor3_1
XFILLER_128_499 VDD VSS sg13g2_decap_8
X_14287_ _14287_/Q clkload40/A _14287_/D _14287_/RESET_B VDD VSS sg13g2_dfrbpq_1
XFILLER_13_1292 VDD VSS sg13g2_decap_8
X_11499_ _11499_/Y _14901_/Q _11792_/B _11722_/B2 VDD VSS sg13g2_a21oi_1
XFILLER_48_1300 VDD VSS sg13g2_decap_8
XFILLER_6_284 VDD VSS sg13g2_decap_8
X_13238_ _13239_/B _13265_/A1 _13233_/X _13232_/Y _13307_/A _13237_/Y VDD VSS sg13g2_a221oi_1
XFILLER_112_801 VDD VSS sg13g2_fill_2
XFILLER_112_812 VDD VSS sg13g2_fill_1
XFILLER_83_1235 VDD VSS sg13g2_decap_8
XFILLER_152_981 VDD VSS sg13g2_fill_2
XFILLER_111_300 VDD VSS sg13g2_decap_8
XFILLER_112_834 VDD VSS sg13g2_fill_1
XFILLER_124_694 VDD VSS sg13g2_decap_8
X_13169_ _13169_/Y _13170_/C _13170_/D VDD VSS sg13g2_nor2_1
XFILLER_48_1377 VDD VSS sg13g2_decap_8
XFILLER_123_171 VDD VSS sg13g2_decap_8
XFILLER_174_1385 VDD VSS sg13g2_decap_8
XFILLER_3_991 VDD VSS sg13g2_decap_8
XFILLER_2_490 VDD VSS sg13g2_decap_8
XFILLER_111_344 VDD VSS sg13g2_decap_8
XFILLER_170_1249 VDD VSS sg13g2_decap_8
XFILLER_97_567 VDD VSS sg13g2_decap_8
XFILLER_135_1369 VDD VSS sg13g2_fill_1
X_14525__1677 _14525_/RESET_B VDD VSS sg13g2_tiehi
XFILLER_66_921 VDD VSS sg13g2_decap_4
X_07730_ _07734_/B _15078_/Q _15084_/Q _15085_/Q _15081_/Q VDD VSS sg13g2_nor4_1
XFILLER_65_420 VDD VSS sg13g2_decap_8
XFILLER_93_740 VDD VSS sg13g2_decap_8
XFILLER_168_1101 VDD VSS sg13g2_decap_8
X_14779__2957 _14779_/RESET_B VDD VSS sg13g2_tiehi
XFILLER_81_902 VDD VSS sg13g2_decap_4
X_07661_ _07661_/Y _07766_/B VDD VSS sg13g2_inv_1
XFILLER_66_987 VDD VSS sg13g2_fill_2
X_16859_ _16859_/X _16859_/A VDD VSS sg13g2_buf_1
X_09400_ _14003_/D _10062_/A0 _14003_/Q _09405_/S VDD VSS sg13g2_mux2_1
XFILLER_0_1324 VDD VSS sg13g2_decap_8
XFILLER_129_1118 VDD VSS sg13g2_fill_1
XFILLER_168_1167 VDD VSS sg13g2_decap_8
XFILLER_20_1263 VDD VSS sg13g2_decap_8
XFILLER_94_1320 VDD VSS sg13g2_decap_8
X_14740__1462 _14740_/RESET_B VDD VSS sg13g2_tiehi
XFILLER_80_434 VDD VSS sg13g2_decap_8
XFILLER_37_199 VDD VSS sg13g2_decap_8
XFILLER_25_339 VDD VSS sg13g2_decap_8
XFILLER_179_801 VDD VSS sg13g2_fill_1
XFILLER_179_823 VDD VSS sg13g2_decap_8
X_09331_ _13938_/D _10161_/A1 _13938_/Q _09337_/S VDD VSS sg13g2_mux2_1
XFILLER_178_311 VDD VSS sg13g2_decap_8
XFILLER_181_1323 VDD VSS sg13g2_decap_8
XFILLER_34_884 VDD VSS sg13g2_decap_8
XFILLER_61_670 VDD VSS sg13g2_decap_8
XFILLER_179_867 VDD VSS sg13g2_decap_8
XFILLER_61_681 VDD VSS sg13g2_fill_1
X_09262_ _13871_/D _13871_/Q _09827_/A0 _09272_/S VDD VSS sg13g2_mux2_1
XFILLER_107_1438 VDD VSS sg13g2_decap_8
XFILLER_178_355 VDD VSS sg13g2_decap_4
XFILLER_179_878 VDD VSS sg13g2_fill_1
XFILLER_166_506 VDD VSS sg13g2_decap_8
X_08213_ _08374_/B _08121_/X _08124_/X _08621_/B VDD VSS sg13g2_mux2_1
XFILLER_119_400 VDD VSS sg13g2_decap_8
X_09193_ _13809_/D _13809_/Q _10160_/A1 _09200_/S VDD VSS sg13g2_mux2_1
XFILLER_14_1023 VDD VSS sg13g2_decap_8
XFILLER_105_1151 VDD VSS sg13g2_fill_1
XFILLER_105_1162 VDD VSS sg13g2_decap_8
X_08144_ _08145_/C _08110_/D _08138_/X _08463_/B _08359_/B2 _08143_/Y VDD VSS sg13g2_a221oi_1
XFILLER_162_712 VDD VSS sg13g2_decap_4
XFILLER_135_937 VDD VSS sg13g2_fill_2
XFILLER_31_1370 VDD VSS sg13g2_decap_8
XFILLER_119_499 VDD VSS sg13g2_decap_8
XFILLER_179_1274 VDD VSS sg13g2_decap_8
X_08075_ _08075_/Y _07900_/B _08422_/S _08074_/C _08074_/B VDD VSS sg13g2_a22oi_1
XFILLER_106_138 VDD VSS sg13g2_decap_8
XFILLER_162_756 VDD VSS sg13g2_decap_8
XFILLER_106_149 VDD VSS sg13g2_fill_2
XFILLER_150_918 VDD VSS sg13g2_decap_8
XFILLER_1_917 VDD VSS sg13g2_decap_8
XFILLER_88_501 VDD VSS sg13g2_decap_8
XFILLER_143_992 VDD VSS sg13g2_decap_8
XFILLER_153_1414 VDD VSS sg13g2_decap_8
XFILLER_66_1466 VDD VSS sg13g2_decap_8
XFILLER_0_427 VDD VSS sg13g2_decap_8
XFILLER_161_299 VDD VSS sg13g2_decap_8
XFILLER_66_1477 VDD VSS sg13g2_fill_2
XFILLER_27_1439 VDD VSS sg13g2_decap_8
XFILLER_76_707 VDD VSS sg13g2_decap_8
XFILLER_103_878 VDD VSS sg13g2_decap_8
XFILLER_29_35 VDD VSS sg13g2_fill_1
X_08977_ _08977_/Y _09141_/A _08977_/B _08977_/C VDD VSS sg13g2_nand3_1
XFILLER_9_1360 VDD VSS sg13g2_decap_8
XFILLER_64_1190 VDD VSS sg13g2_decap_8
XFILLER_25_1152 VDD VSS sg13g2_decap_8
XFILLER_116_1280 VDD VSS sg13g2_decap_8
X_07928_ _07928_/Y _07923_/Y _07925_/Y _07797_/X VDD VSS sg13g2_a21oi_1
XFILLER_69_792 VDD VSS sg13g2_fill_1
XFILLER_112_1122 VDD VSS sg13g2_decap_8
XFILLER_5_1246 VDD VSS sg13g2_decap_8
XFILLER_151_1193 VDD VSS sg13g2_decap_4
XFILLER_112_1166 VDD VSS sg13g2_decap_8
X_07859_ _08641_/C _15014_/Q _12084_/A VDD VSS sg13g2_xnor2_1
XFILLER_95_1106 VDD VSS sg13g2_decap_8
XFILLER_44_604 VDD VSS sg13g2_decap_8
XFILLER_29_678 VDD VSS sg13g2_decap_4
XFILLER_72_924 VDD VSS sg13g2_decap_8
XFILLER_71_401 VDD VSS sg13g2_decap_8
XFILLER_186_1245 VDD VSS sg13g2_decap_8
XFILLER_84_795 VDD VSS sg13g2_decap_8
XFILLER_43_103 VDD VSS sg13g2_decap_8
XFILLER_56_497 VDD VSS sg13g2_fill_2
X_10870_ _10897_/B _10870_/A _10871_/A VDD VSS sg13g2_nand2_1
XFILLER_83_294 VDD VSS sg13g2_fill_1
XFILLER_45_78 VDD VSS sg13g2_fill_2
X_09529_ _14128_/D _09762_/A1 _14128_/Q _09533_/S VDD VSS sg13g2_mux2_1
XFILLER_31_309 VDD VSS sg13g2_decap_8
XFILLER_73_1437 VDD VSS sg13g2_decap_8
X_12540_ _12541_/B _13680_/Q _12596_/A2 _12539_/X _12415_/A _12596_/C1 VDD VSS sg13g2_a221oi_1
X_14824__2912 _14824_/RESET_B VDD VSS sg13g2_tiehi
XFILLER_40_843 VDD VSS sg13g2_decap_8
XFILLER_185_815 VDD VSS sg13g2_decap_8
XFILLER_129_208 VDD VSS sg13g2_decap_8
XFILLER_12_556 VDD VSS sg13g2_decap_8
XFILLER_177_11 VDD VSS sg13g2_decap_8
XFILLER_184_303 VDD VSS sg13g2_decap_8
XFILLER_169_388 VDD VSS sg13g2_decap_4
X_12471_ _14997_/D _12471_/A _12471_/B VDD VSS sg13g2_nor2_1
XFILLER_40_898 VDD VSS sg13g2_decap_8
XFILLER_36_1292 VDD VSS sg13g2_decap_8
X_14210_ _14210_/Q _14722_/CLK _14210_/D _14210_/RESET_B VDD VSS sg13g2_dfrbpq_1
XFILLER_32_1134 VDD VSS sg13g2_decap_8
X_11422_ _11422_/Y _11422_/A _11422_/B VDD VSS sg13g2_nand2_1
XFILLER_71_1194 VDD VSS sg13g2_decap_8
X_14603__1599 _14603_/RESET_B VDD VSS sg13g2_tiehi
X_15161__2658 _15161_/RESET_B VDD VSS sg13g2_tiehi
X_15190_ _15190_/Q _15212_/CLK _15190_/D _15190_/RESET_B VDD VSS sg13g2_dfrbpq_1
XFILLER_137_241 VDD VSS sg13g2_decap_8
XFILLER_177_88 VDD VSS sg13g2_decap_8
XFILLER_6_39 VDD VSS sg13g2_decap_8
XFILLER_4_700 VDD VSS sg13g2_decap_8
XFILLER_117_0 VDD VSS sg13g2_decap_8
X_14141_ _14141_/Q clkload29/A _14141_/D _14141_/RESET_B VDD VSS sg13g2_dfrbpq_1
XFILLER_10_1421 VDD VSS sg13g2_decap_8
X_11353_ _11353_/X _14558_/Q _14590_/Q _11365_/A VDD VSS sg13g2_mux2_1
XFILLER_152_222 VDD VSS sg13g2_decap_8
XFILLER_180_531 VDD VSS sg13g2_decap_4
XFILLER_153_756 VDD VSS sg13g2_fill_1
XFILLER_158_1347 VDD VSS sg13g2_decap_8
XFILLER_153_767 VDD VSS sg13g2_decap_4
X_10304_ _10311_/C _14794_/Q _14795_/Q VDD VSS sg13g2_and2_1
XFILLER_3_221 VDD VSS sg13g2_decap_8
X_14072_ _14072_/Q _14514_/CLK _14072_/D _14072_/RESET_B VDD VSS sg13g2_dfrbpq_1
X_11284_ _11285_/A _11281_/Y _11283_/Y _12174_/A VDD VSS sg13g2_a21oi_1
XFILLER_98_309 VDD VSS sg13g2_fill_1
XFILLER_4_777 VDD VSS sg13g2_decap_8
XFILLER_10_70 VDD VSS sg13g2_decap_8
X_13023_ _13057_/A _14908_/Q _13679_/Q VDD VSS sg13g2_xor2_1
XFILLER_134_992 VDD VSS sg13g2_fill_2
X_10235_ _10235_/Y _07638_/Y _10232_/B _10322_/C VDD VSS sg13g2_o21ai_1
XFILLER_80_1419 VDD VSS sg13g2_decap_8
XFILLER_3_298 VDD VSS sg13g2_decap_8
Xfanout1000 _13279_/B _15070_/Q VDD VSS sg13g2_buf_1
XFILLER_105_193 VDD VSS sg13g2_fill_1
Xfanout1011 _09938_/C _10137_/A VDD VSS sg13g2_buf_1
XFILLER_79_556 VDD VSS sg13g2_fill_1
XFILLER_117_1055 VDD VSS sg13g2_fill_2
Xfanout1022 _09147_/B _09161_/S VDD VSS sg13g2_buf_1
X_14898__2771 _14898_/RESET_B VDD VSS sg13g2_tiehi
Xfanout1033 _13446_/A1 _13412_/B VDD VSS sg13g2_buf_1
X_10166_ _14743_/D _14743_/Q _10166_/A1 _10167_/S VDD VSS sg13g2_mux2_1
XFILLER_120_152 VDD VSS sg13g2_decap_8
XFILLER_121_686 VDD VSS sg13g2_fill_2
Xfanout1044 _08456_/C _15007_/Q VDD VSS sg13g2_buf_1
Xfanout1055 _08483_/A1 _12403_/B1 VDD VSS sg13g2_buf_1
Xfanout1066 _08599_/A _08356_/A1 VDD VSS sg13g2_buf_1
XFILLER_94_537 VDD VSS sg13g2_decap_8
XFILLER_43_1252 VDD VSS sg13g2_decap_8
XFILLER_120_185 VDD VSS sg13g2_fill_1
Xfanout1077 _08196_/A1 _13525_/A VDD VSS sg13g2_buf_1
XFILLER_66_239 VDD VSS sg13g2_decap_8
X_14974_ _14974_/Q clkload25/A _14974_/D _14974_/RESET_B VDD VSS sg13g2_dfrbpq_1
Xfanout1088 _08669_/B1 _07627_/A VDD VSS sg13g2_buf_1
X_10097_ _14677_/D _10097_/A0 _14677_/Q _10101_/S VDD VSS sg13g2_mux2_1
XFILLER_19_133 VDD VSS sg13g2_decap_8
Xfanout1099 _08054_/B _08686_/S0 VDD VSS sg13g2_buf_1
XFILLER_47_442 VDD VSS sg13g2_decap_8
XFILLER_63_902 VDD VSS sg13g2_fill_2
X_13925_ _13925_/Q _14728_/CLK _13925_/D _13925_/RESET_B VDD VSS sg13g2_dfrbpq_1
XFILLER_19_177 VDD VSS sg13g2_decap_8
XFILLER_130_1299 VDD VSS sg13g2_fill_2
X_13856_ _13856_/Q clkload23/A _13856_/D _13856_/RESET_B VDD VSS sg13g2_dfrbpq_1
XFILLER_78_1359 VDD VSS sg13g2_decap_8
XFILLER_35_648 VDD VSS sg13g2_decap_8
XFILLER_165_1329 VDD VSS sg13g2_decap_8
X_12807_ _12807_/Y _14799_/Q _12851_/B _12879_/B _14831_/Q _12930_/C1 VDD VSS sg13g2_a221oi_1
X_13787_ _13787_/Q clkload79/A _13787_/D _13787_/RESET_B VDD VSS sg13g2_dfrbpq_1
X_10999_ _10999_/X _10995_/B _11045_/A2 _11045_/B1 VDD VSS sg13g2_a21o_1
XFILLER_31_810 VDD VSS sg13g2_decap_8
XFILLER_76_1094 VDD VSS sg13g2_decap_4
X_12738_ _12738_/X _14583_/Q _14615_/Q _14647_/Q _14679_/Q _12756_/S0 _12756_/S1 VDD
+ VSS sg13g2_mux4_1
XFILLER_128_1184 VDD VSS sg13g2_decap_8
XFILLER_30_331 VDD VSS sg13g2_decap_8
XFILLER_163_1086 VDD VSS sg13g2_decap_8
XFILLER_89_4 VDD VSS sg13g2_decap_8
X_12669_ _12669_/X _14386_/Q _14418_/Q _14482_/Q _14514_/Q _12759_/S0 _12759_/S1 VDD
+ VSS sg13g2_mux4_1
XFILLER_54_1381 VDD VSS sg13g2_decap_8
XFILLER_106_1460 VDD VSS sg13g2_decap_8
X_14408_ _14408_/Q clkload21/A _14408_/D _14408_/RESET_B VDD VSS sg13g2_dfrbpq_1
XFILLER_89_1411 VDD VSS sg13g2_decap_8
XFILLER_128_241 VDD VSS sg13g2_decap_8
XFILLER_156_550 VDD VSS sg13g2_decap_8
XFILLER_15_1376 VDD VSS sg13g2_decap_8
XFILLER_144_701 VDD VSS sg13g2_decap_8
XFILLER_50_1267 VDD VSS sg13g2_decap_8
XFILLER_117_926 VDD VSS sg13g2_decap_8
XFILLER_102_1346 VDD VSS sg13g2_decap_8
XFILLER_156_572 VDD VSS sg13g2_decap_4
XFILLER_7_560 VDD VSS sg13g2_decap_8
X_14339_ _14339_/Q clkload17/A _14339_/D _14339_/RESET_B VDD VSS sg13g2_dfrbpq_1
XFILLER_144_756 VDD VSS sg13g2_decap_8
XFILLER_176_1436 VDD VSS sg13g2_decap_8
XFILLER_116_458 VDD VSS sg13g2_decap_8
XFILLER_137_1409 VDD VSS sg13g2_decap_8
XFILLER_171_553 VDD VSS sg13g2_decap_8
XFILLER_125_970 VDD VSS sg13g2_fill_2
XFILLER_103_119 VDD VSS sg13g2_fill_1
X_08900_ _08900_/Y _08900_/A1 _08900_/A2 _08899_/Y VDD VSS sg13g2_a21oi_1
XFILLER_171_597 VDD VSS sg13g2_fill_1
XFILLER_106_18 VDD VSS sg13g2_decap_8
XFILLER_135_1111 VDD VSS sg13g2_decap_8
XFILLER_139_1280 VDD VSS sg13g2_fill_2
X_09880_ _14466_/D _09913_/A1 _14466_/Q _09894_/S VDD VSS sg13g2_mux2_1
XFILLER_48_1174 VDD VSS sg13g2_decap_8
XFILLER_174_1182 VDD VSS sg13g2_decap_8
XFILLER_32_0 VDD VSS sg13g2_decap_8
X_08831_ _08831_/Y _13283_/A _11241_/C VDD VSS sg13g2_nor2_1
XFILLER_170_1035 VDD VSS sg13g2_fill_2
XFILLER_44_1038 VDD VSS sg13g2_fill_2
XFILLER_58_729 VDD VSS sg13g2_decap_8
XFILLER_100_826 VDD VSS sg13g2_decap_8
XFILLER_61_1330 VDD VSS sg13g2_decap_8
X_08762_ _13672_/D _08765_/A1 _08760_/Y _08761_/Y VDD VSS sg13g2_a21oi_1
XFILLER_22_1314 VDD VSS sg13g2_decap_8
X_07713_ _07740_/A _07713_/A _07748_/B VDD VSS sg13g2_nor2b_1
XFILLER_39_976 VDD VSS sg13g2_decap_8
X_08693_ _08693_/Y _08693_/A _08693_/B _08693_/C VDD VSS sg13g2_nand3_1
XFILLER_65_261 VDD VSS sg13g2_decap_8
XFILLER_53_401 VDD VSS sg13g2_decap_8
XFILLER_96_1448 VDD VSS sg13g2_decap_8
XFILLER_26_637 VDD VSS sg13g2_decap_8
X_07644_ _10297_/A _14790_/Q VDD VSS sg13g2_inv_1
XFILLER_0_1121 VDD VSS sg13g2_decap_8
XFILLER_183_1407 VDD VSS sg13g2_decap_8
XFILLER_53_445 VDD VSS sg13g2_fill_1
XFILLER_25_136 VDD VSS sg13g2_fill_1
XFILLER_81_776 VDD VSS sg13g2_fill_1
XFILLER_20_1093 VDD VSS sg13g2_decap_4
XFILLER_53_478 VDD VSS sg13g2_decap_8
XFILLER_80_275 VDD VSS sg13g2_fill_1
XFILLER_181_1120 VDD VSS sg13g2_decap_8
XFILLER_40_117 VDD VSS sg13g2_decap_4
XFILLER_0_1198 VDD VSS sg13g2_decap_8
X_09314_ _13921_/D _10144_/A1 _13921_/Q _09329_/S VDD VSS sg13g2_mux2_1
XFILLER_34_681 VDD VSS sg13g2_decap_8
XFILLER_107_1224 VDD VSS sg13g2_decap_4
XFILLER_167_815 VDD VSS sg13g2_decap_8
XFILLER_55_1167 VDD VSS sg13g2_decap_8
XFILLER_146_1295 VDD VSS sg13g2_decap_4
X_09245_ _13854_/D _13854_/Q _09744_/A1 _09259_/S VDD VSS sg13g2_mux2_1
XFILLER_90_1069 VDD VSS sg13g2_decap_8
XFILLER_181_1197 VDD VSS sg13g2_decap_8
XFILLER_166_336 VDD VSS sg13g2_decap_8
XFILLER_167_859 VDD VSS sg13g2_fill_1
XFILLER_107_1279 VDD VSS sg13g2_decap_8
XFILLER_31_14 VDD VSS sg13g2_decap_8
XFILLER_33_1443 VDD VSS sg13g2_decap_8
XFILLER_120_1402 VDD VSS sg13g2_decap_4
XFILLER_147_550 VDD VSS sg13g2_fill_1
X_09176_ _13792_/D _13792_/Q _10143_/A1 _09189_/S VDD VSS sg13g2_mux2_1
XFILLER_107_403 VDD VSS sg13g2_decap_4
X_08127_ _08463_/B _08212_/A _08122_/Y _08126_/Y VDD VSS sg13g2_o21ai_1
XFILLER_110_7 VDD VSS sg13g2_decap_4
XFILLER_179_1071 VDD VSS sg13g2_decap_8
XFILLER_147_69 VDD VSS sg13g2_decap_8
XFILLER_123_907 VDD VSS sg13g2_fill_2
XFILLER_135_767 VDD VSS sg13g2_decap_8
X_08058_ _08058_/X _08044_/X _08052_/Y _08042_/X _08167_/B _08241_/A _08452_/D VDD
+ VSS sg13g2_mux4_1
XFILLER_134_277 VDD VSS sg13g2_fill_1
XFILLER_1_714 VDD VSS sg13g2_decap_8
Xoutput47 mem_axi_araddr[18] _16871_/A VDD VSS sg13g2_buf_1
Xoutput58 mem_axi_araddr[29] _16882_/A VDD VSS sg13g2_buf_1
XFILLER_115_480 VDD VSS sg13g2_decap_4
XFILLER_118_1331 VDD VSS sg13g2_decap_8
Xoutput69 mem_axi_arprot[2] _16854_/X VDD VSS sg13g2_buf_1
XFILLER_66_1263 VDD VSS sg13g2_decap_8
XFILLER_0_224 VDD VSS sg13g2_decap_8
XFILLER_103_631 VDD VSS sg13g2_decap_8
XFILLER_163_35 VDD VSS sg13g2_decap_8
Xhold3130 _13639_/A _13747_/Q VDD VSS sg13g2_dlygate4sd3_1
XFILLER_118_1353 VDD VSS sg13g2_decap_8
XFILLER_27_1236 VDD VSS sg13g2_decap_8
Xhold3141 _13642_/A _13750_/Q VDD VSS sg13g2_dlygate4sd3_1
X_10020_ _14602_/D _10086_/A0 _14602_/Q _10024_/S VDD VSS sg13g2_mux2_1
Xhold3152 _13535_/A _15144_/Q VDD VSS sg13g2_dlygate4sd3_1
XFILLER_88_353 VDD VSS sg13g2_decap_8
XFILLER_62_1138 VDD VSS sg13g2_decap_8
Xhold3163 hold3163/X _14894_/Q VDD VSS sg13g2_dlygate4sd3_1
XFILLER_103_675 VDD VSS sg13g2_decap_8
Xhold3174 hold3174/X _15179_/Q VDD VSS sg13g2_dlygate4sd3_1
XFILLER_103_686 VDD VSS sg13g2_fill_2
XFILLER_118_1397 VDD VSS sg13g2_decap_4
X_14017__2185 _14017_/RESET_B VDD VSS sg13g2_tiehi
XFILLER_88_397 VDD VSS sg13g2_decap_4
XFILLER_40_1403 VDD VSS sg13g2_decap_8
X_13852__2350 _13852_/RESET_B VDD VSS sg13g2_tiehi
XFILLER_57_740 VDD VSS sg13g2_fill_2
XFILLER_5_1043 VDD VSS sg13g2_decap_8
X_11971_ _11971_/Y _11971_/A _11971_/B _11971_/C VDD VSS sg13g2_nand3_1
XFILLER_57_773 VDD VSS sg13g2_decap_8
XFILLER_56_250 VDD VSS sg13g2_decap_8
XFILLER_45_924 VDD VSS sg13g2_decap_8
XFILLER_29_475 VDD VSS sg13g2_decap_8
X_13710_ _16872_/A clkload56/A _13710_/D _13710_/RESET_B VDD VSS sg13g2_dfrbpq_1
X_10922_ _10926_/A _10920_/A _10920_/B _10921_/Y VDD VSS sg13g2_a21o_1
X_14690_ _14690_/Q _14722_/CLK _14690_/D _14690_/RESET_B VDD VSS sg13g2_dfrbpq_1
XFILLER_45_957 VDD VSS sg13g2_decap_8
XFILLER_186_1064 VDD VSS sg13g2_decap_8
X_14196__2006 _14196_/RESET_B VDD VSS sg13g2_tiehi
XFILLER_72_765 VDD VSS sg13g2_decap_8
X_13641_ _13749_/D _13641_/A VDD VSS sg13g2_buf_1
X_10853_ _10857_/A _14751_/Q _10851_/C _10841_/Y VDD VSS sg13g2_a21o_1
XFILLER_38_1321 VDD VSS sg13g2_decap_8
XFILLER_147_1059 VDD VSS sg13g2_decap_8
XFILLER_71_286 VDD VSS sg13g2_fill_2
XFILLER_169_130 VDD VSS sg13g2_fill_2
XFILLER_73_1234 VDD VSS sg13g2_decap_8
X_13572_ _13572_/Y _13572_/A _13593_/B VDD VSS sg13g2_nor2_1
X_10784_ _14922_/D _11168_/B1 _11164_/C _10783_/Y VDD VSS sg13g2_o21ai_1
XFILLER_184_100 VDD VSS sg13g2_decap_8
XFILLER_185_623 VDD VSS sg13g2_decap_8
X_12523_ _12523_/X _12522_/X _12521_/X _12518_/X _12517_/X _12649_/S0 _12455_/S VDD
+ VSS sg13g2_mux4_1
XFILLER_38_1398 VDD VSS sg13g2_decap_8
XFILLER_34_1229 VDD VSS sg13g2_decap_8
XFILLER_12_364 VDD VSS sg13g2_decap_8
XFILLER_157_336 VDD VSS sg13g2_fill_2
XFILLER_160_1248 VDD VSS sg13g2_decap_8
XFILLER_9_847 VDD VSS sg13g2_decap_8
X_15242_ _15242_/Q clkload48/A _15242_/D _15242_/RESET_B VDD VSS sg13g2_dfrbpq_1
X_12454_ _12454_/X _12446_/X _12450_/X _12445_/X _12449_/X _12650_/S _12649_/S0 VDD
+ VSS sg13g2_mux4_1
XFILLER_185_689 VDD VSS sg13g2_decap_8
XFILLER_126_701 VDD VSS sg13g2_decap_8
XFILLER_8_368 VDD VSS sg13g2_decap_8
XFILLER_166_881 VDD VSS sg13g2_decap_8
XFILLER_172_317 VDD VSS sg13g2_decap_8
XFILLER_184_177 VDD VSS sg13g2_decap_8
X_11405_ _11405_/Y _11396_/Y _11830_/B1 _11625_/C VDD VSS sg13g2_a21oi_1
X_15173_ _15173_/Q clkload82/A _15173_/D _15173_/RESET_B VDD VSS sg13g2_dfrbpq_1
X_12385_ _12386_/B _12383_/X _12384_/X _12776_/S VDD VSS sg13g2_mux2_1
XFILLER_126_745 VDD VSS sg13g2_decap_8
XFILLER_67_1016 VDD VSS sg13g2_decap_4
XFILLER_181_862 VDD VSS sg13g2_fill_2
X_14124_ _14124_/Q clkload53/A _14124_/D _14124_/RESET_B VDD VSS sg13g2_dfrbpq_1
X_11336_ _11339_/A _11336_/A _11335_/X VDD VSS sg13g2_nor2b_1
X_14227__1975 _14227_/RESET_B VDD VSS sg13g2_tiehi
XFILLER_67_1049 VDD VSS sg13g2_fill_1
XFILLER_84_1330 VDD VSS sg13g2_decap_8
XFILLER_4_574 VDD VSS sg13g2_decap_8
XFILLER_49_1450 VDD VSS sg13g2_decap_8
XFILLER_141_737 VDD VSS sg13g2_decap_8
XFILLER_10_1295 VDD VSS sg13g2_decap_8
X_14055_ _14055_/Q clkload12/A _14055_/D _14055_/RESET_B VDD VSS sg13g2_dfrbpq_1
XFILLER_180_394 VDD VSS sg13g2_decap_4
X_11267_ _11267_/Y _11263_/Y _11264_/X _11266_/Y VDD VSS sg13g2_o21ai_1
XFILLER_122_940 VDD VSS sg13g2_decap_8
XFILLER_171_1322 VDD VSS sg13g2_decap_8
XFILLER_79_331 VDD VSS sg13g2_decap_8
X_13006_ _13058_/A _14907_/Q _13680_/Q VDD VSS sg13g2_or2_1
XFILLER_140_269 VDD VSS sg13g2_fill_2
X_10218_ _14767_/D _14767_/Q _10435_/A VDD VSS sg13g2_nor2_1
XFILLER_97_84 VDD VSS sg13g2_decap_8
XFILLER_45_1347 VDD VSS sg13g2_decap_8
XFILLER_67_504 VDD VSS sg13g2_fill_2
X_11198_ _11201_/A _11177_/B _11177_/C _11197_/X VDD VSS sg13g2_o21ai_1
XFILLER_80_1249 VDD VSS sg13g2_decap_8
XFILLER_171_1399 VDD VSS sg13g2_decap_8
X_10149_ _14726_/D _14726_/Q _10149_/A1 _10163_/S VDD VSS sg13g2_mux2_1
X_14442__1760 _14442_/RESET_B VDD VSS sg13g2_tiehi
XFILLER_43_1071 VDD VSS sg13g2_decap_8
X_14957_ _14957_/Q clkload73/A _14957_/D _14957_/RESET_B VDD VSS sg13g2_dfrbpq_1
XFILLER_63_710 VDD VSS sg13g2_decap_8
XFILLER_48_795 VDD VSS sg13g2_fill_2
XFILLER_47_283 VDD VSS sg13g2_decap_4
XFILLER_35_423 VDD VSS sg13g2_decap_8
X_13908_ _13908_/Q clkload14/A _13908_/D _13908_/RESET_B VDD VSS sg13g2_dfrbpq_1
XFILLER_78_1156 VDD VSS sg13g2_decap_8
XFILLER_62_220 VDD VSS sg13g2_decap_8
XFILLER_169_1273 VDD VSS sg13g2_decap_8
X_14888_ _14888_/Q clkload88/A _14888_/D _14888_/RESET_B VDD VSS sg13g2_dfrbpq_1
XFILLER_63_754 VDD VSS sg13g2_fill_1
XFILLER_1_1463 VDD VSS sg13g2_decap_8
XFILLER_63_787 VDD VSS sg13g2_decap_8
X_13839_ _13839_/Q clkload35/A _13839_/D _13839_/RESET_B VDD VSS sg13g2_dfrbpq_1
XFILLER_22_106 VDD VSS sg13g2_decap_8
X_13715__2487 _13715_/RESET_B VDD VSS sg13g2_tiehi
XFILLER_62_297 VDD VSS sg13g2_decap_8
XFILLER_149_804 VDD VSS sg13g2_decap_4
XFILLER_143_1413 VDD VSS sg13g2_fill_1
XFILLER_56_1465 VDD VSS sg13g2_decap_8
XFILLER_17_1427 VDD VSS sg13g2_decap_8
XFILLER_91_1367 VDD VSS sg13g2_decap_8
XFILLER_31_695 VDD VSS sg13g2_fill_2
X_09030_ _09043_/A _14905_/Q _12957_/A _10702_/A _09030_/D VDD VSS sg13g2_nand4_1
XFILLER_30_172 VDD VSS sg13g2_decap_4
XFILLER_175_144 VDD VSS sg13g2_decap_8
X_13894__2308 _13894_/RESET_B VDD VSS sg13g2_tiehi
XFILLER_15_1173 VDD VSS sg13g2_decap_8
XFILLER_11_1037 VDD VSS sg13g2_decap_8
XFILLER_144_520 VDD VSS sg13g2_fill_2
X_13930__2272 _13930_/RESET_B VDD VSS sg13g2_tiehi
XFILLER_176_1233 VDD VSS sg13g2_decap_8
XFILLER_102_1198 VDD VSS sg13g2_decap_8
XFILLER_117_28 VDD VSS sg13g2_decap_8
XFILLER_117_789 VDD VSS sg13g2_decap_8
XFILLER_85_1138 VDD VSS sg13g2_decap_4
XFILLER_116_277 VDD VSS sg13g2_decap_8
X_09932_ _14517_/D _14517_/Q _10164_/A1 _09936_/S VDD VSS sg13g2_mux2_1
X_14979__2631 _14979_/RESET_B VDD VSS sg13g2_tiehi
XFILLER_63_1414 VDD VSS sg13g2_decap_8
Xfanout804 _12595_/S _15213_/Q VDD VSS sg13g2_buf_1
Xfanout815 _12747_/S1 _12663_/S1 VDD VSS sg13g2_buf_1
Xfanout826 _12643_/S1 fanout828/X VDD VSS sg13g2_buf_1
XFILLER_113_973 VDD VSS sg13g2_decap_8
Xfanout837 _12536_/S1 fanout841/X VDD VSS sg13g2_buf_1
X_09863_ _14450_/D _14450_/Q _10094_/A0 _09870_/S VDD VSS sg13g2_mux2_1
Xfanout848 _12589_/S1 fanout867/X VDD VSS sg13g2_buf_1
XFILLER_97_150 VDD VSS sg13g2_fill_2
Xfanout859 _12768_/S1 _12717_/S1 VDD VSS sg13g2_buf_1
X_08814_ _08814_/Y _13689_/Q _13469_/B VDD VSS sg13g2_nor2_1
XFILLER_58_548 VDD VSS sg13g2_decap_8
X_09794_ _14383_/D _09827_/A0 _14383_/Q _09804_/S VDD VSS sg13g2_mux2_1
XFILLER_6_1341 VDD VSS sg13g2_decap_8
XFILLER_73_507 VDD VSS sg13g2_decap_8
XFILLER_26_1291 VDD VSS sg13g2_decap_8
X_08745_ _08745_/Y _08751_/A1 _07720_/B _15195_/Q VDD VSS sg13g2_o21ai_1
XFILLER_113_1283 VDD VSS sg13g2_decap_8
XFILLER_26_14 VDD VSS sg13g2_decap_8
XFILLER_148_1302 VDD VSS sg13g2_fill_1
XFILLER_38_283 VDD VSS sg13g2_decap_8
XFILLER_22_1188 VDD VSS sg13g2_decap_8
X_08676_ _08676_/Y _08363_/X _08544_/B _08668_/X _08688_/C _08675_/Y VDD VSS sg13g2_a221oi_1
XFILLER_183_1204 VDD VSS sg13g2_decap_8
X_07627_ _07627_/Y _07627_/A VDD VSS sg13g2_inv_1
XFILLER_96_1289 VDD VSS sg13g2_decap_8
XFILLER_53_264 VDD VSS sg13g2_fill_2
XFILLER_158_7 VDD VSS sg13g2_decap_8
XFILLER_42_949 VDD VSS sg13g2_decap_8
X_14305__1897 _14305_/RESET_B VDD VSS sg13g2_tiehi
XFILLER_139_303 VDD VSS sg13g2_decap_8
XFILLER_50_960 VDD VSS sg13g2_decap_8
XFILLER_42_35 VDD VSS sg13g2_decap_8
XFILLER_139_325 VDD VSS sg13g2_fill_2
XFILLER_158_35 VDD VSS sg13g2_decap_8
XFILLER_166_133 VDD VSS sg13g2_decap_8
X_09228_ _13839_/D _09827_/A0 _13839_/Q _09238_/S VDD VSS sg13g2_mux2_1
XFILLER_33_1240 VDD VSS sg13g2_decap_8
XFILLER_108_701 VDD VSS sg13g2_decap_4
XFILLER_10_868 VDD VSS sg13g2_decap_8
XFILLER_154_317 VDD VSS sg13g2_decap_8
X_14484__1718 _14484_/RESET_B VDD VSS sg13g2_tiehi
XFILLER_182_648 VDD VSS sg13g2_decap_8
X_09159_ _09159_/Y _09158_/A _09155_/Y _09158_/Y VDD VSS sg13g2_o21ai_1
X_14520__1682 _14520_/RESET_B VDD VSS sg13g2_tiehi
XFILLER_68_1314 VDD VSS sg13g2_decap_8
XFILLER_181_147 VDD VSS sg13g2_decap_8
X_12170_ _12170_/Y _12170_/A _12170_/B _12308_/C VDD VSS sg13g2_nand3_1
XFILLER_107_288 VDD VSS sg13g2_decap_4
XFILLER_174_56 VDD VSS sg13g2_decap_8
XFILLER_1_511 VDD VSS sg13g2_decap_8
X_11121_ _11123_/A _11115_/A _11115_/B _11172_/A VDD VSS sg13g2_a21oi_1
XFILLER_123_748 VDD VSS sg13g2_fill_1
XFILLER_150_545 VDD VSS sg13g2_decap_8
X_14774__2962 _14774_/RESET_B VDD VSS sg13g2_tiehi
XFILLER_3_18 VDD VSS sg13g2_decap_8
X_11052_ _11069_/B _11052_/A _11052_/B _11078_/A _11052_/D VDD VSS sg13g2_nor4_1
XFILLER_27_1033 VDD VSS sg13g2_decap_8
XFILLER_150_589 VDD VSS sg13g2_decap_8
XFILLER_89_673 VDD VSS sg13g2_decap_8
XFILLER_66_1093 VDD VSS sg13g2_fill_1
XFILLER_131_770 VDD VSS sg13g2_decap_8
XFILLER_1_588 VDD VSS sg13g2_decap_8
XFILLER_7_1127 VDD VSS sg13g2_decap_8
XFILLER_77_835 VDD VSS sg13g2_decap_8
X_10003_ _14586_/D _10102_/A0 _14586_/Q _10003_/S VDD VSS sg13g2_mux2_1
XFILLER_114_1025 VDD VSS sg13g2_decap_8
XFILLER_88_194 VDD VSS sg13g2_decap_8
XFILLER_114_1047 VDD VSS sg13g2_decap_8
XFILLER_40_1200 VDD VSS sg13g2_decap_8
XFILLER_76_356 VDD VSS sg13g2_decap_8
X_14811_ _14811_/Q clkload85/A _14811_/D _14811_/RESET_B VDD VSS sg13g2_dfrbpq_1
XFILLER_18_924 VDD VSS sg13g2_decap_8
XFILLER_131_1394 VDD VSS sg13g2_decap_8
XFILLER_40_1277 VDD VSS sg13g2_decap_8
XFILLER_123_82 VDD VSS sg13g2_fill_1
XFILLER_166_1402 VDD VSS sg13g2_decap_8
X_14742_ _14742_/Q _14742_/CLK _14742_/D _14742_/RESET_B VDD VSS sg13g2_dfrbpq_1
X_11954_ _11955_/A _13744_/Q _14096_/Q _14448_/Q _14544_/Q _12090_/A _12091_/C VDD
+ VSS sg13g2_mux4_1
XFILLER_79_1465 VDD VSS sg13g2_decap_8
XFILLER_75_1307 VDD VSS sg13g2_decap_8
X_10905_ _10945_/A _14756_/Q _10936_/D VDD VSS sg13g2_nor2_1
X_14673_ _14673_/Q _15139_/CLK _14673_/D _14673_/RESET_B VDD VSS sg13g2_dfrbpq_1
X_11885_ _11885_/Y _11890_/S0 _14382_/Q VDD VSS sg13g2_nand2b_1
XFILLER_83_86 VDD VSS sg13g2_decap_8
XFILLER_83_97 VDD VSS sg13g2_fill_1
XFILLER_44_275 VDD VSS sg13g2_decap_8
X_13624_ _13732_/D _13624_/A VDD VSS sg13g2_buf_1
X_10836_ _14929_/D hold3178/X _10862_/B _10835_/Y VDD VSS sg13g2_a21o_1
XFILLER_60_768 VDD VSS sg13g2_decap_8
XFILLER_158_601 VDD VSS sg13g2_fill_2
XFILLER_186_910 VDD VSS sg13g2_decap_8
XFILLER_13_651 VDD VSS sg13g2_decap_8
XFILLER_158_634 VDD VSS sg13g2_decap_8
X_13555_ _13555_/Y _13555_/A _13566_/B _13563_/C VDD VSS sg13g2_nor3_1
XFILLER_38_1195 VDD VSS sg13g2_decap_8
XFILLER_160_1034 VDD VSS sg13g2_fill_2
XFILLER_185_420 VDD VSS sg13g2_decap_8
X_10767_ _10767_/Y _10767_/A _10767_/B VDD VSS sg13g2_nor2_1
XFILLER_12_161 VDD VSS sg13g2_decap_8
XFILLER_9_644 VDD VSS sg13g2_decap_8
XFILLER_73_1097 VDD VSS sg13g2_fill_1
XFILLER_34_1048 VDD VSS sg13g2_decap_4
X_12506_ _12506_/X _13734_/Q _14086_/Q _14438_/Q _14534_/Q _12506_/S0 _12506_/S1 VDD
+ VSS sg13g2_mux4_1
XFILLER_186_987 VDD VSS sg13g2_decap_8
XFILLER_51_1340 VDD VSS sg13g2_decap_8
XFILLER_125_1198 VDD VSS sg13g2_decap_8
X_13486_ _13502_/D _13486_/A _13486_/B _15169_/D VDD VSS sg13g2_nand3_1
XFILLER_73_7 VDD VSS sg13g2_decap_8
XFILLER_12_1313 VDD VSS sg13g2_decap_8
XFILLER_139_870 VDD VSS sg13g2_decap_8
X_10698_ _10897_/A _14933_/Q _10675_/A _10697_/X VDD VSS sg13g2_a21oi_1
XFILLER_8_165 VDD VSS sg13g2_decap_8
XFILLER_145_328 VDD VSS sg13g2_fill_2
XFILLER_185_497 VDD VSS sg13g2_decap_8
X_15225_ _15225_/Q _15230_/CLK _15225_/D _15225_/RESET_B VDD VSS sg13g2_dfrbpq_1
X_12437_ _12437_/X _14369_/Q _14401_/Q _14465_/Q _14497_/Q _12438_/S0 _12438_/S1 VDD
+ VSS sg13g2_mux4_1
XFILLER_103_1463 VDD VSS sg13g2_decap_8
XFILLER_103_1474 VDD VSS sg13g2_fill_1
XFILLER_154_851 VDD VSS sg13g2_decap_4
XFILLER_172_158 VDD VSS sg13g2_decap_8
X_15156_ _15156_/Q _15160_/CLK _15156_/D _15156_/RESET_B VDD VSS sg13g2_dfrbpq_1
XFILLER_153_350 VDD VSS sg13g2_fill_1
X_12368_ _12368_/X _14684_/Q _14716_/Q _13756_/Q _13788_/Q _12786_/S0 _12786_/S1 VDD
+ VSS sg13g2_mux4_1
XFILLER_86_1447 VDD VSS sg13g2_decap_8
XFILLER_5_861 VDD VSS sg13g2_decap_8
XFILLER_154_884 VDD VSS sg13g2_fill_1
XFILLER_114_726 VDD VSS sg13g2_decap_8
XFILLER_126_586 VDD VSS sg13g2_decap_8
X_14107_ _14107_/Q clkload79/A _14107_/D _14107_/RESET_B VDD VSS sg13g2_dfrbpq_1
XFILLER_173_1428 VDD VSS sg13g2_decap_8
X_11319_ _11319_/Y _11314_/Y _11315_/Y _12108_/B VDD VSS sg13g2_a21oi_1
XFILLER_99_437 VDD VSS sg13g2_decap_8
XFILLER_4_371 VDD VSS sg13g2_decap_8
X_15087_ _15087_/Q clkload72/A _15087_/D _15087_/RESET_B VDD VSS sg13g2_dfrbpq_1
XFILLER_10_1092 VDD VSS sg13g2_decap_8
X_12299_ _12299_/Y _12280_/A _12279_/B _12277_/X VDD VSS sg13g2_a21oi_1
XFILLER_113_247 VDD VSS sg13g2_decap_8
X_14038_ _14038_/Q clkload75/A _14038_/D _14038_/RESET_B VDD VSS sg13g2_dfrbpq_1
XFILLER_68_824 VDD VSS sg13g2_decap_8
XFILLER_122_781 VDD VSS sg13g2_decap_8
XFILLER_132_1103 VDD VSS sg13g2_decap_8
XFILLER_67_334 VDD VSS sg13g2_decap_8
XFILLER_94_120 VDD VSS sg13g2_decap_8
XFILLER_171_1196 VDD VSS sg13g2_decap_8
X_08530_ _08531_/B _07823_/Y _08497_/B _07954_/C VDD VSS sg13g2_o21ai_1
XFILLER_36_732 VDD VSS sg13g2_decap_8
XFILLER_36_743 VDD VSS sg13g2_fill_1
X_13948__2254 _13948_/RESET_B VDD VSS sg13g2_tiehi
XFILLER_36_776 VDD VSS sg13g2_decap_8
XFILLER_1_1260 VDD VSS sg13g2_decap_8
X_08461_ _08462_/C _08461_/A _08461_/B _08461_/C _08461_/D VDD VSS sg13g2_and4_1
XFILLER_36_787 VDD VSS sg13g2_fill_1
XFILLER_91_882 VDD VSS sg13g2_decap_4
XFILLER_17_990 VDD VSS sg13g2_decap_8
XFILLER_50_223 VDD VSS sg13g2_decap_8
X_08392_ _08394_/C _08367_/Y _08391_/Y _08390_/Y VDD VSS sg13g2_a21oi_1
XFILLER_177_921 VDD VSS sg13g2_decap_8
XFILLER_56_1262 VDD VSS sg13g2_decap_8
XFILLER_17_1224 VDD VSS sg13g2_decap_8
XFILLER_182_1292 VDD VSS sg13g2_decap_8
XFILLER_91_1175 VDD VSS sg13g2_decap_8
XFILLER_32_982 VDD VSS sg13g2_decap_4
XFILLER_143_1254 VDD VSS sg13g2_fill_1
XFILLER_176_431 VDD VSS sg13g2_decap_4
XFILLER_91_1186 VDD VSS sg13g2_fill_2
XFILLER_52_1137 VDD VSS sg13g2_decap_8
XFILLER_108_1374 VDD VSS sg13g2_decap_4
XFILLER_91_1197 VDD VSS sg13g2_decap_8
XFILLER_108_1385 VDD VSS sg13g2_fill_1
XFILLER_137_818 VDD VSS sg13g2_decap_4
XFILLER_178_1306 VDD VSS sg13g2_decap_8
XFILLER_12_49 VDD VSS sg13g2_decap_8
XFILLER_164_637 VDD VSS sg13g2_decap_8
X_14859__2849 _14859_/RESET_B VDD VSS sg13g2_tiehi
X_09013_ _09013_/Y _09030_/D _09012_/Y _09010_/Y VDD VSS sg13g2_o21ai_1
XFILLER_148_199 VDD VSS sg13g2_decap_8
XFILLER_3_809 VDD VSS sg13g2_decap_8
XFILLER_30_1468 VDD VSS sg13g2_decap_8
XFILLER_89_1082 VDD VSS sg13g2_decap_8
XFILLER_105_715 VDD VSS sg13g2_decap_8
XFILLER_89_1093 VDD VSS sg13g2_fill_2
XFILLER_2_308 VDD VSS sg13g2_decap_8
XFILLER_176_1052 VDD VSS sg13g2_decap_8
XFILLER_171_191 VDD VSS sg13g2_decap_8
Xfanout601 _11048_/B _13294_/B VDD VSS sg13g2_buf_1
XFILLER_63_1211 VDD VSS sg13g2_decap_8
Xfanout612 _10725_/A _10740_/A1 VDD VSS sg13g2_buf_1
XFILLER_132_578 VDD VSS sg13g2_decap_8
X_09915_ _14500_/D _14500_/Q _09019_/Y _09921_/S VDD VSS sg13g2_mux2_1
XFILLER_160_898 VDD VSS sg13g2_decap_8
Xfanout623 _08873_/A _10710_/A2 VDD VSS sg13g2_buf_1
XFILLER_8_1425 VDD VSS sg13g2_decap_8
Xfanout634 _08843_/B _08900_/A2 VDD VSS sg13g2_buf_1
XFILLER_28_1364 VDD VSS sg13g2_decap_8
Xfanout645 _13390_/A2 _08724_/Y VDD VSS sg13g2_buf_1
XFILLER_98_481 VDD VSS sg13g2_decap_8
Xfanout656 _08359_/A2 _07994_/X VDD VSS sg13g2_buf_1
XFILLER_154_1394 VDD VSS sg13g2_decap_8
X_14762__2977 _14762_/RESET_B VDD VSS sg13g2_tiehi
Xfanout667 _12918_/A2 fanout671/X VDD VSS sg13g2_buf_1
X_09846_ _14433_/D _14433_/Q _10077_/A0 _09858_/S VDD VSS sg13g2_mux2_1
XFILLER_24_1228 VDD VSS sg13g2_decap_8
XFILLER_58_334 VDD VSS sg13g2_decap_4
Xfanout678 _11045_/B1 _10824_/C1 VDD VSS sg13g2_buf_1
XFILLER_63_1288 VDD VSS sg13g2_decap_8
Xfanout689 _12294_/B1 _11868_/A VDD VSS sg13g2_buf_1
XFILLER_37_35 VDD VSS sg13g2_decap_8
X_09777_ _14366_/D _10074_/A0 _14366_/Q _09789_/S VDD VSS sg13g2_mux2_1
XFILLER_74_838 VDD VSS sg13g2_decap_8
XFILLER_160_25 VDD VSS sg13g2_decap_8
X_08728_ _08728_/Y _08727_/X _13459_/B _13392_/A2 VDD VSS sg13g2_a21oi_1
XFILLER_73_359 VDD VSS sg13g2_fill_2
XFILLER_2_1057 VDD VSS sg13g2_decap_8
XFILLER_26_242 VDD VSS sg13g2_decap_4
X_14538__1664 _14538_/RESET_B VDD VSS sg13g2_tiehi
X_08659_ _08661_/C _08659_/A _08659_/B _08659_/C VDD VSS sg13g2_or3_1
XFILLER_14_415 VDD VSS sg13g2_decap_8
XFILLER_54_595 VDD VSS sg13g2_fill_2
XFILLER_42_735 VDD VSS sg13g2_decap_8
XFILLER_96_1097 VDD VSS sg13g2_fill_2
XFILLER_57_1048 VDD VSS sg13g2_fill_1
Xclkbuf_leaf_121_clk_i _14728_/CLK clkload1/A VDD VSS sg13g2_buf_8
X_11670_ _11671_/A _14696_/Q _14728_/Q _13768_/Q _13800_/Q _11686_/S0 _11693_/C VDD
+ VSS sg13g2_mux4_1
XFILLER_183_1078 VDD VSS sg13g2_decap_8
XFILLER_161_1310 VDD VSS sg13g2_decap_8
XFILLER_186_217 VDD VSS sg13g2_decap_8
XFILLER_53_78 VDD VSS sg13g2_decap_4
XFILLER_126_1441 VDD VSS sg13g2_decap_4
XFILLER_169_56 VDD VSS sg13g2_decap_8
X_10621_ _10632_/D _14882_/Q _10651_/D _10625_/D VDD VSS sg13g2_and3_1
XFILLER_74_1373 VDD VSS sg13g2_decap_8
XFILLER_35_1324 VDD VSS sg13g2_decap_8
XFILLER_167_442 VDD VSS sg13g2_decap_8
X_13340_ _15174_/D hold3089/X _15174_/Q _13340_/S VDD VSS sg13g2_mux2_1
XFILLER_70_1259 VDD VSS sg13g2_decap_8
XFILLER_155_604 VDD VSS sg13g2_fill_2
X_10552_ _10554_/A _14865_/Q _10556_/D _14866_/Q VDD VSS sg13g2_a21o_1
XFILLER_161_1387 VDD VSS sg13g2_decap_8
XFILLER_10_665 VDD VSS sg13g2_decap_8
XFILLER_127_328 VDD VSS sg13g2_decap_8
XFILLER_182_434 VDD VSS sg13g2_decap_8
X_13271_ _13271_/Y _13269_/Y _13271_/B _13308_/A VDD VSS sg13g2_nand3b_1
X_10483_ _10487_/B _13084_/A _10489_/D _14849_/Q VDD VSS sg13g2_a21oi_1
XFILLER_183_979 VDD VSS sg13g2_decap_8
X_15010_ _15010_/Q clkload32/A _15010_/D _15010_/RESET_B VDD VSS sg13g2_dfrbpq_1
XFILLER_108_553 VDD VSS sg13g2_decap_8
X_12222_ _12223_/C _12143_/A _12219_/X _12221_/Y VDD VSS sg13g2_a21oi_1
XFILLER_6_669 VDD VSS sg13g2_decap_8
XFILLER_185_77 VDD VSS sg13g2_decap_8
XFILLER_135_361 VDD VSS sg13g2_decap_8
XFILLER_5_168 VDD VSS sg13g2_decap_8
XFILLER_123_512 VDD VSS sg13g2_decap_8
XFILLER_136_895 VDD VSS sg13g2_decap_4
XFILLER_159_1283 VDD VSS sg13g2_decap_8
XFILLER_151_843 VDD VSS sg13g2_decap_8
X_12153_ _12198_/D _12151_/Y _12153_/B VDD VSS sg13g2_nand2b_1
XFILLER_68_1188 VDD VSS sg13g2_decap_8
XFILLER_81_1300 VDD VSS sg13g2_decap_8
X_11104_ _11104_/Y _11085_/Y _11095_/A _11118_/D VDD VSS sg13g2_o21ai_1
XFILLER_46_1442 VDD VSS sg13g2_decap_8
XFILLER_2_875 VDD VSS sg13g2_decap_8
X_12084_ _12197_/B _12084_/A _13668_/Q VDD VSS sg13g2_xnor2_1
XFILLER_77_610 VDD VSS sg13g2_fill_1
XFILLER_110_217 VDD VSS sg13g2_decap_8
XFILLER_150_397 VDD VSS sg13g2_decap_8
XFILLER_1_385 VDD VSS sg13g2_decap_8
X_11035_ _11035_/Y _11023_/A _11024_/B _11034_/Y VDD VSS sg13g2_a21oi_1
XFILLER_89_492 VDD VSS sg13g2_decap_8
XFILLER_42_1317 VDD VSS sg13g2_decap_8
XFILLER_81_1377 VDD VSS sg13g2_decap_8
XFILLER_92_613 VDD VSS sg13g2_decap_8
XFILLER_49_378 VDD VSS sg13g2_fill_1
XFILLER_77_698 VDD VSS sg13g2_decap_8
XFILLER_91_123 VDD VSS sg13g2_fill_1
X_12986_ _13058_/D _14906_/Q _13681_/Q VDD VSS sg13g2_xor2_1
XFILLER_40_1096 VDD VSS sg13g2_decap_8
X_14725_ _14725_/Q _14725_/CLK _14725_/D _14725_/RESET_B VDD VSS sg13g2_dfrbpq_1
XFILLER_45_573 VDD VSS sg13g2_decap_8
X_11937_ _11937_/Y _11914_/A _13673_/Q _11916_/Y VDD VSS sg13g2_a21oi_1
XFILLER_79_1295 VDD VSS sg13g2_decap_8
XFILLER_73_893 VDD VSS sg13g2_decap_8
XFILLER_32_201 VDD VSS sg13g2_decap_8
XFILLER_72_381 VDD VSS sg13g2_fill_2
XFILLER_150_91 VDD VSS sg13g2_decap_8
XFILLER_166_1276 VDD VSS sg13g2_decap_8
X_14656_ _14656_/Q clkload23/A _14656_/D _14656_/RESET_B VDD VSS sg13g2_dfrbpq_1
X_11868_ _11868_/Y _11868_/A _11868_/B _11868_/C VDD VSS sg13g2_nand3_1
XFILLER_127_1249 VDD VSS sg13g2_decap_8
XFILLER_92_1451 VDD VSS sg13g2_decap_8
XFILLER_32_245 VDD VSS sg13g2_decap_8
X_13607_ _15166_/D _13606_/Y _13508_/C _13605_/Y VDD VSS sg13g2_a21oi_1
X_10819_ _10821_/B _10844_/B _15122_/Q VDD VSS sg13g2_nand2_1
XFILLER_60_598 VDD VSS sg13g2_decap_8
X_14587_ _14587_/Q clkload78/A _14587_/D _14587_/RESET_B VDD VSS sg13g2_dfrbpq_1
X_11799_ _11800_/B _11770_/A _13064_/B _11779_/Y VDD VSS sg13g2_a21oi_1
XFILLER_14_1408 VDD VSS sg13g2_decap_8
XFILLER_140_1416 VDD VSS sg13g2_decap_4
XFILLER_53_1468 VDD VSS sg13g2_decap_8
XFILLER_119_818 VDD VSS sg13g2_fill_1
XFILLER_9_441 VDD VSS sg13g2_decap_8
XFILLER_118_306 VDD VSS sg13g2_fill_1
XFILLER_159_998 VDD VSS sg13g2_fill_1
X_13538_ _13538_/Y _14994_/Q _13566_/C _15002_/Q _13546_/B2 VDD VSS sg13g2_a22oi_1
XFILLER_186_784 VDD VSS sg13g2_decap_8
XFILLER_12_1110 VDD VSS sg13g2_decap_8
XFILLER_146_648 VDD VSS sg13g2_decap_4
XFILLER_185_294 VDD VSS sg13g2_decap_8
X_13469_ _13469_/X _13469_/A _13469_/B _13469_/C _13469_/D VDD VSS sg13g2_and4_1
XFILLER_103_1260 VDD VSS sg13g2_decap_8
XFILLER_145_147 VDD VSS sg13g2_decap_8
XFILLER_161_607 VDD VSS sg13g2_decap_8
XFILLER_86_1211 VDD VSS sg13g2_decap_8
XFILLER_161_618 VDD VSS sg13g2_fill_2
XFILLER_173_478 VDD VSS sg13g2_decap_4
X_15208_ _15208_/Q clkload73/A _15208_/D _15208_/RESET_B VDD VSS sg13g2_dfrbpq_1
XFILLER_103_1293 VDD VSS sg13g2_decap_8
XFILLER_12_1187 VDD VSS sg13g2_decap_8
X_14012__2190 _14012_/RESET_B VDD VSS sg13g2_tiehi
XFILLER_182_990 VDD VSS sg13g2_decap_8
XFILLER_126_383 VDD VSS sg13g2_fill_2
XFILLER_138_1323 VDD VSS sg13g2_decap_4
XFILLER_173_1225 VDD VSS sg13g2_decap_8
X_15139_ _15139_/Q _15139_/CLK _15139_/D _15139_/RESET_B VDD VSS sg13g2_dfrbpq_1
XFILLER_47_1228 VDD VSS sg13g2_decap_8
XFILLER_177_1394 VDD VSS sg13g2_decap_8
XFILLER_99_245 VDD VSS sg13g2_decap_8
XFILLER_138_1367 VDD VSS sg13g2_decap_8
XFILLER_86_1299 VDD VSS sg13g2_decap_4
XFILLER_141_353 VDD VSS sg13g2_decap_8
XFILLER_142_887 VDD VSS sg13g2_fill_2
XFILLER_87_407 VDD VSS sg13g2_decap_4
XFILLER_141_364 VDD VSS sg13g2_fill_2
X_14616__1586 _14616_/RESET_B VDD VSS sg13g2_tiehi
X_07961_ _08577_/B _07961_/A _07961_/B VDD VSS sg13g2_nand2_1
XFILLER_99_289 VDD VSS sg13g2_decap_8
X_09700_ _14292_/D _10063_/A0 _14292_/Q _09700_/S VDD VSS sg13g2_mux2_1
X_14191__2011 _14191_/RESET_B VDD VSS sg13g2_tiehi
XFILLER_60_1406 VDD VSS sg13g2_decap_8
X_07892_ _08160_/B _08200_/A _07893_/B VDD VSS sg13g2_nor2b_1
XFILLER_114_29 VDD VSS sg13g2_decap_8
X_09631_ _14227_/D _10062_/A0 _14227_/Q _09637_/S VDD VSS sg13g2_mux2_1
XFILLER_67_153 VDD VSS sg13g2_decap_8
XFILLER_56_816 VDD VSS sg13g2_fill_1
XFILLER_83_613 VDD VSS sg13g2_fill_1
XFILLER_28_529 VDD VSS sg13g2_decap_4
XFILLER_110_795 VDD VSS sg13g2_decap_8
XFILLER_82_101 VDD VSS sg13g2_fill_2
XFILLER_83_646 VDD VSS sg13g2_decap_8
X_09562_ _14160_/D _09960_/A1 _14160_/Q _09562_/S VDD VSS sg13g2_mux2_1
XFILLER_23_1283 VDD VSS sg13g2_decap_8
XFILLER_55_359 VDD VSS sg13g2_decap_8
XFILLER_3_1355 VDD VSS sg13g2_decap_8
XFILLER_184_1310 VDD VSS sg13g2_decap_8
XFILLER_64_860 VDD VSS sg13g2_decap_8
XFILLER_149_1430 VDD VSS sg13g2_decap_8
X_08513_ _08517_/C _08484_/B _08511_/X _08512_/Y VDD VSS sg13g2_o21ai_1
XFILLER_110_1275 VDD VSS sg13g2_decap_8
X_09493_ _14093_/D _10023_/A0 _14093_/Q _09493_/S VDD VSS sg13g2_mux2_1
XFILLER_97_1384 VDD VSS sg13g2_decap_8
XFILLER_130_39 VDD VSS sg13g2_decap_8
XFILLER_93_1226 VDD VSS sg13g2_decap_4
XFILLER_149_1474 VDD VSS sg13g2_fill_1
XFILLER_91_690 VDD VSS sg13g2_decap_8
XFILLER_58_1357 VDD VSS sg13g2_decap_8
X_08444_ _08444_/Y _08574_/A _08574_/B VDD VSS sg13g2_nand2_1
XFILLER_168_206 VDD VSS sg13g2_decap_8
XFILLER_184_1387 VDD VSS sg13g2_decap_8
XFILLER_51_554 VDD VSS sg13g2_decap_8
XFILLER_17_1032 VDD VSS sg13g2_decap_8
X_08375_ _08375_/Y _08484_/B _08223_/X _08397_/A VDD VSS sg13g2_o21ai_1
XFILLER_177_740 VDD VSS sg13g2_fill_1
XFILLER_23_289 VDD VSS sg13g2_decap_8
Xclkbuf_leaf_53_clk_i clkload72/A clkload4/A VDD VSS sg13g2_buf_8
XFILLER_108_1160 VDD VSS sg13g2_decap_8
XFILLER_17_1043 VDD VSS sg13g2_decap_8
X_14222__1980 _14222_/RESET_B VDD VSS sg13g2_tiehi
XFILLER_17_1054 VDD VSS sg13g2_decap_4
XFILLER_104_1013 VDD VSS sg13g2_decap_8
XFILLER_149_464 VDD VSS sg13g2_decap_8
XFILLER_149_486 VDD VSS sg13g2_decap_8
XFILLER_164_412 VDD VSS sg13g2_fill_1
XFILLER_165_935 VDD VSS sg13g2_decap_4
XFILLER_177_795 VDD VSS sg13g2_decap_8
XFILLER_128_8 VDD VSS sg13g2_fill_2
XFILLER_136_114 VDD VSS sg13g2_decap_8
XFILLER_178_1103 VDD VSS sg13g2_decap_8
XFILLER_17_1098 VDD VSS sg13g2_decap_8
XFILLER_109_339 VDD VSS sg13g2_decap_8
XFILLER_34_1390 VDD VSS sg13g2_decap_8
XFILLER_118_862 VDD VSS sg13g2_decap_8
XFILLER_139_1109 VDD VSS sg13g2_decap_8
X_15109__2766 _15109_/RESET_B VDD VSS sg13g2_tiehi
Xclkbuf_leaf_68_clk_i _14893_/CLK clkbuf_leaf_71_clk_i/A VDD VSS sg13g2_buf_8
XFILLER_3_606 VDD VSS sg13g2_decap_8
XFILLER_30_1265 VDD VSS sg13g2_decap_8
XFILLER_155_25 VDD VSS sg13g2_decap_8
XFILLER_2_105 VDD VSS sg13g2_decap_8
XFILLER_117_394 VDD VSS sg13g2_decap_8
XFILLER_156_1434 VDD VSS sg13g2_decap_8
XFILLER_144_191 VDD VSS sg13g2_fill_2
XFILLER_160_651 VDD VSS sg13g2_decap_8
XFILLER_160_684 VDD VSS sg13g2_decap_8
Xfanout1407 _12812_/A fanout1413/X VDD VSS sg13g2_buf_1
Xfanout420 _11163_/A _11164_/A VDD VSS sg13g2_buf_1
Xfanout1418 _13005_/C _13405_/B VDD VSS sg13g2_buf_1
XFILLER_63_1030 VDD VSS sg13g2_decap_8
XFILLER_59_610 VDD VSS sg13g2_fill_1
Xfanout431 _10036_/S fanout432/X VDD VSS sg13g2_buf_1
XFILLER_8_1222 VDD VSS sg13g2_decap_8
XFILLER_28_1161 VDD VSS sg13g2_decap_8
Xfanout1429 _13499_/B _13405_/B VDD VSS sg13g2_buf_1
Xfanout442 _09837_/S _09826_/S VDD VSS sg13g2_buf_1
XFILLER_115_1131 VDD VSS sg13g2_decap_8
Xfanout453 _09659_/S _09661_/S VDD VSS sg13g2_buf_1
XFILLER_59_643 VDD VSS sg13g2_decap_8
XFILLER_115_1142 VDD VSS sg13g2_fill_1
Xfanout464 _09524_/S _09523_/S VDD VSS sg13g2_buf_1
XFILLER_86_440 VDD VSS sg13g2_decap_8
XFILLER_59_654 VDD VSS sg13g2_fill_1
XFILLER_48_56 VDD VSS sg13g2_fill_2
XFILLER_171_35 VDD VSS sg13g2_decap_8
Xfanout475 _09397_/S _09401_/S VDD VSS sg13g2_buf_1
Xfanout486 fanout486/X _09342_/Y VDD VSS sg13g2_buf_1
XFILLER_74_602 VDD VSS sg13g2_decap_8
XFILLER_59_687 VDD VSS sg13g2_fill_1
XFILLER_19_529 VDD VSS sg13g2_decap_8
X_13710__2492 _13710_/RESET_B VDD VSS sg13g2_tiehi
Xfanout497 fanout497/X _08989_/X VDD VSS sg13g2_buf_1
X_09829_ _14417_/D _09928_/A1 _14417_/Q _09837_/S VDD VSS sg13g2_mux2_1
XFILLER_8_1299 VDD VSS sg13g2_decap_8
XFILLER_100_261 VDD VSS sg13g2_decap_8
XFILLER_74_624 VDD VSS sg13g2_decap_8
XFILLER_100_272 VDD VSS sg13g2_fill_2
X_12840_ _15023_/D _12984_/A _12840_/B VDD VSS sg13g2_nor2_1
XFILLER_41_1383 VDD VSS sg13g2_decap_8
XFILLER_104_84 VDD VSS sg13g2_decap_8
XFILLER_15_702 VDD VSS sg13g2_fill_1
X_13689__2517 _13689_/RESET_B VDD VSS sg13g2_tiehi
XFILLER_61_318 VDD VSS sg13g2_decap_8
XFILLER_27_562 VDD VSS sg13g2_decap_4
X_12771_ _12771_/X _13977_/Q _14009_/Q _14041_/Q _14073_/Q _12773_/S0 _12773_/S1 VDD
+ VSS sg13g2_mux4_1
XFILLER_55_882 VDD VSS sg13g2_fill_2
XFILLER_14_201 VDD VSS sg13g2_decap_8
XFILLER_73_189 VDD VSS sg13g2_decap_8
XFILLER_55_893 VDD VSS sg13g2_decap_8
XFILLER_15_735 VDD VSS sg13g2_fill_2
X_14054__2148 _14054_/RESET_B VDD VSS sg13g2_tiehi
XFILLER_76_1457 VDD VSS sg13g2_decap_8
X_14510_ _14510_/Q _14510_/CLK _14510_/D _14510_/RESET_B VDD VSS sg13g2_dfrbpq_1
X_11722_ _11722_/Y _11721_/Y _11720_/Y _11707_/Y _11722_/B2 _11723_/A2 VDD VSS sg13g2_a221oi_1
XFILLER_159_206 VDD VSS sg13g2_decap_8
XFILLER_14_256 VDD VSS sg13g2_decap_8
XFILLER_9_28 VDD VSS sg13g2_decap_8
XFILLER_147_0 VDD VSS sg13g2_decap_8
X_14441_ _14441_/Q _14665_/CLK _14441_/D _14441_/RESET_B VDD VSS sg13g2_dfrbpq_1
X_11653_ _11653_/X _11646_/X _11647_/X _11650_/X _11651_/X _11973_/B _11956_/B1 VDD
+ VSS sg13g2_mux4_1
XFILLER_80_21 VDD VSS sg13g2_decap_8
XFILLER_74_1170 VDD VSS sg13g2_decap_8
XFILLER_70_1001 VDD VSS sg13g2_fill_1
XFILLER_42_587 VDD VSS sg13g2_fill_1
XFILLER_126_1260 VDD VSS sg13g2_fill_2
XFILLER_168_762 VDD VSS sg13g2_decap_8
X_10604_ _10613_/A _14878_/Q _14877_/Q _10610_/D VDD VSS sg13g2_nand3_1
X_14372_ _14372_/Q _14510_/CLK _14372_/D _14372_/RESET_B VDD VSS sg13g2_dfrbpq_1
X_11584_ _11584_/Y _11858_/A _11584_/B VDD VSS sg13g2_nor2_1
XFILLER_11_974 VDD VSS sg13g2_decap_8
XFILLER_161_1184 VDD VSS sg13g2_decap_8
XFILLER_128_637 VDD VSS sg13g2_fill_1
XFILLER_183_721 VDD VSS sg13g2_decap_8
XFILLER_31_1029 VDD VSS sg13g2_decap_4
XFILLER_10_462 VDD VSS sg13g2_decap_8
X_13323_ _13324_/B _15112_/Q _13306_/B _13309_/Y _10137_/A VDD VSS sg13g2_a22oi_1
XFILLER_35_1198 VDD VSS sg13g2_decap_8
XFILLER_156_957 VDD VSS sg13g2_decap_8
X_10535_ _14860_/D _10535_/A _10535_/B _10626_/B VDD VSS sg13g2_and3_1
XFILLER_7_945 VDD VSS sg13g2_decap_8
XFILLER_13_81 VDD VSS sg13g2_decap_8
XFILLER_182_242 VDD VSS sg13g2_decap_8
XFILLER_109_862 VDD VSS sg13g2_decap_8
XFILLER_100_1422 VDD VSS sg13g2_decap_8
XFILLER_13_1474 VDD VSS sg13g2_fill_1
XFILLER_170_404 VDD VSS sg13g2_decap_4
X_13254_ _15050_/D _13247_/Y _13253_/Y _13266_/A VDD VSS sg13g2_a21oi_1
XFILLER_6_466 VDD VSS sg13g2_decap_8
XFILLER_183_798 VDD VSS sg13g2_decap_8
X_10466_ _10509_/B _10500_/A _10471_/C VDD VSS sg13g2_nand2_1
X_12205_ _12205_/X _14263_/Q _14295_/Q _14327_/Q _14359_/Q _12215_/S0 _12241_/B1 VDD
+ VSS sg13g2_mux4_1
XFILLER_124_854 VDD VSS sg13g2_decap_4
X_13185_ _13225_/B _14919_/Q _13668_/Q VDD VSS sg13g2_xor2_1
XFILLER_83_1417 VDD VSS sg13g2_decap_8
XFILLER_123_331 VDD VSS sg13g2_decap_8
X_10397_ _10413_/B _10400_/A _10397_/B _10397_/C VDD VSS sg13g2_nor3_1
XFILLER_123_353 VDD VSS sg13g2_decap_8
XFILLER_9_1008 VDD VSS sg13g2_decap_8
X_12136_ _12136_/X _14709_/Q _14741_/Q _13781_/Q _13813_/Q _12139_/S0 _12139_/S1 VDD
+ VSS sg13g2_mux4_1
XFILLER_36_7 VDD VSS sg13g2_decap_8
XFILLER_2_672 VDD VSS sg13g2_decap_8
XFILLER_97_749 VDD VSS sg13g2_fill_1
XFILLER_111_537 VDD VSS sg13g2_fill_2
XFILLER_1_182 VDD VSS sg13g2_decap_8
X_12067_ _12067_/X _13971_/Q _14003_/Q _14035_/Q _14067_/Q _12135_/S0 _12135_/S1 VDD
+ VSS sg13g2_mux4_1
XFILLER_42_1114 VDD VSS sg13g2_decap_8
XFILLER_172_1291 VDD VSS sg13g2_decap_8
X_14264__1938 _14264_/RESET_B VDD VSS sg13g2_tiehi
X_11018_ _11018_/Y _11022_/B _11014_/Y _11017_/Y VDD VSS sg13g2_a21oi_1
X_16875_ _16875_/X _16875_/A VDD VSS sg13g2_buf_1
XFILLER_64_101 VDD VSS sg13g2_fill_2
XFILLER_49_186 VDD VSS sg13g2_fill_2
XFILLER_93_955 VDD VSS sg13g2_decap_8
XFILLER_65_646 VDD VSS sg13g2_decap_8
XFILLER_20_1445 VDD VSS sg13g2_decap_8
XFILLER_168_1349 VDD VSS sg13g2_decap_8
XFILLER_18_562 VDD VSS sg13g2_decap_8
XFILLER_64_189 VDD VSS sg13g2_decap_4
X_12969_ _12969_/Y _12967_/Y _12968_/Y _12933_/Y VDD VSS sg13g2_o21ai_1
XFILLER_33_510 VDD VSS sg13g2_decap_4
X_14708_ _14708_/Q clkload15/A _14708_/D _14708_/RESET_B VDD VSS sg13g2_dfrbpq_1
XFILLER_60_351 VDD VSS sg13g2_decap_8
XFILLER_21_727 VDD VSS sg13g2_decap_8
XFILLER_61_896 VDD VSS sg13g2_decap_8
XFILLER_127_1068 VDD VSS sg13g2_fill_1
X_14639_ _14639_/Q clkload34/A _14639_/D _14639_/RESET_B VDD VSS sg13g2_dfrbpq_1
XFILLER_92_1270 VDD VSS sg13g2_decap_8
XFILLER_159_740 VDD VSS sg13g2_decap_8
XFILLER_159_751 VDD VSS sg13g2_fill_1
XFILLER_105_1311 VDD VSS sg13g2_decap_4
XFILLER_147_913 VDD VSS sg13g2_decap_8
XFILLER_14_1205 VDD VSS sg13g2_decap_8
X_08160_ _08160_/Y _08422_/S _08160_/B _08160_/C VDD VSS sg13g2_nor3_1
XFILLER_18_1385 VDD VSS sg13g2_decap_8
XFILLER_20_259 VDD VSS sg13g2_fill_2
XFILLER_53_1265 VDD VSS sg13g2_decap_8
XFILLER_118_103 VDD VSS sg13g2_decap_8
XFILLER_146_412 VDD VSS sg13g2_decap_8
XFILLER_186_581 VDD VSS sg13g2_decap_8
X_08091_ _08091_/Y _08074_/B _08088_/Y _08090_/Y VDD VSS sg13g2_a21oi_1
XFILLER_109_18 VDD VSS sg13g2_decap_8
XFILLER_147_979 VDD VSS sg13g2_fill_2
XFILLER_118_158 VDD VSS sg13g2_decap_8
XFILLER_179_1456 VDD VSS sg13g2_decap_8
Xclkload30 clkload30/Y clkload30/A VDD VSS sg13g2_inv_1
XFILLER_162_927 VDD VSS sg13g2_decap_8
Xclkload41 clkload41/Y clkload41/A VDD VSS sg13g2_inv_1
Xclkload52 clkload52/Y clkload52/A VDD VSS sg13g2_inv_2
XFILLER_127_681 VDD VSS sg13g2_decap_8
Xclkload63 clkload63/Y clkload63/A VDD VSS sg13g2_inv_1
XFILLER_127_692 VDD VSS sg13g2_fill_1
XFILLER_173_297 VDD VSS sg13g2_decap_8
Xclkload74 clkload74/Y clkload74/A VDD VSS sg13g2_inv_2
XFILLER_115_843 VDD VSS sg13g2_decap_8
Xclkload85 clkload85/Y clkload85/A VDD VSS sg13g2_inv_1
XFILLER_161_459 VDD VSS sg13g2_decap_8
XFILLER_177_1191 VDD VSS sg13g2_decap_8
XFILLER_0_609 VDD VSS sg13g2_decap_8
XFILLER_138_1153 VDD VSS sg13g2_decap_8
XFILLER_170_982 VDD VSS sg13g2_decap_8
X_08993_ _08993_/X _14899_/Q _12859_/A _10681_/A _10674_/A VDD VSS sg13g2_and4_1
XFILLER_114_397 VDD VSS sg13g2_fill_2
XFILLER_69_930 VDD VSS sg13g2_fill_1
XFILLER_173_1099 VDD VSS sg13g2_decap_8
X_07944_ _07961_/A _07942_/A _07928_/Y _07906_/B VDD VSS sg13g2_o21ai_1
XFILLER_64_1372 VDD VSS sg13g2_decap_8
XFILLER_60_1203 VDD VSS sg13g2_decap_8
XFILLER_87_259 VDD VSS sg13g2_decap_8
XFILLER_25_1334 VDD VSS sg13g2_decap_8
XFILLER_69_974 VDD VSS sg13g2_decap_4
XFILLER_68_451 VDD VSS sg13g2_decap_8
XFILLER_5_1428 VDD VSS sg13g2_decap_8
XFILLER_29_816 VDD VSS sg13g2_decap_4
XFILLER_96_782 VDD VSS sg13g2_decap_4
XFILLER_110_570 VDD VSS sg13g2_fill_1
X_07875_ _07905_/A _07876_/A _07876_/B VDD VSS sg13g2_and2_1
XFILLER_29_849 VDD VSS sg13g2_decap_8
XFILLER_110_592 VDD VSS sg13g2_decap_8
XFILLER_95_292 VDD VSS sg13g2_decap_8
XFILLER_55_123 VDD VSS sg13g2_decap_8
X_09614_ _14210_/D _09614_/A0 _14210_/Q _09632_/S VDD VSS sg13g2_mux2_1
XFILLER_83_443 VDD VSS sg13g2_fill_1
XFILLER_56_657 VDD VSS sg13g2_fill_1
XFILLER_186_1427 VDD VSS sg13g2_decap_8
XFILLER_3_1152 VDD VSS sg13g2_decap_8
X_09545_ _14143_/D _10075_/A0 _14143_/Q _09556_/S VDD VSS sg13g2_mux2_1
XFILLER_58_1110 VDD VSS sg13g2_decap_4
XFILLER_93_1023 VDD VSS sg13g2_fill_2
XFILLER_71_649 VDD VSS sg13g2_decap_8
XFILLER_149_1271 VDD VSS sg13g2_decap_8
XFILLER_58_1154 VDD VSS sg13g2_decap_8
XFILLER_34_25 VDD VSS sg13g2_decap_8
X_09476_ _14076_/D _09841_/A1 _14076_/Q _09506_/S VDD VSS sg13g2_mux2_1
XFILLER_34_36 VDD VSS sg13g2_fill_1
XFILLER_184_1184 VDD VSS sg13g2_decap_8
XFILLER_52_874 VDD VSS sg13g2_fill_2
XFILLER_24_565 VDD VSS sg13g2_decap_8
XFILLER_19_1149 VDD VSS sg13g2_decap_8
X_08427_ _08427_/X _08457_/A3 _07790_/A _07945_/B _07946_/B _13509_/A1 _13553_/A1
+ VDD VSS sg13g2_mux4_1
XFILLER_106_1108 VDD VSS sg13g2_decap_8
XFILLER_51_395 VDD VSS sg13g2_decap_4
X_08358_ _08358_/Y _08412_/A _08275_/B _08357_/Y VDD VSS sg13g2_o21ai_1
XFILLER_36_1474 VDD VSS sg13g2_decap_4
Xclkload2 clkload2/X clkload2/A VDD VSS sg13g2_buf_8
XFILLER_32_1316 VDD VSS sg13g2_decap_8
XFILLER_138_935 VDD VSS sg13g2_decap_8
XFILLER_149_272 VDD VSS sg13g2_decap_8
XFILLER_71_1376 VDD VSS sg13g2_decap_8
XFILLER_50_46 VDD VSS sg13g2_decap_4
X_08289_ _08289_/Y _08265_/X _08315_/C _08315_/A VDD VSS sg13g2_a21oi_1
XFILLER_50_57 VDD VSS sg13g2_fill_1
XFILLER_166_35 VDD VSS sg13g2_decap_8
X_10320_ _10322_/A _14799_/Q _10405_/C _14800_/Q VDD VSS sg13g2_a21o_1
XFILLER_50_79 VDD VSS sg13g2_decap_8
XFILLER_180_713 VDD VSS sg13g2_fill_2
X_13728__2474 _13728_/RESET_B VDD VSS sg13g2_tiehi
XFILLER_137_489 VDD VSS sg13g2_decap_8
XFILLER_164_275 VDD VSS sg13g2_decap_8
XFILLER_3_403 VDD VSS sg13g2_decap_8
XFILLER_152_426 VDD VSS sg13g2_decap_8
X_10251_ _14778_/D _10251_/A _10258_/D VDD VSS sg13g2_nor2_1
XFILLER_4_959 VDD VSS sg13g2_decap_8
XFILLER_69_1283 VDD VSS sg13g2_decap_8
XFILLER_133_651 VDD VSS sg13g2_decap_4
XFILLER_105_364 VDD VSS sg13g2_decap_8
XFILLER_161_982 VDD VSS sg13g2_decap_8
XFILLER_152_1106 VDD VSS sg13g2_fill_1
X_10182_ _10182_/Y _10182_/A _14748_/Q VDD VSS sg13g2_nand2_1
XFILLER_65_1158 VDD VSS sg13g2_decap_8
XFILLER_26_1109 VDD VSS sg13g2_decap_8
Xfanout1204 _13199_/A _14920_/Q VDD VSS sg13g2_buf_1
Xfanout1215 _10674_/A _14896_/Q VDD VSS sg13g2_buf_1
XFILLER_152_1139 VDD VSS sg13g2_decap_8
XFILLER_182_67 VDD VSS sg13g2_decap_8
X_14108__2094 _14108_/RESET_B VDD VSS sg13g2_tiehi
Xfanout1226 _10500_/A _14844_/Q VDD VSS sg13g2_buf_1
Xfanout1237 _10179_/B _14747_/Q VDD VSS sg13g2_buf_1
X_14990_ _14990_/Q _15240_/CLK _14990_/D _14990_/RESET_B VDD VSS sg13g2_dfrbpq_1
Xfanout250 fanout250/X _09045_/Y VDD VSS sg13g2_buf_1
XFILLER_43_1434 VDD VSS sg13g2_decap_8
Xfanout1248 _11625_/C _11832_/C VDD VSS sg13g2_buf_1
XFILLER_87_760 VDD VSS sg13g2_decap_8
Xfanout261 _10059_/S _10063_/S VDD VSS sg13g2_buf_1
Xfanout1259 _11901_/B1 _11834_/A2 VDD VSS sg13g2_buf_1
XFILLER_93_207 VDD VSS sg13g2_decap_8
Xfanout272 _09892_/S _09872_/Y VDD VSS sg13g2_buf_1
X_13941_ _13941_/Q clkload36/A _13941_/D _13941_/RESET_B VDD VSS sg13g2_dfrbpq_1
Xfanout283 _09440_/S fanout284/X VDD VSS sg13g2_buf_1
XFILLER_75_21 VDD VSS sg13g2_decap_8
Xfanout294 _10077_/A0 _09978_/A0 VDD VSS sg13g2_buf_1
XFILLER_8_1096 VDD VSS sg13g2_decap_8
XFILLER_47_646 VDD VSS sg13g2_fill_1
XFILLER_19_348 VDD VSS sg13g2_decap_8
X_13872_ _13872_/Q _14704_/CLK _13872_/D _13872_/RESET_B VDD VSS sg13g2_dfrbpq_1
XFILLER_74_454 VDD VSS sg13g2_fill_2
XFILLER_41_1180 VDD VSS sg13g2_decap_8
X_12823_ _12824_/B _12878_/D _12822_/X _12816_/Y _13004_/A2 _12820_/Y VDD VSS sg13g2_a221oi_1
XFILLER_61_115 VDD VSS sg13g2_decap_8
XFILLER_46_189 VDD VSS sg13g2_decap_8
XFILLER_90_958 VDD VSS sg13g2_decap_8
XFILLER_167_1360 VDD VSS sg13g2_decap_8
XFILLER_76_1254 VDD VSS sg13g2_decap_8
X_12754_ _12754_/X _14392_/Q _14424_/Q _14488_/Q _14520_/Q _12759_/S0 _12759_/S1 VDD
+ VSS sg13g2_mux4_1
XFILLER_43_863 VDD VSS sg13g2_decap_8
XFILLER_72_1107 VDD VSS sg13g2_fill_1
XFILLER_37_1238 VDD VSS sg13g2_decap_8
XFILLER_42_362 VDD VSS sg13g2_decap_8
X_11705_ _11705_/Y _11705_/A _13679_/Q VDD VSS sg13g2_nand2_1
X_12685_ _12685_/X _13971_/Q _14003_/Q _14035_/Q _14067_/Q _12711_/S0 _12711_/S1 VDD
+ VSS sg13g2_mux4_1
XFILLER_163_1268 VDD VSS sg13g2_decap_8
XFILLER_147_209 VDD VSS sg13g2_decap_8
X_14424_ _14424_/Q clkload47/A _14424_/D _14424_/RESET_B VDD VSS sg13g2_dfrbpq_1
X_11636_ _11637_/B _11636_/A _11636_/B _11636_/C VDD VSS sg13g2_nand3_1
XFILLER_128_401 VDD VSS sg13g2_decap_8
XFILLER_50_1449 VDD VSS sg13g2_decap_8
X_14355_ _14355_/Q clkload36/A _14355_/D _14355_/RESET_B VDD VSS sg13g2_dfrbpq_1
X_11567_ _11638_/B _11502_/A _13685_/Q _12942_/B _11526_/A VDD VSS sg13g2_a22oi_1
XFILLER_7_742 VDD VSS sg13g2_decap_8
XFILLER_171_702 VDD VSS sg13g2_decap_8
XFILLER_128_478 VDD VSS sg13g2_fill_1
X_13306_ _15059_/D _13507_/A _13306_/B _13306_/C VDD VSS sg13g2_nor3_1
X_10518_ _10519_/C _14855_/Q _10579_/B VDD VSS sg13g2_and2_1
XFILLER_13_1271 VDD VSS sg13g2_decap_8
XFILLER_155_275 VDD VSS sg13g2_fill_2
X_14286_ _14286_/Q clkload19/A _14286_/D _14286_/RESET_B VDD VSS sg13g2_dfrbpq_1
X_14318__1884 _14318_/RESET_B VDD VSS sg13g2_tiehi
X_11498_ _11498_/Y _11956_/B1 _11496_/X _11497_/Y VDD VSS sg13g2_o21ai_1
XFILLER_6_263 VDD VSS sg13g2_decap_8
XFILLER_183_595 VDD VSS sg13g2_decap_8
XFILLER_100_1252 VDD VSS sg13g2_fill_2
X_13237_ _13237_/Y _13234_/Y _13235_/Y _13236_/Y VDD VSS sg13g2_a21oi_1
XFILLER_143_459 VDD VSS sg13g2_decap_4
XFILLER_171_768 VDD VSS sg13g2_fill_1
X_10449_ _10450_/C _10647_/A _14839_/Q _10647_/D _10514_/A VDD VSS sg13g2_and4_1
XFILLER_83_1214 VDD VSS sg13g2_decap_8
XFILLER_152_960 VDD VSS sg13g2_decap_8
XFILLER_124_673 VDD VSS sg13g2_decap_8
XFILLER_130_109 VDD VSS sg13g2_fill_2
XFILLER_135_1304 VDD VSS sg13g2_decap_4
XFILLER_48_1356 VDD VSS sg13g2_decap_8
XFILLER_174_1364 VDD VSS sg13g2_decap_8
X_13168_ _13225_/A _13189_/A _13189_/B VDD VSS sg13g2_xor2_1
XFILLER_3_970 VDD VSS sg13g2_decap_8
XFILLER_97_524 VDD VSS sg13g2_decap_8
XFILLER_69_226 VDD VSS sg13g2_decap_4
XFILLER_111_323 VDD VSS sg13g2_decap_8
X_14497__1705 _14497_/RESET_B VDD VSS sg13g2_tiehi
XFILLER_97_546 VDD VSS sg13g2_decap_8
XFILLER_112_857 VDD VSS sg13g2_fill_2
XFILLER_170_1228 VDD VSS sg13g2_decap_8
X_12119_ _12119_/Y _12099_/Y _12101_/X _11791_/S VDD VSS sg13g2_o21ai_1
X_13099_ _13099_/Y _13265_/A1 _13098_/X _13097_/Y VDD VSS sg13g2_a21oi_1
XFILLER_66_955 VDD VSS sg13g2_fill_1
X_07660_ _07766_/B _10210_/D _14749_/Q VDD VSS sg13g2_nand2b_1
X_16858_ _16858_/X _16858_/A VDD VSS sg13g2_buf_1
XFILLER_37_145 VDD VSS sg13g2_decap_8
XFILLER_26_808 VDD VSS sg13g2_fill_2
XFILLER_37_156 VDD VSS sg13g2_fill_2
XFILLER_0_1303 VDD VSS sg13g2_decap_8
XFILLER_1_84 VDD VSS sg13g2_decap_8
XFILLER_20_1242 VDD VSS sg13g2_decap_8
XFILLER_168_1146 VDD VSS sg13g2_decap_8
XFILLER_65_487 VDD VSS sg13g2_decap_8
XFILLER_65_498 VDD VSS sg13g2_fill_2
XFILLER_185_1460 VDD VSS sg13g2_decap_8
X_09330_ _13937_/D _09928_/A1 _13937_/Q _09337_/S VDD VSS sg13g2_mux2_1
XFILLER_34_841 VDD VSS sg13g2_decap_8
XFILLER_181_1302 VDD VSS sg13g2_decap_8
X_13806__2396 _13806_/RESET_B VDD VSS sg13g2_tiehi
XFILLER_94_1354 VDD VSS sg13g2_fill_1
XFILLER_34_863 VDD VSS sg13g2_decap_8
XFILLER_179_846 VDD VSS sg13g2_decap_8
XFILLER_146_1466 VDD VSS sg13g2_decap_8
X_09261_ _13870_/D _13870_/Q _10157_/A1 _09261_/S VDD VSS sg13g2_mux2_1
XFILLER_90_1229 VDD VSS sg13g2_decap_4
XFILLER_55_1349 VDD VSS sg13g2_decap_8
XFILLER_181_1379 VDD VSS sg13g2_decap_8
X_08212_ _08212_/X _08212_/A _08688_/D _08688_/A VDD VSS sg13g2_and3_1
XFILLER_14_1002 VDD VSS sg13g2_decap_8
X_09192_ _13808_/D _13808_/Q _10159_/A1 _09196_/S VDD VSS sg13g2_mux2_1
XFILLER_140_1010 VDD VSS sg13g2_fill_2
XFILLER_18_1182 VDD VSS sg13g2_decap_8
X_13985__2217 _13985_/RESET_B VDD VSS sg13g2_tiehi
X_08143_ _08143_/Y _08182_/B _08141_/Y _08142_/Y VDD VSS sg13g2_o21ai_1
X_13673__2549 _13673_/RESET_B VDD VSS sg13g2_tiehi
XFILLER_119_456 VDD VSS sg13g2_decap_4
XFILLER_140_1065 VDD VSS sg13g2_decap_8
XFILLER_147_765 VDD VSS sg13g2_decap_8
XFILLER_147_776 VDD VSS sg13g2_fill_2
XFILLER_105_1196 VDD VSS sg13g2_decap_8
XFILLER_134_404 VDD VSS sg13g2_decap_8
XFILLER_14_1079 VDD VSS sg13g2_decap_8
XFILLER_179_1253 VDD VSS sg13g2_decap_8
X_08074_ _08074_/X _08422_/S _08074_/B _08074_/C VDD VSS sg13g2_and3_1
XFILLER_101_1049 VDD VSS sg13g2_fill_2
XFILLER_106_106 VDD VSS sg13g2_decap_8
XFILLER_140_1098 VDD VSS sg13g2_decap_8
XFILLER_162_735 VDD VSS sg13g2_decap_8
XFILLER_134_437 VDD VSS sg13g2_decap_4
XFILLER_20_49 VDD VSS sg13g2_decap_8
XFILLER_175_1139 VDD VSS sg13g2_decap_8
XFILLER_115_640 VDD VSS sg13g2_fill_1
XFILLER_161_256 VDD VSS sg13g2_decap_8
X_14924__2719 _14924_/RESET_B VDD VSS sg13g2_tiehi
XFILLER_103_802 VDD VSS sg13g2_decap_8
XFILLER_66_1445 VDD VSS sg13g2_decap_8
XFILLER_0_406 VDD VSS sg13g2_decap_8
XFILLER_114_150 VDD VSS sg13g2_fill_1
XFILLER_27_1418 VDD VSS sg13g2_decap_8
XFILLER_114_172 VDD VSS sg13g2_fill_2
XFILLER_142_492 VDD VSS sg13g2_fill_1
XFILLER_88_546 VDD VSS sg13g2_decap_8
XFILLER_29_14 VDD VSS sg13g2_decap_8
XFILLER_102_356 VDD VSS sg13g2_decap_8
X_08976_ _08977_/B _10675_/B _10675_/C VDD VSS sg13g2_nor2_1
XFILLER_88_579 VDD VSS sg13g2_decap_4
XFILLER_69_760 VDD VSS sg13g2_decap_8
XFILLER_25_1131 VDD VSS sg13g2_decap_8
XFILLER_130_687 VDD VSS sg13g2_decap_4
X_15180__2870 _15180_/RESET_B VDD VSS sg13g2_tiehi
X_07927_ _07927_/Y _07922_/Y _07904_/A _07926_/X VDD VSS sg13g2_a21oi_1
XFILLER_5_1225 VDD VSS sg13g2_decap_8
XFILLER_21_1006 VDD VSS sg13g2_decap_8
X_07858_ _07858_/X _15014_/Q _12084_/A VDD VSS sg13g2_and2_1
XFILLER_99_1265 VDD VSS sg13g2_decap_4
XFILLER_57_988 VDD VSS sg13g2_decap_8
XFILLER_186_1224 VDD VSS sg13g2_decap_8
XFILLER_84_774 VDD VSS sg13g2_decap_8
XFILLER_99_1298 VDD VSS sg13g2_fill_2
XFILLER_28_189 VDD VSS sg13g2_decap_8
X_07789_ _08391_/B _07790_/A _15003_/Q VDD VSS sg13g2_nor2_1
XFILLER_25_830 VDD VSS sg13g2_fill_2
X_09528_ _14127_/D _09860_/A1 _14127_/Q _09538_/S VDD VSS sg13g2_mux2_1
XFILLER_43_159 VDD VSS sg13g2_decap_8
XFILLER_73_1416 VDD VSS sg13g2_decap_8
XFILLER_40_800 VDD VSS sg13g2_decap_8
X_09459_ _14060_/D _09989_/A0 _14060_/Q _09461_/S VDD VSS sg13g2_mux2_1
XFILLER_40_822 VDD VSS sg13g2_decap_8
XFILLER_24_384 VDD VSS sg13g2_fill_2
XFILLER_12_535 VDD VSS sg13g2_decap_8
XFILLER_51_192 VDD VSS sg13g2_decap_8
X_12470_ _12471_/B _13685_/Q _12651_/A2 _12469_/X _12386_/A _12651_/C1 VDD VSS sg13g2_a221oi_1
XFILLER_61_56 VDD VSS sg13g2_decap_8
XFILLER_40_877 VDD VSS sg13g2_decap_8
XFILLER_36_1271 VDD VSS sg13g2_decap_8
XFILLER_138_721 VDD VSS sg13g2_decap_8
XFILLER_61_67 VDD VSS sg13g2_fill_2
XFILLER_32_1113 VDD VSS sg13g2_decap_8
XFILLER_71_1173 VDD VSS sg13g2_decap_8
XFILLER_162_1290 VDD VSS sg13g2_decap_8
X_14575__1627 _14575_/RESET_B VDD VSS sg13g2_tiehi
X_11421_ _11422_/A _13951_/Q _13983_/Q _14015_/Q _14047_/Q _11826_/A1 _11374_/C VDD
+ VSS sg13g2_mux4_1
XFILLER_123_1263 VDD VSS sg13g2_decap_8
XFILLER_177_67 VDD VSS sg13g2_decap_8
XFILLER_184_359 VDD VSS sg13g2_decap_8
X_15048__2552 _15048_/RESET_B VDD VSS sg13g2_tiehi
X_14611__1591 _14611_/RESET_B VDD VSS sg13g2_tiehi
XFILLER_6_18 VDD VSS sg13g2_decap_8
XFILLER_10_1400 VDD VSS sg13g2_decap_8
XFILLER_126_927 VDD VSS sg13g2_decap_8
X_14140_ _14140_/Q _14588_/CLK _14140_/D _14140_/RESET_B VDD VSS sg13g2_dfrbpq_1
X_11352_ _11361_/B _11346_/Y _11351_/Y _11834_/A2 VDD VSS sg13g2_o21ai_1
XFILLER_152_201 VDD VSS sg13g2_decap_8
XFILLER_158_1326 VDD VSS sg13g2_decap_8
XFILLER_3_200 VDD VSS sg13g2_decap_8
X_10303_ _10306_/C _14794_/Q _10299_/Y hold3109/X VDD VSS sg13g2_a21oi_1
X_14071_ _14071_/Q clkload44/A _14071_/D _14071_/RESET_B VDD VSS sg13g2_dfrbpq_1
XFILLER_125_459 VDD VSS sg13g2_fill_1
X_11283_ _11283_/Y _11283_/A _11283_/B VDD VSS sg13g2_nand2_1
XFILLER_4_756 VDD VSS sg13g2_decap_8
XFILLER_10_1477 VDD VSS sg13g2_fill_2
X_13022_ _13042_/A _14908_/Q _13679_/Q VDD VSS sg13g2_nand2_1
XFILLER_140_418 VDD VSS sg13g2_fill_1
XFILLER_152_278 VDD VSS sg13g2_fill_1
XFILLER_180_587 VDD VSS sg13g2_decap_8
X_10234_ _10234_/Y _14771_/Q _14772_/Q _14773_/Q _10234_/D VDD VSS sg13g2_nand4_1
XFILLER_3_277 VDD VSS sg13g2_decap_8
Xfanout1001 _08751_/A1 _13343_/B VDD VSS sg13g2_buf_1
XFILLER_117_1045 VDD VSS sg13g2_fill_2
Xfanout1012 _10137_/A _15065_/Q VDD VSS sg13g2_buf_1
X_10165_ _14742_/D _14742_/Q _10165_/A1 _10169_/S VDD VSS sg13g2_mux2_1
XFILLER_67_708 VDD VSS sg13g2_decap_8
XFILLER_120_131 VDD VSS sg13g2_decap_8
Xfanout1023 _09161_/S _13305_/A VDD VSS sg13g2_buf_1
Xfanout1034 _13412_/B _15057_/Q VDD VSS sg13g2_buf_1
XFILLER_79_579 VDD VSS sg13g2_decap_8
XFILLER_48_900 VDD VSS sg13g2_decap_8
Xfanout1045 _08383_/B _15004_/Q VDD VSS sg13g2_buf_1
XFILLER_94_516 VDD VSS sg13g2_decap_8
XFILLER_43_1231 VDD VSS sg13g2_decap_8
Xfanout1056 _12403_/B1 _14993_/Q VDD VSS sg13g2_buf_1
XFILLER_0_995 VDD VSS sg13g2_decap_8
X_14973_ _14973_/Q _15230_/CLK _14973_/D _14973_/RESET_B VDD VSS sg13g2_dfrbpq_1
Xfanout1067 _08241_/A _08244_/B VDD VSS sg13g2_buf_1
X_10096_ _14676_/D _10096_/A0 _14676_/Q _10096_/S VDD VSS sg13g2_mux2_1
XFILLER_19_112 VDD VSS sg13g2_decap_8
Xfanout1078 _13525_/A _14991_/Q VDD VSS sg13g2_buf_1
XFILLER_48_944 VDD VSS sg13g2_decap_4
XFILLER_47_421 VDD VSS sg13g2_decap_8
XFILLER_130_1223 VDD VSS sg13g2_decap_8
Xfanout1089 _07627_/A _08084_/S1 VDD VSS sg13g2_buf_1
XFILLER_48_955 VDD VSS sg13g2_decap_8
XFILLER_130_1234 VDD VSS sg13g2_fill_1
X_13924_ _13924_/Q clkload52/A _13924_/D _13924_/RESET_B VDD VSS sg13g2_dfrbpq_1
XFILLER_19_156 VDD VSS sg13g2_decap_8
XFILLER_19_91 VDD VSS sg13g2_decap_8
XFILLER_90_700 VDD VSS sg13g2_decap_8
XFILLER_74_251 VDD VSS sg13g2_decap_8
XFILLER_48_999 VDD VSS sg13g2_fill_1
XFILLER_130_1278 VDD VSS sg13g2_decap_8
XFILLER_169_1455 VDD VSS sg13g2_decap_8
XFILLER_78_1338 VDD VSS sg13g2_decap_8
XFILLER_62_402 VDD VSS sg13g2_fill_2
XFILLER_35_627 VDD VSS sg13g2_decap_8
XFILLER_165_1308 VDD VSS sg13g2_decap_8
X_13855_ _13855_/Q _14495_/CLK _13855_/D _13855_/RESET_B VDD VSS sg13g2_dfrbpq_1
XFILLER_179_109 VDD VSS sg13g2_decap_8
X_12806_ _12806_/Y _14863_/Q _12895_/B VDD VSS sg13g2_nand2_1
XFILLER_76_1040 VDD VSS sg13g2_fill_1
XFILLER_16_863 VDD VSS sg13g2_decap_4
XFILLER_62_468 VDD VSS sg13g2_decap_4
XFILLER_50_608 VDD VSS sg13g2_decap_4
X_13786_ _13786_/Q clkload76/A _13786_/D _13786_/RESET_B VDD VSS sg13g2_dfrbpq_1
X_10998_ _10998_/Y _11017_/A1 _10992_/X _10997_/Y VDD VSS sg13g2_a21oi_1
XFILLER_50_619 VDD VSS sg13g2_decap_8
XFILLER_43_682 VDD VSS sg13g2_decap_8
X_12737_ _12750_/A _07737_/A _07737_/B _15017_/Q VDD VSS sg13g2_a21oi_1
XFILLER_30_321 VDD VSS sg13g2_decap_4
XFILLER_54_1360 VDD VSS sg13g2_decap_8
X_12668_ _12668_/X _14258_/Q _14290_/Q _14322_/Q _14354_/Q _12675_/S0 _12675_/S1 VDD
+ VSS sg13g2_mux4_1
X_15250__2724 _15250_/RESET_B VDD VSS sg13g2_tiehi
XFILLER_128_220 VDD VSS sg13g2_decap_8
X_14407_ _14407_/Q clkload11/A _14407_/D _14407_/RESET_B VDD VSS sg13g2_dfrbpq_1
XFILLER_30_387 VDD VSS sg13g2_decap_8
XFILLER_102_1303 VDD VSS sg13g2_decap_8
XFILLER_15_1355 VDD VSS sg13g2_decap_8
X_11619_ _11619_/Y _11621_/S0 _13926_/Q _11802_/B VDD VSS sg13g2_a21oi_1
XFILLER_117_905 VDD VSS sg13g2_decap_8
XFILLER_50_1246 VDD VSS sg13g2_decap_8
XFILLER_102_1325 VDD VSS sg13g2_decap_8
XFILLER_141_1374 VDD VSS sg13g2_decap_8
X_12599_ _12599_/X _14573_/Q _14605_/Q _14637_/Q _14669_/Q _12643_/S0 _12643_/S1 VDD
+ VSS sg13g2_mux4_1
XFILLER_11_1219 VDD VSS sg13g2_decap_8
XFILLER_184_882 VDD VSS sg13g2_decap_4
X_14338_ _14338_/Q clkload5/A _14338_/D _14338_/RESET_B VDD VSS sg13g2_dfrbpq_1
XFILLER_144_735 VDD VSS sg13g2_decap_8
XFILLER_176_1415 VDD VSS sg13g2_decap_8
XFILLER_102_1369 VDD VSS sg13g2_fill_1
XFILLER_128_297 VDD VSS sg13g2_decap_4
XFILLER_171_543 VDD VSS sg13g2_decap_4
X_14269_ _14269_/Q _14417_/CLK _14269_/D _14269_/RESET_B VDD VSS sg13g2_dfrbpq_1
XFILLER_131_407 VDD VSS sg13g2_fill_1
XFILLER_83_1011 VDD VSS sg13g2_decap_8
XFILLER_100_1082 VDD VSS sg13g2_decap_8
XFILLER_143_289 VDD VSS sg13g2_fill_1
XFILLER_48_1153 VDD VSS sg13g2_decap_8
XFILLER_98_833 VDD VSS sg13g2_decap_8
XFILLER_83_1044 VDD VSS sg13g2_decap_4
XFILLER_174_1161 VDD VSS sg13g2_decap_8
XFILLER_98_844 VDD VSS sg13g2_fill_1
XFILLER_112_654 VDD VSS sg13g2_decap_8
X_08830_ _08830_/X _13613_/B _13613_/C _08830_/C VDD VSS sg13g2_or3_1
XFILLER_97_343 VDD VSS sg13g2_decap_8
XFILLER_111_131 VDD VSS sg13g2_decap_8
XFILLER_140_963 VDD VSS sg13g2_decap_4
XFILLER_111_142 VDD VSS sg13g2_fill_2
XFILLER_85_505 VDD VSS sg13g2_decap_8
XFILLER_135_1167 VDD VSS sg13g2_fill_1
XFILLER_85_516 VDD VSS sg13g2_fill_2
XFILLER_83_1099 VDD VSS sg13g2_decap_8
XFILLER_39_911 VDD VSS sg13g2_decap_4
X_08761_ _08761_/Y _13129_/B _13469_/B VDD VSS sg13g2_nor2_1
XFILLER_57_218 VDD VSS sg13g2_fill_2
XFILLER_100_849 VDD VSS sg13g2_fill_1
XFILLER_111_175 VDD VSS sg13g2_decap_8
XFILLER_26_1473 VDD VSS sg13g2_decap_4
XFILLER_111_186 VDD VSS sg13g2_fill_2
XFILLER_113_1432 VDD VSS sg13g2_decap_8
XFILLER_85_549 VDD VSS sg13g2_decap_8
XFILLER_39_944 VDD VSS sg13g2_fill_1
XFILLER_39_955 VDD VSS sg13g2_decap_8
XFILLER_113_1443 VDD VSS sg13g2_fill_1
X_07712_ _07713_/A _11241_/C _11241_/A VDD VSS sg13g2_nor2_1
XFILLER_61_1386 VDD VSS sg13g2_decap_8
X_08692_ _08693_/C _08692_/A _12298_/A _08692_/C VDD VSS sg13g2_nand3_1
XFILLER_66_774 VDD VSS sg13g2_fill_1
X_14653__1549 _14653_/RESET_B VDD VSS sg13g2_tiehi
XFILLER_96_1427 VDD VSS sg13g2_decap_8
XFILLER_0_1100 VDD VSS sg13g2_decap_8
X_07643_ _10299_/A _14785_/Q VDD VSS sg13g2_inv_1
XFILLER_66_796 VDD VSS sg13g2_decap_8
XFILLER_93_593 VDD VSS sg13g2_fill_2
XFILLER_179_610 VDD VSS sg13g2_decap_4
XFILLER_94_1151 VDD VSS sg13g2_decap_8
XFILLER_0_1177 VDD VSS sg13g2_decap_8
XFILLER_59_1282 VDD VSS sg13g2_decap_8
XFILLER_55_1113 VDD VSS sg13g2_fill_1
X_09313_ _13920_/D _10143_/A1 _13920_/Q _09333_/S VDD VSS sg13g2_mux2_1
XFILLER_90_1004 VDD VSS sg13g2_decap_8
XFILLER_15_49 VDD VSS sg13g2_decap_8
XFILLER_146_1263 VDD VSS sg13g2_decap_8
XFILLER_55_1146 VDD VSS sg13g2_decap_8
XFILLER_142_1127 VDD VSS sg13g2_decap_8
XFILLER_181_1176 VDD VSS sg13g2_decap_8
X_09244_ _13853_/D _13853_/Q _09875_/A0 _09272_/S VDD VSS sg13g2_mux2_1
XFILLER_166_315 VDD VSS sg13g2_decap_8
XFILLER_22_877 VDD VSS sg13g2_decap_8
XFILLER_107_1258 VDD VSS sg13g2_decap_8
XFILLER_178_175 VDD VSS sg13g2_decap_4
XFILLER_33_1422 VDD VSS sg13g2_decap_8
X_15021__2589 _15021_/RESET_B VDD VSS sg13g2_tiehi
X_09175_ _13791_/D _13791_/Q _09745_/A1 _09196_/S VDD VSS sg13g2_mux2_1
XFILLER_147_562 VDD VSS sg13g2_decap_8
X_08126_ _08126_/Y _08212_/A _08126_/B VDD VSS sg13g2_nand2_1
XFILLER_147_48 VDD VSS sg13g2_decap_8
XFILLER_147_584 VDD VSS sg13g2_fill_1
XFILLER_134_223 VDD VSS sg13g2_decap_8
XFILLER_135_746 VDD VSS sg13g2_decap_8
X_15131__2718 _15131_/RESET_B VDD VSS sg13g2_tiehi
XFILLER_134_234 VDD VSS sg13g2_decap_8
XFILLER_107_459 VDD VSS sg13g2_decap_8
X_08057_ _08057_/Y _08056_/B _08052_/Y _08056_/Y VDD VSS sg13g2_o21ai_1
XFILLER_103_7 VDD VSS sg13g2_fill_2
XFILLER_116_960 VDD VSS sg13g2_fill_1
XFILLER_66_1242 VDD VSS sg13g2_decap_8
XFILLER_0_203 VDD VSS sg13g2_decap_8
XFILLER_103_610 VDD VSS sg13g2_decap_8
XFILLER_116_993 VDD VSS sg13g2_decap_8
XFILLER_162_598 VDD VSS sg13g2_decap_8
Xoutput48 mem_axi_araddr[19] _16872_/A VDD VSS sg13g2_buf_1
XFILLER_89_833 VDD VSS sg13g2_fill_1
XFILLER_163_14 VDD VSS sg13g2_decap_8
Xoutput59 mem_axi_araddr[2] _16855_/A VDD VSS sg13g2_buf_1
XFILLER_27_1215 VDD VSS sg13g2_decap_8
Xhold3120 _13621_/A _13729_/Q VDD VSS sg13g2_dlygate4sd3_1
XFILLER_157_1392 VDD VSS sg13g2_decap_8
Xhold3131 _13632_/A _13740_/Q VDD VSS sg13g2_dlygate4sd3_1
XFILLER_88_332 VDD VSS sg13g2_decap_8
XFILLER_153_1234 VDD VSS sg13g2_fill_1
Xhold3142 _13617_/A _13725_/Q VDD VSS sg13g2_dlygate4sd3_1
XFILLER_7_1309 VDD VSS sg13g2_decap_8
Xhold3153 hold3153/X _15105_/Q VDD VSS sg13g2_dlygate4sd3_1
Xhold3164 _13547_/A _15147_/Q VDD VSS sg13g2_dlygate4sd3_1
XFILLER_131_996 VDD VSS sg13g2_decap_8
Xhold3175 hold3175/X _14928_/Q VDD VSS sg13g2_dlygate4sd3_1
XFILLER_102_164 VDD VSS sg13g2_decap_4
X_08959_ _09204_/D _10793_/A _08969_/C VDD VSS sg13g2_nor2_1
XFILLER_5_1022 VDD VSS sg13g2_decap_8
X_14868__2831 _14868_/RESET_B VDD VSS sg13g2_tiehi
XFILLER_29_432 VDD VSS sg13g2_decap_8
XFILLER_29_443 VDD VSS sg13g2_fill_2
X_11970_ _11971_/B _11970_/A _11970_/B _11970_/C VDD VSS sg13g2_nand3_1
XFILLER_99_1051 VDD VSS sg13g2_fill_2
XFILLER_91_519 VDD VSS sg13g2_fill_1
XFILLER_56_56 VDD VSS sg13g2_decap_8
XFILLER_45_914 VDD VSS sg13g2_decap_4
XFILLER_40_1459 VDD VSS sg13g2_decap_8
XFILLER_72_722 VDD VSS sg13g2_decap_8
XFILLER_17_638 VDD VSS sg13g2_decap_8
X_10921_ _10921_/Y _10920_/A _10920_/B _07649_/A VDD VSS sg13g2_o21ai_1
XFILLER_5_1099 VDD VSS sg13g2_decap_8
XFILLER_186_1043 VDD VSS sg13g2_decap_8
X_14629__1573 _14629_/RESET_B VDD VSS sg13g2_tiehi
XFILLER_72_733 VDD VSS sg13g2_fill_1
XFILLER_16_137 VDD VSS sg13g2_fill_2
XFILLER_71_232 VDD VSS sg13g2_decap_4
XFILLER_38_1300 VDD VSS sg13g2_decap_8
X_13640_ _13748_/D _13640_/A VDD VSS sg13g2_buf_1
X_10852_ _10852_/X _10870_/A _10897_/D VDD VSS sg13g2_xor2_1
XFILLER_72_11 VDD VSS sg13g2_fill_2
XFILLER_73_1213 VDD VSS sg13g2_decap_8
XFILLER_25_682 VDD VSS sg13g2_decap_8
XFILLER_129_1472 VDD VSS sg13g2_fill_2
XFILLER_13_833 VDD VSS sg13g2_fill_2
X_13571_ _13571_/Y _14997_/Q _13566_/B _13569_/S _15013_/Q _13517_/X VDD VSS sg13g2_a221oi_1
X_10783_ _10783_/Y _13245_/A _11133_/B VDD VSS sg13g2_nand2_1
XFILLER_71_298 VDD VSS sg13g2_decap_4
XFILLER_25_693 VDD VSS sg13g2_fill_1
XFILLER_185_602 VDD VSS sg13g2_decap_8
XFILLER_38_1377 VDD VSS sg13g2_decap_8
XFILLER_34_1208 VDD VSS sg13g2_decap_8
XFILLER_164_1385 VDD VSS sg13g2_decap_8
XFILLER_125_1347 VDD VSS sg13g2_decap_8
XFILLER_12_343 VDD VSS sg13g2_decap_8
XFILLER_160_1227 VDD VSS sg13g2_decap_8
X_12522_ _12522_/X _13959_/Q _13991_/Q _14023_/Q _14055_/Q _12576_/S0 _12576_/S1 VDD
+ VSS sg13g2_mux4_1
XFILLER_13_877 VDD VSS sg13g2_decap_4
XFILLER_9_826 VDD VSS sg13g2_decap_8
X_15241_ _15241_/Q clkload48/A _15241_/D _15241_/RESET_B VDD VSS sg13g2_dfrbpq_1
X_12453_ _12453_/X _12448_/X _12452_/X _12447_/X _12451_/X _12650_/S _12649_/S0 VDD
+ VSS sg13g2_mux4_1
XFILLER_8_347 VDD VSS sg13g2_decap_8
XFILLER_166_860 VDD VSS sg13g2_decap_8
XFILLER_173_819 VDD VSS sg13g2_fill_1
XFILLER_184_156 VDD VSS sg13g2_decap_8
XFILLER_185_679 VDD VSS sg13g2_decap_4
X_11404_ _11404_/Y _11402_/Y _11401_/Y _11422_/B _11403_/X VDD VSS sg13g2_a22oi_1
XFILLER_138_584 VDD VSS sg13g2_decap_8
X_15172_ _15172_/Q clkload82/A _15172_/D _15172_/RESET_B VDD VSS sg13g2_dfrbpq_1
X_12384_ _12384_/X _12378_/X _12382_/X _12377_/X _12381_/X _12609_/S _12705_/S0 VDD
+ VSS sg13g2_mux4_1
X_14123_ _14123_/Q _14729_/CLK _14123_/D _14123_/RESET_B VDD VSS sg13g2_dfrbpq_1
X_11335_ _11335_/X _11335_/A _13691_/Q VDD VSS sg13g2_or2_1
XFILLER_21_81 VDD VSS sg13g2_decap_8
XFILLER_119_1107 VDD VSS sg13g2_fill_1
XFILLER_141_705 VDD VSS sg13g2_decap_4
XFILLER_4_553 VDD VSS sg13g2_decap_8
XFILLER_10_1274 VDD VSS sg13g2_decap_8
XFILLER_137_70 VDD VSS sg13g2_fill_1
XFILLER_181_896 VDD VSS sg13g2_decap_8
XFILLER_125_289 VDD VSS sg13g2_decap_8
X_14054_ _14054_/Q clkload50/A _14054_/D _14054_/RESET_B VDD VSS sg13g2_dfrbpq_1
X_11266_ _11266_/Y _11266_/A _11266_/B VDD VSS sg13g2_nand2_1
XFILLER_171_1301 VDD VSS sg13g2_decap_8
XFILLER_140_237 VDD VSS sg13g2_decap_4
XFILLER_45_1326 VDD VSS sg13g2_decap_8
X_13005_ _15033_/D _13005_/A _13005_/B _13005_/C VDD VSS sg13g2_nand3_1
X_10217_ _14765_/D _10195_/S _10322_/C _10216_/Y VDD VSS sg13g2_a21oi_1
XFILLER_122_963 VDD VSS sg13g2_fill_1
XFILLER_84_1386 VDD VSS sg13g2_decap_8
XFILLER_136_1465 VDD VSS sg13g2_decap_8
X_11197_ _11197_/X _11197_/A _11197_/B VDD VSS sg13g2_and2_1
XFILLER_80_1228 VDD VSS sg13g2_decap_8
XFILLER_95_814 VDD VSS sg13g2_decap_8
XFILLER_171_1378 VDD VSS sg13g2_decap_8
X_10148_ _14725_/D _14725_/Q _10148_/A1 _10156_/S VDD VSS sg13g2_mux2_1
XFILLER_94_313 VDD VSS sg13g2_fill_2
XFILLER_0_792 VDD VSS sg13g2_decap_8
XFILLER_95_869 VDD VSS sg13g2_decap_4
XFILLER_130_1031 VDD VSS sg13g2_decap_4
X_14956_ _14956_/Q clkload74/A _14956_/D _14956_/RESET_B VDD VSS sg13g2_dfrbpq_1
X_10079_ _14659_/D _10113_/A0 _14659_/Q _10092_/S VDD VSS sg13g2_mux2_1
XFILLER_94_379 VDD VSS sg13g2_decap_4
XFILLER_36_914 VDD VSS sg13g2_decap_8
XFILLER_78_1113 VDD VSS sg13g2_decap_8
XFILLER_130_1064 VDD VSS sg13g2_fill_2
X_13907_ _13907_/Q clkload39/A _13907_/D _13907_/RESET_B VDD VSS sg13g2_dfrbpq_1
XFILLER_169_1252 VDD VSS sg13g2_decap_8
X_14887_ _14887_/Q clkload88/A _14887_/D _14887_/RESET_B VDD VSS sg13g2_dfrbpq_1
XFILLER_1_1442 VDD VSS sg13g2_decap_8
XFILLER_63_766 VDD VSS sg13g2_decap_8
XFILLER_23_608 VDD VSS sg13g2_decap_8
X_13838_ _13838_/Q _14670_/CLK _13838_/D _13838_/RESET_B VDD VSS sg13g2_dfrbpq_1
XFILLER_95_1471 VDD VSS sg13g2_decap_8
XFILLER_62_276 VDD VSS sg13g2_decap_8
XFILLER_56_1444 VDD VSS sg13g2_decap_8
XFILLER_17_1406 VDD VSS sg13g2_decap_8
X_13769_ _13769_/Q _14729_/CLK _13769_/D _13769_/RESET_B VDD VSS sg13g2_dfrbpq_1
XFILLER_91_1346 VDD VSS sg13g2_decap_8
XFILLER_15_181 VDD VSS sg13g2_fill_1
XFILLER_182_1474 VDD VSS sg13g2_decap_4
XFILLER_176_613 VDD VSS sg13g2_decap_8
XFILLER_52_1319 VDD VSS sg13g2_decap_8
XFILLER_148_326 VDD VSS sg13g2_decap_8
XFILLER_31_674 VDD VSS sg13g2_decap_8
XFILLER_30_151 VDD VSS sg13g2_decap_8
XFILLER_143_1469 VDD VSS sg13g2_fill_1
XFILLER_175_123 VDD VSS sg13g2_decap_8
XFILLER_129_540 VDD VSS sg13g2_decap_8
XFILLER_15_1152 VDD VSS sg13g2_decap_8
XFILLER_129_551 VDD VSS sg13g2_fill_2
X_14067__2135 _14067_/RESET_B VDD VSS sg13g2_tiehi
XFILLER_11_1016 VDD VSS sg13g2_decap_8
XFILLER_89_1242 VDD VSS sg13g2_fill_2
XFILLER_116_212 VDD VSS sg13g2_decap_8
XFILLER_176_1212 VDD VSS sg13g2_decap_8
XFILLER_116_223 VDD VSS sg13g2_fill_2
XFILLER_156_392 VDD VSS sg13g2_decap_8
XFILLER_102_1177 VDD VSS sg13g2_decap_8
XFILLER_117_768 VDD VSS sg13g2_decap_8
XFILLER_171_340 VDD VSS sg13g2_decap_8
XFILLER_116_256 VDD VSS sg13g2_decap_8
XFILLER_172_885 VDD VSS sg13g2_decap_8
XFILLER_89_107 VDD VSS sg13g2_fill_2
XFILLER_137_1218 VDD VSS sg13g2_fill_2
XFILLER_172_1109 VDD VSS sg13g2_decap_8
X_15006__2604 _15006_/RESET_B VDD VSS sg13g2_tiehi
X_09931_ _14516_/D _14516_/Q _09931_/A1 _09931_/S VDD VSS sg13g2_mux2_1
XFILLER_176_1289 VDD VSS sg13g2_decap_8
X_14707__1495 _14707_/RESET_B VDD VSS sg13g2_tiehi
Xfanout805 _12748_/S _12776_/S VDD VSS sg13g2_buf_1
Xfanout816 _12775_/S1 _12663_/S1 VDD VSS sg13g2_buf_1
XFILLER_113_963 VDD VSS sg13g2_decap_4
Xfanout827 _12605_/S1 fanout828/X VDD VSS sg13g2_buf_1
X_09862_ _14449_/D _14449_/Q _09961_/A1 _09870_/S VDD VSS sg13g2_mux2_1
Xfanout838 _12480_/S1 fanout841/X VDD VSS sg13g2_buf_1
XFILLER_98_674 VDD VSS sg13g2_fill_2
XFILLER_100_602 VDD VSS sg13g2_decap_8
Xfanout849 _12661_/S1 _12674_/S1 VDD VSS sg13g2_buf_1
XFILLER_58_527 VDD VSS sg13g2_fill_2
X_08813_ _08813_/Y _07720_/C _12347_/B _08727_/D _15180_/Q _13390_/A2 VDD VSS sg13g2_a221oi_1
XFILLER_133_28 VDD VSS sg13g2_decap_8
XFILLER_6_1320 VDD VSS sg13g2_decap_8
XFILLER_112_495 VDD VSS sg13g2_fill_2
X_09793_ _14382_/D _10157_/A1 _14382_/Q _09793_/S VDD VSS sg13g2_mux2_1
XFILLER_86_869 VDD VSS sg13g2_fill_1
XFILLER_26_1270 VDD VSS sg13g2_decap_8
XFILLER_22_1112 VDD VSS sg13g2_fill_2
XFILLER_39_752 VDD VSS sg13g2_decap_4
X_08744_ _13666_/D _08753_/A1 _08742_/Y _08743_/Y VDD VSS sg13g2_a21oi_1
XFILLER_61_1183 VDD VSS sg13g2_decap_8
XFILLER_27_914 VDD VSS sg13g2_decap_8
XFILLER_113_1262 VDD VSS sg13g2_decap_8
XFILLER_96_1202 VDD VSS sg13g2_decap_8
XFILLER_6_1397 VDD VSS sg13g2_decap_8
XFILLER_22_1167 VDD VSS sg13g2_decap_8
XFILLER_39_796 VDD VSS sg13g2_decap_8
XFILLER_2_1239 VDD VSS sg13g2_decap_8
X_08675_ _08675_/Y _08035_/X _08671_/Y _08674_/Y VDD VSS sg13g2_o21ai_1
XFILLER_54_733 VDD VSS sg13g2_decap_8
XFILLER_27_958 VDD VSS sg13g2_decap_8
XFILLER_27_969 VDD VSS sg13g2_fill_2
XFILLER_57_1219 VDD VSS sg13g2_decap_8
X_07626_ _07626_/Y _08009_/S VDD VSS sg13g2_inv_1
XFILLER_81_563 VDD VSS sg13g2_decap_8
XFILLER_42_917 VDD VSS sg13g2_decap_4
XFILLER_148_1369 VDD VSS sg13g2_fill_2
XFILLER_81_585 VDD VSS sg13g2_decap_8
X_14277__1925 _14277_/RESET_B VDD VSS sg13g2_tiehi
XFILLER_42_14 VDD VSS sg13g2_decap_8
XFILLER_158_14 VDD VSS sg13g2_decap_8
XFILLER_166_112 VDD VSS sg13g2_decap_8
XFILLER_139_348 VDD VSS sg13g2_decap_8
XFILLER_10_847 VDD VSS sg13g2_decap_8
XFILLER_139_359 VDD VSS sg13g2_fill_2
XFILLER_167_668 VDD VSS sg13g2_fill_2
X_09227_ _13838_/D _10157_/A1 _13838_/Q _09227_/S VDD VSS sg13g2_mux2_1
XFILLER_155_819 VDD VSS sg13g2_fill_2
XFILLER_182_627 VDD VSS sg13g2_decap_8
XFILLER_108_724 VDD VSS sg13g2_decap_8
XFILLER_166_189 VDD VSS sg13g2_decap_8
X_14492__1710 _14492_/RESET_B VDD VSS sg13g2_tiehi
X_09158_ _09158_/Y _09158_/A _09158_/B _09158_/C VDD VSS sg13g2_nand3_1
XFILLER_181_126 VDD VSS sg13g2_decap_8
XFILLER_33_1296 VDD VSS sg13g2_decap_8
X_08109_ _08452_/A _08137_/S1 _08402_/B _08023_/Y _08101_/Y VDD VSS sg13g2_a22oi_1
X_09089_ _09090_/C _14911_/Q _13064_/A _09089_/C _09103_/D VDD VSS sg13g2_nand4_1
XFILLER_159_1465 VDD VSS sg13g2_decap_8
XFILLER_101_4 VDD VSS sg13g2_decap_8
XFILLER_174_35 VDD VSS sg13g2_decap_8
XFILLER_122_204 VDD VSS sg13g2_fill_2
X_11120_ _11127_/A _11012_/B _11012_/C _11119_/Y VDD VSS sg13g2_o21ai_1
XFILLER_162_373 VDD VSS sg13g2_decap_8
XFILLER_150_524 VDD VSS sg13g2_decap_8
XFILLER_116_790 VDD VSS sg13g2_decap_8
XFILLER_66_1050 VDD VSS sg13g2_fill_2
XFILLER_89_641 VDD VSS sg13g2_decap_8
X_11051_ _11051_/Y _11064_/D _11051_/B VDD VSS sg13g2_xnor2_1
XFILLER_67_11 VDD VSS sg13g2_fill_2
XFILLER_66_1083 VDD VSS sg13g2_decap_4
XFILLER_1_567 VDD VSS sg13g2_decap_8
XFILLER_7_1106 VDD VSS sg13g2_decap_8
X_13765__2437 _13765_/RESET_B VDD VSS sg13g2_tiehi
XFILLER_114_1004 VDD VSS sg13g2_decap_8
XFILLER_118_1173 VDD VSS sg13g2_decap_4
X_10002_ _14585_/D _10101_/A0 _14585_/Q _10002_/S VDD VSS sg13g2_mux2_1
XFILLER_153_1064 VDD VSS sg13g2_decap_8
XFILLER_103_484 VDD VSS sg13g2_decap_8
XFILLER_118_1195 VDD VSS sg13g2_decap_8
XFILLER_130_281 VDD VSS sg13g2_decap_8
X_14810_ _14810_/Q clkload85/A _14810_/D _14810_/RESET_B VDD VSS sg13g2_dfrbpq_1
XFILLER_18_903 VDD VSS sg13g2_decap_8
XFILLER_64_508 VDD VSS sg13g2_decap_8
XFILLER_131_1351 VDD VSS sg13g2_decap_8
XFILLER_92_828 VDD VSS sg13g2_decap_8
XFILLER_29_240 VDD VSS sg13g2_fill_1
XFILLER_57_560 VDD VSS sg13g2_decap_8
XFILLER_40_1256 VDD VSS sg13g2_decap_8
XFILLER_29_262 VDD VSS sg13g2_fill_2
XFILLER_123_61 VDD VSS sg13g2_decap_8
X_14741_ _14741_/Q clkload37/A _14741_/D _14741_/RESET_B VDD VSS sg13g2_dfrbpq_1
XFILLER_79_1444 VDD VSS sg13g2_decap_8
XFILLER_18_958 VDD VSS sg13g2_decap_8
X_11953_ _11953_/Y _11953_/A _11953_/B _11971_/C VDD VSS sg13g2_nand3_1
XFILLER_83_32 VDD VSS sg13g2_decap_8
XFILLER_17_446 VDD VSS sg13g2_fill_2
XFILLER_18_969 VDD VSS sg13g2_fill_2
X_13980__2222 _13980_/RESET_B VDD VSS sg13g2_tiehi
X_14145__2057 _14145_/RESET_B VDD VSS sg13g2_tiehi
X_10904_ _10907_/A _10888_/Y _10904_/B VDD VSS sg13g2_nand2b_1
X_14672_ _14672_/Q clkload14/A _14672_/D _14672_/RESET_B VDD VSS sg13g2_dfrbpq_1
XFILLER_44_254 VDD VSS sg13g2_decap_8
XFILLER_166_1458 VDD VSS sg13g2_decap_8
X_11884_ _11884_/Y _11765_/A _11883_/X _11625_/C VDD VSS sg13g2_a21oi_1
XFILLER_33_939 VDD VSS sg13g2_fill_2
X_13623_ _13731_/D _13623_/A VDD VSS sg13g2_buf_1
XFILLER_32_438 VDD VSS sg13g2_fill_2
X_10835_ _10835_/Y _10827_/B _10816_/Y _10834_/Y _10429_/D _10886_/B1 VDD VSS sg13g2_a221oi_1
XFILLER_16_81 VDD VSS sg13g2_decap_8
XFILLER_158_613 VDD VSS sg13g2_decap_8
XFILLER_38_1174 VDD VSS sg13g2_decap_8
XFILLER_12_140 VDD VSS sg13g2_decap_8
XFILLER_160_1013 VDD VSS sg13g2_decap_8
XFILLER_164_1182 VDD VSS sg13g2_decap_8
X_13554_ _15149_/D _15149_/Q _13553_/Y _13554_/S VDD VSS sg13g2_mux2_1
X_10766_ _14918_/D _11168_/B1 _11115_/B _10765_/Y VDD VSS sg13g2_o21ai_1
XFILLER_9_623 VDD VSS sg13g2_decap_8
XFILLER_34_1027 VDD VSS sg13g2_decap_8
XFILLER_160_1046 VDD VSS sg13g2_decap_8
XFILLER_186_966 VDD VSS sg13g2_decap_8
X_12505_ _12505_/X _14566_/Q _14598_/Q _14630_/Q _14662_/Q _12506_/S0 _12506_/S1 VDD
+ VSS sg13g2_mux4_1
X_13485_ _13486_/A _15171_/D _13485_/B VDD VSS sg13g2_nor2_1
X_10697_ _10697_/X _10697_/A _10697_/B _10697_/C VDD VSS sg13g2_and3_1
XFILLER_8_144 VDD VSS sg13g2_decap_8
XFILLER_173_616 VDD VSS sg13g2_decap_4
XFILLER_185_476 VDD VSS sg13g2_decap_8
XFILLER_103_1442 VDD VSS sg13g2_decap_8
X_15224_ _15224_/Q _15228_/CLK _15224_/D _15224_/RESET_B VDD VSS sg13g2_dfrbpq_1
X_12436_ _12436_/X _13953_/Q _13985_/Q _14017_/Q _14049_/Q _12450_/S0 _12450_/S1 VDD
+ VSS sg13g2_mux4_1
XFILLER_66_7 VDD VSS sg13g2_decap_8
XFILLER_32_91 VDD VSS sg13g2_decap_8
XFILLER_172_137 VDD VSS sg13g2_decap_8
XFILLER_51_1396 VDD VSS sg13g2_decap_8
XFILLER_12_1369 VDD VSS sg13g2_decap_8
XFILLER_86_1426 VDD VSS sg13g2_decap_8
XFILLER_5_840 VDD VSS sg13g2_decap_8
X_15155_ _15155_/Q _15160_/CLK _15155_/D _15155_/RESET_B VDD VSS sg13g2_dfrbpq_1
X_12367_ _12367_/X _13820_/Q _13852_/Q _13884_/Q _13916_/Q _12752_/S0 _12752_/S1 VDD
+ VSS sg13g2_mux4_1
XFILLER_153_362 VDD VSS sg13g2_decap_8
XFILLER_173_1407 VDD VSS sg13g2_decap_8
XFILLER_4_350 VDD VSS sg13g2_decap_8
X_14106_ _14106_/Q clkload77/A _14106_/D _14106_/RESET_B VDD VSS sg13g2_dfrbpq_1
XFILLER_10_1071 VDD VSS sg13g2_decap_8
X_11318_ _11318_/Y _11318_/A _11318_/B VDD VSS sg13g2_nand2_1
X_15086_ _15086_/Q clkload70/A _15086_/D _15086_/RESET_B VDD VSS sg13g2_dfrbpq_1
X_12298_ _12298_/Y _12298_/A _12298_/B VDD VSS sg13g2_nor2_1
X_14037_ _14037_/Q _14677_/CLK _14037_/D _14037_/RESET_B VDD VSS sg13g2_dfrbpq_1
X_11249_ _11249_/Y _12799_/A _11724_/B VDD VSS sg13g2_nor2_1
XFILLER_122_771 VDD VSS sg13g2_fill_2
X_15182__2862 _15182_/RESET_B VDD VSS sg13g2_tiehi
XFILLER_67_302 VDD VSS sg13g2_fill_1
X_14355__1847 _14355_/RESET_B VDD VSS sg13g2_tiehi
XFILLER_171_1175 VDD VSS sg13g2_decap_8
XFILLER_95_633 VDD VSS sg13g2_decap_8
XFILLER_79_184 VDD VSS sg13g2_decap_8
XFILLER_110_966 VDD VSS sg13g2_decap_8
XFILLER_132_1159 VDD VSS sg13g2_decap_8
XFILLER_110_1413 VDD VSS sg13g2_fill_2
XFILLER_23_1465 VDD VSS sg13g2_decap_8
XFILLER_82_316 VDD VSS sg13g2_fill_2
X_14939_ _14939_/Q clkload59/A _14939_/D _14939_/RESET_B VDD VSS sg13g2_dfrbpq_1
XFILLER_63_530 VDD VSS sg13g2_decap_8
X_08460_ _08461_/D _08212_/A _08458_/X _08459_/Y VDD VSS sg13g2_o21ai_1
XFILLER_169_1082 VDD VSS sg13g2_fill_2
X_14570__1632 _14570_/RESET_B VDD VSS sg13g2_tiehi
XFILLER_93_1419 VDD VSS sg13g2_decap_8
XFILLER_51_725 VDD VSS sg13g2_decap_8
XFILLER_36_799 VDD VSS sg13g2_decap_8
XFILLER_24_939 VDD VSS sg13g2_fill_2
XFILLER_50_202 VDD VSS sg13g2_decap_8
XFILLER_90_382 VDD VSS sg13g2_decap_8
X_08391_ _08391_/Y _08391_/A _08391_/B VDD VSS sg13g2_nor2_1
XFILLER_56_1241 VDD VSS sg13g2_decap_8
XFILLER_143_1200 VDD VSS sg13g2_decap_8
XFILLER_17_1203 VDD VSS sg13g2_decap_8
XFILLER_92_0 VDD VSS sg13g2_decap_8
XFILLER_182_1271 VDD VSS sg13g2_decap_8
X_14852__2863 _14852_/RESET_B VDD VSS sg13g2_tiehi
XFILLER_52_1116 VDD VSS sg13g2_decap_8
XFILLER_108_1353 VDD VSS sg13g2_decap_8
XFILLER_50_279 VDD VSS sg13g2_decap_8
XFILLER_104_1206 VDD VSS sg13g2_fill_2
XFILLER_31_471 VDD VSS sg13g2_fill_2
XFILLER_176_443 VDD VSS sg13g2_decap_8
XFILLER_164_605 VDD VSS sg13g2_decap_8
X_13843__2359 _13843_/RESET_B VDD VSS sg13g2_tiehi
XFILLER_12_28 VDD VSS sg13g2_decap_8
XFILLER_143_1299 VDD VSS sg13g2_decap_8
XFILLER_176_476 VDD VSS sg13g2_decap_4
X_09012_ _09012_/Y _14902_/Q _09022_/D _09024_/A VDD VSS sg13g2_o21ai_1
XFILLER_148_178 VDD VSS sg13g2_decap_8
XFILLER_30_1447 VDD VSS sg13g2_decap_8
XFILLER_89_1050 VDD VSS sg13g2_decap_8
XFILLER_117_543 VDD VSS sg13g2_decap_4
X_14885__2797 _14885_/RESET_B VDD VSS sg13g2_tiehi
XFILLER_89_1061 VDD VSS sg13g2_fill_2
XFILLER_145_863 VDD VSS sg13g2_decap_8
XFILLER_145_874 VDD VSS sg13g2_fill_2
XFILLER_105_738 VDD VSS sg13g2_fill_1
XFILLER_132_524 VDD VSS sg13g2_decap_4
XFILLER_171_170 VDD VSS sg13g2_decap_4
XFILLER_137_1048 VDD VSS sg13g2_decap_8
XFILLER_137_1059 VDD VSS sg13g2_fill_1
Xfanout602 _11133_/B _11196_/B VDD VSS sg13g2_buf_1
X_09914_ _14499_/D _14499_/Q _09914_/A1 _09927_/S VDD VSS sg13g2_mux2_1
XFILLER_8_1404 VDD VSS sg13g2_decap_8
XFILLER_67_1381 VDD VSS sg13g2_decap_8
Xfanout613 _10735_/A _10740_/A1 VDD VSS sg13g2_buf_1
XFILLER_28_1343 VDD VSS sg13g2_decap_8
Xfanout624 _10710_/A2 _08877_/A VDD VSS sg13g2_buf_1
XFILLER_86_600 VDD VSS sg13g2_decap_8
Xfanout635 _08900_/A2 _08831_/Y VDD VSS sg13g2_buf_1
XFILLER_24_1207 VDD VSS sg13g2_decap_8
XFILLER_154_1373 VDD VSS sg13g2_decap_8
Xfanout646 _13392_/A2 _08724_/Y VDD VSS sg13g2_buf_1
Xfanout657 _08522_/C _07994_/X VDD VSS sg13g2_buf_1
X_09845_ _14432_/D _14432_/Q _10010_/A0 _09858_/S VDD VSS sg13g2_mux2_1
XFILLER_63_1267 VDD VSS sg13g2_decap_8
Xfanout668 _13030_/A2 fanout671/X VDD VSS sg13g2_buf_1
XFILLER_101_955 VDD VSS sg13g2_decap_8
XFILLER_112_292 VDD VSS sg13g2_decap_8
Xfanout679 _10886_/B1 _10824_/C1 VDD VSS sg13g2_buf_1
XFILLER_101_966 VDD VSS sg13g2_fill_2
XFILLER_37_14 VDD VSS sg13g2_decap_8
XFILLER_74_817 VDD VSS sg13g2_decap_8
XFILLER_100_465 VDD VSS sg13g2_decap_8
X_09776_ _14365_/D _10140_/A1 _14365_/Q _09799_/S VDD VSS sg13g2_mux2_1
XFILLER_86_688 VDD VSS sg13g2_decap_8
XFILLER_73_305 VDD VSS sg13g2_decap_8
XFILLER_37_69 VDD VSS sg13g2_decap_8
X_08727_ _08727_/X _15129_/Q _15124_/Q _15071_/Q _08727_/D VDD VSS sg13g2_or4_1
XFILLER_6_1194 VDD VSS sg13g2_decap_8
XFILLER_27_733 VDD VSS sg13g2_decap_4
XFILLER_2_1036 VDD VSS sg13g2_decap_8
XFILLER_113_1092 VDD VSS sg13g2_decap_4
XFILLER_148_1122 VDD VSS sg13g2_decap_8
X_14400__1802 _14400_/RESET_B VDD VSS sg13g2_tiehi
X_08658_ _08659_/C _08029_/Y _08591_/X _08511_/X _08599_/A _08657_/Y VDD VSS sg13g2_a221oi_1
XFILLER_42_714 VDD VSS sg13g2_decap_8
XFILLER_96_1076 VDD VSS sg13g2_decap_8
XFILLER_148_1155 VDD VSS sg13g2_decap_8
XFILLER_183_1057 VDD VSS sg13g2_decap_8
XFILLER_41_224 VDD VSS sg13g2_decap_8
XFILLER_81_393 VDD VSS sg13g2_decap_8
XFILLER_53_46 VDD VSS sg13g2_fill_1
X_08589_ _08596_/B _13533_/A _08252_/Y _08652_/B1 VDD VSS sg13g2_o21ai_1
XFILLER_42_769 VDD VSS sg13g2_decap_8
XFILLER_30_909 VDD VSS sg13g2_decap_8
XFILLER_126_1420 VDD VSS sg13g2_decap_8
XFILLER_169_35 VDD VSS sg13g2_decap_8
XFILLER_74_1352 VDD VSS sg13g2_decap_8
XFILLER_35_1303 VDD VSS sg13g2_decap_8
XFILLER_23_950 VDD VSS sg13g2_fill_2
XFILLER_149_4 VDD VSS sg13g2_fill_2
X_10620_ _10623_/B _10651_/D _10622_/C _14882_/Q VDD VSS sg13g2_a21oi_1
XFILLER_167_421 VDD VSS sg13g2_decap_8
XFILLER_70_1238 VDD VSS sg13g2_decap_8
XFILLER_161_1366 VDD VSS sg13g2_decap_8
X_10551_ _14865_/D _14865_/Q _10556_/D _10550_/Y VDD VSS sg13g2_a21oi_1
XFILLER_10_644 VDD VSS sg13g2_decap_8
XFILLER_154_104 VDD VSS sg13g2_decap_8
XFILLER_182_413 VDD VSS sg13g2_decap_8
X_14433__1769 _14433_/RESET_B VDD VSS sg13g2_tiehi
XFILLER_167_498 VDD VSS sg13g2_decap_8
X_13819__2383 _13819_/RESET_B VDD VSS sg13g2_tiehi
XFILLER_183_958 VDD VSS sg13g2_decap_8
X_13270_ _13271_/B _13270_/A _13270_/B _13270_/C VDD VSS sg13g2_nand3_1
X_10482_ _14848_/D _10482_/A _10481_/Y VDD VSS sg13g2_nor2b_1
XFILLER_33_1082 VDD VSS sg13g2_decap_8
XFILLER_6_648 VDD VSS sg13g2_decap_8
XFILLER_185_56 VDD VSS sg13g2_decap_8
X_12221_ _12221_/Y _12143_/A _12220_/Y _12263_/C VDD VSS sg13g2_o21ai_1
XFILLER_5_147 VDD VSS sg13g2_decap_8
XFILLER_136_874 VDD VSS sg13g2_decap_8
XFILLER_159_1262 VDD VSS sg13g2_decap_8
XFILLER_108_598 VDD VSS sg13g2_decap_8
XFILLER_118_61 VDD VSS sg13g2_decap_4
XFILLER_11_1380 VDD VSS sg13g2_decap_8
X_12152_ _12153_/B _12152_/A _13666_/Q VDD VSS sg13g2_nand2_1
XFILLER_78_21 VDD VSS sg13g2_decap_8
XFILLER_68_1167 VDD VSS sg13g2_decap_8
XFILLER_29_1118 VDD VSS sg13g2_decap_4
X_13998__2204 _13998_/RESET_B VDD VSS sg13g2_tiehi
X_11103_ _11118_/D _11202_/A _11115_/B VDD VSS sg13g2_xnor2_1
XFILLER_46_1421 VDD VSS sg13g2_decap_8
XFILLER_2_854 VDD VSS sg13g2_decap_8
XFILLER_155_1159 VDD VSS sg13g2_decap_8
X_12083_ _12198_/A _12084_/A _13668_/Q VDD VSS sg13g2_nor2_1
XFILLER_78_76 VDD VSS sg13g2_decap_8
XFILLER_1_364 VDD VSS sg13g2_decap_8
X_11034_ _11034_/Y _15117_/Q _11042_/D _11023_/Y VDD VSS sg13g2_a21oi_1
XFILLER_81_1356 VDD VSS sg13g2_decap_8
XFILLER_104_793 VDD VSS sg13g2_decap_8
XFILLER_77_666 VDD VSS sg13g2_decap_8
XFILLER_49_357 VDD VSS sg13g2_decap_8
XFILLER_77_677 VDD VSS sg13g2_fill_1
XFILLER_37_508 VDD VSS sg13g2_fill_2
XFILLER_76_154 VDD VSS sg13g2_decap_4
Xclkbuf_5_2__f_clk_i clkbuf_leaf_8_clk_i/A clkbuf_4_1_0_clk_i/X VDD VSS sg13g2_buf_16
XFILLER_94_53 VDD VSS sg13g2_decap_8
XFILLER_18_733 VDD VSS sg13g2_fill_1
XFILLER_92_647 VDD VSS sg13g2_decap_8
X_12985_ _13009_/A _14906_/Q _13681_/Q VDD VSS sg13g2_nand2_1
XFILLER_80_809 VDD VSS sg13g2_fill_1
XFILLER_40_1075 VDD VSS sg13g2_decap_8
XFILLER_92_669 VDD VSS sg13g2_fill_1
X_14724_ _14724_/Q _14724_/CLK _14724_/D _14724_/RESET_B VDD VSS sg13g2_dfrbpq_1
XFILLER_79_1274 VDD VSS sg13g2_decap_8
X_11936_ _12055_/B _11936_/A _13129_/B VDD VSS sg13g2_xnor2_1
XFILLER_73_872 VDD VSS sg13g2_decap_8
XFILLER_60_500 VDD VSS sg13g2_fill_2
XFILLER_166_1255 VDD VSS sg13g2_decap_8
XFILLER_127_1228 VDD VSS sg13g2_decap_8
X_14655_ _14655_/Q _14655_/CLK _14655_/D _14655_/RESET_B VDD VSS sg13g2_dfrbpq_1
XFILLER_92_1430 VDD VSS sg13g2_decap_8
X_11867_ _11868_/C _11867_/A _11867_/B _11910_/C VDD VSS sg13g2_nand3_1
XFILLER_60_544 VDD VSS sg13g2_fill_2
X_13606_ _13606_/Y _12801_/Y _13600_/Y _08830_/X VDD VSS sg13g2_o21ai_1
X_10818_ _10818_/Y _10818_/A _10818_/B VDD VSS sg13g2_nor2_1
XFILLER_60_577 VDD VSS sg13g2_decap_8
X_14586_ _14586_/Q _14682_/CLK _14586_/D _14586_/RESET_B VDD VSS sg13g2_dfrbpq_1
X_11798_ _12056_/A _11798_/A _13676_/Q VDD VSS sg13g2_xor2_1
XFILLER_53_1447 VDD VSS sg13g2_decap_8
XFILLER_9_420 VDD VSS sg13g2_decap_8
XFILLER_41_791 VDD VSS sg13g2_decap_8
XFILLER_186_763 VDD VSS sg13g2_decap_8
X_13537_ _13537_/X _14994_/Q _13566_/C VDD VSS sg13g2_and2_1
X_10749_ _11068_/B _14946_/Q _10752_/A _10747_/Y VDD VSS sg13g2_a21o_1
XFILLER_185_273 VDD VSS sg13g2_decap_8
X_13468_ _13469_/D _15173_/Q _15174_/Q _15175_/Q _13468_/D VDD VSS sg13g2_nor4_1
X_14409__1793 _14409_/RESET_B VDD VSS sg13g2_tiehi
XFILLER_9_497 VDD VSS sg13g2_decap_8
XFILLER_173_446 VDD VSS sg13g2_decap_8
XFILLER_51_1193 VDD VSS sg13g2_decap_8
X_15207_ _15207_/Q clkload73/A _15207_/D _15207_/RESET_B VDD VSS sg13g2_dfrbpq_1
XFILLER_127_863 VDD VSS sg13g2_decap_4
X_12419_ _12419_/X _13952_/Q _13984_/Q _14016_/Q _14048_/Q _12698_/S0 _12698_/S1 VDD
+ VSS sg13g2_mux4_1
XFILLER_12_1166 VDD VSS sg13g2_decap_8
XFILLER_127_885 VDD VSS sg13g2_decap_8
XFILLER_138_1302 VDD VSS sg13g2_decap_8
X_13399_ _15087_/D _13455_/A _13396_/D _13398_/Y VDD VSS sg13g2_o21ai_1
XFILLER_154_682 VDD VSS sg13g2_decap_4
XFILLER_47_1207 VDD VSS sg13g2_decap_8
XFILLER_173_1204 VDD VSS sg13g2_decap_8
XFILLER_177_1373 VDD VSS sg13g2_decap_8
X_15138_ _15138_/Q _15139_/CLK _15138_/D _15138_/RESET_B VDD VSS sg13g2_dfrbpq_1
XFILLER_142_844 VDD VSS sg13g2_fill_2
XFILLER_153_170 VDD VSS sg13g2_decap_8
XFILLER_99_224 VDD VSS sg13g2_decap_8
XFILLER_141_321 VDD VSS sg13g2_fill_1
XFILLER_88_909 VDD VSS sg13g2_decap_8
XFILLER_141_332 VDD VSS sg13g2_decap_8
X_14588__1614 _14588_/RESET_B VDD VSS sg13g2_tiehi
X_15069_ _15069_/Q _15188_/CLK _15069_/D _15069_/RESET_B VDD VSS sg13g2_dfrbpq_1
X_07960_ _07960_/Y _08434_/B _07906_/B _07959_/Y VDD VSS sg13g2_a21oi_1
XFILLER_68_611 VDD VSS sg13g2_decap_4
XFILLER_4_84 VDD VSS sg13g2_decap_8
XFILLER_96_942 VDD VSS sg13g2_fill_1
X_07891_ _07917_/B _07893_/B _08256_/B VDD VSS sg13g2_nor2_1
X_09630_ _14226_/D _09630_/A0 _14226_/Q _09637_/S VDD VSS sg13g2_mux2_1
XFILLER_95_463 VDD VSS sg13g2_fill_2
XFILLER_56_828 VDD VSS sg13g2_decap_8
XFILLER_7_1470 VDD VSS sg13g2_decap_8
XFILLER_68_688 VDD VSS sg13g2_decap_8
XFILLER_83_625 VDD VSS sg13g2_decap_8
XFILLER_23_1262 VDD VSS sg13g2_decap_8
XFILLER_3_1334 VDD VSS sg13g2_decap_8
X_09561_ _14159_/D _09860_/A1 _14159_/Q _09571_/S VDD VSS sg13g2_mux2_1
XFILLER_97_1330 VDD VSS sg13g2_decap_8
XFILLER_55_338 VDD VSS sg13g2_decap_8
XFILLER_110_1232 VDD VSS sg13g2_fill_2
XFILLER_82_135 VDD VSS sg13g2_fill_1
X_08512_ _08512_/Y _08212_/A _08339_/Y _08539_/B1 VDD VSS sg13g2_a21oi_1
XFILLER_97_1363 VDD VSS sg13g2_decap_8
XFILLER_93_1205 VDD VSS sg13g2_decap_8
XFILLER_24_703 VDD VSS sg13g2_fill_2
X_09492_ _14092_/D _09989_/A0 _14092_/Q _09494_/S VDD VSS sg13g2_mux2_1
XFILLER_58_1336 VDD VSS sg13g2_decap_8
XFILLER_36_574 VDD VSS sg13g2_decap_8
XFILLER_23_202 VDD VSS sg13g2_decap_4
XFILLER_169_708 VDD VSS sg13g2_decap_8
XFILLER_184_1366 VDD VSS sg13g2_decap_8
XFILLER_23_224 VDD VSS sg13g2_fill_2
X_08443_ _08443_/Y _08443_/A _08443_/B VDD VSS sg13g2_nor2_1
XFILLER_145_1339 VDD VSS sg13g2_decap_8
XFILLER_90_190 VDD VSS sg13g2_decap_8
XFILLER_17_1011 VDD VSS sg13g2_decap_8
X_08374_ _08374_/Y _08544_/C _08374_/B VDD VSS sg13g2_nor2_1
XFILLER_139_16 VDD VSS sg13g2_decap_8
XFILLER_149_443 VDD VSS sg13g2_decap_8
XFILLER_32_791 VDD VSS sg13g2_fill_2
XFILLER_165_914 VDD VSS sg13g2_decap_8
XFILLER_139_38 VDD VSS sg13g2_decap_8
XFILLER_17_1077 VDD VSS sg13g2_decap_8
XFILLER_109_318 VDD VSS sg13g2_fill_2
XFILLER_20_964 VDD VSS sg13g2_decap_4
XFILLER_118_841 VDD VSS sg13g2_decap_8
XFILLER_30_1244 VDD VSS sg13g2_decap_8
XFILLER_117_340 VDD VSS sg13g2_decap_8
XFILLER_178_1159 VDD VSS sg13g2_decap_8
XFILLER_180_928 VDD VSS sg13g2_decap_4
XFILLER_105_502 VDD VSS sg13g2_decap_8
XFILLER_117_373 VDD VSS sg13g2_decap_8
XFILLER_156_1413 VDD VSS sg13g2_decap_8
XFILLER_69_1465 VDD VSS sg13g2_decap_8
XFILLER_145_693 VDD VSS sg13g2_decap_8
XFILLER_160_630 VDD VSS sg13g2_decap_8
XFILLER_105_546 VDD VSS sg13g2_decap_4
XFILLER_8_1201 VDD VSS sg13g2_decap_8
Xfanout410 _09167_/S _08965_/Y VDD VSS sg13g2_buf_1
Xfanout1408 _10595_/B _10608_/B VDD VSS sg13g2_buf_1
XFILLER_28_1140 VDD VSS sg13g2_decap_8
Xfanout421 _11015_/C _10722_/Y VDD VSS sg13g2_buf_1
Xfanout1419 _07737_/A _13400_/B VDD VSS sg13g2_buf_1
XFILLER_87_920 VDD VSS sg13g2_decap_8
Xfanout432 fanout432/X _10004_/Y VDD VSS sg13g2_buf_1
XFILLER_99_791 VDD VSS sg13g2_fill_1
Xfanout443 _09838_/S _09826_/S VDD VSS sg13g2_buf_1
XFILLER_48_35 VDD VSS sg13g2_decap_8
XFILLER_24_1004 VDD VSS sg13g2_decap_8
XFILLER_171_14 VDD VSS sg13g2_decap_8
Xfanout454 _09672_/S _09661_/S VDD VSS sg13g2_buf_1
XFILLER_150_1023 VDD VSS sg13g2_decap_8
Xfanout465 _09523_/S _09527_/S VDD VSS sg13g2_buf_1
Xfanout476 _09401_/S fanout480/X VDD VSS sg13g2_buf_1
XFILLER_8_1278 VDD VSS sg13g2_decap_8
XFILLER_59_666 VDD VSS sg13g2_decap_8
X_13682__2531 _13682_/RESET_B VDD VSS sg13g2_tiehi
Xfanout487 _09229_/S _09225_/S VDD VSS sg13g2_buf_1
X_09828_ _14416_/D _09960_/A1 _14416_/Q _09828_/S VDD VSS sg13g2_mux2_1
XFILLER_87_986 VDD VSS sg13g2_decap_8
XFILLER_48_79 VDD VSS sg13g2_decap_8
Xfanout498 _08932_/S _08935_/S VDD VSS sg13g2_buf_1
XFILLER_101_785 VDD VSS sg13g2_decap_8
XFILLER_59_699 VDD VSS sg13g2_decap_8
XFILLER_74_647 VDD VSS sg13g2_fill_1
XFILLER_41_1362 VDD VSS sg13g2_decap_8
XFILLER_104_63 VDD VSS sg13g2_decap_8
X_09759_ _14349_/D _14349_/Q _09891_/A0 _09762_/S VDD VSS sg13g2_mux2_1
XFILLER_27_541 VDD VSS sg13g2_decap_4
XFILLER_73_168 VDD VSS sg13g2_decap_8
XFILLER_15_714 VDD VSS sg13g2_decap_8
X_12770_ _12770_/X _14137_/Q _14169_/Q _14201_/Q _14233_/Q _12773_/S0 _12773_/S1 VDD
+ VSS sg13g2_mux4_1
X_14933__2701 _14933_/RESET_B VDD VSS sg13g2_tiehi
XFILLER_76_1436 VDD VSS sg13g2_decap_8
X_14062__2140 _14062_/RESET_B VDD VSS sg13g2_tiehi
X_11721_ _11721_/Y _14908_/Q _11792_/B _11722_/B2 VDD VSS sg13g2_a21oi_1
XFILLER_15_769 VDD VSS sg13g2_decap_8
XFILLER_120_40 VDD VSS sg13g2_fill_2
X_14440_ _14440_/Q _14728_/CLK _14440_/D _14440_/RESET_B VDD VSS sg13g2_dfrbpq_1
X_11652_ _11652_/X _11644_/X _11645_/X _11648_/X _11649_/X _11971_/C _11956_/B1 VDD
+ VSS sg13g2_mux4_1
XFILLER_39_1280 VDD VSS sg13g2_decap_8
XFILLER_126_1250 VDD VSS sg13g2_decap_4
XFILLER_168_741 VDD VSS sg13g2_decap_8
X_14666__1536 _14666_/RESET_B VDD VSS sg13g2_tiehi
X_10603_ _10608_/C _14877_/Q _10610_/D _14878_/Q VDD VSS sg13g2_a21oi_1
XFILLER_70_1035 VDD VSS sg13g2_fill_1
XFILLER_126_1272 VDD VSS sg13g2_decap_8
X_14371_ _14371_/Q clkload9/A _14371_/D _14371_/RESET_B VDD VSS sg13g2_dfrbpq_1
XFILLER_11_953 VDD VSS sg13g2_decap_8
XFILLER_161_1163 VDD VSS sg13g2_decap_8
X_11583_ _11583_/X _11575_/X _11576_/X _11579_/X _11580_/X _11964_/B _11974_/B1 VDD
+ VSS sg13g2_mux4_1
XFILLER_10_441 VDD VSS sg13g2_decap_8
XFILLER_128_616 VDD VSS sg13g2_decap_8
XFILLER_155_402 VDD VSS sg13g2_decap_8
XFILLER_35_1177 VDD VSS sg13g2_decap_8
XFILLER_156_936 VDD VSS sg13g2_decap_8
XFILLER_7_924 VDD VSS sg13g2_decap_8
XFILLER_122_1147 VDD VSS sg13g2_fill_1
XFILLER_13_60 VDD VSS sg13g2_decap_8
X_13322_ _15064_/D _13322_/A _13322_/B VDD VSS sg13g2_nand2_1
X_10534_ _10535_/B _14860_/Q _14859_/Q _13218_/A _10543_/C VDD VSS sg13g2_nand4_1
XFILLER_182_221 VDD VSS sg13g2_decap_8
XFILLER_129_60 VDD VSS sg13g2_fill_1
XFILLER_13_1453 VDD VSS sg13g2_decap_8
XFILLER_155_457 VDD VSS sg13g2_decap_4
XFILLER_6_445 VDD VSS sg13g2_decap_8
XFILLER_183_777 VDD VSS sg13g2_decap_8
X_14810__2926 _14810_/RESET_B VDD VSS sg13g2_tiehi
XFILLER_129_82 VDD VSS sg13g2_decap_8
X_13253_ _13253_/Y _13262_/B1 _13251_/Y _13252_/X _13048_/X VDD VSS sg13g2_a22oi_1
X_10465_ _10468_/B _10471_/C _10471_/D _10500_/A VDD VSS sg13g2_a21oi_1
X_12204_ _12204_/Y _12204_/A _12272_/A VDD VSS sg13g2_xnor2_1
XFILLER_124_833 VDD VSS sg13g2_decap_8
XFILLER_159_1070 VDD VSS sg13g2_fill_1
XFILLER_182_298 VDD VSS sg13g2_decap_8
X_13184_ _15045_/D _13266_/A _13184_/B VDD VSS sg13g2_nor2_1
X_10396_ _10397_/C _14818_/Q _14819_/Q _10396_/C _10396_/D VDD VSS sg13g2_nand4_1
XFILLER_89_86 VDD VSS sg13g2_decap_8
X_15034__2576 _15034_/RESET_B VDD VSS sg13g2_tiehi
X_12135_ _12135_/X _13845_/Q _13877_/Q _13909_/Q _13941_/Q _12135_/S0 _12135_/S1 VDD
+ VSS sg13g2_mux4_1
XFILLER_2_651 VDD VSS sg13g2_decap_8
XFILLER_69_419 VDD VSS sg13g2_decap_8
XFILLER_111_516 VDD VSS sg13g2_decap_8
XFILLER_81_1131 VDD VSS sg13g2_decap_8
XFILLER_1_161 VDD VSS sg13g2_decap_8
XFILLER_172_1270 VDD VSS sg13g2_decap_8
X_12066_ _12066_/X _14131_/Q _14163_/Q _14195_/Q _14227_/Q _12135_/S0 _12135_/S1 VDD
+ VSS sg13g2_mux4_1
XFILLER_133_1232 VDD VSS sg13g2_fill_1
XFILLER_29_7 VDD VSS sg13g2_decap_8
XFILLER_46_1295 VDD VSS sg13g2_decap_8
X_11017_ _11017_/Y _11017_/A1 _11016_/Y _11044_/C VDD VSS sg13g2_o21ai_1
X_14272__1930 _14272_/RESET_B VDD VSS sg13g2_tiehi
X_16874_ _16874_/X _16874_/A VDD VSS sg13g2_buf_1
XFILLER_78_997 VDD VSS sg13g2_decap_8
XFILLER_93_934 VDD VSS sg13g2_decap_8
XFILLER_168_1328 VDD VSS sg13g2_decap_8
XFILLER_20_1424 VDD VSS sg13g2_decap_8
XFILLER_64_135 VDD VSS sg13g2_fill_2
XFILLER_18_541 VDD VSS sg13g2_decap_8
XFILLER_161_91 VDD VSS sg13g2_decap_8
XFILLER_93_989 VDD VSS sg13g2_decap_4
X_12968_ _12968_/Y input22/X _12795_/Y _12937_/Y VDD VSS sg13g2_o21ai_1
XFILLER_46_883 VDD VSS sg13g2_fill_1
XFILLER_45_360 VDD VSS sg13g2_decap_4
XFILLER_92_499 VDD VSS sg13g2_decap_8
XFILLER_166_1041 VDD VSS sg13g2_decap_8
XFILLER_33_522 VDD VSS sg13g2_fill_1
X_14707_ _14707_/Q clkload39/A _14707_/D _14707_/RESET_B VDD VSS sg13g2_dfrbpq_1
X_11919_ _11919_/X _13743_/Q _14095_/Q _14447_/Q _14543_/Q _12072_/S0 _12072_/S1 VDD
+ VSS sg13g2_mux4_1
XFILLER_61_853 VDD VSS sg13g2_decap_8
X_12899_ _12902_/C _12899_/A _12900_/C _12899_/C input27/X VDD VSS sg13g2_nand4_1
XFILLER_127_1036 VDD VSS sg13g2_decap_4
XFILLER_33_566 VDD VSS sg13g2_decap_8
X_14638_ _14638_/Q clkload19/A _14638_/D _14638_/RESET_B VDD VSS sg13g2_dfrbpq_1
XFILLER_57_1380 VDD VSS sg13g2_decap_8
XFILLER_14_791 VDD VSS sg13g2_decap_4
XFILLER_18_1364 VDD VSS sg13g2_decap_8
XFILLER_92_1293 VDD VSS sg13g2_fill_1
XFILLER_53_1244 VDD VSS sg13g2_decap_8
XFILLER_20_238 VDD VSS sg13g2_decap_8
XFILLER_186_560 VDD VSS sg13g2_decap_8
X_14569_ _14569_/Q _14665_/CLK _14569_/D _14569_/RESET_B VDD VSS sg13g2_dfrbpq_1
XFILLER_144_1383 VDD VSS sg13g2_decap_4
XFILLER_147_947 VDD VSS sg13g2_decap_8
XFILLER_140_1247 VDD VSS sg13g2_decap_8
X_08090_ _08090_/Y _13427_/C _08090_/B _08090_/C VDD VSS sg13g2_nor3_1
XFILLER_140_1258 VDD VSS sg13g2_fill_1
XFILLER_147_958 VDD VSS sg13g2_decap_8
XFILLER_179_1435 VDD VSS sg13g2_decap_8
Xclkload20 clkload20/Y clkload20/A VDD VSS sg13g2_inv_1
XFILLER_9_294 VDD VSS sg13g2_decap_8
X_13760__2442 _13760_/RESET_B VDD VSS sg13g2_tiehi
XFILLER_173_254 VDD VSS sg13g2_decap_8
Xclkload31 clkload31/X clkload31/A VDD VSS sg13g2_buf_8
Xclkload42 clkload42/Y clkload42/A VDD VSS sg13g2_inv_1
Xclkload53 clkload53/Y clkload53/A VDD VSS sg13g2_inv_2
Xclkload64 clkload64/Y clkload64/A VDD VSS sg13g2_inv_4
XFILLER_161_438 VDD VSS sg13g2_decap_8
Xclkload75 clkload75/Y clkload75/A VDD VSS sg13g2_inv_2
XFILLER_177_1170 VDD VSS sg13g2_decap_8
Xclkload86 clkload86/X clkload86/A VDD VSS sg13g2_buf_8
XFILLER_138_1132 VDD VSS sg13g2_fill_1
XFILLER_154_490 VDD VSS sg13g2_fill_1
XFILLER_173_1023 VDD VSS sg13g2_decap_4
XFILLER_114_354 VDD VSS sg13g2_decap_8
XFILLER_47_1037 VDD VSS sg13g2_fill_1
XFILLER_102_505 VDD VSS sg13g2_fill_1
XFILLER_114_365 VDD VSS sg13g2_fill_2
XFILLER_115_899 VDD VSS sg13g2_fill_2
Xclkbuf_leaf_120_clk_i clkload21/A clkload1/A VDD VSS sg13g2_buf_8
X_08992_ _08992_/Y _09141_/A _08992_/B _10697_/B VDD VSS sg13g2_nand3_1
XFILLER_134_1018 VDD VSS sg13g2_decap_8
XFILLER_102_527 VDD VSS sg13g2_decap_4
XFILLER_87_227 VDD VSS sg13g2_decap_8
XFILLER_64_1351 VDD VSS sg13g2_decap_8
X_14140__2062 _14140_/RESET_B VDD VSS sg13g2_tiehi
XFILLER_29_1471 VDD VSS sg13g2_decap_8
X_07943_ _08434_/B _07797_/X _07927_/Y _07942_/Y VDD VSS sg13g2_o21ai_1
XFILLER_25_1313 VDD VSS sg13g2_decap_8
XFILLER_116_1441 VDD VSS sg13g2_fill_1
XFILLER_130_869 VDD VSS sg13g2_decap_4
XFILLER_5_1407 VDD VSS sg13g2_decap_8
XFILLER_112_1316 VDD VSS sg13g2_decap_8
X_07874_ _07876_/B _11454_/A _14994_/Q VDD VSS sg13g2_nand2_1
XFILLER_60_1259 VDD VSS sg13g2_decap_8
XFILLER_29_839 VDD VSS sg13g2_decap_4
X_14744__1458 _14744_/RESET_B VDD VSS sg13g2_tiehi
X_09613_ _14209_/D _09714_/A0 _14209_/Q _09632_/S VDD VSS sg13g2_mux2_1
XFILLER_186_1406 VDD VSS sg13g2_decap_8
XFILLER_99_1458 VDD VSS sg13g2_decap_8
XFILLER_3_1131 VDD VSS sg13g2_decap_8
XFILLER_84_989 VDD VSS sg13g2_decap_8
XFILLER_23_1092 VDD VSS sg13g2_decap_8
X_09544_ _14142_/D _09942_/A1 _14142_/Q _09556_/S VDD VSS sg13g2_mux2_1
XFILLER_71_628 VDD VSS sg13g2_decap_8
XFILLER_55_179 VDD VSS sg13g2_decap_4
XFILLER_149_1250 VDD VSS sg13g2_decap_4
XFILLER_64_691 VDD VSS sg13g2_decap_8
XFILLER_110_1095 VDD VSS sg13g2_fill_1
X_09475_ _14075_/D _10005_/A0 _14075_/Q _09506_/S VDD VSS sg13g2_mux2_1
XFILLER_52_853 VDD VSS sg13g2_decap_8
XFILLER_24_544 VDD VSS sg13g2_fill_2
XFILLER_184_1163 VDD VSS sg13g2_decap_8
XFILLER_19_1128 VDD VSS sg13g2_decap_8
XFILLER_12_717 VDD VSS sg13g2_decap_8
X_08426_ _08429_/C _08426_/A _08426_/B VDD VSS sg13g2_nor2_1
XFILLER_36_1453 VDD VSS sg13g2_decap_8
XFILLER_123_1412 VDD VSS sg13g2_fill_1
XFILLER_11_249 VDD VSS sg13g2_decap_8
XFILLER_138_914 VDD VSS sg13g2_decap_8
X_08357_ _08357_/Y _07790_/A _15003_/Q _08523_/B1 VDD VSS sg13g2_o21ai_1
XFILLER_71_1355 VDD VSS sg13g2_decap_8
XFILLER_137_402 VDD VSS sg13g2_decap_4
Xclkload3 clkload3/X clkload3/A VDD VSS sg13g2_buf_8
XFILLER_109_104 VDD VSS sg13g2_decap_4
XFILLER_20_761 VDD VSS sg13g2_decap_8
XFILLER_177_593 VDD VSS sg13g2_decap_4
XFILLER_50_25 VDD VSS sg13g2_decap_8
XFILLER_123_1467 VDD VSS sg13g2_fill_2
XFILLER_166_14 VDD VSS sg13g2_decap_8
XFILLER_20_783 VDD VSS sg13g2_decap_8
X_08288_ _08315_/C _08258_/C _14998_/Q _07768_/A _08263_/B VDD VSS sg13g2_a22oi_1
XFILLER_164_243 VDD VSS sg13g2_decap_8
XFILLER_137_468 VDD VSS sg13g2_decap_8
X_14350__1852 _14350_/RESET_B VDD VSS sg13g2_tiehi
XFILLER_106_811 VDD VSS sg13g2_fill_2
XFILLER_164_287 VDD VSS sg13g2_decap_8
XFILLER_4_938 VDD VSS sg13g2_decap_8
X_10250_ _10258_/D _14776_/Q _14777_/Q _14778_/Q _10250_/D VDD VSS sg13g2_and4_1
XFILLER_69_1262 VDD VSS sg13g2_decap_8
XFILLER_161_950 VDD VSS sg13g2_decap_8
XFILLER_65_1115 VDD VSS sg13g2_fill_2
XFILLER_105_343 VDD VSS sg13g2_decap_8
XFILLER_79_706 VDD VSS sg13g2_decap_8
XFILLER_3_459 VDD VSS sg13g2_decap_8
XFILLER_161_972 VDD VSS sg13g2_decap_4
X_10181_ _10181_/Y _13613_/A _13508_/B _10174_/Y _10179_/B VDD VSS sg13g2_a22oi_1
XFILLER_78_216 VDD VSS sg13g2_decap_4
XFILLER_132_173 VDD VSS sg13g2_decap_8
XFILLER_156_1287 VDD VSS sg13g2_decap_8
Xfanout1205 _13189_/A _14918_/Q VDD VSS sg13g2_buf_1
XFILLER_182_46 VDD VSS sg13g2_decap_8
Xfanout1216 _12835_/A _14896_/Q VDD VSS sg13g2_buf_1
XFILLER_43_1413 VDD VSS sg13g2_decap_8
XFILLER_120_335 VDD VSS sg13g2_decap_8
Xfanout1227 _10471_/C _10511_/D VDD VSS sg13g2_buf_1
Xfanout240 _11432_/A2 _11248_/B VDD VSS sg13g2_buf_1
Xfanout1238 _12836_/B _13692_/Q VDD VSS sg13g2_buf_1
Xfanout251 _10083_/A0 _10150_/A1 VDD VSS sg13g2_buf_1
Xfanout1249 _11832_/C fanout1255/X VDD VSS sg13g2_buf_1
XFILLER_87_750 VDD VSS sg13g2_fill_1
Xfanout262 _10063_/S fanout266/X VDD VSS sg13g2_buf_1
X_13940_ _13940_/Q clkload15/A _13940_/D _13940_/RESET_B VDD VSS sg13g2_dfrbpq_1
Xfanout273 _09599_/S _09589_/S VDD VSS sg13g2_buf_1
XFILLER_59_463 VDD VSS sg13g2_decap_8
Xclkbuf_5_20__f_clk_i clkbuf_leaf_96_clk_i/A clkbuf_4_10_0_clk_i/X VDD VSS sg13g2_buf_16
XFILLER_8_1075 VDD VSS sg13g2_decap_8
XFILLER_130_1416 VDD VSS sg13g2_decap_8
Xfanout284 fanout284/X _09408_/Y VDD VSS sg13g2_buf_1
XFILLER_74_400 VDD VSS sg13g2_decap_8
XFILLER_115_84 VDD VSS sg13g2_decap_8
Xfanout295 _09978_/A0 _10144_/A1 VDD VSS sg13g2_buf_1
XFILLER_87_794 VDD VSS sg13g2_decap_8
XFILLER_19_327 VDD VSS sg13g2_decap_8
XFILLER_75_44 VDD VSS sg13g2_decap_8
XFILLER_130_1449 VDD VSS sg13g2_fill_1
XFILLER_74_433 VDD VSS sg13g2_fill_2
X_13871_ _13871_/Q clkload35/A _13871_/D _13871_/RESET_B VDD VSS sg13g2_dfrbpq_1
X_15140__2700 _15140_/RESET_B VDD VSS sg13g2_tiehi
XFILLER_28_850 VDD VSS sg13g2_fill_1
X_12822_ _12822_/X _14895_/Q _12836_/B VDD VSS sg13g2_xor2_1
XFILLER_28_883 VDD VSS sg13g2_decap_8
XFILLER_74_499 VDD VSS sg13g2_fill_2
X_14003__2199 _14003_/RESET_B VDD VSS sg13g2_tiehi
X_14828__2908 _14828_/RESET_B VDD VSS sg13g2_tiehi
XFILLER_55_680 VDD VSS sg13g2_decap_8
XFILLER_28_894 VDD VSS sg13g2_fill_1
XFILLER_76_1233 VDD VSS sg13g2_decap_8
XFILLER_128_1312 VDD VSS sg13g2_fill_1
X_12753_ _12753_/X _14712_/Q _14744_/Q _13784_/Q _13816_/Q _12759_/S0 _12759_/S1 VDD
+ VSS sg13g2_mux4_1
XFILLER_61_149 VDD VSS sg13g2_decap_8
XFILLER_91_32 VDD VSS sg13g2_fill_2
XFILLER_37_1217 VDD VSS sg13g2_decap_8
X_11704_ _11707_/A _11663_/B _11771_/B _11771_/A VDD VSS sg13g2_a21o_1
XFILLER_163_1247 VDD VSS sg13g2_decap_8
XFILLER_124_1209 VDD VSS sg13g2_decap_4
X_12684_ _12684_/X _14131_/Q _14163_/Q _14195_/Q _14227_/Q _12711_/S0 _12711_/S1 VDD
+ VSS sg13g2_mux4_1
XFILLER_30_514 VDD VSS sg13g2_decap_8
XFILLER_129_903 VDD VSS sg13g2_decap_8
X_14423_ _14423_/Q clkload43/A _14423_/D _14423_/RESET_B VDD VSS sg13g2_dfrbpq_1
XFILLER_129_914 VDD VSS sg13g2_fill_1
X_11635_ _11773_/A _11635_/A _13681_/Q VDD VSS sg13g2_xnor2_1
XFILLER_50_1428 VDD VSS sg13g2_decap_8
X_14354_ _14354_/Q _14546_/CLK _14354_/D _14354_/RESET_B VDD VSS sg13g2_dfrbpq_1
XFILLER_7_721 VDD VSS sg13g2_decap_8
XFILLER_11_783 VDD VSS sg13g2_decap_8
X_11566_ _14966_/D _11566_/A _11566_/B VDD VSS sg13g2_nor2_1
XFILLER_156_755 VDD VSS sg13g2_decap_8
XFILLER_128_457 VDD VSS sg13g2_decap_8
XFILLER_13_1250 VDD VSS sg13g2_decap_8
X_13305_ _13306_/C _13305_/A _13305_/B VDD VSS sg13g2_nor2_1
XFILLER_183_563 VDD VSS sg13g2_decap_8
X_10517_ _10519_/B _10521_/C _10521_/D _14855_/Q VDD VSS sg13g2_a21oi_1
XFILLER_6_242 VDD VSS sg13g2_decap_8
X_14285_ _14285_/Q clkload24/A _14285_/D _14285_/RESET_B VDD VSS sg13g2_dfrbpq_1
XFILLER_137_980 VDD VSS sg13g2_decap_8
X_11497_ _11497_/Y _11956_/B1 _11495_/Y _11858_/A VDD VSS sg13g2_a21oi_1
XFILLER_155_287 VDD VSS sg13g2_decap_8
XFILLER_170_213 VDD VSS sg13g2_fill_2
XFILLER_7_798 VDD VSS sg13g2_decap_8
XFILLER_143_438 VDD VSS sg13g2_decap_8
XFILLER_143_449 VDD VSS sg13g2_fill_2
X_13236_ _13236_/Y _14795_/Q _13275_/A2 _13262_/B1 VDD VSS sg13g2_o21ai_1
X_10448_ _10450_/B _10453_/C _10514_/A _14839_/Q VDD VSS sg13g2_a21oi_1
XFILLER_87_1384 VDD VSS sg13g2_decap_8
XFILLER_48_1335 VDD VSS sg13g2_decap_8
XFILLER_170_268 VDD VSS sg13g2_fill_2
XFILLER_174_1343 VDD VSS sg13g2_decap_8
XFILLER_112_803 VDD VSS sg13g2_fill_1
XFILLER_124_663 VDD VSS sg13g2_decap_4
XFILLER_152_983 VDD VSS sg13g2_fill_1
X_13167_ _15044_/D _13160_/Y _13166_/Y _13155_/A VDD VSS sg13g2_a21oi_1
XFILLER_69_205 VDD VSS sg13g2_decap_8
X_10379_ _14817_/D _10379_/A _10623_/A _10379_/C VDD VSS sg13g2_nor3_1
XFILLER_170_1207 VDD VSS sg13g2_decap_8
XFILLER_151_482 VDD VSS sg13g2_fill_2
X_12118_ _12118_/Y _12116_/Y _12118_/B _12118_/C VDD VSS sg13g2_nand3b_1
XFILLER_123_195 VDD VSS sg13g2_fill_2
X_13098_ _13098_/X input13/X _13272_/A2 _13264_/B1 VDD VSS sg13g2_a21o_1
Xclkbuf_leaf_52_clk_i clkload71/A clkbuf_leaf_52_clk_i/A VDD VSS sg13g2_buf_8
X_14213__1989 _14213_/RESET_B VDD VSS sg13g2_tiehi
XFILLER_46_1092 VDD VSS sg13g2_fill_1
X_12049_ _12049_/Y _12048_/Y _11330_/S _12223_/A VDD VSS sg13g2_a21oi_1
X_15101__2790 _15101_/RESET_B VDD VSS sg13g2_tiehi
XFILLER_78_794 VDD VSS sg13g2_decap_8
XFILLER_66_934 VDD VSS sg13g2_fill_1
XFILLER_65_411 VDD VSS sg13g2_decap_4
XFILLER_133_1073 VDD VSS sg13g2_decap_8
XFILLER_77_282 VDD VSS sg13g2_decap_8
X_16857_ _16857_/X _16857_/A VDD VSS sg13g2_buf_1
XFILLER_1_63 VDD VSS sg13g2_decap_8
XFILLER_20_1221 VDD VSS sg13g2_decap_8
XFILLER_92_252 VDD VSS sg13g2_decap_8
XFILLER_19_872 VDD VSS sg13g2_decap_8
XFILLER_25_319 VDD VSS sg13g2_fill_2
XFILLER_129_1109 VDD VSS sg13g2_decap_8
XFILLER_94_1311 VDD VSS sg13g2_decap_4
XFILLER_111_1382 VDD VSS sg13g2_fill_2
XFILLER_19_894 VDD VSS sg13g2_decap_8
X_13778__2424 _13778_/RESET_B VDD VSS sg13g2_tiehi
XFILLER_34_820 VDD VSS sg13g2_decap_8
Xclkbuf_leaf_67_clk_i clkload88/A clkbuf_leaf_71_clk_i/A VDD VSS sg13g2_buf_8
XFILLER_0_1359 VDD VSS sg13g2_decap_8
XFILLER_59_1464 VDD VSS sg13g2_decap_8
XFILLER_20_1298 VDD VSS sg13g2_decap_8
XFILLER_80_469 VDD VSS sg13g2_decap_8
XFILLER_55_1328 VDD VSS sg13g2_decap_8
XFILLER_146_1445 VDD VSS sg13g2_decap_8
X_09260_ _13869_/D _13869_/Q _09891_/A0 _09263_/S VDD VSS sg13g2_mux2_1
XFILLER_181_1358 VDD VSS sg13g2_decap_8
X_08211_ _15224_/D _08211_/A _08211_/B _08211_/C _08211_/D VDD VSS sg13g2_nand4_1
XFILLER_60_182 VDD VSS sg13g2_fill_2
X_09191_ _13807_/D _13807_/Q _09827_/A0 _09200_/S VDD VSS sg13g2_mux2_1
XFILLER_18_1161 VDD VSS sg13g2_decap_8
XFILLER_105_1120 VDD VSS sg13g2_fill_2
XFILLER_21_569 VDD VSS sg13g2_decap_8
X_14158__2044 _14158_/RESET_B VDD VSS sg13g2_tiehi
X_08142_ _08142_/Y _08142_/A _08340_/A _08142_/C VDD VSS sg13g2_nand3_1
XFILLER_53_1085 VDD VSS sg13g2_decap_8
XFILLER_119_435 VDD VSS sg13g2_decap_8
XFILLER_147_744 VDD VSS sg13g2_decap_8
XFILLER_14_1058 VDD VSS sg13g2_decap_8
XFILLER_179_1232 VDD VSS sg13g2_decap_8
X_08073_ _08074_/C _08073_/A _08073_/B _08073_/C VDD VSS sg13g2_nand3_1
XFILLER_135_928 VDD VSS sg13g2_fill_1
XFILLER_135_939 VDD VSS sg13g2_fill_1
XFILLER_20_28 VDD VSS sg13g2_decap_8
XFILLER_174_596 VDD VSS sg13g2_decap_8
XFILLER_175_1118 VDD VSS sg13g2_decap_8
XFILLER_161_235 VDD VSS sg13g2_decap_8
XFILLER_136_28 VDD VSS sg13g2_decap_8
XFILLER_66_1424 VDD VSS sg13g2_decap_8
XFILLER_142_471 VDD VSS sg13g2_fill_2
X_14950__2667 _14950_/RESET_B VDD VSS sg13g2_tiehi
XFILLER_115_696 VDD VSS sg13g2_fill_2
XFILLER_103_847 VDD VSS sg13g2_decap_8
XFILLER_153_1449 VDD VSS sg13g2_decap_8
X_08975_ _10675_/C _15220_/Q _08991_/S VDD VSS sg13g2_nor2b_1
XFILLER_130_666 VDD VSS sg13g2_decap_8
XFILLER_5_1204 VDD VSS sg13g2_decap_8
X_07926_ _07926_/X _07926_/A _07926_/B VDD VSS sg13g2_or2_1
XFILLER_151_1151 VDD VSS sg13g2_decap_4
XFILLER_75_219 VDD VSS sg13g2_decap_8
XFILLER_68_260 VDD VSS sg13g2_fill_1
XFILLER_60_1034 VDD VSS sg13g2_fill_2
XFILLER_29_614 VDD VSS sg13g2_decap_4
XFILLER_111_880 VDD VSS sg13g2_decap_8
XFILLER_9_1395 VDD VSS sg13g2_decap_8
XFILLER_68_271 VDD VSS sg13g2_decap_8
X_14965__2645 _14965_/RESET_B VDD VSS sg13g2_tiehi
XFILLER_68_282 VDD VSS sg13g2_fill_1
XFILLER_99_1244 VDD VSS sg13g2_decap_8
XFILLER_25_1187 VDD VSS sg13g2_decap_8
XFILLER_186_1203 VDD VSS sg13g2_decap_8
X_07857_ _07857_/X _15014_/Q _12084_/A VDD VSS sg13g2_or2_1
XFILLER_84_753 VDD VSS sg13g2_decap_8
XFILLER_60_1078 VDD VSS sg13g2_decap_4
XFILLER_57_967 VDD VSS sg13g2_decap_8
XFILLER_28_157 VDD VSS sg13g2_decap_8
XFILLER_28_168 VDD VSS sg13g2_decap_8
XFILLER_56_488 VDD VSS sg13g2_decap_4
X_07788_ _07797_/C _08414_/A _08414_/B _08414_/D VDD VSS sg13g2_o21ai_1
XFILLER_56_499 VDD VSS sg13g2_fill_1
XFILLER_44_639 VDD VSS sg13g2_decap_4
XFILLER_72_959 VDD VSS sg13g2_decap_8
X_14368__1834 _14368_/RESET_B VDD VSS sg13g2_tiehi
X_09527_ _14126_/D _09626_/A0 _14126_/Q _09527_/S VDD VSS sg13g2_mux2_1
XFILLER_43_138 VDD VSS sg13g2_decap_8
XFILLER_52_650 VDD VSS sg13g2_decap_8
XFILLER_24_341 VDD VSS sg13g2_decap_8
XFILLER_24_363 VDD VSS sg13g2_decap_8
XFILLER_101_53 VDD VSS sg13g2_decap_4
XFILLER_12_514 VDD VSS sg13g2_decap_8
X_09458_ _14059_/D _10154_/A1 _14059_/Q _09467_/S VDD VSS sg13g2_mux2_1
XFILLER_160_1409 VDD VSS sg13g2_decap_8
XFILLER_51_171 VDD VSS sg13g2_decap_8
X_08409_ _08410_/B _08431_/C _08407_/Y _08408_/Y VDD VSS sg13g2_a21o_1
XFILLER_61_35 VDD VSS sg13g2_decap_8
XFILLER_36_1250 VDD VSS sg13g2_decap_8
X_09389_ _13992_/D _09620_/A0 _13992_/Q _09395_/S VDD VSS sg13g2_mux2_1
XFILLER_131_4 VDD VSS sg13g2_fill_2
XFILLER_71_1152 VDD VSS sg13g2_decap_8
XFILLER_8_529 VDD VSS sg13g2_decap_8
XFILLER_123_1242 VDD VSS sg13g2_decap_8
XFILLER_177_46 VDD VSS sg13g2_decap_8
XFILLER_184_338 VDD VSS sg13g2_decap_8
X_11420_ _11420_/Y _11420_/A _11420_/B _11898_/C VDD VSS sg13g2_nand3_1
XFILLER_123_1286 VDD VSS sg13g2_fill_2
XFILLER_32_1169 VDD VSS sg13g2_decap_8
XFILLER_153_714 VDD VSS sg13g2_fill_1
X_11351_ _11351_/Y _11347_/Y _11348_/Y _11350_/Y _11349_/Y _11351_/C1 VDD VSS sg13g2_a221oi_1
XFILLER_125_416 VDD VSS sg13g2_decap_4
XFILLER_158_1305 VDD VSS sg13g2_decap_8
X_10302_ _14794_/D _14794_/Q _10299_/Y _10301_/Y VDD VSS sg13g2_a21oi_1
XFILLER_4_735 VDD VSS sg13g2_decap_8
X_14070_ _14070_/Q clkload75/A _14070_/D _14070_/RESET_B VDD VSS sg13g2_dfrbpq_1
XFILLER_10_1456 VDD VSS sg13g2_decap_8
X_11282_ _11283_/A _13948_/Q _13980_/Q _14012_/Q _14044_/Q _11282_/S0 _11282_/S1 VDD
+ VSS sg13g2_mux4_1
XFILLER_106_641 VDD VSS sg13g2_fill_1
XFILLER_152_257 VDD VSS sg13g2_decap_8
XFILLER_180_566 VDD VSS sg13g2_decap_8
X_13021_ _15034_/D _13127_/A _13021_/B VDD VSS sg13g2_nor2_1
X_10233_ _10237_/D _14772_/Q _14773_/Q VDD VSS sg13g2_nand2_1
XFILLER_79_503 VDD VSS sg13g2_decap_8
XFILLER_3_256 VDD VSS sg13g2_decap_8
XFILLER_134_983 VDD VSS sg13g2_decap_4
XFILLER_133_471 VDD VSS sg13g2_decap_8
XFILLER_134_994 VDD VSS sg13g2_fill_1
X_13856__2346 _13856_/RESET_B VDD VSS sg13g2_tiehi
XFILLER_156_1073 VDD VSS sg13g2_decap_8
XFILLER_120_110 VDD VSS sg13g2_decap_8
Xfanout1002 _13343_/B _15069_/Q VDD VSS sg13g2_buf_1
X_10164_ _14741_/D _14741_/Q _10164_/A1 _10167_/S VDD VSS sg13g2_mux2_1
Xfanout1013 _09441_/A _15064_/Q VDD VSS sg13g2_buf_1
XFILLER_86_21 VDD VSS sg13g2_fill_2
XFILLER_117_1057 VDD VSS sg13g2_fill_1
Xfanout1024 _09107_/B _13305_/A VDD VSS sg13g2_buf_1
XFILLER_43_1210 VDD VSS sg13g2_decap_8
Xfanout1035 _13293_/A _15056_/Q VDD VSS sg13g2_buf_1
XFILLER_82_1281 VDD VSS sg13g2_decap_8
XFILLER_0_974 VDD VSS sg13g2_decap_8
Xfanout1046 _08351_/B _15001_/Q VDD VSS sg13g2_buf_1
XFILLER_66_208 VDD VSS sg13g2_decap_8
X_14972_ _14972_/Q _15228_/CLK _14972_/D _14972_/RESET_B VDD VSS sg13g2_dfrbpq_1
Xfanout1057 _13533_/A _14993_/Q VDD VSS sg13g2_buf_1
X_10095_ _14675_/D _10095_/A0 _14675_/Q _10101_/S VDD VSS sg13g2_mux2_1
XFILLER_47_400 VDD VSS sg13g2_decap_8
Xfanout1068 _08244_/B _08356_/A1 VDD VSS sg13g2_buf_1
Xfanout1079 _08337_/S1 _13510_/A1 VDD VSS sg13g2_buf_1
X_13923_ _13923_/Q clkload17/A _13923_/D _13923_/RESET_B VDD VSS sg13g2_dfrbpq_1
XFILLER_59_293 VDD VSS sg13g2_decap_4
XFILLER_43_1287 VDD VSS sg13g2_decap_8
XFILLER_19_70 VDD VSS sg13g2_decap_8
XFILLER_169_1434 VDD VSS sg13g2_decap_8
XFILLER_78_1317 VDD VSS sg13g2_decap_8
XFILLER_35_606 VDD VSS sg13g2_decap_8
XFILLER_47_477 VDD VSS sg13g2_decap_8
X_13854_ _13854_/Q _14526_/CLK _13854_/D _13854_/RESET_B VDD VSS sg13g2_dfrbpq_1
XFILLER_34_116 VDD VSS sg13g2_fill_1
XFILLER_34_127 VDD VSS sg13g2_decap_8
XFILLER_16_842 VDD VSS sg13g2_decap_8
X_12805_ _12805_/Y _12914_/A _12802_/Y _12804_/Y VDD VSS sg13g2_o21ai_1
X_13785_ _13785_/Q _14745_/CLK _13785_/D _13785_/RESET_B VDD VSS sg13g2_dfrbpq_1
X_10997_ _10997_/Y _10995_/Y _10996_/Y _10969_/B VDD VSS sg13g2_o21ai_1
XFILLER_90_789 VDD VSS sg13g2_decap_8
XFILLER_43_661 VDD VSS sg13g2_decap_8
X_12736_ _15016_/D _12736_/A _12736_/B VDD VSS sg13g2_nor2_1
XFILLER_35_91 VDD VSS sg13g2_fill_1
XFILLER_70_491 VDD VSS sg13g2_fill_1
X_12667_ _12680_/A _07737_/A _07737_/B _15012_/Q VDD VSS sg13g2_a21oi_1
XFILLER_30_366 VDD VSS sg13g2_decap_8
XFILLER_15_1334 VDD VSS sg13g2_decap_8
X_14406_ _14406_/Q _14655_/CLK _14406_/D _14406_/RESET_B VDD VSS sg13g2_dfrbpq_1
XFILLER_129_744 VDD VSS sg13g2_decap_8
X_11618_ _11618_/Y _11617_/A1 _13894_/Q VDD VSS sg13g2_nand2b_1
XFILLER_50_1225 VDD VSS sg13g2_decap_8
XFILLER_141_1353 VDD VSS sg13g2_decap_8
XFILLER_102_1315 VDD VSS sg13g2_fill_2
X_12598_ _12611_/A _12639_/A1 _12639_/A2 _08456_/C VDD VSS sg13g2_a21oi_1
XFILLER_184_861 VDD VSS sg13g2_decap_8
X_14337_ _14337_/Q clkload9/A _14337_/D _14337_/RESET_B VDD VSS sg13g2_dfrbpq_1
X_11549_ _11549_/X _11549_/A _11549_/B VDD VSS sg13g2_and2_1
XFILLER_89_1457 VDD VSS sg13g2_decap_8
XFILLER_128_276 VDD VSS sg13g2_decap_8
XFILLER_171_522 VDD VSS sg13g2_decap_8
XFILLER_183_382 VDD VSS sg13g2_decap_8
XFILLER_143_224 VDD VSS sg13g2_decap_8
XFILLER_7_595 VDD VSS sg13g2_decap_8
X_14268_ _14268_/Q _14588_/CLK _14268_/D _14268_/RESET_B VDD VSS sg13g2_dfrbpq_1
XFILLER_100_1050 VDD VSS sg13g2_fill_1
XFILLER_100_1061 VDD VSS sg13g2_decap_8
X_13219_ _13219_/Y _14826_/Q _13219_/A2 _13219_/B1 _14890_/Q _13219_/C1 VDD VSS sg13g2_a221oi_1
XFILLER_98_812 VDD VSS sg13g2_decap_8
XFILLER_48_1132 VDD VSS sg13g2_decap_8
XFILLER_171_588 VDD VSS sg13g2_decap_8
XFILLER_174_1140 VDD VSS sg13g2_decap_8
X_14199_ _14199_/Q clkload43/A _14199_/D _14199_/RESET_B VDD VSS sg13g2_dfrbpq_1
XFILLER_139_1282 VDD VSS sg13g2_fill_1
XFILLER_152_791 VDD VSS sg13g2_decap_8
XFILLER_97_322 VDD VSS sg13g2_decap_8
XFILLER_44_1007 VDD VSS sg13g2_decap_4
XFILLER_111_110 VDD VSS sg13g2_decap_8
X_14446__1756 _14446_/RESET_B VDD VSS sg13g2_tiehi
XFILLER_135_1146 VDD VSS sg13g2_decap_8
XFILLER_83_1078 VDD VSS sg13g2_decap_8
XFILLER_170_1037 VDD VSS sg13g2_fill_1
XFILLER_170_1048 VDD VSS sg13g2_fill_1
XFILLER_111_154 VDD VSS sg13g2_decap_8
XFILLER_26_1452 VDD VSS sg13g2_decap_8
X_08760_ _08760_/Y _13343_/B _11288_/A _15190_/Q VDD VSS sg13g2_o21ai_1
XFILLER_113_1422 VDD VSS sg13g2_decap_4
XFILLER_78_591 VDD VSS sg13g2_fill_1
XFILLER_61_1365 VDD VSS sg13g2_decap_8
X_07711_ _07748_/B _13356_/B _07754_/B VDD VSS sg13g2_and2_1
XFILLER_22_1349 VDD VSS sg13g2_decap_8
X_08691_ _08693_/B _08692_/C _12298_/A _08690_/X VDD VSS sg13g2_o21ai_1
XFILLER_96_1406 VDD VSS sg13g2_decap_8
XFILLER_113_1477 VDD VSS sg13g2_fill_2
XFILLER_93_561 VDD VSS sg13g2_decap_4
X_13901__2301 _13901_/RESET_B VDD VSS sg13g2_tiehi
X_14661__1541 _14661_/RESET_B VDD VSS sg13g2_tiehi
X_07642_ _10265_/C _14783_/Q VDD VSS sg13g2_inv_1
XFILLER_54_937 VDD VSS sg13g2_fill_2
XFILLER_81_734 VDD VSS sg13g2_decap_8
XFILLER_80_211 VDD VSS sg13g2_decap_4
XFILLER_4_1281 VDD VSS sg13g2_decap_8
XFILLER_53_436 VDD VSS sg13g2_decap_8
XFILLER_25_127 VDD VSS sg13g2_decap_8
XFILLER_81_756 VDD VSS sg13g2_fill_2
XFILLER_0_1156 VDD VSS sg13g2_decap_8
XFILLER_80_244 VDD VSS sg13g2_decap_4
XFILLER_59_1261 VDD VSS sg13g2_decap_8
XFILLER_15_28 VDD VSS sg13g2_decap_8
XFILLER_22_801 VDD VSS sg13g2_fill_1
X_09312_ _13919_/D _09745_/A1 _13919_/Q _09325_/S VDD VSS sg13g2_mux2_1
XFILLER_146_1242 VDD VSS sg13g2_decap_8
XFILLER_22_812 VDD VSS sg13g2_decap_8
XFILLER_55_1125 VDD VSS sg13g2_decap_8
X_15183__2842 _15183_/RESET_B VDD VSS sg13g2_tiehi
XFILLER_90_1016 VDD VSS sg13g2_fill_2
XFILLER_142_1106 VDD VSS sg13g2_decap_8
XFILLER_181_1155 VDD VSS sg13g2_decap_8
XFILLER_178_154 VDD VSS sg13g2_decap_8
XFILLER_21_333 VDD VSS sg13g2_fill_1
X_09243_ _13852_/D _13852_/Q _09742_/A1 _09273_/S VDD VSS sg13g2_mux2_1
XFILLER_179_688 VDD VSS sg13g2_fill_1
XFILLER_33_1401 VDD VSS sg13g2_decap_8
XFILLER_72_1461 VDD VSS sg13g2_decap_8
X_13934__2268 _13934_/RESET_B VDD VSS sg13g2_tiehi
XFILLER_119_210 VDD VSS sg13g2_decap_8
XFILLER_178_198 VDD VSS sg13g2_decap_4
XFILLER_119_221 VDD VSS sg13g2_fill_2
X_09174_ _13790_/D _13790_/Q _09744_/A1 _09196_/S VDD VSS sg13g2_mux2_1
XFILLER_181_308 VDD VSS sg13g2_decap_8
XFILLER_31_49 VDD VSS sg13g2_decap_4
X_08125_ _08126_/B _08688_/D _08124_/X _08597_/B VDD VSS sg13g2_mux2_1
XFILLER_120_1437 VDD VSS sg13g2_decap_8
XFILLER_147_27 VDD VSS sg13g2_decap_8
XFILLER_120_1459 VDD VSS sg13g2_decap_8
XFILLER_162_544 VDD VSS sg13g2_decap_8
X_08056_ _08056_/Y _08167_/B _08056_/B VDD VSS sg13g2_nand2b_1
XFILLER_89_801 VDD VSS sg13g2_decap_8
XFILLER_66_1221 VDD VSS sg13g2_decap_8
XFILLER_116_972 VDD VSS sg13g2_decap_8
XFILLER_122_408 VDD VSS sg13g2_fill_2
XFILLER_122_419 VDD VSS sg13g2_decap_8
XFILLER_150_739 VDD VSS sg13g2_fill_2
Xoutput49 mem_axi_araddr[20] _16873_/A VDD VSS sg13g2_buf_1
XFILLER_157_1371 VDD VSS sg13g2_decap_8
Xhold3110 _13628_/A _13736_/Q VDD VSS sg13g2_dlygate4sd3_1
XFILLER_88_311 VDD VSS sg13g2_decap_8
Xhold3121 _13623_/A _13731_/Q VDD VSS sg13g2_dlygate4sd3_1
XFILLER_153_1224 VDD VSS sg13g2_fill_2
XFILLER_1_749 VDD VSS sg13g2_decap_8
Xhold3132 _13622_/A _13730_/Q VDD VSS sg13g2_dlygate4sd3_1
XFILLER_89_867 VDD VSS sg13g2_fill_2
XFILLER_62_1118 VDD VSS sg13g2_decap_4
Xhold3143 _13640_/A _13748_/Q VDD VSS sg13g2_dlygate4sd3_1
XFILLER_49_709 VDD VSS sg13g2_fill_2
Xhold3154 _10875_/A _14933_/Q VDD VSS sg13g2_dlygate4sd3_1
XFILLER_89_878 VDD VSS sg13g2_fill_1
XFILLER_66_1298 VDD VSS sg13g2_decap_8
XFILLER_0_259 VDD VSS sg13g2_decap_8
Xhold3165 _13543_/A _15146_/Q VDD VSS sg13g2_dlygate4sd3_1
XFILLER_89_889 VDD VSS sg13g2_fill_2
XFILLER_76_506 VDD VSS sg13g2_decap_8
XFILLER_131_986 VDD VSS sg13g2_fill_1
XFILLER_153_1268 VDD VSS sg13g2_decap_4
Xhold3176 _11102_/A _14949_/Q VDD VSS sg13g2_dlygate4sd3_1
XFILLER_76_517 VDD VSS sg13g2_fill_2
XFILLER_130_474 VDD VSS sg13g2_fill_2
X_08958_ _10105_/D _09905_/A _09938_/C VDD VSS sg13g2_nor2_1
XFILLER_5_1001 VDD VSS sg13g2_decap_8
XFILLER_102_187 VDD VSS sg13g2_decap_4
XFILLER_130_496 VDD VSS sg13g2_decap_8
XFILLER_9_1192 VDD VSS sg13g2_decap_8
X_07909_ _07909_/Y _14994_/Q _07909_/B VDD VSS sg13g2_nor2_1
XFILLER_56_35 VDD VSS sg13g2_decap_8
XFILLER_56_230 VDD VSS sg13g2_fill_2
XFILLER_40_1438 VDD VSS sg13g2_decap_8
X_08889_ _13705_/D _08935_/S _08887_/Y _08888_/Y VDD VSS sg13g2_a21oi_1
XFILLER_17_617 VDD VSS sg13g2_decap_8
XFILLER_99_1063 VDD VSS sg13g2_fill_1
XFILLER_72_701 VDD VSS sg13g2_decap_8
XFILLER_5_1078 VDD VSS sg13g2_decap_8
XFILLER_179_4 VDD VSS sg13g2_decap_8
XFILLER_186_1022 VDD VSS sg13g2_decap_8
X_10920_ _10934_/B _10920_/A _10920_/B VDD VSS sg13g2_nand2_1
XFILLER_71_200 VDD VSS sg13g2_fill_1
XFILLER_16_116 VDD VSS sg13g2_decap_8
XFILLER_56_285 VDD VSS sg13g2_fill_2
XFILLER_99_1096 VDD VSS sg13g2_fill_1
XFILLER_71_211 VDD VSS sg13g2_decap_8
XFILLER_147_1006 VDD VSS sg13g2_decap_4
X_10851_ _10871_/B _10851_/A _10870_/A _10851_/C _10851_/D VDD VSS sg13g2_nand4_1
XFILLER_60_907 VDD VSS sg13g2_fill_2
XFILLER_129_1440 VDD VSS sg13g2_fill_1
XFILLER_13_801 VDD VSS sg13g2_fill_1
XFILLER_186_1099 VDD VSS sg13g2_decap_8
XFILLER_53_970 VDD VSS sg13g2_decap_8
XFILLER_25_661 VDD VSS sg13g2_decap_8
XFILLER_77_1383 VDD VSS sg13g2_decap_8
XFILLER_53_981 VDD VSS sg13g2_fill_1
X_13570_ _15155_/D _15155_/Q _13569_/X _13587_/B VDD VSS sg13g2_mux2_1
XFILLER_72_56 VDD VSS sg13g2_fill_2
XFILLER_31_119 VDD VSS sg13g2_decap_8
X_10782_ _11164_/C _14953_/Q _08943_/A _10781_/X VDD VSS sg13g2_a21oi_1
XFILLER_38_1356 VDD VSS sg13g2_decap_8
XFILLER_164_1364 VDD VSS sg13g2_decap_8
XFILLER_12_322 VDD VSS sg13g2_decap_8
XFILLER_160_1206 VDD VSS sg13g2_decap_8
X_12521_ _12521_/X _14119_/Q _14151_/Q _14183_/Q _14215_/Q _12647_/S0 _12647_/S1 VDD
+ VSS sg13g2_mux4_1
XFILLER_9_805 VDD VSS sg13g2_decap_8
XFILLER_72_89 VDD VSS sg13g2_decap_4
XFILLER_125_1337 VDD VSS sg13g2_decap_4
XFILLER_73_1269 VDD VSS sg13g2_decap_8
XFILLER_157_338 VDD VSS sg13g2_fill_1
X_14524__1678 _14524_/RESET_B VDD VSS sg13g2_tiehi
X_15240_ _15240_/Q _15240_/CLK _15240_/D _15240_/RESET_B VDD VSS sg13g2_dfrbpq_1
XFILLER_8_326 VDD VSS sg13g2_decap_8
XFILLER_36_1080 VDD VSS sg13g2_decap_8
XFILLER_184_135 VDD VSS sg13g2_decap_8
XFILLER_185_658 VDD VSS sg13g2_decap_8
X_12452_ _12452_/X _14242_/Q _14274_/Q _14306_/Q _14338_/Q _12520_/S0 _12520_/S1 VDD
+ VSS sg13g2_mux4_1
XFILLER_12_399 VDD VSS sg13g2_decap_8
XFILLER_138_541 VDD VSS sg13g2_decap_8
XFILLER_122_0 VDD VSS sg13g2_decap_4
X_11403_ _11403_/X _13727_/Q _14079_/Q _14431_/Q _14527_/Q _11403_/S0 _11419_/C VDD
+ VSS sg13g2_mux4_1
XFILLER_138_574 VDD VSS sg13g2_decap_4
X_15171_ _15171_/Q _15185_/CLK _15171_/D _15171_/RESET_B VDD VSS sg13g2_dfrbpq_1
XFILLER_123_1083 VDD VSS sg13g2_decap_8
XFILLER_126_725 VDD VSS sg13g2_fill_1
X_12383_ _12383_/X _12376_/X _12380_/X _12375_/X _12379_/X _12664_/S _12663_/S1 VDD
+ VSS sg13g2_mux4_1
X_14778__2958 _14778_/RESET_B VDD VSS sg13g2_tiehi
XFILLER_125_213 VDD VSS sg13g2_fill_2
X_14122_ _14122_/Q clkload27/A _14122_/D _14122_/RESET_B VDD VSS sg13g2_dfrbpq_1
X_11334_ _11336_/A _11335_/A _13691_/Q VDD VSS sg13g2_and2_1
XFILLER_4_532 VDD VSS sg13g2_decap_8
XFILLER_10_1253 VDD VSS sg13g2_decap_8
XFILLER_181_864 VDD VSS sg13g2_fill_1
XFILLER_107_961 VDD VSS sg13g2_fill_1
XFILLER_140_205 VDD VSS sg13g2_fill_1
X_14053_ _14053_/Q clkload17/A _14053_/D _14053_/RESET_B VDD VSS sg13g2_dfrbpq_1
XFILLER_137_82 VDD VSS sg13g2_decap_8
XFILLER_153_599 VDD VSS sg13g2_fill_1
XFILLER_158_1179 VDD VSS sg13g2_decap_8
X_11265_ _11266_/A _14684_/Q _14716_/Q _13756_/Q _13788_/Q _12328_/A1 _12326_/B1 VDD
+ VSS sg13g2_mux4_1
X_15219__3010 _15219_/RESET_B VDD VSS sg13g2_tiehi
X_15079__2858 _15079_/RESET_B VDD VSS sg13g2_tiehi
XFILLER_45_1305 VDD VSS sg13g2_decap_8
X_13004_ _13005_/B _12999_/Y _13004_/A2 _13003_/Y VDD VSS sg13g2_a21oi_1
XFILLER_97_64 VDD VSS sg13g2_decap_4
XFILLER_84_1365 VDD VSS sg13g2_decap_8
XFILLER_136_1444 VDD VSS sg13g2_decap_8
X_10216_ _10216_/Y _10322_/C _10216_/B VDD VSS sg13g2_nor2_1
XFILLER_80_1207 VDD VSS sg13g2_decap_8
XFILLER_121_430 VDD VSS sg13g2_decap_8
XFILLER_133_290 VDD VSS sg13g2_decap_8
X_11196_ _11209_/A _11196_/A _11196_/B VDD VSS sg13g2_nand2_1
XFILLER_122_986 VDD VSS sg13g2_decap_4
XFILLER_171_1357 VDD VSS sg13g2_decap_8
XFILLER_79_377 VDD VSS sg13g2_fill_1
XFILLER_0_771 VDD VSS sg13g2_decap_8
X_10147_ _14724_/D _14724_/Q _10147_/A1 _10163_/S VDD VSS sg13g2_mux2_1
XFILLER_130_1010 VDD VSS sg13g2_decap_8
XFILLER_94_347 VDD VSS sg13g2_decap_8
X_14955_ _14955_/Q clkload74/A _14955_/D _14955_/RESET_B VDD VSS sg13g2_dfrbpq_1
X_10078_ _14658_/D _10145_/A1 _14658_/Q _10092_/S VDD VSS sg13g2_mux2_1
XFILLER_75_561 VDD VSS sg13g2_fill_2
XFILLER_169_1231 VDD VSS sg13g2_decap_8
XFILLER_48_786 VDD VSS sg13g2_decap_4
X_13906_ _13906_/Q _14743_/CLK _13906_/D _13906_/RESET_B VDD VSS sg13g2_dfrbpq_1
XFILLER_75_583 VDD VSS sg13g2_decap_8
XFILLER_48_797 VDD VSS sg13g2_fill_1
XFILLER_1_1421 VDD VSS sg13g2_decap_8
X_14886_ _14886_/Q clkload88/A _14886_/D _14886_/RESET_B VDD VSS sg13g2_dfrbpq_1
XFILLER_75_594 VDD VSS sg13g2_decap_8
X_13837_ _13837_/Q clkload24/A _13837_/D _13837_/RESET_B VDD VSS sg13g2_dfrbpq_1
XFILLER_21_1393 VDD VSS sg13g2_decap_8
XFILLER_95_1450 VDD VSS sg13g2_decap_8
XFILLER_35_469 VDD VSS sg13g2_decap_8
XFILLER_62_255 VDD VSS sg13g2_decap_8
XFILLER_51_929 VDD VSS sg13g2_decap_8
XFILLER_56_1423 VDD VSS sg13g2_decap_8
XFILLER_44_970 VDD VSS sg13g2_decap_8
XFILLER_44_981 VDD VSS sg13g2_fill_1
X_13768_ _13768_/Q _14728_/CLK _13768_/D _13768_/RESET_B VDD VSS sg13g2_dfrbpq_1
XFILLER_91_1325 VDD VSS sg13g2_decap_8
XFILLER_143_1404 VDD VSS sg13g2_decap_8
XFILLER_182_1453 VDD VSS sg13g2_decap_8
XFILLER_94_4 VDD VSS sg13g2_decap_8
XFILLER_148_305 VDD VSS sg13g2_decap_8
X_12719_ _12719_/X _12710_/X _12711_/X _12717_/X _12716_/X _12747_/S1 _12762_/S VDD
+ VSS sg13g2_mux4_1
XFILLER_31_653 VDD VSS sg13g2_decap_8
XFILLER_175_102 VDD VSS sg13g2_decap_8
X_13699_ _16861_/A clkload58/A _13699_/D _13699_/RESET_B VDD VSS sg13g2_dfrbpq_1
XFILLER_176_647 VDD VSS sg13g2_decap_4
XFILLER_15_1131 VDD VSS sg13g2_decap_8
XFILLER_50_1022 VDD VSS sg13g2_fill_2
XFILLER_141_1150 VDD VSS sg13g2_fill_1
XFILLER_89_1221 VDD VSS sg13g2_decap_8
XFILLER_141_1183 VDD VSS sg13g2_decap_8
XFILLER_156_371 VDD VSS sg13g2_decap_8
XFILLER_50_1077 VDD VSS sg13g2_fill_2
XFILLER_144_533 VDD VSS sg13g2_decap_8
XFILLER_8_893 VDD VSS sg13g2_decap_8
XFILLER_7_84 VDD VSS sg13g2_decap_8
XFILLER_116_235 VDD VSS sg13g2_decap_8
XFILLER_144_544 VDD VSS sg13g2_fill_1
XFILLER_7_392 VDD VSS sg13g2_decap_8
XFILLER_172_864 VDD VSS sg13g2_decap_8
XFILLER_132_717 VDD VSS sg13g2_fill_2
XFILLER_132_728 VDD VSS sg13g2_decap_8
XFILLER_176_1268 VDD VSS sg13g2_decap_8
X_14679__1523 _14679_/RESET_B VDD VSS sg13g2_tiehi
X_09930_ _14515_/D _14515_/Q _09930_/A1 _09936_/S VDD VSS sg13g2_mux2_1
XFILLER_144_599 VDD VSS sg13g2_decap_8
XFILLER_171_396 VDD VSS sg13g2_decap_8
XFILLER_98_631 VDD VSS sg13g2_fill_1
Xfanout806 _12776_/S _12790_/S VDD VSS sg13g2_buf_1
XFILLER_131_249 VDD VSS sg13g2_decap_4
Xfanout817 _12663_/S1 _12788_/S0 VDD VSS sg13g2_buf_1
X_09861_ _14448_/D _14448_/Q _09960_/A1 _09865_/S VDD VSS sg13g2_mux2_1
Xfanout828 fanout828/X fanout829/X VDD VSS sg13g2_buf_1
XFILLER_63_1449 VDD VSS sg13g2_decap_8
Xfanout839 _12616_/S1 fanout841/X VDD VSS sg13g2_buf_1
X_14823__2913 _14823_/RESET_B VDD VSS sg13g2_tiehi
X_08812_ _08812_/Y _13482_/A _15193_/Q VDD VSS sg13g2_nand2_1
XFILLER_86_826 VDD VSS sg13g2_decap_8
XFILLER_150_1419 VDD VSS sg13g2_decap_8
XFILLER_140_794 VDD VSS sg13g2_fill_2
X_09792_ _14381_/D _09891_/A0 _14381_/Q _09795_/S VDD VSS sg13g2_mux2_1
XFILLER_86_859 VDD VSS sg13g2_fill_2
XFILLER_85_336 VDD VSS sg13g2_decap_8
XFILLER_61_1162 VDD VSS sg13g2_decap_8
X_08743_ _08743_/Y _13666_/Q _08752_/B VDD VSS sg13g2_nor2_1
XFILLER_113_1241 VDD VSS sg13g2_fill_1
XFILLER_6_1376 VDD VSS sg13g2_decap_8
XFILLER_22_1146 VDD VSS sg13g2_decap_8
XFILLER_2_1218 VDD VSS sg13g2_decap_8
X_08674_ _08674_/Y _08684_/A _08522_/C _08674_/B1 _08673_/X _08672_/X VDD VSS sg13g2_a221oi_1
XFILLER_53_211 VDD VSS sg13g2_decap_8
XFILLER_96_1258 VDD VSS sg13g2_fill_2
XFILLER_93_391 VDD VSS sg13g2_fill_1
X_07625_ _07625_/Y _10630_/C VDD VSS sg13g2_inv_1
XFILLER_26_49 VDD VSS sg13g2_decap_8
XFILLER_148_1337 VDD VSS sg13g2_decap_4
XFILLER_81_553 VDD VSS sg13g2_fill_2
XFILLER_183_1239 VDD VSS sg13g2_decap_8
XFILLER_179_441 VDD VSS sg13g2_fill_1
XFILLER_41_439 VDD VSS sg13g2_decap_8
XFILLER_146_1061 VDD VSS sg13g2_fill_1
XFILLER_22_642 VDD VSS sg13g2_decap_8
XFILLER_21_130 VDD VSS sg13g2_decap_8
XFILLER_139_327 VDD VSS sg13g2_fill_1
XFILLER_10_826 VDD VSS sg13g2_decap_8
XFILLER_22_686 VDD VSS sg13g2_fill_2
X_09226_ _13837_/D _09891_/A0 _13837_/Q _09229_/S VDD VSS sg13g2_mux2_1
XFILLER_148_850 VDD VSS sg13g2_fill_1
XFILLER_107_1089 VDD VSS sg13g2_decap_8
XFILLER_182_606 VDD VSS sg13g2_decap_8
XFILLER_166_168 VDD VSS sg13g2_decap_8
XFILLER_181_105 VDD VSS sg13g2_decap_8
X_09157_ _09158_/C _14924_/Q _14923_/Q _09157_/C _09157_/D VDD VSS sg13g2_nand4_1
XFILLER_33_1275 VDD VSS sg13g2_decap_8
XFILLER_120_1245 VDD VSS sg13g2_fill_2
XFILLER_147_371 VDD VSS sg13g2_decap_4
XFILLER_5_329 VDD VSS sg13g2_decap_8
XFILLER_135_522 VDD VSS sg13g2_decap_8
X_08108_ _08112_/C _15104_/Q _15091_/Q _08105_/Y VDD VSS sg13g2_o21ai_1
XFILLER_108_758 VDD VSS sg13g2_fill_1
XFILLER_159_1444 VDD VSS sg13g2_decap_8
XFILLER_174_14 VDD VSS sg13g2_decap_8
X_09088_ _09103_/D _14914_/Q _14913_/Q _13088_/A VDD VSS sg13g2_and3_1
XFILLER_68_1349 VDD VSS sg13g2_decap_8
XFILLER_135_577 VDD VSS sg13g2_fill_2
XFILLER_150_503 VDD VSS sg13g2_decap_8
XFILLER_155_1319 VDD VSS sg13g2_decap_8
X_08039_ _08039_/Y _08039_/A _08039_/B _08039_/C _08039_/D VDD VSS sg13g2_nand4_1
XFILLER_107_30 VDD VSS sg13g2_fill_1
XFILLER_27_1002 VDD VSS sg13g2_fill_1
XFILLER_153_1010 VDD VSS sg13g2_fill_1
XFILLER_1_546 VDD VSS sg13g2_decap_8
X_11050_ _11051_/B _11036_/Y _11064_/C _11032_/Y VDD VSS sg13g2_a21oi_1
XFILLER_66_1062 VDD VSS sg13g2_decap_8
XFILLER_27_1013 VDD VSS sg13g2_decap_8
XFILLER_118_1141 VDD VSS sg13g2_fill_1
XFILLER_157_1190 VDD VSS sg13g2_decap_8
XFILLER_104_986 VDD VSS sg13g2_decap_8
X_10001_ _14584_/D _10100_/A0 _14584_/Q _10003_/S VDD VSS sg13g2_mux2_1
XFILLER_104_997 VDD VSS sg13g2_fill_1
XFILLER_49_528 VDD VSS sg13g2_decap_8
X_15103__2782 _15103_/RESET_B VDD VSS sg13g2_tiehi
XFILLER_67_67 VDD VSS sg13g2_fill_2
XFILLER_131_1330 VDD VSS sg13g2_fill_2
XFILLER_44_1382 VDD VSS sg13g2_decap_8
XFILLER_123_40 VDD VSS sg13g2_decap_8
XFILLER_40_1235 VDD VSS sg13g2_decap_8
XFILLER_79_1423 VDD VSS sg13g2_decap_8
X_14740_ _14740_/Q clkload15/A _14740_/D _14740_/RESET_B VDD VSS sg13g2_dfrbpq_1
X_11952_ _11953_/B _11952_/A _11952_/B _12091_/C VDD VSS sg13g2_nand3_1
XFILLER_83_11 VDD VSS sg13g2_decap_8
XFILLER_29_285 VDD VSS sg13g2_fill_2
X_10903_ _10903_/Y _10903_/A _10929_/B VDD VSS sg13g2_nand2_1
X_14671_ _14671_/Q clkload34/A _14671_/D _14671_/RESET_B VDD VSS sg13g2_dfrbpq_1
XFILLER_72_553 VDD VSS sg13g2_decap_8
XFILLER_33_907 VDD VSS sg13g2_decap_4
XFILLER_166_1437 VDD VSS sg13g2_decap_8
X_11883_ _11883_/X _11900_/B _11882_/X _11881_/Y VDD VSS sg13g2_a21o_1
XFILLER_72_564 VDD VSS sg13g2_fill_2
XFILLER_26_970 VDD VSS sg13g2_fill_1
X_13622_ _13730_/D _13622_/A VDD VSS sg13g2_buf_1
XFILLER_16_60 VDD VSS sg13g2_decap_8
X_10834_ _10834_/Y _11043_/A _10876_/D _10830_/X _10832_/X VDD VSS sg13g2_a22oi_1
XFILLER_77_1180 VDD VSS sg13g2_decap_8
XFILLER_13_620 VDD VSS sg13g2_decap_4
XFILLER_41_940 VDD VSS sg13g2_decap_8
XFILLER_38_1153 VDD VSS sg13g2_decap_8
XFILLER_164_1161 VDD VSS sg13g2_decap_8
XFILLER_73_1044 VDD VSS sg13g2_fill_1
XFILLER_129_1292 VDD VSS sg13g2_decap_8
X_13553_ _13553_/Y _13553_/A1 _13567_/A2 _13552_/Y VDD VSS sg13g2_a21oi_1
XFILLER_9_602 VDD VSS sg13g2_decap_8
XFILLER_34_1006 VDD VSS sg13g2_decap_8
X_10765_ _10765_/Y _13189_/A _11133_/B VDD VSS sg13g2_nand2_1
XFILLER_186_945 VDD VSS sg13g2_decap_8
XFILLER_13_686 VDD VSS sg13g2_decap_8
X_12504_ _12504_/X _14694_/Q _14726_/Q _13766_/Q _13798_/Q _12506_/S0 _12506_/S1 VDD
+ VSS sg13g2_mux4_1
XFILLER_146_809 VDD VSS sg13g2_decap_4
XFILLER_185_455 VDD VSS sg13g2_decap_8
X_13484_ _15123_/D _13484_/A _13484_/B _13484_/C VDD VSS sg13g2_nand3_1
XFILLER_8_123 VDD VSS sg13g2_decap_8
X_10696_ _14901_/D _10696_/A VDD VSS sg13g2_inv_1
XFILLER_40_494 VDD VSS sg13g2_decap_8
XFILLER_12_196 VDD VSS sg13g2_decap_8
X_15223_ _15223_/Q clkload22/A _15223_/D _15223_/RESET_B VDD VSS sg13g2_dfrbpq_1
XFILLER_9_679 VDD VSS sg13g2_decap_8
X_12435_ _12435_/X _14113_/Q _14145_/Q _14177_/Q _14209_/Q _12438_/S0 _12438_/S1 VDD
+ VSS sg13g2_mux4_1
XFILLER_32_70 VDD VSS sg13g2_decap_8
XFILLER_172_116 VDD VSS sg13g2_decap_8
XFILLER_51_1375 VDD VSS sg13g2_decap_8
XFILLER_154_820 VDD VSS sg13g2_decap_4
XFILLER_12_1348 VDD VSS sg13g2_decap_8
XFILLER_166_691 VDD VSS sg13g2_decap_4
XFILLER_86_1405 VDD VSS sg13g2_decap_8
X_15154_ _15154_/Q _15162_/CLK _15154_/D _15154_/RESET_B VDD VSS sg13g2_dfrbpq_1
X_12366_ _12366_/X _13724_/Q _14076_/Q _14428_/Q _14524_/Q _12725_/S0 _12725_/S1 VDD
+ VSS sg13g2_mux4_1
XFILLER_154_864 VDD VSS sg13g2_fill_2
XFILLER_59_7 VDD VSS sg13g2_decap_8
XFILLER_10_1050 VDD VSS sg13g2_decap_8
XFILLER_141_503 VDD VSS sg13g2_decap_4
XFILLER_181_672 VDD VSS sg13g2_decap_8
X_14105_ _14105_/Q clkload44/A _14105_/D _14105_/RESET_B VDD VSS sg13g2_dfrbpq_1
X_11317_ _11318_/A _12100_/S0 _14493_/Q _12088_/B VDD VSS sg13g2_a21oi_1
X_14960__2650 _14960_/RESET_B VDD VSS sg13g2_tiehi
X_15085_ _15085_/Q clkload81/A _15085_/D _15085_/RESET_B VDD VSS sg13g2_dfrbpq_1
X_12297_ _14987_/D _12297_/A _12297_/B VDD VSS sg13g2_nand2_1
XFILLER_5_896 VDD VSS sg13g2_decap_8
XFILLER_113_227 VDD VSS sg13g2_fill_2
XFILLER_180_182 VDD VSS sg13g2_decap_8
XFILLER_171_1110 VDD VSS sg13g2_decap_8
X_14036_ _14036_/Q clkload15/A _14036_/D _14036_/RESET_B VDD VSS sg13g2_dfrbpq_1
X_11248_ _11248_/Y _11248_/A _11248_/B VDD VSS sg13g2_nor2_1
XFILLER_49_1282 VDD VSS sg13g2_decap_8
XFILLER_80_1026 VDD VSS sg13g2_decap_8
XFILLER_164_91 VDD VSS sg13g2_decap_8
XFILLER_171_1154 VDD VSS sg13g2_decap_8
XFILLER_80_1037 VDD VSS sg13g2_decap_8
XFILLER_79_163 VDD VSS sg13g2_decap_8
XFILLER_67_314 VDD VSS sg13g2_decap_8
X_11179_ _11179_/X _11186_/B _11191_/A VDD VSS sg13g2_and2_1
XFILLER_110_945 VDD VSS sg13g2_decap_8
XFILLER_136_1296 VDD VSS sg13g2_decap_8
XFILLER_68_859 VDD VSS sg13g2_decap_8
XFILLER_45_1179 VDD VSS sg13g2_decap_8
XFILLER_132_1138 VDD VSS sg13g2_decap_8
XFILLER_62_1460 VDD VSS sg13g2_decap_8
XFILLER_23_1444 VDD VSS sg13g2_decap_8
XFILLER_110_1436 VDD VSS sg13g2_decap_8
X_14938_ _14938_/Q clkload59/A _14938_/D _14938_/RESET_B VDD VSS sg13g2_dfrbpq_1
XFILLER_82_339 VDD VSS sg13g2_decap_8
XFILLER_110_1447 VDD VSS sg13g2_fill_2
XFILLER_51_704 VDD VSS sg13g2_decap_8
XFILLER_21_1190 VDD VSS sg13g2_decap_8
X_14869_ _14869_/Q clkload83/A _14869_/D _14869_/RESET_B VDD VSS sg13g2_dfrbpq_1
XFILLER_56_1220 VDD VSS sg13g2_decap_8
XFILLER_1_1295 VDD VSS sg13g2_decap_8
X_08390_ _08390_/Y _07790_/A _08422_/S _08412_/A VDD VSS sg13g2_o21ai_1
XFILLER_182_1250 VDD VSS sg13g2_decap_8
XFILLER_108_1332 VDD VSS sg13g2_fill_2
XFILLER_50_258 VDD VSS sg13g2_decap_8
XFILLER_149_625 VDD VSS sg13g2_fill_2
XFILLER_148_113 VDD VSS sg13g2_decap_8
XFILLER_56_1297 VDD VSS sg13g2_decap_8
XFILLER_148_124 VDD VSS sg13g2_fill_1
XFILLER_177_956 VDD VSS sg13g2_fill_2
XFILLER_85_0 VDD VSS sg13g2_decap_8
XFILLER_17_1259 VDD VSS sg13g2_decap_8
XFILLER_149_669 VDD VSS sg13g2_fill_2
XFILLER_104_1229 VDD VSS sg13g2_fill_1
XFILLER_143_1278 VDD VSS sg13g2_decap_8
XFILLER_148_146 VDD VSS sg13g2_decap_4
XFILLER_177_989 VDD VSS sg13g2_decap_8
XFILLER_136_308 VDD VSS sg13g2_decap_4
X_13851__2351 _13851_/RESET_B VDD VSS sg13g2_tiehi
X_14016__2186 _14016_/RESET_B VDD VSS sg13g2_tiehi
X_09011_ _09030_/D _09011_/A _09011_/B _09011_/C _09011_/D VDD VSS sg13g2_nor4_1
XFILLER_163_105 VDD VSS sg13g2_decap_8
XFILLER_128_18 VDD VSS sg13g2_fill_1
XFILLER_30_1426 VDD VSS sg13g2_decap_8
XFILLER_8_690 VDD VSS sg13g2_decap_8
XFILLER_117_566 VDD VSS sg13g2_decap_8
XFILLER_160_801 VDD VSS sg13g2_decap_8
XFILLER_132_503 VDD VSS sg13g2_decap_8
XFILLER_137_1005 VDD VSS sg13g2_decap_4
XFILLER_132_514 VDD VSS sg13g2_fill_1
X_14195__2007 _14195_/RESET_B VDD VSS sg13g2_tiehi
XFILLER_144_385 VDD VSS sg13g2_decap_8
XFILLER_104_227 VDD VSS sg13g2_decap_8
XFILLER_137_1027 VDD VSS sg13g2_decap_8
X_13661__1447 _13661_/RESET_B VDD VSS sg13g2_tiehi
XFILLER_132_547 VDD VSS sg13g2_decap_8
XFILLER_99_940 VDD VSS sg13g2_decap_8
XFILLER_67_1360 VDD VSS sg13g2_decap_8
X_09913_ _14498_/D _14498_/Q _09913_/A1 _09927_/S VDD VSS sg13g2_mux2_1
XFILLER_28_1322 VDD VSS sg13g2_decap_8
Xfanout603 _11170_/B _11196_/B VDD VSS sg13g2_buf_1
XFILLER_101_901 VDD VSS sg13g2_fill_2
Xfanout614 _10740_/A1 _10675_/A VDD VSS sg13g2_buf_1
XFILLER_154_1352 VDD VSS sg13g2_decap_8
Xfanout625 _08877_/A _08893_/A VDD VSS sg13g2_buf_1
XFILLER_99_984 VDD VSS sg13g2_decap_8
XFILLER_59_815 VDD VSS sg13g2_fill_1
Xfanout636 _08955_/S _08928_/S VDD VSS sg13g2_buf_1
XFILLER_63_1246 VDD VSS sg13g2_decap_8
XFILLER_100_400 VDD VSS sg13g2_decap_8
XFILLER_115_1325 VDD VSS sg13g2_decap_8
Xfanout647 _08523_/B1 _07998_/X VDD VSS sg13g2_buf_1
X_09844_ _14431_/D _14431_/Q _10142_/A1 _09865_/S VDD VSS sg13g2_mux2_1
Xfanout658 _08001_/A _08432_/A2 VDD VSS sg13g2_buf_1
XFILLER_115_1347 VDD VSS sg13g2_decap_8
Xfanout669 _13164_/A2 fanout671/X VDD VSS sg13g2_buf_1
XFILLER_28_1399 VDD VSS sg13g2_decap_8
X_09775_ _14364_/D _09907_/A1 _14364_/Q _09805_/S VDD VSS sg13g2_mux2_1
XFILLER_67_870 VDD VSS sg13g2_fill_1
XFILLER_85_177 VDD VSS sg13g2_decap_4
XFILLER_73_317 VDD VSS sg13g2_decap_8
XFILLER_6_1173 VDD VSS sg13g2_decap_8
X_08726_ _08727_/D _13499_/C _13481_/A VDD VSS sg13g2_or2_1
XFILLER_2_1015 VDD VSS sg13g2_decap_8
XFILLER_113_1071 VDD VSS sg13g2_decap_8
XFILLER_27_767 VDD VSS sg13g2_decap_8
XFILLER_15_918 VDD VSS sg13g2_decap_4
X_08657_ _08657_/Y _13553_/A1 _08655_/Y _08656_/X VDD VSS sg13g2_a21oi_1
XFILLER_163_7 VDD VSS sg13g2_decap_8
XFILLER_53_14 VDD VSS sg13g2_decap_8
XFILLER_26_277 VDD VSS sg13g2_fill_1
X_14226__1976 _14226_/RESET_B VDD VSS sg13g2_tiehi
XFILLER_183_1047 VDD VSS sg13g2_fill_1
XFILLER_109_1129 VDD VSS sg13g2_decap_8
X_08588_ _08596_/A _08587_/Y _08588_/B _08588_/C VDD VSS sg13g2_nand3b_1
XFILLER_74_1331 VDD VSS sg13g2_decap_8
XFILLER_26_299 VDD VSS sg13g2_decap_8
XFILLER_169_14 VDD VSS sg13g2_decap_8
XFILLER_39_1462 VDD VSS sg13g2_decap_8
XFILLER_23_973 VDD VSS sg13g2_decap_4
XFILLER_70_1217 VDD VSS sg13g2_decap_8
XFILLER_161_1345 VDD VSS sg13g2_decap_8
XFILLER_179_293 VDD VSS sg13g2_decap_8
XFILLER_35_1359 VDD VSS sg13g2_decap_8
XFILLER_23_995 VDD VSS sg13g2_decap_8
XFILLER_10_623 VDD VSS sg13g2_decap_8
XFILLER_128_809 VDD VSS sg13g2_decap_8
XFILLER_139_135 VDD VSS sg13g2_fill_1
X_10550_ _10550_/Y _14865_/Q _10556_/D _10557_/C VDD VSS sg13g2_o21ai_1
XFILLER_167_477 VDD VSS sg13g2_decap_8
XFILLER_183_926 VDD VSS sg13g2_decap_8
X_09209_ _13820_/D _09907_/A1 _13820_/Q _09239_/S VDD VSS sg13g2_mux2_1
XFILLER_108_500 VDD VSS sg13g2_decap_8
X_14441__1761 _14441_/RESET_B VDD VSS sg13g2_tiehi
X_10481_ _10481_/Y _13084_/A _14847_/Q _14846_/Q _10492_/C VDD VSS sg13g2_nand4_1
XFILLER_6_627 VDD VSS sg13g2_decap_8
XFILLER_185_35 VDD VSS sg13g2_decap_8
XFILLER_120_1042 VDD VSS sg13g2_fill_2
X_12220_ _12220_/Y _12237_/C _12215_/X _12214_/Y VDD VSS sg13g2_o21ai_1
XFILLER_5_126 VDD VSS sg13g2_decap_8
XFILLER_136_853 VDD VSS sg13g2_decap_8
XFILLER_182_469 VDD VSS sg13g2_decap_8
XFILLER_159_1241 VDD VSS sg13g2_decap_8
XFILLER_68_1146 VDD VSS sg13g2_decap_8
XFILLER_155_1105 VDD VSS sg13g2_decap_8
X_12151_ _12151_/Y _12152_/A _13666_/Q VDD VSS sg13g2_nor2_1
XFILLER_151_834 VDD VSS sg13g2_decap_4
XFILLER_162_160 VDD VSS sg13g2_fill_1
XFILLER_150_311 VDD VSS sg13g2_decap_8
XFILLER_135_396 VDD VSS sg13g2_decap_8
XFILLER_162_182 VDD VSS sg13g2_decap_8
XFILLER_46_1400 VDD VSS sg13g2_decap_8
XFILLER_2_833 VDD VSS sg13g2_decap_8
X_11102_ _11102_/Y _11102_/A _11102_/B VDD VSS sg13g2_nand2_1
XFILLER_85_1460 VDD VSS sg13g2_decap_8
XFILLER_123_558 VDD VSS sg13g2_fill_1
XFILLER_150_355 VDD VSS sg13g2_decap_8
XFILLER_151_878 VDD VSS sg13g2_fill_1
X_12082_ _12125_/A _12084_/A _12298_/B VDD VSS sg13g2_nor2_1
XFILLER_96_409 VDD VSS sg13g2_fill_1
XFILLER_1_343 VDD VSS sg13g2_decap_8
XFILLER_104_761 VDD VSS sg13g2_decap_8
X_13714__2488 _13714_/RESET_B VDD VSS sg13g2_tiehi
XFILLER_81_1335 VDD VSS sg13g2_decap_8
XFILLER_172_1452 VDD VSS sg13g2_decap_8
X_11033_ _11064_/C _14760_/Q _11033_/B VDD VSS sg13g2_xor2_1
XFILLER_89_472 VDD VSS sg13g2_decap_8
XFILLER_46_1477 VDD VSS sg13g2_fill_2
XFILLER_103_282 VDD VSS sg13g2_fill_1
XFILLER_94_32 VDD VSS sg13g2_decap_8
XFILLER_40_1043 VDD VSS sg13g2_decap_8
X_13893__2309 _13893_/RESET_B VDD VSS sg13g2_tiehi
XFILLER_91_114 VDD VSS sg13g2_fill_1
X_12984_ _15032_/D _12984_/A _12984_/B VDD VSS sg13g2_nor2_1
XFILLER_45_531 VDD VSS sg13g2_decap_8
XFILLER_79_1253 VDD VSS sg13g2_decap_8
XFILLER_73_851 VDD VSS sg13g2_decap_8
X_14723_ _14723_/Q _14723_/CLK _14723_/D _14723_/RESET_B VDD VSS sg13g2_dfrbpq_1
X_11935_ _11986_/A _11936_/A _13129_/B VDD VSS sg13g2_nor2_1
XFILLER_17_255 VDD VSS sg13g2_fill_2
XFILLER_166_1234 VDD VSS sg13g2_decap_8
X_15185__2834 _15185_/RESET_B VDD VSS sg13g2_tiehi
XFILLER_75_1139 VDD VSS sg13g2_decap_8
X_14654_ _14654_/Q _14668_/CLK _14654_/D _14654_/RESET_B VDD VSS sg13g2_dfrbpq_1
XFILLER_72_383 VDD VSS sg13g2_fill_1
X_11866_ _11868_/B _11867_/A _11867_/B _11910_/C VDD VSS sg13g2_a21o_1
XFILLER_33_748 VDD VSS sg13g2_decap_8
X_13605_ _13605_/Y _13600_/A _10173_/B _15166_/Q VDD VSS sg13g2_a21oi_1
X_14978__2632 _14978_/RESET_B VDD VSS sg13g2_tiehi
XFILLER_177_219 VDD VSS sg13g2_decap_8
X_10817_ _10821_/A _10818_/B _10818_/A VDD VSS sg13g2_nand2_1
X_14585_ _14585_/Q clkload44/A _14585_/D _14585_/RESET_B VDD VSS sg13g2_dfrbpq_1
X_11797_ _11907_/A _11798_/A _13676_/Q VDD VSS sg13g2_nor2_1
XFILLER_53_1426 VDD VSS sg13g2_decap_8
XFILLER_13_461 VDD VSS sg13g2_decap_8
XFILLER_14_995 VDD VSS sg13g2_decap_8
XFILLER_186_742 VDD VSS sg13g2_decap_8
X_13536_ _15144_/D _13535_/B _13534_/Y _13535_/Y VDD VSS sg13g2_a21oi_1
XFILLER_119_809 VDD VSS sg13g2_fill_2
XFILLER_159_978 VDD VSS sg13g2_decap_8
X_10748_ _11078_/B _14946_/Q _10752_/A _10747_/Y VDD VSS sg13g2_a21oi_1
XFILLER_13_494 VDD VSS sg13g2_decap_8
XFILLER_185_252 VDD VSS sg13g2_decap_8
XFILLER_146_617 VDD VSS sg13g2_decap_8
XFILLER_118_319 VDD VSS sg13g2_decap_8
XFILLER_146_628 VDD VSS sg13g2_fill_2
XFILLER_159_91 VDD VSS sg13g2_decap_8
XFILLER_9_476 VDD VSS sg13g2_decap_8
XFILLER_16_1281 VDD VSS sg13g2_decap_8
X_13467_ _13468_/D _15169_/Q _15170_/Q _15171_/Q _15172_/Q VDD VSS sg13g2_nand4_1
XFILLER_139_680 VDD VSS sg13g2_decap_8
X_10679_ _10818_/B _08980_/X _08844_/A _08844_/Y VDD VSS sg13g2_a21oi_1
XFILLER_51_1172 VDD VSS sg13g2_decap_8
X_15206_ _15206_/Q clkload73/A _15206_/D _15206_/RESET_B VDD VSS sg13g2_dfrbpq_1
XFILLER_12_1145 VDD VSS sg13g2_decap_8
X_12418_ _12418_/X _14112_/Q _14144_/Q _14176_/Q _14208_/Q _12698_/S0 _12698_/S1 VDD
+ VSS sg13g2_mux4_1
X_13398_ _13398_/Y _13490_/B _13400_/B _15087_/Q VDD VSS sg13g2_nand3_1
XFILLER_154_661 VDD VSS sg13g2_decap_8
XFILLER_177_1352 VDD VSS sg13g2_decap_8
XFILLER_57_4 VDD VSS sg13g2_decap_8
XFILLER_142_823 VDD VSS sg13g2_decap_8
X_15137_ _15137_/Q _15139_/CLK _15137_/D _15137_/RESET_B VDD VSS sg13g2_dfrbpq_1
XFILLER_99_203 VDD VSS sg13g2_decap_8
XFILLER_86_1246 VDD VSS sg13g2_decap_8
X_12349_ _12349_/X _13819_/Q _13851_/Q _13883_/Q _13915_/Q _12786_/S0 _12786_/S1 VDD
+ VSS sg13g2_mux4_1
XFILLER_126_385 VDD VSS sg13g2_fill_1
X_14855__2857 _14855_/RESET_B VDD VSS sg13g2_tiehi
XFILLER_153_182 VDD VSS sg13g2_decap_4
XFILLER_5_693 VDD VSS sg13g2_decap_8
XFILLER_114_558 VDD VSS sg13g2_decap_4
X_15068_ _15068_/Q _15188_/CLK _15068_/D _15068_/RESET_B VDD VSS sg13g2_dfrbpq_1
XFILLER_142_889 VDD VSS sg13g2_fill_1
XFILLER_4_63 VDD VSS sg13g2_decap_8
X_14019_ _14019_/Q clkload9/A _14019_/D _14019_/RESET_B VDD VSS sg13g2_dfrbpq_1
X_14304__1898 _14304_/RESET_B VDD VSS sg13g2_tiehi
X_07890_ _07904_/A _07924_/C _07890_/B VDD VSS sg13g2_nor2_1
XFILLER_110_731 VDD VSS sg13g2_decap_4
XFILLER_96_954 VDD VSS sg13g2_decap_8
XFILLER_67_111 VDD VSS sg13g2_decap_8
XFILLER_96_965 VDD VSS sg13g2_fill_1
XFILLER_110_753 VDD VSS sg13g2_decap_8
XFILLER_68_667 VDD VSS sg13g2_decap_8
XFILLER_83_604 VDD VSS sg13g2_decap_4
XFILLER_96_998 VDD VSS sg13g2_decap_8
XFILLER_55_306 VDD VSS sg13g2_decap_8
XFILLER_23_1241 VDD VSS sg13g2_decap_8
XFILLER_3_1313 VDD VSS sg13g2_decap_8
XFILLER_110_1211 VDD VSS sg13g2_decap_8
X_09560_ _14158_/D _09626_/A0 _14158_/Q _09560_/S VDD VSS sg13g2_mux2_1
XFILLER_82_114 VDD VSS sg13g2_decap_8
XFILLER_67_188 VDD VSS sg13g2_decap_8
XFILLER_97_1320 VDD VSS sg13g2_fill_2
XFILLER_114_1391 VDD VSS sg13g2_decap_8
X_14483__1719 _14483_/RESET_B VDD VSS sg13g2_tiehi
X_13869__2333 _13869_/RESET_B VDD VSS sg13g2_tiehi
XFILLER_110_1244 VDD VSS sg13g2_fill_2
X_08511_ _08511_/X _08427_/X _08510_/X _08511_/S VDD VSS sg13g2_mux2_1
XFILLER_110_1255 VDD VSS sg13g2_decap_8
XFILLER_36_553 VDD VSS sg13g2_decap_8
X_09491_ _14091_/D _10087_/A0 _14091_/Q _09500_/S VDD VSS sg13g2_mux2_1
XFILLER_58_1315 VDD VSS sg13g2_decap_8
XFILLER_149_1465 VDD VSS sg13g2_decap_8
XFILLER_184_1345 VDD VSS sg13g2_decap_8
X_08442_ _08443_/B _08574_/A _08442_/B VDD VSS sg13g2_nor2_1
XFILLER_1_1092 VDD VSS sg13g2_decap_8
X_14773__2963 _14773_/RESET_B VDD VSS sg13g2_tiehi
X_08373_ _15232_/D _08372_/Y _08373_/B _08373_/C VDD VSS sg13g2_nand3b_1
XFILLER_149_422 VDD VSS sg13g2_decap_8
XFILLER_32_770 VDD VSS sg13g2_decap_8
XFILLER_23_39 VDD VSS sg13g2_decap_8
XFILLER_176_230 VDD VSS sg13g2_decap_8
XFILLER_20_943 VDD VSS sg13g2_decap_8
XFILLER_137_617 VDD VSS sg13g2_decap_8
XFILLER_104_1048 VDD VSS sg13g2_fill_2
XFILLER_30_1223 VDD VSS sg13g2_decap_8
XFILLER_136_149 VDD VSS sg13g2_decap_8
XFILLER_178_1138 VDD VSS sg13g2_decap_8
XFILLER_133_801 VDD VSS sg13g2_decap_4
XFILLER_145_661 VDD VSS sg13g2_fill_1
XFILLER_69_1444 VDD VSS sg13g2_decap_8
XFILLER_121_1395 VDD VSS sg13g2_decap_8
XFILLER_118_897 VDD VSS sg13g2_fill_2
XFILLER_173_981 VDD VSS sg13g2_decap_8
XFILLER_105_514 VDD VSS sg13g2_decap_4
XFILLER_105_525 VDD VSS sg13g2_decap_8
XFILLER_172_480 VDD VSS sg13g2_decap_8
XFILLER_132_322 VDD VSS sg13g2_decap_8
XFILLER_65_1319 VDD VSS sg13g2_decap_8
XFILLER_156_1469 VDD VSS sg13g2_decap_4
XFILLER_120_506 VDD VSS sg13g2_fill_1
Xfanout400 _10110_/A0 _08996_/Y VDD VSS sg13g2_buf_1
Xfanout411 _13444_/B _13442_/B VDD VSS sg13g2_buf_1
Xfanout1409 _10608_/B _10599_/A VDD VSS sg13g2_buf_1
XFILLER_99_770 VDD VSS sg13g2_decap_8
Xfanout422 _10123_/S _10130_/S VDD VSS sg13g2_buf_1
XFILLER_48_14 VDD VSS sg13g2_decap_8
XFILLER_132_388 VDD VSS sg13g2_fill_1
XFILLER_160_697 VDD VSS sg13g2_decap_4
Xfanout433 _09990_/S _09997_/S VDD VSS sg13g2_buf_1
XFILLER_150_1002 VDD VSS sg13g2_decap_8
Xfanout444 _09826_/S _09806_/Y VDD VSS sg13g2_buf_1
Xfanout455 _09673_/S _09661_/S VDD VSS sg13g2_buf_1
XFILLER_98_291 VDD VSS sg13g2_decap_4
XFILLER_8_1257 VDD VSS sg13g2_decap_8
Xfanout466 _09538_/S _09527_/S VDD VSS sg13g2_buf_1
XFILLER_48_58 VDD VSS sg13g2_fill_1
XFILLER_28_1196 VDD VSS sg13g2_decap_8
XFILLER_101_753 VDD VSS sg13g2_fill_2
Xfanout477 _09395_/S fanout480/X VDD VSS sg13g2_buf_1
X_09827_ _14415_/D _09827_/A0 _14415_/Q _09837_/S VDD VSS sg13g2_mux2_1
XFILLER_63_1087 VDD VSS sg13g2_decap_4
Xfanout488 _09233_/S _09225_/S VDD VSS sg13g2_buf_1
XFILLER_100_252 VDD VSS sg13g2_decap_4
Xfanout499 _08935_/S _08956_/S VDD VSS sg13g2_buf_1
XFILLER_41_1341 VDD VSS sg13g2_decap_8
XFILLER_104_42 VDD VSS sg13g2_decap_8
XFILLER_46_328 VDD VSS sg13g2_decap_8
XFILLER_100_285 VDD VSS sg13g2_decap_4
X_09758_ _14348_/D _14348_/Q _09923_/A1 _09758_/S VDD VSS sg13g2_mux2_1
XFILLER_46_339 VDD VSS sg13g2_fill_1
XFILLER_73_147 VDD VSS sg13g2_decap_8
X_14459__1743 _14459_/RESET_B VDD VSS sg13g2_tiehi
X_08709_ _15187_/D hold3077/X _15187_/Q _13340_/S VDD VSS sg13g2_mux2_1
XFILLER_76_1415 VDD VSS sg13g2_decap_8
X_09689_ _14281_/D _09755_/A1 _14281_/Q _09700_/S VDD VSS sg13g2_mux2_1
XFILLER_55_884 VDD VSS sg13g2_fill_1
XFILLER_15_737 VDD VSS sg13g2_fill_1
X_11720_ _11720_/Y _11791_/S _11718_/X _11719_/Y VDD VSS sg13g2_o21ai_1
XFILLER_54_383 VDD VSS sg13g2_decap_8
XFILLER_14_236 VDD VSS sg13g2_fill_2
XFILLER_163_1429 VDD VSS sg13g2_decap_8
XFILLER_42_556 VDD VSS sg13g2_fill_1
XFILLER_30_707 VDD VSS sg13g2_decap_4
X_11651_ _11651_/X _13959_/Q _13991_/Q _14023_/Q _14055_/Q _11786_/S0 _11786_/S1 VDD
+ VSS sg13g2_mux4_1
XFILLER_42_578 VDD VSS sg13g2_decap_8
XFILLER_168_731 VDD VSS sg13g2_decap_4
XFILLER_30_729 VDD VSS sg13g2_decap_8
XFILLER_70_1014 VDD VSS sg13g2_decap_8
XFILLER_120_96 VDD VSS sg13g2_decap_8
X_10602_ _14877_/D _10608_/B _10602_/B _10602_/C VDD VSS sg13g2_nor3_1
XFILLER_11_932 VDD VSS sg13g2_decap_8
XFILLER_126_1262 VDD VSS sg13g2_fill_1
XFILLER_161_1142 VDD VSS sg13g2_decap_8
X_14370_ _14370_/Q clkload5/A _14370_/D _14370_/RESET_B VDD VSS sg13g2_dfrbpq_1
XFILLER_10_420 VDD VSS sg13g2_decap_8
X_11582_ _11584_/B _11957_/A _11582_/B VDD VSS sg13g2_nor2_1
XFILLER_80_56 VDD VSS sg13g2_decap_8
XFILLER_35_1156 VDD VSS sg13g2_decap_8
XFILLER_156_915 VDD VSS sg13g2_decap_8
XFILLER_7_903 VDD VSS sg13g2_decap_8
X_13321_ _13322_/A _15111_/Q _13306_/B _13324_/A VDD VSS sg13g2_a21oi_1
XFILLER_122_1137 VDD VSS sg13g2_decap_4
XFILLER_127_105 VDD VSS sg13g2_decap_8
XFILLER_182_200 VDD VSS sg13g2_decap_8
X_10533_ _10535_/A _14860_/Q _10533_/B VDD VSS sg13g2_nand2b_1
XFILLER_167_285 VDD VSS sg13g2_decap_8
XFILLER_13_1432 VDD VSS sg13g2_decap_8
XFILLER_183_756 VDD VSS sg13g2_decap_8
XFILLER_6_424 VDD VSS sg13g2_decap_8
XFILLER_10_497 VDD VSS sg13g2_decap_8
X_13252_ _13252_/X input25/X _13272_/A2 _13049_/X VDD VSS sg13g2_a21o_1
XFILLER_136_650 VDD VSS sg13g2_fill_2
X_10464_ _14843_/D _10471_/C _10471_/D _10463_/Y VDD VSS sg13g2_a21oi_1
XFILLER_182_277 VDD VSS sg13g2_decap_8
X_12203_ _12272_/A _12203_/A _13665_/Q VDD VSS sg13g2_xnor2_1
XFILLER_100_1457 VDD VSS sg13g2_decap_8
X_13183_ _13184_/B _13265_/A1 _13178_/X _13177_/X _13307_/A _13182_/Y VDD VSS sg13g2_a221oi_1
XFILLER_123_311 VDD VSS sg13g2_decap_8
X_10395_ _10396_/D _10395_/A _10400_/C _10395_/C VDD VSS sg13g2_nor3_1
XFILLER_151_631 VDD VSS sg13g2_decap_8
X_13947__2255 _13947_/RESET_B VDD VSS sg13g2_tiehi
XFILLER_2_630 VDD VSS sg13g2_decap_8
X_12134_ _12134_/X _13749_/Q _14101_/Q _14453_/Q _14549_/Q _12139_/S0 _12139_/S1 VDD
+ VSS sg13g2_mux4_1
XFILLER_124_878 VDD VSS sg13g2_decap_8
XFILLER_1_140 VDD VSS sg13g2_decap_8
XFILLER_151_686 VDD VSS sg13g2_decap_8
XFILLER_78_921 VDD VSS sg13g2_decap_8
XFILLER_111_539 VDD VSS sg13g2_fill_1
X_12065_ _12065_/Y _12065_/A _12065_/B VDD VSS sg13g2_nand2_1
XFILLER_104_580 VDD VSS sg13g2_decap_8
XFILLER_150_196 VDD VSS sg13g2_decap_8
XFILLER_46_1274 VDD VSS sg13g2_decap_8
XFILLER_133_1244 VDD VSS sg13g2_fill_2
X_11016_ _11016_/Y _11042_/D _10995_/Y _11052_/D VDD VSS sg13g2_o21ai_1
XFILLER_78_976 VDD VSS sg13g2_decap_8
X_16873_ _16873_/X _16873_/A VDD VSS sg13g2_buf_1
XFILLER_93_913 VDD VSS sg13g2_decap_8
XFILLER_65_604 VDD VSS sg13g2_decap_8
XFILLER_42_1149 VDD VSS sg13g2_decap_8
XFILLER_92_412 VDD VSS sg13g2_decap_8
XFILLER_64_103 VDD VSS sg13g2_fill_1
XFILLER_168_1307 VDD VSS sg13g2_decap_8
XFILLER_20_1403 VDD VSS sg13g2_decap_8
XFILLER_18_520 VDD VSS sg13g2_decap_8
XFILLER_92_434 VDD VSS sg13g2_decap_8
XFILLER_161_70 VDD VSS sg13g2_decap_8
XFILLER_46_862 VDD VSS sg13g2_decap_8
X_12967_ _12967_/Y _12900_/A _13017_/A2 input5/X VDD VSS sg13g2_a21oi_1
XFILLER_80_618 VDD VSS sg13g2_decap_8
XFILLER_79_1072 VDD VSS sg13g2_decap_8
XFILLER_18_597 VDD VSS sg13g2_decap_8
X_14706_ _14706_/Q _14743_/CLK _14706_/D _14706_/RESET_B VDD VSS sg13g2_dfrbpq_1
X_11918_ _11918_/X _14575_/Q _14607_/Q _14639_/Q _14671_/Q _12072_/S0 _12072_/S1 VDD
+ VSS sg13g2_mux4_1
X_12898_ _12898_/Y _12895_/Y _12896_/Y _12897_/Y VDD VSS sg13g2_a21oi_1
XFILLER_72_180 VDD VSS sg13g2_decap_8
XFILLER_60_331 VDD VSS sg13g2_decap_8
XFILLER_178_528 VDD VSS sg13g2_decap_8
XFILLER_166_1097 VDD VSS sg13g2_decap_4
X_14637_ _14637_/Q _14637_/CLK _14637_/D _14637_/RESET_B VDD VSS sg13g2_dfrbpq_1
X_11849_ _11849_/X _13837_/Q _13869_/Q _13901_/Q _13933_/Q _11756_/S _11760_/C VDD
+ VSS sg13g2_mux4_1
XFILLER_127_1059 VDD VSS sg13g2_decap_8
XFILLER_18_1343 VDD VSS sg13g2_decap_8
XFILLER_53_1223 VDD VSS sg13g2_decap_8
XFILLER_60_386 VDD VSS sg13g2_decap_8
X_14568_ _14568_/Q _14728_/CLK _14568_/D _14568_/RESET_B VDD VSS sg13g2_dfrbpq_1
XFILLER_13_291 VDD VSS sg13g2_decap_8
X_14761__2978 _14761_/RESET_B VDD VSS sg13g2_tiehi
XFILLER_119_639 VDD VSS sg13g2_decap_8
XFILLER_179_1414 VDD VSS sg13g2_decap_8
X_13519_ _13519_/Y _13519_/A _13565_/S VDD VSS sg13g2_nor2_1
X_14499_ _14499_/Q clkload9/A _14499_/D _14499_/RESET_B VDD VSS sg13g2_dfrbpq_1
XFILLER_9_273 VDD VSS sg13g2_decap_8
XFILLER_174_745 VDD VSS sg13g2_decap_8
XFILLER_88_1319 VDD VSS sg13g2_fill_2
Xclkload10 clkload10/X clkload10/A VDD VSS sg13g2_buf_8
Xclkload21 clkload21/Y clkload21/A VDD VSS sg13g2_inv_2
XFILLER_134_609 VDD VSS sg13g2_decap_8
Xclkload32 clkload32/Y clkload32/A VDD VSS sg13g2_inv_2
XFILLER_127_650 VDD VSS sg13g2_fill_1
XFILLER_103_1070 VDD VSS sg13g2_decap_8
XFILLER_127_661 VDD VSS sg13g2_fill_2
Xclkload43 clkload43/Y clkload43/A VDD VSS sg13g2_inv_2
XFILLER_155_981 VDD VSS sg13g2_decap_8
XFILLER_161_417 VDD VSS sg13g2_decap_8
Xclkload54 clkload54/Y clkload54/A VDD VSS sg13g2_inv_8
Xclkload65 clkload65/Y clkload65/A VDD VSS sg13g2_inv_1
Xclkload76 clkload76/X clkload76/A VDD VSS sg13g2_buf_8
Xclkload87 clkload87/Y clkload87/A VDD VSS sg13g2_inv_2
XFILLER_6_991 VDD VSS sg13g2_decap_8
XFILLER_86_1054 VDD VSS sg13g2_decap_8
X_14537__1665 _14537_/RESET_B VDD VSS sg13g2_tiehi
XFILLER_5_490 VDD VSS sg13g2_decap_8
XFILLER_48_0 VDD VSS sg13g2_decap_8
XFILLER_115_878 VDD VSS sg13g2_decap_8
XFILLER_86_1087 VDD VSS sg13g2_fill_2
XFILLER_142_664 VDD VSS sg13g2_fill_1
X_08991_ _08992_/B _15026_/Q _15223_/Q _08991_/S VDD VSS sg13g2_mux2_1
XFILLER_130_826 VDD VSS sg13g2_fill_1
X_15105__2774 _15105_/RESET_B VDD VSS sg13g2_tiehi
XFILLER_64_1330 VDD VSS sg13g2_decap_8
XFILLER_29_1450 VDD VSS sg13g2_decap_8
XFILLER_130_848 VDD VSS sg13g2_decap_8
XFILLER_138_1199 VDD VSS sg13g2_decap_8
X_07942_ _07942_/Y _07942_/A VDD VSS sg13g2_inv_1
XFILLER_151_1322 VDD VSS sg13g2_decap_8
X_07873_ _08188_/B _07909_/B _07910_/A VDD VSS sg13g2_nor2_1
XFILLER_69_987 VDD VSS sg13g2_decap_8
XFILLER_60_1238 VDD VSS sg13g2_decap_8
XFILLER_25_1369 VDD VSS sg13g2_decap_8
X_09612_ _14208_/D _09612_/A0 _14208_/Q _09623_/S VDD VSS sg13g2_mux2_1
XFILLER_99_1437 VDD VSS sg13g2_decap_8
XFILLER_68_486 VDD VSS sg13g2_decap_8
XFILLER_151_1388 VDD VSS sg13g2_decap_8
XFILLER_18_39 VDD VSS sg13g2_decap_8
XFILLER_3_1110 VDD VSS sg13g2_decap_8
XFILLER_84_957 VDD VSS sg13g2_decap_4
XFILLER_56_648 VDD VSS sg13g2_decap_8
X_09543_ _14141_/D _09743_/A1 _14141_/Q _09562_/S VDD VSS sg13g2_mux2_1
XFILLER_71_607 VDD VSS sg13g2_decap_4
XFILLER_55_158 VDD VSS sg13g2_decap_8
XFILLER_110_1063 VDD VSS sg13g2_decap_8
XFILLER_64_670 VDD VSS sg13g2_decap_8
XFILLER_3_1187 VDD VSS sg13g2_decap_8
XFILLER_92_990 VDD VSS sg13g2_decap_8
XFILLER_24_523 VDD VSS sg13g2_decap_8
XFILLER_184_1142 VDD VSS sg13g2_decap_8
X_09474_ _09474_/X _09938_/A _09938_/B _09938_/C _10137_/C VDD VSS sg13g2_or4_1
XFILLER_19_1107 VDD VSS sg13g2_decap_8
XFILLER_145_1115 VDD VSS sg13g2_fill_2
X_08425_ _08441_/C _08668_/A _08058_/X _08688_/C VDD VSS sg13g2_o21ai_1
XFILLER_93_1069 VDD VSS sg13g2_fill_2
XFILLER_58_1189 VDD VSS sg13g2_decap_8
X_13685__2525 _13685_/RESET_B VDD VSS sg13g2_tiehi
XFILLER_36_1432 VDD VSS sg13g2_decap_8
XFILLER_11_228 VDD VSS sg13g2_decap_8
XFILLER_162_1451 VDD VSS sg13g2_decap_8
XFILLER_71_1334 VDD VSS sg13g2_decap_8
X_08356_ _08668_/B _08356_/A1 _08196_/Y _08241_/Y VDD VSS sg13g2_o21ai_1
XFILLER_177_550 VDD VSS sg13g2_decap_8
XFILLER_177_561 VDD VSS sg13g2_fill_1
XFILLER_20_740 VDD VSS sg13g2_decap_8
XFILLER_165_712 VDD VSS sg13g2_fill_2
Xclkload4 clkload4/X clkload4/A VDD VSS sg13g2_buf_8
XFILLER_137_425 VDD VSS sg13g2_decap_8
X_08287_ _08287_/Y _07797_/A _07927_/Y _07932_/Y VDD VSS sg13g2_o21ai_1
XFILLER_137_436 VDD VSS sg13g2_fill_2
XFILLER_180_715 VDD VSS sg13g2_fill_1
XFILLER_4_917 VDD VSS sg13g2_decap_8
XFILLER_30_1064 VDD VSS sg13g2_decap_8
XFILLER_69_1241 VDD VSS sg13g2_decap_8
XFILLER_3_438 VDD VSS sg13g2_decap_8
XFILLER_106_856 VDD VSS sg13g2_fill_2
XFILLER_156_1222 VDD VSS sg13g2_fill_1
XFILLER_121_804 VDD VSS sg13g2_decap_4
XFILLER_156_1255 VDD VSS sg13g2_fill_1
X_10180_ _14747_/D _10173_/Y _10176_/Y _10179_/Y VDD VSS sg13g2_o21ai_1
XFILLER_182_25 VDD VSS sg13g2_decap_8
Xfanout1206 _13156_/A _13157_/A VDD VSS sg13g2_buf_1
Xfanout1217 _10651_/D _14881_/Q VDD VSS sg13g2_buf_1
Xfanout230 _10152_/A1 fanout234/X VDD VSS sg13g2_buf_1
Xfanout1228 _10511_/D _14843_/Q VDD VSS sg13g2_buf_1
XFILLER_82_1463 VDD VSS sg13g2_decap_8
Xfanout241 _11248_/B fanout242/X VDD VSS sg13g2_buf_1
XFILLER_82_1474 VDD VSS sg13g2_fill_1
Xfanout1239 _12942_/B _13684_/Q VDD VSS sg13g2_buf_1
Xfanout252 _10150_/A1 _09654_/A0 VDD VSS sg13g2_buf_1
XFILLER_8_1054 VDD VSS sg13g2_decap_8
XFILLER_115_52 VDD VSS sg13g2_decap_4
XFILLER_120_369 VDD VSS sg13g2_decap_8
Xfanout263 _10057_/S fanout266/X VDD VSS sg13g2_buf_1
Xfanout274 _09590_/S _09589_/S VDD VSS sg13g2_buf_1
XFILLER_19_306 VDD VSS sg13g2_decap_8
Xfanout285 _10081_/A0 fanout289/X VDD VSS sg13g2_buf_1
XFILLER_43_1469 VDD VSS sg13g2_decap_4
Xfanout296 _09714_/A0 _10144_/A1 VDD VSS sg13g2_buf_1
XFILLER_75_935 VDD VSS sg13g2_fill_2
XFILLER_47_626 VDD VSS sg13g2_fill_2
XFILLER_59_497 VDD VSS sg13g2_decap_4
X_13870_ _13870_/Q _14670_/CLK _13870_/D _13870_/RESET_B VDD VSS sg13g2_dfrbpq_1
XFILLER_86_283 VDD VSS sg13g2_decap_4
XFILLER_46_136 VDD VSS sg13g2_decap_8
XFILLER_75_78 VDD VSS sg13g2_decap_8
XFILLER_74_456 VDD VSS sg13g2_fill_1
X_12821_ _12821_/Y _14895_/Q _12836_/B VDD VSS sg13g2_nand2_1
XFILLER_90_916 VDD VSS sg13g2_fill_1
XFILLER_90_927 VDD VSS sg13g2_decap_4
XFILLER_62_618 VDD VSS sg13g2_fill_1
XFILLER_28_862 VDD VSS sg13g2_decap_8
XFILLER_74_478 VDD VSS sg13g2_decap_8
XFILLER_15_501 VDD VSS sg13g2_fill_1
XFILLER_76_1212 VDD VSS sg13g2_decap_8
XFILLER_83_990 VDD VSS sg13g2_decap_8
XFILLER_131_62 VDD VSS sg13g2_decap_8
X_12752_ _12752_/X _13848_/Q _13880_/Q _13912_/Q _13944_/Q _12752_/S0 _12752_/S1 VDD
+ VSS sg13g2_mux4_1
X_14011__2191 _14011_/RESET_B VDD VSS sg13g2_tiehi
XFILLER_91_11 VDD VSS sg13g2_fill_2
XFILLER_152_0 VDD VSS sg13g2_decap_8
XFILLER_163_1226 VDD VSS sg13g2_decap_8
XFILLER_167_1395 VDD VSS sg13g2_decap_8
X_11703_ _11771_/B _11635_/A _13681_/Q _13680_/Q _14970_/Q VDD VSS sg13g2_a22oi_1
XFILLER_76_1289 VDD VSS sg13g2_decap_8
XFILLER_15_578 VDD VSS sg13g2_fill_2
X_12683_ _12683_/X _13747_/Q _14099_/Q _14451_/Q _14547_/Q _12711_/S0 _12711_/S1 VDD
+ VSS sg13g2_mux4_1
XFILLER_128_1368 VDD VSS sg13g2_fill_2
X_14422_ _14422_/Q _14588_/CLK _14422_/D _14422_/RESET_B VDD VSS sg13g2_dfrbpq_1
X_14615__1587 _14615_/RESET_B VDD VSS sg13g2_tiehi
XFILLER_70_695 VDD VSS sg13g2_decap_4
X_11634_ _11643_/A _11635_/A _13681_/Q VDD VSS sg13g2_xor2_1
X_14190__2012 _14190_/RESET_B VDD VSS sg13g2_tiehi
XFILLER_50_1407 VDD VSS sg13g2_decap_8
XFILLER_7_700 VDD VSS sg13g2_decap_8
XFILLER_11_762 VDD VSS sg13g2_decap_8
X_14353_ _14353_/Q _14417_/CLK _14353_/D _14353_/RESET_B VDD VSS sg13g2_dfrbpq_1
XFILLER_156_734 VDD VSS sg13g2_decap_8
X_11565_ _11566_/B _11527_/Y _11631_/A2 _11564_/Y VDD VSS sg13g2_a21oi_1
XFILLER_128_436 VDD VSS sg13g2_decap_8
XFILLER_183_542 VDD VSS sg13g2_decap_8
X_13304_ _13320_/A _13303_/A _13308_/B VDD VSS sg13g2_nand2b_1
XFILLER_6_221 VDD VSS sg13g2_decap_8
X_10516_ _14854_/D _10453_/C _10521_/D _10499_/B _07623_/Y _10595_/B VDD VSS sg13g2_a221oi_1
XFILLER_10_294 VDD VSS sg13g2_decap_8
X_14284_ _14284_/Q _14495_/CLK _14284_/D _14284_/RESET_B VDD VSS sg13g2_dfrbpq_1
XFILLER_100_1210 VDD VSS sg13g2_fill_1
X_11496_ _11496_/X _11486_/X _11487_/X _11490_/X _11491_/X _11973_/B _11975_/A VDD
+ VSS sg13g2_mux4_1
XFILLER_7_777 VDD VSS sg13g2_decap_8
X_13235_ _13235_/Y _14827_/Q _13206_/B _07728_/C _14891_/Q _13248_/B VDD VSS sg13g2_a221oi_1
XFILLER_124_620 VDD VSS sg13g2_decap_8
X_10447_ _14838_/D _10453_/C _10514_/A _10444_/B _07624_/Y _10487_/A VDD VSS sg13g2_a221oi_1
XFILLER_87_1363 VDD VSS sg13g2_decap_8
XFILLER_48_1314 VDD VSS sg13g2_decap_8
XFILLER_136_491 VDD VSS sg13g2_fill_1
XFILLER_174_1322 VDD VSS sg13g2_decap_8
XFILLER_6_298 VDD VSS sg13g2_decap_8
XFILLER_124_642 VDD VSS sg13g2_decap_8
XFILLER_156_70 VDD VSS sg13g2_decap_8
X_13166_ _13166_/Y _13265_/A1 _13161_/X _13165_/Y VDD VSS sg13g2_a21oi_1
XFILLER_41_7 VDD VSS sg13g2_decap_8
X_10378_ _10379_/A _14815_/Q _14816_/Q _14817_/Q _10378_/D VDD VSS sg13g2_and4_1
XFILLER_97_504 VDD VSS sg13g2_fill_2
XFILLER_83_1249 VDD VSS sg13g2_decap_8
XFILLER_151_472 VDD VSS sg13g2_fill_2
XFILLER_135_1328 VDD VSS sg13g2_decap_8
X_12117_ _12118_/B _12106_/Y _12108_/X _11717_/A VDD VSS sg13g2_o21ai_1
XFILLER_174_1399 VDD VSS sg13g2_decap_8
X_13097_ _13097_/Y _13094_/Y _13095_/Y _13096_/Y VDD VSS sg13g2_a21oi_1
XFILLER_46_1082 VDD VSS sg13g2_fill_2
X_12048_ _12048_/Y _12142_/S1 _12043_/X _12047_/Y VDD VSS sg13g2_a21oi_1
X_14221__1981 _14221_/RESET_B VDD VSS sg13g2_tiehi
XFILLER_78_773 VDD VSS sg13g2_decap_8
XFILLER_133_1085 VDD VSS sg13g2_fill_1
XFILLER_1_42 VDD VSS sg13g2_decap_8
XFILLER_20_1200 VDD VSS sg13g2_decap_8
X_16856_ _16856_/X _16856_/A VDD VSS sg13g2_buf_1
XFILLER_65_434 VDD VSS sg13g2_decap_4
XFILLER_93_754 VDD VSS sg13g2_decap_8
XFILLER_4_1463 VDD VSS sg13g2_decap_8
XFILLER_93_776 VDD VSS sg13g2_decap_8
XFILLER_81_916 VDD VSS sg13g2_fill_1
XFILLER_111_1361 VDD VSS sg13g2_decap_8
XFILLER_80_404 VDD VSS sg13g2_decap_8
XFILLER_81_938 VDD VSS sg13g2_decap_8
XFILLER_111_1372 VDD VSS sg13g2_fill_1
XFILLER_18_361 VDD VSS sg13g2_fill_1
X_13999_ _13999_/Q clkload39/A _13999_/D _13999_/RESET_B VDD VSS sg13g2_dfrbpq_1
XFILLER_0_1338 VDD VSS sg13g2_decap_8
XFILLER_59_1443 VDD VSS sg13g2_decap_8
XFILLER_20_1277 VDD VSS sg13g2_decap_8
XFILLER_94_1334 VDD VSS sg13g2_decap_8
XFILLER_80_448 VDD VSS sg13g2_decap_8
XFILLER_146_1424 VDD VSS sg13g2_decap_8
XFILLER_55_1307 VDD VSS sg13g2_decap_8
XFILLER_94_1378 VDD VSS sg13g2_fill_2
XFILLER_178_325 VDD VSS sg13g2_decap_8
XFILLER_181_1337 VDD VSS sg13g2_decap_8
XFILLER_178_336 VDD VSS sg13g2_fill_1
XFILLER_34_898 VDD VSS sg13g2_decap_8
XFILLER_60_161 VDD VSS sg13g2_decap_8
XFILLER_33_375 VDD VSS sg13g2_fill_1
X_08210_ _08211_/A _08359_/B2 _08197_/X _08209_/X _08110_/D _08193_/Y VDD VSS sg13g2_a221oi_1
XFILLER_18_1140 VDD VSS sg13g2_decap_8
X_09190_ _13806_/D _13806_/Q _10124_/A0 _09190_/S VDD VSS sg13g2_mux2_1
XFILLER_53_1031 VDD VSS sg13g2_decap_8
XFILLER_119_414 VDD VSS sg13g2_decap_8
XFILLER_140_1012 VDD VSS sg13g2_fill_1
XFILLER_147_723 VDD VSS sg13g2_decap_8
X_08141_ _08141_/Y _08359_/A2 _08140_/Y _08523_/B1 VDD VSS sg13g2_a21oi_1
XFILLER_144_1192 VDD VSS sg13g2_fill_2
XFILLER_159_594 VDD VSS sg13g2_decap_4
XFILLER_14_1037 VDD VSS sg13g2_decap_8
XFILLER_179_1211 VDD VSS sg13g2_decap_8
XFILLER_146_233 VDD VSS sg13g2_fill_1
XFILLER_105_1176 VDD VSS sg13g2_decap_4
XFILLER_146_244 VDD VSS sg13g2_decap_8
XFILLER_135_918 VDD VSS sg13g2_decap_4
X_08072_ _08078_/B _07882_/Y _08142_/A _08071_/Y _08073_/A _08070_/X VDD VSS sg13g2_a221oi_1
XFILLER_88_1127 VDD VSS sg13g2_decap_8
XFILLER_147_789 VDD VSS sg13g2_decap_8
XFILLER_174_564 VDD VSS sg13g2_decap_4
XFILLER_128_981 VDD VSS sg13g2_decap_4
XFILLER_31_1384 VDD VSS sg13g2_decap_8
XFILLER_179_1288 VDD VSS sg13g2_decap_8
XFILLER_127_480 VDD VSS sg13g2_decap_4
XFILLER_66_1403 VDD VSS sg13g2_decap_8
XFILLER_143_962 VDD VSS sg13g2_decap_8
X_14053__2149 _14053_/RESET_B VDD VSS sg13g2_tiehi
XFILLER_130_623 VDD VSS sg13g2_decap_8
XFILLER_153_1428 VDD VSS sg13g2_decap_8
X_08974_ _10675_/B _08991_/S _15023_/Q VDD VSS sg13g2_nor2_1
X_07925_ _07925_/Y _07926_/A _07926_/B VDD VSS sg13g2_nor2_1
XFILLER_9_1374 VDD VSS sg13g2_decap_8
XFILLER_99_1201 VDD VSS sg13g2_decap_8
XFILLER_25_1166 VDD VSS sg13g2_decap_8
XFILLER_116_1294 VDD VSS sg13g2_decap_8
XFILLER_84_732 VDD VSS sg13g2_decap_8
XFILLER_112_1136 VDD VSS sg13g2_decap_8
X_07856_ _07856_/Y _07855_/A _07855_/B _08641_/A VDD VSS sg13g2_o21ai_1
XFILLER_29_648 VDD VSS sg13g2_decap_8
XFILLER_29_659 VDD VSS sg13g2_fill_1
X_15187__2826 _15187_/RESET_B VDD VSS sg13g2_tiehi
XFILLER_44_618 VDD VSS sg13g2_decap_4
X_07787_ _07796_/B _08414_/A _08414_/B VDD VSS sg13g2_nor2_1
XFILLER_72_938 VDD VSS sg13g2_decap_8
XFILLER_71_415 VDD VSS sg13g2_fill_2
XFILLER_186_1259 VDD VSS sg13g2_decap_8
XFILLER_65_990 VDD VSS sg13g2_fill_2
XFILLER_43_117 VDD VSS sg13g2_decap_8
X_09526_ _14125_/D _10089_/A0 _14125_/Q _09533_/S VDD VSS sg13g2_mux2_1
XFILLER_25_832 VDD VSS sg13g2_fill_1
XFILLER_25_854 VDD VSS sg13g2_fill_2
XFILLER_101_32 VDD VSS sg13g2_decap_8
X_09457_ _14058_/D _09723_/A0 _14058_/Q _09461_/S VDD VSS sg13g2_mux2_1
XFILLER_51_150 VDD VSS sg13g2_decap_8
XFILLER_61_14 VDD VSS sg13g2_decap_8
X_08408_ _08408_/Y _08431_/C _08236_/X _08110_/D VDD VSS sg13g2_o21ai_1
XFILLER_24_397 VDD VSS sg13g2_decap_8
XFILLER_40_857 VDD VSS sg13g2_fill_2
XFILLER_185_829 VDD VSS sg13g2_decap_8
X_09388_ _13991_/D _10150_/A1 _13991_/Q _09397_/S VDD VSS sg13g2_mux2_1
XFILLER_8_508 VDD VSS sg13g2_decap_8
XFILLER_177_25 VDD VSS sg13g2_decap_8
XFILLER_184_317 VDD VSS sg13g2_decap_8
XFILLER_127_1390 VDD VSS sg13g2_decap_8
XFILLER_178_892 VDD VSS sg13g2_decap_8
X_08339_ _08339_/Y _08377_/B _08337_/X _08338_/Y VDD VSS sg13g2_o21ai_1
XFILLER_137_222 VDD VSS sg13g2_decap_8
X_14263__1939 _14263_/RESET_B VDD VSS sg13g2_tiehi
XFILLER_32_1148 VDD VSS sg13g2_decap_8
XFILLER_138_778 VDD VSS sg13g2_decap_8
X_11350_ _11350_/Y _11812_/A1 _13790_/Q _11355_/B1 VDD VSS sg13g2_a21oi_1
XFILLER_137_255 VDD VSS sg13g2_fill_2
XFILLER_165_564 VDD VSS sg13g2_decap_8
XFILLER_4_714 VDD VSS sg13g2_decap_8
X_10301_ _10301_/Y _14794_/Q _10299_/Y _10544_/C VDD VSS sg13g2_o21ai_1
XFILLER_10_1435 VDD VSS sg13g2_decap_8
XFILLER_137_299 VDD VSS sg13g2_decap_4
X_11281_ _11281_/Y _11282_/S1 _11277_/X _11280_/Y VDD VSS sg13g2_o21ai_1
XFILLER_152_236 VDD VSS sg13g2_decap_8
XFILLER_134_951 VDD VSS sg13g2_decap_8
X_13020_ _13021_/B _13020_/A1 _13019_/Y _13012_/Y _13009_/Y _13016_/Y VDD VSS sg13g2_a221oi_1
XFILLER_3_235 VDD VSS sg13g2_decap_8
XFILLER_134_962 VDD VSS sg13g2_decap_8
X_10232_ _14772_/D _10232_/A _10232_/B _10322_/C VDD VSS sg13g2_and3_1
XFILLER_106_664 VDD VSS sg13g2_decap_8
XFILLER_140_409 VDD VSS sg13g2_fill_1
XFILLER_106_686 VDD VSS sg13g2_decap_8
X_14029__2173 _14029_/RESET_B VDD VSS sg13g2_tiehi
XFILLER_10_84 VDD VSS sg13g2_decap_8
XFILLER_133_494 VDD VSS sg13g2_decap_8
Xfanout1003 _07720_/B _15068_/Q VDD VSS sg13g2_buf_1
X_10163_ _14740_/D _14740_/Q _10163_/A1 _10163_/S VDD VSS sg13g2_mux2_1
XFILLER_121_645 VDD VSS sg13g2_decap_8
XFILLER_160_291 VDD VSS sg13g2_decap_8
Xfanout1014 _10004_/B _15063_/Q VDD VSS sg13g2_buf_1
XFILLER_0_953 VDD VSS sg13g2_decap_8
Xfanout1025 _13305_/A fanout1026/X VDD VSS sg13g2_buf_1
XFILLER_82_1260 VDD VSS sg13g2_decap_8
XFILLER_117_1069 VDD VSS sg13g2_decap_8
Xfanout1036 _13613_/A _15056_/Q VDD VSS sg13g2_buf_1
Xfanout1047 _08306_/B _15000_/Q VDD VSS sg13g2_buf_1
XFILLER_120_166 VDD VSS sg13g2_decap_8
X_14971_ _14971_/Q _15228_/CLK _14971_/D _14971_/RESET_B VDD VSS sg13g2_dfrbpq_1
X_10094_ _14674_/D _10094_/A0 _14674_/Q _10101_/S VDD VSS sg13g2_mux2_1
XFILLER_130_1203 VDD VSS sg13g2_decap_8
Xfanout1058 _08484_/B _13529_/A VDD VSS sg13g2_buf_1
Xfanout1069 _08356_/A1 _08360_/A1 VDD VSS sg13g2_buf_1
XFILLER_86_88 VDD VSS sg13g2_decap_8
XFILLER_48_935 VDD VSS sg13g2_fill_1
XFILLER_134_1383 VDD VSS sg13g2_decap_4
XFILLER_43_1266 VDD VSS sg13g2_decap_8
X_13922_ _13922_/Q _14704_/CLK _13922_/D _13922_/RESET_B VDD VSS sg13g2_dfrbpq_1
XFILLER_169_1413 VDD VSS sg13g2_decap_8
XFILLER_19_147 VDD VSS sg13g2_decap_4
XFILLER_47_456 VDD VSS sg13g2_decap_8
XFILLER_142_61 VDD VSS sg13g2_decap_8
X_13853_ _13853_/Q clkload31/A _13853_/D _13853_/RESET_B VDD VSS sg13g2_dfrbpq_1
XFILLER_62_404 VDD VSS sg13g2_fill_1
XFILLER_16_810 VDD VSS sg13g2_decap_8
XFILLER_63_938 VDD VSS sg13g2_decap_4
XFILLER_62_426 VDD VSS sg13g2_fill_2
X_12804_ _12804_/Y input4/X _12841_/B _12803_/X input34/X _12800_/X VDD VSS sg13g2_a221oi_1
X_13784_ _13784_/Q clkload46/A _13784_/D _13784_/RESET_B VDD VSS sg13g2_dfrbpq_1
X_10996_ _10996_/Y _11014_/A _10996_/B VDD VSS sg13g2_nand2_1
XFILLER_43_640 VDD VSS sg13g2_decap_8
XFILLER_128_1143 VDD VSS sg13g2_decap_8
XFILLER_167_1192 VDD VSS sg13g2_decap_8
X_12735_ _12736_/B _13666_/Q _12749_/A2 _12734_/X _12749_/B2 _12777_/C1 VDD VSS sg13g2_a221oi_1
XFILLER_76_1075 VDD VSS sg13g2_fill_2
XFILLER_31_824 VDD VSS sg13g2_fill_2
X_12666_ _15011_/D _12666_/A _12666_/B VDD VSS sg13g2_nor2_1
XFILLER_128_1198 VDD VSS sg13g2_decap_4
XFILLER_19_1471 VDD VSS sg13g2_decap_8
XFILLER_30_345 VDD VSS sg13g2_decap_8
XFILLER_15_1313 VDD VSS sg13g2_decap_8
XFILLER_50_1204 VDD VSS sg13g2_decap_8
XFILLER_141_1332 VDD VSS sg13g2_decap_8
X_14405_ _14405_/Q clkload18/A _14405_/D _14405_/RESET_B VDD VSS sg13g2_dfrbpq_1
X_11617_ _11617_/Y _11617_/A1 _13862_/Q _11391_/B VDD VSS sg13g2_a21oi_1
XFILLER_156_520 VDD VSS sg13g2_decap_8
XFILLER_180_1392 VDD VSS sg13g2_decap_8
X_12597_ _15006_/D _12597_/A _12597_/B VDD VSS sg13g2_nor2_1
XFILLER_54_1395 VDD VSS sg13g2_decap_8
XFILLER_184_840 VDD VSS sg13g2_decap_8
XFILLER_11_592 VDD VSS sg13g2_decap_8
X_14239__1963 _14239_/RESET_B VDD VSS sg13g2_tiehi
X_14336_ _14336_/Q clkload25/A _14336_/D _14336_/RESET_B VDD VSS sg13g2_dfrbpq_1
X_11548_ _11549_/A _14244_/Q _14276_/Q _14308_/Q _14340_/Q _11555_/S0 _11532_/C VDD
+ VSS sg13g2_mux4_1
XFILLER_116_406 VDD VSS sg13g2_decap_8
XFILLER_144_715 VDD VSS sg13g2_decap_4
XFILLER_171_501 VDD VSS sg13g2_decap_8
XFILLER_183_361 VDD VSS sg13g2_decap_8
XFILLER_143_203 VDD VSS sg13g2_decap_8
XFILLER_156_586 VDD VSS sg13g2_fill_2
XFILLER_7_574 VDD VSS sg13g2_decap_8
X_14267_ _14267_/Q _14491_/CLK _14267_/D _14267_/RESET_B VDD VSS sg13g2_dfrbpq_1
X_11479_ _11479_/Y _14900_/Q _11433_/B _11837_/A1 VDD VSS sg13g2_a21oi_1
XFILLER_143_258 VDD VSS sg13g2_decap_8
XFILLER_171_567 VDD VSS sg13g2_decap_8
X_13218_ _13218_/Y _13218_/A _13234_/B VDD VSS sg13g2_nand2_1
XFILLER_125_984 VDD VSS sg13g2_decap_8
X_14198_ _14198_/Q clkload75/A _14198_/D _14198_/RESET_B VDD VSS sg13g2_dfrbpq_1
XFILLER_124_472 VDD VSS sg13g2_fill_1
XFILLER_140_932 VDD VSS sg13g2_fill_2
XFILLER_135_1125 VDD VSS sg13g2_decap_4
XFILLER_140_943 VDD VSS sg13g2_decap_4
X_13149_ _13149_/X input18/X _12914_/A _13272_/B1 VDD VSS sg13g2_a21o_1
XFILLER_83_1057 VDD VSS sg13g2_decap_8
XFILLER_135_1136 VDD VSS sg13g2_fill_2
XFILLER_48_1188 VDD VSS sg13g2_decap_8
XFILLER_174_1196 VDD VSS sg13g2_decap_8
XFILLER_26_1431 VDD VSS sg13g2_decap_8
X_14920__2727 _14920_/RESET_B VDD VSS sg13g2_tiehi
XFILLER_61_1344 VDD VSS sg13g2_decap_8
XFILLER_38_401 VDD VSS sg13g2_decap_8
XFILLER_39_935 VDD VSS sg13g2_decap_8
X_07710_ _07710_/Y _13324_/A _13281_/C VDD VSS sg13g2_nor2_1
XFILLER_66_721 VDD VSS sg13g2_fill_2
XFILLER_38_412 VDD VSS sg13g2_fill_1
XFILLER_22_1328 VDD VSS sg13g2_decap_8
X_08690_ _08690_/X _15103_/Q _15090_/Q _08690_/C VDD VSS sg13g2_or3_1
XFILLER_66_765 VDD VSS sg13g2_decap_8
XFILLER_54_916 VDD VSS sg13g2_decap_8
X_07641_ _10265_/B _14782_/Q VDD VSS sg13g2_inv_1
XFILLER_81_713 VDD VSS sg13g2_decap_8
XFILLER_4_1260 VDD VSS sg13g2_decap_8
XFILLER_20_1030 VDD VSS sg13g2_fill_2
XFILLER_65_275 VDD VSS sg13g2_decap_8
XFILLER_53_415 VDD VSS sg13g2_decap_8
XFILLER_25_106 VDD VSS sg13g2_decap_8
X_13727__2475 _13727_/RESET_B VDD VSS sg13g2_tiehi
XFILLER_93_595 VDD VSS sg13g2_fill_1
XFILLER_0_1135 VDD VSS sg13g2_decap_8
XFILLER_59_1240 VDD VSS sg13g2_decap_8
X_09311_ _13918_/D _10141_/A1 _13918_/Q _09325_/S VDD VSS sg13g2_mux2_1
XFILLER_34_651 VDD VSS sg13g2_decap_8
XFILLER_146_1232 VDD VSS sg13g2_fill_2
XFILLER_62_982 VDD VSS sg13g2_decap_8
XFILLER_179_645 VDD VSS sg13g2_fill_2
XFILLER_185_1292 VDD VSS sg13g2_decap_8
XFILLER_80_289 VDD VSS sg13g2_decap_8
XFILLER_181_1134 VDD VSS sg13g2_decap_8
XFILLER_21_301 VDD VSS sg13g2_decap_8
XFILLER_61_470 VDD VSS sg13g2_fill_1
XFILLER_178_133 VDD VSS sg13g2_decap_8
XFILLER_34_695 VDD VSS sg13g2_fill_2
X_09242_ _13851_/D _13851_/Q _09906_/A1 _09273_/S VDD VSS sg13g2_mux2_1
XFILLER_33_183 VDD VSS sg13g2_decap_8
XFILLER_139_509 VDD VSS sg13g2_decap_8
XFILLER_72_1440 VDD VSS sg13g2_decap_8
XFILLER_107_1238 VDD VSS sg13g2_fill_1
XFILLER_167_829 VDD VSS sg13g2_decap_8
X_14107__2095 _14107_/RESET_B VDD VSS sg13g2_tiehi
X_13942__2260 _13942_/RESET_B VDD VSS sg13g2_tiehi
X_09173_ _13789_/D _13789_/Q _10140_/A1 _09200_/S VDD VSS sg13g2_mux2_1
XFILLER_119_233 VDD VSS sg13g2_decap_8
XFILLER_33_1457 VDD VSS sg13g2_decap_8
XFILLER_31_28 VDD VSS sg13g2_decap_8
X_08124_ _08124_/X _07850_/B _07845_/B _08653_/B _08673_/B _08054_/B _08669_/B1 VDD
+ VSS sg13g2_mux4_1
XFILLER_135_704 VDD VSS sg13g2_decap_4
X_08055_ _08167_/B _08931_/A1 _08934_/A1 _08012_/B _07845_/B _08046_/B _07627_/A VDD
+ VSS sg13g2_mux4_1
XFILLER_31_1181 VDD VSS sg13g2_decap_8
XFILLER_179_1085 VDD VSS sg13g2_decap_8
XFILLER_66_1200 VDD VSS sg13g2_decap_8
X_15044__2560 _15044_/RESET_B VDD VSS sg13g2_tiehi
XFILLER_157_1350 VDD VSS sg13g2_decap_8
Xoutput39 mem_axi_araddr[10] _16863_/A VDD VSS sg13g2_buf_1
XFILLER_153_1203 VDD VSS sg13g2_decap_8
XFILLER_1_728 VDD VSS sg13g2_decap_8
Xhold3100 input23/A mem_axi_rdata[27] VDD VSS sg13g2_dlygate4sd3_1
Xhold3111 _13636_/A _13744_/Q VDD VSS sg13g2_dlygate4sd3_1
XFILLER_143_792 VDD VSS sg13g2_decap_8
Xhold3122 _13645_/A _13753_/Q VDD VSS sg13g2_dlygate4sd3_1
Xhold3133 _13615_/A _13723_/Q VDD VSS sg13g2_dlygate4sd3_1
XFILLER_66_1277 VDD VSS sg13g2_decap_8
XFILLER_0_238 VDD VSS sg13g2_decap_8
XFILLER_103_645 VDD VSS sg13g2_fill_2
Xhold3144 _10903_/A _14935_/Q VDD VSS sg13g2_dlygate4sd3_1
XFILLER_102_133 VDD VSS sg13g2_decap_4
XFILLER_118_1367 VDD VSS sg13g2_decap_4
XFILLER_130_442 VDD VSS sg13g2_decap_8
XFILLER_153_1247 VDD VSS sg13g2_decap_8
XFILLER_163_49 VDD VSS sg13g2_decap_8
Xhold3155 _10796_/A _14926_/Q VDD VSS sg13g2_dlygate4sd3_1
XFILLER_114_1209 VDD VSS sg13g2_decap_8
Xhold3166 _13531_/A _15143_/Q VDD VSS sg13g2_dlygate4sd3_1
Xhold3177 hold3177/X _14985_/Q VDD VSS sg13g2_dlygate4sd3_1
XFILLER_88_378 VDD VSS sg13g2_decap_8
X_08957_ _10137_/B _09905_/A _09938_/B VDD VSS sg13g2_nand2b_1
XFILLER_9_1171 VDD VSS sg13g2_decap_8
XFILLER_29_401 VDD VSS sg13g2_fill_2
XFILLER_56_14 VDD VSS sg13g2_decap_8
XFILLER_40_1417 VDD VSS sg13g2_decap_8
X_07908_ _13290_/A _07908_/A _07908_/B VDD VSS sg13g2_nand2_1
X_08888_ _08888_/Y _08835_/A _08835_/B _16867_/A VDD VSS sg13g2_a21oi_1
XFILLER_99_1031 VDD VSS sg13g2_decap_8
XFILLER_99_1042 VDD VSS sg13g2_fill_1
XFILLER_5_1057 VDD VSS sg13g2_decap_8
XFILLER_186_1001 VDD VSS sg13g2_decap_8
XFILLER_84_551 VDD VSS sg13g2_decap_8
X_07839_ _07969_/A _07979_/C _07981_/C _08697_/B _08698_/A VDD VSS sg13g2_nand4_1
XFILLER_44_404 VDD VSS sg13g2_decap_4
XFILLER_99_1075 VDD VSS sg13g2_decap_8
XFILLER_56_264 VDD VSS sg13g2_decap_8
XFILLER_45_938 VDD VSS sg13g2_decap_8
XFILLER_29_489 VDD VSS sg13g2_decap_8
XFILLER_112_42 VDD VSS sg13g2_fill_2
XFILLER_16_139 VDD VSS sg13g2_fill_1
X_14317__1885 _14317_/RESET_B VDD VSS sg13g2_tiehi
X_10850_ _10850_/Y _10850_/A _10875_/B VDD VSS sg13g2_nand2_1
XFILLER_186_1078 VDD VSS sg13g2_decap_8
XFILLER_72_13 VDD VSS sg13g2_fill_1
XFILLER_77_1362 VDD VSS sg13g2_decap_8
XFILLER_72_779 VDD VSS sg13g2_decap_8
X_09509_ _14108_/D _09841_/A1 _14108_/Q _09539_/S VDD VSS sg13g2_mux2_1
XFILLER_38_1335 VDD VSS sg13g2_decap_8
X_10781_ _10781_/X _10781_/A _10793_/B _10793_/A VDD VSS sg13g2_and3_1
XFILLER_12_301 VDD VSS sg13g2_decap_8
XFILLER_164_1343 VDD VSS sg13g2_decap_8
XFILLER_129_1474 VDD VSS sg13g2_fill_1
XFILLER_13_835 VDD VSS sg13g2_fill_1
XFILLER_72_68 VDD VSS sg13g2_decap_8
XFILLER_125_1316 VDD VSS sg13g2_decap_8
X_12520_ _12520_/X _13735_/Q _14087_/Q _14439_/Q _14535_/Q _12520_/S0 _12520_/S1 VDD
+ VSS sg13g2_mux4_1
XFILLER_73_1248 VDD VSS sg13g2_decap_8
X_14496__1706 _14496_/RESET_B VDD VSS sg13g2_tiehi
XFILLER_40_654 VDD VSS sg13g2_decap_8
XFILLER_8_305 VDD VSS sg13g2_decap_8
XFILLER_184_114 VDD VSS sg13g2_decap_8
XFILLER_185_637 VDD VSS sg13g2_decap_8
X_12451_ _12451_/X _14370_/Q _14402_/Q _14466_/Q _14498_/Q _12520_/S0 _12520_/S1 VDD
+ VSS sg13g2_mux4_1
XFILLER_12_378 VDD VSS sg13g2_decap_8
XFILLER_138_520 VDD VSS sg13g2_decap_8
X_14532__1670 _14532_/RESET_B VDD VSS sg13g2_tiehi
Xclkbuf_leaf_51_clk_i clkload70/A clkbuf_leaf_52_clk_i/A VDD VSS sg13g2_buf_8
X_11402_ _11402_/Y _11397_/Y _11398_/Y _11422_/B VDD VSS sg13g2_a21oi_1
X_15170_ _15170_/Q _15185_/CLK _15170_/D _15170_/RESET_B VDD VSS sg13g2_dfrbpq_1
X_12382_ _12382_/X _14237_/Q _14269_/Q _14301_/Q _14333_/Q _12550_/S0 _12550_/S1 VDD
+ VSS sg13g2_mux4_1
XFILLER_126_715 VDD VSS sg13g2_decap_4
XFILLER_165_361 VDD VSS sg13g2_decap_8
XFILLER_166_895 VDD VSS sg13g2_fill_2
X_14121_ _14121_/Q clkload28/A _14121_/D _14121_/RESET_B VDD VSS sg13g2_dfrbpq_1
X_14786__2950 _14786_/RESET_B VDD VSS sg13g2_tiehi
X_11333_ _11333_/Y _12835_/A _11931_/A2 _11837_/A1 VDD VSS sg13g2_a21oi_1
XFILLER_4_511 VDD VSS sg13g2_decap_8
XFILLER_10_1232 VDD VSS sg13g2_decap_8
XFILLER_126_759 VDD VSS sg13g2_fill_2
XFILLER_158_1158 VDD VSS sg13g2_decap_8
X_14052_ _14052_/Q clkload49/A _14052_/D _14052_/RESET_B VDD VSS sg13g2_dfrbpq_1
Xclkbuf_leaf_66_clk_i _14491_/CLK clkbuf_leaf_78_clk_i/A VDD VSS sg13g2_buf_8
X_11264_ _11264_/X _11259_/Y _11260_/Y _11266_/B VDD VSS sg13g2_a21o_1
XFILLER_97_21 VDD VSS sg13g2_decap_8
XFILLER_97_32 VDD VSS sg13g2_fill_1
XFILLER_122_921 VDD VSS sg13g2_decap_8
XFILLER_175_1461 VDD VSS sg13g2_decap_8
XFILLER_84_1344 VDD VSS sg13g2_decap_8
XFILLER_49_1464 VDD VSS sg13g2_decap_8
XFILLER_136_1423 VDD VSS sg13g2_decap_8
X_13003_ _13003_/Y _13000_/Y _13001_/Y _13002_/Y VDD VSS sg13g2_a21oi_1
X_13805__2397 _13805_/RESET_B VDD VSS sg13g2_tiehi
XFILLER_4_588 VDD VSS sg13g2_decap_8
XFILLER_106_483 VDD VSS sg13g2_decap_4
X_10215_ _14764_/D _13005_/C _10209_/B hold3107/X VDD VSS sg13g2_a21oi_1
XFILLER_122_954 VDD VSS sg13g2_decap_8
X_11195_ _14955_/D _07614_/Y _10671_/Y _11194_/Y VDD VSS sg13g2_o21ai_1
XFILLER_171_1336 VDD VSS sg13g2_decap_8
XFILLER_0_750 VDD VSS sg13g2_decap_8
XFILLER_132_1309 VDD VSS sg13g2_decap_8
XFILLER_97_98 VDD VSS sg13g2_decap_8
XFILLER_121_464 VDD VSS sg13g2_fill_2
X_10146_ _14723_/D _14723_/Q _10146_/A1 _10156_/S VDD VSS sg13g2_mux2_1
XFILLER_121_486 VDD VSS sg13g2_fill_2
XFILLER_153_60 VDD VSS sg13g2_decap_4
XFILLER_94_326 VDD VSS sg13g2_decap_8
X_13984__2218 _13984_/RESET_B VDD VSS sg13g2_tiehi
X_14954_ _14954_/Q clkload74/A _14954_/D _14954_/RESET_B VDD VSS sg13g2_dfrbpq_1
X_10077_ _14657_/D _10077_/A0 _14657_/Q _10092_/S VDD VSS sg13g2_mux2_1
XFILLER_48_743 VDD VSS sg13g2_decap_8
XFILLER_75_540 VDD VSS sg13g2_decap_8
XFILLER_48_754 VDD VSS sg13g2_fill_1
XFILLER_169_1210 VDD VSS sg13g2_decap_8
XFILLER_48_765 VDD VSS sg13g2_decap_8
XFILLER_43_1085 VDD VSS sg13g2_decap_8
XFILLER_1_1400 VDD VSS sg13g2_decap_8
X_13905_ _13905_/Q _14417_/CLK _13905_/D _13905_/RESET_B VDD VSS sg13g2_dfrbpq_1
XFILLER_35_404 VDD VSS sg13g2_decap_8
X_14885_ _14885_/Q clkload88/A _14885_/D _14885_/RESET_B VDD VSS sg13g2_dfrbpq_1
XFILLER_63_724 VDD VSS sg13g2_decap_8
XFILLER_36_949 VDD VSS sg13g2_decap_4
XFILLER_35_437 VDD VSS sg13g2_decap_8
XFILLER_29_990 VDD VSS sg13g2_decap_8
XFILLER_21_1372 VDD VSS sg13g2_decap_8
X_13836_ _13836_/Q _14508_/CLK _13836_/D _13836_/RESET_B VDD VSS sg13g2_dfrbpq_1
XFILLER_62_234 VDD VSS sg13g2_decap_8
XFILLER_169_1287 VDD VSS sg13g2_decap_8
XFILLER_90_554 VDD VSS sg13g2_decap_8
XFILLER_90_565 VDD VSS sg13g2_fill_1
XFILLER_56_1402 VDD VSS sg13g2_decap_8
XFILLER_1_1477 VDD VSS sg13g2_fill_2
XFILLER_44_960 VDD VSS sg13g2_decap_4
XFILLER_182_1432 VDD VSS sg13g2_decap_8
XFILLER_90_587 VDD VSS sg13g2_decap_8
XFILLER_16_684 VDD VSS sg13g2_decap_4
X_13767_ _13767_/Q clkload5/A _13767_/D _13767_/RESET_B VDD VSS sg13g2_dfrbpq_1
X_10979_ _10979_/Y _14759_/Q _10722_/Y _11009_/D VDD VSS sg13g2_o21ai_1
XFILLER_44_993 VDD VSS sg13g2_decap_8
X_12718_ _12718_/X _12713_/X _12715_/X _12712_/X _12714_/X _12762_/S _12747_/S1 VDD
+ VSS sg13g2_mux4_1
XFILLER_149_829 VDD VSS sg13g2_decap_8
X_13698_ _16860_/A clkload62/A _13698_/D _13698_/RESET_B VDD VSS sg13g2_dfrbpq_1
XFILLER_15_1110 VDD VSS sg13g2_decap_8
XFILLER_30_142 VDD VSS sg13g2_fill_1
Xclkbuf_leaf_19_clk_i clkload38/A clkbuf_leaf_30_clk_i/A VDD VSS sg13g2_buf_8
XFILLER_87_4 VDD VSS sg13g2_decap_8
X_12649_ _12649_/X _12647_/X _12646_/X _12643_/X _12642_/X _12649_/S0 _12455_/S VDD
+ VSS sg13g2_mux4_1
XFILLER_106_1260 VDD VSS sg13g2_decap_8
XFILLER_54_1192 VDD VSS sg13g2_decap_8
XFILLER_175_158 VDD VSS sg13g2_decap_4
XFILLER_106_1293 VDD VSS sg13g2_decap_8
XFILLER_129_575 VDD VSS sg13g2_decap_8
XFILLER_157_884 VDD VSS sg13g2_decap_8
XFILLER_50_1056 VDD VSS sg13g2_decap_8
XFILLER_129_586 VDD VSS sg13g2_fill_2
XFILLER_15_1187 VDD VSS sg13g2_decap_8
XFILLER_8_872 VDD VSS sg13g2_decap_8
XFILLER_89_1244 VDD VSS sg13g2_fill_1
XFILLER_117_737 VDD VSS sg13g2_decap_8
XFILLER_7_63 VDD VSS sg13g2_decap_8
XFILLER_117_748 VDD VSS sg13g2_fill_2
XFILLER_172_843 VDD VSS sg13g2_decap_8
X_14319_ _14319_/Q clkload40/A _14319_/D _14319_/RESET_B VDD VSS sg13g2_dfrbpq_1
XFILLER_7_371 VDD VSS sg13g2_decap_8
XFILLER_89_1288 VDD VSS sg13g2_decap_8
XFILLER_176_1247 VDD VSS sg13g2_decap_8
XFILLER_89_109 VDD VSS sg13g2_fill_1
XFILLER_171_375 VDD VSS sg13g2_decap_8
XFILLER_98_621 VDD VSS sg13g2_fill_1
Xfanout807 _12790_/S _15213_/Q VDD VSS sg13g2_buf_1
X_09860_ _14447_/D _14447_/Q _09860_/A1 _09870_/S VDD VSS sg13g2_mux2_1
Xfanout818 _12788_/S0 _12789_/S0 VDD VSS sg13g2_buf_1
XFILLER_63_1428 VDD VSS sg13g2_decap_8
XFILLER_112_442 VDD VSS sg13g2_decap_8
Xfanout829 fanout829/X _12425_/S1 VDD VSS sg13g2_buf_1
XFILLER_113_987 VDD VSS sg13g2_decap_4
XFILLER_140_773 VDD VSS sg13g2_decap_8
X_08811_ _13688_/D _08811_/A _08811_/B VDD VSS sg13g2_nor2_1
X_09791_ _14380_/D _09923_/A1 _14380_/Q _09793_/S VDD VSS sg13g2_mux2_1
XFILLER_98_698 VDD VSS sg13g2_fill_1
XFILLER_58_529 VDD VSS sg13g2_fill_1
XFILLER_112_486 VDD VSS sg13g2_decap_4
XFILLER_100_637 VDD VSS sg13g2_decap_8
XFILLER_112_497 VDD VSS sg13g2_fill_1
XFILLER_100_648 VDD VSS sg13g2_fill_1
XFILLER_113_1220 VDD VSS sg13g2_decap_8
X_08742_ _08742_/Y _08751_/A1 _07720_/B _15196_/Q VDD VSS sg13g2_o21ai_1
XFILLER_22_1125 VDD VSS sg13g2_decap_8
X_14574__1628 _14574_/RESET_B VDD VSS sg13g2_tiehi
XFILLER_6_1355 VDD VSS sg13g2_decap_8
XFILLER_38_242 VDD VSS sg13g2_decap_8
X_14610__1592 _14610_/RESET_B VDD VSS sg13g2_tiehi
X_08673_ _08673_/X _15019_/Q _08673_/B VDD VSS sg13g2_or2_1
XFILLER_38_264 VDD VSS sg13g2_fill_2
XFILLER_26_404 VDD VSS sg13g2_fill_1
XFILLER_94_893 VDD VSS sg13g2_decap_4
XFILLER_93_370 VDD VSS sg13g2_fill_2
XFILLER_26_28 VDD VSS sg13g2_decap_8
X_07624_ _07624_/Y _14838_/Q VDD VSS sg13g2_inv_1
XFILLER_38_297 VDD VSS sg13g2_decap_8
XFILLER_183_1218 VDD VSS sg13g2_decap_8
XFILLER_54_768 VDD VSS sg13g2_decap_8
XFILLER_13_109 VDD VSS sg13g2_decap_8
XFILLER_41_418 VDD VSS sg13g2_decap_8
XFILLER_146_1040 VDD VSS sg13g2_decap_8
XFILLER_35_993 VDD VSS sg13g2_decap_4
XFILLER_10_805 VDD VSS sg13g2_decap_8
XFILLER_50_974 VDD VSS sg13g2_decap_8
X_09225_ _13836_/D _10155_/A1 _13836_/Q _09225_/S VDD VSS sg13g2_mux2_1
XFILLER_42_49 VDD VSS sg13g2_decap_8
X_14897__2773 _14897_/RESET_B VDD VSS sg13g2_tiehi
XFILLER_21_175 VDD VSS sg13g2_fill_2
XFILLER_158_49 VDD VSS sg13g2_decap_8
XFILLER_166_147 VDD VSS sg13g2_decap_8
XFILLER_6_809 VDD VSS sg13g2_decap_8
XFILLER_33_1254 VDD VSS sg13g2_decap_8
X_09156_ _09158_/B _14924_/Q _09156_/B VDD VSS sg13g2_nand2b_1
XFILLER_147_350 VDD VSS sg13g2_decap_8
XFILLER_148_884 VDD VSS sg13g2_decap_8
XFILLER_5_308 VDD VSS sg13g2_decap_8
XFILLER_107_203 VDD VSS sg13g2_decap_8
XFILLER_107_214 VDD VSS sg13g2_fill_2
X_08107_ _08112_/D _07879_/A _08200_/B _08106_/Y VDD VSS sg13g2_o21ai_1
XFILLER_135_534 VDD VSS sg13g2_decap_8
XFILLER_159_1423 VDD VSS sg13g2_decap_8
XFILLER_163_843 VDD VSS sg13g2_decap_4
X_09087_ _09090_/B _14914_/Q _09087_/B VDD VSS sg13g2_nand2b_1
XFILLER_68_1328 VDD VSS sg13g2_decap_8
X_08038_ _08039_/D _08692_/A _07896_/X _08037_/A _08523_/B1 VDD VSS sg13g2_a22oi_1
XFILLER_135_589 VDD VSS sg13g2_decap_8
XFILLER_104_910 VDD VSS sg13g2_decap_8
XFILLER_1_525 VDD VSS sg13g2_decap_8
XFILLER_66_1052 VDD VSS sg13g2_fill_1
XFILLER_150_559 VDD VSS sg13g2_decap_8
XFILLER_153_1022 VDD VSS sg13g2_decap_8
XFILLER_103_442 VDD VSS sg13g2_decap_8
XFILLER_67_13 VDD VSS sg13g2_fill_1
X_10000_ _14583_/D _10066_/A0 _14583_/Q _10002_/S VDD VSS sg13g2_mux2_1
XFILLER_89_687 VDD VSS sg13g2_fill_1
XFILLER_76_304 VDD VSS sg13g2_fill_1
XFILLER_131_784 VDD VSS sg13g2_decap_8
XFILLER_27_1069 VDD VSS sg13g2_decap_8
X_09989_ _14572_/D _09989_/A0 _14572_/Q _09991_/S VDD VSS sg13g2_mux2_1
XFILLER_77_849 VDD VSS sg13g2_decap_8
XFILLER_44_1361 VDD VSS sg13g2_decap_8
XFILLER_40_1214 VDD VSS sg13g2_decap_8
XFILLER_79_1402 VDD VSS sg13g2_decap_8
X_11951_ _11952_/B _12090_/A _14672_/Q VDD VSS sg13g2_nand2_1
XFILLER_131_1386 VDD VSS sg13g2_decap_4
XFILLER_44_212 VDD VSS sg13g2_decap_8
XFILLER_166_1416 VDD VSS sg13g2_decap_8
XFILLER_17_448 VDD VSS sg13g2_fill_1
X_10902_ _14934_/D _14934_/Q _10929_/B _10901_/Y VDD VSS sg13g2_a21o_1
XFILLER_17_459 VDD VSS sg13g2_fill_1
X_14670_ _14670_/Q _14670_/CLK _14670_/D _14670_/RESET_B VDD VSS sg13g2_dfrbpq_1
X_11882_ _11882_/X _13742_/Q _14094_/Q _14446_/Q _14542_/Q _11882_/S0 _11897_/C VDD
+ VSS sg13g2_mux4_1
X_13621_ _13729_/D _13621_/A VDD VSS sg13g2_buf_1
X_10833_ _10876_/D _10844_/A _10844_/B _10851_/D VDD VSS sg13g2_nand3_1
XFILLER_73_1012 VDD VSS sg13g2_decap_8
XFILLER_44_289 VDD VSS sg13g2_decap_8
XFILLER_38_1132 VDD VSS sg13g2_decap_8
XFILLER_129_1271 VDD VSS sg13g2_decap_8
X_13552_ _13552_/Y _15006_/Q _13566_/B _13552_/C VDD VSS sg13g2_nor3_1
X_10764_ _10764_/X _14949_/Q _10767_/A _10762_/Y VDD VSS sg13g2_a21o_1
XFILLER_186_924 VDD VSS sg13g2_decap_8
XFILLER_13_665 VDD VSS sg13g2_decap_8
XFILLER_41_985 VDD VSS sg13g2_decap_4
XFILLER_158_648 VDD VSS sg13g2_decap_8
X_12503_ _12503_/X _13830_/Q _13862_/Q _13894_/Q _13926_/Q _12506_/S0 _12506_/S1 VDD
+ VSS sg13g2_mux4_1
XFILLER_8_102 VDD VSS sg13g2_decap_8
XFILLER_158_659 VDD VSS sg13g2_fill_2
XFILLER_185_434 VDD VSS sg13g2_decap_8
X_13483_ _13484_/C _08723_/A _08723_/B _15123_/Q VDD VSS sg13g2_o21ai_1
XFILLER_40_473 VDD VSS sg13g2_decap_8
XFILLER_12_175 VDD VSS sg13g2_decap_8
XFILLER_157_136 VDD VSS sg13g2_decap_8
X_10695_ _10696_/A _14901_/Q _10875_/B _10912_/B1 _10871_/A VDD VSS sg13g2_a22oi_1
XFILLER_157_147 VDD VSS sg13g2_fill_2
XFILLER_9_658 VDD VSS sg13g2_decap_8
XFILLER_139_862 VDD VSS sg13g2_decap_4
XFILLER_16_1463 VDD VSS sg13g2_decap_8
XFILLER_16_1474 VDD VSS sg13g2_fill_1
X_15222_ _15222_/Q _15228_/CLK _15222_/D _15222_/RESET_B VDD VSS sg13g2_dfrbpq_1
X_12434_ _12434_/X _14689_/Q _14721_/Q _13761_/Q _13793_/Q _12438_/S0 _12438_/S1 VDD
+ VSS sg13g2_mux4_1
XFILLER_51_1354 VDD VSS sg13g2_decap_8
XFILLER_12_1327 VDD VSS sg13g2_decap_8
XFILLER_138_361 VDD VSS sg13g2_fill_2
XFILLER_139_884 VDD VSS sg13g2_decap_8
XFILLER_126_512 VDD VSS sg13g2_decap_8
XFILLER_8_179 VDD VSS sg13g2_decap_8
XFILLER_154_843 VDD VSS sg13g2_fill_2
X_15153_ _15153_/Q clkload33/A _15153_/D _15153_/RESET_B VDD VSS sg13g2_dfrbpq_1
X_12365_ _12365_/X _14556_/Q _14588_/Q _14620_/Q _14652_/Q _12725_/S0 _12725_/S1 VDD
+ VSS sg13g2_mux4_1
XFILLER_165_191 VDD VSS sg13g2_decap_4
XFILLER_114_707 VDD VSS sg13g2_decap_8
XFILLER_153_342 VDD VSS sg13g2_decap_4
XFILLER_181_651 VDD VSS sg13g2_decap_8
X_14104_ _14104_/Q clkload46/A _14104_/D _14104_/RESET_B VDD VSS sg13g2_dfrbpq_1
X_11316_ _11318_/B _11315_/A1 _14461_/Q VDD VSS sg13g2_nand2b_1
X_15084_ _15084_/Q clkload81/A _15084_/D _15084_/RESET_B VDD VSS sg13g2_dfrbpq_1
XFILLER_5_875 VDD VSS sg13g2_decap_8
X_12296_ _12297_/B _11664_/A _12280_/Y _12295_/Y VDD VSS sg13g2_o21ai_1
XFILLER_180_161 VDD VSS sg13g2_decap_8
XFILLER_107_792 VDD VSS sg13g2_decap_8
X_14035_ _14035_/Q _15160_/CLK _14035_/D _14035_/RESET_B VDD VSS sg13g2_dfrbpq_1
XFILLER_4_385 VDD VSS sg13g2_decap_8
XFILLER_49_1261 VDD VSS sg13g2_decap_8
X_11247_ _11247_/X _11243_/B _07690_/X _11245_/Y VDD VSS sg13g2_a21o_1
XFILLER_84_1174 VDD VSS sg13g2_decap_8
XFILLER_164_70 VDD VSS sg13g2_decap_8
XFILLER_80_1016 VDD VSS sg13g2_fill_2
XFILLER_79_142 VDD VSS sg13g2_decap_8
XFILLER_110_913 VDD VSS sg13g2_decap_4
XFILLER_122_773 VDD VSS sg13g2_fill_1
XFILLER_136_1275 VDD VSS sg13g2_decap_8
X_11178_ _11186_/B _11177_/B _11177_/C _11197_/A VDD VSS sg13g2_o21ai_1
XFILLER_45_1158 VDD VSS sg13g2_decap_8
XFILLER_121_272 VDD VSS sg13g2_decap_8
XFILLER_122_795 VDD VSS sg13g2_decap_4
X_10129_ _14707_/D _10162_/A1 _14707_/Q _10134_/S VDD VSS sg13g2_mux2_1
XFILLER_67_348 VDD VSS sg13g2_decap_8
XFILLER_23_1423 VDD VSS sg13g2_decap_8
XFILLER_94_156 VDD VSS sg13g2_decap_8
XFILLER_110_1415 VDD VSS sg13g2_fill_1
XFILLER_82_318 VDD VSS sg13g2_fill_1
X_14937_ _14937_/Q clkload59/A _14937_/D _14937_/RESET_B VDD VSS sg13g2_dfrbpq_1
XFILLER_91_830 VDD VSS sg13g2_decap_8
XFILLER_180_91 VDD VSS sg13g2_decap_8
XFILLER_110_1459 VDD VSS sg13g2_decap_8
XFILLER_91_841 VDD VSS sg13g2_fill_1
XFILLER_24_908 VDD VSS sg13g2_decap_8
X_14868_ _14868_/Q clkload84/A _14868_/D _14868_/RESET_B VDD VSS sg13g2_dfrbpq_1
XFILLER_169_1084 VDD VSS sg13g2_fill_1
XFILLER_1_1274 VDD VSS sg13g2_decap_8
XFILLER_17_982 VDD VSS sg13g2_decap_4
X_13819_ _13819_/Q clkload80/A _13819_/D _13819_/RESET_B VDD VSS sg13g2_dfrbpq_1
X_14799_ _14799_/Q _15185_/CLK _14799_/D _14799_/RESET_B VDD VSS sg13g2_dfrbpq_1
XFILLER_108_1311 VDD VSS sg13g2_decap_8
XFILLER_91_1123 VDD VSS sg13g2_decap_8
XFILLER_50_237 VDD VSS sg13g2_decap_8
XFILLER_32_941 VDD VSS sg13g2_decap_8
XFILLER_143_1213 VDD VSS sg13g2_decap_8
XFILLER_177_913 VDD VSS sg13g2_decap_4
XFILLER_147_1393 VDD VSS sg13g2_decap_8
XFILLER_177_935 VDD VSS sg13g2_decap_8
XFILLER_56_1276 VDD VSS sg13g2_decap_8
XFILLER_17_1238 VDD VSS sg13g2_decap_8
XFILLER_104_1208 VDD VSS sg13g2_fill_1
XFILLER_31_473 VDD VSS sg13g2_fill_1
X_09010_ _09010_/Y _09141_/A _10697_/A _10697_/B VDD VSS sg13g2_nand3_1
XFILLER_31_495 VDD VSS sg13g2_decap_4
XFILLER_78_0 VDD VSS sg13g2_decap_8
XFILLER_30_1405 VDD VSS sg13g2_decap_8
XFILLER_117_512 VDD VSS sg13g2_decap_8
XFILLER_129_383 VDD VSS sg13g2_decap_8
XFILLER_172_662 VDD VSS sg13g2_decap_8
X_14628__1574 _14628_/RESET_B VDD VSS sg13g2_tiehi
XFILLER_104_206 VDD VSS sg13g2_decap_8
XFILLER_105_729 VDD VSS sg13g2_decap_8
XFILLER_117_589 VDD VSS sg13g2_fill_2
XFILLER_171_161 VDD VSS sg13g2_decap_4
XFILLER_172_684 VDD VSS sg13g2_decap_8
XFILLER_176_1066 VDD VSS sg13g2_decap_8
XFILLER_28_1301 VDD VSS sg13g2_decap_8
XFILLER_160_846 VDD VSS sg13g2_fill_1
X_09912_ _14497_/D _14497_/Q _09912_/A1 _09927_/S VDD VSS sg13g2_mux2_1
XFILLER_132_559 VDD VSS sg13g2_decap_4
XFILLER_154_1331 VDD VSS sg13g2_decap_8
Xfanout604 _11196_/B _11102_/B VDD VSS sg13g2_buf_1
XFILLER_98_440 VDD VSS sg13g2_decap_8
Xfanout615 _10675_/A fanout622/X VDD VSS sg13g2_buf_1
XFILLER_63_1225 VDD VSS sg13g2_decap_8
Xfanout626 _08893_/A _10788_/S VDD VSS sg13g2_buf_1
Xfanout637 _08928_/S _08922_/S VDD VSS sg13g2_buf_1
X_09843_ _14430_/D _14430_/Q _10141_/A1 _09865_/S VDD VSS sg13g2_mux2_1
XFILLER_8_1439 VDD VSS sg13g2_decap_8
Xfanout648 _08674_/B1 _07998_/X VDD VSS sg13g2_buf_1
XFILLER_28_1378 VDD VSS sg13g2_decap_8
Xfanout659 _08432_/A2 _07993_/Y VDD VSS sg13g2_buf_1
XFILLER_98_495 VDD VSS sg13g2_decap_8
XFILLER_150_1239 VDD VSS sg13g2_decap_8
X_09774_ _14363_/D _09906_/A1 _14363_/Q _09805_/S VDD VSS sg13g2_mux2_1
XFILLER_6_1152 VDD VSS sg13g2_decap_8
XFILLER_100_478 VDD VSS sg13g2_decap_8
XFILLER_37_49 VDD VSS sg13g2_decap_8
X_08725_ _13482_/A _15129_/Q _15124_/Q _15071_/Q VDD VSS sg13g2_or3_1
XFILLER_67_882 VDD VSS sg13g2_decap_8
XFILLER_39_573 VDD VSS sg13g2_decap_8
XFILLER_160_39 VDD VSS sg13g2_decap_8
XFILLER_96_1012 VDD VSS sg13g2_decap_8
XFILLER_94_690 VDD VSS sg13g2_fill_2
XFILLER_39_595 VDD VSS sg13g2_decap_8
XFILLER_66_392 VDD VSS sg13g2_fill_2
X_08656_ _08656_/X _08669_/B1 _08619_/Y _08402_/C VDD VSS sg13g2_a21o_1
XFILLER_96_1045 VDD VSS sg13g2_decap_8
XFILLER_96_1056 VDD VSS sg13g2_fill_2
XFILLER_26_256 VDD VSS sg13g2_decap_8
XFILLER_74_1310 VDD VSS sg13g2_decap_8
XFILLER_14_429 VDD VSS sg13g2_decap_8
X_08587_ _08587_/Y _08586_/B _08586_/C _08641_/C VDD VSS sg13g2_a21oi_1
XFILLER_156_7 VDD VSS sg13g2_decap_8
XFILLER_42_749 VDD VSS sg13g2_fill_2
XFILLER_39_1441 VDD VSS sg13g2_decap_8
XFILLER_148_1179 VDD VSS sg13g2_decap_8
XFILLER_161_1324 VDD VSS sg13g2_decap_8
XFILLER_179_272 VDD VSS sg13g2_decap_8
XFILLER_10_602 VDD VSS sg13g2_decap_8
XFILLER_74_1387 VDD VSS sg13g2_decap_8
XFILLER_35_1338 VDD VSS sg13g2_decap_8
XFILLER_126_1477 VDD VSS sg13g2_fill_2
XFILLER_50_782 VDD VSS sg13g2_decap_8
XFILLER_168_979 VDD VSS sg13g2_fill_1
XFILLER_167_456 VDD VSS sg13g2_decap_8
XFILLER_22_495 VDD VSS sg13g2_decap_4
X_09208_ _10070_/C _09905_/A _10105_/C VDD VSS sg13g2_nor2_1
XFILLER_6_606 VDD VSS sg13g2_decap_8
X_10480_ _10482_/A _13084_/A _10489_/D _10499_/C VDD VSS sg13g2_o21ai_1
XFILLER_185_14 VDD VSS sg13g2_decap_8
XFILLER_10_679 VDD VSS sg13g2_decap_8
XFILLER_120_1021 VDD VSS sg13g2_decap_8
XFILLER_136_821 VDD VSS sg13g2_decap_8
XFILLER_5_105 VDD VSS sg13g2_decap_8
XFILLER_154_139 VDD VSS sg13g2_decap_8
XFILLER_182_448 VDD VSS sg13g2_decap_8
X_09139_ _13782_/D _13782_/Q _10165_/A1 _09167_/S VDD VSS sg13g2_mux2_1
XFILLER_159_1220 VDD VSS sg13g2_decap_8
XFILLER_68_1103 VDD VSS sg13g2_fill_1
XFILLER_120_1065 VDD VSS sg13g2_decap_8
Xclkbuf_5_14__f_clk_i clkbuf_leaf_42_clk_i/A clkbuf_4_7_0_clk_i/X VDD VSS sg13g2_buf_16
XFILLER_68_1125 VDD VSS sg13g2_decap_8
XFILLER_120_1076 VDD VSS sg13g2_decap_4
X_12150_ _12150_/Y _12152_/A _12298_/B VDD VSS sg13g2_nor2_1
XFILLER_135_375 VDD VSS sg13g2_decap_8
XFILLER_2_812 VDD VSS sg13g2_decap_8
XFILLER_123_537 VDD VSS sg13g2_decap_8
X_11101_ _14948_/D _11100_/Y _11099_/Y _11084_/Y VDD VSS sg13g2_o21ai_1
XFILLER_151_857 VDD VSS sg13g2_decap_8
XFILLER_159_1297 VDD VSS sg13g2_decap_8
XFILLER_1_322 VDD VSS sg13g2_decap_8
X_12081_ _14981_/D _12061_/A _12126_/A _12080_/Y VDD VSS sg13g2_a21o_1
XFILLER_172_1431 VDD VSS sg13g2_decap_8
XFILLER_81_1314 VDD VSS sg13g2_decap_8
XFILLER_133_1404 VDD VSS sg13g2_decap_8
X_11032_ _11032_/Y _11052_/B _14760_/Q VDD VSS sg13g2_nor2b_1
XFILLER_46_1456 VDD VSS sg13g2_decap_8
XFILLER_103_250 VDD VSS sg13g2_fill_2
X_13722__2480 _13722_/RESET_B VDD VSS sg13g2_tiehi
XFILLER_2_889 VDD VSS sg13g2_decap_8
XFILLER_133_1426 VDD VSS sg13g2_decap_8
XFILLER_76_112 VDD VSS sg13g2_fill_1
XFILLER_1_399 VDD VSS sg13g2_decap_8
XFILLER_76_123 VDD VSS sg13g2_fill_1
XFILLER_94_11 VDD VSS sg13g2_decap_8
XFILLER_40_1022 VDD VSS sg13g2_decap_8
XFILLER_92_627 VDD VSS sg13g2_decap_8
XFILLER_131_1161 VDD VSS sg13g2_decap_8
X_12983_ _12984_/B _12983_/A1 _12982_/Y _12975_/X _12878_/D _12979_/Y VDD VSS sg13g2_a221oi_1
X_14066__2136 _14066_/RESET_B VDD VSS sg13g2_tiehi
XFILLER_17_212 VDD VSS sg13g2_decap_8
XFILLER_79_1232 VDD VSS sg13g2_decap_8
XFILLER_73_830 VDD VSS sg13g2_decap_8
X_14722_ _14722_/Q _14722_/CLK _14722_/D _14722_/RESET_B VDD VSS sg13g2_dfrbpq_1
XFILLER_166_1213 VDD VSS sg13g2_decap_8
X_11934_ _11934_/Y _11936_/A _11934_/B VDD VSS sg13g2_nor2_1
XFILLER_33_705 VDD VSS sg13g2_fill_2
XFILLER_72_362 VDD VSS sg13g2_decap_8
X_14653_ _14653_/Q clkload32/A _14653_/D _14653_/RESET_B VDD VSS sg13g2_dfrbpq_1
X_11865_ _11910_/C _11865_/A _13674_/Q VDD VSS sg13g2_xnor2_1
X_15005__2605 _15005_/RESET_B VDD VSS sg13g2_tiehi
X_13604_ _15165_/D _13603_/Y _10173_/B _13599_/Y VDD VSS sg13g2_a21oi_1
X_14706__1496 _14706_/RESET_B VDD VSS sg13g2_tiehi
X_10816_ _10816_/Y _10843_/C _10851_/A _10429_/D VDD VSS sg13g2_o21ai_1
XFILLER_53_1405 VDD VSS sg13g2_decap_8
XFILLER_158_401 VDD VSS sg13g2_fill_2
X_14584_ _14584_/Q clkload45/A _14584_/D _14584_/RESET_B VDD VSS sg13g2_dfrbpq_1
X_11796_ _11839_/A _11798_/A _11934_/B VDD VSS sg13g2_nor2_1
XFILLER_92_1465 VDD VSS sg13g2_decap_8
XFILLER_32_259 VDD VSS sg13g2_decap_8
XFILLER_14_974 VDD VSS sg13g2_decap_8
XFILLER_186_721 VDD VSS sg13g2_decap_8
X_13535_ _13535_/Y _13535_/A _13535_/B VDD VSS sg13g2_nor2_1
XFILLER_185_231 VDD VSS sg13g2_decap_8
X_10747_ _10747_/Y _10752_/A _10747_/B VDD VSS sg13g2_nor2_1
XFILLER_159_70 VDD VSS sg13g2_decap_8
XFILLER_16_1260 VDD VSS sg13g2_decap_8
XFILLER_174_927 VDD VSS sg13g2_decap_8
XFILLER_9_455 VDD VSS sg13g2_decap_8
XFILLER_71_7 VDD VSS sg13g2_decap_8
XFILLER_51_1151 VDD VSS sg13g2_decap_8
XFILLER_145_106 VDD VSS sg13g2_decap_4
XFILLER_186_798 VDD VSS sg13g2_decap_8
X_13466_ _15108_/D _13459_/Y _13463_/X _13465_/Y VDD VSS sg13g2_o21ai_1
X_10678_ _14896_/D _10886_/B1 _10813_/A _10674_/Y VDD VSS sg13g2_o21ai_1
XFILLER_103_1230 VDD VSS sg13g2_decap_4
XFILLER_12_1124 VDD VSS sg13g2_decap_8
X_15205_ _15205_/Q clkload73/A _15205_/D _15205_/RESET_B VDD VSS sg13g2_dfrbpq_1
X_12417_ _14993_/D _12415_/Y _12416_/Y _12403_/Y VDD VSS sg13g2_a21oi_1
XFILLER_154_640 VDD VSS sg13g2_decap_8
XFILLER_103_1274 VDD VSS sg13g2_decap_8
XFILLER_177_1331 VDD VSS sg13g2_decap_8
X_13397_ _15086_/D _15086_/Q _13470_/A2 _13396_/Y VDD VSS sg13g2_a21o_1
XFILLER_142_802 VDD VSS sg13g2_fill_2
XFILLER_86_1225 VDD VSS sg13g2_decap_8
XFILLER_126_353 VDD VSS sg13g2_fill_1
XFILLER_160_109 VDD VSS sg13g2_decap_8
XFILLER_114_504 VDD VSS sg13g2_decap_4
X_15136_ _15136_/Q _15139_/CLK _15136_/D _15136_/RESET_B VDD VSS sg13g2_dfrbpq_1
X_12348_ _12348_/Y _12348_/A _15217_/Q _15126_/Q _12348_/D VDD VSS sg13g2_nor4_1
XFILLER_5_672 VDD VSS sg13g2_decap_8
XFILLER_114_537 VDD VSS sg13g2_decap_8
XFILLER_142_846 VDD VSS sg13g2_fill_1
XFILLER_181_481 VDD VSS sg13g2_decap_8
XFILLER_173_1239 VDD VSS sg13g2_decap_8
X_15067_ _15067_/Q _15165_/CLK _15067_/D _15067_/RESET_B VDD VSS sg13g2_dfrbpq_1
X_12279_ _12280_/B _12277_/X _12279_/B VDD VSS sg13g2_nand2b_1
XFILLER_4_42 VDD VSS sg13g2_decap_8
XFILLER_4_182 VDD VSS sg13g2_decap_8
X_14276__1926 _14276_/RESET_B VDD VSS sg13g2_tiehi
XFILLER_49_1080 VDD VSS sg13g2_fill_2
X_14018_ _14018_/Q _14727_/CLK _14018_/D _14018_/RESET_B VDD VSS sg13g2_dfrbpq_1
XFILLER_141_389 VDD VSS sg13g2_decap_8
X_14312__1890 _14312_/RESET_B VDD VSS sg13g2_tiehi
XFILLER_95_443 VDD VSS sg13g2_fill_2
XFILLER_23_1220 VDD VSS sg13g2_decap_8
XFILLER_95_465 VDD VSS sg13g2_fill_1
XFILLER_67_167 VDD VSS sg13g2_decap_8
XFILLER_114_1381 VDD VSS sg13g2_decap_4
XFILLER_110_1234 VDD VSS sg13g2_fill_1
X_14491__1711 _14491_/RESET_B VDD VSS sg13g2_tiehi
X_08510_ _08510_/X _11936_/A _07820_/B _08471_/B _07949_/C _13509_/A1 _13510_/A1 VDD
+ VSS sg13g2_mux4_1
XFILLER_36_532 VDD VSS sg13g2_decap_8
XFILLER_23_1297 VDD VSS sg13g2_decap_8
X_09490_ _14090_/D _10153_/A1 _14090_/Q _09494_/S VDD VSS sg13g2_mux2_1
XFILLER_3_1369 VDD VSS sg13g2_decap_8
XFILLER_184_1324 VDD VSS sg13g2_decap_8
XFILLER_149_1444 VDD VSS sg13g2_decap_8
XFILLER_24_716 VDD VSS sg13g2_decap_8
XFILLER_110_1289 VDD VSS sg13g2_decap_8
X_08441_ _15235_/D _08441_/A _08441_/B _08441_/C _08441_/D VDD VSS sg13g2_nand4_1
XFILLER_63_362 VDD VSS sg13g2_decap_8
XFILLER_51_513 VDD VSS sg13g2_decap_8
XFILLER_1_1071 VDD VSS sg13g2_decap_8
X_08372_ _08372_/Y _07795_/A _08370_/Y _08371_/Y VDD VSS sg13g2_a21oi_1
XFILLER_149_401 VDD VSS sg13g2_decap_8
XFILLER_51_568 VDD VSS sg13g2_decap_8
XFILLER_23_18 VDD VSS sg13g2_decap_8
Xclkbuf_4_15_0_clk_i clkbuf_4_15_0_clk_i/X clkbuf_0_clk_i/X VDD VSS sg13g2_buf_8
XFILLER_20_911 VDD VSS sg13g2_fill_1
XFILLER_20_922 VDD VSS sg13g2_decap_8
XFILLER_143_1043 VDD VSS sg13g2_decap_8
X_13764__2438 _13764_/RESET_B VDD VSS sg13g2_tiehi
XFILLER_32_793 VDD VSS sg13g2_fill_1
XFILLER_108_1174 VDD VSS sg13g2_decap_8
XFILLER_104_1027 VDD VSS sg13g2_decap_8
XFILLER_30_1202 VDD VSS sg13g2_decap_8
XFILLER_178_1117 VDD VSS sg13g2_decap_8
XFILLER_136_128 VDD VSS sg13g2_decap_8
XFILLER_69_1423 VDD VSS sg13g2_decap_8
XFILLER_121_1374 VDD VSS sg13g2_decap_8
XFILLER_118_876 VDD VSS sg13g2_decap_8
XFILLER_30_1279 VDD VSS sg13g2_decap_8
XFILLER_144_150 VDD VSS sg13g2_fill_1
X_14144__2058 _14144_/RESET_B VDD VSS sg13g2_tiehi
XFILLER_155_39 VDD VSS sg13g2_decap_8
XFILLER_2_119 VDD VSS sg13g2_decap_8
XFILLER_133_846 VDD VSS sg13g2_decap_8
XFILLER_156_1448 VDD VSS sg13g2_decap_8
XFILLER_160_665 VDD VSS sg13g2_decap_8
Xfanout401 _10140_/A1 _09875_/A0 VDD VSS sg13g2_buf_1
Xfanout412 _13470_/A2 _13353_/Y VDD VSS sg13g2_buf_1
XFILLER_115_1101 VDD VSS sg13g2_fill_2
Xfanout423 _10130_/S _10103_/Y VDD VSS sg13g2_buf_1
XFILLER_119_1281 VDD VSS sg13g2_decap_4
Xfanout434 _09997_/S fanout438/X VDD VSS sg13g2_buf_1
XFILLER_86_410 VDD VSS sg13g2_fill_2
XFILLER_63_1044 VDD VSS sg13g2_fill_2
XFILLER_58_101 VDD VSS sg13g2_fill_1
Xfanout445 _09795_/S _09789_/S VDD VSS sg13g2_buf_1
XFILLER_8_1236 VDD VSS sg13g2_decap_8
XFILLER_87_944 VDD VSS sg13g2_fill_2
XFILLER_28_1175 VDD VSS sg13g2_decap_8
XFILLER_86_421 VDD VSS sg13g2_decap_8
XFILLER_101_743 VDD VSS sg13g2_decap_4
XFILLER_154_1183 VDD VSS sg13g2_decap_8
Xfanout456 _09661_/S _09641_/X VDD VSS sg13g2_buf_1
XFILLER_100_220 VDD VSS sg13g2_decap_8
Xfanout467 _09539_/S _09527_/S VDD VSS sg13g2_buf_1
X_09826_ _14414_/D _10157_/A1 _14414_/Q _09826_/S VDD VSS sg13g2_mux2_1
Xfanout478 _09405_/S fanout480/X VDD VSS sg13g2_buf_1
XFILLER_86_454 VDD VSS sg13g2_decap_8
XFILLER_150_1047 VDD VSS sg13g2_fill_1
XFILLER_171_49 VDD VSS sg13g2_decap_8
Xfanout489 _09225_/S _09227_/S VDD VSS sg13g2_buf_1
XFILLER_41_1320 VDD VSS sg13g2_decap_8
XFILLER_104_21 VDD VSS sg13g2_decap_8
XFILLER_115_1178 VDD VSS sg13g2_fill_2
XFILLER_80_1391 VDD VSS sg13g2_decap_8
X_09757_ _14347_/D _14347_/Q _09922_/A1 _09766_/S VDD VSS sg13g2_mux2_1
XFILLER_74_638 VDD VSS sg13g2_decap_8
XFILLER_27_510 VDD VSS sg13g2_decap_4
XFILLER_73_126 VDD VSS sg13g2_decap_8
XFILLER_64_14 VDD VSS sg13g2_decap_8
X_08708_ _13659_/D _15186_/D _15117_/Q _13651_/S VDD VSS sg13g2_mux2_1
XFILLER_41_1397 VDD VSS sg13g2_decap_8
XFILLER_104_98 VDD VSS sg13g2_decap_8
X_09688_ _14280_/D _09919_/A1 _14280_/Q _09692_/S VDD VSS sg13g2_mux2_1
XFILLER_70_811 VDD VSS sg13g2_decap_8
XFILLER_27_576 VDD VSS sg13g2_fill_2
XFILLER_14_215 VDD VSS sg13g2_decap_8
X_08639_ _08640_/B _08678_/B _08674_/B1 _08522_/C _08650_/A VDD VSS sg13g2_a22oi_1
XFILLER_15_749 VDD VSS sg13g2_decap_4
XFILLER_163_1408 VDD VSS sg13g2_decap_8
XFILLER_82_693 VDD VSS sg13g2_decap_8
X_11650_ _11650_/X _14119_/Q _14151_/Q _14183_/Q _14215_/Q _11972_/S0 _11970_/C VDD
+ VSS sg13g2_mux4_1
XFILLER_35_1102 VDD VSS sg13g2_fill_2
XFILLER_11_911 VDD VSS sg13g2_decap_8
XFILLER_161_1121 VDD VSS sg13g2_decap_8
X_10601_ _10602_/C _14877_/Q _14876_/Q _14875_/Q _10607_/C VDD VSS sg13g2_and4_1
XFILLER_80_35 VDD VSS sg13g2_decap_8
XFILLER_74_1184 VDD VSS sg13g2_decap_8
XFILLER_35_1135 VDD VSS sg13g2_decap_8
XFILLER_167_220 VDD VSS sg13g2_fill_1
X_11581_ _11582_/B _11573_/X _11574_/X _11577_/X _11578_/X _11964_/B _11974_/B1 VDD
+ VSS sg13g2_mux4_1
X_14354__1848 _14354_/RESET_B VDD VSS sg13g2_tiehi
XFILLER_50_590 VDD VSS sg13g2_decap_8
XFILLER_122_1116 VDD VSS sg13g2_decap_8
XFILLER_167_253 VDD VSS sg13g2_fill_1
XFILLER_168_776 VDD VSS sg13g2_decap_8
XFILLER_167_264 VDD VSS sg13g2_fill_2
X_13320_ _13322_/B _13320_/A _15064_/Q _13320_/C VDD VSS sg13g2_nand3_1
X_10532_ _14859_/D _10533_/B _10626_/B _10532_/C VDD VSS sg13g2_and3_1
XFILLER_13_1411 VDD VSS sg13g2_decap_8
XFILLER_161_1198 VDD VSS sg13g2_decap_8
XFILLER_6_403 VDD VSS sg13g2_decap_8
XFILLER_11_988 VDD VSS sg13g2_decap_8
XFILLER_183_735 VDD VSS sg13g2_decap_8
XFILLER_109_832 VDD VSS sg13g2_fill_2
XFILLER_10_476 VDD VSS sg13g2_decap_8
XFILLER_7_959 VDD VSS sg13g2_decap_8
XFILLER_13_95 VDD VSS sg13g2_decap_8
X_13251_ _13251_/Y _13251_/A _13251_/B _13251_/C VDD VSS sg13g2_nand3_1
X_10463_ _10463_/Y _10471_/C _10471_/D _10557_/C VDD VSS sg13g2_o21ai_1
XFILLER_89_11 VDD VSS sg13g2_decap_4
XFILLER_171_919 VDD VSS sg13g2_decap_8
XFILLER_182_256 VDD VSS sg13g2_decap_8
XFILLER_108_353 VDD VSS sg13g2_decap_8
XFILLER_100_1436 VDD VSS sg13g2_decap_8
XFILLER_124_813 VDD VSS sg13g2_decap_8
XFILLER_142_109 VDD VSS sg13g2_decap_4
X_12202_ _12274_/A _12203_/A _13665_/Q VDD VSS sg13g2_nand2_1
XFILLER_170_429 VDD VSS sg13g2_fill_1
X_13182_ _13182_/Y _13179_/Y _13180_/Y _13181_/Y VDD VSS sg13g2_a21oi_1
XFILLER_108_375 VDD VSS sg13g2_decap_8
XFILLER_151_610 VDD VSS sg13g2_decap_8
X_10394_ _10395_/C _14820_/Q _14821_/Q _14822_/Q VDD VSS sg13g2_nand3_1
XFILLER_135_183 VDD VSS sg13g2_decap_8
X_12133_ _12133_/X _14581_/Q _14613_/Q _14645_/Q _14677_/Q _12139_/S0 _12139_/S1 VDD
+ VSS sg13g2_mux4_1
XFILLER_123_345 VDD VSS sg13g2_fill_2
XFILLER_151_654 VDD VSS sg13g2_decap_4
XFILLER_123_367 VDD VSS sg13g2_decap_8
XFILLER_78_900 VDD VSS sg13g2_decap_8
X_12064_ _12065_/B _12062_/A _12062_/B _12197_/A VDD VSS sg13g2_a21o_1
XFILLER_133_1201 VDD VSS sg13g2_decap_8
XFILLER_151_698 VDD VSS sg13g2_decap_8
XFILLER_46_1253 VDD VSS sg13g2_decap_8
XFILLER_2_686 VDD VSS sg13g2_decap_8
XFILLER_133_1212 VDD VSS sg13g2_fill_1
XFILLER_137_1381 VDD VSS sg13g2_fill_1
XFILLER_78_944 VDD VSS sg13g2_decap_8
XFILLER_49_112 VDD VSS sg13g2_decap_8
X_11015_ _11052_/D _11015_/A _11042_/B _11015_/C _11042_/D VDD VSS sg13g2_nand4_1
XFILLER_1_196 VDD VSS sg13g2_decap_8
XFILLER_77_443 VDD VSS sg13g2_fill_1
XFILLER_42_1128 VDD VSS sg13g2_decap_8
X_16872_ _16872_/X _16872_/A VDD VSS sg13g2_buf_1
XFILLER_81_1177 VDD VSS sg13g2_fill_1
XFILLER_133_1267 VDD VSS sg13g2_decap_4
Xfanout990 _13427_/C _15096_/Q VDD VSS sg13g2_buf_1
XFILLER_38_81 VDD VSS sg13g2_decap_4
XFILLER_93_969 VDD VSS sg13g2_decap_4
XFILLER_64_137 VDD VSS sg13g2_fill_1
XFILLER_46_841 VDD VSS sg13g2_decap_8
XFILLER_92_468 VDD VSS sg13g2_fill_2
XFILLER_20_1459 VDD VSS sg13g2_decap_8
X_12966_ _12966_/Y _12963_/Y _12964_/Y _12965_/Y VDD VSS sg13g2_a21oi_1
XFILLER_79_1051 VDD VSS sg13g2_decap_8
XFILLER_166_1010 VDD VSS sg13g2_decap_8
XFILLER_166_1021 VDD VSS sg13g2_fill_2
XFILLER_18_576 VDD VSS sg13g2_decap_8
X_14705_ _14705_/Q _15139_/CLK _14705_/D _14705_/RESET_B VDD VSS sg13g2_dfrbpq_1
XFILLER_61_822 VDD VSS sg13g2_decap_4
X_11917_ _11917_/Y _11917_/A _12055_/A VDD VSS sg13g2_xnor2_1
XFILLER_73_693 VDD VSS sg13g2_decap_8
XFILLER_127_1005 VDD VSS sg13g2_decap_8
X_12897_ _12897_/Y _14773_/Q _12918_/A2 _12918_/B1 VDD VSS sg13g2_o21ai_1
X_14636_ _14636_/Q _14668_/CLK _14636_/D _14636_/RESET_B VDD VSS sg13g2_dfrbpq_1
XFILLER_54_80 VDD VSS sg13g2_decap_8
X_11848_ _11848_/X _13741_/Q _14093_/Q _14445_/Q _14541_/Q _11963_/S0 _11963_/S1 VDD
+ VSS sg13g2_mux4_1
XFILLER_53_1202 VDD VSS sg13g2_decap_8
XFILLER_18_1322 VDD VSS sg13g2_decap_8
XFILLER_60_365 VDD VSS sg13g2_decap_8
XFILLER_92_1284 VDD VSS sg13g2_decap_4
XFILLER_13_270 VDD VSS sg13g2_decap_8
XFILLER_158_231 VDD VSS sg13g2_decap_4
X_14567_ _14567_/Q _14727_/CLK _14567_/D _14567_/RESET_B VDD VSS sg13g2_dfrbpq_1
X_11779_ _11779_/Y _11910_/A _11912_/A VDD VSS sg13g2_nor2_1
XFILLER_119_618 VDD VSS sg13g2_decap_8
XFILLER_147_927 VDD VSS sg13g2_decap_8
XFILLER_14_1219 VDD VSS sg13g2_decap_8
XFILLER_158_264 VDD VSS sg13g2_decap_8
XFILLER_18_1399 VDD VSS sg13g2_decap_8
X_13518_ _13518_/Y _13517_/A _13563_/C _08263_/B _13546_/B2 VDD VSS sg13g2_a22oi_1
XFILLER_9_252 VDD VSS sg13g2_decap_8
XFILLER_53_1279 VDD VSS sg13g2_decap_8
XFILLER_173_201 VDD VSS sg13g2_decap_8
XFILLER_118_117 VDD VSS sg13g2_decap_4
XFILLER_173_212 VDD VSS sg13g2_fill_1
XFILLER_186_595 VDD VSS sg13g2_decap_8
X_14498_ _14498_/Q _14704_/CLK _14498_/D _14498_/RESET_B VDD VSS sg13g2_dfrbpq_1
Xclkload11 clkload11/X clkload11/A VDD VSS sg13g2_buf_8
X_13449_ _13449_/X _15196_/Q _13449_/B VDD VSS sg13g2_or2_1
Xclkload22 clkload22/Y clkload22/A VDD VSS sg13g2_inv_4
Xclkload33 clkload33/Y clkload33/A VDD VSS sg13g2_inv_2
Xclkload44 clkload44/Y clkload44/A VDD VSS sg13g2_inv_1
Xclkload55 clkload55/Y clkload55/A VDD VSS sg13g2_inv_2
XFILLER_126_150 VDD VSS sg13g2_fill_1
XFILLER_6_970 VDD VSS sg13g2_decap_8
XFILLER_114_301 VDD VSS sg13g2_decap_4
XFILLER_126_161 VDD VSS sg13g2_decap_4
Xclkload66 clkload66/Y clkload66/A VDD VSS sg13g2_inv_1
XFILLER_86_1033 VDD VSS sg13g2_decap_8
XFILLER_138_1112 VDD VSS sg13g2_decap_4
XFILLER_142_621 VDD VSS sg13g2_fill_2
XFILLER_170_930 VDD VSS sg13g2_decap_8
Xclkload77 clkload77/Y clkload77/A VDD VSS sg13g2_inv_2
XFILLER_138_1123 VDD VSS sg13g2_decap_8
Xclkload88 clkload88/Y clkload88/A VDD VSS sg13g2_inv_1
XFILLER_47_1006 VDD VSS sg13g2_fill_2
XFILLER_115_857 VDD VSS sg13g2_decap_8
XFILLER_141_120 VDD VSS sg13g2_decap_8
X_15119_ _15119_/Q _15214_/CLK _15119_/D _15119_/RESET_B VDD VSS sg13g2_dfrbpq_1
XFILLER_47_1028 VDD VSS sg13g2_decap_8
X_08990_ _13759_/D _13759_/Q _10142_/A1 _09127_/S VDD VSS sg13g2_mux2_1
XFILLER_88_719 VDD VSS sg13g2_fill_2
XFILLER_138_1167 VDD VSS sg13g2_fill_2
XFILLER_87_207 VDD VSS sg13g2_fill_2
XFILLER_141_175 VDD VSS sg13g2_decap_4
X_07941_ _07942_/A _07796_/Y _07940_/Y _07938_/Y VDD VSS sg13g2_a21o_1
XFILLER_116_1432 VDD VSS sg13g2_decap_8
XFILLER_64_1386 VDD VSS sg13g2_decap_8
XFILLER_60_1217 VDD VSS sg13g2_decap_8
X_07872_ _07876_/A _07909_/B _07910_/A VDD VSS sg13g2_nand2_1
XFILLER_25_1348 VDD VSS sg13g2_decap_8
XFILLER_95_240 VDD VSS sg13g2_decap_8
XFILLER_84_903 VDD VSS sg13g2_fill_2
XFILLER_99_1416 VDD VSS sg13g2_decap_8
XFILLER_68_465 VDD VSS sg13g2_decap_8
XFILLER_18_18 VDD VSS sg13g2_decap_8
XFILLER_68_476 VDD VSS sg13g2_fill_2
X_09611_ _14207_/D _09910_/A1 _14207_/Q _09622_/S VDD VSS sg13g2_mux2_1
XFILLER_83_413 VDD VSS sg13g2_fill_2
X_13818__2384 _13818_/RESET_B VDD VSS sg13g2_tiehi
XFILLER_55_137 VDD VSS sg13g2_decap_8
XFILLER_110_1031 VDD VSS sg13g2_decap_8
XFILLER_23_1083 VDD VSS sg13g2_decap_4
X_09542_ _14140_/D _09841_/A1 _14140_/Q _09572_/S VDD VSS sg13g2_mux2_1
XFILLER_110_1042 VDD VSS sg13g2_fill_1
XFILLER_83_468 VDD VSS sg13g2_decap_8
XFILLER_37_863 VDD VSS sg13g2_decap_8
XFILLER_3_1166 VDD VSS sg13g2_decap_8
XFILLER_37_874 VDD VSS sg13g2_fill_1
XFILLER_184_1121 VDD VSS sg13g2_decap_8
XFILLER_97_1173 VDD VSS sg13g2_fill_2
XFILLER_24_502 VDD VSS sg13g2_decap_8
X_09473_ _14074_/D _09638_/A0 _14074_/Q _09473_/S VDD VSS sg13g2_mux2_1
XFILLER_52_833 VDD VSS sg13g2_decap_4
XFILLER_93_1037 VDD VSS sg13g2_decap_8
XFILLER_24_546 VDD VSS sg13g2_fill_1
XFILLER_169_518 VDD VSS sg13g2_fill_1
XFILLER_63_192 VDD VSS sg13g2_fill_2
XFILLER_58_1168 VDD VSS sg13g2_decap_8
XFILLER_51_332 VDD VSS sg13g2_fill_1
XFILLER_149_1296 VDD VSS sg13g2_fill_1
X_08424_ _15234_/D _08424_/A1 _08423_/X _08410_/X VDD VSS sg13g2_o21ai_1
X_13997__2205 _13997_/RESET_B VDD VSS sg13g2_tiehi
XFILLER_36_1411 VDD VSS sg13g2_decap_8
XFILLER_184_1198 VDD VSS sg13g2_decap_8
XFILLER_24_579 VDD VSS sg13g2_decap_8
XFILLER_11_207 VDD VSS sg13g2_decap_8
XFILLER_71_1313 VDD VSS sg13g2_decap_8
XFILLER_162_1430 VDD VSS sg13g2_decap_8
X_08355_ _15231_/D _08424_/A1 _08354_/Y _08347_/Y VDD VSS sg13g2_o21ai_1
XFILLER_123_1403 VDD VSS sg13g2_decap_8
Xclkload5 clkload5/X clkload5/A VDD VSS sg13g2_buf_8
X_08286_ _08286_/Y _08286_/A _08286_/B _08286_/C VDD VSS sg13g2_nor3_1
XFILLER_149_286 VDD VSS sg13g2_decap_8
XFILLER_123_1469 VDD VSS sg13g2_fill_1
XFILLER_164_223 VDD VSS sg13g2_decap_4
XFILLER_166_49 VDD VSS sg13g2_decap_8
XFILLER_69_1220 VDD VSS sg13g2_decap_8
XFILLER_106_813 VDD VSS sg13g2_fill_1
XFILLER_121_1182 VDD VSS sg13g2_decap_8
XFILLER_3_417 VDD VSS sg13g2_decap_8
XFILLER_105_301 VDD VSS sg13g2_fill_1
XFILLER_156_1201 VDD VSS sg13g2_decap_8
XFILLER_105_323 VDD VSS sg13g2_decap_8
XFILLER_59_14 VDD VSS sg13g2_decap_8
XFILLER_106_879 VDD VSS sg13g2_decap_8
XFILLER_1_7 VDD VSS sg13g2_decap_8
XFILLER_69_1297 VDD VSS sg13g2_decap_8
XFILLER_117_1207 VDD VSS sg13g2_decap_8
XFILLER_156_1267 VDD VSS sg13g2_decap_8
XFILLER_160_473 VDD VSS sg13g2_fill_2
XFILLER_161_996 VDD VSS sg13g2_decap_8
XFILLER_105_389 VDD VSS sg13g2_decap_8
XFILLER_82_1442 VDD VSS sg13g2_decap_8
Xfanout1207 _13157_/A _14917_/Q VDD VSS sg13g2_buf_1
Xfanout220 _10154_/A1 _09590_/A1 VDD VSS sg13g2_buf_1
Xfanout1218 _12963_/A _14873_/Q VDD VSS sg13g2_buf_1
Xfanout231 _09656_/A0 fanout234/X VDD VSS sg13g2_buf_1
Xfanout1229 _10342_/A _14798_/Q VDD VSS sg13g2_buf_1
XFILLER_8_1033 VDD VSS sg13g2_decap_8
Xfanout242 fanout242/X _11247_/X VDD VSS sg13g2_buf_1
Xfanout253 _09720_/A0 _09654_/A0 VDD VSS sg13g2_buf_1
Xfanout264 _10068_/S fanout266/X VDD VSS sg13g2_buf_1
XFILLER_43_1448 VDD VSS sg13g2_decap_8
XFILLER_101_551 VDD VSS sg13g2_fill_2
Xfanout275 _09589_/S _09593_/S VDD VSS sg13g2_buf_1
Xfanout286 _10148_/A1 fanout289/X VDD VSS sg13g2_buf_1
XFILLER_86_262 VDD VSS sg13g2_decap_8
Xfanout297 _09912_/A1 _10144_/A1 VDD VSS sg13g2_buf_1
X_09809_ _14397_/D _10140_/A1 _14397_/Q _09832_/S VDD VSS sg13g2_mux2_1
XFILLER_74_435 VDD VSS sg13g2_fill_1
XFILLER_75_969 VDD VSS sg13g2_fill_2
X_12820_ _12820_/Y _12817_/Y _12818_/Y _12819_/Y VDD VSS sg13g2_a21oi_1
X_14408__1794 _14408_/RESET_B VDD VSS sg13g2_tiehi
XFILLER_41_1194 VDD VSS sg13g2_decap_8
XFILLER_27_351 VDD VSS sg13g2_fill_1
X_12751_ _12764_/A _07737_/A _12779_/A2 _15018_/Q VDD VSS sg13g2_a21oi_1
XFILLER_163_1205 VDD VSS sg13g2_decap_8
XFILLER_128_1325 VDD VSS sg13g2_decap_8
XFILLER_167_1374 VDD VSS sg13g2_decap_8
X_11702_ _14970_/D _11702_/A _11702_/B VDD VSS sg13g2_nor2_1
XFILLER_76_1268 VDD VSS sg13g2_decap_8
XFILLER_70_652 VDD VSS sg13g2_fill_2
X_12682_ _12682_/X _14579_/Q _14611_/Q _14643_/Q _14675_/Q _12711_/S0 _12711_/S1 VDD
+ VSS sg13g2_mux4_1
X_14587__1615 _14587_/RESET_B VDD VSS sg13g2_tiehi
XFILLER_42_376 VDD VSS sg13g2_decap_8
X_14421_ _14421_/Q clkload42/A _14421_/D _14421_/RESET_B VDD VSS sg13g2_dfrbpq_1
XFILLER_42_387 VDD VSS sg13g2_fill_2
X_11633_ _11663_/A _11635_/A _13681_/Q VDD VSS sg13g2_nand2_1
XFILLER_11_741 VDD VSS sg13g2_fill_1
XFILLER_129_927 VDD VSS sg13g2_decap_8
XFILLER_156_713 VDD VSS sg13g2_decap_8
XFILLER_128_415 VDD VSS sg13g2_decap_8
X_14352_ _14352_/Q _14637_/CLK _14352_/D _14352_/RESET_B VDD VSS sg13g2_dfrbpq_1
XFILLER_155_201 VDD VSS sg13g2_decap_8
X_11564_ _11564_/Y _11722_/B2 _11563_/Y _11934_/B VDD VSS sg13g2_o21ai_1
XFILLER_6_200 VDD VSS sg13g2_decap_8
X_13303_ _13306_/B _13303_/A _13308_/B VDD VSS sg13g2_nor2b_1
XFILLER_10_273 VDD VSS sg13g2_decap_8
X_10515_ _10579_/B _10538_/A _10538_/B VDD VSS sg13g2_nor2_1
X_14283_ _14283_/Q _14729_/CLK _14283_/D _14283_/RESET_B VDD VSS sg13g2_dfrbpq_1
X_11495_ _11495_/Y _11495_/A VDD VSS sg13g2_inv_1
XFILLER_7_756 VDD VSS sg13g2_decap_8
XFILLER_171_716 VDD VSS sg13g2_decap_8
XFILLER_104_1391 VDD VSS sg13g2_decap_4
XFILLER_40_60 VDD VSS sg13g2_fill_2
XFILLER_13_1285 VDD VSS sg13g2_decap_8
X_13234_ _13234_/Y _14859_/Q _13234_/B VDD VSS sg13g2_nand2_1
X_10446_ _10514_/A _10459_/B _10459_/C VDD VSS sg13g2_nor2_1
XFILLER_87_1342 VDD VSS sg13g2_decap_8
XFILLER_170_215 VDD VSS sg13g2_fill_1
XFILLER_6_277 VDD VSS sg13g2_decap_8
XFILLER_174_1301 VDD VSS sg13g2_decap_8
XFILLER_108_183 VDD VSS sg13g2_fill_2
XFILLER_170_237 VDD VSS sg13g2_fill_2
X_13165_ _13165_/Y _13162_/Y _13163_/Y _13164_/Y VDD VSS sg13g2_a21oi_1
X_10377_ _10396_/C _14815_/Q _14816_/Q _14817_/Q VDD VSS sg13g2_and3_1
XFILLER_83_1228 VDD VSS sg13g2_decap_8
XFILLER_100_1299 VDD VSS sg13g2_fill_2
XFILLER_152_974 VDD VSS sg13g2_decap_8
XFILLER_124_687 VDD VSS sg13g2_decap_8
XFILLER_152_996 VDD VSS sg13g2_decap_8
XFILLER_123_164 VDD VSS sg13g2_decap_8
XFILLER_174_1378 VDD VSS sg13g2_decap_8
X_12116_ _12116_/Y _12092_/Y _12094_/Y _11717_/A VDD VSS sg13g2_a21oi_1
XFILLER_3_984 VDD VSS sg13g2_decap_8
XFILLER_151_484 VDD VSS sg13g2_fill_1
X_13096_ _13096_/Y _14785_/Q _13164_/A2 _13262_/B1 VDD VSS sg13g2_o21ai_1
XFILLER_34_7 VDD VSS sg13g2_decap_8
XFILLER_151_495 VDD VSS sg13g2_decap_8
XFILLER_111_337 VDD VSS sg13g2_decap_8
XFILLER_2_483 VDD VSS sg13g2_decap_8
XFILLER_46_1061 VDD VSS sg13g2_decap_8
X_12047_ _12047_/Y _12027_/Y _12029_/Y _12142_/S1 VDD VSS sg13g2_a21oi_1
XFILLER_78_752 VDD VSS sg13g2_decap_8
XFILLER_133_1031 VDD VSS sg13g2_decap_8
XFILLER_66_914 VDD VSS sg13g2_decap_8
XFILLER_49_91 VDD VSS sg13g2_decap_8
XFILLER_172_81 VDD VSS sg13g2_decap_8
XFILLER_66_925 VDD VSS sg13g2_fill_1
XFILLER_1_21 VDD VSS sg13g2_decap_8
XFILLER_37_104 VDD VSS sg13g2_decap_8
X_16855_ _16855_/X _16855_/A VDD VSS sg13g2_buf_1
XFILLER_133_1097 VDD VSS sg13g2_decap_8
XFILLER_92_232 VDD VSS sg13g2_decap_8
XFILLER_4_1442 VDD VSS sg13g2_decap_8
XFILLER_98_1460 VDD VSS sg13g2_decap_8
XFILLER_0_1317 VDD VSS sg13g2_decap_8
X_13998_ _13998_/Q clkload58/A _13998_/D _13998_/RESET_B VDD VSS sg13g2_dfrbpq_1
XFILLER_59_1422 VDD VSS sg13g2_decap_8
XFILLER_1_98 VDD VSS sg13g2_decap_8
XFILLER_20_1256 VDD VSS sg13g2_decap_8
XFILLER_34_811 VDD VSS sg13g2_fill_1
XFILLER_80_427 VDD VSS sg13g2_decap_8
X_15108__2768 _15108_/RESET_B VDD VSS sg13g2_tiehi
XFILLER_111_1395 VDD VSS sg13g2_decap_8
X_12949_ _12949_/Y _14776_/Q _13030_/A2 _13030_/B1 VDD VSS sg13g2_o21ai_1
XFILLER_185_1474 VDD VSS sg13g2_fill_1
XFILLER_34_855 VDD VSS sg13g2_fill_2
XFILLER_178_304 VDD VSS sg13g2_decap_8
XFILLER_181_1316 VDD VSS sg13g2_decap_8
XFILLER_45_192 VDD VSS sg13g2_decap_8
XFILLER_34_877 VDD VSS sg13g2_decap_8
XFILLER_61_663 VDD VSS sg13g2_decap_8
XFILLER_60_151 VDD VSS sg13g2_decap_4
XFILLER_178_348 VDD VSS sg13g2_decap_8
X_14619_ _14619_/Q clkload78/A _14619_/D _14619_/RESET_B VDD VSS sg13g2_dfrbpq_1
XFILLER_60_184 VDD VSS sg13g2_fill_1
X_15149__2682 _15149_/RESET_B VDD VSS sg13g2_tiehi
X_08140_ _08140_/Y _08142_/C _08340_/A VDD VSS sg13g2_nand2_1
XFILLER_14_1016 VDD VSS sg13g2_decap_8
XFILLER_140_1024 VDD VSS sg13g2_fill_2
XFILLER_146_212 VDD VSS sg13g2_decap_8
XFILLER_18_1196 VDD VSS sg13g2_decap_8
XFILLER_186_392 VDD VSS sg13g2_decap_8
X_08071_ _08071_/Y _07882_/Y _08432_/A2 _08325_/B VDD VSS sg13g2_o21ai_1
XFILLER_140_1079 VDD VSS sg13g2_decap_4
XFILLER_162_705 VDD VSS sg13g2_decap_8
XFILLER_162_716 VDD VSS sg13g2_fill_2
XFILLER_174_576 VDD VSS sg13g2_decap_4
XFILLER_134_418 VDD VSS sg13g2_decap_8
XFILLER_179_1267 VDD VSS sg13g2_decap_8
XFILLER_31_1363 VDD VSS sg13g2_decap_8
XFILLER_162_749 VDD VSS sg13g2_decap_8
X_13688__2519 _13688_/RESET_B VDD VSS sg13g2_tiehi
XFILLER_103_816 VDD VSS sg13g2_decap_4
XFILLER_143_985 VDD VSS sg13g2_decap_8
XFILLER_153_1407 VDD VSS sg13g2_decap_8
X_14061__2141 _14061_/RESET_B VDD VSS sg13g2_tiehi
XFILLER_66_1459 VDD VSS sg13g2_decap_8
XFILLER_142_473 VDD VSS sg13g2_fill_1
XFILLER_102_315 VDD VSS sg13g2_fill_1
XFILLER_115_698 VDD VSS sg13g2_fill_1
X_08973_ _13756_/D _13756_/Q _10105_/A _09167_/S VDD VSS sg13g2_mux2_1
XFILLER_29_28 VDD VSS sg13g2_decap_8
XFILLER_9_1353 VDD VSS sg13g2_decap_8
XFILLER_152_18 VDD VSS sg13g2_fill_2
X_07924_ _07926_/B _08203_/A _14995_/Q _07924_/C VDD VSS sg13g2_nor3_1
XFILLER_64_1183 VDD VSS sg13g2_decap_8
XFILLER_57_903 VDD VSS sg13g2_fill_2
X_14665__1537 _14665_/RESET_B VDD VSS sg13g2_tiehi
XFILLER_96_560 VDD VSS sg13g2_decap_8
XFILLER_25_1145 VDD VSS sg13g2_decap_8
XFILLER_111_871 VDD VSS sg13g2_fill_1
XFILLER_116_1273 VDD VSS sg13g2_decap_8
XFILLER_60_1036 VDD VSS sg13g2_fill_1
XFILLER_57_925 VDD VSS sg13g2_fill_2
XFILLER_56_402 VDD VSS sg13g2_decap_4
X_15000__2610 _15000_/RESET_B VDD VSS sg13g2_tiehi
XFILLER_5_1239 VDD VSS sg13g2_decap_8
X_07855_ _08641_/B _07855_/A _07855_/B VDD VSS sg13g2_or2_1
XFILLER_110_381 VDD VSS sg13g2_fill_2
XFILLER_110_392 VDD VSS sg13g2_decap_8
XFILLER_151_1197 VDD VSS sg13g2_fill_1
XFILLER_112_1159 VDD VSS sg13g2_decap_8
XFILLER_72_917 VDD VSS sg13g2_decap_8
XFILLER_186_1238 VDD VSS sg13g2_decap_8
X_07786_ _08414_/B _07786_/A _08351_/B VDD VSS sg13g2_and2_1
XFILLER_84_788 VDD VSS sg13g2_decap_8
XFILLER_25_800 VDD VSS sg13g2_decap_8
XFILLER_71_427 VDD VSS sg13g2_decap_4
XFILLER_65_980 VDD VSS sg13g2_decap_4
X_09525_ _14124_/D _10088_/A0 _14124_/Q _09527_/S VDD VSS sg13g2_mux2_1
XFILLER_24_310 VDD VSS sg13g2_fill_2
XFILLER_101_11 VDD VSS sg13g2_decap_8
XFILLER_149_1071 VDD VSS sg13g2_decap_8
X_09456_ _14057_/D _09953_/A1 _14057_/Q _09467_/S VDD VSS sg13g2_mux2_1
X_15033__2577 _15033_/RESET_B VDD VSS sg13g2_tiehi
XFILLER_169_348 VDD VSS sg13g2_fill_2
X_08407_ _08407_/Y _08377_/B _08327_/X _08406_/X VDD VSS sg13g2_a21oi_1
XFILLER_40_836 VDD VSS sg13g2_decap_8
XFILLER_185_808 VDD VSS sg13g2_decap_8
XFILLER_12_549 VDD VSS sg13g2_decap_8
X_09387_ _13990_/D _09686_/A0 _13990_/Q _09401_/S VDD VSS sg13g2_mux2_1
XFILLER_178_871 VDD VSS sg13g2_decap_8
XFILLER_131_6 VDD VSS sg13g2_fill_1
XFILLER_137_201 VDD VSS sg13g2_decap_8
X_08338_ _08338_/Y _08253_/X _08377_/B VDD VSS sg13g2_nand2b_1
XFILLER_36_1285 VDD VSS sg13g2_decap_8
XFILLER_138_735 VDD VSS sg13g2_decap_4
XFILLER_32_1127 VDD VSS sg13g2_decap_8
XFILLER_71_1187 VDD VSS sg13g2_decap_8
XFILLER_137_234 VDD VSS sg13g2_decap_8
X_14271__1931 _14271_/RESET_B VDD VSS sg13g2_tiehi
X_08269_ _15227_/D _08395_/A _08268_/Y _08262_/Y VDD VSS sg13g2_o21ai_1
XFILLER_123_1288 VDD VSS sg13g2_fill_1
XFILLER_10_1414 VDD VSS sg13g2_decap_8
X_10300_ _14793_/D _10311_/A _10311_/B _10295_/B _10297_/B _12812_/A VDD VSS sg13g2_a221oi_1
XFILLER_152_215 VDD VSS sg13g2_decap_8
X_11280_ _11280_/Y _11279_/Y _11278_/Y _11283_/B VDD VSS sg13g2_a21oi_1
XFILLER_118_481 VDD VSS sg13g2_decap_8
XFILLER_134_930 VDD VSS sg13g2_decap_8
XFILLER_3_214 VDD VSS sg13g2_decap_8
X_10231_ _10232_/B _14771_/Q _14772_/Q _10234_/D VDD VSS sg13g2_nand3_1
XFILLER_10_63 VDD VSS sg13g2_decap_8
XFILLER_121_602 VDD VSS sg13g2_decap_4
XFILLER_117_1015 VDD VSS sg13g2_fill_2
X_10162_ _14739_/D _14739_/Q _10162_/A1 _10167_/S VDD VSS sg13g2_mux2_1
XFILLER_0_932 VDD VSS sg13g2_decap_8
XFILLER_105_186 VDD VSS sg13g2_decap_8
Xfanout1004 _11288_/A _15068_/Q VDD VSS sg13g2_buf_1
XFILLER_79_549 VDD VSS sg13g2_decap_8
XFILLER_126_74 VDD VSS sg13g2_fill_1
Xfanout1015 _09806_/B _15063_/Q VDD VSS sg13g2_buf_1
XFILLER_86_23 VDD VSS sg13g2_fill_1
XFILLER_126_96 VDD VSS sg13g2_decap_8
Xfanout1026 fanout1026/X _15059_/Q VDD VSS sg13g2_buf_1
XFILLER_120_145 VDD VSS sg13g2_decap_8
X_14970_ _14970_/Q clkload56/A _14970_/D _14970_/RESET_B VDD VSS sg13g2_dfrbpq_1
Xfanout1037 _10174_/B _13283_/A VDD VSS sg13g2_buf_1
X_10093_ _14673_/D _10160_/A1 _14673_/Q _10101_/S VDD VSS sg13g2_mux2_1
Xfanout1048 _08276_/B _14999_/Q VDD VSS sg13g2_buf_1
XFILLER_134_1362 VDD VSS sg13g2_decap_8
Xfanout1059 _08621_/A _13529_/A VDD VSS sg13g2_buf_1
XFILLER_43_1245 VDD VSS sg13g2_decap_8
XFILLER_75_711 VDD VSS sg13g2_decap_8
X_13921_ _13921_/Q clkload10/A _13921_/D _13921_/RESET_B VDD VSS sg13g2_dfrbpq_1
XFILLER_134_1395 VDD VSS sg13g2_fill_1
XFILLER_19_126 VDD VSS sg13g2_decap_8
XFILLER_47_435 VDD VSS sg13g2_decap_8
XFILLER_142_40 VDD VSS sg13g2_decap_8
X_13852_ _13852_/Q _15052_/CLK _13852_/D _13852_/RESET_B VDD VSS sg13g2_dfrbpq_1
XFILLER_90_714 VDD VSS sg13g2_decap_4
XFILLER_142_95 VDD VSS sg13g2_decap_8
XFILLER_169_1469 VDD VSS sg13g2_decap_4
X_12803_ _12803_/X _13609_/A _12936_/B _12866_/A VDD VSS sg13g2_and3_1
X_13783_ _13783_/Q clkload42/A _13783_/D _13783_/RESET_B VDD VSS sg13g2_dfrbpq_1
X_10995_ _10995_/Y _10995_/A _10995_/B _10995_/C VDD VSS sg13g2_nor3_1
XFILLER_128_1122 VDD VSS sg13g2_decap_8
XFILLER_163_1002 VDD VSS sg13g2_fill_2
XFILLER_167_1171 VDD VSS sg13g2_decap_8
X_12734_ _12734_/X _12733_/X _12732_/X _12790_/S VDD VSS sg13g2_mux2_1
XFILLER_31_803 VDD VSS sg13g2_decap_8
XFILLER_163_1035 VDD VSS sg13g2_fill_2
XFILLER_76_1087 VDD VSS sg13g2_decap_8
XFILLER_43_696 VDD VSS sg13g2_decap_8
XFILLER_128_1177 VDD VSS sg13g2_decap_8
XFILLER_19_1450 VDD VSS sg13g2_decap_8
X_12665_ _12666_/B _13671_/Q _12749_/A2 _12664_/X _12749_/B2 _12749_/C1 VDD VSS sg13g2_a221oi_1
X_14404_ _14404_/Q _14510_/CLK _14404_/D _14404_/RESET_B VDD VSS sg13g2_dfrbpq_1
XFILLER_180_1371 VDD VSS sg13g2_decap_8
X_11616_ _11616_/Y _11617_/A1 _13830_/Q VDD VSS sg13g2_nand2b_1
XFILLER_54_1374 VDD VSS sg13g2_decap_8
XFILLER_106_1453 VDD VSS sg13g2_decap_8
X_12596_ _12597_/B _13676_/Q _12596_/A2 _12595_/X _12415_/A _12596_/C1 VDD VSS sg13g2_a221oi_1
XFILLER_11_571 VDD VSS sg13g2_decap_8
XFILLER_89_1404 VDD VSS sg13g2_decap_8
XFILLER_128_234 VDD VSS sg13g2_decap_8
XFILLER_156_543 VDD VSS sg13g2_decap_8
XFILLER_129_768 VDD VSS sg13g2_fill_1
XFILLER_15_1369 VDD VSS sg13g2_decap_8
X_14335_ _14335_/Q _14495_/CLK _14335_/D _14335_/RESET_B VDD VSS sg13g2_dfrbpq_1
XFILLER_117_919 VDD VSS sg13g2_decap_8
XFILLER_183_340 VDD VSS sg13g2_decap_8
X_11547_ _11547_/Y _11543_/Y _11544_/Y _11546_/Y _11545_/Y _11549_/B VDD VSS sg13g2_a221oi_1
XFILLER_102_1339 VDD VSS sg13g2_decap_8
X_14743__1459 _14743_/RESET_B VDD VSS sg13g2_tiehi
XFILLER_7_553 VDD VSS sg13g2_decap_8
XFILLER_156_576 VDD VSS sg13g2_fill_2
XFILLER_116_429 VDD VSS sg13g2_decap_4
XFILLER_167_81 VDD VSS sg13g2_decap_8
XFILLER_144_749 VDD VSS sg13g2_fill_2
XFILLER_176_1429 VDD VSS sg13g2_decap_8
X_14266_ _14266_/Q _14682_/CLK _14266_/D _14266_/RESET_B VDD VSS sg13g2_dfrbpq_1
XFILLER_13_1082 VDD VSS sg13g2_decap_8
X_11478_ _11478_/Y _11975_/A _11476_/X _11477_/Y VDD VSS sg13g2_o21ai_1
XFILLER_109_492 VDD VSS sg13g2_decap_8
XFILLER_48_1101 VDD VSS sg13g2_decap_8
XFILLER_125_952 VDD VSS sg13g2_fill_1
X_13217_ _13217_/X input23/X _13272_/A2 _13264_/B1 VDD VSS sg13g2_a21o_1
X_10429_ _10434_/C _10647_/A _14832_/Q _14831_/Q _10429_/D VDD VSS sg13g2_and4_1
X_14197_ _14197_/Q clkload42/A _14197_/D _14197_/RESET_B VDD VSS sg13g2_dfrbpq_1
XFILLER_112_602 VDD VSS sg13g2_decap_8
XFILLER_100_1096 VDD VSS sg13g2_decap_8
XFILLER_112_613 VDD VSS sg13g2_fill_2
XFILLER_135_1104 VDD VSS sg13g2_decap_8
XFILLER_139_1273 VDD VSS sg13g2_decap_8
XFILLER_152_782 VDD VSS sg13g2_decap_4
XFILLER_48_1167 VDD VSS sg13g2_decap_8
XFILLER_112_624 VDD VSS sg13g2_fill_2
X_13148_ _13148_/Y _13170_/C _13148_/B VDD VSS sg13g2_xnor2_1
XFILLER_3_781 VDD VSS sg13g2_decap_8
XFILLER_174_1175 VDD VSS sg13g2_decap_8
XFILLER_98_869 VDD VSS sg13g2_decap_4
XFILLER_26_1410 VDD VSS sg13g2_decap_8
XFILLER_170_1028 VDD VSS sg13g2_decap_8
XFILLER_65_1470 VDD VSS sg13g2_fill_2
XFILLER_2_280 VDD VSS sg13g2_decap_8
XFILLER_100_808 VDD VSS sg13g2_decap_8
XFILLER_112_668 VDD VSS sg13g2_fill_1
XFILLER_61_1323 VDD VSS sg13g2_decap_8
XFILLER_100_819 VDD VSS sg13g2_decap_8
X_13079_ _13079_/Y _13077_/X _13092_/A _13079_/C VDD VSS sg13g2_nand3b_1
XFILLER_113_1402 VDD VSS sg13g2_decap_8
XFILLER_78_571 VDD VSS sg13g2_fill_1
XFILLER_152_1473 VDD VSS sg13g2_fill_2
XFILLER_22_1307 VDD VSS sg13g2_decap_8
XFILLER_39_969 VDD VSS sg13g2_decap_8
XFILLER_93_541 VDD VSS sg13g2_fill_1
X_07640_ _10265_/A _14781_/Q VDD VSS sg13g2_inv_1
XFILLER_81_703 VDD VSS sg13g2_decap_4
X_13699__2503 _13699_/RESET_B VDD VSS sg13g2_tiehi
XFILLER_54_939 VDD VSS sg13g2_fill_1
XFILLER_0_1114 VDD VSS sg13g2_decap_8
XFILLER_19_682 VDD VSS sg13g2_decap_8
XFILLER_20_1053 VDD VSS sg13g2_fill_1
XFILLER_94_1132 VDD VSS sg13g2_decap_8
XFILLER_20_1086 VDD VSS sg13g2_decap_8
XFILLER_81_769 VDD VSS sg13g2_decap_8
XFILLER_20_1097 VDD VSS sg13g2_fill_1
X_09310_ _13917_/D _09875_/A0 _13917_/Q _09337_/S VDD VSS sg13g2_mux2_1
XFILLER_185_1271 VDD VSS sg13g2_decap_8
XFILLER_181_1113 VDD VSS sg13g2_decap_8
XFILLER_178_112 VDD VSS sg13g2_decap_8
XFILLER_59_1296 VDD VSS sg13g2_decap_8
XFILLER_34_674 VDD VSS sg13g2_decap_8
XFILLER_90_1018 VDD VSS sg13g2_fill_1
XFILLER_107_1217 VDD VSS sg13g2_decap_8
XFILLER_167_808 VDD VSS sg13g2_decap_8
X_09241_ _09241_/Y _09307_/B _10137_/C VDD VSS sg13g2_nor2_1
XFILLER_107_1228 VDD VSS sg13g2_fill_1
XFILLER_146_1288 VDD VSS sg13g2_decap_8
XFILLER_22_858 VDD VSS sg13g2_fill_1
X_14079__2123 _14079_/RESET_B VDD VSS sg13g2_tiehi
XFILLER_146_1299 VDD VSS sg13g2_fill_2
XFILLER_166_329 VDD VSS sg13g2_decap_8
X_09172_ _13788_/D _13788_/Q _10105_/A _09202_/S VDD VSS sg13g2_mux2_1
XFILLER_21_368 VDD VSS sg13g2_decap_8
XFILLER_33_1436 VDD VSS sg13g2_decap_8
XFILLER_120_1406 VDD VSS sg13g2_fill_2
XFILLER_159_392 VDD VSS sg13g2_decap_8
X_08123_ _08688_/D _08669_/B1 _08048_/Y _08242_/A VDD VSS sg13g2_o21ai_1
XFILLER_30_880 VDD VSS sg13g2_decap_8
XFILLER_107_407 VDD VSS sg13g2_fill_1
X_14719__1483 _14719_/RESET_B VDD VSS sg13g2_tiehi
X_08054_ _08054_/Y _07845_/B _08054_/B VDD VSS sg13g2_nand2b_1
XFILLER_31_1160 VDD VSS sg13g2_decap_8
XFILLER_179_1064 VDD VSS sg13g2_decap_8
XFILLER_116_941 VDD VSS sg13g2_decap_8
XFILLER_134_248 VDD VSS sg13g2_decap_8
XFILLER_1_707 VDD VSS sg13g2_decap_8
X_14827__2909 _14827_/RESET_B VDD VSS sg13g2_tiehi
XFILLER_115_451 VDD VSS sg13g2_decap_8
XFILLER_115_462 VDD VSS sg13g2_fill_1
Xhold3101 input21/A mem_axi_rdata[25] VDD VSS sg13g2_dlygate4sd3_1
Xhold3112 _13616_/A _13724_/Q VDD VSS sg13g2_dlygate4sd3_1
XFILLER_66_1256 VDD VSS sg13g2_decap_8
XFILLER_0_217 VDD VSS sg13g2_decap_8
XFILLER_103_624 VDD VSS sg13g2_decap_8
XFILLER_115_484 VDD VSS sg13g2_fill_1
XFILLER_142_270 VDD VSS sg13g2_decap_8
XFILLER_163_28 VDD VSS sg13g2_decap_8
Xhold3123 _13638_/A _13746_/Q VDD VSS sg13g2_dlygate4sd3_1
XFILLER_27_1229 VDD VSS sg13g2_decap_8
XFILLER_118_1346 VDD VSS sg13g2_decap_8
XFILLER_153_1226 VDD VSS sg13g2_fill_1
Xhold3134 _13646_/A _13754_/Q VDD VSS sg13g2_dlygate4sd3_1
Xhold3145 _11001_/A _14942_/Q VDD VSS sg13g2_dlygate4sd3_1
XFILLER_88_346 VDD VSS sg13g2_decap_8
Xhold3156 _10959_/A _14939_/Q VDD VSS sg13g2_dlygate4sd3_1
XFILLER_103_668 VDD VSS sg13g2_decap_8
XFILLER_131_977 VDD VSS sg13g2_decap_4
Xhold3167 _13527_/A _15142_/Q VDD VSS sg13g2_dlygate4sd3_1
X_08956_ _13722_/D _16884_/A _08955_/X _08956_/S VDD VSS sg13g2_mux2_1
Xhold3178 hold3178/X _14929_/Q VDD VSS sg13g2_dlygate4sd3_1
XFILLER_57_700 VDD VSS sg13g2_fill_1
XFILLER_130_476 VDD VSS sg13g2_fill_1
X_07907_ _07908_/B _15073_/Q _15216_/Q _15215_/Q _07907_/D VDD VSS sg13g2_nor4_1
XFILLER_99_1010 VDD VSS sg13g2_fill_2
XFILLER_69_582 VDD VSS sg13g2_fill_2
XFILLER_5_1036 VDD VSS sg13g2_decap_8
X_08887_ _08887_/Y _11705_/A _08904_/S _08886_/Y VDD VSS sg13g2_a21oi_1
XFILLER_186_7 VDD VSS sg13g2_decap_8
XFILLER_56_243 VDD VSS sg13g2_decap_8
X_07838_ _08684_/A _08697_/B _08698_/A VDD VSS sg13g2_nand2_1
XFILLER_29_468 VDD VSS sg13g2_decap_8
X_14289__1913 _14289_/RESET_B VDD VSS sg13g2_tiehi
XFILLER_84_596 VDD VSS sg13g2_decap_8
XFILLER_186_1057 VDD VSS sg13g2_decap_8
X_07769_ _08318_/A _08265_/A _08265_/B VDD VSS sg13g2_nor2_1
XFILLER_77_1341 VDD VSS sg13g2_decap_8
XFILLER_72_758 VDD VSS sg13g2_decap_8
XFILLER_60_909 VDD VSS sg13g2_fill_1
XFILLER_37_490 VDD VSS sg13g2_decap_8
XFILLER_129_1431 VDD VSS sg13g2_decap_4
X_09508_ _14107_/D _10005_/A0 _14107_/Q _09539_/S VDD VSS sg13g2_mux2_1
XFILLER_72_25 VDD VSS sg13g2_decap_8
XFILLER_38_1314 VDD VSS sg13g2_decap_8
XFILLER_164_1322 VDD VSS sg13g2_decap_8
XFILLER_169_112 VDD VSS sg13g2_decap_8
X_10780_ _14921_/D _11168_/B1 _11164_/B _10779_/Y VDD VSS sg13g2_o21ai_1
XFILLER_71_279 VDD VSS sg13g2_decap_8
XFILLER_73_1227 VDD VSS sg13g2_decap_8
XFILLER_80_791 VDD VSS sg13g2_fill_1
X_09439_ _14041_/D _09969_/A1 _14041_/Q _09440_/S VDD VSS sg13g2_mux2_1
XFILLER_40_633 VDD VSS sg13g2_decap_8
XFILLER_185_616 VDD VSS sg13g2_decap_8
XFILLER_164_1399 VDD VSS sg13g2_decap_8
XFILLER_12_357 VDD VSS sg13g2_decap_8
X_12450_ _12450_/X _13954_/Q _13986_/Q _14018_/Q _14050_/Q _12450_/S0 _12450_/S1 VDD
+ VSS sg13g2_mux4_1
XFILLER_40_699 VDD VSS sg13g2_decap_8
X_11401_ _11401_/Y _11401_/A _11401_/B _11419_/C VDD VSS sg13g2_nand3_1
XFILLER_165_340 VDD VSS sg13g2_decap_8
XFILLER_166_874 VDD VSS sg13g2_decap_8
X_12381_ _12381_/X _14365_/Q _14397_/Q _14461_/Q _14493_/Q _12703_/S0 _12703_/S1 VDD
+ VSS sg13g2_mux4_1
X_14120_ _14120_/Q clkload20/A _14120_/D _14120_/RESET_B VDD VSS sg13g2_dfrbpq_1
XFILLER_10_1211 VDD VSS sg13g2_decap_8
XFILLER_125_215 VDD VSS sg13g2_fill_1
XFILLER_126_738 VDD VSS sg13g2_decap_8
XFILLER_138_598 VDD VSS sg13g2_decap_8
XFILLER_14_1380 VDD VSS sg13g2_decap_8
X_11332_ _11332_/Y _12118_/C _11313_/Y _11331_/Y VDD VSS sg13g2_o21ai_1
X_15072__2884 _15072_/RESET_B VDD VSS sg13g2_tiehi
XFILLER_67_1009 VDD VSS sg13g2_decap_8
XFILLER_108_0 VDD VSS sg13g2_decap_8
XFILLER_21_95 VDD VSS sg13g2_decap_8
X_14051_ _14051_/Q _14723_/CLK _14051_/D _14051_/RESET_B VDD VSS sg13g2_dfrbpq_1
XFILLER_101_1383 VDD VSS sg13g2_decap_8
XFILLER_175_1440 VDD VSS sg13g2_decap_8
X_13777__2425 _13777_/RESET_B VDD VSS sg13g2_tiehi
X_11263_ _11263_/Y _12328_/A1 _13916_/Q _11262_/Y VDD VSS sg13g2_a21oi_1
XFILLER_84_1323 VDD VSS sg13g2_decap_8
XFILLER_49_1443 VDD VSS sg13g2_decap_8
XFILLER_134_760 VDD VSS sg13g2_decap_8
XFILLER_4_567 VDD VSS sg13g2_decap_8
XFILLER_10_1288 VDD VSS sg13g2_decap_8
XFILLER_134_771 VDD VSS sg13g2_fill_1
XFILLER_107_996 VDD VSS sg13g2_fill_2
XFILLER_180_387 VDD VSS sg13g2_decap_8
X_13002_ _13002_/Y _14779_/Q _13030_/A2 _13030_/B1 VDD VSS sg13g2_o21ai_1
XFILLER_122_933 VDD VSS sg13g2_decap_8
XFILLER_180_398 VDD VSS sg13g2_fill_2
X_15087__2840 _15087_/RESET_B VDD VSS sg13g2_tiehi
X_10214_ _10214_/Y _07661_/Y _10213_/X _14764_/Q VDD VSS sg13g2_a21oi_1
XFILLER_171_1315 VDD VSS sg13g2_decap_8
X_11194_ _11194_/Y _11192_/X _11188_/Y _11193_/Y VDD VSS sg13g2_o21ai_1
X_10145_ _14722_/D _14722_/Q _10145_/A1 _10156_/S VDD VSS sg13g2_mux2_1
XFILLER_48_722 VDD VSS sg13g2_decap_8
X_14953_ _14953_/Q clkload68/A _14953_/D _14953_/RESET_B VDD VSS sg13g2_dfrbpq_1
X_10076_ _14656_/D _10110_/A0 _14656_/Q _10092_/S VDD VSS sg13g2_mux2_1
X_14157__2045 _14157_/RESET_B VDD VSS sg13g2_tiehi
X_13992__2210 _13992_/RESET_B VDD VSS sg13g2_tiehi
X_13904_ _13904_/Q _14704_/CLK _13904_/D _13904_/RESET_B VDD VSS sg13g2_dfrbpq_1
XFILLER_75_563 VDD VSS sg13g2_fill_1
XFILLER_63_703 VDD VSS sg13g2_decap_8
X_14884_ _14884_/Q clkload88/A _14884_/D _14884_/RESET_B VDD VSS sg13g2_dfrbpq_1
XFILLER_78_1127 VDD VSS sg13g2_fill_2
XFILLER_21_1351 VDD VSS sg13g2_decap_8
XFILLER_47_276 VDD VSS sg13g2_decap_8
XFILLER_62_213 VDD VSS sg13g2_decap_8
XFILLER_169_1266 VDD VSS sg13g2_decap_8
X_13835_ _13835_/Q clkload12/A _13835_/D _13835_/RESET_B VDD VSS sg13g2_dfrbpq_1
XFILLER_90_533 VDD VSS sg13g2_fill_2
XFILLER_63_747 VDD VSS sg13g2_decap_8
XFILLER_16_630 VDD VSS sg13g2_decap_8
XFILLER_1_1456 VDD VSS sg13g2_decap_8
XFILLER_16_641 VDD VSS sg13g2_fill_2
XFILLER_182_1411 VDD VSS sg13g2_decap_8
XFILLER_15_140 VDD VSS sg13g2_decap_8
X_13766_ _13766_/Q clkload51/A _13766_/D _13766_/RESET_B VDD VSS sg13g2_dfrbpq_1
XFILLER_15_151 VDD VSS sg13g2_fill_1
X_10978_ _10978_/Y _10978_/A _10978_/B VDD VSS sg13g2_nor2_1
XFILLER_90_599 VDD VSS sg13g2_decap_8
XFILLER_71_780 VDD VSS sg13g2_fill_1
XFILLER_31_611 VDD VSS sg13g2_fill_2
XFILLER_56_1458 VDD VSS sg13g2_decap_8
XFILLER_149_808 VDD VSS sg13g2_fill_1
X_12717_ _12717_/X _14261_/Q _14293_/Q _14325_/Q _14357_/Q _12717_/S0 _12717_/S1 VDD
+ VSS sg13g2_mux4_1
XFILLER_149_819 VDD VSS sg13g2_fill_2
X_13697_ _16859_/A clkload62/A _13697_/D _13697_/RESET_B VDD VSS sg13g2_dfrbpq_1
X_12648_ _12648_/X _12645_/X _12644_/X _12641_/X _12640_/X _12649_/S0 _12455_/S VDD
+ VSS sg13g2_mux4_1
XFILLER_54_1171 VDD VSS sg13g2_decap_8
XFILLER_50_1013 VDD VSS sg13g2_fill_1
XFILLER_31_688 VDD VSS sg13g2_decap_8
XFILLER_30_165 VDD VSS sg13g2_decap_8
XFILLER_175_137 VDD VSS sg13g2_decap_8
XFILLER_30_176 VDD VSS sg13g2_fill_1
XFILLER_50_1024 VDD VSS sg13g2_fill_1
XFILLER_178_91 VDD VSS sg13g2_decap_8
XFILLER_15_1166 VDD VSS sg13g2_decap_8
XFILLER_8_851 VDD VSS sg13g2_decap_8
X_14964__2646 _14964_/RESET_B VDD VSS sg13g2_tiehi
X_12579_ _12579_/X _12574_/X _12578_/X _12573_/X _12577_/X _12706_/S _12705_/S0 VDD
+ VSS sg13g2_mux4_1
XFILLER_7_42 VDD VSS sg13g2_decap_8
XFILLER_144_502 VDD VSS sg13g2_decap_8
XFILLER_102_1136 VDD VSS sg13g2_decap_8
XFILLER_117_727 VDD VSS sg13g2_decap_4
XFILLER_172_822 VDD VSS sg13g2_decap_8
XFILLER_7_350 VDD VSS sg13g2_decap_8
X_14318_ _14318_/Q _14510_/CLK _14318_/D _14318_/RESET_B VDD VSS sg13g2_dfrbpq_1
XFILLER_176_1226 VDD VSS sg13g2_decap_8
XFILLER_144_557 VDD VSS sg13g2_fill_2
XFILLER_132_719 VDD VSS sg13g2_fill_1
X_14249_ _14249_/Q clkload28/A _14249_/D _14249_/RESET_B VDD VSS sg13g2_dfrbpq_1
XFILLER_125_771 VDD VSS sg13g2_fill_1
XFILLER_172_899 VDD VSS sg13g2_decap_8
X_14367__1835 _14367_/RESET_B VDD VSS sg13g2_tiehi
XFILLER_125_793 VDD VSS sg13g2_decap_4
XFILLER_63_1407 VDD VSS sg13g2_decap_8
XFILLER_112_421 VDD VSS sg13g2_decap_8
Xfanout808 _12649_/S0 _12427_/S0 VDD VSS sg13g2_buf_1
XFILLER_139_1092 VDD VSS sg13g2_decap_4
Xfanout819 _12789_/S0 _15212_/Q VDD VSS sg13g2_buf_1
X_08810_ _08811_/B _13688_/Q _08810_/B VDD VSS sg13g2_nor2_1
XFILLER_97_143 VDD VSS sg13g2_decap_8
X_09790_ _14379_/D _09889_/A0 _14379_/Q _09799_/S VDD VSS sg13g2_mux2_1
XFILLER_140_796 VDD VSS sg13g2_fill_1
XFILLER_22_1104 VDD VSS sg13g2_decap_4
X_08741_ _13665_/D _08765_/A1 _08739_/Y _08740_/Y VDD VSS sg13g2_a21oi_1
XFILLER_6_1334 VDD VSS sg13g2_decap_8
XFILLER_78_390 VDD VSS sg13g2_decap_8
XFILLER_38_221 VDD VSS sg13g2_decap_8
XFILLER_26_1284 VDD VSS sg13g2_decap_8
X_14582__1620 _14582_/RESET_B VDD VSS sg13g2_tiehi
Xfanout1390 _12330_/S0 _11221_/S0 VDD VSS sg13g2_buf_1
XFILLER_61_1197 VDD VSS sg13g2_decap_8
X_15047__2554 _15047_/RESET_B VDD VSS sg13g2_tiehi
X_08672_ _08672_/X _08692_/A _08673_/B _15019_/Q VDD VSS sg13g2_and3_1
XFILLER_94_872 VDD VSS sg13g2_decap_8
XFILLER_113_1276 VDD VSS sg13g2_decap_8
XFILLER_96_1216 VDD VSS sg13g2_fill_2
XFILLER_81_522 VDD VSS sg13g2_decap_8
X_07623_ _07623_/Y _14854_/Q VDD VSS sg13g2_inv_1
XFILLER_53_257 VDD VSS sg13g2_decap_8
XFILLER_35_972 VDD VSS sg13g2_decap_8
XFILLER_81_599 VDD VSS sg13g2_decap_8
XFILLER_59_1082 VDD VSS sg13g2_decap_4
X_14202__2000 _14202_/RESET_B VDD VSS sg13g2_tiehi
XFILLER_50_931 VDD VSS sg13g2_decap_8
X_13855__2347 _13855_/RESET_B VDD VSS sg13g2_tiehi
XFILLER_42_28 VDD VSS sg13g2_decap_8
XFILLER_107_1047 VDD VSS sg13g2_decap_4
XFILLER_146_1096 VDD VSS sg13g2_decap_8
X_09224_ _13835_/D _09889_/A0 _13835_/Q _09233_/S VDD VSS sg13g2_mux2_1
XFILLER_158_28 VDD VSS sg13g2_decap_8
XFILLER_166_126 VDD VSS sg13g2_decap_8
XFILLER_148_841 VDD VSS sg13g2_decap_8
XFILLER_33_1233 VDD VSS sg13g2_decap_8
XFILLER_72_1293 VDD VSS sg13g2_decap_8
X_09155_ _09155_/Y _09161_/S _15051_/Q _09154_/Y VDD VSS sg13g2_o21ai_1
XFILLER_108_705 VDD VSS sg13g2_fill_2
XFILLER_148_874 VDD VSS sg13g2_decap_4
XFILLER_159_1402 VDD VSS sg13g2_decap_8
XFILLER_108_738 VDD VSS sg13g2_decap_4
X_08106_ _08106_/Y _08432_/A2 _08105_/Y _08325_/B VDD VSS sg13g2_o21ai_1
XFILLER_68_1307 VDD VSS sg13g2_decap_8
XFILLER_107_226 VDD VSS sg13g2_fill_1
X_09086_ _09086_/Y _09107_/B _15041_/Q _09085_/Y VDD VSS sg13g2_o21ai_1
XFILLER_123_708 VDD VSS sg13g2_fill_1
X_08037_ _08039_/C _08037_/A _08037_/B _08522_/C VDD VSS sg13g2_nand3_1
XFILLER_135_579 VDD VSS sg13g2_fill_1
XFILLER_174_49 VDD VSS sg13g2_decap_8
XFILLER_66_1020 VDD VSS sg13g2_fill_2
XFILLER_1_504 VDD VSS sg13g2_decap_8
XFILLER_107_21 VDD VSS sg13g2_decap_8
XFILLER_162_387 VDD VSS sg13g2_decap_4
XFILLER_150_538 VDD VSS sg13g2_decap_8
XFILLER_153_1001 VDD VSS sg13g2_fill_1
XFILLER_118_1132 VDD VSS sg13g2_decap_8
XFILLER_118_1154 VDD VSS sg13g2_fill_1
XFILLER_89_666 VDD VSS sg13g2_decap_8
XFILLER_131_763 VDD VSS sg13g2_decap_8
XFILLER_88_143 VDD VSS sg13g2_fill_1
XFILLER_77_828 VDD VSS sg13g2_decap_8
X_09988_ _14571_/D _10087_/A0 _14571_/Q _09997_/S VDD VSS sg13g2_mux2_1
XFILLER_88_165 VDD VSS sg13g2_fill_1
XFILLER_114_1018 VDD VSS sg13g2_decap_8
XFILLER_44_1340 VDD VSS sg13g2_decap_8
XFILLER_88_187 VDD VSS sg13g2_decap_8
XFILLER_103_498 VDD VSS sg13g2_decap_8
X_08939_ _08939_/X _15049_/Q _14953_/Q _08943_/A VDD VSS sg13g2_mux2_1
XFILLER_130_295 VDD VSS sg13g2_fill_1
XFILLER_76_349 VDD VSS sg13g2_decap_8
XFILLER_18_917 VDD VSS sg13g2_decap_8
XFILLER_91_308 VDD VSS sg13g2_fill_1
X_11950_ _11952_/A _12090_/A _14640_/Q VDD VSS sg13g2_nand2b_1
XFILLER_85_872 VDD VSS sg13g2_fill_2
XFILLER_131_1376 VDD VSS sg13g2_decap_4
XFILLER_72_500 VDD VSS sg13g2_decap_8
X_10901_ _10901_/Y _11045_/A2 _10923_/A _10900_/Y VDD VSS sg13g2_a21oi_1
XFILLER_79_1458 VDD VSS sg13g2_decap_8
XFILLER_83_46 VDD VSS sg13g2_decap_4
X_11881_ _11881_/Y _11877_/Y _11878_/Y _11880_/Y _11879_/Y _11900_/B VDD VSS sg13g2_a221oi_1
X_13620_ _13728_/D _13620_/A VDD VSS sg13g2_buf_1
XFILLER_38_1100 VDD VSS sg13g2_fill_1
XFILLER_26_961 VDD VSS sg13g2_decap_8
X_10832_ _10832_/X _10832_/A _10843_/C VDD VSS sg13g2_and2_1
XFILLER_44_268 VDD VSS sg13g2_decap_8
XFILLER_129_1250 VDD VSS sg13g2_decap_8
XFILLER_25_471 VDD VSS sg13g2_fill_2
XFILLER_186_903 VDD VSS sg13g2_decap_8
X_13551_ _15148_/D _15148_/Q _13550_/Y _13554_/S VDD VSS sg13g2_mux2_1
XFILLER_16_95 VDD VSS sg13g2_decap_8
X_10763_ _11115_/B _14949_/Q _10767_/A _10762_/Y VDD VSS sg13g2_a21oi_1
X_14445__1757 _14445_/RESET_B VDD VSS sg13g2_tiehi
XFILLER_158_627 VDD VSS sg13g2_decap_8
XFILLER_185_413 VDD VSS sg13g2_decap_8
X_12502_ _12502_/X _14374_/Q _14406_/Q _14470_/Q _14502_/Q _12506_/S0 _12506_/S1 VDD
+ VSS sg13g2_mux4_1
XFILLER_38_1188 VDD VSS sg13g2_decap_8
XFILLER_12_154 VDD VSS sg13g2_decap_8
XFILLER_160_1027 VDD VSS sg13g2_decap_8
XFILLER_164_1196 VDD VSS sg13g2_decap_8
X_13482_ _13484_/B _13482_/A _13482_/B _15189_/Q VDD VSS sg13g2_nand3_1
XFILLER_9_637 VDD VSS sg13g2_decap_8
XFILLER_16_1442 VDD VSS sg13g2_decap_8
X_10694_ _10871_/A _14932_/Q _09003_/X _10694_/S VDD VSS sg13g2_mux2_1
XFILLER_139_841 VDD VSS sg13g2_decap_8
XFILLER_51_1333 VDD VSS sg13g2_decap_8
X_15221_ _15221_/Q clkload54/A _15221_/D _15221_/RESET_B VDD VSS sg13g2_dfrbpq_1
XFILLER_90_1393 VDD VSS sg13g2_decap_8
X_12433_ _12433_/X _13825_/Q _13857_/Q _13889_/Q _13921_/Q _12438_/S0 _12438_/S1 VDD
+ VSS sg13g2_mux4_1
XFILLER_12_1306 VDD VSS sg13g2_decap_8
XFILLER_8_158 VDD VSS sg13g2_decap_8
XFILLER_103_1456 VDD VSS sg13g2_decap_8
X_15152_ _15152_/Q _15160_/CLK _15152_/D _15152_/RESET_B VDD VSS sg13g2_dfrbpq_1
X_12364_ _12364_/X _13948_/Q _13980_/Q _14012_/Q _14044_/Q _12725_/S0 _12725_/S1 VDD
+ VSS sg13g2_mux4_1
XFILLER_153_321 VDD VSS sg13g2_fill_2
XFILLER_181_630 VDD VSS sg13g2_decap_8
X_13900__2302 _13900_/RESET_B VDD VSS sg13g2_tiehi
XFILLER_154_866 VDD VSS sg13g2_fill_1
X_14103_ _14103_/Q clkload41/A _14103_/D _14103_/RESET_B VDD VSS sg13g2_dfrbpq_1
X_14660__1542 _14660_/RESET_B VDD VSS sg13g2_tiehi
XFILLER_5_854 VDD VSS sg13g2_decap_8
X_11315_ _11315_/Y _11315_/A1 _14397_/Q _12100_/S1 VDD VSS sg13g2_a21oi_1
XFILLER_126_579 VDD VSS sg13g2_decap_8
XFILLER_180_140 VDD VSS sg13g2_decap_8
X_15083_ _15083_/Q clkload81/A _15083_/D _15083_/RESET_B VDD VSS sg13g2_dfrbpq_1
X_12295_ _12295_/Y _12293_/Y _12294_/Y _12271_/A VDD VSS sg13g2_a21oi_1
XFILLER_107_771 VDD VSS sg13g2_decap_8
XFILLER_4_364 VDD VSS sg13g2_decap_8
XFILLER_49_1240 VDD VSS sg13g2_decap_8
XFILLER_10_1085 VDD VSS sg13g2_decap_8
X_14034_ _14034_/Q _14546_/CLK _14034_/D _14034_/RESET_B VDD VSS sg13g2_dfrbpq_1
X_11246_ _11246_/Y _11243_/B _07690_/X _11245_/Y VDD VSS sg13g2_a21oi_1
XFILLER_79_121 VDD VSS sg13g2_decap_8
XFILLER_68_817 VDD VSS sg13g2_decap_8
XFILLER_95_603 VDD VSS sg13g2_decap_8
X_11177_ _11177_/X _11197_/A _11177_/B _11177_/C VDD VSS sg13g2_or3_1
XFILLER_23_1402 VDD VSS sg13g2_decap_8
XFILLER_94_113 VDD VSS sg13g2_decap_8
XFILLER_0_581 VDD VSS sg13g2_decap_8
XFILLER_171_1189 VDD VSS sg13g2_decap_8
X_13933__2269 _13933_/RESET_B VDD VSS sg13g2_tiehi
X_10128_ _14706_/D _10161_/A1 _14706_/Q _10134_/S VDD VSS sg13g2_mux2_1
XFILLER_95_647 VDD VSS sg13g2_decap_4
XFILLER_79_198 VDD VSS sg13g2_decap_8
XFILLER_76_850 VDD VSS sg13g2_fill_1
XFILLER_76_861 VDD VSS sg13g2_fill_2
X_14936_ _14936_/Q clkload59/A _14936_/D _14936_/RESET_B VDD VSS sg13g2_dfrbpq_1
X_10059_ _14640_/D _10159_/A1 _14640_/Q _10059_/S VDD VSS sg13g2_mux2_1
XFILLER_57_91 VDD VSS sg13g2_decap_8
XFILLER_180_70 VDD VSS sg13g2_decap_8
XFILLER_36_725 VDD VSS sg13g2_decap_8
XFILLER_75_393 VDD VSS sg13g2_decap_8
XFILLER_169_1063 VDD VSS sg13g2_fill_1
X_14867_ _14867_/Q clkload84/A _14867_/D _14867_/RESET_B VDD VSS sg13g2_dfrbpq_1
XFILLER_63_544 VDD VSS sg13g2_fill_2
XFILLER_36_769 VDD VSS sg13g2_decap_8
XFILLER_91_864 VDD VSS sg13g2_fill_2
XFILLER_17_961 VDD VSS sg13g2_decap_8
XFILLER_1_1253 VDD VSS sg13g2_decap_8
XFILLER_91_875 VDD VSS sg13g2_decap_8
XFILLER_90_352 VDD VSS sg13g2_fill_2
X_13818_ _13818_/Q clkload76/A _13818_/D _13818_/RESET_B VDD VSS sg13g2_dfrbpq_1
XFILLER_91_886 VDD VSS sg13g2_fill_1
XFILLER_91_897 VDD VSS sg13g2_fill_2
X_14798_ _14798_/Q _15185_/CLK _14798_/D _14798_/RESET_B VDD VSS sg13g2_dfrbpq_1
XFILLER_51_739 VDD VSS sg13g2_decap_4
XFILLER_50_216 VDD VSS sg13g2_decap_8
XFILLER_147_1372 VDD VSS sg13g2_decap_8
X_13749_ _13749_/Q _14677_/CLK _13749_/D _13749_/RESET_B VDD VSS sg13g2_dfrbpq_1
XFILLER_56_1255 VDD VSS sg13g2_decap_8
XFILLER_108_1334 VDD VSS sg13g2_fill_1
XFILLER_17_1217 VDD VSS sg13g2_decap_8
XFILLER_31_430 VDD VSS sg13g2_decap_8
XFILLER_182_1285 VDD VSS sg13g2_decap_8
XFILLER_176_424 VDD VSS sg13g2_decap_8
XFILLER_108_1367 VDD VSS sg13g2_decap_8
XFILLER_108_1378 VDD VSS sg13g2_fill_2
XFILLER_164_619 VDD VSS sg13g2_decap_8
XFILLER_106_1080 VDD VSS sg13g2_decap_8
XFILLER_129_362 VDD VSS sg13g2_decap_8
X_14867__2833 _14867_/RESET_B VDD VSS sg13g2_tiehi
XFILLER_144_310 VDD VSS sg13g2_decap_8
XFILLER_89_1075 VDD VSS sg13g2_decap_8
XFILLER_105_708 VDD VSS sg13g2_decap_8
XFILLER_171_140 VDD VSS sg13g2_decap_8
XFILLER_176_1045 VDD VSS sg13g2_decap_8
X_09911_ _14496_/D _14496_/Q _09911_/A1 _09927_/S VDD VSS sg13g2_mux2_1
XFILLER_99_931 VDD VSS sg13g2_decap_4
XFILLER_119_1430 VDD VSS sg13g2_decap_8
XFILLER_154_1310 VDD VSS sg13g2_decap_8
XFILLER_171_184 VDD VSS sg13g2_decap_8
XFILLER_63_1204 VDD VSS sg13g2_decap_8
Xfanout605 _11102_/B _13294_/B VDD VSS sg13g2_buf_1
Xfanout616 _10752_/A fanout622/X VDD VSS sg13g2_buf_1
XFILLER_8_1418 VDD VSS sg13g2_decap_8
XFILLER_67_1395 VDD VSS sg13g2_decap_8
XFILLER_101_903 VDD VSS sg13g2_fill_1
XFILLER_115_1305 VDD VSS sg13g2_decap_4
Xclkbuf_4_11_0_clk_i clkbuf_4_11_0_clk_i/X clkbuf_0_clk_i/X VDD VSS sg13g2_buf_8
Xfanout627 _08852_/A _10694_/S VDD VSS sg13g2_buf_1
X_09842_ _14429_/D _14429_/Q _10040_/A0 _09870_/S VDD VSS sg13g2_mux2_1
XFILLER_28_1357 VDD VSS sg13g2_decap_8
Xfanout638 _08922_/S _08831_/Y VDD VSS sg13g2_buf_1
Xfanout649 _08325_/B _08654_/B VDD VSS sg13g2_buf_1
XFILLER_98_474 VDD VSS sg13g2_decap_8
XFILLER_140_582 VDD VSS sg13g2_fill_2
XFILLER_154_1387 VDD VSS sg13g2_decap_8
XFILLER_58_338 VDD VSS sg13g2_fill_1
X_09773_ _09773_/Y _09905_/A _10105_/C _10037_/A _10105_/B VDD VSS sg13g2_nand4_1
XFILLER_6_1131 VDD VSS sg13g2_decap_8
X_14523__1679 _14523_/RESET_B VDD VSS sg13g2_tiehi
XFILLER_37_28 VDD VSS sg13g2_decap_8
XFILLER_26_1081 VDD VSS sg13g2_decap_8
X_13909__2293 _13909_/RESET_B VDD VSS sg13g2_tiehi
Xclkbuf_leaf_50_clk_i clkload69/A clkbuf_leaf_52_clk_i/A VDD VSS sg13g2_buf_8
XFILLER_67_861 VDD VSS sg13g2_decap_8
X_08724_ _08724_/Y _08723_/A _10647_/D VDD VSS sg13g2_nand2b_1
XFILLER_160_18 VDD VSS sg13g2_decap_8
X_14777__2959 _14777_/RESET_B VDD VSS sg13g2_tiehi
X_08655_ _08655_/Y _08054_/B _08653_/B _08054_/Y VDD VSS sg13g2_o21ai_1
XFILLER_26_235 VDD VSS sg13g2_decap_8
XFILLER_148_1136 VDD VSS sg13g2_fill_2
XFILLER_14_408 VDD VSS sg13g2_decap_8
XFILLER_81_352 VDD VSS sg13g2_fill_2
XFILLER_42_728 VDD VSS sg13g2_decap_8
XFILLER_39_1420 VDD VSS sg13g2_decap_8
X_08586_ _08588_/C _08641_/C _08586_/B _08586_/C VDD VSS sg13g2_nand3_1
Xclkbuf_leaf_65_clk_i _15165_/CLK clkbuf_leaf_78_clk_i/A VDD VSS sg13g2_buf_8
XFILLER_161_1303 VDD VSS sg13g2_decap_8
XFILLER_126_1434 VDD VSS sg13g2_decap_8
XFILLER_169_49 VDD VSS sg13g2_decap_8
XFILLER_74_1366 VDD VSS sg13g2_decap_8
XFILLER_35_1317 VDD VSS sg13g2_decap_8
XFILLER_167_435 VDD VSS sg13g2_decap_8
X_09207_ _13819_/D _10138_/A1 _13819_/Q _09239_/S VDD VSS sg13g2_mux2_1
XFILLER_10_658 VDD VSS sg13g2_decap_8
XFILLER_136_800 VDD VSS sg13g2_decap_8
XFILLER_120_1011 VDD VSS sg13g2_fill_2
XFILLER_182_427 VDD VSS sg13g2_decap_8
XFILLER_148_693 VDD VSS sg13g2_decap_8
X_09138_ _09138_/X _09137_/A _10776_/A _09137_/Y VDD VSS sg13g2_a21o_1
XFILLER_33_1096 VDD VSS sg13g2_decap_8
XFILLER_108_546 VDD VSS sg13g2_decap_8
XFILLER_147_181 VDD VSS sg13g2_fill_2
XFILLER_147_192 VDD VSS sg13g2_fill_2
XFILLER_118_31 VDD VSS sg13g2_decap_8
XFILLER_118_42 VDD VSS sg13g2_fill_2
XFILLER_135_354 VDD VSS sg13g2_decap_8
XFILLER_123_505 VDD VSS sg13g2_decap_8
XFILLER_136_888 VDD VSS sg13g2_decap_8
X_09069_ _09069_/X _09069_/A _09069_/B _09103_/C VDD VSS sg13g2_or3_1
XFILLER_159_1276 VDD VSS sg13g2_decap_8
XFILLER_1_301 VDD VSS sg13g2_decap_8
X_11100_ _11100_/Y _11109_/B _10759_/X _11154_/B1 VDD VSS sg13g2_o21ai_1
XFILLER_11_1394 VDD VSS sg13g2_decap_8
XFILLER_78_35 VDD VSS sg13g2_decap_8
XFILLER_104_730 VDD VSS sg13g2_decap_4
XFILLER_172_1410 VDD VSS sg13g2_decap_8
X_12080_ _12080_/Y _12079_/Y _12078_/Y _12065_/Y _12156_/A _12126_/A VDD VSS sg13g2_a221oi_1
XFILLER_46_1435 VDD VSS sg13g2_decap_8
XFILLER_2_868 VDD VSS sg13g2_decap_8
X_11031_ _14943_/D _11029_/Y _11030_/Y _11021_/X VDD VSS sg13g2_a21o_1
XFILLER_103_262 VDD VSS sg13g2_fill_1
XFILLER_1_378 VDD VSS sg13g2_decap_8
XFILLER_49_316 VDD VSS sg13g2_fill_2
XFILLER_49_327 VDD VSS sg13g2_fill_1
XFILLER_131_593 VDD VSS sg13g2_decap_8
XFILLER_103_295 VDD VSS sg13g2_decap_8
XFILLER_76_135 VDD VSS sg13g2_fill_2
Xclkbuf_leaf_18_clk_i clkload54/A clkbuf_leaf_18_clk_i/A VDD VSS sg13g2_buf_8
XFILLER_58_850 VDD VSS sg13g2_decap_8
XFILLER_40_1001 VDD VSS sg13g2_decap_8
XFILLER_92_606 VDD VSS sg13g2_decap_8
X_12982_ _12982_/Y _12980_/Y _12981_/Y _12933_/Y VDD VSS sg13g2_o21ai_1
XFILLER_79_1211 VDD VSS sg13g2_decap_8
XFILLER_94_67 VDD VSS sg13g2_fill_1
XFILLER_45_511 VDD VSS sg13g2_decap_8
XFILLER_100_991 VDD VSS sg13g2_decap_4
X_14721_ _14721_/Q clkload10/A _14721_/D _14721_/RESET_B VDD VSS sg13g2_dfrbpq_1
XFILLER_94_89 VDD VSS sg13g2_decap_8
X_11933_ _14977_/D _11914_/A _12126_/A _11932_/Y VDD VSS sg13g2_a21o_1
XFILLER_40_1089 VDD VSS sg13g2_decap_8
XFILLER_27_61 VDD VSS sg13g2_decap_8
XFILLER_72_341 VDD VSS sg13g2_decap_8
XFILLER_17_257 VDD VSS sg13g2_fill_1
XFILLER_79_1288 VDD VSS sg13g2_decap_8
X_14652_ _14652_/Q _14682_/CLK _14652_/D _14652_/RESET_B VDD VSS sg13g2_dfrbpq_1
XFILLER_73_886 VDD VSS sg13g2_decap_8
X_11864_ _11864_/Y _11865_/A _13674_/Q VDD VSS sg13g2_nor2_1
X_14678__1524 _14678_/RESET_B VDD VSS sg13g2_tiehi
XFILLER_45_599 VDD VSS sg13g2_fill_1
XFILLER_166_1269 VDD VSS sg13g2_decap_8
X_13603_ _13603_/Y _13602_/Y _13600_/Y _08830_/X VDD VSS sg13g2_o21ai_1
X_10815_ _10815_/Y _11043_/A _10814_/Y _10886_/A2 VDD VSS sg13g2_a21oi_1
XFILLER_92_1444 VDD VSS sg13g2_decap_8
XFILLER_186_700 VDD VSS sg13g2_decap_8
X_14583_ _14583_/Q clkload41/A _14583_/D _14583_/RESET_B VDD VSS sg13g2_dfrbpq_1
X_11795_ _14973_/D _11770_/A _11978_/B1 _11794_/Y VDD VSS sg13g2_a21o_1
XFILLER_13_452 VDD VSS sg13g2_decap_4
XFILLER_185_210 VDD VSS sg13g2_decap_8
X_13534_ _13534_/Y _13533_/A _13566_/C _08351_/B _13546_/B2 VDD VSS sg13g2_a22oi_1
X_10746_ _14914_/D _13279_/D _11078_/A _10745_/Y VDD VSS sg13g2_o21ai_1
XFILLER_140_1409 VDD VSS sg13g2_decap_8
XFILLER_43_82 VDD VSS sg13g2_decap_8
X_14822__2914 _14822_/RESET_B VDD VSS sg13g2_tiehi
XFILLER_9_434 VDD VSS sg13g2_decap_8
XFILLER_146_608 VDD VSS sg13g2_decap_4
XFILLER_186_777 VDD VSS sg13g2_decap_8
XFILLER_127_800 VDD VSS sg13g2_decap_8
XFILLER_173_405 VDD VSS sg13g2_fill_1
X_13465_ _13465_/Y _08723_/A _08723_/B _13249_/B VDD VSS sg13g2_o21ai_1
XFILLER_12_1103 VDD VSS sg13g2_decap_8
X_10677_ _10844_/A _08977_/B _10669_/S _10805_/B VDD VSS sg13g2_a21o_1
XFILLER_185_287 VDD VSS sg13g2_decap_8
X_15204_ _15204_/Q clkload73/A _15204_/D _15204_/RESET_B VDD VSS sg13g2_dfrbpq_1
X_12416_ _12416_/Y _12347_/B _12348_/A _12596_/A2 _13689_/Q _12596_/C1 VDD VSS sg13g2_a221oi_1
XFILLER_103_1253 VDD VSS sg13g2_decap_8
XFILLER_177_1310 VDD VSS sg13g2_decap_8
X_13396_ _13396_/Y _13401_/C _13401_/B _13438_/B _13396_/D VDD VSS sg13g2_nor4_1
XFILLER_86_1204 VDD VSS sg13g2_decap_8
XFILLER_64_7 VDD VSS sg13g2_decap_8
XFILLER_103_1286 VDD VSS sg13g2_decap_8
X_15135_ _15135_/Q clkload32/A _15135_/D _15135_/RESET_B VDD VSS sg13g2_dfrbpq_1
X_12347_ _12348_/D _15122_/Q _12347_/B _15119_/Q _12347_/D VDD VSS sg13g2_nor4_1
XFILLER_5_651 VDD VSS sg13g2_decap_8
XFILLER_127_899 VDD VSS sg13g2_decap_4
XFILLER_138_1316 VDD VSS sg13g2_decap_8
XFILLER_182_983 VDD VSS sg13g2_decap_8
XFILLER_126_376 VDD VSS sg13g2_decap_8
XFILLER_138_1327 VDD VSS sg13g2_fill_1
XFILLER_126_398 VDD VSS sg13g2_fill_1
XFILLER_173_1218 VDD VSS sg13g2_decap_8
XFILLER_175_81 VDD VSS sg13g2_decap_8
XFILLER_177_1387 VDD VSS sg13g2_decap_8
XFILLER_4_161 VDD VSS sg13g2_decap_8
X_15066_ _15066_/Q _15165_/CLK _15066_/D _15066_/RESET_B VDD VSS sg13g2_dfrbpq_1
XFILLER_99_238 VDD VSS sg13g2_decap_8
XFILLER_4_21 VDD VSS sg13g2_decap_8
XFILLER_107_590 VDD VSS sg13g2_decap_8
X_12278_ _12279_/B _12278_/A _13663_/Q VDD VSS sg13g2_or2_1
XFILLER_141_346 VDD VSS sg13g2_decap_8
X_14017_ _14017_/Q clkload6/A _14017_/D _14017_/RESET_B VDD VSS sg13g2_dfrbpq_1
XFILLER_136_1040 VDD VSS sg13g2_fill_1
X_11229_ _11229_/X _13819_/Q _13851_/Q _13883_/Q _13915_/Q _12328_/A1 _12326_/B1 VDD
+ VSS sg13g2_mux4_1
XFILLER_95_400 VDD VSS sg13g2_decap_8
XFILLER_122_582 VDD VSS sg13g2_decap_8
XFILLER_4_98 VDD VSS sg13g2_decap_8
XFILLER_67_146 VDD VSS sg13g2_decap_8
XFILLER_56_809 VDD VSS sg13g2_decap_8
XFILLER_27_1390 VDD VSS sg13g2_decap_8
XFILLER_49_861 VDD VSS sg13g2_decap_8
XFILLER_62_1292 VDD VSS sg13g2_decap_8
XFILLER_110_788 VDD VSS sg13g2_decap_8
XFILLER_83_639 VDD VSS sg13g2_decap_8
XFILLER_49_894 VDD VSS sg13g2_decap_8
XFILLER_23_1276 VDD VSS sg13g2_decap_8
XFILLER_3_1348 VDD VSS sg13g2_decap_8
XFILLER_110_1246 VDD VSS sg13g2_fill_1
X_14919_ _14919_/Q clkload71/A _14919_/D _14919_/RESET_B VDD VSS sg13g2_dfrbpq_1
XFILLER_149_1423 VDD VSS sg13g2_decap_8
XFILLER_184_1303 VDD VSS sg13g2_decap_8
XFILLER_97_1377 VDD VSS sg13g2_decap_8
XFILLER_1_1050 VDD VSS sg13g2_decap_8
X_08440_ _08441_/B _08574_/A _08438_/Y _08439_/Y VDD VSS sg13g2_o21ai_1
XFILLER_93_1219 VDD VSS sg13g2_decap_8
XFILLER_97_1399 VDD VSS sg13g2_decap_4
XFILLER_91_683 VDD VSS sg13g2_decap_8
XFILLER_17_791 VDD VSS sg13g2_decap_4
XFILLER_51_547 VDD VSS sg13g2_decap_8
X_08371_ _08371_/Y _07795_/A _08370_/Y _08499_/B1 VDD VSS sg13g2_o21ai_1
XFILLER_90_0 VDD VSS sg13g2_fill_2
XFILLER_143_1022 VDD VSS sg13g2_decap_8
XFILLER_177_733 VDD VSS sg13g2_decap_8
XFILLER_17_1025 VDD VSS sg13g2_decap_8
XFILLER_108_1153 VDD VSS sg13g2_decap_8
XFILLER_182_1082 VDD VSS sg13g2_decap_8
XFILLER_104_1006 VDD VSS sg13g2_decap_8
XFILLER_17_1058 VDD VSS sg13g2_fill_2
X_13772__2430 _13772_/RESET_B VDD VSS sg13g2_tiehi
XFILLER_149_457 VDD VSS sg13g2_decap_8
XFILLER_143_1077 VDD VSS sg13g2_fill_1
XFILLER_165_928 VDD VSS sg13g2_decap_8
XFILLER_177_788 VDD VSS sg13g2_decap_8
XFILLER_136_107 VDD VSS sg13g2_decap_8
X_15074__2876 _15074_/RESET_B VDD VSS sg13g2_tiehi
XFILLER_34_1383 VDD VSS sg13g2_decap_8
XFILLER_117_310 VDD VSS sg13g2_decap_8
XFILLER_121_1342 VDD VSS sg13g2_decap_8
XFILLER_69_1402 VDD VSS sg13g2_decap_8
XFILLER_117_321 VDD VSS sg13g2_fill_1
XFILLER_118_855 VDD VSS sg13g2_decap_8
XFILLER_173_950 VDD VSS sg13g2_decap_4
XFILLER_30_1258 VDD VSS sg13g2_decap_8
XFILLER_155_18 VDD VSS sg13g2_decap_8
XFILLER_118_899 VDD VSS sg13g2_fill_1
X_15089__2832 _15089_/RESET_B VDD VSS sg13g2_tiehi
XFILLER_117_387 VDD VSS sg13g2_decap_8
XFILLER_156_1427 VDD VSS sg13g2_decap_8
X_14152__2050 _14152_/RESET_B VDD VSS sg13g2_tiehi
XFILLER_144_184 VDD VSS sg13g2_decap_8
XFILLER_160_644 VDD VSS sg13g2_decap_8
Xfanout402 _09743_/A1 _09875_/A0 VDD VSS sg13g2_buf_1
XFILLER_63_1012 VDD VSS sg13g2_fill_1
XFILLER_160_677 VDD VSS sg13g2_decap_8
Xfanout413 _12386_/A _12777_/B2 VDD VSS sg13g2_buf_1
XFILLER_67_1192 VDD VSS sg13g2_decap_8
XFILLER_63_1023 VDD VSS sg13g2_decap_8
XFILLER_8_1215 VDD VSS sg13g2_decap_8
Xfanout424 _10124_/S _10103_/Y VDD VSS sg13g2_buf_1
XFILLER_28_1154 VDD VSS sg13g2_decap_8
XFILLER_154_1162 VDD VSS sg13g2_decap_8
Xfanout435 _09991_/S fanout438/X VDD VSS sg13g2_buf_1
XFILLER_98_271 VDD VSS sg13g2_fill_1
XFILLER_87_934 VDD VSS sg13g2_fill_2
XFILLER_101_722 VDD VSS sg13g2_decap_8
Xfanout446 _09799_/S _09789_/S VDD VSS sg13g2_buf_1
XFILLER_98_282 VDD VSS sg13g2_decap_4
XFILLER_59_636 VDD VSS sg13g2_decap_8
Xfanout457 _09562_/S _09556_/S VDD VSS sg13g2_buf_1
X_09825_ _14413_/D _09891_/A0 _14413_/Q _09828_/S VDD VSS sg13g2_mux2_1
XFILLER_48_49 VDD VSS sg13g2_decap_8
XFILLER_171_28 VDD VSS sg13g2_decap_8
Xfanout468 _09527_/S _09507_/Y VDD VSS sg13g2_buf_1
XFILLER_101_755 VDD VSS sg13g2_fill_1
XFILLER_150_1037 VDD VSS sg13g2_fill_1
Xfanout479 _09407_/S fanout480/X VDD VSS sg13g2_buf_1
XFILLER_80_1370 VDD VSS sg13g2_decap_8
X_09756_ _14346_/D _14346_/Q _09921_/A1 _09762_/S VDD VSS sg13g2_mux2_1
XFILLER_86_488 VDD VSS sg13g2_fill_1
XFILLER_101_799 VDD VSS sg13g2_decap_8
XFILLER_67_691 VDD VSS sg13g2_fill_1
X_08707_ _15186_/D hold3081/X _15186_/Q _13340_/S VDD VSS sg13g2_mux2_1
XFILLER_41_1376 VDD VSS sg13g2_decap_8
XFILLER_104_77 VDD VSS sg13g2_decap_8
X_09687_ _14279_/D _09720_/A0 _14279_/Q _09696_/S VDD VSS sg13g2_mux2_1
XFILLER_66_190 VDD VSS sg13g2_decap_4
XFILLER_82_650 VDD VSS sg13g2_fill_2
XFILLER_55_875 VDD VSS sg13g2_decap_8
XFILLER_27_566 VDD VSS sg13g2_fill_1
XFILLER_15_728 VDD VSS sg13g2_decap_8
X_08638_ _08640_/A _07844_/X _08692_/A _08544_/B _08330_/Y VDD VSS sg13g2_a22oi_1
XFILLER_82_672 VDD VSS sg13g2_decap_8
XFILLER_81_171 VDD VSS sg13g2_decap_8
XFILLER_14_238 VDD VSS sg13g2_fill_1
XFILLER_14_249 VDD VSS sg13g2_decap_8
X_08569_ _08569_/Y _07808_/Y _08568_/Y _08567_/X VDD VSS sg13g2_o21ai_1
XFILLER_80_14 VDD VSS sg13g2_decap_8
XFILLER_74_1163 VDD VSS sg13g2_decap_8
XFILLER_165_1280 VDD VSS sg13g2_decap_8
X_10600_ _10602_/B _10607_/C _10607_/D _14877_/Q VDD VSS sg13g2_a21oi_1
XFILLER_39_1294 VDD VSS sg13g2_decap_8
X_11580_ _11580_/X _14245_/Q _14277_/Q _14309_/Q _14341_/Q _11580_/S0 _11580_/S1 VDD
+ VSS sg13g2_mux4_1
XFILLER_167_232 VDD VSS sg13g2_decap_8
XFILLER_168_755 VDD VSS sg13g2_decap_8
X_14362__1840 _14362_/RESET_B VDD VSS sg13g2_tiehi
XFILLER_126_1286 VDD VSS sg13g2_fill_1
X_10531_ _10533_/B _14859_/Q _14858_/Q _10564_/D _10531_/D VDD VSS sg13g2_nand4_1
XFILLER_11_967 VDD VSS sg13g2_decap_8
XFILLER_161_1177 VDD VSS sg13g2_decap_8
XFILLER_183_714 VDD VSS sg13g2_decap_8
XFILLER_109_811 VDD VSS sg13g2_decap_8
XFILLER_10_455 VDD VSS sg13g2_decap_8
XFILLER_155_416 VDD VSS sg13g2_decap_4
XFILLER_7_938 VDD VSS sg13g2_decap_8
XFILLER_13_74 VDD VSS sg13g2_decap_8
X_13250_ _13251_/C _14828_/Q _13206_/B _13273_/B _14860_/Q VDD VSS sg13g2_a22oi_1
XFILLER_182_235 VDD VSS sg13g2_decap_8
X_10462_ _10473_/D _10471_/C _14842_/Q _14841_/Q _10462_/D VDD VSS sg13g2_and4_1
XFILLER_109_855 VDD VSS sg13g2_decap_8
XFILLER_13_1467 VDD VSS sg13g2_decap_8
X_12201_ _12204_/A _12060_/Y _12197_/Y _12200_/X VDD VSS sg13g2_a21oi_1
XFILLER_6_459 VDD VSS sg13g2_decap_8
XFILLER_170_408 VDD VSS sg13g2_fill_1
XFILLER_129_96 VDD VSS sg13g2_decap_4
X_13181_ _13181_/Y _14791_/Q _13275_/A2 _13262_/B1 VDD VSS sg13g2_o21ai_1
X_10393_ _10401_/C _14822_/Q _10392_/A VDD VSS sg13g2_nor2b_1
XFILLER_123_302 VDD VSS sg13g2_decap_4
XFILLER_135_162 VDD VSS sg13g2_decap_8
XFILLER_123_324 VDD VSS sg13g2_decap_8
XFILLER_124_847 VDD VSS sg13g2_decap_8
X_12132_ _12132_/Y _12198_/B _12132_/B VDD VSS sg13g2_xnor2_1
XFILLER_11_1191 VDD VSS sg13g2_decap_8
XFILLER_124_858 VDD VSS sg13g2_fill_1
XFILLER_97_709 VDD VSS sg13g2_fill_2
XFILLER_151_666 VDD VSS sg13g2_decap_4
XFILLER_85_1281 VDD VSS sg13g2_decap_8
XFILLER_46_1232 VDD VSS sg13g2_decap_8
XFILLER_2_665 VDD VSS sg13g2_decap_8
XFILLER_150_165 VDD VSS sg13g2_fill_2
X_12063_ _12063_/Y _12062_/A _12062_/B _12197_/A VDD VSS sg13g2_a21oi_1
XFILLER_77_400 VDD VSS sg13g2_fill_2
XFILLER_132_891 VDD VSS sg13g2_decap_8
XFILLER_1_175 VDD VSS sg13g2_decap_8
X_14851__2865 _14851_/RESET_B VDD VSS sg13g2_tiehi
X_11014_ _11014_/Y _11014_/A _11014_/B VDD VSS sg13g2_nor2_1
XFILLER_42_1107 VDD VSS sg13g2_decap_8
XFILLER_172_1284 VDD VSS sg13g2_decap_8
XFILLER_133_1246 VDD VSS sg13g2_fill_1
X_16871_ _16871_/X _16871_/A VDD VSS sg13g2_buf_1
Xfanout980 _13206_/B _13068_/B VDD VSS sg13g2_buf_1
Xfanout991 _11017_/A1 _07649_/A VDD VSS sg13g2_buf_1
XFILLER_38_60 VDD VSS sg13g2_decap_8
XFILLER_49_179 VDD VSS sg13g2_decap_8
X_13850__2352 _13850_/RESET_B VDD VSS sg13g2_tiehi
X_14015__2187 _14015_/RESET_B VDD VSS sg13g2_tiehi
XFILLER_93_948 VDD VSS sg13g2_decap_8
XFILLER_65_639 VDD VSS sg13g2_decap_8
XFILLER_46_820 VDD VSS sg13g2_decap_8
XFILLER_20_1438 VDD VSS sg13g2_decap_8
X_12965_ _12965_/Y _14777_/Q _13030_/A2 _13030_/B1 VDD VSS sg13g2_o21ai_1
XFILLER_18_555 VDD VSS sg13g2_decap_8
X_14884__2799 _14884_/RESET_B VDD VSS sg13g2_tiehi
XFILLER_61_801 VDD VSS sg13g2_decap_8
X_14704_ _14704_/Q _14704_/CLK _14704_/D _14704_/RESET_B VDD VSS sg13g2_dfrbpq_1
X_11916_ _11916_/Y _12055_/A _11917_/A VDD VSS sg13g2_nor2_1
XFILLER_60_300 VDD VSS sg13g2_fill_2
X_12896_ _12896_/Y _14805_/Q _13029_/A2 _12879_/B _14837_/Q _13069_/C1 VDD VSS sg13g2_a221oi_1
XFILLER_72_160 VDD VSS sg13g2_fill_2
XFILLER_166_1055 VDD VSS sg13g2_decap_4
X_14194__2008 _14194_/RESET_B VDD VSS sg13g2_tiehi
X_14635_ _14635_/Q clkload13/A _14635_/D _14635_/RESET_B VDD VSS sg13g2_dfrbpq_1
XFILLER_18_1301 VDD VSS sg13g2_decap_8
X_11847_ _11847_/X _14573_/Q _14605_/Q _14637_/Q _14669_/Q _11963_/S0 _11963_/S1 VDD
+ VSS sg13g2_mux4_1
XFILLER_60_344 VDD VSS sg13g2_decap_8
XFILLER_14_750 VDD VSS sg13g2_decap_8
XFILLER_92_1252 VDD VSS sg13g2_decap_4
XFILLER_61_889 VDD VSS sg13g2_decap_8
XFILLER_92_1263 VDD VSS sg13g2_decap_8
XFILLER_158_210 VDD VSS sg13g2_decap_8
X_14566_ _14566_/Q clkload52/A _14566_/D _14566_/RESET_B VDD VSS sg13g2_dfrbpq_1
XFILLER_57_1394 VDD VSS sg13g2_decap_8
XFILLER_105_1304 VDD VSS sg13g2_decap_8
X_11778_ _11912_/A _11778_/A _11778_/B VDD VSS sg13g2_nor2_1
XFILLER_105_1315 VDD VSS sg13g2_fill_2
XFILLER_105_1326 VDD VSS sg13g2_fill_2
XFILLER_18_1378 VDD VSS sg13g2_decap_8
XFILLER_9_231 VDD VSS sg13g2_decap_8
XFILLER_53_1258 VDD VSS sg13g2_decap_8
XFILLER_174_703 VDD VSS sg13g2_fill_1
X_13517_ _13517_/X _13517_/A _13566_/C VDD VSS sg13g2_and2_1
XFILLER_186_574 VDD VSS sg13g2_decap_8
X_10729_ _10995_/B _09060_/X _08893_/A _08893_/Y VDD VSS sg13g2_a21oi_1
X_14497_ _14497_/Q clkload8/A _14497_/D _14497_/RESET_B VDD VSS sg13g2_dfrbpq_1
X_13448_ _13449_/B _15199_/Q _13459_/B _13448_/C _13459_/D VDD VSS sg13g2_nand4_1
Xclkload12 clkload12/Y clkload12/A VDD VSS sg13g2_inv_2
XFILLER_179_1449 VDD VSS sg13g2_decap_8
Xclkload23 clkload23/Y clkload23/A VDD VSS sg13g2_inv_1
XFILLER_155_950 VDD VSS sg13g2_fill_2
XFILLER_62_4 VDD VSS sg13g2_decap_8
Xclkload34 clkload34/Y clkload34/A VDD VSS sg13g2_inv_2
XFILLER_127_663 VDD VSS sg13g2_fill_1
XFILLER_173_268 VDD VSS sg13g2_fill_1
XFILLER_186_91 VDD VSS sg13g2_decap_8
Xclkload45 clkload45/Y clkload45/A VDD VSS sg13g2_inv_1
XFILLER_115_814 VDD VSS sg13g2_decap_8
XFILLER_127_674 VDD VSS sg13g2_decap_8
Xclkload56 clkload56/Y clkload56/A VDD VSS sg13g2_inv_1
XFILLER_142_600 VDD VSS sg13g2_decap_8
XFILLER_154_460 VDD VSS sg13g2_decap_8
X_13379_ _15079_/D _15079_/Q _13390_/A2 _13378_/Y VDD VSS sg13g2_a21o_1
Xclkload67 clkload67/Y clkload67/A VDD VSS sg13g2_inv_8
XFILLER_155_994 VDD VSS sg13g2_fill_2
Xclkload78 clkload78/Y clkload78/A VDD VSS sg13g2_inv_4
XFILLER_115_836 VDD VSS sg13g2_decap_8
X_15118_ _15118_/Q clkload82/A _15118_/D _15118_/RESET_B VDD VSS sg13g2_dfrbpq_1
Xclkload89 clkload89/Y clkload89/A VDD VSS sg13g2_inv_2
XFILLER_142_644 VDD VSS sg13g2_decap_4
XFILLER_177_1184 VDD VSS sg13g2_decap_8
XFILLER_138_1146 VDD VSS sg13g2_decap_8
XFILLER_170_975 VDD VSS sg13g2_decap_8
X_14225__1977 _14225_/RESET_B VDD VSS sg13g2_tiehi
XFILLER_86_1089 VDD VSS sg13g2_fill_1
XFILLER_114_379 VDD VSS sg13g2_decap_4
X_15049_ _15049_/Q _15052_/CLK _15049_/D _15049_/RESET_B VDD VSS sg13g2_dfrbpq_1
X_07940_ _07940_/Y _07797_/B _07932_/Y _07939_/Y VDD VSS sg13g2_o21ai_1
XFILLER_116_1411 VDD VSS sg13g2_fill_1
XFILLER_96_720 VDD VSS sg13g2_decap_4
XFILLER_64_1365 VDD VSS sg13g2_decap_8
XFILLER_25_1327 VDD VSS sg13g2_decap_8
X_07871_ _07871_/X _08183_/B _08188_/A VDD VSS sg13g2_or2_1
XFILLER_68_444 VDD VSS sg13g2_decap_8
XFILLER_29_809 VDD VSS sg13g2_decap_8
X_09610_ _14206_/D _10074_/A0 _14206_/Q _09622_/S VDD VSS sg13g2_mux2_1
XFILLER_96_775 VDD VSS sg13g2_decap_8
XFILLER_7_1281 VDD VSS sg13g2_decap_8
XFILLER_55_116 VDD VSS sg13g2_decap_8
XFILLER_95_285 VDD VSS sg13g2_decap_8
XFILLER_110_1010 VDD VSS sg13g2_decap_8
X_14440__1762 _14440_/RESET_B VDD VSS sg13g2_tiehi
XFILLER_49_691 VDD VSS sg13g2_decap_8
X_09541_ _14139_/D _10005_/A0 _14139_/Q _09572_/S VDD VSS sg13g2_mux2_1
XFILLER_3_1145 VDD VSS sg13g2_decap_8
XFILLER_184_1100 VDD VSS sg13g2_decap_8
XFILLER_58_1103 VDD VSS sg13g2_decap_8
XFILLER_52_812 VDD VSS sg13g2_decap_8
X_09472_ _14073_/D _09969_/A1 _14073_/Q _09473_/S VDD VSS sg13g2_mux2_1
XFILLER_93_1016 VDD VSS sg13g2_decap_8
XFILLER_51_300 VDD VSS sg13g2_fill_1
XFILLER_51_311 VDD VSS sg13g2_decap_8
XFILLER_34_18 VDD VSS sg13g2_decap_8
XFILLER_91_491 VDD VSS sg13g2_decap_8
XFILLER_36_396 VDD VSS sg13g2_decap_8
XFILLER_145_1117 VDD VSS sg13g2_fill_1
X_08423_ _08423_/X _08574_/B _08423_/B VDD VSS sg13g2_xor2_1
XFILLER_52_867 VDD VSS sg13g2_decap_8
XFILLER_24_558 VDD VSS sg13g2_decap_8
XFILLER_184_1177 VDD VSS sg13g2_decap_8
XFILLER_75_1461 VDD VSS sg13g2_decap_8
XFILLER_149_210 VDD VSS sg13g2_fill_2
X_08354_ _08354_/Y _08414_/D _08354_/B VDD VSS sg13g2_xnor2_1
XFILLER_51_388 VDD VSS sg13g2_decap_8
X_13713__2489 _13713_/RESET_B VDD VSS sg13g2_tiehi
XFILLER_149_243 VDD VSS sg13g2_fill_1
XFILLER_36_1467 VDD VSS sg13g2_decap_8
XFILLER_36_1478 VDD VSS sg13g2_fill_1
XFILLER_32_1309 VDD VSS sg13g2_decap_8
XFILLER_138_928 VDD VSS sg13g2_decap_8
XFILLER_71_1369 VDD VSS sg13g2_decap_8
XFILLER_149_265 VDD VSS sg13g2_decap_8
Xclkload6 clkload6/Y clkload6/A VDD VSS sg13g2_inv_2
X_08285_ _08286_/C _07923_/Y _07925_/Y _07797_/A VDD VSS sg13g2_a21oi_1
XFILLER_20_775 VDD VSS sg13g2_fill_2
XFILLER_109_129 VDD VSS sg13g2_fill_1
XFILLER_50_39 VDD VSS sg13g2_decap_8
XFILLER_34_1180 VDD VSS sg13g2_decap_8
XFILLER_166_28 VDD VSS sg13g2_decap_8
XFILLER_20_797 VDD VSS sg13g2_decap_8
XFILLER_164_257 VDD VSS sg13g2_decap_4
XFILLER_118_663 VDD VSS sg13g2_decap_4
XFILLER_145_471 VDD VSS sg13g2_decap_8
XFILLER_118_696 VDD VSS sg13g2_decap_8
XFILLER_145_482 VDD VSS sg13g2_fill_1
XFILLER_106_858 VDD VSS sg13g2_fill_1
XFILLER_69_1276 VDD VSS sg13g2_decap_8
XFILLER_133_644 VDD VSS sg13g2_decap_8
XFILLER_133_655 VDD VSS sg13g2_fill_1
XFILLER_161_964 VDD VSS sg13g2_decap_4
XFILLER_105_357 VDD VSS sg13g2_decap_8
XFILLER_133_666 VDD VSS sg13g2_fill_1
XFILLER_160_452 VDD VSS sg13g2_decap_8
XFILLER_82_1421 VDD VSS sg13g2_decap_8
XFILLER_121_828 VDD VSS sg13g2_fill_2
XFILLER_114_880 VDD VSS sg13g2_fill_1
Xfanout210 _10156_/A1 _09726_/A0 VDD VSS sg13g2_buf_1
Xfanout1208 _13142_/A _14916_/Q VDD VSS sg13g2_buf_1
XFILLER_8_1012 VDD VSS sg13g2_decap_8
X_14977__2633 _14977_/RESET_B VDD VSS sg13g2_tiehi
Xfanout221 _09889_/A0 _09922_/A1 VDD VSS sg13g2_buf_1
Xfanout1219 _12895_/A _14869_/Q VDD VSS sg13g2_buf_1
Xfanout232 _09920_/A1 fanout234/X VDD VSS sg13g2_buf_1
XFILLER_59_422 VDD VSS sg13g2_decap_8
XFILLER_43_1427 VDD VSS sg13g2_decap_8
XFILLER_101_530 VDD VSS sg13g2_decap_8
Xfanout243 _11934_/B _11724_/B VDD VSS sg13g2_buf_1
Xfanout254 _09918_/A1 _09654_/A0 VDD VSS sg13g2_buf_1
Xfanout265 _10069_/S fanout266/X VDD VSS sg13g2_buf_1
XFILLER_86_241 VDD VSS sg13g2_decap_8
Xfanout276 _09604_/S _09593_/S VDD VSS sg13g2_buf_1
XFILLER_87_775 VDD VSS sg13g2_fill_2
XFILLER_75_14 VDD VSS sg13g2_decap_8
Xfanout287 _09617_/A0 fanout289/X VDD VSS sg13g2_buf_1
X_09808_ _14396_/D _09907_/A1 _14396_/Q _09838_/S VDD VSS sg13g2_mux2_1
XFILLER_59_477 VDD VSS sg13g2_decap_4
XFILLER_8_1089 VDD VSS sg13g2_decap_8
XFILLER_47_628 VDD VSS sg13g2_fill_1
Xfanout298 _10144_/A1 _09001_/X VDD VSS sg13g2_buf_1
XFILLER_115_98 VDD VSS sg13g2_decap_8
XFILLER_28_831 VDD VSS sg13g2_decap_4
XFILLER_74_447 VDD VSS sg13g2_decap_8
X_09739_ _14330_/D _09904_/A0 _14330_/Q _09739_/S VDD VSS sg13g2_mux2_1
XFILLER_41_1173 VDD VSS sg13g2_decap_8
XFILLER_55_650 VDD VSS sg13g2_decap_8
XFILLER_55_661 VDD VSS sg13g2_fill_2
XFILLER_61_108 VDD VSS sg13g2_decap_8
X_12750_ _15017_/D _12750_/A _12750_/B VDD VSS sg13g2_nor2_1
XFILLER_42_300 VDD VSS sg13g2_decap_8
XFILLER_167_1353 VDD VSS sg13g2_decap_8
XFILLER_91_13 VDD VSS sg13g2_fill_1
XFILLER_55_694 VDD VSS sg13g2_decap_8
XFILLER_76_1247 VDD VSS sg13g2_decap_8
X_11701_ _11702_/B _11664_/A _11700_/X _11664_/Y _11663_/Y _11723_/A2 VDD VSS sg13g2_a221oi_1
X_12681_ _12694_/A _07737_/A _07737_/B _15013_/Q VDD VSS sg13g2_a21oi_1
XFILLER_42_355 VDD VSS sg13g2_decap_8
XFILLER_91_68 VDD VSS sg13g2_fill_1
X_14420_ _14420_/Q _14528_/CLK _14420_/D _14420_/RESET_B VDD VSS sg13g2_dfrbpq_1
X_11632_ _14968_/D _11632_/A _11632_/B VDD VSS sg13g2_nor2_1
XFILLER_30_528 VDD VSS sg13g2_decap_4
XFILLER_168_541 VDD VSS sg13g2_decap_8
XFILLER_23_580 VDD VSS sg13g2_decap_8
X_14303__1899 _14303_/RESET_B VDD VSS sg13g2_tiehi
XFILLER_126_1061 VDD VSS sg13g2_decap_8
X_14351_ _14351_/Q clkload40/A _14351_/D _14351_/RESET_B VDD VSS sg13g2_dfrbpq_1
X_11563_ _11563_/Y _10702_/A _11792_/B _11559_/Y _11562_/Y VDD VSS sg13g2_a22oi_1
XFILLER_10_252 VDD VSS sg13g2_decap_8
X_13302_ _15058_/D _13299_/Y _13302_/B _13596_/B VDD VSS sg13g2_nand3b_1
X_10514_ _10538_/B _10514_/A _10514_/B _10514_/C VDD VSS sg13g2_nand3_1
XFILLER_7_735 VDD VSS sg13g2_decap_8
XFILLER_11_797 VDD VSS sg13g2_decap_8
X_14282_ _14282_/Q clkload20/A _14282_/D _14282_/RESET_B VDD VSS sg13g2_dfrbpq_1
X_11494_ _11495_/A _11488_/X _11489_/X _11493_/X _11492_/X _11971_/C _11975_/A VDD
+ VSS sg13g2_mux4_1
XFILLER_52_1291 VDD VSS sg13g2_decap_8
XFILLER_13_1264 VDD VSS sg13g2_decap_8
XFILLER_155_268 VDD VSS sg13g2_decap_8
X_13233_ _13233_/X input24/X _13264_/A2 _13264_/B1 VDD VSS sg13g2_a21o_1
XFILLER_87_1321 VDD VSS sg13g2_decap_8
XFILLER_6_256 VDD VSS sg13g2_decap_8
XFILLER_183_588 VDD VSS sg13g2_decap_8
X_10445_ _10459_/C _14838_/Q _14837_/Q _14832_/Q _14831_/Q VDD VSS sg13g2_nand4_1
XFILLER_137_994 VDD VSS sg13g2_decap_4
XFILLER_178_1460 VDD VSS sg13g2_decap_8
X_13868__2334 _13868_/RESET_B VDD VSS sg13g2_tiehi
XFILLER_100_1245 VDD VSS sg13g2_decap_8
XFILLER_136_471 VDD VSS sg13g2_decap_8
XFILLER_139_1444 VDD VSS sg13g2_fill_1
XFILLER_152_953 VDD VSS sg13g2_decap_8
X_13164_ _13164_/Y _14790_/Q _13164_/A2 _13275_/B1 VDD VSS sg13g2_o21ai_1
XFILLER_83_1207 VDD VSS sg13g2_decap_8
X_10376_ _10379_/C _14817_/Q _10375_/B VDD VSS sg13g2_nor2b_1
XFILLER_87_1398 VDD VSS sg13g2_decap_8
XFILLER_48_1349 VDD VSS sg13g2_decap_8
XFILLER_135_1308 VDD VSS sg13g2_fill_1
XFILLER_174_1357 VDD VSS sg13g2_decap_8
XFILLER_3_963 VDD VSS sg13g2_decap_8
XFILLER_139_1477 VDD VSS sg13g2_fill_2
X_12115_ _12115_/X _12108_/B _12114_/X _12113_/Y VDD VSS sg13g2_a21o_1
XFILLER_97_517 VDD VSS sg13g2_decap_8
XFILLER_69_219 VDD VSS sg13g2_decap_8
XFILLER_111_316 VDD VSS sg13g2_decap_8
X_13095_ _13095_/Y _10651_/D _13219_/B1 _13248_/B VDD VSS sg13g2_a21oi_1
XFILLER_2_462 VDD VSS sg13g2_decap_8
X_14772__2964 _14772_/RESET_B VDD VSS sg13g2_tiehi
XFILLER_46_1040 VDD VSS sg13g2_decap_8
XFILLER_133_1010 VDD VSS sg13g2_decap_8
X_12046_ _12046_/Y _12044_/Y _12046_/B _12143_/A VDD VSS sg13g2_nand3b_1
XFILLER_49_70 VDD VSS sg13g2_decap_8
XFILLER_137_1190 VDD VSS sg13g2_decap_8
XFILLER_27_7 VDD VSS sg13g2_decap_8
XFILLER_172_1092 VDD VSS sg13g2_decap_4
XFILLER_172_60 VDD VSS sg13g2_decap_8
X_16854_ _16854_/X _16854_/A VDD VSS sg13g2_buf_1
XFILLER_4_1421 VDD VSS sg13g2_decap_8
XFILLER_77_296 VDD VSS sg13g2_decap_8
XFILLER_37_138 VDD VSS sg13g2_decap_8
XFILLER_24_1382 VDD VSS sg13g2_decap_8
XFILLER_1_77 VDD VSS sg13g2_decap_8
XFILLER_20_1235 VDD VSS sg13g2_decap_8
X_13997_ _13997_/Q clkload24/A _13997_/D _13997_/RESET_B VDD VSS sg13g2_dfrbpq_1
XFILLER_59_1401 VDD VSS sg13g2_decap_8
XFILLER_168_1139 VDD VSS sg13g2_decap_8
XFILLER_92_266 VDD VSS sg13g2_decap_4
X_12948_ _12948_/Y _14808_/Q _13029_/A2 _12976_/B _14840_/Q _13069_/C1 VDD VSS sg13g2_a221oi_1
XFILLER_74_992 VDD VSS sg13g2_decap_8
XFILLER_34_834 VDD VSS sg13g2_decap_8
XFILLER_185_1453 VDD VSS sg13g2_decap_8
XFILLER_73_480 VDD VSS sg13g2_decap_8
XFILLER_33_322 VDD VSS sg13g2_fill_2
XFILLER_61_642 VDD VSS sg13g2_fill_2
XFILLER_59_1478 VDD VSS sg13g2_fill_1
X_12879_ _12879_/Y _14836_/Q _12879_/B VDD VSS sg13g2_nand2_1
XFILLER_146_1459 VDD VSS sg13g2_decap_8
XFILLER_159_530 VDD VSS sg13g2_fill_2
X_14618_ _14618_/Q _14682_/CLK _14618_/D _14618_/RESET_B VDD VSS sg13g2_dfrbpq_1
XFILLER_57_1191 VDD VSS sg13g2_decap_8
XFILLER_18_1175 VDD VSS sg13g2_decap_8
X_14549_ _14549_/Q clkload41/A _14549_/D _14549_/RESET_B VDD VSS sg13g2_dfrbpq_1
XFILLER_144_1194 VDD VSS sg13g2_fill_1
XFILLER_186_371 VDD VSS sg13g2_decap_8
XFILLER_53_1099 VDD VSS sg13g2_decap_8
XFILLER_119_449 VDD VSS sg13g2_decap_8
XFILLER_147_758 VDD VSS sg13g2_fill_2
X_13681__2533 _13681_/RESET_B VDD VSS sg13g2_tiehi
X_08070_ _08070_/X _08431_/A _08177_/S _08256_/B _08110_/D VDD VSS sg13g2_and4_1
XFILLER_140_1058 VDD VSS sg13g2_decap_8
XFILLER_179_1246 VDD VSS sg13g2_decap_8
XFILLER_31_1342 VDD VSS sg13g2_decap_8
XFILLER_162_728 VDD VSS sg13g2_decap_8
XFILLER_115_611 VDD VSS sg13g2_fill_1
XFILLER_127_471 VDD VSS sg13g2_fill_1
XFILLER_155_791 VDD VSS sg13g2_decap_8
X_14458__1744 _14458_/RESET_B VDD VSS sg13g2_tiehi
XFILLER_53_0 VDD VSS sg13g2_decap_8
XFILLER_115_633 VDD VSS sg13g2_decap_8
XFILLER_161_249 VDD VSS sg13g2_decap_8
X_14932__2703 _14932_/RESET_B VDD VSS sg13g2_tiehi
XFILLER_170_750 VDD VSS sg13g2_decap_8
XFILLER_66_1438 VDD VSS sg13g2_decap_8
XFILLER_114_143 VDD VSS sg13g2_decap_8
XFILLER_130_603 VDD VSS sg13g2_fill_2
X_08972_ _08972_/X _14895_/Q _08971_/X _08972_/S VDD VSS sg13g2_mux2_1
XFILLER_142_485 VDD VSS sg13g2_decap_8
XFILLER_170_794 VDD VSS sg13g2_decap_4
XFILLER_88_539 VDD VSS sg13g2_decap_8
XFILLER_9_1332 VDD VSS sg13g2_decap_8
XFILLER_102_349 VDD VSS sg13g2_decap_8
XFILLER_151_1110 VDD VSS sg13g2_fill_2
X_07923_ _07923_/Y _07909_/Y _07921_/Y _07904_/A VDD VSS sg13g2_o21ai_1
XFILLER_64_1162 VDD VSS sg13g2_decap_8
XFILLER_29_1282 VDD VSS sg13g2_decap_8
XFILLER_69_753 VDD VSS sg13g2_decap_8
XFILLER_25_1124 VDD VSS sg13g2_decap_8
XFILLER_111_850 VDD VSS sg13g2_decap_8
XFILLER_5_1218 VDD VSS sg13g2_decap_8
XFILLER_110_360 VDD VSS sg13g2_fill_1
X_07854_ _08643_/D _07855_/A _07855_/B VDD VSS sg13g2_nor2_1
XFILLER_111_894 VDD VSS sg13g2_decap_8
XFILLER_83_222 VDD VSS sg13g2_decap_8
XFILLER_99_1258 VDD VSS sg13g2_decap_8
XFILLER_42_1471 VDD VSS sg13g2_decap_8
XFILLER_186_1217 VDD VSS sg13g2_decap_8
XFILLER_84_767 VDD VSS sg13g2_decap_8
X_07785_ _08414_/A _07786_/A _08351_/B VDD VSS sg13g2_nor2_1
X_09524_ _14123_/D _10154_/A1 _14123_/Q _09524_/S VDD VSS sg13g2_mux2_1
XFILLER_25_823 VDD VSS sg13g2_decap_8
XFILLER_83_299 VDD VSS sg13g2_decap_8
XFILLER_65_992 VDD VSS sg13g2_fill_1
XFILLER_149_1050 VDD VSS sg13g2_fill_1
XFILLER_36_182 VDD VSS sg13g2_fill_1
X_09455_ _14056_/D _09620_/A0 _14056_/Q _09461_/S VDD VSS sg13g2_mux2_1
XFILLER_73_1409 VDD VSS sg13g2_decap_8
X_13946__2256 _13946_/RESET_B VDD VSS sg13g2_tiehi
XFILLER_40_815 VDD VSS sg13g2_decap_8
XFILLER_25_889 VDD VSS sg13g2_decap_4
X_08406_ _08406_/X _08406_/A _08428_/S VDD VSS sg13g2_and2_1
XFILLER_24_377 VDD VSS sg13g2_decap_8
XFILLER_12_528 VDD VSS sg13g2_decap_8
XFILLER_52_697 VDD VSS sg13g2_decap_8
XFILLER_101_78 VDD VSS sg13g2_fill_1
X_09386_ _13989_/D _09617_/A0 _13989_/Q _09397_/S VDD VSS sg13g2_mux2_1
XFILLER_178_850 VDD VSS sg13g2_decap_8
XFILLER_51_185 VDD VSS sg13g2_decap_8
XFILLER_127_1370 VDD VSS sg13g2_decap_8
XFILLER_123_1212 VDD VSS sg13g2_decap_8
XFILLER_61_49 VDD VSS sg13g2_decap_8
XFILLER_36_1264 VDD VSS sg13g2_decap_8
X_08337_ _08337_/X _07782_/A _07786_/A _08362_/A3 _08276_/A _08337_/S0 _08337_/S1
+ VDD VSS sg13g2_mux4_1
XFILLER_32_1106 VDD VSS sg13g2_decap_8
XFILLER_162_1283 VDD VSS sg13g2_decap_8
XFILLER_165_511 VDD VSS sg13g2_fill_2
XFILLER_71_1166 VDD VSS sg13g2_decap_8
XFILLER_177_382 VDD VSS sg13g2_decap_8
XFILLER_123_1256 VDD VSS sg13g2_decap_8
X_08268_ _08268_/Y _08318_/B _08268_/B VDD VSS sg13g2_xnor2_1
XFILLER_118_460 VDD VSS sg13g2_decap_4
XFILLER_158_1319 VDD VSS sg13g2_decap_8
X_08199_ _08201_/C _08200_/A _08199_/B _08199_/C VDD VSS sg13g2_nor3_1
XFILLER_69_1040 VDD VSS sg13g2_fill_1
XFILLER_4_749 VDD VSS sg13g2_decap_8
XFILLER_106_633 VDD VSS sg13g2_fill_2
X_10230_ _10232_/A _14771_/Q _10234_/D _14772_/Q VDD VSS sg13g2_a21o_1
XFILLER_105_132 VDD VSS sg13g2_decap_8
XFILLER_10_42 VDD VSS sg13g2_decap_8
XFILLER_133_452 VDD VSS sg13g2_fill_1
XFILLER_161_772 VDD VSS sg13g2_decap_8
XFILLER_79_517 VDD VSS sg13g2_decap_8
XFILLER_0_911 VDD VSS sg13g2_decap_8
X_10161_ _14738_/D _14738_/Q _10161_/A1 _10167_/S VDD VSS sg13g2_mux2_1
Xfanout1005 _09905_/A _15067_/Q VDD VSS sg13g2_buf_1
XFILLER_120_124 VDD VSS sg13g2_decap_8
Xfanout1016 _10793_/A _15060_/Q VDD VSS sg13g2_buf_1
Xfanout1027 _08977_/C fanout1031/X VDD VSS sg13g2_buf_1
XFILLER_47_1382 VDD VSS sg13g2_decap_8
Xfanout1038 _13283_/A _15054_/Q VDD VSS sg13g2_buf_1
X_10092_ _14672_/D _10159_/A1 _14672_/Q _10092_/S VDD VSS sg13g2_mux2_1
XFILLER_94_509 VDD VSS sg13g2_decap_8
XFILLER_43_1224 VDD VSS sg13g2_decap_8
XFILLER_86_57 VDD VSS sg13g2_decap_4
Xfanout1049 _08263_/B _14997_/Q VDD VSS sg13g2_buf_1
XFILLER_82_1295 VDD VSS sg13g2_decap_8
XFILLER_0_988 VDD VSS sg13g2_decap_8
XFILLER_101_360 VDD VSS sg13g2_decap_8
XFILLER_102_883 VDD VSS sg13g2_fill_2
XFILLER_19_105 VDD VSS sg13g2_decap_8
X_13920_ _13920_/Q clkload23/A _13920_/D _13920_/RESET_B VDD VSS sg13g2_dfrbpq_1
XFILLER_47_414 VDD VSS sg13g2_decap_8
XFILLER_87_583 VDD VSS sg13g2_decap_8
XFILLER_74_200 VDD VSS sg13g2_decap_8
XFILLER_48_948 VDD VSS sg13g2_fill_2
X_14760__2979 _14760_/RESET_B VDD VSS sg13g2_tiehi
XFILLER_87_594 VDD VSS sg13g2_decap_8
XFILLER_130_1249 VDD VSS sg13g2_fill_2
XFILLER_19_84 VDD VSS sg13g2_decap_8
X_13851_ _13851_/Q clkload80/A _13851_/D _13851_/RESET_B VDD VSS sg13g2_dfrbpq_1
XFILLER_169_1448 VDD VSS sg13g2_decap_8
X_12802_ _12802_/Y _12900_/B input11/X _12900_/C VDD VSS sg13g2_nand3_1
XFILLER_62_428 VDD VSS sg13g2_fill_1
XFILLER_56_981 VDD VSS sg13g2_fill_1
X_13782_ _13782_/Q _14742_/CLK _13782_/D _13782_/RESET_B VDD VSS sg13g2_dfrbpq_1
X_10994_ _11042_/B _10995_/A _10995_/B VDD VSS sg13g2_nor2_1
XFILLER_43_620 VDD VSS sg13g2_decap_8
XFILLER_128_1101 VDD VSS sg13g2_decap_8
XFILLER_167_1150 VDD VSS sg13g2_decap_8
XFILLER_16_856 VDD VSS sg13g2_decap_8
XFILLER_16_867 VDD VSS sg13g2_fill_2
X_12733_ _12733_/X _12729_/X _12728_/X _12727_/X _12726_/X _12788_/S0 _12355_/S VDD
+ VSS sg13g2_mux4_1
XFILLER_15_366 VDD VSS sg13g2_fill_2
X_14536__1666 _14536_/RESET_B VDD VSS sg13g2_tiehi
XFILLER_76_1077 VDD VSS sg13g2_fill_1
XFILLER_43_675 VDD VSS sg13g2_decap_8
XFILLER_42_152 VDD VSS sg13g2_decap_8
XFILLER_31_826 VDD VSS sg13g2_fill_1
X_12664_ _12664_/X _12662_/X _12663_/X _12664_/S VDD VSS sg13g2_mux2_1
XFILLER_31_837 VDD VSS sg13g2_fill_2
XFILLER_30_314 VDD VSS sg13g2_decap_8
XFILLER_30_325 VDD VSS sg13g2_fill_2
XFILLER_180_1350 VDD VSS sg13g2_decap_8
X_14403_ _14403_/Q clkload8/A _14403_/D _14403_/RESET_B VDD VSS sg13g2_dfrbpq_1
XFILLER_54_1353 VDD VSS sg13g2_decap_8
XFILLER_106_1432 VDD VSS sg13g2_decap_8
X_11615_ _11615_/X _11615_/A _11615_/B VDD VSS sg13g2_and2_1
X_15076__2868 _15076_/RESET_B VDD VSS sg13g2_tiehi
X_12595_ _12595_/X _12594_/X _12593_/X _12595_/S VDD VSS sg13g2_mux2_1
XFILLER_11_550 VDD VSS sg13g2_decap_8
XFILLER_129_736 VDD VSS sg13g2_fill_2
XFILLER_15_1348 VDD VSS sg13g2_decap_8
X_14334_ _14334_/Q _14526_/CLK _14334_/D _14334_/RESET_B VDD VSS sg13g2_dfrbpq_1
XFILLER_50_1239 VDD VSS sg13g2_decap_8
XFILLER_129_758 VDD VSS sg13g2_decap_4
XFILLER_141_1367 VDD VSS sg13g2_decap_8
X_11546_ _11546_/Y _11531_/A _14500_/Q _11529_/B VDD VSS sg13g2_a21oi_1
XFILLER_7_532 VDD VSS sg13g2_decap_8
XFILLER_51_82 VDD VSS sg13g2_fill_2
XFILLER_184_875 VDD VSS sg13g2_decap_8
XFILLER_167_60 VDD VSS sg13g2_decap_8
XFILLER_176_1408 VDD VSS sg13g2_decap_8
XFILLER_13_1061 VDD VSS sg13g2_decap_8
XFILLER_144_728 VDD VSS sg13g2_decap_8
XFILLER_156_588 VDD VSS sg13g2_fill_1
X_14265_ _14265_/Q _14745_/CLK _14265_/D _14265_/RESET_B VDD VSS sg13g2_dfrbpq_1
X_11477_ _11477_/Y _11858_/A _11477_/B VDD VSS sg13g2_nor2_1
XFILLER_171_536 VDD VSS sg13g2_decap_8
XFILLER_125_931 VDD VSS sg13g2_decap_8
XFILLER_183_396 VDD VSS sg13g2_decap_8
XFILLER_87_1140 VDD VSS sg13g2_fill_2
XFILLER_171_547 VDD VSS sg13g2_fill_2
X_13216_ _13216_/Y _13308_/A _13216_/B VDD VSS sg13g2_nand2_1
X_10428_ _10430_/C _14831_/Q _10453_/C _14832_/Q VDD VSS sg13g2_a21oi_1
X_14196_ _14196_/Q clkload11/A _14196_/D _14196_/RESET_B VDD VSS sg13g2_dfrbpq_1
XFILLER_83_1004 VDD VSS sg13g2_decap_8
XFILLER_100_1075 VDD VSS sg13g2_decap_8
XFILLER_139_1252 VDD VSS sg13g2_fill_2
XFILLER_98_826 VDD VSS sg13g2_decap_8
XFILLER_48_1146 VDD VSS sg13g2_decap_8
XFILLER_174_1154 VDD VSS sg13g2_decap_8
X_13147_ _13158_/B _13146_/B _13145_/Y _13170_/C VDD VSS sg13g2_a21o_1
XFILLER_83_1037 VDD VSS sg13g2_decap_8
XFILLER_3_760 VDD VSS sg13g2_decap_8
XFILLER_140_934 VDD VSS sg13g2_fill_1
X_10359_ _10359_/Y _10400_/A _10400_/B VDD VSS sg13g2_nor2_1
XFILLER_83_1048 VDD VSS sg13g2_fill_1
XFILLER_112_636 VDD VSS sg13g2_fill_1
XFILLER_97_336 VDD VSS sg13g2_decap_8
XFILLER_111_124 VDD VSS sg13g2_decap_8
XFILLER_140_956 VDD VSS sg13g2_decap_8
XFILLER_183_81 VDD VSS sg13g2_decap_8
XFILLER_61_1302 VDD VSS sg13g2_decap_8
X_13078_ _13092_/A _13078_/A _13172_/A _13172_/B VDD VSS sg13g2_nand3_1
XFILLER_39_904 VDD VSS sg13g2_decap_8
XFILLER_152_1452 VDD VSS sg13g2_decap_8
XFILLER_39_915 VDD VSS sg13g2_fill_1
XFILLER_25_4 VDD VSS sg13g2_decap_8
XFILLER_111_168 VDD VSS sg13g2_decap_8
XFILLER_26_1466 VDD VSS sg13g2_decap_8
X_12029_ _12029_/Y _12029_/A _12036_/B VDD VSS sg13g2_nand2_1
XFILLER_66_723 VDD VSS sg13g2_fill_1
XFILLER_26_1477 VDD VSS sg13g2_fill_2
XFILLER_61_1379 VDD VSS sg13g2_decap_8
XFILLER_54_907 VDD VSS sg13g2_decap_4
XFILLER_66_789 VDD VSS sg13g2_decap_8
XFILLER_19_661 VDD VSS sg13g2_decap_8
XFILLER_20_1032 VDD VSS sg13g2_fill_1
XFILLER_111_1171 VDD VSS sg13g2_decap_8
XFILLER_47_992 VDD VSS sg13g2_decap_8
XFILLER_81_748 VDD VSS sg13g2_decap_4
XFILLER_4_1295 VDD VSS sg13g2_decap_8
XFILLER_98_1291 VDD VSS sg13g2_decap_8
XFILLER_185_1250 VDD VSS sg13g2_decap_8
XFILLER_59_1275 VDD VSS sg13g2_decap_8
XFILLER_94_1177 VDD VSS sg13g2_decap_8
XFILLER_146_1256 VDD VSS sg13g2_decap_8
XFILLER_179_647 VDD VSS sg13g2_fill_1
XFILLER_22_826 VDD VSS sg13g2_fill_1
X_09240_ _10137_/C _09806_/B _10004_/C VDD VSS sg13g2_nand2_1
XFILLER_55_1139 VDD VSS sg13g2_decap_8
XFILLER_181_1169 VDD VSS sg13g2_decap_8
XFILLER_166_308 VDD VSS sg13g2_decap_8
XFILLER_178_168 VDD VSS sg13g2_decap_8
XFILLER_178_179 VDD VSS sg13g2_fill_1
X_09171_ _13787_/D _13787_/Q _10138_/A1 _09202_/S VDD VSS sg13g2_mux2_1
XFILLER_33_1415 VDD VSS sg13g2_decap_8
X_08122_ _08122_/Y _08511_/S _08121_/X _08120_/Y VDD VSS sg13g2_o21ai_1
XFILLER_108_909 VDD VSS sg13g2_fill_2
XFILLER_147_555 VDD VSS sg13g2_decap_8
XFILLER_147_577 VDD VSS sg13g2_decap_8
X_08053_ _08053_/Y _07853_/B _08054_/B VDD VSS sg13g2_nand2b_1
XFILLER_134_216 VDD VSS sg13g2_decap_8
XFILLER_116_920 VDD VSS sg13g2_decap_8
XFILLER_162_558 VDD VSS sg13g2_decap_4
XFILLER_89_815 VDD VSS sg13g2_decap_4
XFILLER_66_1235 VDD VSS sg13g2_decap_8
XFILLER_103_603 VDD VSS sg13g2_decap_8
XFILLER_116_986 VDD VSS sg13g2_decap_8
X_14010__2192 _14010_/RESET_B VDD VSS sg13g2_tiehi
XFILLER_89_826 VDD VSS sg13g2_decap_8
Xhold3102 input22/A mem_axi_rdata[26] VDD VSS sg13g2_dlygate4sd3_1
XFILLER_118_1325 VDD VSS sg13g2_fill_2
Xhold3113 _13619_/A _13727_/Q VDD VSS sg13g2_dlygate4sd3_1
XFILLER_27_1208 VDD VSS sg13g2_decap_8
XFILLER_157_1385 VDD VSS sg13g2_decap_8
Xhold3124 _10800_/A _14927_/Q VDD VSS sg13g2_dlygate4sd3_1
Xhold3135 _10914_/A _14936_/Q VDD VSS sg13g2_dlygate4sd3_1
Xhold3146 _13624_/A _13732_/Q VDD VSS sg13g2_dlygate4sd3_1
Xhold3157 _13423_/C _15095_/Q VDD VSS sg13g2_dlygate4sd3_1
X_08955_ _08955_/X _08954_/X _12298_/A _08955_/S VDD VSS sg13g2_mux2_1
Xhold3168 _13539_/A _15145_/Q VDD VSS sg13g2_dlygate4sd3_1
X_14614__1588 _14614_/RESET_B VDD VSS sg13g2_tiehi
XFILLER_69_550 VDD VSS sg13g2_fill_1
XFILLER_102_168 VDD VSS sg13g2_fill_1
X_07906_ _07908_/A _07797_/X _07906_/B _07906_/C VDD VSS sg13g2_nand3b_1
XFILLER_29_403 VDD VSS sg13g2_fill_1
XFILLER_5_1015 VDD VSS sg13g2_decap_8
X_08886_ _08886_/Y _08884_/Y _08885_/Y _08904_/S VDD VSS sg13g2_a21oi_1
XFILLER_29_425 VDD VSS sg13g2_decap_8
XFILLER_116_1082 VDD VSS sg13g2_decap_8
XFILLER_84_531 VDD VSS sg13g2_decap_8
XFILLER_56_49 VDD VSS sg13g2_decap_8
X_07837_ _08698_/A _12278_/A _15019_/Q VDD VSS sg13g2_nand2b_1
XFILLER_45_907 VDD VSS sg13g2_decap_8
XFILLER_45_918 VDD VSS sg13g2_fill_2
XFILLER_72_715 VDD VSS sg13g2_decap_8
XFILLER_186_1036 VDD VSS sg13g2_decap_8
XFILLER_38_981 VDD VSS sg13g2_decap_8
XFILLER_77_1320 VDD VSS sg13g2_decap_8
X_07768_ _08265_/B _07768_/A _08263_/B VDD VSS sg13g2_and2_1
XFILLER_112_44 VDD VSS sg13g2_fill_1
XFILLER_71_225 VDD VSS sg13g2_decap_8
XFILLER_71_236 VDD VSS sg13g2_fill_2
XFILLER_164_1301 VDD VSS sg13g2_decap_8
X_09507_ _09507_/Y _10037_/A _10105_/B _09606_/C VDD VSS sg13g2_nand3_1
XFILLER_73_1206 VDD VSS sg13g2_decap_8
X_07699_ _07700_/C _15078_/Q _15081_/Q _07694_/Y VDD VSS sg13g2_o21ai_1
XFILLER_25_675 VDD VSS sg13g2_decap_8
XFILLER_77_1397 VDD VSS sg13g2_decap_8
XFILLER_40_612 VDD VSS sg13g2_decap_8
X_09438_ _14040_/D _09737_/A0 _14040_/Q _09438_/S VDD VSS sg13g2_mux2_1
XFILLER_80_781 VDD VSS sg13g2_decap_4
XFILLER_164_1378 VDD VSS sg13g2_decap_8
XFILLER_52_494 VDD VSS sg13g2_decap_8
XFILLER_12_336 VDD VSS sg13g2_decap_8
XFILLER_24_196 VDD VSS sg13g2_decap_8
XFILLER_9_819 VDD VSS sg13g2_decap_8
X_09369_ _13973_/D _09767_/A1 _13973_/Q _09372_/S VDD VSS sg13g2_mux2_1
XFILLER_123_1020 VDD VSS sg13g2_decap_4
X_11400_ _11401_/B _11418_/A _14655_/Q VDD VSS sg13g2_nand2_1
XFILLER_184_149 VDD VSS sg13g2_decap_8
XFILLER_21_881 VDD VSS sg13g2_fill_2
X_14220__1982 _14220_/RESET_B VDD VSS sg13g2_tiehi
XFILLER_36_1094 VDD VSS sg13g2_decap_8
XFILLER_166_853 VDD VSS sg13g2_fill_2
X_12380_ _12380_/X _13949_/Q _13981_/Q _14013_/Q _14045_/Q _12380_/S0 _12380_/S1 VDD
+ VSS sg13g2_mux4_1
X_11331_ _11331_/Y _12118_/C _11330_/X _12223_/A VDD VSS sg13g2_a21oi_1
XFILLER_123_1097 VDD VSS sg13g2_decap_8
XFILLER_153_514 VDD VSS sg13g2_decap_4
XFILLER_107_931 VDD VSS sg13g2_fill_1
XFILLER_88_1460 VDD VSS sg13g2_decap_8
XFILLER_101_1362 VDD VSS sg13g2_decap_8
X_14050_ _14050_/Q _14722_/CLK _14050_/D _14050_/RESET_B VDD VSS sg13g2_dfrbpq_1
X_11262_ _11262_/Y _11262_/A _12187_/C VDD VSS sg13g2_nand2_1
XFILLER_4_546 VDD VSS sg13g2_decap_8
XFILLER_49_1422 VDD VSS sg13g2_decap_8
XFILLER_137_63 VDD VSS sg13g2_decap_8
XFILLER_10_1267 VDD VSS sg13g2_decap_8
X_13001_ _13001_/Y _14875_/Q _13028_/B _13138_/B1 VDD VSS sg13g2_a21oi_1
X_10213_ _10213_/X _13400_/B input37/X VDD VSS sg13g2_and2_1
XFILLER_121_400 VDD VSS sg13g2_decap_8
XFILLER_121_411 VDD VSS sg13g2_fill_2
X_11193_ _11193_/Y _11199_/B _11193_/A2 _11207_/B1 VDD VSS sg13g2_a21oi_1
XFILLER_45_1319 VDD VSS sg13g2_decap_8
XFILLER_84_1379 VDD VSS sg13g2_decap_8
XFILLER_136_1458 VDD VSS sg13g2_decap_8
XFILLER_121_444 VDD VSS sg13g2_decap_4
X_10144_ _14721_/D _14721_/Q _10144_/A1 _10156_/S VDD VSS sg13g2_mux2_1
XFILLER_94_306 VDD VSS sg13g2_decap_8
XFILLER_0_785 VDD VSS sg13g2_decap_8
X_14952_ _14952_/Q clkload68/A _14952_/D _14952_/RESET_B VDD VSS sg13g2_dfrbpq_1
X_10075_ _14655_/D _10075_/A0 _14655_/Q _10096_/S VDD VSS sg13g2_mux2_1
XFILLER_130_1024 VDD VSS sg13g2_decap_8
XFILLER_153_95 VDD VSS sg13g2_decap_8
XFILLER_47_233 VDD VSS sg13g2_fill_2
XFILLER_130_1035 VDD VSS sg13g2_fill_2
X_13903_ _13903_/Q clkload35/A _13903_/D _13903_/RESET_B VDD VSS sg13g2_dfrbpq_1
XFILLER_78_1106 VDD VSS sg13g2_decap_8
XFILLER_21_1330 VDD VSS sg13g2_decap_8
X_14883_ _14883_/Q clkload88/A _14883_/D _14883_/RESET_B VDD VSS sg13g2_dfrbpq_1
XFILLER_29_970 VDD VSS sg13g2_fill_2
XFILLER_169_1245 VDD VSS sg13g2_decap_8
XFILLER_90_512 VDD VSS sg13g2_decap_8
XFILLER_1_1435 VDD VSS sg13g2_decap_8
X_13834_ _13834_/Q clkload27/A _13834_/D _13834_/RESET_B VDD VSS sg13g2_dfrbpq_1
Xclkbuf_5_5__f_clk_i clkload1/A clkbuf_4_2_0_clk_i/X VDD VSS sg13g2_buf_16
XFILLER_90_545 VDD VSS sg13g2_decap_4
XFILLER_63_759 VDD VSS sg13g2_decap_8
X_13765_ _13765_/Q _14728_/CLK _13765_/D _13765_/RESET_B VDD VSS sg13g2_dfrbpq_1
XFILLER_95_1464 VDD VSS sg13g2_decap_8
X_10977_ _10978_/B _10949_/Y _11004_/A _11009_/B VDD VSS sg13g2_a21oi_1
XFILLER_62_269 VDD VSS sg13g2_decap_8
XFILLER_43_450 VDD VSS sg13g2_fill_2
XFILLER_56_1437 VDD VSS sg13g2_decap_8
X_12716_ _12716_/X _14389_/Q _14421_/Q _14485_/Q _14517_/Q _12716_/S0 _12716_/S1 VDD
+ VSS sg13g2_mux4_1
XFILLER_91_1339 VDD VSS sg13g2_decap_8
XFILLER_143_1418 VDD VSS sg13g2_decap_8
XFILLER_182_1467 VDD VSS sg13g2_decap_8
X_13696_ _16858_/A clkload62/A _13696_/D _13696_/RESET_B VDD VSS sg13g2_dfrbpq_1
XFILLER_15_196 VDD VSS sg13g2_decap_8
XFILLER_176_606 VDD VSS sg13g2_decap_8
XFILLER_182_1478 VDD VSS sg13g2_fill_1
XFILLER_148_319 VDD VSS sg13g2_decap_8
XFILLER_54_1150 VDD VSS sg13g2_decap_8
XFILLER_129_500 VDD VSS sg13g2_decap_8
X_12647_ _12647_/X _13968_/Q _14000_/Q _14032_/Q _14064_/Q _12647_/S0 _12647_/S1 VDD
+ VSS sg13g2_mux4_1
XFILLER_31_667 VDD VSS sg13g2_decap_8
XFILLER_175_116 VDD VSS sg13g2_decap_8
XFILLER_62_81 VDD VSS sg13g2_decap_8
XFILLER_178_70 VDD VSS sg13g2_decap_8
XFILLER_129_533 VDD VSS sg13g2_decap_8
XFILLER_15_1145 VDD VSS sg13g2_decap_8
XFILLER_8_830 VDD VSS sg13g2_decap_8
XFILLER_7_21 VDD VSS sg13g2_decap_8
X_12578_ _12578_/X _14251_/Q _14283_/Q _14315_/Q _14347_/Q _12699_/S0 _12699_/S1 VDD
+ VSS sg13g2_mux4_1
XFILLER_117_706 VDD VSS sg13g2_decap_4
XFILLER_141_1164 VDD VSS sg13g2_fill_1
XFILLER_172_801 VDD VSS sg13g2_decap_8
XFILLER_117_717 VDD VSS sg13g2_decap_4
XFILLER_11_1009 VDD VSS sg13g2_decap_8
XFILLER_184_661 VDD VSS sg13g2_decap_8
XFILLER_89_1235 VDD VSS sg13g2_fill_2
XFILLER_141_1197 VDD VSS sg13g2_decap_8
X_14317_ _14317_/Q clkload24/A _14317_/D _14317_/RESET_B VDD VSS sg13g2_dfrbpq_1
X_11529_ _11533_/A _11528_/X _11529_/B VDD VSS sg13g2_nand2b_1
XFILLER_32_1470 VDD VSS sg13g2_decap_8
XFILLER_156_385 VDD VSS sg13g2_decap_8
XFILLER_176_1205 VDD VSS sg13g2_decap_8
XFILLER_171_333 VDD VSS sg13g2_decap_8
XFILLER_183_193 VDD VSS sg13g2_decap_8
XFILLER_7_98 VDD VSS sg13g2_decap_8
XFILLER_116_249 VDD VSS sg13g2_decap_8
X_14248_ _14248_/Q clkload21/A _14248_/D _14248_/RESET_B VDD VSS sg13g2_dfrbpq_1
XFILLER_172_878 VDD VSS sg13g2_decap_8
XFILLER_125_750 VDD VSS sg13g2_decap_8
XFILLER_98_612 VDD VSS sg13g2_decap_8
XFILLER_112_400 VDD VSS sg13g2_decap_8
X_14179_ _14179_/Q clkload8/A _14179_/D _14179_/RESET_B VDD VSS sg13g2_dfrbpq_1
XFILLER_139_1071 VDD VSS sg13g2_decap_8
Xfanout809 _12608_/S1 _12427_/S0 VDD VSS sg13g2_buf_1
XFILLER_140_742 VDD VSS sg13g2_decap_8
XFILLER_113_967 VDD VSS sg13g2_fill_2
XFILLER_140_753 VDD VSS sg13g2_fill_2
XFILLER_112_477 VDD VSS sg13g2_fill_2
XFILLER_6_1313 VDD VSS sg13g2_decap_8
X_08740_ _08740_/Y _13665_/Q _08752_/B VDD VSS sg13g2_nor2_1
XFILLER_152_1260 VDD VSS sg13g2_decap_8
XFILLER_26_1263 VDD VSS sg13g2_decap_8
XFILLER_78_380 VDD VSS sg13g2_fill_1
XFILLER_61_1176 VDD VSS sg13g2_decap_8
XFILLER_39_756 VDD VSS sg13g2_fill_1
Xfanout1380 _12286_/S0 _12140_/S0 VDD VSS sg13g2_buf_1
XFILLER_94_851 VDD VSS sg13g2_decap_8
XFILLER_27_907 VDD VSS sg13g2_decap_8
XFILLER_113_1255 VDD VSS sg13g2_decap_8
Xfanout1391 _11218_/S _11221_/S0 VDD VSS sg13g2_buf_1
X_08671_ _08671_/Y _08599_/C _08029_/Y _08520_/X _08599_/A _08670_/Y VDD VSS sg13g2_a221oi_1
XFILLER_38_255 VDD VSS sg13g2_fill_1
XFILLER_39_789 VDD VSS sg13g2_decap_8
XFILLER_54_726 VDD VSS sg13g2_decap_8
X_07622_ _07622_/Y _14861_/Q VDD VSS sg13g2_inv_1
XFILLER_26_439 VDD VSS sg13g2_fill_2
XFILLER_19_480 VDD VSS sg13g2_decap_8
XFILLER_4_1092 VDD VSS sg13g2_decap_8
XFILLER_179_411 VDD VSS sg13g2_decap_8
XFILLER_81_578 VDD VSS sg13g2_decap_8
XFILLER_59_1061 VDD VSS sg13g2_decap_8
XFILLER_22_601 VDD VSS sg13g2_fill_1
XFILLER_22_612 VDD VSS sg13g2_fill_2
X_14028__2174 _14028_/RESET_B VDD VSS sg13g2_tiehi
XFILLER_34_494 VDD VSS sg13g2_decap_8
XFILLER_167_617 VDD VSS sg13g2_decap_8
XFILLER_22_656 VDD VSS sg13g2_fill_2
X_09223_ _13834_/D _09723_/A0 _13834_/Q _09229_/S VDD VSS sg13g2_mux2_1
XFILLER_166_105 VDD VSS sg13g2_decap_8
XFILLER_179_488 VDD VSS sg13g2_decap_8
XFILLER_21_144 VDD VSS sg13g2_decap_4
XFILLER_50_987 VDD VSS sg13g2_decap_4
XFILLER_33_1212 VDD VSS sg13g2_decap_8
XFILLER_72_1272 VDD VSS sg13g2_decap_8
XFILLER_37_1392 VDD VSS sg13g2_decap_8
XFILLER_124_1351 VDD VSS sg13g2_decap_8
X_09154_ _09154_/Y _15248_/Q _09161_/S VDD VSS sg13g2_nand2b_1
XFILLER_148_864 VDD VSS sg13g2_fill_1
XFILLER_108_717 VDD VSS sg13g2_decap_8
X_08105_ _08105_/Y _08105_/A _08199_/B VDD VSS sg13g2_nor2_1
XFILLER_181_119 VDD VSS sg13g2_decap_8
XFILLER_33_1289 VDD VSS sg13g2_decap_8
X_09085_ _09085_/Y _15238_/Q _09107_/B VDD VSS sg13g2_nand2b_1
XFILLER_159_1458 VDD VSS sg13g2_decap_8
X_08036_ _08039_/B _08036_/A _08036_/B _08452_/C _08452_/D VDD VSS sg13g2_nand4_1
XFILLER_174_28 VDD VSS sg13g2_decap_8
XFILLER_116_750 VDD VSS sg13g2_decap_8
XFILLER_162_366 VDD VSS sg13g2_fill_2
XFILLER_150_517 VDD VSS sg13g2_decap_8
XFILLER_89_612 VDD VSS sg13g2_fill_2
XFILLER_116_783 VDD VSS sg13g2_decap_8
XFILLER_118_1111 VDD VSS sg13g2_decap_8
XFILLER_115_282 VDD VSS sg13g2_decap_8
XFILLER_88_122 VDD VSS sg13g2_decap_8
XFILLER_89_656 VDD VSS sg13g2_decap_4
XFILLER_66_1076 VDD VSS sg13g2_decap_8
XFILLER_66_1087 VDD VSS sg13g2_fill_2
XFILLER_118_1166 VDD VSS sg13g2_decap_8
X_09987_ _14570_/D _10153_/A1 _14570_/Q _09991_/S VDD VSS sg13g2_mux2_1
XFILLER_118_1177 VDD VSS sg13g2_fill_2
XFILLER_130_252 VDD VSS sg13g2_fill_1
XFILLER_153_1057 VDD VSS sg13g2_decap_8
XFILLER_103_477 VDD VSS sg13g2_decap_8
XFILLER_67_48 VDD VSS sg13g2_fill_2
XFILLER_118_1188 VDD VSS sg13g2_decap_8
XFILLER_130_274 VDD VSS sg13g2_decap_8
X_08938_ _13718_/D _16880_/A _08937_/X _08956_/S VDD VSS sg13g2_mux2_1
XFILLER_29_200 VDD VSS sg13g2_decap_4
XFILLER_170_1382 VDD VSS sg13g2_decap_8
XFILLER_69_391 VDD VSS sg13g2_fill_2
XFILLER_131_1344 VDD VSS sg13g2_decap_8
XFILLER_85_851 VDD VSS sg13g2_decap_8
XFILLER_44_1396 VDD VSS sg13g2_decap_8
XFILLER_29_233 VDD VSS sg13g2_decap_8
XFILLER_57_553 VDD VSS sg13g2_decap_8
X_08869_ _08869_/Y _08873_/A _14935_/Q VDD VSS sg13g2_nor2b_1
XFILLER_123_54 VDD VSS sg13g2_decap_8
XFILLER_40_1249 VDD VSS sg13g2_decap_8
XFILLER_29_255 VDD VSS sg13g2_decap_8
X_14238__1964 _14238_/RESET_B VDD VSS sg13g2_tiehi
XFILLER_79_1437 VDD VSS sg13g2_decap_8
X_10900_ _10900_/Y _10899_/Y _10896_/Y _10912_/B1 VDD VSS sg13g2_o21ai_1
XFILLER_85_895 VDD VSS sg13g2_decap_8
XFILLER_177_4 VDD VSS sg13g2_decap_8
XFILLER_83_25 VDD VSS sg13g2_decap_8
XFILLER_17_439 VDD VSS sg13g2_decap_8
X_11880_ _11880_/Y _11882_/S0 _14670_/Q _11529_/B VDD VSS sg13g2_a21oi_1
XFILLER_45_748 VDD VSS sg13g2_fill_1
XFILLER_26_940 VDD VSS sg13g2_decap_8
XFILLER_44_247 VDD VSS sg13g2_decap_8
X_10831_ _10832_/A _10831_/A _10831_/B _10831_/C VDD VSS sg13g2_nand3_1
XFILLER_129_1240 VDD VSS sg13g2_fill_2
XFILLER_26_995 VDD VSS sg13g2_decap_8
XFILLER_16_74 VDD VSS sg13g2_decap_8
X_13550_ _13550_/Y _13550_/A1 _13567_/A2 _13549_/Y VDD VSS sg13g2_a21oi_1
XFILLER_77_1194 VDD VSS sg13g2_decap_8
X_10762_ _10762_/Y _10767_/A _10762_/B VDD VSS sg13g2_nor2_1
XFILLER_25_494 VDD VSS sg13g2_decap_8
XFILLER_38_1167 VDD VSS sg13g2_decap_8
XFILLER_12_133 VDD VSS sg13g2_decap_8
XFILLER_160_1006 VDD VSS sg13g2_decap_8
XFILLER_164_1175 VDD VSS sg13g2_decap_8
X_12501_ _12501_/X _14246_/Q _14278_/Q _14310_/Q _14342_/Q _12506_/S0 _12506_/S1 VDD
+ VSS sg13g2_mux4_1
XFILLER_9_616 VDD VSS sg13g2_decap_8
XFILLER_16_1421 VDD VSS sg13g2_decap_8
X_13481_ _13484_/A _13481_/A _15176_/Q _13482_/B VDD VSS sg13g2_nand3_1
XFILLER_186_959 VDD VSS sg13g2_decap_8
X_10693_ _14900_/D _10693_/A VDD VSS sg13g2_inv_1
XFILLER_51_1312 VDD VSS sg13g2_decap_8
X_15220_ _15220_/Q clkload64/A _15220_/D _15220_/RESET_B VDD VSS sg13g2_dfrbpq_1
XFILLER_90_1372 VDD VSS sg13g2_decap_8
X_12432_ _12432_/X _13729_/Q _14081_/Q _14433_/Q _14529_/Q _12450_/S0 _12450_/S1 VDD
+ VSS sg13g2_mux4_1
XFILLER_185_469 VDD VSS sg13g2_decap_8
XFILLER_8_137 VDD VSS sg13g2_decap_8
XFILLER_103_1435 VDD VSS sg13g2_decap_8
XFILLER_120_0 VDD VSS sg13g2_decap_8
XFILLER_148_40 VDD VSS sg13g2_decap_8
X_15151_ _15151_/Q _15162_/CLK _15151_/D _15151_/RESET_B VDD VSS sg13g2_dfrbpq_1
XFILLER_32_84 VDD VSS sg13g2_decap_8
X_12363_ _12363_/X _14108_/Q _14140_/Q _14172_/Q _14204_/Q _12731_/S0 _12731_/S1 VDD
+ VSS sg13g2_mux4_1
XFILLER_51_1389 VDD VSS sg13g2_decap_8
XFILLER_154_845 VDD VSS sg13g2_fill_1
XFILLER_5_833 VDD VSS sg13g2_decap_8
X_14102_ _14102_/Q clkload75/A _14102_/D _14102_/RESET_B VDD VSS sg13g2_dfrbpq_1
XFILLER_86_1419 VDD VSS sg13g2_decap_8
X_11314_ _11314_/Y _11315_/A1 _14365_/Q VDD VSS sg13g2_nand2b_1
X_15082_ _15082_/Q _15203_/CLK _15082_/D _15082_/RESET_B VDD VSS sg13g2_dfrbpq_1
XFILLER_153_355 VDD VSS sg13g2_decap_8
XFILLER_154_878 VDD VSS sg13g2_fill_2
X_13726__2476 _13726_/RESET_B VDD VSS sg13g2_tiehi
X_12294_ _12294_/Y _14924_/Q _12294_/A2 _12294_/B1 VDD VSS sg13g2_a21oi_1
XFILLER_99_409 VDD VSS sg13g2_decap_8
XFILLER_4_343 VDD VSS sg13g2_decap_8
XFILLER_101_1170 VDD VSS sg13g2_decap_8
XFILLER_10_1064 VDD VSS sg13g2_decap_8
XFILLER_84_1121 VDD VSS sg13g2_decap_8
X_14033_ _14033_/Q clkload34/A _14033_/D _14033_/RESET_B VDD VSS sg13g2_dfrbpq_1
XFILLER_136_1200 VDD VSS sg13g2_decap_8
XFILLER_153_388 VDD VSS sg13g2_fill_2
X_11245_ _11245_/Y _11245_/A _11245_/B _11245_/C VDD VSS sg13g2_nand3_1
XFILLER_79_100 VDD VSS sg13g2_decap_8
XFILLER_180_196 VDD VSS sg13g2_decap_8
XFILLER_134_591 VDD VSS sg13g2_decap_4
XFILLER_45_1127 VDD VSS sg13g2_decap_4
XFILLER_121_230 VDD VSS sg13g2_decap_8
XFILLER_175_1293 VDD VSS sg13g2_decap_8
XFILLER_80_1018 VDD VSS sg13g2_fill_1
XFILLER_49_1296 VDD VSS sg13g2_decap_8
X_11176_ _11177_/B _11171_/B _11147_/Y _11175_/Y VDD VSS sg13g2_a21o_1
XFILLER_84_1198 VDD VSS sg13g2_decap_8
XFILLER_0_560 VDD VSS sg13g2_decap_8
XFILLER_171_1168 VDD VSS sg13g2_decap_8
XFILLER_95_626 VDD VSS sg13g2_decap_8
XFILLER_79_177 VDD VSS sg13g2_decap_8
X_10127_ _14705_/D _10160_/A1 _14705_/Q _10134_/S VDD VSS sg13g2_mux2_1
XFILLER_110_959 VDD VSS sg13g2_decap_8
X_14106__2096 _14106_/RESET_B VDD VSS sg13g2_tiehi
X_13941__2261 _13941_/RESET_B VDD VSS sg13g2_tiehi
XFILLER_95_659 VDD VSS sg13g2_decap_8
XFILLER_62_1474 VDD VSS sg13g2_fill_1
XFILLER_110_1406 VDD VSS sg13g2_decap_8
XFILLER_23_1458 VDD VSS sg13g2_decap_8
X_14935_ _14935_/Q clkload64/A _14935_/D _14935_/RESET_B VDD VSS sg13g2_dfrbpq_1
X_10058_ _14639_/D _10125_/A0 _14639_/Q _10068_/S VDD VSS sg13g2_mux2_1
XFILLER_82_309 VDD VSS sg13g2_decap_8
XFILLER_75_350 VDD VSS sg13g2_decap_8
XFILLER_63_523 VDD VSS sg13g2_decap_8
X_14866_ _14866_/Q clkload85/A _14866_/D _14866_/RESET_B VDD VSS sg13g2_dfrbpq_1
XFILLER_35_225 VDD VSS sg13g2_decap_8
XFILLER_1_1232 VDD VSS sg13g2_decap_8
XFILLER_169_1075 VDD VSS sg13g2_decap_8
X_13817_ _13817_/Q _14745_/CLK _13817_/D _13817_/RESET_B VDD VSS sg13g2_dfrbpq_1
X_14797_ _14797_/Q clkload89/A _14797_/D _14797_/RESET_B VDD VSS sg13g2_dfrbpq_1
XFILLER_90_375 VDD VSS sg13g2_decap_8
XFILLER_56_1234 VDD VSS sg13g2_decap_8
XFILLER_32_921 VDD VSS sg13g2_decap_8
X_13748_ _13748_/Q _15005_/CLK _13748_/D _13748_/RESET_B VDD VSS sg13g2_dfrbpq_1
XFILLER_182_1264 VDD VSS sg13g2_decap_8
XFILLER_43_291 VDD VSS sg13g2_decap_8
XFILLER_108_1346 VDD VSS sg13g2_decap_8
XFILLER_31_464 VDD VSS sg13g2_decap_8
X_13679_ _13679_/Q clkload57/A _13679_/D _13679_/RESET_B VDD VSS sg13g2_dfrbpq_1
XFILLER_129_341 VDD VSS sg13g2_decap_8
XFILLER_157_650 VDD VSS sg13g2_decap_8
XFILLER_145_801 VDD VSS sg13g2_decap_8
XFILLER_163_119 VDD VSS sg13g2_decap_8
XFILLER_185_992 VDD VSS sg13g2_decap_8
XFILLER_89_1043 VDD VSS sg13g2_decap_8
XFILLER_117_536 VDD VSS sg13g2_decap_8
XFILLER_145_856 VDD VSS sg13g2_decap_8
X_14893__2781 _14893_/RESET_B VDD VSS sg13g2_tiehi
XFILLER_160_815 VDD VSS sg13g2_decap_4
XFILLER_99_910 VDD VSS sg13g2_decap_8
X_14316__1886 _14316_/RESET_B VDD VSS sg13g2_tiehi
X_09910_ _14495_/D _14495_/Q _09910_/A1 _09921_/S VDD VSS sg13g2_mux2_1
XFILLER_99_954 VDD VSS sg13g2_decap_8
XFILLER_67_1374 VDD VSS sg13g2_decap_8
Xfanout606 _13294_/B _10670_/Y VDD VSS sg13g2_buf_1
XFILLER_28_1336 VDD VSS sg13g2_decap_8
XFILLER_113_753 VDD VSS sg13g2_fill_2
Xfanout617 _10757_/A fanout622/X VDD VSS sg13g2_buf_1
X_09841_ _14428_/D _14428_/Q _09841_/A1 _09871_/S VDD VSS sg13g2_mux2_1
XFILLER_113_764 VDD VSS sg13g2_fill_1
Xfanout628 _08844_/A _10694_/S VDD VSS sg13g2_buf_1
XFILLER_154_1366 VDD VSS sg13g2_decap_8
Xfanout639 _10173_/B _13508_/C VDD VSS sg13g2_buf_1
XFILLER_99_998 VDD VSS sg13g2_decap_8
XFILLER_100_414 VDD VSS sg13g2_fill_2
XFILLER_101_948 VDD VSS sg13g2_decap_8
X_14495__1707 _14495_/RESET_B VDD VSS sg13g2_tiehi
X_09772_ _14362_/D _14362_/Q _09904_/A0 _09772_/S VDD VSS sg13g2_mux2_1
XFILLER_6_1110 VDD VSS sg13g2_decap_8
XFILLER_112_285 VDD VSS sg13g2_decap_8
XFILLER_67_840 VDD VSS sg13g2_decap_8
X_14531__1671 _14531_/RESET_B VDD VSS sg13g2_tiehi
X_08723_ _08723_/Y _08723_/A _08723_/B VDD VSS sg13g2_nor2_1
XFILLER_113_1063 VDD VSS sg13g2_decap_4
XFILLER_6_1187 VDD VSS sg13g2_decap_8
XFILLER_2_1029 VDD VSS sg13g2_decap_8
XFILLER_113_1085 VDD VSS sg13g2_decap_8
X_08654_ _08654_/Y _08654_/A _08654_/B VDD VSS sg13g2_nor2_1
XFILLER_94_692 VDD VSS sg13g2_fill_1
XFILLER_27_737 VDD VSS sg13g2_fill_2
XFILLER_113_1096 VDD VSS sg13g2_fill_1
XFILLER_148_1115 VDD VSS sg13g2_decap_8
X_14785__2951 _14785_/RESET_B VDD VSS sg13g2_tiehi
XFILLER_81_331 VDD VSS sg13g2_decap_8
XFILLER_96_1069 VDD VSS sg13g2_decap_8
XFILLER_148_1148 VDD VSS sg13g2_decap_8
X_08585_ _08586_/C _08608_/B _08576_/Y _08584_/Y VDD VSS sg13g2_o21ai_1
XFILLER_81_386 VDD VSS sg13g2_decap_8
XFILLER_41_217 VDD VSS sg13g2_decap_8
XFILLER_126_1413 VDD VSS sg13g2_decap_8
XFILLER_165_1462 VDD VSS sg13g2_decap_8
XFILLER_168_904 VDD VSS sg13g2_fill_1
XFILLER_74_1345 VDD VSS sg13g2_decap_8
XFILLER_169_28 VDD VSS sg13g2_decap_8
X_13804__2398 _13804_/RESET_B VDD VSS sg13g2_tiehi
XFILLER_39_1476 VDD VSS sg13g2_fill_2
XFILLER_50_740 VDD VSS sg13g2_decap_8
XFILLER_22_442 VDD VSS sg13g2_decap_8
XFILLER_168_937 VDD VSS sg13g2_fill_2
XFILLER_161_1359 VDD VSS sg13g2_decap_8
X_09206_ _09206_/X _09441_/A _09307_/B _09806_/B _09641_/D VDD VSS sg13g2_or4_1
XFILLER_10_637 VDD VSS sg13g2_decap_8
XFILLER_72_1080 VDD VSS sg13g2_decap_8
XFILLER_33_1042 VDD VSS sg13g2_fill_2
XFILLER_148_672 VDD VSS sg13g2_decap_8
X_13983__2219 _13983_/RESET_B VDD VSS sg13g2_tiehi
X_09137_ _09137_/Y _09137_/A _09137_/B _09137_/C VDD VSS sg13g2_nor3_1
XFILLER_185_49 VDD VSS sg13g2_decap_8
XFILLER_135_344 VDD VSS sg13g2_decap_4
XFILLER_136_867 VDD VSS sg13g2_decap_8
XFILLER_162_130 VDD VSS sg13g2_fill_2
X_09068_ _09103_/C _14911_/Q _13064_/A _09089_/C VDD VSS sg13g2_and3_1
XFILLER_159_1255 VDD VSS sg13g2_decap_8
XFILLER_118_54 VDD VSS sg13g2_decap_8
XFILLER_118_65 VDD VSS sg13g2_fill_1
XFILLER_11_1373 VDD VSS sg13g2_decap_8
XFILLER_155_1119 VDD VSS sg13g2_decap_4
X_08019_ _08019_/X _08177_/S _08019_/B VDD VSS sg13g2_and2_1
XFILLER_78_14 VDD VSS sg13g2_decap_8
XFILLER_116_580 VDD VSS sg13g2_decap_8
XFILLER_89_420 VDD VSS sg13g2_decap_8
XFILLER_46_1414 VDD VSS sg13g2_decap_8
XFILLER_2_847 VDD VSS sg13g2_decap_8
XFILLER_85_1474 VDD VSS sg13g2_decap_4
X_11030_ _11030_/Y _11024_/B _11045_/A2 _11045_/B1 VDD VSS sg13g2_a21oi_1
XFILLER_78_69 VDD VSS sg13g2_decap_8
XFILLER_150_369 VDD VSS sg13g2_fill_1
XFILLER_1_357 VDD VSS sg13g2_decap_8
XFILLER_77_604 VDD VSS sg13g2_fill_2
XFILLER_104_775 VDD VSS sg13g2_fill_2
XFILLER_104_786 VDD VSS sg13g2_decap_8
XFILLER_172_1466 VDD VSS sg13g2_decap_4
XFILLER_81_1349 VDD VSS sg13g2_decap_8
XFILLER_131_572 VDD VSS sg13g2_decap_8
XFILLER_89_486 VDD VSS sg13g2_fill_1
XFILLER_77_659 VDD VSS sg13g2_decap_8
XFILLER_76_147 VDD VSS sg13g2_decap_8
XFILLER_76_158 VDD VSS sg13g2_fill_1
X_12981_ _12981_/Y input23/X _12795_/Y _12937_/Y VDD VSS sg13g2_o21ai_1
XFILLER_94_46 VDD VSS sg13g2_decap_8
XFILLER_44_1193 VDD VSS sg13g2_decap_8
Xclkbuf_5_23__f_clk_i clkbuf_leaf_92_clk_i/A clkbuf_4_11_0_clk_i/X VDD VSS sg13g2_buf_16
X_14720_ _14720_/Q clkload23/A _14720_/D _14720_/RESET_B VDD VSS sg13g2_dfrbpq_1
X_11932_ _11932_/Y _11931_/Y _11930_/Y _11917_/Y _12156_/A _12126_/A VDD VSS sg13g2_a221oi_1
XFILLER_40_1068 VDD VSS sg13g2_decap_8
XFILLER_131_1196 VDD VSS sg13g2_decap_4
XFILLER_72_320 VDD VSS sg13g2_decap_8
XFILLER_45_545 VDD VSS sg13g2_fill_1
XFILLER_79_1267 VDD VSS sg13g2_decap_8
XFILLER_73_865 VDD VSS sg13g2_decap_8
XFILLER_150_52 VDD VSS sg13g2_decap_8
XFILLER_75_1109 VDD VSS sg13g2_fill_2
XFILLER_150_63 VDD VSS sg13g2_fill_1
XFILLER_168_0 VDD VSS sg13g2_decap_8
X_14651_ _14651_/Q clkload79/A _14651_/D _14651_/RESET_B VDD VSS sg13g2_dfrbpq_1
X_11863_ _11863_/Y _11865_/A _11934_/B VDD VSS sg13g2_nor2_1
XFILLER_166_1248 VDD VSS sg13g2_decap_8
XFILLER_26_770 VDD VSS sg13g2_decap_8
XFILLER_92_1423 VDD VSS sg13g2_decap_8
XFILLER_14_932 VDD VSS sg13g2_decap_4
X_13602_ _13602_/Y _13602_/A _13609_/B VDD VSS sg13g2_nor2_1
X_10814_ _10814_/Y _10805_/B _10805_/C _10844_/B VDD VSS sg13g2_o21ai_1
XFILLER_60_537 VDD VSS sg13g2_decap_8
X_14582_ _14582_/Q clkload45/A _14582_/D _14582_/RESET_B VDD VSS sg13g2_dfrbpq_1
X_11794_ _11794_/Y _11793_/Y _11792_/Y _11780_/Y _11868_/A _11978_/B1 VDD VSS sg13g2_a221oi_1
XFILLER_129_1070 VDD VSS sg13g2_decap_8
XFILLER_13_431 VDD VSS sg13g2_decap_8
XFILLER_41_740 VDD VSS sg13g2_decap_4
XFILLER_25_291 VDD VSS sg13g2_decap_8
XFILLER_158_403 VDD VSS sg13g2_fill_1
XFILLER_129_1081 VDD VSS sg13g2_fill_2
XFILLER_159_937 VDD VSS sg13g2_decap_8
X_13533_ _13533_/X _13533_/A _13566_/C VDD VSS sg13g2_and2_1
X_10745_ _10745_/Y _14914_/Q _11102_/B VDD VSS sg13g2_nand2_1
XFILLER_9_413 VDD VSS sg13g2_decap_8
XFILLER_13_475 VDD VSS sg13g2_decap_4
XFILLER_186_756 VDD VSS sg13g2_decap_8
XFILLER_40_272 VDD VSS sg13g2_fill_1
X_13464_ _15107_/D _13449_/X _13463_/X _13461_/Y VDD VSS sg13g2_o21ai_1
X_10676_ _10813_/A _08977_/B _10669_/S _10805_/B VDD VSS sg13g2_a21oi_1
XFILLER_185_266 VDD VSS sg13g2_decap_8
X_15203_ _15203_/Q _15203_/CLK _15203_/D _15203_/RESET_B VDD VSS sg13g2_dfrbpq_1
X_12415_ _12415_/Y _12415_/A _12415_/B VDD VSS sg13g2_nand2_1
XFILLER_16_1295 VDD VSS sg13g2_decap_8
X_14573__1629 _14573_/RESET_B VDD VSS sg13g2_tiehi
XFILLER_138_171 VDD VSS sg13g2_fill_2
XFILLER_139_694 VDD VSS sg13g2_decap_8
X_13395_ _13396_/D _13407_/B _15129_/Q _13507_/B VDD VSS sg13g2_nand3_1
X_13959__2243 _13959_/RESET_B VDD VSS sg13g2_tiehi
XFILLER_51_1186 VDD VSS sg13g2_decap_8
XFILLER_127_856 VDD VSS sg13g2_decap_8
XFILLER_127_867 VDD VSS sg13g2_fill_1
XFILLER_12_1159 VDD VSS sg13g2_decap_8
XFILLER_5_630 VDD VSS sg13g2_decap_8
XFILLER_153_130 VDD VSS sg13g2_decap_8
X_15134_ _15134_/Q _15139_/CLK _15134_/D _15134_/RESET_B VDD VSS sg13g2_dfrbpq_1
X_12346_ _12347_/D _12346_/A _15121_/Q VDD VSS sg13g2_or2_1
XFILLER_126_366 VDD VSS sg13g2_decap_4
XFILLER_154_675 VDD VSS sg13g2_decap_8
XFILLER_154_686 VDD VSS sg13g2_fill_2
XFILLER_175_60 VDD VSS sg13g2_decap_8
XFILLER_177_1366 VDD VSS sg13g2_decap_8
XFILLER_4_140 VDD VSS sg13g2_decap_8
XFILLER_141_303 VDD VSS sg13g2_decap_4
XFILLER_142_837 VDD VSS sg13g2_decap_8
XFILLER_153_163 VDD VSS sg13g2_decap_8
XFILLER_99_217 VDD VSS sg13g2_decap_8
X_15065_ _15065_/Q _15165_/CLK _15065_/D _15065_/RESET_B VDD VSS sg13g2_dfrbpq_1
X_12277_ _12277_/X _12278_/A _13663_/Q VDD VSS sg13g2_and2_1
X_14016_ _14016_/Q _14528_/CLK _14016_/D _14016_/RESET_B VDD VSS sg13g2_dfrbpq_1
X_11228_ _11228_/X _14683_/Q _14715_/Q _13755_/Q _13787_/Q _11218_/S _11228_/S1 VDD
+ VSS sg13g2_mux4_1
XFILLER_49_1082 VDD VSS sg13g2_fill_1
XFILLER_49_1093 VDD VSS sg13g2_decap_8
XFILLER_4_77 VDD VSS sg13g2_decap_8
XFILLER_68_615 VDD VSS sg13g2_fill_1
XFILLER_136_1085 VDD VSS sg13g2_decap_8
X_11159_ _11159_/Y _11171_/B _11180_/C _11173_/C VDD VSS sg13g2_a21oi_1
XFILLER_95_456 VDD VSS sg13g2_decap_8
XFILLER_62_1271 VDD VSS sg13g2_decap_8
XFILLER_110_767 VDD VSS sg13g2_decap_4
XFILLER_7_1463 VDD VSS sg13g2_decap_8
XFILLER_110_778 VDD VSS sg13g2_fill_2
XFILLER_83_618 VDD VSS sg13g2_decap_8
XFILLER_23_1255 VDD VSS sg13g2_decap_8
XFILLER_3_1327 VDD VSS sg13g2_decap_8
XFILLER_110_1225 VDD VSS sg13g2_decap_8
XFILLER_82_128 VDD VSS sg13g2_fill_2
XFILLER_48_372 VDD VSS sg13g2_fill_1
XFILLER_149_1402 VDD VSS sg13g2_decap_4
X_14918_ _14918_/Q clkload71/A _14918_/D _14918_/RESET_B VDD VSS sg13g2_dfrbpq_1
XFILLER_97_1356 VDD VSS sg13g2_decap_8
XFILLER_110_1269 VDD VSS sg13g2_fill_1
XFILLER_36_567 VDD VSS sg13g2_decap_8
XFILLER_58_1329 VDD VSS sg13g2_decap_8
X_14849_ _14849_/Q clkload84/A _14849_/D _14849_/RESET_B VDD VSS sg13g2_dfrbpq_1
XFILLER_64_898 VDD VSS sg13g2_decap_4
XFILLER_184_1359 VDD VSS sg13g2_decap_8
XFILLER_23_217 VDD VSS sg13g2_decap_8
X_08370_ _08370_/Y _08369_/B _08367_/Y _08389_/B VDD VSS sg13g2_o21ai_1
XFILLER_90_183 VDD VSS sg13g2_decap_8
XFILLER_95_1080 VDD VSS sg13g2_decap_8
XFILLER_177_712 VDD VSS sg13g2_decap_8
XFILLER_17_1004 VDD VSS sg13g2_decap_8
XFILLER_108_1132 VDD VSS sg13g2_decap_8
XFILLER_182_1061 VDD VSS sg13g2_decap_8
XFILLER_149_436 VDD VSS sg13g2_decap_8
XFILLER_32_784 VDD VSS sg13g2_decap_8
XFILLER_165_907 VDD VSS sg13g2_decap_8
XFILLER_176_255 VDD VSS sg13g2_fill_2
XFILLER_20_957 VDD VSS sg13g2_decap_8
XFILLER_20_968 VDD VSS sg13g2_fill_1
XFILLER_34_1362 VDD VSS sg13g2_decap_8
XFILLER_158_981 VDD VSS sg13g2_decap_8
XFILLER_160_1381 VDD VSS sg13g2_decap_8
XFILLER_9_980 VDD VSS sg13g2_decap_8
XFILLER_118_834 VDD VSS sg13g2_decap_8
XFILLER_145_620 VDD VSS sg13g2_decap_8
XFILLER_157_480 VDD VSS sg13g2_decap_8
XFILLER_30_1237 VDD VSS sg13g2_decap_8
XFILLER_157_491 VDD VSS sg13g2_fill_2
X_14549__1653 _14549_/RESET_B VDD VSS sg13g2_tiehi
XFILLER_117_333 VDD VSS sg13g2_decap_8
XFILLER_117_355 VDD VSS sg13g2_fill_1
XFILLER_117_366 VDD VSS sg13g2_decap_8
XFILLER_145_675 VDD VSS sg13g2_decap_8
XFILLER_156_1406 VDD VSS sg13g2_decap_8
Xclkbuf_leaf_132_clk_i clkload7/A clkbuf_leaf_2_clk_i/A VDD VSS sg13g2_buf_8
XFILLER_69_1458 VDD VSS sg13g2_decap_8
XFILLER_160_612 VDD VSS sg13g2_decap_8
XFILLER_173_995 VDD VSS sg13g2_fill_1
XFILLER_105_539 VDD VSS sg13g2_decap_8
XFILLER_172_494 VDD VSS sg13g2_decap_8
XFILLER_132_336 VDD VSS sg13g2_fill_1
XFILLER_67_1171 VDD VSS sg13g2_decap_8
XFILLER_132_369 VDD VSS sg13g2_decap_8
Xfanout403 _09875_/A0 _10073_/A0 VDD VSS sg13g2_buf_1
XFILLER_28_1133 VDD VSS sg13g2_decap_8
Xfanout414 _12624_/B2 _12777_/B2 VDD VSS sg13g2_buf_1
XFILLER_98_250 VDD VSS sg13g2_decap_8
XFILLER_87_913 VDD VSS sg13g2_decap_8
XFILLER_115_1103 VDD VSS sg13g2_fill_1
Xfanout425 _10134_/S _10136_/S VDD VSS sg13g2_buf_1
XFILLER_99_784 VDD VSS sg13g2_decap_8
Xfanout436 _10002_/S fanout438/X VDD VSS sg13g2_buf_1
XFILLER_48_28 VDD VSS sg13g2_decap_8
Xfanout447 _09789_/S _09793_/S VDD VSS sg13g2_buf_1
X_09824_ _14412_/D _09923_/A1 _14412_/Q _09826_/S VDD VSS sg13g2_mux2_1
XFILLER_150_1016 VDD VSS sg13g2_decap_8
Xfanout458 _09566_/S _09556_/S VDD VSS sg13g2_buf_1
Xfanout469 _09463_/S _09467_/S VDD VSS sg13g2_buf_1
XFILLER_59_659 VDD VSS sg13g2_decap_8
XFILLER_58_136 VDD VSS sg13g2_fill_2
XFILLER_101_778 VDD VSS sg13g2_fill_2
X_09755_ _14345_/D _14345_/Q _09755_/A1 _09766_/S VDD VSS sg13g2_mux2_1
XFILLER_86_478 VDD VSS sg13g2_decap_4
XFILLER_58_169 VDD VSS sg13g2_decap_4
XFILLER_41_1355 VDD VSS sg13g2_decap_8
XFILLER_104_56 VDD VSS sg13g2_decap_8
XFILLER_100_299 VDD VSS sg13g2_decap_8
X_08706_ _13658_/D _15185_/D _15116_/Q _13651_/S VDD VSS sg13g2_mux2_1
X_09686_ _14278_/D _09686_/A0 _14278_/Q _09692_/S VDD VSS sg13g2_mux2_1
XFILLER_27_545 VDD VSS sg13g2_fill_1
Xclkbuf_4_9_0_clk_i clkbuf_4_9_0_clk_i/X clkbuf_0_clk_i/X VDD VSS sg13g2_buf_8
XFILLER_27_556 VDD VSS sg13g2_fill_2
XFILLER_15_707 VDD VSS sg13g2_decap_8
X_08637_ _08640_/D _08637_/A _08637_/B VDD VSS sg13g2_nand2_1
XFILLER_82_662 VDD VSS sg13g2_decap_4
XFILLER_76_1429 VDD VSS sg13g2_decap_8
XFILLER_54_353 VDD VSS sg13g2_decap_4
XFILLER_161_7 VDD VSS sg13g2_decap_8
XFILLER_54_375 VDD VSS sg13g2_decap_4
XFILLER_120_22 VDD VSS sg13g2_fill_2
XFILLER_74_1120 VDD VSS sg13g2_fill_2
XFILLER_54_397 VDD VSS sg13g2_decap_8
XFILLER_120_33 VDD VSS sg13g2_decap_8
X_08568_ _08568_/Y _15012_/Q _08591_/A2 _15011_/Q _11983_/A VDD VSS sg13g2_a22oi_1
XFILLER_161_1101 VDD VSS sg13g2_decap_8
XFILLER_39_1273 VDD VSS sg13g2_decap_8
XFILLER_126_1232 VDD VSS sg13g2_decap_4
X_08499_ _08499_/Y _08527_/B _08498_/Y _08499_/B1 VDD VSS sg13g2_o21ai_1
XFILLER_126_1254 VDD VSS sg13g2_fill_1
XFILLER_11_946 VDD VSS sg13g2_decap_8
XFILLER_122_1107 VDD VSS sg13g2_decap_4
XFILLER_161_1156 VDD VSS sg13g2_decap_8
X_10530_ _10532_/C _13218_/A _10543_/C _14859_/Q VDD VSS sg13g2_a21o_1
XFILLER_128_609 VDD VSS sg13g2_decap_8
XFILLER_10_434 VDD VSS sg13g2_decap_8
XFILLER_156_929 VDD VSS sg13g2_decap_8
XFILLER_7_917 VDD VSS sg13g2_decap_8
XFILLER_167_266 VDD VSS sg13g2_fill_1
XFILLER_13_53 VDD VSS sg13g2_decap_8
XFILLER_182_214 VDD VSS sg13g2_decap_8
XFILLER_52_1473 VDD VSS sg13g2_fill_2
XFILLER_109_834 VDD VSS sg13g2_fill_1
XFILLER_167_299 VDD VSS sg13g2_decap_8
X_10461_ _10502_/A _10471_/C _14842_/Q _14841_/Q VDD VSS sg13g2_nand3_1
XFILLER_129_53 VDD VSS sg13g2_decap_8
XFILLER_13_1446 VDD VSS sg13g2_decap_8
XFILLER_6_438 VDD VSS sg13g2_decap_8
X_12200_ _12200_/X _12200_/A _12200_/B VDD VSS sg13g2_or2_1
XFILLER_129_75 VDD VSS sg13g2_decap_8
X_13180_ _13180_/Y _14823_/Q _13068_/B _13219_/B1 _14887_/Q _13219_/C1 VDD VSS sg13g2_a221oi_1
XFILLER_135_141 VDD VSS sg13g2_decap_8
X_10392_ _14821_/D _10392_/A _10544_/C _10392_/C VDD VSS sg13g2_and3_1
XFILLER_11_1170 VDD VSS sg13g2_decap_8
XFILLER_159_1063 VDD VSS sg13g2_decap_8
X_12131_ _12155_/B _12198_/B _12132_/B VDD VSS sg13g2_nand2b_1
XFILLER_108_399 VDD VSS sg13g2_fill_2
XFILLER_123_347 VDD VSS sg13g2_fill_1
XFILLER_85_1260 VDD VSS sg13g2_decap_8
XFILLER_46_1211 VDD VSS sg13g2_decap_8
XFILLER_2_644 VDD VSS sg13g2_decap_8
XFILLER_111_509 VDD VSS sg13g2_decap_8
XFILLER_150_144 VDD VSS sg13g2_decap_4
X_12062_ _12065_/A _12062_/A _12062_/B _12197_/A VDD VSS sg13g2_nand3_1
XFILLER_1_154 VDD VSS sg13g2_decap_8
XFILLER_81_1124 VDD VSS sg13g2_decap_8
XFILLER_137_1372 VDD VSS sg13g2_decap_8
XFILLER_78_935 VDD VSS sg13g2_decap_4
XFILLER_172_1263 VDD VSS sg13g2_decap_8
X_11013_ _11022_/B _11012_/B _11012_/C _11064_/A VDD VSS sg13g2_o21ai_1
XFILLER_104_594 VDD VSS sg13g2_decap_8
X_16870_ _16870_/X _16870_/A VDD VSS sg13g2_buf_1
XFILLER_89_294 VDD VSS sg13g2_fill_1
XFILLER_46_1288 VDD VSS sg13g2_decap_8
XFILLER_131_391 VDD VSS sg13g2_fill_2
Xfanout970 _13028_/B _13249_/B VDD VSS sg13g2_buf_1
XFILLER_49_147 VDD VSS sg13g2_decap_4
Xfanout981 _13068_/B _13219_/A2 VDD VSS sg13g2_buf_1
XFILLER_93_927 VDD VSS sg13g2_decap_8
XFILLER_65_618 VDD VSS sg13g2_decap_8
Xfanout992 _07649_/A _13279_/B VDD VSS sg13g2_buf_1
XFILLER_92_426 VDD VSS sg13g2_fill_1
XFILLER_20_1417 VDD VSS sg13g2_decap_8
XFILLER_79_1020 VDD VSS sg13g2_decap_8
XFILLER_18_534 VDD VSS sg13g2_decap_8
X_12964_ _12964_/Y _14809_/Q _13029_/A2 _12976_/B _14841_/Q _13069_/C1 VDD VSS sg13g2_a221oi_1
XFILLER_57_180 VDD VSS sg13g2_decap_8
XFILLER_161_84 VDD VSS sg13g2_decap_8
X_14703_ _14703_/Q clkload35/A _14703_/D _14703_/RESET_B VDD VSS sg13g2_dfrbpq_1
XFILLER_46_876 VDD VSS sg13g2_decap_8
XFILLER_45_353 VDD VSS sg13g2_decap_8
X_11915_ _12055_/A _11915_/A VDD VSS sg13g2_inv_1
XFILLER_45_364 VDD VSS sg13g2_fill_1
XFILLER_166_1034 VDD VSS sg13g2_decap_8
X_12895_ _12895_/Y _12895_/A _12895_/B VDD VSS sg13g2_nand2_1
XFILLER_79_1086 VDD VSS sg13g2_decap_4
X_14627__1575 _14627_/RESET_B VDD VSS sg13g2_tiehi
XFILLER_2_1393 VDD VSS sg13g2_decap_8
X_14634_ _14634_/Q clkload19/A _14634_/D _14634_/RESET_B VDD VSS sg13g2_dfrbpq_1
XFILLER_127_1029 VDD VSS sg13g2_decap_8
X_11846_ _11846_/Y _11846_/A _11867_/B VDD VSS sg13g2_nand2_1
XFILLER_92_1231 VDD VSS sg13g2_decap_8
XFILLER_144_1310 VDD VSS sg13g2_fill_1
XFILLER_57_1373 VDD VSS sg13g2_decap_8
XFILLER_144_1343 VDD VSS sg13g2_fill_1
X_14565_ _14565_/Q _14725_/CLK _14565_/D _14565_/RESET_B VDD VSS sg13g2_dfrbpq_1
X_11777_ _11778_/B _11777_/A _11777_/B _11777_/C VDD VSS sg13g2_nor3_1
XFILLER_14_784 VDD VSS sg13g2_decap_8
XFILLER_18_1357 VDD VSS sg13g2_decap_8
XFILLER_53_1237 VDD VSS sg13g2_decap_8
XFILLER_14_795 VDD VSS sg13g2_fill_2
XFILLER_9_210 VDD VSS sg13g2_decap_8
XFILLER_144_1376 VDD VSS sg13g2_decap_8
XFILLER_186_553 VDD VSS sg13g2_decap_8
X_13516_ _15139_/D _15139_/Q _14996_/Q _13565_/S VDD VSS sg13g2_mux2_1
X_10728_ _14909_/D _10985_/B1 _10995_/A _10727_/Y VDD VSS sg13g2_o21ai_1
XFILLER_144_1387 VDD VSS sg13g2_fill_1
X_14496_ _14496_/Q clkload25/A _14496_/D _14496_/RESET_B VDD VSS sg13g2_dfrbpq_1
XFILLER_179_1428 VDD VSS sg13g2_decap_8
XFILLER_127_620 VDD VSS sg13g2_decap_8
X_13447_ _13459_/D _15193_/Q _15194_/Q _15195_/Q _15197_/Q VDD VSS sg13g2_nor4_1
X_10659_ _10661_/B _14891_/Q _10663_/D _14892_/Q VDD VSS sg13g2_a21oi_1
XFILLER_9_287 VDD VSS sg13g2_decap_8
XFILLER_16_1092 VDD VSS sg13g2_decap_8
XFILLER_174_759 VDD VSS sg13g2_decap_4
Xclkload13 clkload13/X clkload13/A VDD VSS sg13g2_buf_8
XFILLER_186_70 VDD VSS sg13g2_decap_8
Xclkload24 clkload24/Y clkload24/A VDD VSS sg13g2_inv_2
Xclkload35 clkload35/X clkload35/A VDD VSS sg13g2_buf_8
XFILLER_86_1002 VDD VSS sg13g2_decap_8
Xclkload46 clkload46/X clkload46/A VDD VSS sg13g2_buf_8
X_13378_ _13378_/Y _13429_/A _13494_/B _13378_/C VDD VSS sg13g2_nor3_1
Xclkload57 clkload57/Y clkload57/A VDD VSS sg13g2_inv_4
Xclkload68 clkload68/X clkload68/A VDD VSS sg13g2_buf_8
XFILLER_55_4 VDD VSS sg13g2_decap_8
XFILLER_177_1163 VDD VSS sg13g2_decap_8
Xclkload79 clkload79/Y clkload79/A VDD VSS sg13g2_inv_2
X_15117_ _15117_/Q clkload63/A _15117_/D _15117_/RESET_B VDD VSS sg13g2_dfrbpq_1
XFILLER_181_280 VDD VSS sg13g2_decap_8
X_12329_ _12329_/Y _12325_/Y _12326_/Y _12328_/Y _12327_/Y _12324_/B VDD VSS sg13g2_a221oi_1
XFILLER_86_1068 VDD VSS sg13g2_decap_4
XFILLER_114_347 VDD VSS sg13g2_decap_8
XFILLER_173_1027 VDD VSS sg13g2_fill_1
XFILLER_173_1038 VDD VSS sg13g2_fill_1
X_15048_ _15048_/Q clkload74/A _15048_/D _15048_/RESET_B VDD VSS sg13g2_dfrbpq_1
Xclkbuf_leaf_64_clk_i clkload80/A clkbuf_leaf_64_clk_i/A VDD VSS sg13g2_buf_8
XFILLER_64_1344 VDD VSS sg13g2_decap_8
XFILLER_29_1464 VDD VSS sg13g2_decap_8
XFILLER_25_1306 VDD VSS sg13g2_decap_8
X_07870_ _08188_/A _07912_/B _08174_/A VDD VSS sg13g2_and2_1
XFILLER_151_1347 VDD VSS sg13g2_decap_8
XFILLER_28_309 VDD VSS sg13g2_decap_4
XFILLER_7_1260 VDD VSS sg13g2_decap_8
XFILLER_83_415 VDD VSS sg13g2_fill_1
XFILLER_62_1090 VDD VSS sg13g2_decap_8
XFILLER_23_1052 VDD VSS sg13g2_decap_8
Xclkbuf_leaf_79_clk_i _15203_/CLK clkbuf_leaf_80_clk_i/A VDD VSS sg13g2_buf_8
X_09540_ _09540_/Y _10070_/A _10004_/B _10004_/C _09606_/C VDD VSS sg13g2_nand4_1
XFILLER_3_1124 VDD VSS sg13g2_decap_8
XFILLER_23_1063 VDD VSS sg13g2_fill_1
XFILLER_114_1191 VDD VSS sg13g2_fill_1
XFILLER_23_1074 VDD VSS sg13g2_fill_2
XFILLER_83_459 VDD VSS sg13g2_fill_1
XFILLER_36_342 VDD VSS sg13g2_decap_4
X_09471_ _14072_/D _09737_/A0 _14072_/Q _09471_/S VDD VSS sg13g2_mux2_1
XFILLER_149_1243 VDD VSS sg13g2_decap_8
XFILLER_70_109 VDD VSS sg13g2_decap_4
XFILLER_64_684 VDD VSS sg13g2_decap_8
XFILLER_110_1088 VDD VSS sg13g2_decap_8
X_08422_ _08423_/B _08434_/B _08421_/Y _08422_/S VDD VSS sg13g2_mux2_1
XFILLER_24_537 VDD VSS sg13g2_decap_8
XFILLER_184_1156 VDD VSS sg13g2_decap_8
XFILLER_75_1440 VDD VSS sg13g2_decap_8
X_08353_ _08354_/B _08353_/A _08353_/B VDD VSS sg13g2_nand2_1
XFILLER_36_1446 VDD VSS sg13g2_decap_8
X_13721__2481 _13721_/RESET_B VDD VSS sg13g2_tiehi
XFILLER_138_907 VDD VSS sg13g2_decap_8
XFILLER_162_1465 VDD VSS sg13g2_decap_4
XFILLER_71_1348 VDD VSS sg13g2_decap_8
X_08284_ _08293_/B _08270_/Y _08271_/Y _08273_/Y _08334_/A1 _08283_/Y VDD VSS sg13g2_a221oi_1
XFILLER_137_406 VDD VSS sg13g2_fill_1
XFILLER_20_754 VDD VSS sg13g2_decap_8
Xclkload7 clkload7/Y clkload7/A VDD VSS sg13g2_inv_8
XFILLER_50_18 VDD VSS sg13g2_decap_8
Xclkbuf_leaf_17_clk_i clkload22/A clkbuf_5_6__f_clk_i/X VDD VSS sg13g2_buf_8
XFILLER_121_1140 VDD VSS sg13g2_fill_2
XFILLER_118_642 VDD VSS sg13g2_decap_8
XFILLER_146_962 VDD VSS sg13g2_decap_8
X_14065__2137 _14065_/RESET_B VDD VSS sg13g2_tiehi
XFILLER_106_804 VDD VSS sg13g2_fill_2
XFILLER_146_973 VDD VSS sg13g2_fill_2
XFILLER_69_1255 VDD VSS sg13g2_decap_8
XFILLER_161_943 VDD VSS sg13g2_decap_8
XFILLER_105_336 VDD VSS sg13g2_decap_8
XFILLER_160_420 VDD VSS sg13g2_decap_8
XFILLER_82_1400 VDD VSS sg13g2_decap_8
XFILLER_161_976 VDD VSS sg13g2_fill_2
XFILLER_133_678 VDD VSS sg13g2_decap_4
XFILLER_78_209 VDD VSS sg13g2_decap_8
Xfanout200 _10159_/A1 _09098_/Y VDD VSS sg13g2_buf_1
XFILLER_132_166 VDD VSS sg13g2_decap_8
XFILLER_160_475 VDD VSS sg13g2_fill_1
XFILLER_182_39 VDD VSS sg13g2_decap_8
X_15004__2606 _15004_/RESET_B VDD VSS sg13g2_tiehi
XFILLER_99_570 VDD VSS sg13g2_decap_8
X_14705__1497 _14705_/RESET_B VDD VSS sg13g2_tiehi
Xfanout211 _09726_/A0 _09076_/Y VDD VSS sg13g2_buf_1
Xfanout1209 _13088_/A _14912_/Q VDD VSS sg13g2_buf_1
XFILLER_87_721 VDD VSS sg13g2_decap_4
XFILLER_114_892 VDD VSS sg13g2_decap_8
XFILLER_120_328 VDD VSS sg13g2_decap_8
Xfanout222 _09922_/A1 _09590_/A1 VDD VSS sg13g2_buf_1
XFILLER_43_1406 VDD VSS sg13g2_decap_8
Xfanout233 _09755_/A1 fanout234/X VDD VSS sg13g2_buf_1
Xfanout244 _12298_/B _11724_/B VDD VSS sg13g2_buf_1
XFILLER_86_220 VDD VSS sg13g2_decap_8
Xfanout255 _09654_/A0 _09037_/X VDD VSS sg13g2_buf_1
XFILLER_59_456 VDD VSS sg13g2_decap_8
XFILLER_101_553 VDD VSS sg13g2_fill_1
Xfanout266 fanout266/X _10037_/Y VDD VSS sg13g2_buf_1
XFILLER_8_1068 VDD VSS sg13g2_decap_8
Xfanout277 _09605_/S _09593_/S VDD VSS sg13g2_buf_1
X_09807_ _14395_/D _09906_/A1 _14395_/Q _09838_/S VDD VSS sg13g2_mux2_1
XFILLER_115_77 VDD VSS sg13g2_decap_8
Xfanout288 _09916_/A1 fanout289/X VDD VSS sg13g2_buf_1
XFILLER_101_575 VDD VSS sg13g2_decap_4
Xfanout299 _09942_/A1 _10074_/A0 VDD VSS sg13g2_buf_1
X_07999_ _08001_/D _15097_/Q _15092_/Q _15131_/Q _08027_/B VDD VSS sg13g2_nor4_1
XFILLER_28_810 VDD VSS sg13g2_fill_1
XFILLER_74_426 VDD VSS sg13g2_decap_8
XFILLER_68_990 VDD VSS sg13g2_decap_8
XFILLER_41_1152 VDD VSS sg13g2_decap_8
X_09738_ _14329_/D _09903_/A0 _14329_/Q _09738_/S VDD VSS sg13g2_mux2_1
XFILLER_28_876 VDD VSS sg13g2_decap_8
XFILLER_167_1332 VDD VSS sg13g2_decap_8
XFILLER_55_673 VDD VSS sg13g2_decap_8
X_09669_ _14262_/D _10165_/A1 _14262_/Q _09673_/S VDD VSS sg13g2_mux2_1
XFILLER_76_1226 VDD VSS sg13g2_decap_8
XFILLER_54_150 VDD VSS sg13g2_decap_8
XFILLER_128_1305 VDD VSS sg13g2_fill_1
XFILLER_82_470 VDD VSS sg13g2_decap_8
XFILLER_42_312 VDD VSS sg13g2_decap_4
X_11700_ _11700_/X _14907_/Q _11792_/B _11699_/Y VDD VSS sg13g2_a21o_1
XFILLER_91_25 VDD VSS sg13g2_decap_8
XFILLER_54_183 VDD VSS sg13g2_fill_2
X_12680_ _15012_/D _12680_/A _12680_/B VDD VSS sg13g2_nor2_1
X_14854__2859 _14854_/RESET_B VDD VSS sg13g2_tiehi
X_11631_ _11632_/B _11593_/Y _11631_/A2 _11630_/Y VDD VSS sg13g2_a21oi_1
XFILLER_30_507 VDD VSS sg13g2_decap_8
X_14275__1927 _14275_/RESET_B VDD VSS sg13g2_tiehi
XFILLER_126_1040 VDD VSS sg13g2_decap_8
XFILLER_11_732 VDD VSS sg13g2_decap_8
X_14311__1891 _14311_/RESET_B VDD VSS sg13g2_tiehi
X_14350_ _14350_/Q _14510_/CLK _14350_/D _14350_/RESET_B VDD VSS sg13g2_dfrbpq_1
X_11562_ _11562_/Y _11560_/Y _11561_/Y _11903_/C1 VDD VSS sg13g2_a21oi_1
XFILLER_10_231 VDD VSS sg13g2_decap_8
XFILLER_183_501 VDD VSS sg13g2_decap_8
XFILLER_7_714 VDD VSS sg13g2_decap_8
XFILLER_11_776 VDD VSS sg13g2_decap_8
X_13301_ _13302_/B _07744_/C _13300_/Y _08969_/C VDD VSS sg13g2_o21ai_1
X_10513_ _10514_/C _14854_/Q _14853_/Q _14852_/Q _10513_/D VDD VSS sg13g2_and4_1
XFILLER_156_748 VDD VSS sg13g2_decap_8
X_14281_ _14281_/Q clkload28/A _14281_/D _14281_/RESET_B VDD VSS sg13g2_dfrbpq_1
XFILLER_52_1270 VDD VSS sg13g2_decap_8
X_11493_ _11493_/X _13954_/Q _13986_/Q _14018_/Q _14050_/Q _11493_/S0 _07654_/A VDD
+ VSS sg13g2_mux4_1
XFILLER_137_940 VDD VSS sg13g2_fill_2
XFILLER_13_1243 VDD VSS sg13g2_decap_8
XFILLER_109_642 VDD VSS sg13g2_decap_8
XFILLER_183_556 VDD VSS sg13g2_decap_8
XFILLER_6_235 VDD VSS sg13g2_decap_8
XFILLER_109_653 VDD VSS sg13g2_fill_1
X_13232_ _13232_/Y _13232_/A _13244_/B VDD VSS sg13g2_xnor2_1
X_10444_ _14837_/D _10444_/A _10444_/B _10444_/C VDD VSS sg13g2_and3_1
XFILLER_108_141 VDD VSS sg13g2_decap_8
XFILLER_139_1401 VDD VSS sg13g2_decap_8
XFILLER_170_206 VDD VSS sg13g2_decap_8
X_14490__1712 _14490_/RESET_B VDD VSS sg13g2_tiehi
XFILLER_152_932 VDD VSS sg13g2_decap_8
XFILLER_170_239 VDD VSS sg13g2_fill_1
X_13163_ _13163_/Y _14822_/Q _13206_/B _13248_/B VDD VSS sg13g2_a21oi_1
XFILLER_108_185 VDD VSS sg13g2_fill_1
X_14938__2691 _14938_/RESET_B VDD VSS sg13g2_tiehi
X_10375_ _14816_/D _10375_/A _10375_/B _10630_/C VDD VSS sg13g2_and3_1
XFILLER_87_1377 VDD VSS sg13g2_decap_8
XFILLER_48_1328 VDD VSS sg13g2_decap_8
XFILLER_3_942 VDD VSS sg13g2_decap_8
XFILLER_124_656 VDD VSS sg13g2_decap_8
XFILLER_151_442 VDD VSS sg13g2_fill_2
XFILLER_174_1336 VDD VSS sg13g2_decap_8
X_12114_ _12114_/X _14708_/Q _14740_/Q _13780_/Q _13812_/Q _12087_/S _12114_/S1 VDD
+ VSS sg13g2_mux4_1
XFILLER_2_441 VDD VSS sg13g2_decap_8
X_13094_ _13094_/Y _14817_/Q _13219_/A2 _13273_/B _14849_/Q VDD VSS sg13g2_a22oi_1
XFILLER_123_188 VDD VSS sg13g2_fill_2
X_12045_ _12046_/B _12034_/Y _12036_/X _12142_/S1 VDD VSS sg13g2_o21ai_1
XFILLER_172_1060 VDD VSS sg13g2_fill_2
XFILLER_104_391 VDD VSS sg13g2_decap_8
XFILLER_120_862 VDD VSS sg13g2_decap_4
X_13763__2439 _13763_/RESET_B VDD VSS sg13g2_tiehi
XFILLER_133_1055 VDD VSS sg13g2_fill_1
XFILLER_78_787 VDD VSS sg13g2_decap_8
XFILLER_65_404 VDD VSS sg13g2_decap_8
XFILLER_4_1400 VDD VSS sg13g2_decap_8
XFILLER_65_415 VDD VSS sg13g2_fill_1
XFILLER_77_275 VDD VSS sg13g2_decap_8
XFILLER_24_1361 VDD VSS sg13g2_decap_8
XFILLER_1_56 VDD VSS sg13g2_decap_8
XFILLER_20_1214 VDD VSS sg13g2_decap_8
X_13996_ _13996_/Q clkload50/A _13996_/D _13996_/RESET_B VDD VSS sg13g2_dfrbpq_1
XFILLER_92_245 VDD VSS sg13g2_decap_8
XFILLER_4_1477 VDD VSS sg13g2_fill_2
XFILLER_94_1304 VDD VSS sg13g2_decap_8
XFILLER_74_971 VDD VSS sg13g2_decap_8
XFILLER_185_1432 VDD VSS sg13g2_decap_8
X_12947_ _12947_/Y _14872_/Q _12947_/B VDD VSS sg13g2_nand2_1
X_15116__2750 _15116_/RESET_B VDD VSS sg13g2_tiehi
XFILLER_61_621 VDD VSS sg13g2_decap_8
XFILLER_59_1457 VDD VSS sg13g2_decap_8
XFILLER_46_695 VDD VSS sg13g2_fill_2
XFILLER_18_397 VDD VSS sg13g2_decap_8
X_14143__2059 _14143_/RESET_B VDD VSS sg13g2_tiehi
XFILLER_34_857 VDD VSS sg13g2_fill_1
XFILLER_2_1190 VDD VSS sg13g2_decap_8
XFILLER_146_1438 VDD VSS sg13g2_decap_8
X_12878_ _12878_/Y _12878_/A _12878_/B _12878_/C _12878_/D VDD VSS sg13g2_nand4_1
XFILLER_33_356 VDD VSS sg13g2_decap_4
X_14617_ _14617_/Q clkload44/A _14617_/D _14617_/RESET_B VDD VSS sg13g2_dfrbpq_1
XFILLER_61_687 VDD VSS sg13g2_fill_2
XFILLER_57_1170 VDD VSS sg13g2_decap_8
X_11829_ _11829_/X _11829_/A1 _11828_/X _11827_/Y VDD VSS sg13g2_a21o_1
XFILLER_92_1061 VDD VSS sg13g2_fill_1
XFILLER_14_570 VDD VSS sg13g2_decap_8
XFILLER_60_175 VDD VSS sg13g2_decap_8
XFILLER_109_1271 VDD VSS sg13g2_decap_8
XFILLER_18_1154 VDD VSS sg13g2_decap_8
XFILLER_60_197 VDD VSS sg13g2_decap_8
XFILLER_53_1045 VDD VSS sg13g2_fill_2
XFILLER_144_1173 VDD VSS sg13g2_decap_4
XFILLER_186_350 VDD VSS sg13g2_decap_8
X_14548_ _14548_/Q _15005_/CLK _14548_/D _14548_/RESET_B VDD VSS sg13g2_dfrbpq_1
XFILLER_109_1293 VDD VSS sg13g2_fill_2
XFILLER_147_715 VDD VSS sg13g2_fill_2
XFILLER_119_428 VDD VSS sg13g2_decap_8
XFILLER_140_1026 VDD VSS sg13g2_fill_1
XFILLER_147_737 VDD VSS sg13g2_decap_8
XFILLER_31_1321 VDD VSS sg13g2_decap_8
XFILLER_179_1225 VDD VSS sg13g2_decap_8
X_14479_ _14479_/Q clkload35/A _14479_/D _14479_/RESET_B VDD VSS sg13g2_dfrbpq_1
XFILLER_70_1392 VDD VSS sg13g2_decap_8
XFILLER_146_258 VDD VSS sg13g2_fill_2
XFILLER_128_973 VDD VSS sg13g2_decap_4
XFILLER_31_1398 VDD VSS sg13g2_decap_8
XFILLER_143_932 VDD VSS sg13g2_decap_8
XFILLER_114_111 VDD VSS sg13g2_fill_1
XFILLER_127_494 VDD VSS sg13g2_decap_8
XFILLER_66_1417 VDD VSS sg13g2_decap_8
XFILLER_114_122 VDD VSS sg13g2_decap_8
XFILLER_142_442 VDD VSS sg13g2_decap_8
XFILLER_143_976 VDD VSS sg13g2_decap_4
XFILLER_46_0 VDD VSS sg13g2_decap_8
X_08971_ _08971_/X _15022_/Q _15219_/Q _08991_/S VDD VSS sg13g2_mux2_1
XFILLER_9_1311 VDD VSS sg13g2_decap_8
XFILLER_29_1261 VDD VSS sg13g2_decap_8
XFILLER_69_732 VDD VSS sg13g2_decap_8
XFILLER_116_1220 VDD VSS sg13g2_fill_2
X_07922_ _07922_/Y _07905_/A _07920_/Y _07910_/Y VDD VSS sg13g2_o21ai_1
XFILLER_151_1144 VDD VSS sg13g2_decap_8
XFILLER_84_702 VDD VSS sg13g2_decap_8
XFILLER_60_1027 VDD VSS sg13g2_decap_8
XFILLER_29_607 VDD VSS sg13g2_decap_8
XFILLER_112_1106 VDD VSS sg13g2_fill_2
XFILLER_151_1155 VDD VSS sg13g2_fill_1
X_07853_ _07855_/B _15015_/Q _07853_/B VDD VSS sg13g2_and2_1
XFILLER_9_1388 VDD VSS sg13g2_decap_8
XFILLER_29_618 VDD VSS sg13g2_fill_1
X_14353__1849 _14353_/RESET_B VDD VSS sg13g2_tiehi
XFILLER_29_629 VDD VSS sg13g2_decap_4
X_13739__2463 _13739_/RESET_B VDD VSS sg13g2_tiehi
XFILLER_99_1237 VDD VSS sg13g2_decap_8
XFILLER_42_1450 VDD VSS sg13g2_decap_8
XFILLER_110_383 VDD VSS sg13g2_fill_1
XFILLER_84_746 VDD VSS sg13g2_decap_8
X_07784_ _08414_/D _08411_/A _07784_/B VDD VSS sg13g2_or2_1
XFILLER_37_651 VDD VSS sg13g2_decap_4
X_09523_ _14122_/D _09921_/A1 _14122_/Q _09523_/S VDD VSS sg13g2_mux2_1
X_09454_ _14055_/D _10150_/A1 _14055_/Q _09463_/S VDD VSS sg13g2_mux2_1
XFILLER_52_643 VDD VSS sg13g2_fill_2
XFILLER_36_194 VDD VSS sg13g2_decap_8
X_14119__2083 _14119_/RESET_B VDD VSS sg13g2_tiehi
XFILLER_24_356 VDD VSS sg13g2_decap_8
XFILLER_101_46 VDD VSS sg13g2_decap_8
XFILLER_12_507 VDD VSS sg13g2_decap_8
X_08405_ _08406_/A _08383_/A _07782_/A _07946_/B _07790_/A _13510_/A1 _13550_/A1 VDD
+ VSS sg13g2_mux4_1
XFILLER_101_57 VDD VSS sg13g2_fill_1
X_09385_ _13988_/D _09583_/A1 _13988_/Q _09401_/S VDD VSS sg13g2_mux2_1
XFILLER_51_164 VDD VSS sg13g2_decap_8
XFILLER_61_28 VDD VSS sg13g2_decap_8
XFILLER_36_1243 VDD VSS sg13g2_decap_8
X_08336_ _08336_/Y _08356_/A1 _08169_/Y _08241_/Y VDD VSS sg13g2_o21ai_1
XFILLER_162_1262 VDD VSS sg13g2_decap_8
XFILLER_71_1145 VDD VSS sg13g2_decap_8
XFILLER_177_39 VDD VSS sg13g2_decap_8
XFILLER_20_562 VDD VSS sg13g2_decap_8
XFILLER_20_573 VDD VSS sg13g2_fill_2
X_08267_ _08268_/B _08266_/Y _08265_/X _08263_/Y _08264_/Y VDD VSS sg13g2_a22oi_1
XFILLER_124_7 VDD VSS sg13g2_decap_8
XFILLER_123_1279 VDD VSS sg13g2_decap_8
XFILLER_125_409 VDD VSS sg13g2_decap_8
X_08198_ _08198_/X _08086_/B _08094_/X _08198_/S VDD VSS sg13g2_mux2_1
XFILLER_146_781 VDD VSS sg13g2_decap_8
XFILLER_4_728 VDD VSS sg13g2_decap_8
XFILLER_10_1449 VDD VSS sg13g2_decap_8
XFILLER_10_21 VDD VSS sg13g2_decap_8
XFILLER_105_111 VDD VSS sg13g2_decap_8
XFILLER_133_420 VDD VSS sg13g2_decap_8
XFILLER_156_1033 VDD VSS sg13g2_fill_1
XFILLER_3_249 VDD VSS sg13g2_decap_8
XFILLER_134_976 VDD VSS sg13g2_decap_8
XFILLER_106_678 VDD VSS sg13g2_fill_2
XFILLER_133_464 VDD VSS sg13g2_decap_8
XFILLER_134_987 VDD VSS sg13g2_fill_1
X_10160_ _14737_/D _14737_/Q _10160_/A1 _10167_/S VDD VSS sg13g2_mux2_1
XFILLER_117_1017 VDD VSS sg13g2_fill_1
XFILLER_156_1066 VDD VSS sg13g2_decap_8
XFILLER_120_103 VDD VSS sg13g2_decap_8
XFILLER_161_795 VDD VSS sg13g2_decap_8
XFILLER_10_98 VDD VSS sg13g2_decap_8
Xfanout1006 _09938_/A _15067_/Q VDD VSS sg13g2_buf_1
XFILLER_86_14 VDD VSS sg13g2_decap_8
XFILLER_47_1361 VDD VSS sg13g2_decap_8
XFILLER_43_1203 VDD VSS sg13g2_decap_8
XFILLER_121_659 VDD VSS sg13g2_decap_8
XFILLER_156_1099 VDD VSS sg13g2_decap_8
Xfanout1017 _10697_/C _15060_/Q VDD VSS sg13g2_buf_1
X_10091_ _14671_/D _10125_/A0 _14671_/Q _10101_/S VDD VSS sg13g2_mux2_1
Xfanout1028 _10697_/B fanout1031/X VDD VSS sg13g2_buf_1
XFILLER_0_967 VDD VSS sg13g2_decap_8
Xfanout1039 _11241_/C _08832_/D VDD VSS sg13g2_buf_1
XFILLER_82_1274 VDD VSS sg13g2_decap_8
XFILLER_130_1217 VDD VSS sg13g2_fill_2
XFILLER_19_63 VDD VSS sg13g2_decap_8
X_14329__1873 _14329_/RESET_B VDD VSS sg13g2_tiehi
X_13850_ _13850_/Q _15052_/CLK _13850_/D _13850_/RESET_B VDD VSS sg13g2_dfrbpq_1
XFILLER_169_1427 VDD VSS sg13g2_decap_8
XFILLER_28_640 VDD VSS sg13g2_decap_8
XFILLER_142_75 VDD VSS sg13g2_fill_2
XFILLER_56_960 VDD VSS sg13g2_decap_8
X_12801_ _12801_/Y _13609_/A _12801_/B VDD VSS sg13g2_nor2_1
X_13781_ _13781_/Q clkload37/A _13781_/D _13781_/RESET_B VDD VSS sg13g2_dfrbpq_1
X_10993_ _10996_/B _10995_/A _10995_/C _10995_/B VDD VSS sg13g2_o21ai_1
XFILLER_15_301 VDD VSS sg13g2_decap_4
X_12732_ _12732_/X _12731_/X _12730_/X _12724_/X _12725_/X _12788_/S0 _12355_/S VDD
+ VSS sg13g2_mux4_1
XFILLER_71_963 VDD VSS sg13g2_decap_4
XFILLER_43_654 VDD VSS sg13g2_decap_8
XFILLER_70_440 VDD VSS sg13g2_fill_2
XFILLER_163_1037 VDD VSS sg13g2_fill_1
X_12663_ _12663_/X _12657_/X _12661_/X _12656_/X _12660_/X _12776_/S _12663_/S1 VDD
+ VSS sg13g2_mux4_1
XFILLER_93_1370 VDD VSS sg13g2_fill_2
XFILLER_54_1332 VDD VSS sg13g2_decap_8
XFILLER_145_1460 VDD VSS sg13g2_decap_8
X_14402_ _14402_/Q clkload5/A _14402_/D _14402_/RESET_B VDD VSS sg13g2_dfrbpq_1
XFILLER_42_197 VDD VSS sg13g2_decap_8
X_11614_ _11615_/A _14246_/Q _14278_/Q _14310_/Q _14342_/Q _11621_/S0 _11391_/B VDD
+ VSS sg13g2_mux4_1
XFILLER_30_359 VDD VSS sg13g2_decap_8
XFILLER_156_501 VDD VSS sg13g2_decap_8
XFILLER_15_1327 VDD VSS sg13g2_decap_8
X_12594_ _12594_/X _12590_/X _12589_/X _12586_/X _12585_/X _12594_/S0 _12511_/S VDD
+ VSS sg13g2_mux4_1
XFILLER_50_1218 VDD VSS sg13g2_decap_8
XFILLER_141_1346 VDD VSS sg13g2_decap_8
XFILLER_156_534 VDD VSS sg13g2_decap_4
X_14333_ _14333_/Q clkload28/A _14333_/D _14333_/RESET_B VDD VSS sg13g2_dfrbpq_1
XFILLER_7_511 VDD VSS sg13g2_decap_8
X_11545_ _11545_/Y _11531_/A _14468_/Q VDD VSS sg13g2_nand2b_1
XFILLER_184_854 VDD VSS sg13g2_decap_8
XFILLER_13_1040 VDD VSS sg13g2_decap_8
XFILLER_128_269 VDD VSS sg13g2_decap_8
X_14264_ _14264_/Q _14514_/CLK _14264_/D _14264_/RESET_B VDD VSS sg13g2_dfrbpq_1
X_11476_ _11476_/X _11473_/X _11472_/X _11468_/X _11469_/X _11971_/C _11956_/B1 VDD
+ VSS sg13g2_mux4_1
XFILLER_171_515 VDD VSS sg13g2_decap_8
XFILLER_183_375 VDD VSS sg13g2_decap_8
X_13817__2385 _13817_/RESET_B VDD VSS sg13g2_tiehi
X_15145__2690 _15145_/RESET_B VDD VSS sg13g2_tiehi
XFILLER_143_217 VDD VSS sg13g2_decap_8
XFILLER_7_588 VDD VSS sg13g2_decap_8
XFILLER_100_1043 VDD VSS sg13g2_decap_8
X_13215_ _13216_/B _13215_/A _13215_/B VDD VSS sg13g2_xnor2_1
X_10427_ _14831_/D _14831_/Q _10453_/C _10426_/Y VDD VSS sg13g2_a21oi_1
XFILLER_100_1054 VDD VSS sg13g2_decap_8
XFILLER_139_1220 VDD VSS sg13g2_fill_1
X_14195_ _14195_/Q clkload37/A _14195_/D _14195_/RESET_B VDD VSS sg13g2_dfrbpq_1
XFILLER_139_1242 VDD VSS sg13g2_fill_2
XFILLER_98_805 VDD VSS sg13g2_decap_8
XFILLER_48_1125 VDD VSS sg13g2_decap_8
XFILLER_174_1133 VDD VSS sg13g2_decap_8
X_13146_ _13148_/B _13146_/A _13146_/B _13146_/C VDD VSS sg13g2_nand3_1
X_10358_ _10400_/B _14809_/Q _14810_/Q _10358_/C VDD VSS sg13g2_nand3_1
XFILLER_125_998 VDD VSS sg13g2_fill_2
XFILLER_140_924 VDD VSS sg13g2_decap_4
XFILLER_111_103 VDD VSS sg13g2_decap_8
XFILLER_183_60 VDD VSS sg13g2_decap_8
XFILLER_98_849 VDD VSS sg13g2_fill_1
XFILLER_151_283 VDD VSS sg13g2_decap_8
X_13996__2206 _13996_/RESET_B VDD VSS sg13g2_tiehi
X_13077_ _13077_/X _14910_/Q _13677_/Q _13172_/B VDD VSS sg13g2_and3_1
XFILLER_152_1431 VDD VSS sg13g2_decap_8
X_10289_ _14790_/D _10281_/D _10298_/D _10284_/Y _10297_/A _10608_/B VDD VSS sg13g2_a221oi_1
X_13684__2527 _13684_/RESET_B VDD VSS sg13g2_tiehi
XFILLER_26_1445 VDD VSS sg13g2_decap_8
X_12028_ _12029_/A _13746_/Q _14098_/Q _14450_/Q _14546_/Q _12025_/A _12026_/C VDD
+ VSS sg13g2_mux4_1
XFILLER_113_1426 VDD VSS sg13g2_fill_1
XFILLER_61_1358 VDD VSS sg13g2_decap_8
XFILLER_18_4 VDD VSS sg13g2_decap_8
XFILLER_93_532 VDD VSS sg13g2_decap_8
XFILLER_19_640 VDD VSS sg13g2_decap_8
XFILLER_20_1011 VDD VSS sg13g2_fill_2
XFILLER_93_565 VDD VSS sg13g2_fill_2
XFILLER_93_576 VDD VSS sg13g2_decap_4
XFILLER_81_727 VDD VSS sg13g2_decap_8
XFILLER_4_1274 VDD VSS sg13g2_decap_8
XFILLER_53_429 VDD VSS sg13g2_decap_8
X_13979_ _13979_/Q clkload79/A _13979_/D _13979_/RESET_B VDD VSS sg13g2_dfrbpq_1
XFILLER_80_215 VDD VSS sg13g2_fill_2
XFILLER_46_481 VDD VSS sg13g2_fill_2
XFILLER_0_1149 VDD VSS sg13g2_decap_8
XFILLER_59_1254 VDD VSS sg13g2_decap_8
XFILLER_55_1118 VDD VSS sg13g2_fill_2
XFILLER_34_665 VDD VSS sg13g2_decap_4
XFILLER_62_996 VDD VSS sg13g2_decap_8
XFILLER_181_1148 VDD VSS sg13g2_decap_8
XFILLER_21_315 VDD VSS sg13g2_decap_8
XFILLER_178_147 VDD VSS sg13g2_decap_8
XFILLER_21_326 VDD VSS sg13g2_decap_8
XFILLER_33_197 VDD VSS sg13g2_decap_8
X_09170_ _09170_/Y _09938_/C _10137_/B _09938_/D VDD VSS sg13g2_nor3_1
XFILLER_72_1454 VDD VSS sg13g2_decap_8
XFILLER_119_203 VDD VSS sg13g2_decap_8
X_08121_ _08121_/X _08591_/A2 _07861_/B _12129_/B2 _07853_/B _13517_/A _13521_/A VDD
+ VSS sg13g2_mux4_1
XFILLER_147_534 VDD VSS sg13g2_fill_1
XFILLER_179_1011 VDD VSS sg13g2_fill_1
XFILLER_119_247 VDD VSS sg13g2_decap_4
XFILLER_179_1022 VDD VSS sg13g2_decap_8
X_08052_ _08052_/Y _08079_/S _08047_/Y _08048_/Y _08051_/Y VDD VSS sg13g2_a22oi_1
XFILLER_116_910 VDD VSS sg13g2_fill_2
XFILLER_175_898 VDD VSS sg13g2_fill_1
XFILLER_162_526 VDD VSS sg13g2_fill_1
XFILLER_162_537 VDD VSS sg13g2_decap_8
X_14407__1795 _14407_/RESET_B VDD VSS sg13g2_tiehi
XFILLER_31_1195 VDD VSS sg13g2_decap_8
XFILLER_115_431 VDD VSS sg13g2_decap_8
XFILLER_179_1099 VDD VSS sg13g2_decap_8
XFILLER_66_1214 VDD VSS sg13g2_decap_8
XFILLER_116_965 VDD VSS sg13g2_decap_8
XFILLER_118_1315 VDD VSS sg13g2_decap_4
XFILLER_157_1364 VDD VSS sg13g2_decap_8
Xhold3103 hold3103/X mem_axi_rdata[16] VDD VSS sg13g2_dlygate4sd3_1
XFILLER_88_304 VDD VSS sg13g2_decap_8
Xhold3114 _13620_/A _13728_/Q VDD VSS sg13g2_dlygate4sd3_1
XFILLER_153_1217 VDD VSS sg13g2_decap_8
Xhold3125 _13634_/A _13742_/Q VDD VSS sg13g2_dlygate4sd3_1
XFILLER_115_497 VDD VSS sg13g2_decap_8
Xhold3136 _13629_/A _13737_/Q VDD VSS sg13g2_dlygate4sd3_1
XFILLER_131_957 VDD VSS sg13g2_fill_1
Xhold3147 _07761_/B _15204_/Q VDD VSS sg13g2_dlygate4sd3_1
X_14586__1616 _14586_/RESET_B VDD VSS sg13g2_tiehi
Xhold3158 _13519_/A _15140_/Q VDD VSS sg13g2_dlygate4sd3_1
X_08954_ _08954_/X _15052_/Q _14956_/Q _08954_/S VDD VSS sg13g2_mux2_1
XFILLER_9_1141 VDD VSS sg13g2_decap_8
Xhold3169 _13572_/A _15156_/Q VDD VSS sg13g2_dlygate4sd3_1
XFILLER_97_860 VDD VSS sg13g2_decap_8
X_14622__1580 _14622_/RESET_B VDD VSS sg13g2_tiehi
X_07905_ _07906_/C _07905_/A _07905_/B _07905_/C _07905_/D VDD VSS sg13g2_nor4_1
XFILLER_116_1061 VDD VSS sg13g2_decap_4
XFILLER_130_489 VDD VSS sg13g2_decap_8
XFILLER_9_1185 VDD VSS sg13g2_decap_8
X_08885_ _08885_/Y _10725_/A _14939_/Q VDD VSS sg13g2_nand2_1
XFILLER_84_510 VDD VSS sg13g2_decap_8
XFILLER_69_584 VDD VSS sg13g2_fill_1
XFILLER_111_681 VDD VSS sg13g2_decap_4
XFILLER_56_28 VDD VSS sg13g2_decap_8
XFILLER_56_212 VDD VSS sg13g2_decap_8
XFILLER_96_381 VDD VSS sg13g2_decap_8
X_07836_ _08697_/B _15019_/Q _12278_/A VDD VSS sg13g2_nand2b_1
XFILLER_186_1015 VDD VSS sg13g2_decap_8
XFILLER_84_565 VDD VSS sg13g2_decap_4
XFILLER_16_109 VDD VSS sg13g2_decap_8
XFILLER_99_1089 VDD VSS sg13g2_decap_8
XFILLER_56_278 VDD VSS sg13g2_decap_8
X_07767_ _08265_/A _07768_/A _08263_/B VDD VSS sg13g2_nor2_1
XFILLER_25_621 VDD VSS sg13g2_decap_4
X_09506_ _14106_/D _10102_/A0 _14106_/Q _09506_/S VDD VSS sg13g2_mux2_1
XFILLER_71_248 VDD VSS sg13g2_fill_2
X_07698_ _07700_/B _15083_/Q _07701_/B VDD VSS sg13g2_nand2_1
XFILLER_53_963 VDD VSS sg13g2_decap_8
XFILLER_25_654 VDD VSS sg13g2_decap_8
XFILLER_77_1376 VDD VSS sg13g2_decap_8
XFILLER_24_142 VDD VSS sg13g2_fill_2
XFILLER_72_49 VDD VSS sg13g2_decap_8
XFILLER_38_1349 VDD VSS sg13g2_decap_8
X_09437_ _14039_/D _09635_/A0 _14039_/Q _09438_/S VDD VSS sg13g2_mux2_1
XFILLER_12_315 VDD VSS sg13g2_decap_8
XFILLER_164_1357 VDD VSS sg13g2_decap_8
XFILLER_169_169 VDD VSS sg13g2_fill_2
X_09368_ _13972_/D _10130_/A0 _13972_/Q _09368_/S VDD VSS sg13g2_mux2_1
XFILLER_8_319 VDD VSS sg13g2_decap_8
XFILLER_166_832 VDD VSS sg13g2_decap_8
XFILLER_184_128 VDD VSS sg13g2_decap_8
XFILLER_138_534 VDD VSS sg13g2_decap_8
XFILLER_162_1092 VDD VSS sg13g2_decap_8
X_08319_ _08420_/A _08319_/A _08319_/B _08319_/C VDD VSS sg13g2_nor3_1
X_09299_ _13907_/D _13907_/Q _09963_/A1 _09304_/S VDD VSS sg13g2_mux2_1
XFILLER_20_381 VDD VSS sg13g2_fill_1
XFILLER_123_1076 VDD VSS sg13g2_decap_8
XFILLER_138_567 VDD VSS sg13g2_decap_8
XFILLER_20_392 VDD VSS sg13g2_decap_8
X_11330_ _11330_/X _11321_/Y _11329_/Y _11330_/S VDD VSS sg13g2_mux2_1
XFILLER_138_578 VDD VSS sg13g2_fill_2
XFILLER_125_206 VDD VSS sg13g2_decap_8
XFILLER_158_1106 VDD VSS sg13g2_decap_8
XFILLER_180_301 VDD VSS sg13g2_decap_8
XFILLER_101_1341 VDD VSS sg13g2_decap_8
XFILLER_4_525 VDD VSS sg13g2_decap_8
XFILLER_49_1401 VDD VSS sg13g2_decap_8
X_11261_ _11262_/A _11273_/A1 _13884_/Q VDD VSS sg13g2_nand2b_1
XFILLER_10_1246 VDD VSS sg13g2_decap_8
XFILLER_84_1303 VDD VSS sg13g2_fill_2
XFILLER_137_75 VDD VSS sg13g2_decap_8
X_13000_ _13000_/Y _14811_/Q _13029_/A2 _12976_/B _10511_/D VDD VSS sg13g2_a22oi_1
X_10212_ _14763_/D _10441_/C _10209_/B hold3042/X VDD VSS sg13g2_a21oi_1
XFILLER_107_998 VDD VSS sg13g2_fill_1
X_11192_ _11192_/X _11191_/Y _11189_/Y _11193_/A2 VDD VSS sg13g2_a21o_1
XFILLER_84_1358 VDD VSS sg13g2_decap_8
XFILLER_49_1478 VDD VSS sg13g2_fill_1
XFILLER_121_423 VDD VSS sg13g2_decap_8
XFILLER_136_1437 VDD VSS sg13g2_decap_8
XFILLER_97_68 VDD VSS sg13g2_fill_2
X_10143_ _14720_/D _14720_/Q _10143_/A1 _10156_/S VDD VSS sg13g2_mux2_1
XFILLER_122_979 VDD VSS sg13g2_decap_8
XFILLER_0_764 VDD VSS sg13g2_decap_8
XFILLER_88_860 VDD VSS sg13g2_decap_8
XFILLER_121_478 VDD VSS sg13g2_fill_2
XFILLER_88_871 VDD VSS sg13g2_fill_1
X_14951_ _14951_/Q clkload68/A _14951_/D _14951_/RESET_B VDD VSS sg13g2_dfrbpq_1
X_10074_ _14654_/D _10074_/A0 _14654_/Q _10096_/S VDD VSS sg13g2_mux2_1
XFILLER_48_713 VDD VSS sg13g2_decap_4
XFILLER_47_201 VDD VSS sg13g2_fill_1
XFILLER_130_990 VDD VSS sg13g2_decap_8
XFILLER_43_1066 VDD VSS sg13g2_fill_1
X_13902_ _13902_/Q _14670_/CLK _13902_/D _13902_/RESET_B VDD VSS sg13g2_dfrbpq_1
X_14882_ _14882_/Q clkload88/A _14882_/D _14882_/RESET_B VDD VSS sg13g2_dfrbpq_1
XFILLER_75_554 VDD VSS sg13g2_decap_8
XFILLER_169_1224 VDD VSS sg13g2_decap_8
XFILLER_48_779 VDD VSS sg13g2_decap_8
XFILLER_1_1414 VDD VSS sg13g2_decap_8
XFILLER_75_576 VDD VSS sg13g2_decap_8
X_13833_ _13833_/Q _14729_/CLK _13833_/D _13833_/RESET_B VDD VSS sg13g2_dfrbpq_1
XFILLER_21_1386 VDD VSS sg13g2_decap_8
XFILLER_95_1443 VDD VSS sg13g2_decap_8
XFILLER_62_248 VDD VSS sg13g2_decap_8
X_13764_ _13764_/Q _14724_/CLK _13764_/D _13764_/RESET_B VDD VSS sg13g2_dfrbpq_1
X_10976_ _11009_/B _14759_/Q _10722_/Y _10942_/Y VDD VSS sg13g2_a21o_1
XFILLER_56_1416 VDD VSS sg13g2_decap_8
XFILLER_91_1307 VDD VSS sg13g2_fill_1
XFILLER_182_1446 VDD VSS sg13g2_decap_8
X_12715_ _12715_/X _13973_/Q _14005_/Q _14037_/Q _14069_/Q _12716_/S0 _12716_/S1 VDD
+ VSS sg13g2_mux4_1
XFILLER_31_613 VDD VSS sg13g2_fill_1
X_14060__2142 _14060_/RESET_B VDD VSS sg13g2_tiehi
X_13695_ _16857_/A _14668_/CLK _13695_/D _13695_/RESET_B VDD VSS sg13g2_dfrbpq_1
XFILLER_31_635 VDD VSS sg13g2_decap_4
X_12646_ _12646_/X _14128_/Q _14160_/Q _14192_/Q _14224_/Q _12647_/S0 _12647_/S1 VDD
+ VSS sg13g2_mux4_1
XFILLER_19_1282 VDD VSS sg13g2_decap_8
XFILLER_15_1124 VDD VSS sg13g2_decap_8
XFILLER_141_1143 VDD VSS sg13g2_decap_8
X_14664__1538 _14664_/RESET_B VDD VSS sg13g2_tiehi
X_12577_ _12577_/X _14379_/Q _14411_/Q _14475_/Q _14507_/Q _12699_/S0 _12699_/S1 VDD
+ VSS sg13g2_mux4_1
XFILLER_89_1214 VDD VSS sg13g2_decap_8
XFILLER_141_1176 VDD VSS sg13g2_decap_8
X_14316_ _14316_/Q _14508_/CLK _14316_/D _14316_/RESET_B VDD VSS sg13g2_dfrbpq_1
XFILLER_157_898 VDD VSS sg13g2_decap_8
X_11528_ _11528_/X _14116_/Q _14148_/Q _11531_/A VDD VSS sg13g2_mux2_1
XFILLER_8_886 VDD VSS sg13g2_decap_8
XFILLER_144_526 VDD VSS sg13g2_decap_8
XFILLER_171_312 VDD VSS sg13g2_decap_8
XFILLER_183_172 VDD VSS sg13g2_decap_8
XFILLER_7_77 VDD VSS sg13g2_decap_8
XFILLER_172_857 VDD VSS sg13g2_decap_8
XFILLER_7_385 VDD VSS sg13g2_decap_8
XFILLER_109_280 VDD VSS sg13g2_decap_4
XFILLER_144_559 VDD VSS sg13g2_fill_1
X_14247_ _14247_/Q clkload12/A _14247_/D _14247_/RESET_B VDD VSS sg13g2_dfrbpq_1
X_11459_ _11459_/Y _11457_/Y _11458_/Y _11451_/Y _11458_/A _11978_/B1 VDD VSS sg13g2_a221oi_1
XFILLER_98_602 VDD VSS sg13g2_decap_4
XFILLER_171_389 VDD VSS sg13g2_decap_8
X_14178_ _14178_/Q _14722_/CLK _14178_/D _14178_/RESET_B VDD VSS sg13g2_dfrbpq_1
XFILLER_124_272 VDD VSS sg13g2_decap_8
X_13129_ _13133_/C _14915_/Q _13129_/B VDD VSS sg13g2_xor2_1
X_15032__2578 _15032_/RESET_B VDD VSS sg13g2_tiehi
XFILLER_112_456 VDD VSS sg13g2_decap_4
XFILLER_61_1111 VDD VSS sg13g2_decap_4
XFILLER_65_1291 VDD VSS sg13g2_decap_8
XFILLER_26_1242 VDD VSS sg13g2_decap_8
XFILLER_140_787 VDD VSS sg13g2_decap_8
XFILLER_79_882 VDD VSS sg13g2_decap_8
XFILLER_85_329 VDD VSS sg13g2_decap_8
XFILLER_61_1155 VDD VSS sg13g2_decap_8
Xfanout1370 _12040_/A1 fanout1371/X VDD VSS sg13g2_buf_1
XFILLER_66_532 VDD VSS sg13g2_decap_8
X_08670_ _08670_/Y _08080_/Y _08012_/Y _08010_/Y _08669_/Y _08402_/C VDD VSS sg13g2_a221oi_1
XFILLER_22_1139 VDD VSS sg13g2_decap_8
Xfanout1381 _12140_/S0 fanout1394/X VDD VSS sg13g2_buf_1
XFILLER_6_1369 VDD VSS sg13g2_decap_8
Xfanout1392 _12328_/A1 _11221_/S0 VDD VSS sg13g2_buf_1
X_14270__1932 _14270_/RESET_B VDD VSS sg13g2_tiehi
X_07621_ _07621_/Y _14868_/Q VDD VSS sg13g2_inv_1
XFILLER_53_204 VDD VSS sg13g2_decap_8
XFILLER_93_384 VDD VSS sg13g2_decap_8
XFILLER_4_1071 VDD VSS sg13g2_decap_8
XFILLER_50_911 VDD VSS sg13g2_fill_2
XFILLER_21_123 VDD VSS sg13g2_decap_8
X_09222_ _13833_/D _09920_/A1 _13833_/Q _09233_/S VDD VSS sg13g2_mux2_1
XFILLER_72_1251 VDD VSS sg13g2_decap_8
XFILLER_37_1371 VDD VSS sg13g2_decap_8
XFILLER_10_819 VDD VSS sg13g2_decap_8
X_09153_ _13784_/D _13784_/Q _10167_/A1 _09153_/S VDD VSS sg13g2_mux2_1
XFILLER_147_331 VDD VSS sg13g2_decap_8
X_08104_ _08104_/Y _08201_/A _08201_/B _08104_/C _08104_/D VDD VSS sg13g2_nor4_1
XFILLER_33_1268 VDD VSS sg13g2_decap_8
XFILLER_147_364 VDD VSS sg13g2_decap_8
XFILLER_175_673 VDD VSS sg13g2_decap_4
X_09084_ _13774_/D _13774_/Q _10124_/A0 _09084_/S VDD VSS sg13g2_mux2_1
XFILLER_147_375 VDD VSS sg13g2_fill_1
XFILLER_148_898 VDD VSS sg13g2_decap_4
XFILLER_174_161 VDD VSS sg13g2_decap_8
XFILLER_159_1437 VDD VSS sg13g2_decap_8
X_08035_ _08035_/X _08659_/A _08600_/B VDD VSS sg13g2_or2_1
XFILLER_116_762 VDD VSS sg13g2_decap_8
XFILLER_66_1022 VDD VSS sg13g2_fill_1
XFILLER_104_924 VDD VSS sg13g2_decap_4
XFILLER_115_261 VDD VSS sg13g2_decap_8
XFILLER_88_101 VDD VSS sg13g2_decap_8
XFILLER_104_946 VDD VSS sg13g2_decap_4
XFILLER_171_890 VDD VSS sg13g2_decap_8
XFILLER_131_732 VDD VSS sg13g2_decap_8
XFILLER_157_1183 VDD VSS sg13g2_decap_8
XFILLER_1_539 VDD VSS sg13g2_decap_8
XFILLER_153_1036 VDD VSS sg13g2_decap_4
XFILLER_103_456 VDD VSS sg13g2_decap_8
XFILLER_104_979 VDD VSS sg13g2_decap_8
XFILLER_130_231 VDD VSS sg13g2_decap_8
X_09986_ _14569_/D _10152_/A1 _14569_/Q _09990_/S VDD VSS sg13g2_mux2_1
X_08937_ _08937_/X _08936_/X _08012_/B _08955_/S VDD VSS sg13g2_mux2_1
XFILLER_131_1312 VDD VSS sg13g2_decap_8
XFILLER_170_1361 VDD VSS sg13g2_decap_8
XFILLER_85_830 VDD VSS sg13g2_decap_8
XFILLER_123_11 VDD VSS sg13g2_fill_2
XFILLER_57_532 VDD VSS sg13g2_decap_8
XFILLER_44_1375 VDD VSS sg13g2_decap_8
XFILLER_40_1228 VDD VSS sg13g2_decap_8
X_08868_ _13700_/D _16862_/A _08867_/X _08876_/S VDD VSS sg13g2_mux2_1
XFILLER_79_1416 VDD VSS sg13g2_decap_8
X_07819_ _07822_/A _15009_/Q _11914_/A VDD VSS sg13g2_nor2_1
XFILLER_57_598 VDD VSS sg13g2_decap_8
X_08799_ _13684_/D _08799_/A _08799_/B VDD VSS sg13g2_nor2_1
XFILLER_44_226 VDD VSS sg13g2_decap_4
X_10830_ _10830_/X _10831_/A _10831_/B _10831_/C VDD VSS sg13g2_a21o_1
XFILLER_60_719 VDD VSS sg13g2_decap_4
XFILLER_16_53 VDD VSS sg13g2_decap_8
XFILLER_53_760 VDD VSS sg13g2_fill_1
XFILLER_77_1173 VDD VSS sg13g2_decap_8
XFILLER_41_911 VDD VSS sg13g2_fill_2
X_10761_ _14917_/D _11168_/B1 _11115_/A _10760_/Y VDD VSS sg13g2_o21ai_1
XFILLER_38_1146 VDD VSS sg13g2_decap_8
XFILLER_12_112 VDD VSS sg13g2_decap_8
XFILLER_80_590 VDD VSS sg13g2_decap_8
XFILLER_129_1285 VDD VSS sg13g2_decap_8
XFILLER_16_1400 VDD VSS sg13g2_decap_8
X_12500_ _12513_/A _12570_/A1 _12570_/A2 _08306_/B VDD VSS sg13g2_a21oi_1
XFILLER_40_443 VDD VSS sg13g2_fill_2
XFILLER_186_938 VDD VSS sg13g2_decap_8
X_13480_ _15114_/D _15180_/D _15114_/Q _13480_/S VDD VSS sg13g2_mux2_1
X_10692_ _10693_/A _14900_/Q _10875_/B _10912_/B1 _10870_/A VDD VSS sg13g2_a22oi_1
XFILLER_13_679 VDD VSS sg13g2_decap_8
XFILLER_90_1351 VDD VSS sg13g2_decap_8
XFILLER_8_116 VDD VSS sg13g2_decap_8
XFILLER_185_448 VDD VSS sg13g2_decap_8
X_12431_ _12431_/X _14561_/Q _14593_/Q _14625_/Q _14657_/Q _12450_/S0 _12450_/S1 VDD
+ VSS sg13g2_mux4_1
XFILLER_40_487 VDD VSS sg13g2_decap_8
XFILLER_12_189 VDD VSS sg13g2_decap_8
XFILLER_32_63 VDD VSS sg13g2_decap_8
XFILLER_138_353 VDD VSS sg13g2_decap_4
XFILLER_51_1368 VDD VSS sg13g2_decap_8
XFILLER_154_813 VDD VSS sg13g2_decap_8
XFILLER_172_109 VDD VSS sg13g2_decap_8
X_15150_ _15150_/Q _15162_/CLK _15150_/D _15150_/RESET_B VDD VSS sg13g2_dfrbpq_1
XFILLER_139_898 VDD VSS sg13g2_fill_2
XFILLER_154_824 VDD VSS sg13g2_fill_2
X_12362_ _12362_/X _14364_/Q _14396_/Q _14460_/Q _14492_/Q _12752_/S0 _12752_/S1 VDD
+ VSS sg13g2_mux4_1
XFILLER_5_812 VDD VSS sg13g2_decap_8
XFILLER_138_386 VDD VSS sg13g2_fill_2
XFILLER_166_695 VDD VSS sg13g2_fill_1
X_14101_ _14101_/Q _14677_/CLK _14101_/D _14101_/RESET_B VDD VSS sg13g2_dfrbpq_1
X_13698__2504 _13698_/RESET_B VDD VSS sg13g2_tiehi
X_11313_ _11313_/Y _11330_/S _11301_/Y _11312_/Y VDD VSS sg13g2_o21ai_1
X_15081_ _15081_/Q _15214_/CLK _15081_/D _15081_/RESET_B VDD VSS sg13g2_dfrbpq_1
X_12293_ _12293_/Y _12217_/A _12289_/X _12292_/Y VDD VSS sg13g2_o21ai_1
XFILLER_4_322 VDD VSS sg13g2_decap_8
XFILLER_10_1043 VDD VSS sg13g2_decap_8
XFILLER_107_751 VDD VSS sg13g2_fill_2
XFILLER_181_665 VDD VSS sg13g2_decap_8
XFILLER_84_1100 VDD VSS sg13g2_decap_8
XFILLER_141_507 VDD VSS sg13g2_fill_2
X_14032_ _14032_/Q clkload8/A _14032_/D _14032_/RESET_B VDD VSS sg13g2_dfrbpq_1
X_11244_ _11245_/C _13293_/A _11243_/C _07687_/B VDD VSS sg13g2_a21oi_1
XFILLER_5_889 VDD VSS sg13g2_decap_8
XFILLER_180_175 VDD VSS sg13g2_decap_8
XFILLER_175_1272 VDD VSS sg13g2_decap_8
XFILLER_4_399 VDD VSS sg13g2_decap_8
XFILLER_49_1275 VDD VSS sg13g2_decap_8
XFILLER_122_743 VDD VSS sg13g2_fill_1
X_11175_ _11175_/Y _11164_/B _11164_/C _11185_/A VDD VSS sg13g2_a21oi_1
XFILLER_136_1256 VDD VSS sg13g2_fill_2
XFILLER_164_84 VDD VSS sg13g2_decap_8
XFILLER_79_156 VDD VSS sg13g2_decap_8
XFILLER_171_1147 VDD VSS sg13g2_decap_8
XFILLER_67_307 VDD VSS sg13g2_decap_8
X_10126_ _14704_/D _10159_/A1 _14704_/Q _10130_/S VDD VSS sg13g2_mux2_1
XFILLER_110_938 VDD VSS sg13g2_decap_8
XFILLER_136_1289 VDD VSS sg13g2_decap_8
X_14078__2124 _14078_/RESET_B VDD VSS sg13g2_tiehi
XFILLER_62_1453 VDD VSS sg13g2_decap_8
XFILLER_121_286 VDD VSS sg13g2_decap_8
XFILLER_23_1437 VDD VSS sg13g2_decap_8
X_14934_ _14934_/Q clkload59/A _14934_/D _14934_/RESET_B VDD VSS sg13g2_dfrbpq_1
X_10057_ _14638_/D _10057_/A0 _14638_/Q _10057_/S VDD VSS sg13g2_mux2_1
XFILLER_48_543 VDD VSS sg13g2_fill_1
XFILLER_36_705 VDD VSS sg13g2_fill_2
XFILLER_91_800 VDD VSS sg13g2_fill_1
XFILLER_36_716 VDD VSS sg13g2_decap_4
XFILLER_110_1429 VDD VSS sg13g2_decap_8
XFILLER_1_1211 VDD VSS sg13g2_decap_8
X_14865_ _14865_/Q clkload85/A _14865_/D _14865_/RESET_B VDD VSS sg13g2_dfrbpq_1
X_14718__1484 _14718_/RESET_B VDD VSS sg13g2_tiehi
XFILLER_21_1183 VDD VSS sg13g2_decap_8
X_13816_ _13816_/Q clkload46/A _13816_/D _13816_/RESET_B VDD VSS sg13g2_dfrbpq_1
XFILLER_91_866 VDD VSS sg13g2_fill_1
X_14796_ _14796_/Q clkload86/A _14796_/D _14796_/RESET_B VDD VSS sg13g2_dfrbpq_1
XFILLER_90_354 VDD VSS sg13g2_fill_1
XFILLER_63_579 VDD VSS sg13g2_fill_2
X_15043__2562 _15043_/RESET_B VDD VSS sg13g2_tiehi
XFILLER_56_1213 VDD VSS sg13g2_decap_8
XFILLER_1_1288 VDD VSS sg13g2_decap_8
XFILLER_91_899 VDD VSS sg13g2_fill_1
X_13747_ _13747_/Q _15160_/CLK _13747_/D _13747_/RESET_B VDD VSS sg13g2_dfrbpq_1
XFILLER_182_1243 VDD VSS sg13g2_decap_8
X_10959_ _10959_/Y _10959_/A _10973_/B VDD VSS sg13g2_nand2_1
XFILLER_108_1325 VDD VSS sg13g2_decap_8
XFILLER_16_495 VDD VSS sg13g2_decap_8
XFILLER_91_1137 VDD VSS sg13g2_fill_1
XFILLER_143_1227 VDD VSS sg13g2_fill_1
XFILLER_149_618 VDD VSS sg13g2_decap_8
XFILLER_148_106 VDD VSS sg13g2_decap_8
XFILLER_177_949 VDD VSS sg13g2_decap_8
X_13678_ _13678_/Q clkload57/A _13678_/D _13678_/RESET_B VDD VSS sg13g2_dfrbpq_1
X_12629_ _12629_/X _14255_/Q _14287_/Q _14319_/Q _14351_/Q _12686_/S0 _12686_/S1 VDD
+ VSS sg13g2_mux4_1
XFILLER_106_1060 VDD VSS sg13g2_fill_1
XFILLER_185_971 VDD VSS sg13g2_decap_8
XFILLER_30_1419 VDD VSS sg13g2_decap_8
XFILLER_157_695 VDD VSS sg13g2_decap_8
XFILLER_8_683 VDD VSS sg13g2_decap_8
XFILLER_129_397 VDD VSS sg13g2_decap_8
XFILLER_184_492 VDD VSS sg13g2_decap_8
XFILLER_117_559 VDD VSS sg13g2_decap_8
XFILLER_7_182 VDD VSS sg13g2_decap_8
X_14288__1914 _14288_/RESET_B VDD VSS sg13g2_tiehi
XFILLER_172_676 VDD VSS sg13g2_fill_2
XFILLER_89_1099 VDD VSS sg13g2_decap_8
XFILLER_113_710 VDD VSS sg13g2_fill_1
XFILLER_172_698 VDD VSS sg13g2_decap_8
XFILLER_67_1353 VDD VSS sg13g2_decap_8
XFILLER_28_1315 VDD VSS sg13g2_decap_8
XFILLER_113_732 VDD VSS sg13g2_fill_2
XFILLER_125_592 VDD VSS sg13g2_decap_8
Xfanout607 _10453_/C _10521_/C VDD VSS sg13g2_buf_1
X_09840_ _14427_/D _14427_/Q _10005_/A0 _09871_/S VDD VSS sg13g2_mux2_1
XFILLER_154_1345 VDD VSS sg13g2_decap_8
Xfanout618 _10767_/A _08936_/S VDD VSS sg13g2_buf_1
XFILLER_99_977 VDD VSS sg13g2_fill_2
XFILLER_98_454 VDD VSS sg13g2_fill_2
Xfanout629 _10694_/S _10669_/S VDD VSS sg13g2_buf_1
XFILLER_63_1239 VDD VSS sg13g2_decap_8
XFILLER_101_916 VDD VSS sg13g2_fill_1
XFILLER_115_1318 VDD VSS sg13g2_decap_8
X_09771_ _14361_/D _14361_/Q _09903_/A0 _09771_/S VDD VSS sg13g2_mux2_1
XFILLER_85_137 VDD VSS sg13g2_decap_4
X_08722_ _15214_/D _15193_/D _12347_/B _13648_/S VDD VSS sg13g2_mux2_1
XFILLER_85_159 VDD VSS sg13g2_decap_8
XFILLER_6_1166 VDD VSS sg13g2_decap_8
XFILLER_2_1008 VDD VSS sg13g2_decap_8
XFILLER_67_896 VDD VSS sg13g2_decap_8
X_08653_ _08661_/B _08692_/A _08653_/B _15018_/Q VDD VSS sg13g2_nand3_1
XFILLER_96_1026 VDD VSS sg13g2_decap_4
XFILLER_82_833 VDD VSS sg13g2_fill_2
XFILLER_81_321 VDD VSS sg13g2_decap_4
XFILLER_183_1007 VDD VSS sg13g2_decap_8
X_08584_ _08584_/Y _08698_/B _08608_/A VDD VSS sg13g2_nor2_1
XFILLER_183_1029 VDD VSS sg13g2_decap_8
XFILLER_78_1471 VDD VSS sg13g2_decap_8
XFILLER_82_899 VDD VSS sg13g2_decap_8
XFILLER_41_207 VDD VSS sg13g2_fill_2
XFILLER_165_1441 VDD VSS sg13g2_decap_8
X_13776__2426 _13776_/RESET_B VDD VSS sg13g2_tiehi
XFILLER_74_1324 VDD VSS sg13g2_decap_8
XFILLER_23_922 VDD VSS sg13g2_fill_1
XFILLER_39_1455 VDD VSS sg13g2_decap_8
X_13812__2390 _13812_/RESET_B VDD VSS sg13g2_tiehi
XFILLER_34_292 VDD VSS sg13g2_decap_8
XFILLER_23_966 VDD VSS sg13g2_decap_8
XFILLER_161_1338 VDD VSS sg13g2_decap_8
XFILLER_179_286 VDD VSS sg13g2_decap_8
XFILLER_23_988 VDD VSS sg13g2_decap_8
XFILLER_10_616 VDD VSS sg13g2_decap_8
X_09205_ _09307_/B _09938_/A _09938_/B _10137_/A VDD VSS sg13g2_nand3b_1
XFILLER_50_796 VDD VSS sg13g2_decap_4
XFILLER_33_1032 VDD VSS sg13g2_decap_4
XFILLER_148_651 VDD VSS sg13g2_decap_8
XFILLER_183_919 VDD VSS sg13g2_decap_8
XFILLER_33_1054 VDD VSS sg13g2_fill_2
XFILLER_147_150 VDD VSS sg13g2_decap_8
X_14156__2046 _14156_/RESET_B VDD VSS sg13g2_tiehi
X_09136_ _09137_/C _13142_/A _09136_/B _09150_/C _09164_/C VDD VSS sg13g2_and4_1
XFILLER_185_28 VDD VSS sg13g2_decap_8
X_13991__2211 _13991_/RESET_B VDD VSS sg13g2_tiehi
XFILLER_120_1035 VDD VSS sg13g2_decap_8
XFILLER_135_312 VDD VSS sg13g2_decap_4
XFILLER_136_835 VDD VSS sg13g2_fill_2
XFILLER_5_119 VDD VSS sg13g2_decap_8
XFILLER_136_846 VDD VSS sg13g2_decap_8
XFILLER_118_11 VDD VSS sg13g2_decap_4
XFILLER_147_183 VDD VSS sg13g2_fill_1
XFILLER_159_1234 VDD VSS sg13g2_decap_8
X_09067_ _09069_/B _13064_/A _09089_/C _14911_/Q VDD VSS sg13g2_a21oi_1
XFILLER_11_1352 VDD VSS sg13g2_decap_8
Xclkbuf_4_5_0_clk_i clkbuf_4_5_0_clk_i/X clkbuf_0_clk_i/X VDD VSS sg13g2_buf_8
XFILLER_68_1139 VDD VSS sg13g2_decap_8
XFILLER_150_304 VDD VSS sg13g2_decap_8
XFILLER_163_687 VDD VSS sg13g2_fill_1
X_08018_ _08018_/X _11635_/A _11659_/A _11705_/A _11726_/A _08083_/S0 _08102_/S0 VDD
+ VSS sg13g2_mux4_1
XFILLER_135_389 VDD VSS sg13g2_decap_8
XFILLER_151_838 VDD VSS sg13g2_fill_1
XFILLER_163_698 VDD VSS sg13g2_decap_8
XFILLER_2_826 VDD VSS sg13g2_decap_8
XFILLER_85_1453 VDD VSS sg13g2_decap_8
XFILLER_1_336 VDD VSS sg13g2_decap_8
XFILLER_172_1445 VDD VSS sg13g2_decap_8
XFILLER_81_1328 VDD VSS sg13g2_decap_8
XFILLER_131_551 VDD VSS sg13g2_decap_8
XFILLER_89_465 VDD VSS sg13g2_decap_8
XFILLER_133_1418 VDD VSS sg13g2_fill_2
XFILLER_49_318 VDD VSS sg13g2_fill_1
XFILLER_103_275 VDD VSS sg13g2_decap_8
X_09969_ _14553_/D _14553_/Q _09969_/A1 _09969_/S VDD VSS sg13g2_mux2_1
XFILLER_94_25 VDD VSS sg13g2_decap_8
XFILLER_44_1172 VDD VSS sg13g2_decap_8
X_12980_ _12980_/Y _12900_/A _13017_/A2 input6/X VDD VSS sg13g2_a21oi_1
XFILLER_57_351 VDD VSS sg13g2_fill_1
XFILLER_91_107 VDD VSS sg13g2_fill_2
XFILLER_40_1036 VDD VSS sg13g2_decap_8
X_14963__2647 _14963_/RESET_B VDD VSS sg13g2_tiehi
X_11931_ _11931_/Y _14914_/Q _11931_/A2 _07684_/B VDD VSS sg13g2_a21oi_1
XFILLER_45_524 VDD VSS sg13g2_decap_8
XFILLER_17_226 VDD VSS sg13g2_fill_2
XFILLER_79_1246 VDD VSS sg13g2_decap_8
XFILLER_73_844 VDD VSS sg13g2_decap_8
XFILLER_150_31 VDD VSS sg13g2_decap_8
XFILLER_166_1227 VDD VSS sg13g2_decap_8
X_14650_ _14650_/Q _14682_/CLK _14650_/D _14650_/RESET_B VDD VSS sg13g2_dfrbpq_1
X_11862_ _14975_/D _11843_/A _11978_/B1 _11861_/Y VDD VSS sg13g2_a21o_1
XFILLER_92_1402 VDD VSS sg13g2_decap_8
X_13601_ _13609_/B _13601_/A _13601_/B VDD VSS sg13g2_nor2_1
X_10813_ _10851_/A _10813_/A _10818_/B VDD VSS sg13g2_nor2_1
XFILLER_13_410 VDD VSS sg13g2_decap_8
X_14366__1836 _14366_/RESET_B VDD VSS sg13g2_tiehi
X_14581_ _14581_/Q _14677_/CLK _14581_/D _14581_/RESET_B VDD VSS sg13g2_dfrbpq_1
XFILLER_72_398 VDD VSS sg13g2_decap_8
X_11793_ _11793_/Y _11425_/B _11791_/X _11868_/A VDD VSS sg13g2_a21oi_1
XFILLER_25_270 VDD VSS sg13g2_decap_8
X_13532_ _15143_/D _13535_/B _13530_/Y _13531_/Y VDD VSS sg13g2_a21oi_1
XFILLER_53_1419 VDD VSS sg13g2_decap_8
X_10744_ _11068_/C _10735_/A _09086_/Y _08913_/Y VDD VSS sg13g2_o21ai_1
XFILLER_14_988 VDD VSS sg13g2_decap_8
XFILLER_186_735 VDD VSS sg13g2_decap_8
XFILLER_40_251 VDD VSS sg13g2_decap_8
XFILLER_139_640 VDD VSS sg13g2_decap_8
XFILLER_185_245 VDD VSS sg13g2_decap_8
X_13463_ _13463_/X _15191_/Q _13463_/B _15192_/Q _13463_/D VDD VSS sg13g2_or4_1
X_10675_ _10805_/C _10675_/A _10675_/B _10675_/C VDD VSS sg13g2_nor3_1
XFILLER_159_84 VDD VSS sg13g2_decap_8
X_15202_ _15202_/Q _15203_/CLK _15202_/D _15202_/RESET_B VDD VSS sg13g2_dfrbpq_1
XFILLER_9_469 VDD VSS sg13g2_decap_8
XFILLER_139_673 VDD VSS sg13g2_decap_8
XFILLER_16_1274 VDD VSS sg13g2_decap_8
X_12414_ _12415_/B _12413_/X _12412_/X _12623_/S VDD VSS sg13g2_mux2_1
XFILLER_51_1165 VDD VSS sg13g2_decap_8
X_13394_ _15085_/D _13455_/A _13391_/C _13393_/Y VDD VSS sg13g2_o21ai_1
XFILLER_12_1138 VDD VSS sg13g2_decap_8
X_14581__1621 _14581_/RESET_B VDD VSS sg13g2_tiehi
XFILLER_166_492 VDD VSS sg13g2_decap_8
X_15133_ _15133_/Q clkload31/A _15133_/D _15133_/RESET_B VDD VSS sg13g2_dfrbpq_1
XFILLER_154_654 VDD VSS sg13g2_decap_8
X_12345_ _12345_/X _13723_/Q _14075_/Q _14427_/Q _14523_/Q _12352_/S0 _12352_/S1 VDD
+ VSS sg13g2_mux4_1
XFILLER_177_1345 VDD VSS sg13g2_decap_8
XFILLER_86_1239 VDD VSS sg13g2_decap_8
XFILLER_142_816 VDD VSS sg13g2_decap_8
X_14863__2841 _14863_/RESET_B VDD VSS sg13g2_tiehi
X_15064_ _15064_/Q clkload80/A _15064_/D _15064_/RESET_B VDD VSS sg13g2_dfrbpq_1
X_12276_ _12280_/A _12273_/Y _12204_/A _12275_/Y VDD VSS sg13g2_o21ai_1
XFILLER_5_686 VDD VSS sg13g2_decap_8
XFILLER_153_186 VDD VSS sg13g2_fill_1
X_14015_ _14015_/Q _14655_/CLK _14015_/D _14015_/RESET_B VDD VSS sg13g2_dfrbpq_1
X_11227_ _11227_/X _11225_/X _11226_/X _11266_/B VDD VSS sg13g2_mux2_1
XFILLER_4_56 VDD VSS sg13g2_decap_8
XFILLER_4_196 VDD VSS sg13g2_decap_8
XFILLER_122_551 VDD VSS sg13g2_decap_8
X_14201__2001 _14201_/RESET_B VDD VSS sg13g2_tiehi
XFILLER_110_702 VDD VSS sg13g2_decap_8
XFILLER_136_1053 VDD VSS sg13g2_decap_4
X_13854__2348 _13854_/RESET_B VDD VSS sg13g2_tiehi
XFILLER_110_724 VDD VSS sg13g2_decap_8
XFILLER_67_104 VDD VSS sg13g2_decap_8
X_11158_ _11158_/Y _11144_/Y _11151_/B _11173_/C VDD VSS sg13g2_o21ai_1
XFILLER_96_947 VDD VSS sg13g2_decap_8
XFILLER_110_735 VDD VSS sg13g2_fill_2
XFILLER_7_1442 VDD VSS sg13g2_decap_8
XFILLER_62_1250 VDD VSS sg13g2_decap_8
X_14896__2775 _14896_/RESET_B VDD VSS sg13g2_tiehi
X_10109_ _14687_/D _10142_/A1 _14687_/Q _10130_/S VDD VSS sg13g2_mux2_1
XFILLER_23_1234 VDD VSS sg13g2_decap_8
X_11089_ _11091_/B _11086_/A _10754_/X _11058_/Y VDD VSS sg13g2_a21oi_1
XFILLER_83_608 VDD VSS sg13g2_fill_1
XFILLER_49_874 VDD VSS sg13g2_fill_2
XFILLER_3_1306 VDD VSS sg13g2_decap_8
XFILLER_114_1362 VDD VSS sg13g2_decap_8
XFILLER_97_1302 VDD VSS sg13g2_decap_8
XFILLER_110_1204 VDD VSS sg13g2_decap_8
XFILLER_82_107 VDD VSS sg13g2_decap_8
X_14917_ _14917_/Q _15240_/CLK _14917_/D _14917_/RESET_B VDD VSS sg13g2_dfrbpq_1
XFILLER_58_1308 VDD VSS sg13g2_decap_8
XFILLER_36_546 VDD VSS sg13g2_decap_8
X_14848_ _14848_/Q _14848_/CLK _14848_/D _14848_/RESET_B VDD VSS sg13g2_dfrbpq_1
XFILLER_84_91 VDD VSS sg13g2_decap_8
XFILLER_184_1338 VDD VSS sg13g2_decap_8
XFILLER_149_1458 VDD VSS sg13g2_decap_8
XFILLER_1_1085 VDD VSS sg13g2_decap_8
XFILLER_56_1021 VDD VSS sg13g2_fill_1
X_14779_ _14779_/Q clkload85/A _14779_/D _14779_/RESET_B VDD VSS sg13g2_dfrbpq_1
XFILLER_44_590 VDD VSS sg13g2_decap_8
XFILLER_149_415 VDD VSS sg13g2_decap_8
XFILLER_147_1193 VDD VSS sg13g2_decap_8
XFILLER_32_763 VDD VSS sg13g2_decap_8
XFILLER_176_223 VDD VSS sg13g2_decap_8
XFILLER_20_936 VDD VSS sg13g2_decap_8
XFILLER_143_1057 VDD VSS sg13g2_decap_8
XFILLER_34_1341 VDD VSS sg13g2_decap_8
XFILLER_31_295 VDD VSS sg13g2_decap_8
XFILLER_160_1360 VDD VSS sg13g2_decap_8
XFILLER_76_0 VDD VSS sg13g2_decap_8
XFILLER_30_1216 VDD VSS sg13g2_decap_8
XFILLER_121_1333 VDD VSS sg13g2_decap_4
XFILLER_8_480 VDD VSS sg13g2_decap_8
XFILLER_145_654 VDD VSS sg13g2_decap_8
XFILLER_69_1437 VDD VSS sg13g2_decap_8
XFILLER_121_1388 VDD VSS sg13g2_decap_8
XFILLER_133_805 VDD VSS sg13g2_fill_2
XFILLER_105_518 VDD VSS sg13g2_fill_2
XFILLER_172_473 VDD VSS sg13g2_decap_8
XFILLER_132_315 VDD VSS sg13g2_decap_8
XFILLER_67_1150 VDD VSS sg13g2_decap_8
XFILLER_154_1120 VDD VSS sg13g2_fill_1
Xfanout404 _10040_/A0 _10073_/A0 VDD VSS sg13g2_buf_1
XFILLER_113_551 VDD VSS sg13g2_decap_8
Xfanout415 _12749_/B2 _12777_/B2 VDD VSS sg13g2_buf_1
Xfanout426 _10136_/S _10103_/Y VDD VSS sg13g2_buf_1
XFILLER_141_882 VDD VSS sg13g2_decap_8
Xfanout437 _10003_/S fanout438/X VDD VSS sg13g2_buf_1
X_09823_ _14411_/D _09889_/A0 _14411_/Q _09832_/S VDD VSS sg13g2_mux2_1
XFILLER_113_584 VDD VSS sg13g2_decap_4
X_14444__1758 _14444_/RESET_B VDD VSS sg13g2_tiehi
Xfanout448 _09804_/S _09793_/S VDD VSS sg13g2_buf_1
Xfanout459 _09556_/S _09560_/S VDD VSS sg13g2_buf_1
XFILLER_87_958 VDD VSS sg13g2_decap_8
XFILLER_28_1189 VDD VSS sg13g2_decap_8
XFILLER_98_295 VDD VSS sg13g2_fill_1
XFILLER_86_435 VDD VSS sg13g2_fill_1
XFILLER_154_1197 VDD VSS sg13g2_decap_8
XFILLER_45_1470 VDD VSS sg13g2_fill_2
XFILLER_100_234 VDD VSS sg13g2_fill_2
XFILLER_101_768 VDD VSS sg13g2_decap_4
X_09754_ _14344_/D _14344_/Q _09919_/A1 _09758_/S VDD VSS sg13g2_mux2_1
XFILLER_100_256 VDD VSS sg13g2_fill_1
XFILLER_41_1334 VDD VSS sg13g2_decap_8
XFILLER_39_340 VDD VSS sg13g2_decap_8
XFILLER_104_35 VDD VSS sg13g2_decap_8
XFILLER_67_671 VDD VSS sg13g2_decap_8
XFILLER_100_278 VDD VSS sg13g2_decap_8
X_08705_ _15185_/D hold3075/X _15185_/Q _10195_/S VDD VSS sg13g2_mux2_1
X_09685_ _14277_/D _09916_/A1 _14277_/Q _09696_/S VDD VSS sg13g2_mux2_1
XFILLER_39_395 VDD VSS sg13g2_decap_8
XFILLER_54_332 VDD VSS sg13g2_decap_8
XFILLER_76_1408 VDD VSS sg13g2_decap_8
X_08636_ _08637_/A _08406_/A _08488_/B _08560_/C _08635_/X _08056_/B _08617_/A VDD
+ VSS sg13g2_mux4_1
XFILLER_82_652 VDD VSS sg13g2_fill_1
XFILLER_70_825 VDD VSS sg13g2_decap_8
XFILLER_14_229 VDD VSS sg13g2_decap_8
X_08567_ _08567_/X _08567_/A _08567_/B _08567_/C VDD VSS sg13g2_or3_1
XFILLER_154_7 VDD VSS sg13g2_decap_8
XFILLER_42_549 VDD VSS sg13g2_decap_8
XFILLER_39_1252 VDD VSS sg13g2_decap_8
XFILLER_168_702 VDD VSS sg13g2_decap_8
XFILLER_168_713 VDD VSS sg13g2_fill_1
XFILLER_167_201 VDD VSS sg13g2_fill_1
XFILLER_168_724 VDD VSS sg13g2_decap_8
XFILLER_126_1244 VDD VSS sg13g2_fill_1
XFILLER_168_735 VDD VSS sg13g2_fill_2
X_08498_ _08498_/Y _08497_/A _08495_/Y _08497_/Y VDD VSS sg13g2_o21ai_1
XFILLER_11_925 VDD VSS sg13g2_decap_8
XFILLER_161_1135 VDD VSS sg13g2_decap_8
XFILLER_22_262 VDD VSS sg13g2_fill_2
XFILLER_80_49 VDD VSS sg13g2_decap_8
XFILLER_74_1198 VDD VSS sg13g2_decap_8
XFILLER_50_571 VDD VSS sg13g2_decap_8
XFILLER_35_1149 VDD VSS sg13g2_decap_8
XFILLER_10_413 VDD VSS sg13g2_decap_8
XFILLER_156_908 VDD VSS sg13g2_decap_8
X_15181__2866 _15181_/RESET_B VDD VSS sg13g2_tiehi
XFILLER_13_32 VDD VSS sg13g2_decap_8
XFILLER_52_1452 VDD VSS sg13g2_decap_8
XFILLER_167_278 VDD VSS sg13g2_decap_8
XFILLER_13_1425 VDD VSS sg13g2_decap_8
X_10460_ _14842_/D _10471_/D _10487_/A _10460_/C VDD VSS sg13g2_nor3_1
XFILLER_108_301 VDD VSS sg13g2_decap_4
XFILLER_136_610 VDD VSS sg13g2_decap_8
XFILLER_6_417 VDD VSS sg13g2_decap_8
XFILLER_183_749 VDD VSS sg13g2_decap_8
XFILLER_136_643 VDD VSS sg13g2_decap_8
X_09119_ _13779_/D _13779_/Q _10162_/A1 _09153_/S VDD VSS sg13g2_mux2_1
X_10391_ _10392_/A _14820_/Q _14821_/Q _10391_/C _10398_/D VDD VSS sg13g2_nand4_1
XFILLER_159_1042 VDD VSS sg13g2_decap_8
XFILLER_124_827 VDD VSS sg13g2_fill_1
XFILLER_163_462 VDD VSS sg13g2_fill_1
X_12130_ _12132_/B _12065_/B _12198_/C _12198_/A VDD VSS sg13g2_a21oi_1
XFILLER_108_389 VDD VSS sg13g2_decap_4
XFILLER_151_624 VDD VSS sg13g2_decap_8
XFILLER_2_623 VDD VSS sg13g2_decap_8
X_12061_ _12197_/A _12061_/A _13189_/B VDD VSS sg13g2_xnor2_1
XFILLER_81_1103 VDD VSS sg13g2_decap_4
XFILLER_137_1351 VDD VSS sg13g2_decap_8
XFILLER_151_679 VDD VSS sg13g2_decap_8
XFILLER_1_133 VDD VSS sg13g2_decap_8
XFILLER_172_1242 VDD VSS sg13g2_decap_8
XFILLER_78_914 VDD VSS sg13g2_decap_8
XFILLER_150_167 VDD VSS sg13g2_fill_1
XFILLER_104_573 VDD VSS sg13g2_decap_8
X_11012_ _11014_/B _11064_/A _11012_/B _11012_/C VDD VSS sg13g2_nor3_1
XFILLER_150_189 VDD VSS sg13g2_decap_8
XFILLER_46_1267 VDD VSS sg13g2_decap_8
XFILLER_131_370 VDD VSS sg13g2_decap_8
XFILLER_78_969 VDD VSS sg13g2_decap_8
Xfanout960 _13389_/A _15181_/Q VDD VSS sg13g2_buf_1
XFILLER_93_906 VDD VSS sg13g2_decap_8
Xfanout971 _13249_/B _15108_/Q VDD VSS sg13g2_buf_1
Xfanout982 _13219_/A2 _13051_/B VDD VSS sg13g2_buf_1
Xfanout993 _10898_/B1 _10885_/A1 VDD VSS sg13g2_buf_1
XFILLER_92_405 VDD VSS sg13g2_decap_8
XFILLER_180_0 VDD VSS sg13g2_decap_8
XFILLER_18_513 VDD VSS sg13g2_decap_8
XFILLER_58_682 VDD VSS sg13g2_decap_8
XFILLER_161_63 VDD VSS sg13g2_decap_8
X_12963_ _12963_/Y _12963_/A _13028_/B VDD VSS sg13g2_nand2_1
XFILLER_100_790 VDD VSS sg13g2_decap_8
XFILLER_46_855 VDD VSS sg13g2_decap_8
X_14702_ _14702_/Q clkload19/A _14702_/D _14702_/RESET_B VDD VSS sg13g2_dfrbpq_1
X_11914_ _11915_/A _11914_/A _13673_/Q VDD VSS sg13g2_xor2_1
XFILLER_45_343 VDD VSS sg13g2_fill_1
X_14599__1603 _14599_/RESET_B VDD VSS sg13g2_tiehi
XFILLER_79_1065 VDD VSS sg13g2_fill_2
X_12894_ _12894_/X _12894_/A _12894_/B VDD VSS sg13g2_xor2_1
XFILLER_2_1372 VDD VSS sg13g2_decap_8
XFILLER_79_1098 VDD VSS sg13g2_fill_2
X_14633_ _14633_/Q _14665_/CLK _14633_/D _14633_/RESET_B VDD VSS sg13g2_dfrbpq_1
XFILLER_92_1210 VDD VSS sg13g2_decap_8
XFILLER_72_173 VDD VSS sg13g2_decap_8
X_11845_ _11867_/B _11907_/A _11910_/B _11845_/C VDD VSS sg13g2_or3_1
XFILLER_60_324 VDD VSS sg13g2_decap_8
XFILLER_127_1019 VDD VSS sg13g2_decap_4
XFILLER_57_1352 VDD VSS sg13g2_decap_8
XFILLER_54_94 VDD VSS sg13g2_decap_8
X_14564_ _14564_/Q clkload49/A _14564_/D _14564_/RESET_B VDD VSS sg13g2_dfrbpq_1
XFILLER_53_1216 VDD VSS sg13g2_decap_8
XFILLER_18_1336 VDD VSS sg13g2_decap_8
X_11776_ _11777_/B _11776_/A _11776_/B VDD VSS sg13g2_nand2_1
XFILLER_183_1393 VDD VSS sg13g2_decap_8
XFILLER_186_532 VDD VSS sg13g2_decap_8
X_13515_ _15138_/D _15138_/Q _14995_/Q _13515_/S VDD VSS sg13g2_mux2_1
XFILLER_105_1328 VDD VSS sg13g2_fill_1
XFILLER_13_284 VDD VSS sg13g2_decap_8
XFILLER_147_908 VDD VSS sg13g2_fill_1
X_10727_ _10727_/Y _14909_/Q _10973_/B VDD VSS sg13g2_nand2_1
XFILLER_159_779 VDD VSS sg13g2_decap_4
X_14495_ _14495_/Q _14495_/CLK _14495_/D _14495_/RESET_B VDD VSS sg13g2_dfrbpq_1
XFILLER_179_1407 VDD VSS sg13g2_decap_8
XFILLER_9_266 VDD VSS sg13g2_decap_8
XFILLER_16_1071 VDD VSS sg13g2_decap_8
XFILLER_174_738 VDD VSS sg13g2_decap_8
X_13446_ _13446_/Y _13446_/A1 _13412_/C hold3153/X VDD VSS sg13g2_o21ai_1
XFILLER_70_71 VDD VSS sg13g2_fill_2
XFILLER_103_1030 VDD VSS sg13g2_decap_8
X_10658_ _14891_/D _13328_/A _10658_/B _10666_/D VDD VSS sg13g2_nor3_1
X_13908__2294 _13908_/RESET_B VDD VSS sg13g2_tiehi
Xclkload14 clkload14/Y clkload14/A VDD VSS sg13g2_inv_2
XFILLER_10_980 VDD VSS sg13g2_decap_8
Xclkload25 clkload25/Y clkload25/A VDD VSS sg13g2_inv_1
Xclkload36 clkload36/Y clkload36/A VDD VSS sg13g2_inv_1
XFILLER_155_974 VDD VSS sg13g2_fill_2
X_13377_ _15078_/D _15078_/Q _13390_/A2 _13376_/Y VDD VSS sg13g2_a21o_1
Xclkload47 clkload47/Y clkload47/A VDD VSS sg13g2_inv_4
XFILLER_170_900 VDD VSS sg13g2_fill_2
Xclkload58 clkload58/X clkload58/A VDD VSS sg13g2_buf_8
X_10589_ _10592_/B _12963_/A _10594_/D _14874_/Q VDD VSS sg13g2_a21oi_1
XFILLER_177_1142 VDD VSS sg13g2_decap_8
Xclkload69 clkload69/Y clkload69/A VDD VSS sg13g2_inv_1
XFILLER_155_996 VDD VSS sg13g2_fill_1
X_15116_ _15116_/Q _15185_/CLK _15116_/D _15116_/RESET_B VDD VSS sg13g2_dfrbpq_1
XFILLER_6_984 VDD VSS sg13g2_decap_8
XFILLER_114_315 VDD VSS sg13g2_decap_8
XFILLER_127_698 VDD VSS sg13g2_decap_8
X_12328_ _12328_/Y _12328_/A1 _13946_/Q _12304_/B VDD VSS sg13g2_a21oi_1
XFILLER_86_1047 VDD VSS sg13g2_decap_8
XFILLER_170_944 VDD VSS sg13g2_decap_4
XFILLER_5_483 VDD VSS sg13g2_decap_8
XFILLER_141_134 VDD VSS sg13g2_decap_8
X_15047_ _15047_/Q clkload73/A _15047_/D _15047_/RESET_B VDD VSS sg13g2_dfrbpq_1
XFILLER_130_819 VDD VSS sg13g2_decap_8
XFILLER_141_145 VDD VSS sg13g2_decap_4
X_12259_ _12259_/X _14712_/Q _14744_/Q _13784_/Q _13816_/Q _12259_/S0 _12236_/C VDD
+ VSS sg13g2_mux4_1
XFILLER_64_1323 VDD VSS sg13g2_decap_8
XFILLER_29_1443 VDD VSS sg13g2_decap_8
XFILLER_123_871 VDD VSS sg13g2_decap_8
XFILLER_123_882 VDD VSS sg13g2_decap_8
XFILLER_151_1315 VDD VSS sg13g2_decap_8
XFILLER_110_532 VDD VSS sg13g2_decap_8
Xclkbuf_0_clk_i clkbuf_0_clk_i/X clk_i VDD VSS sg13g2_buf_16
XFILLER_116_1468 VDD VSS sg13g2_fill_2
XFILLER_23_1031 VDD VSS sg13g2_decap_8
XFILLER_49_660 VDD VSS sg13g2_decap_8
XFILLER_3_1103 VDD VSS sg13g2_decap_8
XFILLER_49_671 VDD VSS sg13g2_fill_2
XFILLER_114_1170 VDD VSS sg13g2_decap_8
XFILLER_83_427 VDD VSS sg13g2_fill_1
XFILLER_37_833 VDD VSS sg13g2_fill_2
XFILLER_92_950 VDD VSS sg13g2_decap_8
XFILLER_48_192 VDD VSS sg13g2_fill_1
XFILLER_110_1056 VDD VSS sg13g2_decap_8
X_09470_ _14071_/D _09635_/A0 _14071_/Q _09471_/S VDD VSS sg13g2_mux2_1
XFILLER_64_663 VDD VSS sg13g2_decap_8
XFILLER_36_365 VDD VSS sg13g2_fill_2
XFILLER_184_1135 VDD VSS sg13g2_decap_8
XFILLER_24_516 VDD VSS sg13g2_decap_8
X_08421_ _08421_/Y _08419_/Y _08420_/A _08417_/Y VDD VSS sg13g2_o21ai_1
XFILLER_145_1108 VDD VSS sg13g2_decap_8
X_08352_ _08353_/B _08352_/A _08352_/B _08369_/B VDD VSS sg13g2_nand3_1
XFILLER_36_1425 VDD VSS sg13g2_decap_8
XFILLER_71_1327 VDD VSS sg13g2_decap_8
XFILLER_162_1444 VDD VSS sg13g2_decap_8
XFILLER_177_543 VDD VSS sg13g2_decap_8
XFILLER_165_705 VDD VSS sg13g2_decap_8
XFILLER_20_733 VDD VSS sg13g2_decap_8
X_08283_ _08283_/Y _08539_/B1 _08282_/Y _08277_/Y VDD VSS sg13g2_o21ai_1
Xclkload8 clkload8/Y clkload8/A VDD VSS sg13g2_inv_1
XFILLER_137_418 VDD VSS sg13g2_decap_8
XFILLER_20_777 VDD VSS sg13g2_fill_1
XFILLER_118_621 VDD VSS sg13g2_decap_8
XFILLER_117_120 VDD VSS sg13g2_fill_2
XFILLER_69_1234 VDD VSS sg13g2_decap_8
XFILLER_121_1196 VDD VSS sg13g2_decap_8
XFILLER_173_782 VDD VSS sg13g2_decap_8
XFILLER_106_849 VDD VSS sg13g2_decap_8
XFILLER_156_1215 VDD VSS sg13g2_decap_8
XFILLER_145_495 VDD VSS sg13g2_fill_2
XFILLER_156_1248 VDD VSS sg13g2_decap_8
XFILLER_182_18 VDD VSS sg13g2_decap_8
X_14677__1525 _14677_/RESET_B VDD VSS sg13g2_tiehi
Xfanout201 _09960_/A1 _09098_/Y VDD VSS sg13g2_buf_1
XFILLER_160_487 VDD VSS sg13g2_decap_8
Xfanout212 _13265_/A1 _13154_/A1 VDD VSS sg13g2_buf_1
Xfanout223 _09590_/A1 _09063_/X VDD VSS sg13g2_buf_1
XFILLER_82_1456 VDD VSS sg13g2_decap_8
Xfanout234 fanout234/X _09051_/Y VDD VSS sg13g2_buf_1
Xfanout245 _11724_/B _11246_/Y VDD VSS sg13g2_buf_1
XFILLER_8_1047 VDD VSS sg13g2_decap_8
XFILLER_115_45 VDD VSS sg13g2_decap_8
Xfanout256 _10149_/A1 _10082_/A0 VDD VSS sg13g2_buf_1
XFILLER_115_56 VDD VSS sg13g2_fill_1
Xfanout267 _09894_/S _09898_/S VDD VSS sg13g2_buf_1
X_09806_ _09806_/Y _09938_/C _09806_/B _10004_/C _09806_/D VDD VSS sg13g2_nand4_1
XFILLER_75_906 VDD VSS sg13g2_fill_2
Xfanout278 _09593_/S _09573_/X VDD VSS sg13g2_buf_1
XFILLER_87_777 VDD VSS sg13g2_fill_1
X_14821__2915 _14821_/RESET_B VDD VSS sg13g2_tiehi
XFILLER_47_619 VDD VSS sg13g2_decap_8
Xfanout289 fanout289/X _09025_/X VDD VSS sg13g2_buf_1
X_07998_ _07998_/X _15103_/Q _15090_/Q VDD VSS sg13g2_or2_1
XFILLER_86_276 VDD VSS sg13g2_decap_8
XFILLER_41_1131 VDD VSS sg13g2_decap_8
XFILLER_86_287 VDD VSS sg13g2_fill_1
X_09737_ _14328_/D _09737_/A0 _14328_/Q _09738_/S VDD VSS sg13g2_mux2_1
XFILLER_90_909 VDD VSS sg13g2_decap_8
XFILLER_55_630 VDD VSS sg13g2_decap_8
XFILLER_27_321 VDD VSS sg13g2_fill_1
XFILLER_28_855 VDD VSS sg13g2_decap_8
XFILLER_167_1311 VDD VSS sg13g2_decap_8
XFILLER_76_1205 VDD VSS sg13g2_decap_8
X_09668_ _14261_/D _09767_/A1 _14261_/Q _09672_/S VDD VSS sg13g2_mux2_1
XFILLER_83_983 VDD VSS sg13g2_decap_8
XFILLER_131_55 VDD VSS sg13g2_decap_8
X_08619_ _08619_/Y _08054_/B _07850_/B _08053_/Y VDD VSS sg13g2_o21ai_1
XFILLER_163_1219 VDD VSS sg13g2_decap_8
X_09599_ _14196_/D _14196_/Q _10163_/A1 _09599_/S VDD VSS sg13g2_mux2_1
XFILLER_128_1339 VDD VSS sg13g2_decap_4
XFILLER_131_99 VDD VSS sg13g2_decap_8
XFILLER_167_1388 VDD VSS sg13g2_decap_8
X_11630_ _11630_/Y _11837_/A1 _11629_/Y _11934_/B VDD VSS sg13g2_o21ai_1
XFILLER_70_688 VDD VSS sg13g2_decap_8
XFILLER_24_42 VDD VSS sg13g2_decap_8
XFILLER_11_711 VDD VSS sg13g2_decap_8
XFILLER_70_699 VDD VSS sg13g2_fill_2
XFILLER_10_210 VDD VSS sg13g2_decap_8
X_11561_ _11561_/Y _11556_/X _11901_/B1 _11559_/C VDD VSS sg13g2_a21oi_1
XFILLER_156_727 VDD VSS sg13g2_decap_8
X_13300_ _13300_/Y _13307_/A _13300_/B _13300_/C _13312_/A VDD VSS sg13g2_nor4_1
XFILLER_128_429 VDD VSS sg13g2_decap_8
X_10512_ _10514_/B _10512_/A _10512_/B _10512_/C VDD VSS sg13g2_nor3_1
X_14280_ _14280_/Q clkload21/A _14280_/D _14280_/RESET_B VDD VSS sg13g2_dfrbpq_1
XFILLER_13_1222 VDD VSS sg13g2_decap_8
XFILLER_149_790 VDD VSS sg13g2_decap_8
X_11492_ _11492_/X _14114_/Q _14146_/Q _14178_/Q _14210_/Q _11649_/S0 _11649_/S1 VDD
+ VSS sg13g2_mux4_1
XFILLER_6_214 VDD VSS sg13g2_decap_8
XFILLER_87_1301 VDD VSS sg13g2_decap_8
XFILLER_10_287 VDD VSS sg13g2_decap_8
X_13231_ _13242_/A _13232_/A _13244_/B VDD VSS sg13g2_nand2b_1
X_10443_ _10444_/B _14837_/Q _14836_/Q _14835_/Q _10443_/D VDD VSS sg13g2_nand4_1
XFILLER_13_1299 VDD VSS sg13g2_decap_8
XFILLER_48_1307 VDD VSS sg13g2_decap_8
XFILLER_136_484 VDD VSS sg13g2_decap_8
X_13162_ _13162_/Y _14854_/Q _13273_/B _13028_/B _14886_/Q VDD VSS sg13g2_a22oi_1
XFILLER_87_1356 VDD VSS sg13g2_decap_8
XFILLER_3_921 VDD VSS sg13g2_decap_8
XFILLER_124_635 VDD VSS sg13g2_decap_8
XFILLER_156_63 VDD VSS sg13g2_decap_8
XFILLER_174_1315 VDD VSS sg13g2_decap_8
X_10374_ _10375_/B _14815_/Q _14816_/Q _10391_/C VDD VSS sg13g2_nand3_1
XFILLER_40_96 VDD VSS sg13g2_decap_4
XFILLER_151_432 VDD VSS sg13g2_fill_2
XFILLER_2_420 VDD VSS sg13g2_decap_8
X_12113_ _12113_/Y _12109_/Y _12110_/Y _12112_/Y _12111_/Y _12108_/B VDD VSS sg13g2_a221oi_1
XFILLER_112_808 VDD VSS sg13g2_decap_4
X_13093_ _13093_/Y _13091_/Y _13093_/B _13134_/C VDD VSS sg13g2_nand3b_1
XFILLER_111_307 VDD VSS sg13g2_decap_4
XFILLER_85_1080 VDD VSS sg13g2_decap_8
XFILLER_3_998 VDD VSS sg13g2_decap_8
X_12044_ _12044_/Y _12019_/Y _12021_/Y _12142_/S1 VDD VSS sg13g2_a21oi_1
XFILLER_104_370 VDD VSS sg13g2_decap_8
XFILLER_77_210 VDD VSS sg13g2_decap_8
XFILLER_2_497 VDD VSS sg13g2_decap_8
XFILLER_46_1075 VDD VSS sg13g2_decap_8
XFILLER_78_766 VDD VSS sg13g2_decap_8
X_13771__2431 _13771_/RESET_B VDD VSS sg13g2_tiehi
XFILLER_24_1340 VDD VSS sg13g2_decap_8
XFILLER_172_95 VDD VSS sg13g2_decap_8
XFILLER_19_811 VDD VSS sg13g2_fill_1
XFILLER_1_35 VDD VSS sg13g2_decap_8
Xfanout790 _10429_/D _10647_/D VDD VSS sg13g2_buf_1
XFILLER_65_427 VDD VSS sg13g2_decap_8
XFILLER_168_1108 VDD VSS sg13g2_fill_2
XFILLER_19_833 VDD VSS sg13g2_fill_2
XFILLER_93_747 VDD VSS sg13g2_decap_8
XFILLER_65_438 VDD VSS sg13g2_fill_2
X_13995_ _13995_/Q clkload13/A _13995_/D _13995_/RESET_B VDD VSS sg13g2_dfrbpq_1
XFILLER_93_769 VDD VSS sg13g2_decap_8
XFILLER_4_1456 VDD VSS sg13g2_decap_8
XFILLER_74_950 VDD VSS sg13g2_decap_8
XFILLER_185_1411 VDD VSS sg13g2_decap_8
XFILLER_18_354 VDD VSS sg13g2_decap_8
X_12946_ _12946_/Y _12946_/A _13079_/C _12961_/A VDD VSS sg13g2_nand3_1
XFILLER_98_1474 VDD VSS sg13g2_decap_4
XFILLER_61_600 VDD VSS sg13g2_decap_8
XFILLER_59_1436 VDD VSS sg13g2_decap_8
XFILLER_94_1327 VDD VSS sg13g2_decap_8
XFILLER_65_93 VDD VSS sg13g2_decap_8
Xclkbuf_leaf_131_clk_i clkload6/A clkbuf_leaf_2_clk_i/A VDD VSS sg13g2_buf_8
XFILLER_146_1417 VDD VSS sg13g2_decap_8
X_12877_ _12878_/C _14898_/Q _13689_/Q _12877_/C VDD VSS sg13g2_nand3_1
X_14151__2051 _14151_/RESET_B VDD VSS sg13g2_tiehi
XFILLER_61_644 VDD VSS sg13g2_fill_1
XFILLER_178_318 VDD VSS sg13g2_decap_8
X_14616_ _14616_/Q _14742_/CLK _14616_/D _14616_/RESET_B VDD VSS sg13g2_dfrbpq_1
X_11828_ _11828_/X _14700_/Q _14732_/Q _13772_/Q _13804_/Q _11373_/A _11805_/C VDD
+ VSS sg13g2_mux4_1
XFILLER_61_677 VDD VSS sg13g2_decap_4
XFILLER_18_1133 VDD VSS sg13g2_decap_8
XFILLER_159_532 VDD VSS sg13g2_fill_1
XFILLER_183_1190 VDD VSS sg13g2_decap_8
XFILLER_53_1024 VDD VSS sg13g2_decap_8
XFILLER_92_1084 VDD VSS sg13g2_fill_2
XFILLER_144_1152 VDD VSS sg13g2_decap_8
X_14547_ _14547_/Q _15160_/CLK _14547_/D _14547_/RESET_B VDD VSS sg13g2_dfrbpq_1
X_11759_ _11760_/B _11759_/A _13930_/Q VDD VSS sg13g2_nand2_1
XFILLER_119_407 VDD VSS sg13g2_fill_2
XFILLER_31_1300 VDD VSS sg13g2_decap_8
XFILLER_179_1204 VDD VSS sg13g2_decap_8
XFILLER_146_226 VDD VSS sg13g2_decap_8
X_14478_ _14478_/Q clkload50/A _14478_/D _14478_/RESET_B VDD VSS sg13g2_dfrbpq_1
XFILLER_105_1169 VDD VSS sg13g2_decap_8
XFILLER_70_1371 VDD VSS sg13g2_decap_8
XFILLER_128_952 VDD VSS sg13g2_decap_8
X_13429_ _13429_/Y _13429_/A _13494_/B _13444_/B _13444_/C VDD VSS sg13g2_nor4_1
XFILLER_31_1377 VDD VSS sg13g2_decap_8
XFILLER_127_484 VDD VSS sg13g2_fill_2
XFILLER_142_410 VDD VSS sg13g2_fill_1
XFILLER_6_781 VDD VSS sg13g2_decap_8
XFILLER_154_281 VDD VSS sg13g2_decap_8
XFILLER_5_280 VDD VSS sg13g2_decap_8
XFILLER_115_668 VDD VSS sg13g2_decap_8
XFILLER_88_508 VDD VSS sg13g2_fill_2
X_08970_ _13755_/D _13755_/Q _10138_/A1 _09167_/S VDD VSS sg13g2_mux2_1
XFILLER_69_700 VDD VSS sg13g2_decap_8
XFILLER_64_1120 VDD VSS sg13g2_decap_4
XFILLER_130_616 VDD VSS sg13g2_decap_8
XFILLER_143_999 VDD VSS sg13g2_decap_8
XFILLER_29_1240 VDD VSS sg13g2_decap_8
X_07921_ _07921_/Y _07876_/A _07876_/B _07912_/Y _07919_/Y VDD VSS sg13g2_a22oi_1
XFILLER_39_0 VDD VSS sg13g2_decap_8
XFILLER_151_1123 VDD VSS sg13g2_decap_4
XFILLER_9_1367 VDD VSS sg13g2_decap_8
X_07852_ _07855_/A _15015_/Q _07853_/B VDD VSS sg13g2_nor2_1
XFILLER_64_1197 VDD VSS sg13g2_decap_8
XFILLER_96_574 VDD VSS sg13g2_decap_4
XFILLER_25_1159 VDD VSS sg13g2_decap_8
XFILLER_116_1287 VDD VSS sg13g2_decap_8
X_14361__1841 _14361_/RESET_B VDD VSS sg13g2_tiehi
XFILLER_112_1129 VDD VSS sg13g2_decap_8
XFILLER_96_585 VDD VSS sg13g2_decap_4
XFILLER_96_596 VDD VSS sg13g2_decap_8
Xinput1 input1/X input1/A VDD VSS sg13g2_buf_1
X_07783_ _07796_/A _08411_/A _07784_/B VDD VSS sg13g2_nor2_1
XFILLER_65_950 VDD VSS sg13g2_decap_8
X_09522_ _14121_/D _09953_/A1 _14121_/Q _09524_/S VDD VSS sg13g2_mux2_1
XFILLER_65_961 VDD VSS sg13g2_fill_2
XFILLER_71_408 VDD VSS sg13g2_decap_8
XFILLER_25_814 VDD VSS sg13g2_decap_4
XFILLER_52_600 VDD VSS sg13g2_fill_2
XFILLER_36_173 VDD VSS sg13g2_decap_4
X_09453_ _14054_/D _09686_/A0 _14054_/Q _09467_/S VDD VSS sg13g2_mux2_1
XFILLER_80_942 VDD VSS sg13g2_decap_4
XFILLER_149_1063 VDD VSS sg13g2_fill_2
XFILLER_64_493 VDD VSS sg13g2_decap_4
XFILLER_101_25 VDD VSS sg13g2_decap_8
XFILLER_80_953 VDD VSS sg13g2_fill_2
XFILLER_149_1085 VDD VSS sg13g2_decap_8
X_08404_ _08410_/A _07826_/X _08306_/A _08523_/B1 _08436_/B _08402_/Y VDD VSS sg13g2_a221oi_1
XFILLER_51_143 VDD VSS sg13g2_decap_8
X_09384_ _13987_/D _09914_/A1 _13987_/Q _09397_/S VDD VSS sg13g2_mux2_1
XFILLER_36_1222 VDD VSS sg13g2_decap_8
XFILLER_162_1241 VDD VSS sg13g2_decap_8
XFILLER_75_1293 VDD VSS sg13g2_decap_8
X_08335_ _15230_/D _08335_/A _08335_/B _08335_/C _08335_/D VDD VSS sg13g2_nand4_1
XFILLER_177_18 VDD VSS sg13g2_decap_8
XFILLER_178_885 VDD VSS sg13g2_decap_8
XFILLER_137_215 VDD VSS sg13g2_decap_8
XFILLER_36_1299 VDD VSS sg13g2_decap_8
X_08266_ _08266_/Y _07929_/B _08263_/B _08391_/A VDD VSS sg13g2_a21oi_1
XFILLER_165_546 VDD VSS sg13g2_fill_1
XFILLER_119_952 VDD VSS sg13g2_fill_2
XFILLER_137_248 VDD VSS sg13g2_decap_8
XFILLER_165_557 VDD VSS sg13g2_decap_8
XFILLER_118_440 VDD VSS sg13g2_fill_2
X_14014__2188 _14014_/RESET_B VDD VSS sg13g2_tiehi
X_08197_ _08197_/X _08397_/B _08079_/X _08081_/X _08085_/A _08056_/B _08452_/C VDD
+ VSS sg13g2_mux4_1
XFILLER_4_707 VDD VSS sg13g2_decap_8
XFILLER_10_1428 VDD VSS sg13g2_decap_8
XFILLER_152_229 VDD VSS sg13g2_decap_8
XFILLER_106_635 VDD VSS sg13g2_fill_1
XFILLER_134_944 VDD VSS sg13g2_decap_8
XFILLER_156_1012 VDD VSS sg13g2_decap_8
XFILLER_3_228 VDD VSS sg13g2_decap_8
XFILLER_106_657 VDD VSS sg13g2_decap_8
XFILLER_126_11 VDD VSS sg13g2_decap_4
XFILLER_10_77 VDD VSS sg13g2_decap_8
X_14193__2009 _14193_/RESET_B VDD VSS sg13g2_tiehi
XFILLER_47_1340 VDD VSS sg13g2_decap_8
XFILLER_133_487 VDD VSS sg13g2_decap_8
X_14908__2751 _14908_/RESET_B VDD VSS sg13g2_tiehi
XFILLER_121_638 VDD VSS sg13g2_fill_2
XFILLER_160_273 VDD VSS sg13g2_fill_1
XFILLER_160_284 VDD VSS sg13g2_decap_8
Xfanout1007 _10105_/C _15066_/Q VDD VSS sg13g2_buf_1
X_10090_ _14670_/D _10124_/A0 _14670_/Q _10090_/S VDD VSS sg13g2_mux2_1
XFILLER_0_946 VDD VSS sg13g2_decap_8
Xfanout1018 _09060_/S fanout1026/X VDD VSS sg13g2_buf_1
XFILLER_82_1253 VDD VSS sg13g2_decap_8
Xfanout1029 _10793_/B fanout1031/X VDD VSS sg13g2_buf_1
XFILLER_87_530 VDD VSS sg13g2_decap_8
XFILLER_120_159 VDD VSS sg13g2_decap_8
XFILLER_134_1376 VDD VSS sg13g2_decap_8
XFILLER_19_42 VDD VSS sg13g2_decap_8
XFILLER_43_1259 VDD VSS sg13g2_decap_8
XFILLER_134_1387 VDD VSS sg13g2_fill_1
XFILLER_75_725 VDD VSS sg13g2_fill_2
XFILLER_75_736 VDD VSS sg13g2_fill_1
XFILLER_169_1406 VDD VSS sg13g2_decap_8
XFILLER_75_747 VDD VSS sg13g2_decap_8
XFILLER_47_449 VDD VSS sg13g2_decap_8
XFILLER_142_54 VDD VSS sg13g2_decap_8
XFILLER_28_630 VDD VSS sg13g2_fill_2
X_12800_ _12800_/X _12866_/A _12900_/C _12899_/C input20/X VDD VSS sg13g2_and4_1
X_13780_ _13780_/Q clkload15/A _13780_/D _13780_/RESET_B VDD VSS sg13g2_dfrbpq_1
XFILLER_27_140 VDD VSS sg13g2_decap_8
X_10992_ _10992_/X _11009_/C _10992_/B VDD VSS sg13g2_xor2_1
XFILLER_28_674 VDD VSS sg13g2_fill_2
XFILLER_76_1024 VDD VSS sg13g2_fill_2
X_12731_ _12731_/X _14710_/Q _14742_/Q _13782_/Q _13814_/Q _12731_/S0 _12731_/S1 VDD
+ VSS sg13g2_mux4_1
XFILLER_42_110 VDD VSS sg13g2_decap_8
XFILLER_42_132 VDD VSS sg13g2_decap_4
XFILLER_128_1136 VDD VSS sg13g2_decap_8
XFILLER_167_1185 VDD VSS sg13g2_decap_8
XFILLER_76_1068 VDD VSS sg13g2_fill_2
XFILLER_31_817 VDD VSS sg13g2_decap_8
X_12662_ _12662_/X _12655_/X _12659_/X _12654_/X _12658_/X _12776_/S _12663_/S1 VDD
+ VSS sg13g2_mux4_1
XFILLER_54_1311 VDD VSS sg13g2_decap_8
X_14224__1978 _14224_/RESET_B VDD VSS sg13g2_tiehi
Xclkbuf_leaf_63_clk_i clkload79/A clkbuf_leaf_64_clk_i/A VDD VSS sg13g2_buf_8
XFILLER_106_1401 VDD VSS sg13g2_decap_8
X_14401_ _14401_/Q clkload8/A _14401_/D _14401_/RESET_B VDD VSS sg13g2_dfrbpq_1
XFILLER_19_1464 VDD VSS sg13g2_decap_8
X_11613_ _11613_/Y _11609_/Y _11610_/Y _11612_/Y _11611_/Y _11615_/B VDD VSS sg13g2_a221oi_1
XFILLER_15_1306 VDD VSS sg13g2_decap_8
XFILLER_30_338 VDD VSS sg13g2_decap_8
X_12593_ _12593_/X _12592_/X _12591_/X _12588_/X _12587_/X _12594_/S0 _12511_/S VDD
+ VSS sg13g2_mux4_1
XFILLER_141_1325 VDD VSS sg13g2_decap_8
XFILLER_129_738 VDD VSS sg13g2_fill_1
XFILLER_156_513 VDD VSS sg13g2_decap_8
XFILLER_180_1385 VDD VSS sg13g2_decap_8
X_14332_ _14332_/Q _14588_/CLK _14332_/D _14332_/RESET_B VDD VSS sg13g2_dfrbpq_1
XFILLER_54_1388 VDD VSS sg13g2_decap_8
XFILLER_51_40 VDD VSS sg13g2_decap_4
XFILLER_106_1467 VDD VSS sg13g2_fill_2
XFILLER_184_833 VDD VSS sg13g2_decap_8
X_11544_ _11544_/Y _11531_/A _14404_/Q _11532_/C VDD VSS sg13g2_a21oi_1
XFILLER_11_585 VDD VSS sg13g2_decap_8
XFILLER_89_1418 VDD VSS sg13g2_decap_8
XFILLER_128_248 VDD VSS sg13g2_fill_2
XFILLER_156_557 VDD VSS sg13g2_decap_8
X_15119__2744 _15119_/RESET_B VDD VSS sg13g2_tiehi
XFILLER_144_708 VDD VSS sg13g2_decap_8
XFILLER_51_84 VDD VSS sg13g2_fill_1
XFILLER_183_354 VDD VSS sg13g2_decap_8
X_13789__2413 _13789_/RESET_B VDD VSS sg13g2_tiehi
X_14263_ _14263_/Q clkload41/A _14263_/D _14263_/RESET_B VDD VSS sg13g2_dfrbpq_1
XFILLER_144_719 VDD VSS sg13g2_fill_2
Xclkbuf_leaf_78_clk_i clkload87/A clkbuf_leaf_78_clk_i/A VDD VSS sg13g2_buf_8
X_11475_ _11477_/B _11957_/A _11475_/B VDD VSS sg13g2_nor2_1
XFILLER_7_567 VDD VSS sg13g2_decap_8
XFILLER_167_95 VDD VSS sg13g2_decap_8
X_13214_ _13215_/B _14920_/Q _13667_/Q _13203_/Y VDD VSS sg13g2_a21oi_1
X_10426_ _10426_/Y _14831_/Q _10453_/C _10441_/C VDD VSS sg13g2_o21ai_1
XFILLER_13_1096 VDD VSS sg13g2_decap_8
X_14194_ _14194_/Q clkload40/A _14194_/D _14194_/RESET_B VDD VSS sg13g2_dfrbpq_1
XFILLER_174_1112 VDD VSS sg13g2_decap_8
XFILLER_178_1292 VDD VSS sg13g2_decap_8
XFILLER_125_977 VDD VSS sg13g2_decap_8
XFILLER_151_240 VDD VSS sg13g2_fill_1
X_13145_ _13145_/Y _13145_/A VDD VSS sg13g2_inv_1
XFILLER_124_465 VDD VSS sg13g2_decap_8
X_10357_ _10358_/C _14807_/Q _14808_/Q _14811_/Q _10357_/D VDD VSS sg13g2_and4_1
XFILLER_135_1118 VDD VSS sg13g2_decap_8
XFILLER_151_262 VDD VSS sg13g2_fill_2
XFILLER_135_1129 VDD VSS sg13g2_fill_2
XFILLER_140_947 VDD VSS sg13g2_fill_2
X_14169__2033 _14169_/RESET_B VDD VSS sg13g2_tiehi
XFILLER_3_795 VDD VSS sg13g2_decap_8
XFILLER_112_649 VDD VSS sg13g2_fill_1
XFILLER_152_1410 VDD VSS sg13g2_decap_8
XFILLER_174_1189 VDD VSS sg13g2_decap_8
X_13076_ _13076_/Y _13064_/A _13064_/B _13172_/B VDD VSS sg13g2_a21oi_1
XFILLER_32_7 VDD VSS sg13g2_decap_8
X_10288_ _10294_/C _10297_/A _10288_/B VDD VSS sg13g2_nor2_1
XFILLER_26_1424 VDD VSS sg13g2_decap_8
XFILLER_78_541 VDD VSS sg13g2_decap_8
XFILLER_2_294 VDD VSS sg13g2_decap_8
X_12027_ _12027_/Y _12027_/A _12027_/B _12219_/S VDD VSS sg13g2_nand3_1
XFILLER_61_1337 VDD VSS sg13g2_decap_8
XFILLER_39_928 VDD VSS sg13g2_decap_8
XFILLER_120_682 VDD VSS sg13g2_decap_8
XFILLER_76_70 VDD VSS sg13g2_decap_8
Xclkbuf_leaf_16_clk_i _15230_/CLK clkbuf_5_6__f_clk_i/X VDD VSS sg13g2_buf_8
XFILLER_4_1253 VDD VSS sg13g2_decap_8
XFILLER_111_1140 VDD VSS sg13g2_fill_1
XFILLER_20_1023 VDD VSS sg13g2_decap_8
XFILLER_65_268 VDD VSS sg13g2_decap_8
XFILLER_53_408 VDD VSS sg13g2_decap_8
X_13978_ _13978_/Q clkload78/A _13978_/D _13978_/RESET_B VDD VSS sg13g2_dfrbpq_1
XFILLER_98_1260 VDD VSS sg13g2_decap_4
XFILLER_93_588 VDD VSS sg13g2_fill_2
XFILLER_98_1271 VDD VSS sg13g2_decap_4
XFILLER_46_460 VDD VSS sg13g2_decap_8
XFILLER_0_1128 VDD VSS sg13g2_decap_8
XFILLER_59_1233 VDD VSS sg13g2_decap_8
XFILLER_19_696 VDD VSS sg13g2_decap_8
X_12929_ _12929_/Y _14871_/Q _12947_/B VDD VSS sg13g2_nand2_1
XFILLER_34_633 VDD VSS sg13g2_fill_2
XFILLER_94_1146 VDD VSS sg13g2_fill_1
XFILLER_34_644 VDD VSS sg13g2_decap_8
XFILLER_33_121 VDD VSS sg13g2_decap_8
XFILLER_185_1285 VDD VSS sg13g2_decap_8
XFILLER_62_975 VDD VSS sg13g2_decap_8
XFILLER_181_1127 VDD VSS sg13g2_decap_8
XFILLER_178_126 VDD VSS sg13g2_decap_8
XFILLER_34_688 VDD VSS sg13g2_fill_2
XFILLER_33_176 VDD VSS sg13g2_decap_8
XFILLER_72_1433 VDD VSS sg13g2_decap_8
X_14976__2634 _14976_/RESET_B VDD VSS sg13g2_tiehi
X_08120_ _08120_/Y _08119_/X _08511_/S VDD VSS sg13g2_nand2b_1
XFILLER_147_524 VDD VSS sg13g2_fill_1
XFILLER_147_546 VDD VSS sg13g2_decap_4
XFILLER_30_894 VDD VSS sg13g2_fill_1
XFILLER_135_708 VDD VSS sg13g2_fill_2
X_08051_ _08051_/Y _08079_/S _08397_/B VDD VSS sg13g2_nor2_1
XFILLER_116_900 VDD VSS sg13g2_decap_4
X_14379__1823 _14379_/RESET_B VDD VSS sg13g2_tiehi
XFILLER_122_1280 VDD VSS sg13g2_decap_8
XFILLER_31_1174 VDD VSS sg13g2_decap_8
XFILLER_128_793 VDD VSS sg13g2_decap_4
XFILLER_179_1078 VDD VSS sg13g2_decap_8
XFILLER_115_410 VDD VSS sg13g2_decap_8
XFILLER_127_281 VDD VSS sg13g2_decap_8
XFILLER_157_1343 VDD VSS sg13g2_decap_8
Xhold3104 input3/A mem_axi_bvalid VDD VSS sg13g2_dlygate4sd3_1
Xhold3115 _13635_/A _13743_/Q VDD VSS sg13g2_dlygate4sd3_1
XFILLER_118_1338 VDD VSS sg13g2_fill_2
XFILLER_130_413 VDD VSS sg13g2_fill_2
XFILLER_170_582 VDD VSS sg13g2_decap_8
Xhold3126 _13625_/A _13733_/Q VDD VSS sg13g2_dlygate4sd3_1
XFILLER_103_638 VDD VSS sg13g2_decap_8
Xhold3137 _13643_/A _13751_/Q VDD VSS sg13g2_dlygate4sd3_1
X_08953_ _13721_/D _08956_/S _08951_/Y _08952_/Y VDD VSS sg13g2_a21oi_1
XFILLER_9_1120 VDD VSS sg13g2_decap_8
XFILLER_102_126 VDD VSS sg13g2_decap_8
XFILLER_130_435 VDD VSS sg13g2_decap_8
Xhold3148 _10987_/A _14941_/Q VDD VSS sg13g2_dlygate4sd3_1
X_15059__2520 _15059_/RESET_B VDD VSS sg13g2_tiehi
Xhold3159 _10850_/A _14931_/Q VDD VSS sg13g2_dlygate4sd3_1
XFILLER_97_850 VDD VSS sg13g2_fill_1
X_07904_ _07905_/C _07904_/A _07904_/B _07904_/C _08402_/B VDD VSS sg13g2_nand4_1
XFILLER_9_1164 VDD VSS sg13g2_decap_8
XFILLER_111_660 VDD VSS sg13g2_decap_8
X_08884_ _08884_/Y _10697_/C _08977_/C _15035_/Q VDD VSS sg13g2_nand3_1
XFILLER_84_500 VDD VSS sg13g2_decap_4
XFILLER_57_736 VDD VSS sg13g2_decap_4
XFILLER_110_170 VDD VSS sg13g2_decap_8
X_07835_ _07835_/Y _07979_/C _07981_/C VDD VSS sg13g2_nand2_1
XFILLER_99_1057 VDD VSS sg13g2_fill_2
XFILLER_99_1068 VDD VSS sg13g2_decap_8
XFILLER_56_257 VDD VSS sg13g2_decap_8
XFILLER_44_408 VDD VSS sg13g2_fill_2
X_07766_ _07766_/Y _14762_/Q _07766_/B VDD VSS sg13g2_nor2_1
XFILLER_112_35 VDD VSS sg13g2_decap_8
X_09505_ _14105_/D _10101_/A0 _14105_/Q _09505_/S VDD VSS sg13g2_mux2_1
XFILLER_168_1461 VDD VSS sg13g2_decap_8
X_13867__2335 _13867_/RESET_B VDD VSS sg13g2_tiehi
XFILLER_77_1355 VDD VSS sg13g2_decap_8
X_07697_ _07700_/A _07697_/A _13558_/C VDD VSS sg13g2_nand2_1
XFILLER_24_121 VDD VSS sg13g2_decap_8
XFILLER_13_806 VDD VSS sg13g2_decap_4
XFILLER_38_1328 VDD VSS sg13g2_decap_8
XFILLER_164_1336 VDD VSS sg13g2_decap_8
X_09436_ _14038_/D _10098_/A0 _14038_/Q _09440_/S VDD VSS sg13g2_mux2_1
XFILLER_53_986 VDD VSS sg13g2_fill_1
XFILLER_169_126 VDD VSS sg13g2_decap_4
X_14771__2965 _14771_/RESET_B VDD VSS sg13g2_tiehi
X_09367_ _13971_/D _10062_/A0 _13971_/Q _09372_/S VDD VSS sg13g2_mux2_1
XFILLER_166_811 VDD VSS sg13g2_decap_8
XFILLER_184_107 VDD VSS sg13g2_decap_8
XFILLER_138_513 VDD VSS sg13g2_fill_2
XFILLER_162_1071 VDD VSS sg13g2_decap_8
X_08318_ _08319_/B _08318_/A _08318_/B _08318_/C _08318_/D VDD VSS sg13g2_nand4_1
XFILLER_21_883 VDD VSS sg13g2_fill_1
X_09298_ _13906_/D _13906_/Q _10161_/A1 _09304_/S VDD VSS sg13g2_mux2_1
XFILLER_166_855 VDD VSS sg13g2_fill_1
XFILLER_177_192 VDD VSS sg13g2_decap_8
XFILLER_126_708 VDD VSS sg13g2_decap_8
X_15100__2794 _15100_/RESET_B VDD VSS sg13g2_tiehi
XFILLER_126_719 VDD VSS sg13g2_fill_2
XFILLER_165_354 VDD VSS sg13g2_decap_8
XFILLER_166_888 VDD VSS sg13g2_decap_8
X_08249_ _08250_/B _08369_/B _07927_/Y _08248_/Y VDD VSS sg13g2_a21oi_1
XFILLER_21_32 VDD VSS sg13g2_decap_8
XFILLER_21_43 VDD VSS sg13g2_fill_1
XFILLER_4_504 VDD VSS sg13g2_decap_8
XFILLER_115_4 VDD VSS sg13g2_fill_2
XFILLER_137_21 VDD VSS sg13g2_decap_8
XFILLER_10_1225 VDD VSS sg13g2_decap_8
XFILLER_14_1394 VDD VSS sg13g2_decap_8
X_11260_ _11260_/Y _12328_/A1 _13852_/Q _12326_/B1 VDD VSS sg13g2_a21oi_1
XFILLER_106_421 VDD VSS sg13g2_decap_8
XFILLER_118_281 VDD VSS sg13g2_decap_8
Xclkbuf_5_17__f_clk_i clkload3/A clkbuf_4_8_0_clk_i/X VDD VSS sg13g2_buf_16
X_10211_ _10211_/Y _14763_/Q _10210_/Y VDD VSS sg13g2_nor2b_1
XFILLER_84_1337 VDD VSS sg13g2_decap_8
XFILLER_122_914 VDD VSS sg13g2_decap_8
XFILLER_175_1454 VDD VSS sg13g2_decap_8
X_11191_ _11191_/Y _11191_/A _11205_/B VDD VSS sg13g2_nor2_1
XFILLER_49_1457 VDD VSS sg13g2_decap_8
XFILLER_136_1416 VDD VSS sg13g2_decap_8
XFILLER_106_487 VDD VSS sg13g2_fill_2
XFILLER_161_571 VDD VSS sg13g2_fill_2
XFILLER_122_947 VDD VSS sg13g2_decap_8
XFILLER_0_721 VDD VSS sg13g2_decap_8
XFILLER_161_593 VDD VSS sg13g2_decap_8
XFILLER_171_1329 VDD VSS sg13g2_decap_8
X_10142_ _14719_/D _14719_/Q _10142_/A1 _10163_/S VDD VSS sg13g2_mux2_1
XFILLER_79_338 VDD VSS sg13g2_decap_4
XFILLER_0_743 VDD VSS sg13g2_decap_8
X_14950_ _14950_/Q _15240_/CLK _14950_/D _14950_/RESET_B VDD VSS sg13g2_dfrbpq_1
X_10073_ _14653_/D _10073_/A0 _14653_/Q _10101_/S VDD VSS sg13g2_mux2_1
XFILLER_153_53 VDD VSS sg13g2_decap_8
XFILLER_94_319 VDD VSS sg13g2_decap_8
XFILLER_102_671 VDD VSS sg13g2_decap_8
X_15148__2684 _15148_/RESET_B VDD VSS sg13g2_tiehi
XFILLER_48_736 VDD VSS sg13g2_decap_8
X_13901_ _13901_/Q clkload26/A _13901_/D _13901_/RESET_B VDD VSS sg13g2_dfrbpq_1
XFILLER_134_1195 VDD VSS sg13g2_decap_8
XFILLER_169_1203 VDD VSS sg13g2_decap_8
X_14881_ _14881_/Q clkload90/A _14881_/D _14881_/RESET_B VDD VSS sg13g2_dfrbpq_1
XFILLER_87_393 VDD VSS sg13g2_decap_8
XFILLER_43_1078 VDD VSS sg13g2_decap_8
XFILLER_101_192 VDD VSS sg13g2_decap_8
X_13832_ _13832_/Q clkload21/A _13832_/D _13832_/RESET_B VDD VSS sg13g2_dfrbpq_1
XFILLER_63_717 VDD VSS sg13g2_decap_8
XFILLER_60_1392 VDD VSS sg13g2_decap_8
XFILLER_21_1365 VDD VSS sg13g2_decap_8
XFILLER_95_1422 VDD VSS sg13g2_decap_8
XFILLER_44_920 VDD VSS sg13g2_decap_4
XFILLER_62_227 VDD VSS sg13g2_decap_8
X_13763_ _13763_/Q _14725_/CLK _13763_/D _13763_/RESET_B VDD VSS sg13g2_dfrbpq_1
X_14457__1745 _14457_/RESET_B VDD VSS sg13g2_tiehi
X_10975_ _11009_/D _15115_/Q _10995_/A VDD VSS sg13g2_xnor2_1
XFILLER_44_953 VDD VSS sg13g2_decap_8
XFILLER_44_964 VDD VSS sg13g2_fill_2
XFILLER_182_1425 VDD VSS sg13g2_decap_8
X_12714_ _12714_/X _14133_/Q _14165_/Q _14197_/Q _14229_/Q _12716_/S0 _12716_/S1 VDD
+ VSS sg13g2_mux4_1
XFILLER_44_986 VDD VSS sg13g2_decap_8
XFILLER_43_452 VDD VSS sg13g2_fill_1
X_13694_ _16856_/A _14668_/CLK _13694_/D _13694_/RESET_B VDD VSS sg13g2_dfrbpq_1
X_12645_ _12645_/X _13744_/Q _14096_/Q _14448_/Q _14544_/Q _12699_/S0 _12699_/S1 VDD
+ VSS sg13g2_mux4_1
XFILLER_19_1261 VDD VSS sg13g2_decap_8
XFILLER_106_1220 VDD VSS sg13g2_decap_4
XFILLER_157_811 VDD VSS sg13g2_decap_8
XFILLER_15_1103 VDD VSS sg13g2_decap_8
XFILLER_12_872 VDD VSS sg13g2_decap_4
XFILLER_156_310 VDD VSS sg13g2_fill_2
XFILLER_180_1182 VDD VSS sg13g2_decap_8
XFILLER_54_1185 VDD VSS sg13g2_decap_8
XFILLER_106_1253 VDD VSS sg13g2_decap_8
X_12576_ _12576_/X _14699_/Q _14731_/Q _13771_/Q _13803_/Q _12576_/S0 _12576_/S1 VDD
+ VSS sg13g2_mux4_1
X_14672__1530 _14672_/RESET_B VDD VSS sg13g2_tiehi
XFILLER_168_192 VDD VSS sg13g2_decap_8
XFILLER_11_382 VDD VSS sg13g2_decap_8
XFILLER_156_343 VDD VSS sg13g2_fill_1
X_14315_ _14315_/Q _14729_/CLK _14315_/D _14315_/RESET_B VDD VSS sg13g2_dfrbpq_1
XFILLER_157_877 VDD VSS sg13g2_decap_8
X_11527_ _11527_/Y _11527_/A _11636_/B VDD VSS sg13g2_xnor2_1
XFILLER_8_865 VDD VSS sg13g2_decap_8
XFILLER_89_1237 VDD VSS sg13g2_fill_1
XFILLER_7_56 VDD VSS sg13g2_decap_8
XFILLER_144_516 VDD VSS sg13g2_decap_4
XFILLER_183_151 VDD VSS sg13g2_decap_8
XFILLER_172_836 VDD VSS sg13g2_decap_8
XFILLER_7_364 VDD VSS sg13g2_decap_8
X_14246_ _14246_/Q clkload52/A _14246_/D _14246_/RESET_B VDD VSS sg13g2_dfrbpq_1
X_11458_ _11458_/Y _11458_/A _11458_/B VDD VSS sg13g2_nor2_1
XFILLER_171_368 VDD VSS sg13g2_decap_8
X_10409_ _14825_/D _14825_/Q _10406_/A _10408_/Y VDD VSS sg13g2_a21oi_1
XFILLER_139_1051 VDD VSS sg13g2_decap_8
X_14177_ _14177_/Q clkload9/A _14177_/D _14177_/RESET_B VDD VSS sg13g2_dfrbpq_1
X_11389_ _11389_/Y _11403_/S0 _13855_/Q _11391_/B VDD VSS sg13g2_a21oi_1
XFILLER_152_593 VDD VSS sg13g2_decap_8
X_13128_ _13146_/A _14915_/Q _13129_/B VDD VSS sg13g2_nand2_1
X_13945__2257 _13945_/RESET_B VDD VSS sg13g2_tiehi
XFILLER_112_435 VDD VSS sg13g2_decap_8
XFILLER_3_592 VDD VSS sg13g2_decap_8
XFILLER_30_4 VDD VSS sg13g2_decap_8
XFILLER_65_1270 VDD VSS sg13g2_decap_8
XFILLER_26_1221 VDD VSS sg13g2_decap_8
XFILLER_140_766 VDD VSS sg13g2_decap_8
XFILLER_79_861 VDD VSS sg13g2_decap_8
X_13059_ _13066_/C _12993_/B _12993_/C _13058_/Y VDD VSS sg13g2_a21oi_1
XFILLER_87_80 VDD VSS sg13g2_decap_8
XFILLER_113_1213 VDD VSS sg13g2_decap_8
XFILLER_121_991 VDD VSS sg13g2_fill_1
XFILLER_117_1393 VDD VSS sg13g2_decap_8
XFILLER_22_1118 VDD VSS sg13g2_decap_8
Xfanout1360 _11814_/S0 fanout1361/X VDD VSS sg13g2_buf_1
XFILLER_94_831 VDD VSS sg13g2_decap_8
XFILLER_6_1348 VDD VSS sg13g2_decap_8
Xfanout1371 fanout1371/X _12140_/S0 VDD VSS sg13g2_buf_1
XFILLER_120_490 VDD VSS sg13g2_decap_4
Xfanout1382 _12186_/A fanout1388/X VDD VSS sg13g2_buf_1
XFILLER_38_235 VDD VSS sg13g2_decap_8
XFILLER_26_1298 VDD VSS sg13g2_decap_8
Xfanout1393 _11221_/S0 fanout1394/X VDD VSS sg13g2_buf_1
XFILLER_66_555 VDD VSS sg13g2_decap_4
XFILLER_54_706 VDD VSS sg13g2_fill_2
X_07620_ _07620_/Y _14880_/Q VDD VSS sg13g2_inv_1
XFILLER_93_352 VDD VSS sg13g2_decap_8
XFILLER_94_886 VDD VSS sg13g2_decap_8
XFILLER_4_1050 VDD VSS sg13g2_decap_8
XFILLER_94_897 VDD VSS sg13g2_fill_2
XFILLER_47_780 VDD VSS sg13g2_decap_8
XFILLER_35_986 VDD VSS sg13g2_decap_8
XFILLER_146_1033 VDD VSS sg13g2_decap_8
XFILLER_185_1082 VDD VSS sg13g2_decap_8
XFILLER_22_614 VDD VSS sg13g2_fill_1
XFILLER_35_997 VDD VSS sg13g2_fill_1
XFILLER_59_1096 VDD VSS sg13g2_decap_8
XFILLER_21_102 VDD VSS sg13g2_decap_8
X_09221_ _13832_/D _10151_/A1 _13832_/Q _09225_/S VDD VSS sg13g2_mux2_1
XFILLER_72_1230 VDD VSS sg13g2_decap_8
XFILLER_37_1350 VDD VSS sg13g2_decap_8
XFILLER_22_658 VDD VSS sg13g2_fill_1
XFILLER_50_967 VDD VSS sg13g2_decap_8
XFILLER_163_1380 VDD VSS sg13g2_decap_8
X_09152_ _09152_/Y _09151_/A _09148_/Y _09151_/Y VDD VSS sg13g2_o21ai_1
XFILLER_33_1247 VDD VSS sg13g2_decap_8
XFILLER_124_1364 VDD VSS sg13g2_fill_2
X_14502__1700 _14502_/RESET_B VDD VSS sg13g2_tiehi
XFILLER_120_1206 VDD VSS sg13g2_fill_2
XFILLER_175_652 VDD VSS sg13g2_decap_8
X_08103_ _08104_/D _08200_/A _08200_/B _08103_/C VDD VSS sg13g2_nor3_1
XFILLER_174_140 VDD VSS sg13g2_decap_8
X_09083_ _09083_/Y _09090_/A _09079_/Y _09082_/Y VDD VSS sg13g2_o21ai_1
XFILLER_135_516 VDD VSS sg13g2_fill_1
XFILLER_159_1416 VDD VSS sg13g2_decap_8
XFILLER_162_302 VDD VSS sg13g2_decap_8
XFILLER_163_847 VDD VSS sg13g2_fill_2
X_08034_ _08637_/B _08659_/A _08600_/B VDD VSS sg13g2_nor2_1
XFILLER_162_368 VDD VSS sg13g2_fill_1
XFILLER_131_711 VDD VSS sg13g2_decap_8
XFILLER_157_1162 VDD VSS sg13g2_decap_8
XFILLER_1_518 VDD VSS sg13g2_decap_8
XFILLER_143_582 VDD VSS sg13g2_decap_8
XFILLER_103_435 VDD VSS sg13g2_decap_8
XFILLER_131_744 VDD VSS sg13g2_decap_4
XFILLER_170_390 VDD VSS sg13g2_decap_8
X_14535__1667 _14535_/RESET_B VDD VSS sg13g2_tiehi
X_09985_ _14568_/D _10084_/A0 _14568_/Q _09991_/S VDD VSS sg13g2_mux2_1
XFILLER_107_68 VDD VSS sg13g2_fill_2
XFILLER_131_777 VDD VSS sg13g2_decap_8
X_08936_ _08936_/X _15048_/Q _14952_/Q _08936_/S VDD VSS sg13g2_mux2_1
XFILLER_170_1340 VDD VSS sg13g2_decap_8
XFILLER_44_1354 VDD VSS sg13g2_decap_8
XFILLER_40_1207 VDD VSS sg13g2_decap_8
X_14789__2947 _14789_/RESET_B VDD VSS sg13g2_tiehi
XFILLER_69_393 VDD VSS sg13g2_fill_1
X_08867_ _08867_/X _08866_/X _11526_/A _08875_/S VDD VSS sg13g2_mux2_1
X_07818_ _07818_/Y _15010_/Q _07818_/B VDD VSS sg13g2_xnor2_1
XFILLER_72_514 VDD VSS sg13g2_decap_8
XFILLER_44_205 VDD VSS sg13g2_decap_8
XFILLER_123_78 VDD VSS sg13g2_decap_4
X_08798_ _08799_/B _12942_/B _08810_/B VDD VSS sg13g2_nor2_1
XFILLER_166_1409 VDD VSS sg13g2_decap_8
Xclkbuf_4_1_0_clk_i clkbuf_4_1_0_clk_i/X clkbuf_0_clk_i/X VDD VSS sg13g2_buf_8
XFILLER_84_396 VDD VSS sg13g2_decap_8
XFILLER_38_791 VDD VSS sg13g2_decap_4
X_07749_ _07750_/A _07738_/Y _07744_/D _07748_/Y VDD VSS sg13g2_o21ai_1
XFILLER_16_32 VDD VSS sg13g2_decap_8
XFILLER_77_1152 VDD VSS sg13g2_decap_8
XFILLER_164_1111 VDD VSS sg13g2_fill_2
XFILLER_26_975 VDD VSS sg13g2_fill_2
XFILLER_73_1005 VDD VSS sg13g2_decap_8
X_10760_ _10760_/Y _13156_/A _11133_/B VDD VSS sg13g2_nand2_1
XFILLER_129_1264 VDD VSS sg13g2_decap_8
XFILLER_53_794 VDD VSS sg13g2_decap_8
XFILLER_40_422 VDD VSS sg13g2_decap_8
XFILLER_186_917 VDD VSS sg13g2_decap_8
X_09419_ _14021_/D _09617_/A0 _14021_/Q _09430_/S VDD VSS sg13g2_mux2_1
XFILLER_13_658 VDD VSS sg13g2_decap_8
XFILLER_52_293 VDD VSS sg13g2_fill_2
X_10691_ _10691_/X _14931_/Q _08998_/X _10694_/S VDD VSS sg13g2_mux2_1
XFILLER_55_1461 VDD VSS sg13g2_decap_8
XFILLER_157_107 VDD VSS sg13g2_fill_2
XFILLER_185_427 VDD VSS sg13g2_decap_8
XFILLER_40_466 VDD VSS sg13g2_decap_8
XFILLER_12_168 VDD VSS sg13g2_decap_8
X_12430_ _14994_/D _07910_/A _12624_/C1 _12429_/Y VDD VSS sg13g2_a21oi_1
XFILLER_16_1456 VDD VSS sg13g2_decap_8
XFILLER_32_42 VDD VSS sg13g2_decap_8
XFILLER_139_855 VDD VSS sg13g2_fill_2
XFILLER_51_1347 VDD VSS sg13g2_decap_8
XFILLER_139_877 VDD VSS sg13g2_decap_8
XFILLER_166_663 VDD VSS sg13g2_decap_8
X_12361_ _12361_/X _14236_/Q _14268_/Q _14300_/Q _14332_/Q _12731_/S0 _12731_/S1 VDD
+ VSS sg13g2_mux4_1
XFILLER_20_190 VDD VSS sg13g2_fill_1
XFILLER_165_162 VDD VSS sg13g2_decap_8
XFILLER_154_836 VDD VSS sg13g2_decap_8
X_14100_ _14100_/Q _15005_/CLK _14100_/D _14100_/RESET_B VDD VSS sg13g2_dfrbpq_1
XFILLER_148_75 VDD VSS sg13g2_fill_2
X_11312_ _11312_/Y _11306_/Y _11311_/Y _11330_/S VDD VSS sg13g2_o21ai_1
XFILLER_4_301 VDD VSS sg13g2_decap_8
XFILLER_10_1022 VDD VSS sg13g2_decap_8
XFILLER_165_184 VDD VSS sg13g2_decap_8
X_15080_ _15080_/Q _15203_/CLK _15080_/D _15080_/RESET_B VDD VSS sg13g2_dfrbpq_1
XFILLER_14_1191 VDD VSS sg13g2_decap_8
XFILLER_165_195 VDD VSS sg13g2_fill_2
XFILLER_181_644 VDD VSS sg13g2_decap_8
X_12292_ _12292_/Y _12292_/A _12292_/B VDD VSS sg13g2_nor2_1
XFILLER_88_1270 VDD VSS sg13g2_fill_1
XFILLER_5_868 VDD VSS sg13g2_decap_8
X_14031_ _14031_/Q clkload39/A _14031_/D _14031_/RESET_B VDD VSS sg13g2_dfrbpq_1
XFILLER_180_154 VDD VSS sg13g2_decap_8
X_11243_ _11245_/B _13297_/S _11243_/B _11243_/C VDD VSS sg13g2_or3_1
XFILLER_107_785 VDD VSS sg13g2_decap_8
XFILLER_175_1251 VDD VSS sg13g2_decap_8
XFILLER_4_378 VDD VSS sg13g2_decap_8
XFILLER_49_1254 VDD VSS sg13g2_decap_8
XFILLER_136_1213 VDD VSS sg13g2_fill_2
XFILLER_10_1099 VDD VSS sg13g2_decap_8
XFILLER_164_63 VDD VSS sg13g2_decap_8
X_11174_ _11177_/C _11127_/A _11127_/B _11173_/Y VDD VSS sg13g2_a21oi_1
XFILLER_84_1167 VDD VSS sg13g2_decap_8
XFILLER_79_135 VDD VSS sg13g2_decap_8
XFILLER_80_1009 VDD VSS sg13g2_decap_8
XFILLER_110_906 VDD VSS sg13g2_decap_8
XFILLER_110_917 VDD VSS sg13g2_fill_1
X_10125_ _14703_/D _10125_/A0 _14703_/Q _10134_/S VDD VSS sg13g2_mux2_1
XFILLER_62_1432 VDD VSS sg13g2_decap_8
XFILLER_121_265 VDD VSS sg13g2_fill_2
XFILLER_122_788 VDD VSS sg13g2_decap_8
XFILLER_122_799 VDD VSS sg13g2_fill_2
XFILLER_103_991 VDD VSS sg13g2_decap_4
XFILLER_23_1416 VDD VSS sg13g2_decap_8
XFILLER_94_127 VDD VSS sg13g2_fill_1
XFILLER_0_595 VDD VSS sg13g2_decap_8
XFILLER_57_50 VDD VSS sg13g2_decap_8
X_14933_ _14933_/Q clkload64/A _14933_/D _14933_/RESET_B VDD VSS sg13g2_dfrbpq_1
X_10056_ _14637_/D _10089_/A0 _14637_/Q _10059_/S VDD VSS sg13g2_mux2_1
XFILLER_94_149 VDD VSS sg13g2_decap_8
XFILLER_76_875 VDD VSS sg13g2_fill_1
XFILLER_180_84 VDD VSS sg13g2_decap_8
X_14864_ _14864_/Q clkload90/A _14864_/D _14864_/RESET_B VDD VSS sg13g2_dfrbpq_1
XFILLER_91_823 VDD VSS sg13g2_decap_8
XFILLER_36_739 VDD VSS sg13g2_decap_4
XFILLER_21_1162 VDD VSS sg13g2_decap_8
X_13815_ _13815_/Q clkload42/A _13815_/D _13815_/RESET_B VDD VSS sg13g2_dfrbpq_1
X_14795_ _14795_/Q clkload89/A _14795_/D _14795_/RESET_B VDD VSS sg13g2_dfrbpq_1
XFILLER_169_1099 VDD VSS sg13g2_fill_2
XFILLER_17_975 VDD VSS sg13g2_decap_8
XFILLER_1_1267 VDD VSS sg13g2_decap_8
XFILLER_182_1222 VDD VSS sg13g2_decap_8
X_13746_ _13746_/Q _14546_/CLK _13746_/D _13746_/RESET_B VDD VSS sg13g2_dfrbpq_1
XFILLER_44_772 VDD VSS sg13g2_decap_8
XFILLER_17_997 VDD VSS sg13g2_decap_8
X_10958_ _14938_/D _10956_/Y _10957_/Y _10941_/X VDD VSS sg13g2_a21o_1
XFILLER_147_1386 VDD VSS sg13g2_decap_8
XFILLER_177_928 VDD VSS sg13g2_decap_8
XFILLER_56_1269 VDD VSS sg13g2_decap_8
X_13677_ _13677_/Q clkload57/A _13677_/D _13677_/RESET_B VDD VSS sg13g2_dfrbpq_1
XFILLER_31_444 VDD VSS sg13g2_fill_2
X_10889_ _10948_/A _14755_/Q _10923_/A VDD VSS sg13g2_xor2_1
XFILLER_182_1299 VDD VSS sg13g2_decap_8
X_12628_ _12628_/X _14383_/Q _14415_/Q _14479_/Q _14511_/Q _12686_/S0 _12686_/S1 VDD
+ VSS sg13g2_mux4_1
X_14613__1589 _14613_/RESET_B VDD VSS sg13g2_tiehi
XFILLER_129_332 VDD VSS sg13g2_fill_1
XFILLER_185_950 VDD VSS sg13g2_decap_8
XFILLER_89_1012 VDD VSS sg13g2_decap_8
XFILLER_117_505 VDD VSS sg13g2_decap_8
X_12559_ _12559_/X _14378_/Q _14410_/Q _14474_/Q _14506_/Q _12616_/S0 _12616_/S1 VDD
+ VSS sg13g2_mux4_1
XFILLER_8_662 VDD VSS sg13g2_decap_8
XFILLER_89_1023 VDD VSS sg13g2_fill_2
XFILLER_106_1094 VDD VSS sg13g2_decap_8
XFILLER_129_376 VDD VSS sg13g2_decap_8
XFILLER_156_162 VDD VSS sg13g2_decap_4
XFILLER_184_471 VDD VSS sg13g2_decap_8
XFILLER_7_161 VDD VSS sg13g2_decap_8
XFILLER_144_324 VDD VSS sg13g2_fill_2
XFILLER_89_1067 VDD VSS sg13g2_decap_4
XFILLER_89_1089 VDD VSS sg13g2_decap_4
XFILLER_171_154 VDD VSS sg13g2_decap_8
X_14229_ _14229_/Q clkload42/A _14229_/D _14229_/RESET_B VDD VSS sg13g2_dfrbpq_1
XFILLER_67_1332 VDD VSS sg13g2_decap_8
XFILLER_171_165 VDD VSS sg13g2_fill_1
XFILLER_176_1059 VDD VSS sg13g2_decap_8
XFILLER_125_560 VDD VSS sg13g2_fill_2
XFILLER_125_571 VDD VSS sg13g2_decap_8
XFILLER_119_1444 VDD VSS sg13g2_decap_4
XFILLER_154_1324 VDD VSS sg13g2_decap_8
XFILLER_171_198 VDD VSS sg13g2_decap_8
Xfanout608 _09031_/A _08972_/S VDD VSS sg13g2_buf_1
XFILLER_98_433 VDD VSS sg13g2_decap_8
XFILLER_63_1218 VDD VSS sg13g2_decap_8
XFILLER_140_530 VDD VSS sg13g2_decap_8
Xfanout619 _08936_/S _08943_/A VDD VSS sg13g2_buf_1
XFILLER_119_1477 VDD VSS sg13g2_fill_2
X_09770_ _14360_/D _14360_/Q _09770_/A1 _09771_/S VDD VSS sg13g2_mux2_1
XFILLER_100_416 VDD VSS sg13g2_fill_1
XFILLER_98_488 VDD VSS sg13g2_decap_8
XFILLER_100_438 VDD VSS sg13g2_fill_1
X_08721_ _15193_/D input20/X _15193_/Q _13479_/S VDD VSS sg13g2_mux2_1
XFILLER_79_691 VDD VSS sg13g2_decap_8
XFILLER_6_1145 VDD VSS sg13g2_decap_8
XFILLER_39_533 VDD VSS sg13g2_fill_1
XFILLER_152_1092 VDD VSS sg13g2_decap_8
XFILLER_26_1095 VDD VSS sg13g2_decap_8
XFILLER_67_875 VDD VSS sg13g2_decap_8
XFILLER_39_566 VDD VSS sg13g2_decap_8
Xfanout1190 _08089_/B2 _13602_/A VDD VSS sg13g2_buf_1
X_08652_ _08661_/A _08659_/A _08336_/Y _08652_/B1 VDD VSS sg13g2_o21ai_1
XFILLER_96_1005 VDD VSS sg13g2_decap_8
XFILLER_82_812 VDD VSS sg13g2_decap_8
XFILLER_66_363 VDD VSS sg13g2_fill_2
XFILLER_94_683 VDD VSS sg13g2_decap_8
XFILLER_81_300 VDD VSS sg13g2_decap_8
XFILLER_39_588 VDD VSS sg13g2_decap_8
XFILLER_54_536 VDD VSS sg13g2_fill_1
X_15071__2886 _15071_/RESET_B VDD VSS sg13g2_tiehi
XFILLER_93_193 VDD VSS sg13g2_decap_8
X_08583_ _08586_/B _07963_/Y _08583_/B VDD VSS sg13g2_nand2b_1
XFILLER_78_1450 VDD VSS sg13g2_decap_8
XFILLER_74_1303 VDD VSS sg13g2_decap_8
XFILLER_165_1420 VDD VSS sg13g2_decap_8
XFILLER_39_1434 VDD VSS sg13g2_decap_8
XFILLER_39_1478 VDD VSS sg13g2_fill_1
XFILLER_161_1317 VDD VSS sg13g2_decap_8
XFILLER_179_265 VDD VSS sg13g2_decap_8
XFILLER_168_939 VDD VSS sg13g2_fill_1
X_09204_ _10105_/B _09441_/A _10004_/B _13279_/D _09204_/D VDD VSS sg13g2_nor4_1
XFILLER_50_775 VDD VSS sg13g2_decap_8
XFILLER_33_1011 VDD VSS sg13g2_decap_8
XFILLER_167_449 VDD VSS sg13g2_decap_8
XFILLER_148_630 VDD VSS sg13g2_fill_2
XFILLER_22_499 VDD VSS sg13g2_fill_1
XFILLER_72_1093 VDD VSS sg13g2_decap_8
X_09135_ _09164_/C _14921_/Q _13199_/A VDD VSS sg13g2_and2_1
XFILLER_136_814 VDD VSS sg13g2_decap_8
XFILLER_108_527 VDD VSS sg13g2_fill_1
XFILLER_159_1213 VDD VSS sg13g2_decap_8
XFILLER_11_1331 VDD VSS sg13g2_decap_8
X_09066_ _09066_/Y _09078_/B _15038_/Q _09065_/Y VDD VSS sg13g2_o21ai_1
XFILLER_162_132 VDD VSS sg13g2_fill_1
XFILLER_151_806 VDD VSS sg13g2_fill_2
XFILLER_135_368 VDD VSS sg13g2_decap_8
X_08017_ _08019_/B _07929_/B _11526_/A _11570_/A _11591_/A _07900_/B _07883_/A VDD
+ VSS sg13g2_mux4_1
XFILLER_2_805 VDD VSS sg13g2_decap_8
XFILLER_123_519 VDD VSS sg13g2_decap_8
XFILLER_85_1432 VDD VSS sg13g2_decap_8
XFILLER_1_315 VDD VSS sg13g2_decap_8
XFILLER_172_1424 VDD VSS sg13g2_decap_8
XFILLER_81_1307 VDD VSS sg13g2_decap_8
XFILLER_46_1449 VDD VSS sg13g2_decap_8
X_09968_ _14552_/D _14552_/Q _10100_/A0 _09970_/S VDD VSS sg13g2_mux2_1
XFILLER_89_499 VDD VSS sg13g2_decap_8
XFILLER_134_66 VDD VSS sg13g2_decap_8
X_08919_ _08919_/X _08918_/X _08919_/A1 _08922_/S VDD VSS sg13g2_mux2_1
XFILLER_134_77 VDD VSS sg13g2_fill_2
X_09899_ _14485_/D _09899_/A0 _14485_/Q _09903_/S VDD VSS sg13g2_mux2_1
XFILLER_58_864 VDD VSS sg13g2_decap_8
XFILLER_40_1015 VDD VSS sg13g2_decap_8
XFILLER_131_1154 VDD VSS sg13g2_decap_8
XFILLER_182_4 VDD VSS sg13g2_decap_8
X_11930_ _11930_/Y _11330_/S _11928_/X _11929_/Y VDD VSS sg13g2_o21ai_1
XFILLER_73_812 VDD VSS sg13g2_decap_8
XFILLER_17_205 VDD VSS sg13g2_decap_8
XFILLER_91_119 VDD VSS sg13g2_decap_4
XFILLER_85_683 VDD VSS sg13g2_fill_2
XFILLER_79_1225 VDD VSS sg13g2_decap_8
XFILLER_73_823 VDD VSS sg13g2_fill_1
XFILLER_166_1206 VDD VSS sg13g2_decap_8
X_11861_ _11861_/Y _11860_/Y _11859_/Y _11846_/Y _11868_/A _11978_/B1 VDD VSS sg13g2_a221oi_1
XFILLER_27_86 VDD VSS sg13g2_decap_4
XFILLER_72_355 VDD VSS sg13g2_fill_2
X_13600_ _13600_/Y _13600_/A _13600_/B _13600_/C VDD VSS sg13g2_nand3_1
X_10812_ _14927_/D _10811_/Y _10810_/Y _10800_/Y VDD VSS sg13g2_o21ai_1
X_14580_ _14580_/Q clkload30/A _14580_/D _14580_/RESET_B VDD VSS sg13g2_dfrbpq_1
XFILLER_150_98 VDD VSS sg13g2_fill_2
X_11792_ _11792_/Y _14910_/Q _11792_/B VDD VSS sg13g2_nand2_1
X_13531_ _13531_/Y _13531_/A _13535_/B VDD VSS sg13g2_nor2_1
XFILLER_92_1458 VDD VSS sg13g2_decap_8
XFILLER_14_967 VDD VSS sg13g2_decap_8
XFILLER_186_714 VDD VSS sg13g2_decap_8
X_10743_ _11078_/A _07615_/Y _09086_/Y _10788_/S VDD VSS sg13g2_mux2_1
XFILLER_185_224 VDD VSS sg13g2_decap_8
X_13462_ _13463_/B _15189_/Q _15190_/Q VDD VSS sg13g2_nand2b_1
XFILLER_159_63 VDD VSS sg13g2_decap_8
X_10674_ _10674_/Y _10674_/A _10800_/B VDD VSS sg13g2_nand2_1
XFILLER_43_96 VDD VSS sg13g2_decap_8
XFILLER_9_448 VDD VSS sg13g2_decap_8
XFILLER_16_1253 VDD VSS sg13g2_decap_8
X_15201_ _15201_/Q _15203_/CLK _15201_/D _15201_/RESET_B VDD VSS sg13g2_dfrbpq_1
X_12413_ _12413_/X _12409_/X _12408_/X _12405_/X _12404_/X _12594_/S0 _12511_/S VDD
+ VSS sg13g2_mux4_1
XFILLER_51_1144 VDD VSS sg13g2_decap_8
XFILLER_103_1223 VDD VSS sg13g2_decap_8
XFILLER_127_814 VDD VSS sg13g2_fill_2
XFILLER_138_140 VDD VSS sg13g2_decap_4
XFILLER_103_1234 VDD VSS sg13g2_fill_2
XFILLER_12_1117 VDD VSS sg13g2_decap_8
XFILLER_167_983 VDD VSS sg13g2_decap_4
X_13393_ _13393_/Y _13446_/A1 _13412_/C _15085_/Q VDD VSS sg13g2_o21ai_1
X_15132_ _15132_/Q clkload31/A _15132_/D _15132_/RESET_B VDD VSS sg13g2_dfrbpq_1
XFILLER_103_1267 VDD VSS sg13g2_decap_8
XFILLER_154_633 VDD VSS sg13g2_decap_8
XFILLER_177_1324 VDD VSS sg13g2_decap_8
X_15046__2556 _15046_/RESET_B VDD VSS sg13g2_tiehi
X_12344_ _12344_/X _14555_/Q _14587_/Q _14619_/Q _14651_/Q _12352_/S0 _12352_/S1 VDD
+ VSS sg13g2_mux4_1
XFILLER_126_335 VDD VSS sg13g2_decap_4
XFILLER_86_1218 VDD VSS sg13g2_decap_8
XFILLER_114_508 VDD VSS sg13g2_fill_1
X_15063_ _15063_/Q _15165_/CLK _15063_/D _15063_/RESET_B VDD VSS sg13g2_dfrbpq_1
XFILLER_5_665 VDD VSS sg13g2_decap_8
XFILLER_107_560 VDD VSS sg13g2_decap_8
XFILLER_182_997 VDD VSS sg13g2_decap_8
X_12275_ _12275_/Y _14986_/Q _13664_/Q _12274_/Y VDD VSS sg13g2_a21oi_1
XFILLER_175_95 VDD VSS sg13g2_decap_8
X_14014_ _14014_/Q clkload53/A _14014_/D _14014_/RESET_B VDD VSS sg13g2_dfrbpq_1
XFILLER_4_175 VDD VSS sg13g2_decap_8
X_11226_ _11226_/X _14235_/Q _14267_/Q _14299_/Q _14331_/Q _11218_/S _11228_/S1 VDD
+ VSS sg13g2_mux4_1
XFILLER_4_35 VDD VSS sg13g2_decap_8
XFILLER_122_530 VDD VSS sg13g2_fill_1
XFILLER_134_390 VDD VSS sg13g2_fill_2
XFILLER_49_1073 VDD VSS sg13g2_decap_8
XFILLER_150_861 VDD VSS sg13g2_decap_8
XFILLER_150_872 VDD VSS sg13g2_fill_2
X_14027__2175 _14027_/RESET_B VDD VSS sg13g2_tiehi
X_11157_ _11173_/C _11171_/B _11164_/C VDD VSS sg13g2_xnor2_1
XFILLER_68_60 VDD VSS sg13g2_decap_8
X_13862__2340 _13862_/RESET_B VDD VSS sg13g2_tiehi
XFILLER_7_1421 VDD VSS sg13g2_decap_8
XFILLER_1_882 VDD VSS sg13g2_decap_8
XFILLER_122_596 VDD VSS sg13g2_decap_8
XFILLER_95_436 VDD VSS sg13g2_decap_8
XFILLER_49_831 VDD VSS sg13g2_decap_4
XFILLER_23_1213 VDD VSS sg13g2_decap_8
X_10108_ _14686_/D _10141_/A1 _14686_/Q _10130_/S VDD VSS sg13g2_mux2_1
XFILLER_0_392 VDD VSS sg13g2_decap_8
XFILLER_114_1341 VDD VSS sg13g2_decap_8
X_11088_ _11091_/A _11088_/A _11118_/B _11118_/A VDD VSS sg13g2_nand3_1
XFILLER_36_503 VDD VSS sg13g2_fill_2
X_14916_ _14916_/Q clkload71/A _14916_/D _14916_/RESET_B VDD VSS sg13g2_dfrbpq_1
X_10039_ _14620_/D _10072_/A0 _14620_/Q _10069_/S VDD VSS sg13g2_mux2_1
XFILLER_114_1385 VDD VSS sg13g2_fill_2
XFILLER_76_683 VDD VSS sg13g2_fill_2
XFILLER_91_642 VDD VSS sg13g2_decap_4
XFILLER_64_867 VDD VSS sg13g2_decap_4
XFILLER_149_1437 VDD VSS sg13g2_decap_8
XFILLER_184_1317 VDD VSS sg13g2_decap_8
X_14847_ _14847_/Q _14848_/CLK _14847_/D _14847_/RESET_B VDD VSS sg13g2_dfrbpq_1
XFILLER_24_709 VDD VSS sg13g2_decap_8
XFILLER_51_506 VDD VSS sg13g2_decap_8
XFILLER_1_1064 VDD VSS sg13g2_decap_8
XFILLER_91_697 VDD VSS sg13g2_fill_2
X_14778_ _14778_/Q clkload85/A _14778_/D _14778_/RESET_B VDD VSS sg13g2_dfrbpq_1
XFILLER_32_742 VDD VSS sg13g2_decap_8
X_13729_ _13729_/Q clkload6/A _13729_/D _13729_/RESET_B VDD VSS sg13g2_dfrbpq_1
XFILLER_31_241 VDD VSS sg13g2_decap_4
XFILLER_143_1036 VDD VSS sg13g2_decap_8
XFILLER_108_1167 VDD VSS sg13g2_decap_8
XFILLER_182_1096 VDD VSS sg13g2_decap_8
XFILLER_56_1099 VDD VSS sg13g2_decap_8
XFILLER_34_1320 VDD VSS sg13g2_decap_8
X_15102__2786 _15102_/RESET_B VDD VSS sg13g2_tiehi
XFILLER_129_151 VDD VSS sg13g2_decap_8
XFILLER_185_780 VDD VSS sg13g2_decap_8
XFILLER_34_1397 VDD VSS sg13g2_decap_8
XFILLER_121_1356 VDD VSS sg13g2_fill_2
XFILLER_69_1416 VDD VSS sg13g2_decap_8
XFILLER_121_1367 VDD VSS sg13g2_decap_8
XFILLER_118_869 VDD VSS sg13g2_decap_8
X_14237__1965 _14237_/RESET_B VDD VSS sg13g2_tiehi
XFILLER_144_143 VDD VSS sg13g2_decap_8
XFILLER_172_452 VDD VSS sg13g2_decap_8
X_15168__2522 _15168_/RESET_B VDD VSS sg13g2_tiehi
X_15229__3020 _15229_/RESET_B VDD VSS sg13g2_tiehi
XFILLER_160_658 VDD VSS sg13g2_decap_8
XFILLER_113_530 VDD VSS sg13g2_fill_2
Xfanout405 _10073_/A0 _08978_/Y VDD VSS sg13g2_buf_1
Xfanout416 _12777_/B2 _12372_/A VDD VSS sg13g2_buf_1
Xfanout427 _10023_/S _10030_/S VDD VSS sg13g2_buf_1
X_09822_ _14410_/D _09921_/A1 _14410_/Q _09822_/S VDD VSS sg13g2_mux2_1
XFILLER_63_1037 VDD VSS sg13g2_decap_8
XFILLER_119_1274 VDD VSS sg13g2_decap_8
XFILLER_8_1229 VDD VSS sg13g2_decap_8
XFILLER_86_403 VDD VSS sg13g2_fill_2
XFILLER_119_1285 VDD VSS sg13g2_fill_1
XFILLER_140_360 VDD VSS sg13g2_fill_1
Xfanout438 fanout438/X _09971_/Y VDD VSS sg13g2_buf_1
XFILLER_28_1168 VDD VSS sg13g2_decap_8
XFILLER_154_1176 VDD VSS sg13g2_decap_8
Xfanout449 _09805_/S _09793_/S VDD VSS sg13g2_buf_1
XFILLER_100_213 VDD VSS sg13g2_decap_8
XFILLER_101_736 VDD VSS sg13g2_decap_8
XFILLER_115_1138 VDD VSS sg13g2_decap_4
X_14452__1750 _14452_/RESET_B VDD VSS sg13g2_tiehi
XFILLER_101_747 VDD VSS sg13g2_fill_2
XFILLER_86_447 VDD VSS sg13g2_decap_8
X_09753_ _14343_/D _14343_/Q _09918_/A1 _09762_/S VDD VSS sg13g2_mux2_1
XFILLER_41_1313 VDD VSS sg13g2_decap_8
XFILLER_74_609 VDD VSS sg13g2_fill_1
XFILLER_80_1384 VDD VSS sg13g2_decap_8
XFILLER_100_268 VDD VSS sg13g2_decap_4
X_08704_ _13657_/D _15184_/D _15115_/Q _13651_/S VDD VSS sg13g2_mux2_1
X_09684_ _14276_/D _09882_/A0 _14276_/Q _09692_/S VDD VSS sg13g2_mux2_1
XFILLER_73_119 VDD VSS sg13g2_decap_8
XFILLER_66_160 VDD VSS sg13g2_fill_1
X_08635_ _08635_/X _07845_/B _07850_/B _07853_/B _12129_/B2 _08635_/S0 _08635_/S1
+ VDD VSS sg13g2_mux4_1
XFILLER_70_804 VDD VSS sg13g2_decap_8
XFILLER_14_208 VDD VSS sg13g2_decap_8
X_13725__2477 _13725_/RESET_B VDD VSS sg13g2_tiehi
XFILLER_82_686 VDD VSS sg13g2_decap_8
X_08566_ _08574_/D _08567_/A _08567_/B _08566_/C VDD VSS sg13g2_nor3_1
XFILLER_39_1231 VDD VSS sg13g2_decap_8
XFILLER_11_904 VDD VSS sg13g2_decap_8
XFILLER_161_1114 VDD VSS sg13g2_decap_8
XFILLER_23_764 VDD VSS sg13g2_fill_2
X_08497_ _08497_/Y _08497_/A _08497_/B VDD VSS sg13g2_nand2_1
XFILLER_147_7 VDD VSS sg13g2_decap_4
XFILLER_80_28 VDD VSS sg13g2_decap_8
XFILLER_74_1177 VDD VSS sg13g2_decap_8
XFILLER_50_550 VDD VSS sg13g2_decap_8
XFILLER_165_1294 VDD VSS sg13g2_decap_8
XFILLER_167_213 VDD VSS sg13g2_decap_8
XFILLER_13_11 VDD VSS sg13g2_decap_8
XFILLER_167_246 VDD VSS sg13g2_decap_8
XFILLER_168_769 VDD VSS sg13g2_decap_8
XFILLER_52_1431 VDD VSS sg13g2_decap_8
XFILLER_50_583 VDD VSS sg13g2_decap_8
XFILLER_13_1404 VDD VSS sg13g2_decap_8
XFILLER_183_728 VDD VSS sg13g2_decap_8
X_14105__2097 _14105_/RESET_B VDD VSS sg13g2_tiehi
XFILLER_109_825 VDD VSS sg13g2_decap_8
XFILLER_10_469 VDD VSS sg13g2_decap_8
X_13940__2262 _13940_/RESET_B VDD VSS sg13g2_tiehi
XFILLER_13_88 VDD VSS sg13g2_decap_8
X_09118_ _09118_/Y _09151_/A _10762_/B _09117_/Y VDD VSS sg13g2_o21ai_1
XFILLER_182_249 VDD VSS sg13g2_decap_8
XFILLER_109_869 VDD VSS sg13g2_fill_2
XFILLER_163_430 VDD VSS sg13g2_fill_1
X_10390_ _10392_/C _10369_/Y _10387_/X _14821_/Q VDD VSS sg13g2_a21o_1
XFILLER_100_1429 VDD VSS sg13g2_decap_8
XFILLER_108_346 VDD VSS sg13g2_decap_8
XFILLER_136_666 VDD VSS sg13g2_decap_4
XFILLER_108_368 VDD VSS sg13g2_decap_8
XFILLER_151_603 VDD VSS sg13g2_decap_8
X_09049_ _09049_/Y _14908_/Q _09056_/C _09074_/B1 VDD VSS sg13g2_o21ai_1
X_14989__2621 _14989_/RESET_B VDD VSS sg13g2_tiehi
XFILLER_2_602 VDD VSS sg13g2_decap_8
XFILLER_135_176 VDD VSS sg13g2_decap_8
XFILLER_117_891 VDD VSS sg13g2_decap_8
XFILLER_123_338 VDD VSS sg13g2_decap_8
XFILLER_135_198 VDD VSS sg13g2_decap_8
XFILLER_1_112 VDD VSS sg13g2_decap_8
X_12060_ _12060_/Y _12062_/A _12062_/B VDD VSS sg13g2_nand2_1
XFILLER_8_4 VDD VSS sg13g2_decap_8
XFILLER_137_1330 VDD VSS sg13g2_decap_8
XFILLER_172_1221 VDD VSS sg13g2_decap_8
X_14833__2901 _14833_/RESET_B VDD VSS sg13g2_tiehi
X_11011_ _11011_/Y _11012_/B _11012_/C VDD VSS sg13g2_nor2_1
XFILLER_85_1295 VDD VSS sg13g2_fill_1
XFILLER_46_1246 VDD VSS sg13g2_decap_8
XFILLER_2_679 VDD VSS sg13g2_decap_8
XFILLER_145_76 VDD VSS sg13g2_fill_2
XFILLER_89_263 VDD VSS sg13g2_decap_4
XFILLER_49_105 VDD VSS sg13g2_decap_8
XFILLER_1_189 VDD VSS sg13g2_decap_8
Xfanout950 _12899_/C _12936_/B VDD VSS sg13g2_buf_1
XFILLER_172_1298 VDD VSS sg13g2_decap_8
Xfanout961 _13499_/C _15128_/Q VDD VSS sg13g2_buf_1
Xfanout972 _12879_/B _12976_/B VDD VSS sg13g2_buf_1
Xfanout983 _13051_/B _15106_/Q VDD VSS sg13g2_buf_1
Xfanout994 _10885_/A1 _13345_/B VDD VSS sg13g2_buf_1
XFILLER_58_661 VDD VSS sg13g2_fill_2
XFILLER_161_42 VDD VSS sg13g2_decap_8
XFILLER_38_74 VDD VSS sg13g2_decap_8
X_12962_ _12962_/Y _12960_/Y _12962_/B _13079_/C VDD VSS sg13g2_nand3b_1
XFILLER_38_85 VDD VSS sg13g2_fill_2
XFILLER_46_834 VDD VSS sg13g2_decap_8
X_14866__2835 _14866_/RESET_B VDD VSS sg13g2_tiehi
XFILLER_85_491 VDD VSS sg13g2_decap_8
XFILLER_45_322 VDD VSS sg13g2_decap_8
XFILLER_173_0 VDD VSS sg13g2_decap_8
X_14701_ _14701_/Q clkload26/A _14701_/D _14701_/RESET_B VDD VSS sg13g2_dfrbpq_1
X_11913_ _11917_/A _11913_/A _11913_/B VDD VSS sg13g2_nor2_1
XFILLER_79_1044 VDD VSS sg13g2_decap_8
XFILLER_73_642 VDD VSS sg13g2_decap_8
XFILLER_166_1003 VDD VSS sg13g2_decap_8
XFILLER_73_653 VDD VSS sg13g2_fill_1
XFILLER_18_569 VDD VSS sg13g2_decap_8
X_12893_ _12925_/B _12894_/A _12894_/B VDD VSS sg13g2_nand2_1
XFILLER_2_1351 VDD VSS sg13g2_decap_8
XFILLER_61_815 VDD VSS sg13g2_decap_8
X_14632_ _14632_/Q _14728_/CLK _14632_/D _14632_/RESET_B VDD VSS sg13g2_dfrbpq_1
X_11844_ _11846_/A _11907_/A _11845_/C _11910_/B VDD VSS sg13g2_o21ai_1
X_14315__1887 _14315_/RESET_B VDD VSS sg13g2_tiehi
XFILLER_57_1331 VDD VSS sg13g2_decap_8
XFILLER_54_73 VDD VSS sg13g2_decap_8
XFILLER_18_1315 VDD VSS sg13g2_decap_8
X_14563_ _14563_/Q _14723_/CLK _14563_/D _14563_/RESET_B VDD VSS sg13g2_dfrbpq_1
XFILLER_60_358 VDD VSS sg13g2_decap_8
XFILLER_183_1372 VDD VSS sg13g2_decap_8
X_11775_ _11778_/A _11725_/Y _11772_/Y _11774_/Y VDD VSS sg13g2_o21ai_1
XFILLER_186_511 VDD VSS sg13g2_decap_8
X_14899__2769 _14899_/RESET_B VDD VSS sg13g2_tiehi
XFILLER_92_1277 VDD VSS sg13g2_decap_8
XFILLER_109_1465 VDD VSS sg13g2_fill_1
XFILLER_158_224 VDD VSS sg13g2_decap_8
XFILLER_159_747 VDD VSS sg13g2_decap_4
XFILLER_13_263 VDD VSS sg13g2_decap_8
X_13514_ _15137_/D _15137_/Q _14994_/Q _13515_/S VDD VSS sg13g2_mux2_1
X_10726_ _10995_/A _14940_/Q _10740_/A1 _10725_/Y VDD VSS sg13g2_a21oi_1
XFILLER_158_235 VDD VSS sg13g2_fill_2
X_14494_ _14494_/Q clkload67/A _14494_/D _14494_/RESET_B VDD VSS sg13g2_dfrbpq_1
XFILLER_9_245 VDD VSS sg13g2_decap_8
XFILLER_16_1050 VDD VSS sg13g2_decap_8
X_14494__1708 _14494_/RESET_B VDD VSS sg13g2_tiehi
XFILLER_146_419 VDD VSS sg13g2_fill_2
XFILLER_186_588 VDD VSS sg13g2_decap_8
X_13445_ _15104_/D _15104_/Q _13470_/A2 _13444_/Y VDD VSS sg13g2_a21o_1
X_10657_ _10666_/D _14891_/Q _10663_/D VDD VSS sg13g2_and2_1
XFILLER_139_471 VDD VSS sg13g2_decap_4
XFILLER_167_780 VDD VSS sg13g2_decap_8
X_14530__1672 _14530_/RESET_B VDD VSS sg13g2_tiehi
Xclkload15 clkload15/Y clkload15/A VDD VSS sg13g2_inv_1
Xclkload26 clkload26/Y clkload26/A VDD VSS sg13g2_inv_1
X_13376_ _13376_/Y _13389_/A _13389_/B _13429_/A _13378_/C VDD VSS sg13g2_nor4_1
Xclkload37 clkload37/Y clkload37/A VDD VSS sg13g2_inv_2
XFILLER_103_1064 VDD VSS sg13g2_fill_2
XFILLER_177_1121 VDD VSS sg13g2_decap_8
XFILLER_182_750 VDD VSS sg13g2_decap_8
X_10588_ _14873_/D _12963_/A _10594_/D _10587_/Y VDD VSS sg13g2_a21oi_1
Xclkload48 clkload48/Y clkload48/A VDD VSS sg13g2_inv_8
Xclkload59 clkload59/Y clkload59/A VDD VSS sg13g2_inv_8
XFILLER_6_963 VDD VSS sg13g2_decap_8
XFILLER_138_1105 VDD VSS sg13g2_decap_8
X_15115_ _15115_/Q clkload65/A _15115_/D _15115_/RESET_B VDD VSS sg13g2_dfrbpq_1
X_12327_ _12327_/Y _12328_/A1 _13914_/Q VDD VSS sg13g2_nand2b_1
XFILLER_114_305 VDD VSS sg13g2_fill_2
XFILLER_127_688 VDD VSS sg13g2_decap_4
XFILLER_142_614 VDD VSS sg13g2_decap_8
XFILLER_154_474 VDD VSS sg13g2_decap_4
XFILLER_170_923 VDD VSS sg13g2_decap_8
XFILLER_182_783 VDD VSS sg13g2_fill_2
XFILLER_5_462 VDD VSS sg13g2_decap_8
XFILLER_138_1116 VDD VSS sg13g2_fill_2
X_14784__2952 _14784_/RESET_B VDD VSS sg13g2_tiehi
XFILLER_177_1198 VDD VSS sg13g2_decap_8
X_15046_ _15046_/Q clkload71/A _15046_/D _15046_/RESET_B VDD VSS sg13g2_dfrbpq_1
XFILLER_64_1302 VDD VSS sg13g2_decap_8
XFILLER_29_1422 VDD VSS sg13g2_decap_8
X_12258_ _12258_/Y _12254_/Y _12255_/Y _12257_/Y _12256_/Y _12258_/C1 VDD VSS sg13g2_a221oi_1
XFILLER_155_1452 VDD VSS sg13g2_decap_8
X_13803__2399 _13803_/RESET_B VDD VSS sg13g2_tiehi
X_11209_ _14956_/D _11209_/A _11209_/B VDD VSS sg13g2_nand2_1
XFILLER_68_403 VDD VSS sg13g2_fill_2
XFILLER_116_1425 VDD VSS sg13g2_decap_8
XFILLER_141_179 VDD VSS sg13g2_fill_2
XFILLER_110_511 VDD VSS sg13g2_decap_4
X_12189_ _12190_/A _14710_/Q _14742_/Q _13782_/Q _13814_/Q _12189_/S0 _12169_/C VDD
+ VSS sg13g2_mux4_1
XFILLER_122_382 VDD VSS sg13g2_decap_8
XFILLER_64_1379 VDD VSS sg13g2_decap_8
XFILLER_68_458 VDD VSS sg13g2_decap_8
XFILLER_110_566 VDD VSS sg13g2_decap_4
XFILLER_83_406 VDD VSS sg13g2_decap_8
XFILLER_37_801 VDD VSS sg13g2_decap_4
XFILLER_95_80 VDD VSS sg13g2_decap_8
XFILLER_7_1295 VDD VSS sg13g2_decap_8
XFILLER_95_299 VDD VSS sg13g2_decap_4
XFILLER_110_1024 VDD VSS sg13g2_decap_8
XFILLER_92_940 VDD VSS sg13g2_decap_4
XFILLER_3_1159 VDD VSS sg13g2_decap_8
XFILLER_63_130 VDD VSS sg13g2_decap_8
XFILLER_184_1114 VDD VSS sg13g2_decap_8
X_08420_ _08575_/C _08420_/A _08419_/A VDD VSS sg13g2_nor2b_1
XFILLER_52_826 VDD VSS sg13g2_decap_8
XFILLER_52_837 VDD VSS sg13g2_fill_2
XFILLER_149_1278 VDD VSS sg13g2_decap_8
XFILLER_63_185 VDD VSS sg13g2_decap_8
XFILLER_51_325 VDD VSS sg13g2_decap_8
XFILLER_17_591 VDD VSS sg13g2_decap_4
XFILLER_36_1404 VDD VSS sg13g2_decap_8
X_08351_ _08352_/B _08362_/A2 _08351_/B VDD VSS sg13g2_nand2b_1
XFILLER_162_1423 VDD VSS sg13g2_decap_8
XFILLER_75_1475 VDD VSS sg13g2_decap_4
XFILLER_71_1306 VDD VSS sg13g2_decap_8
XFILLER_177_522 VDD VSS sg13g2_decap_8
XFILLER_20_701 VDD VSS sg13g2_fill_2
XFILLER_20_712 VDD VSS sg13g2_decap_8
X_08282_ _08282_/Y _08452_/A _08234_/Y _08431_/C _08280_/X VDD VSS sg13g2_a22oi_1
XFILLER_123_1429 VDD VSS sg13g2_fill_2
Xclkload9 clkload9/Y clkload9/A VDD VSS sg13g2_inv_2
XFILLER_118_600 VDD VSS sg13g2_decap_8
XFILLER_149_279 VDD VSS sg13g2_decap_8
XFILLER_164_216 VDD VSS sg13g2_decap_8
XFILLER_164_227 VDD VSS sg13g2_fill_2
XFILLER_34_1194 VDD VSS sg13g2_decap_8
XFILLER_69_1213 VDD VSS sg13g2_decap_8
XFILLER_106_806 VDD VSS sg13g2_fill_1
XFILLER_161_912 VDD VSS sg13g2_fill_2
XFILLER_146_997 VDD VSS sg13g2_decap_8
XFILLER_161_923 VDD VSS sg13g2_fill_2
XFILLER_105_316 VDD VSS sg13g2_decap_8
XFILLER_133_625 VDD VSS sg13g2_decap_8
XFILLER_117_187 VDD VSS sg13g2_fill_2
XFILLER_156_1227 VDD VSS sg13g2_fill_2
X_15184__2838 _15184_/RESET_B VDD VSS sg13g2_tiehi
XFILLER_161_989 VDD VSS sg13g2_decap_8
XFILLER_160_466 VDD VSS sg13g2_fill_2
Xfanout202 _10124_/A0 _10157_/A1 VDD VSS sg13g2_buf_1
XFILLER_82_1435 VDD VSS sg13g2_decap_8
Xfanout213 _13154_/A1 _13048_/X VDD VSS sg13g2_buf_1
Xfanout224 _09723_/A0 _09622_/A0 VDD VSS sg13g2_buf_1
XFILLER_8_1026 VDD VSS sg13g2_decap_8
Xfanout235 _12126_/A fanout242/X VDD VSS sg13g2_buf_1
Xfanout246 _10084_/A0 fanout250/X VDD VSS sg13g2_buf_1
XFILLER_59_436 VDD VSS sg13g2_fill_2
XFILLER_101_544 VDD VSS sg13g2_decap_8
Xfanout257 _10082_/A0 _09752_/A1 VDD VSS sg13g2_buf_1
X_09805_ _14394_/D _09904_/A0 _14394_/Q _09805_/S VDD VSS sg13g2_mux2_1
Xfanout268 _09898_/S _09890_/S VDD VSS sg13g2_buf_1
XFILLER_87_767 VDD VSS sg13g2_decap_4
Xfanout279 _09430_/S _09434_/S VDD VSS sg13g2_buf_1
X_07997_ _07997_/Y _15103_/Q _15090_/Q VDD VSS sg13g2_nor2_1
XFILLER_86_255 VDD VSS sg13g2_decap_8
XFILLER_41_1110 VDD VSS sg13g2_decap_8
XFILLER_75_28 VDD VSS sg13g2_fill_2
XFILLER_41_1121 VDD VSS sg13g2_fill_2
X_09736_ _14327_/D _10066_/A0 _14327_/Q _09738_/S VDD VSS sg13g2_mux2_1
XFILLER_39_171 VDD VSS sg13g2_decap_8
X_13958__2244 _13958_/RESET_B VDD VSS sg13g2_tiehi
XFILLER_83_951 VDD VSS sg13g2_decap_8
XFILLER_41_1187 VDD VSS sg13g2_decap_8
X_09667_ _14260_/D _10063_/A0 _14260_/Q _09667_/S VDD VSS sg13g2_mux2_1
XFILLER_131_34 VDD VSS sg13g2_decap_4
XFILLER_70_601 VDD VSS sg13g2_decap_8
X_08618_ _08622_/A _08030_/Y _08537_/X _08036_/B VDD VSS sg13g2_o21ai_1
XFILLER_128_1318 VDD VSS sg13g2_decap_8
XFILLER_15_539 VDD VSS sg13g2_decap_4
XFILLER_167_1367 VDD VSS sg13g2_decap_8
X_09598_ _14195_/D _14195_/Q _10062_/A0 _09604_/S VDD VSS sg13g2_mux2_1
XFILLER_91_38 VDD VSS sg13g2_fill_2
XFILLER_70_645 VDD VSS sg13g2_decap_8
X_08549_ _08549_/Y _08522_/A _08529_/Y _08548_/Y VDD VSS sg13g2_a21oi_1
XFILLER_39_1061 VDD VSS sg13g2_decap_8
XFILLER_24_21 VDD VSS sg13g2_decap_8
XFILLER_42_369 VDD VSS sg13g2_decap_8
X_11560_ _11560_/Y _11540_/Y _11542_/X _11765_/A VDD VSS sg13g2_o21ai_1
XFILLER_168_555 VDD VSS sg13g2_fill_2
XFILLER_156_706 VDD VSS sg13g2_decap_8
XFILLER_23_594 VDD VSS sg13g2_decap_8
XFILLER_128_408 VDD VSS sg13g2_decap_8
X_10511_ _10512_/C _14850_/Q _14845_/Q _14844_/Q _10511_/D VDD VSS sg13g2_nand4_1
XFILLER_13_1201 VDD VSS sg13g2_decap_8
X_11491_ _11491_/X _13730_/Q _14082_/Q _14434_/Q _14530_/Q _11493_/S0 _07654_/A VDD
+ VSS sg13g2_mux4_1
XFILLER_10_266 VDD VSS sg13g2_decap_8
XFILLER_17_1392 VDD VSS sg13g2_decap_8
X_13230_ _13244_/B _13245_/A _13665_/Q VDD VSS sg13g2_xor2_1
XFILLER_7_749 VDD VSS sg13g2_decap_8
X_10442_ _10444_/A _14837_/Q _10442_/B VDD VSS sg13g2_nand2b_1
XFILLER_171_709 VDD VSS sg13g2_decap_8
XFILLER_13_1278 VDD VSS sg13g2_decap_8
XFILLER_104_1395 VDD VSS sg13g2_fill_2
XFILLER_87_1335 VDD VSS sg13g2_decap_8
XFILLER_156_42 VDD VSS sg13g2_decap_8
X_13161_ _13161_/X input19/X _13272_/A2 _13264_/B1 VDD VSS sg13g2_a21o_1
XFILLER_3_900 VDD VSS sg13g2_decap_8
XFILLER_109_699 VDD VSS sg13g2_decap_8
XFILLER_178_1474 VDD VSS sg13g2_decap_4
X_10373_ _10375_/A _14815_/Q _10378_/D _14816_/Q VDD VSS sg13g2_a21o_1
X_12112_ _12112_/Y _12112_/A1 _13940_/Q _12112_/B1 VDD VSS sg13g2_a21oi_1
XFILLER_152_967 VDD VSS sg13g2_decap_8
XFILLER_163_293 VDD VSS sg13g2_decap_8
XFILLER_151_444 VDD VSS sg13g2_fill_1
X_13092_ _13093_/B _13092_/A _13112_/A _13092_/C VDD VSS sg13g2_nand3_1
XFILLER_123_157 VDD VSS sg13g2_decap_8
XFILLER_3_977 VDD VSS sg13g2_decap_8
X_12043_ _12043_/X _12036_/B _12042_/X _12041_/Y VDD VSS sg13g2_a21o_1
XFILLER_2_476 VDD VSS sg13g2_decap_8
XFILLER_46_1054 VDD VSS sg13g2_decap_8
XFILLER_172_1062 VDD VSS sg13g2_fill_1
XFILLER_78_745 VDD VSS sg13g2_decap_8
XFILLER_133_1024 VDD VSS sg13g2_decap_8
XFILLER_49_84 VDD VSS sg13g2_decap_8
XFILLER_66_907 VDD VSS sg13g2_decap_8
XFILLER_172_74 VDD VSS sg13g2_decap_8
XFILLER_1_14 VDD VSS sg13g2_decap_8
Xfanout780 _09141_/A _07613_/Y VDD VSS sg13g2_buf_1
Xfanout791 _10647_/D _15250_/Q VDD VSS sg13g2_buf_1
XFILLER_111_1311 VDD VSS sg13g2_decap_4
XFILLER_120_897 VDD VSS sg13g2_decap_8
XFILLER_4_1435 VDD VSS sg13g2_decap_8
X_13994_ _13994_/Q clkload26/A _13994_/D _13994_/RESET_B VDD VSS sg13g2_dfrbpq_1
XFILLER_92_225 VDD VSS sg13g2_decap_8
XFILLER_105_90 VDD VSS sg13g2_decap_8
XFILLER_74_940 VDD VSS sg13g2_decap_4
XFILLER_58_491 VDD VSS sg13g2_decap_8
XFILLER_98_1453 VDD VSS sg13g2_decap_8
XFILLER_24_1396 VDD VSS sg13g2_decap_8
XFILLER_20_1249 VDD VSS sg13g2_decap_8
X_12945_ _12945_/Y _12945_/A _12988_/B VDD VSS sg13g2_nor2_1
X_14548__1654 _14548_/RESET_B VDD VSS sg13g2_tiehi
XFILLER_59_1415 VDD VSS sg13g2_decap_8
XFILLER_34_804 VDD VSS sg13g2_decap_8
XFILLER_111_1388 VDD VSS sg13g2_decap_8
XFILLER_46_697 VDD VSS sg13g2_fill_1
XFILLER_34_848 VDD VSS sg13g2_decap_8
XFILLER_185_1467 VDD VSS sg13g2_decap_8
X_12876_ _12878_/B _12876_/A _12877_/C VDD VSS sg13g2_nand2_1
XFILLER_73_494 VDD VSS sg13g2_decap_8
XFILLER_45_185 VDD VSS sg13g2_decap_8
XFILLER_181_1309 VDD VSS sg13g2_decap_8
XFILLER_185_1478 VDD VSS sg13g2_fill_1
XFILLER_60_122 VDD VSS sg13g2_decap_8
XFILLER_61_656 VDD VSS sg13g2_decap_8
X_14615_ _14615_/Q clkload41/A _14615_/D _14615_/RESET_B VDD VSS sg13g2_dfrbpq_1
XFILLER_18_1112 VDD VSS sg13g2_decap_8
X_11827_ _11827_/Y _11823_/Y _11824_/Y _11826_/Y _11825_/Y _11822_/B VDD VSS sg13g2_a221oi_1
XFILLER_92_1052 VDD VSS sg13g2_decap_8
XFILLER_60_155 VDD VSS sg13g2_fill_2
XFILLER_61_689 VDD VSS sg13g2_fill_1
X_14546_ _14546_/Q _14546_/CLK _14546_/D _14546_/RESET_B VDD VSS sg13g2_dfrbpq_1
X_11758_ _11760_/A _11759_/A _13898_/Q VDD VSS sg13g2_nand2b_1
XFILLER_92_1096 VDD VSS sg13g2_fill_2
XFILLER_53_1047 VDD VSS sg13g2_fill_1
XFILLER_14_1009 VDD VSS sg13g2_decap_8
XFILLER_147_717 VDD VSS sg13g2_fill_1
XFILLER_18_1189 VDD VSS sg13g2_decap_8
X_10709_ _10954_/A _09027_/X _10710_/A2 _08873_/Y VDD VSS sg13g2_a21oi_1
XFILLER_70_1350 VDD VSS sg13g2_decap_8
XFILLER_186_385 VDD VSS sg13g2_decap_8
X_14477_ _14477_/Q clkload23/A _14477_/D _14477_/RESET_B VDD VSS sg13g2_dfrbpq_1
X_11689_ _11689_/X _14120_/Q _14152_/Q _11692_/A VDD VSS sg13g2_mux2_1
X_13428_ _15096_/D _13421_/Y _13425_/Y _13427_/Y VDD VSS sg13g2_o21ai_1
XFILLER_127_441 VDD VSS sg13g2_decap_8
XFILLER_31_1356 VDD VSS sg13g2_decap_8
XFILLER_60_4 VDD VSS sg13g2_decap_8
XFILLER_6_760 VDD VSS sg13g2_decap_8
X_13359_ _13438_/D _13401_/B _13401_/C VDD VSS sg13g2_nor2b_1
XFILLER_142_422 VDD VSS sg13g2_decap_8
XFILLER_170_731 VDD VSS sg13g2_decap_8
XFILLER_103_809 VDD VSS sg13g2_decap_8
XFILLER_102_308 VDD VSS sg13g2_decap_8
X_07920_ _07920_/Y _07918_/Y _07871_/X _07911_/Y VDD VSS sg13g2_a21oi_1
X_15029_ _15029_/Q _15196_/CLK _15029_/D _15029_/RESET_B VDD VSS sg13g2_dfrbpq_1
XFILLER_151_1102 VDD VSS sg13g2_decap_4
XFILLER_9_1346 VDD VSS sg13g2_decap_8
XFILLER_68_222 VDD VSS sg13g2_fill_2
XFILLER_64_1176 VDD VSS sg13g2_decap_8
XFILLER_29_1296 VDD VSS sg13g2_decap_8
X_07851_ _08641_/A _08643_/C _08646_/A VDD VSS sg13g2_nand2_1
XFILLER_69_767 VDD VSS sg13g2_decap_4
XFILLER_25_1138 VDD VSS sg13g2_decap_8
XFILLER_84_726 VDD VSS sg13g2_fill_2
XFILLER_83_203 VDD VSS sg13g2_fill_2
Xinput2 input2/X input2/A VDD VSS sg13g2_buf_1
X_07782_ _07784_/B _07782_/A _15002_/Q VDD VSS sg13g2_and2_1
XFILLER_83_236 VDD VSS sg13g2_decap_8
XFILLER_7_1092 VDD VSS sg13g2_decap_8
X_09521_ _14120_/D _09620_/A0 _14120_/Q _09523_/S VDD VSS sg13g2_mux2_1
XFILLER_65_973 VDD VSS sg13g2_decap_8
XFILLER_65_984 VDD VSS sg13g2_fill_2
XFILLER_36_152 VDD VSS sg13g2_decap_8
X_09452_ _14053_/D _09617_/A0 _14053_/Q _09463_/S VDD VSS sg13g2_mux2_1
XFILLER_64_472 VDD VSS sg13g2_decap_8
X_08403_ _08410_/D _15100_/Q _15089_/Q _08574_/B VDD VSS sg13g2_o21ai_1
XFILLER_40_807 VDD VSS sg13g2_decap_4
X_09383_ _13986_/D _09614_/A0 _13986_/Q _09397_/S VDD VSS sg13g2_mux2_1
XFILLER_36_1201 VDD VSS sg13g2_decap_8
XFILLER_162_1220 VDD VSS sg13g2_decap_8
XFILLER_75_1272 VDD VSS sg13g2_decap_8
XFILLER_40_829 VDD VSS sg13g2_decap_8
XFILLER_127_1340 VDD VSS sg13g2_fill_2
X_08334_ _08335_/D _08334_/A1 _08333_/Y _08036_/B _08330_/Y VDD VSS sg13g2_a22oi_1
XFILLER_178_864 VDD VSS sg13g2_decap_8
XFILLER_20_520 VDD VSS sg13g2_decap_8
XFILLER_51_199 VDD VSS sg13g2_decap_8
XFILLER_127_1384 VDD VSS sg13g2_fill_1
XFILLER_138_706 VDD VSS sg13g2_fill_2
XFILLER_123_1226 VDD VSS sg13g2_decap_8
X_14850__2867 _14850_/RESET_B VDD VSS sg13g2_tiehi
XFILLER_36_1278 VDD VSS sg13g2_decap_8
XFILLER_138_728 VDD VSS sg13g2_decap_8
XFILLER_20_553 VDD VSS sg13g2_decap_4
X_08265_ _08265_/X _08265_/A _08265_/B _08319_/A _08319_/C VDD VSS sg13g2_or4_1
XFILLER_138_739 VDD VSS sg13g2_fill_2
XFILLER_162_1297 VDD VSS sg13g2_decap_8
XFILLER_177_396 VDD VSS sg13g2_decap_8
X_08196_ _08196_/Y _08196_/A1 _08079_/X _08688_/A VDD VSS sg13g2_o21ai_1
XFILLER_10_1407 VDD VSS sg13g2_decap_8
X_14022__2180 _14022_/RESET_B VDD VSS sg13g2_tiehi
XFILLER_152_208 VDD VSS sg13g2_decap_8
XFILLER_118_474 VDD VSS sg13g2_decap_8
XFILLER_134_923 VDD VSS sg13g2_decap_8
XFILLER_3_207 VDD VSS sg13g2_decap_8
XFILLER_69_1054 VDD VSS sg13g2_decap_4
XFILLER_161_742 VDD VSS sg13g2_decap_8
XFILLER_105_146 VDD VSS sg13g2_fill_2
XFILLER_10_56 VDD VSS sg13g2_decap_8
X_14626__1576 _14626_/RESET_B VDD VSS sg13g2_tiehi
XFILLER_121_606 VDD VSS sg13g2_fill_2
XFILLER_160_252 VDD VSS sg13g2_decap_8
XFILLER_0_925 VDD VSS sg13g2_decap_8
XFILLER_105_179 VDD VSS sg13g2_decap_8
XFILLER_134_1300 VDD VSS sg13g2_fill_2
XFILLER_82_1232 VDD VSS sg13g2_decap_8
XFILLER_126_67 VDD VSS sg13g2_decap_8
Xfanout1008 _09938_/B _15066_/Q VDD VSS sg13g2_buf_1
XFILLER_87_520 VDD VSS sg13g2_fill_2
Xfanout1019 _09078_/B fanout1026/X VDD VSS sg13g2_buf_1
XFILLER_120_138 VDD VSS sg13g2_decap_8
XFILLER_102_853 VDD VSS sg13g2_fill_2
XFILLER_173_1393 VDD VSS sg13g2_decap_8
XFILLER_48_907 VDD VSS sg13g2_fill_2
XFILLER_47_1396 VDD VSS sg13g2_decap_8
XFILLER_134_1355 VDD VSS sg13g2_decap_8
XFILLER_19_21 VDD VSS sg13g2_decap_8
XFILLER_43_1238 VDD VSS sg13g2_decap_8
XFILLER_75_704 VDD VSS sg13g2_decap_8
XFILLER_87_575 VDD VSS sg13g2_fill_2
XFILLER_142_33 VDD VSS sg13g2_decap_8
XFILLER_19_119 VDD VSS sg13g2_decap_8
XFILLER_74_214 VDD VSS sg13g2_fill_2
XFILLER_47_428 VDD VSS sg13g2_decap_8
XFILLER_101_396 VDD VSS sg13g2_decap_8
XFILLER_75_759 VDD VSS sg13g2_fill_2
XFILLER_19_98 VDD VSS sg13g2_decap_8
XFILLER_142_77 VDD VSS sg13g2_fill_1
X_09719_ _14310_/D _09752_/A1 _14310_/Q _09725_/S VDD VSS sg13g2_mux2_1
XFILLER_90_707 VDD VSS sg13g2_decap_8
XFILLER_74_258 VDD VSS sg13g2_fill_2
XFILLER_142_88 VDD VSS sg13g2_decap_8
X_10991_ _10992_/B _10979_/Y _10978_/B _10974_/Y VDD VSS sg13g2_o21ai_1
XFILLER_90_718 VDD VSS sg13g2_fill_1
XFILLER_43_601 VDD VSS sg13g2_fill_1
XFILLER_55_472 VDD VSS sg13g2_decap_8
X_12730_ _12730_/X _13846_/Q _13878_/Q _13910_/Q _13942_/Q _12752_/S0 _12752_/S1 VDD
+ VSS sg13g2_mux4_1
XFILLER_71_932 VDD VSS sg13g2_decap_8
XFILLER_43_634 VDD VSS sg13g2_fill_2
XFILLER_128_1115 VDD VSS sg13g2_decap_8
XFILLER_167_1164 VDD VSS sg13g2_decap_8
XFILLER_70_442 VDD VSS sg13g2_fill_1
X_12661_ _12661_/X _14257_/Q _14289_/Q _14321_/Q _14353_/Q _12661_/S0 _12661_/S1 VDD
+ VSS sg13g2_mux4_1
XFILLER_43_689 VDD VSS sg13g2_fill_2
XFILLER_169_831 VDD VSS sg13g2_fill_1
XFILLER_19_1443 VDD VSS sg13g2_decap_8
X_14232__1970 _14232_/RESET_B VDD VSS sg13g2_tiehi
XFILLER_93_1372 VDD VSS sg13g2_fill_1
XFILLER_42_166 VDD VSS sg13g2_decap_4
X_14400_ _14400_/Q clkload25/A _14400_/D _14400_/RESET_B VDD VSS sg13g2_dfrbpq_1
X_15104__2778 _15104_/RESET_B VDD VSS sg13g2_tiehi
X_11612_ _11612_/Y _11621_/S0 _14502_/Q _11802_/B VDD VSS sg13g2_a21oi_1
XFILLER_24_892 VDD VSS sg13g2_decap_8
X_12592_ _12592_/X _14700_/Q _14732_/Q _13772_/Q _13804_/Q _12592_/S0 _12592_/S1 VDD
+ VSS sg13g2_mux4_1
XFILLER_129_706 VDD VSS sg13g2_decap_4
XFILLER_23_380 VDD VSS sg13g2_fill_1
XFILLER_180_1364 VDD VSS sg13g2_decap_8
XFILLER_54_1367 VDD VSS sg13g2_decap_8
XFILLER_106_1446 VDD VSS sg13g2_decap_8
XFILLER_184_812 VDD VSS sg13g2_decap_8
XFILLER_136_0 VDD VSS sg13g2_decap_8
X_14331_ _14331_/Q _14491_/CLK _14331_/D _14331_/RESET_B VDD VSS sg13g2_dfrbpq_1
X_11543_ _11543_/Y _11531_/A _14372_/Q VDD VSS sg13g2_nand2b_1
XFILLER_11_564 VDD VSS sg13g2_decap_8
XFILLER_128_227 VDD VSS sg13g2_decap_8
XFILLER_183_333 VDD VSS sg13g2_decap_8
X_14262_ _14262_/Q _14742_/CLK _14262_/D _14262_/RESET_B VDD VSS sg13g2_dfrbpq_1
XFILLER_7_546 VDD VSS sg13g2_decap_8
X_11474_ _11475_/B _11471_/X _11470_/X _11467_/X _11466_/X _11971_/C _11956_/B1 VDD
+ VSS sg13g2_mux4_1
XFILLER_137_750 VDD VSS sg13g2_fill_2
XFILLER_104_1170 VDD VSS sg13g2_decap_8
XFILLER_167_74 VDD VSS sg13g2_decap_8
X_13213_ _13215_/A _14921_/Q _13666_/Q VDD VSS sg13g2_xor2_1
XFILLER_137_783 VDD VSS sg13g2_decap_4
XFILLER_13_1075 VDD VSS sg13g2_decap_8
X_10425_ _10538_/A _10647_/A _10429_/D VDD VSS sg13g2_nand2_1
X_14193_ _14193_/Q clkload33/A _14193_/D _14193_/RESET_B VDD VSS sg13g2_dfrbpq_1
XFILLER_109_485 VDD VSS sg13g2_decap_8
XFILLER_125_945 VDD VSS sg13g2_decap_8
XFILLER_178_1271 VDD VSS sg13g2_decap_8
X_13144_ _13145_/A _13146_/A _13146_/C VDD VSS sg13g2_nand2_1
X_10356_ _10364_/C _10400_/A _10397_/B _10395_/A VDD VSS sg13g2_nor3_1
XFILLER_83_1018 VDD VSS sg13g2_fill_2
XFILLER_100_1089 VDD VSS sg13g2_decap_8
XFILLER_139_1266 VDD VSS sg13g2_decap_8
XFILLER_152_775 VDD VSS sg13g2_decap_8
XFILLER_152_786 VDD VSS sg13g2_fill_1
XFILLER_139_1288 VDD VSS sg13g2_decap_4
XFILLER_174_1168 VDD VSS sg13g2_decap_8
XFILLER_3_774 VDD VSS sg13g2_decap_8
X_13075_ _13172_/B _14911_/Q _13676_/Q VDD VSS sg13g2_xor2_1
XFILLER_65_1452 VDD VSS sg13g2_decap_8
XFILLER_26_1403 VDD VSS sg13g2_decap_8
XFILLER_105_680 VDD VSS sg13g2_decap_8
X_10287_ _10298_/D _14788_/Q _14789_/Q _14790_/Q _10305_/B VDD VSS sg13g2_and4_1
XFILLER_2_273 VDD VSS sg13g2_decap_8
XFILLER_111_138 VDD VSS sg13g2_decap_4
XFILLER_183_95 VDD VSS sg13g2_decap_8
XFILLER_61_1316 VDD VSS sg13g2_decap_8
X_12026_ _12027_/B _12026_/A _12026_/B _12026_/C VDD VSS sg13g2_nand3_1
X_13720__2482 _13720_/RESET_B VDD VSS sg13g2_tiehi
XFILLER_120_661 VDD VSS sg13g2_decap_8
XFILLER_152_1466 VDD VSS sg13g2_decap_8
XFILLER_113_1439 VDD VSS sg13g2_decap_4
XFILLER_8_1390 VDD VSS sg13g2_decap_8
XFILLER_4_1232 VDD VSS sg13g2_decap_8
XFILLER_65_236 VDD VSS sg13g2_fill_2
XFILLER_81_707 VDD VSS sg13g2_fill_1
XFILLER_18_130 VDD VSS sg13g2_decap_8
XFILLER_24_1193 VDD VSS sg13g2_decap_8
XFILLER_0_1107 VDD VSS sg13g2_decap_8
X_13977_ _13977_/Q clkload45/A _13977_/D _13977_/RESET_B VDD VSS sg13g2_dfrbpq_1
XFILLER_59_1212 VDD VSS sg13g2_decap_8
XFILLER_19_675 VDD VSS sg13g2_decap_8
X_14064__2138 _14064_/RESET_B VDD VSS sg13g2_tiehi
XFILLER_111_1185 VDD VSS sg13g2_fill_1
XFILLER_98_1283 VDD VSS sg13g2_fill_1
XFILLER_18_174 VDD VSS sg13g2_fill_2
XFILLER_20_1079 VDD VSS sg13g2_decap_8
X_12928_ _12928_/X _12988_/A _12928_/B VDD VSS sg13g2_xor2_1
XFILLER_94_1125 VDD VSS sg13g2_decap_8
XFILLER_46_483 VDD VSS sg13g2_fill_1
XFILLER_33_100 VDD VSS sg13g2_decap_8
XFILLER_62_943 VDD VSS sg13g2_decap_4
XFILLER_185_1264 VDD VSS sg13g2_decap_8
XFILLER_73_291 VDD VSS sg13g2_decap_8
XFILLER_181_1106 VDD VSS sg13g2_decap_8
XFILLER_94_1158 VDD VSS sg13g2_decap_4
XFILLER_55_1109 VDD VSS sg13g2_decap_4
XFILLER_178_105 VDD VSS sg13g2_decap_8
XFILLER_59_1289 VDD VSS sg13g2_decap_8
X_12859_ _12861_/B _12859_/A _13689_/Q VDD VSS sg13g2_xnor2_1
XFILLER_72_1412 VDD VSS sg13g2_decap_8
X_15003__2607 _15003_/RESET_B VDD VSS sg13g2_tiehi
X_14704__1498 _14704_/RESET_B VDD VSS sg13g2_tiehi
XFILLER_159_352 VDD VSS sg13g2_decap_8
XFILLER_33_1429 VDD VSS sg13g2_decap_8
X_14529_ _14529_/Q clkload10/A _14529_/D _14529_/RESET_B VDD VSS sg13g2_dfrbpq_1
XFILLER_159_385 VDD VSS sg13g2_decap_8
XFILLER_30_873 VDD VSS sg13g2_decap_8
XFILLER_186_182 VDD VSS sg13g2_decap_8
X_08050_ _08242_/A _15102_/Q _15094_/Q _08048_/B VDD VSS sg13g2_o21ai_1
XFILLER_147_569 VDD VSS sg13g2_fill_2
XFILLER_31_1153 VDD VSS sg13g2_decap_8
XFILLER_116_912 VDD VSS sg13g2_fill_1
XFILLER_174_377 VDD VSS sg13g2_fill_1
XFILLER_116_934 VDD VSS sg13g2_decap_8
XFILLER_116_956 VDD VSS sg13g2_decap_4
XFILLER_157_1322 VDD VSS sg13g2_decap_8
XFILLER_51_0 VDD VSS sg13g2_decap_8
XFILLER_115_444 VDD VSS sg13g2_decap_8
XFILLER_143_753 VDD VSS sg13g2_decap_8
XFILLER_142_241 VDD VSS sg13g2_fill_1
XFILLER_66_1249 VDD VSS sg13g2_decap_8
XFILLER_103_617 VDD VSS sg13g2_decap_8
XFILLER_170_561 VDD VSS sg13g2_decap_8
Xhold3105 input24/A mem_axi_rdata[28] VDD VSS sg13g2_dlygate4sd3_1
XFILLER_142_263 VDD VSS sg13g2_decap_8
Xhold3116 _13633_/A _13741_/Q VDD VSS sg13g2_dlygate4sd3_1
Xhold3127 _13630_/A _13738_/Q VDD VSS sg13g2_dlygate4sd3_1
XFILLER_157_1399 VDD VSS sg13g2_decap_8
Xhold3138 _13637_/A _13745_/Q VDD VSS sg13g2_dlygate4sd3_1
X_08952_ _08952_/Y _08835_/A _08835_/B _16883_/A VDD VSS sg13g2_a21oi_1
XFILLER_88_339 VDD VSS sg13g2_decap_8
XFILLER_29_1060 VDD VSS sg13g2_decap_8
Xhold3149 hold3149/X _15020_/Q VDD VSS sg13g2_dlygate4sd3_1
XFILLER_69_531 VDD VSS sg13g2_decap_8
X_14274__1928 _14274_/RESET_B VDD VSS sg13g2_tiehi
X_07903_ _08402_/B _08063_/A _07903_/B VDD VSS sg13g2_nand2_1
X_08883_ _13704_/D _16866_/A _08882_/X _08935_/S VDD VSS sg13g2_mux2_1
X_14310__1892 _14310_/RESET_B VDD VSS sg13g2_tiehi
X_07834_ _07974_/D _07834_/A _07834_/B VDD VSS sg13g2_nor2_1
XFILLER_69_597 VDD VSS sg13g2_fill_1
XFILLER_5_1029 VDD VSS sg13g2_decap_8
XFILLER_29_439 VDD VSS sg13g2_decap_4
XFILLER_116_1096 VDD VSS sg13g2_decap_4
XFILLER_99_1047 VDD VSS sg13g2_decap_4
XFILLER_84_545 VDD VSS sg13g2_fill_1
XFILLER_56_236 VDD VSS sg13g2_decap_8
XFILLER_42_1282 VDD VSS sg13g2_decap_8
X_07765_ _15215_/D _15099_/Q _15088_/Q _15076_/Q VDD VSS sg13g2_or3_1
XFILLER_72_729 VDD VSS sg13g2_decap_4
XFILLER_168_1440 VDD VSS sg13g2_decap_8
X_09504_ _14104_/D _10100_/A0 _14104_/Q _09506_/S VDD VSS sg13g2_mux2_1
XFILLER_77_1334 VDD VSS sg13g2_decap_8
XFILLER_53_932 VDD VSS sg13g2_fill_1
XFILLER_37_483 VDD VSS sg13g2_decap_8
X_07696_ _15203_/D _07696_/A _07696_/B _07696_/C VDD VSS sg13g2_nand3_1
XFILLER_72_18 VDD VSS sg13g2_decap_8
XFILLER_38_1307 VDD VSS sg13g2_decap_8
XFILLER_164_1315 VDD VSS sg13g2_decap_8
X_09435_ _14037_/D _09767_/A1 _14037_/Q _09438_/S VDD VSS sg13g2_mux2_1
XFILLER_169_105 VDD VSS sg13g2_decap_8
XFILLER_24_144 VDD VSS sg13g2_fill_1
XFILLER_25_689 VDD VSS sg13g2_decap_4
XFILLER_40_626 VDD VSS sg13g2_decap_8
X_09366_ _13970_/D _09630_/A0 _13970_/Q _09372_/S VDD VSS sg13g2_mux2_1
XFILLER_185_609 VDD VSS sg13g2_decap_8
XFILLER_36_1053 VDD VSS sg13g2_fill_2
X_08317_ _08418_/A _08315_/Y _08318_/D _08316_/Y VDD VSS sg13g2_a21oi_1
X_09297_ _13905_/D _13905_/Q _09895_/A0 _09304_/S VDD VSS sg13g2_mux2_1
XFILLER_165_333 VDD VSS sg13g2_decap_8
XFILLER_166_867 VDD VSS sg13g2_decap_8
XFILLER_21_11 VDD VSS sg13g2_decap_8
X_08248_ _08248_/Y _08369_/B _08319_/A _08319_/C VDD VSS sg13g2_nor3_1
XFILLER_101_1310 VDD VSS sg13g2_decap_4
XFILLER_10_1204 VDD VSS sg13g2_decap_8
XFILLER_14_1373 VDD VSS sg13g2_decap_8
XFILLER_107_912 VDD VSS sg13g2_decap_4
XFILLER_106_400 VDD VSS sg13g2_decap_8
X_08179_ _08179_/Y _08402_/C _08066_/Y _08178_/Y VDD VSS sg13g2_o21ai_1
XFILLER_146_591 VDD VSS sg13g2_decap_4
XFILLER_101_1376 VDD VSS sg13g2_decap_8
XFILLER_21_88 VDD VSS sg13g2_decap_8
X_10210_ _10210_/Y _10441_/C _14749_/Q _10210_/C _10210_/D VDD VSS sg13g2_nand4_1
XFILLER_88_1474 VDD VSS sg13g2_decap_4
XFILLER_134_753 VDD VSS sg13g2_decap_8
XFILLER_175_1433 VDD VSS sg13g2_decap_8
XFILLER_84_1316 VDD VSS sg13g2_decap_8
XFILLER_49_1436 VDD VSS sg13g2_decap_8
XFILLER_106_455 VDD VSS sg13g2_fill_2
XFILLER_122_904 VDD VSS sg13g2_decap_4
X_11190_ _11205_/B _11190_/A _11199_/B _11190_/C VDD VSS sg13g2_nor3_1
XFILLER_101_1398 VDD VSS sg13g2_fill_2
XFILLER_107_989 VDD VSS sg13g2_decap_8
XFILLER_133_252 VDD VSS sg13g2_decap_8
Xclkbuf_leaf_130_clk_i clkload10/A clkload0/A VDD VSS sg13g2_buf_8
XFILLER_0_700 VDD VSS sg13g2_decap_8
XFILLER_171_1308 VDD VSS sg13g2_decap_8
X_10141_ _14718_/D _14718_/Q _10141_/A1 _10163_/S VDD VSS sg13g2_mux2_1
XFILLER_43_1002 VDD VSS sg13g2_decap_4
XFILLER_153_32 VDD VSS sg13g2_fill_2
X_10072_ _14652_/D _10072_/A0 _14652_/Q _10102_/S VDD VSS sg13g2_mux2_1
XFILLER_173_1190 VDD VSS sg13g2_decap_8
XFILLER_47_1193 VDD VSS sg13g2_decap_8
XFILLER_134_1152 VDD VSS sg13g2_decap_8
XFILLER_88_895 VDD VSS sg13g2_decap_8
XFILLER_0_799 VDD VSS sg13g2_decap_8
X_13900_ _13900_/Q _14655_/CLK _13900_/D _13900_/RESET_B VDD VSS sg13g2_dfrbpq_1
XFILLER_87_372 VDD VSS sg13g2_decap_8
XFILLER_101_171 VDD VSS sg13g2_decap_8
X_14880_ _14880_/Q clkload90/A _14880_/D _14880_/RESET_B VDD VSS sg13g2_dfrbpq_1
X_13680__2535 _13680_/RESET_B VDD VSS sg13g2_tiehi
XFILLER_60_1371 VDD VSS sg13g2_decap_8
X_13831_ _13831_/Q clkload5/A _13831_/D _13831_/RESET_B VDD VSS sg13g2_dfrbpq_1
XFILLER_112_1461 VDD VSS sg13g2_decap_4
XFILLER_21_1344 VDD VSS sg13g2_decap_8
XFILLER_95_1401 VDD VSS sg13g2_decap_8
XFILLER_62_206 VDD VSS sg13g2_decap_8
XFILLER_169_1259 VDD VSS sg13g2_decap_8
XFILLER_90_526 VDD VSS sg13g2_decap_8
XFILLER_56_781 VDD VSS sg13g2_decap_8
XFILLER_28_472 VDD VSS sg13g2_fill_2
XFILLER_1_1449 VDD VSS sg13g2_decap_8
XFILLER_44_932 VDD VSS sg13g2_decap_8
X_13762_ _13762_/Q clkload6/A _13762_/D _13762_/RESET_B VDD VSS sg13g2_dfrbpq_1
X_10974_ _10974_/Y _10995_/A _15115_/Q VDD VSS sg13g2_nand2b_1
XFILLER_182_1404 VDD VSS sg13g2_decap_8
XFILLER_15_133 VDD VSS sg13g2_decap_8
X_12713_ _12713_/X _13749_/Q _14101_/Q _14453_/Q _14549_/Q _12716_/S0 _12716_/S1 VDD
+ VSS sg13g2_mux4_1
XFILLER_95_1478 VDD VSS sg13g2_fill_1
XFILLER_71_762 VDD VSS sg13g2_decap_8
X_14931__2705 _14931_/RESET_B VDD VSS sg13g2_tiehi
X_13693_ _16855_/A clkload65/A _13693_/D _13693_/RESET_B VDD VSS sg13g2_dfrbpq_1
XFILLER_19_1240 VDD VSS sg13g2_decap_8
X_12644_ _12644_/X _14576_/Q _14608_/Q _14640_/Q _14672_/Q _12699_/S0 _12699_/S1 VDD
+ VSS sg13g2_mux4_1
XFILLER_169_650 VDD VSS sg13g2_decap_8
XFILLER_12_851 VDD VSS sg13g2_decap_8
XFILLER_180_1161 VDD VSS sg13g2_decap_8
XFILLER_54_1164 VDD VSS sg13g2_decap_8
XFILLER_30_158 VDD VSS sg13g2_decap_8
XFILLER_141_1123 VDD VSS sg13g2_fill_1
X_12575_ _12575_/X _13835_/Q _13867_/Q _13899_/Q _13931_/Q _12576_/S0 _12576_/S1 VDD
+ VSS sg13g2_mux4_1
XFILLER_62_95 VDD VSS sg13g2_decap_8
XFILLER_11_361 VDD VSS sg13g2_decap_8
XFILLER_178_84 VDD VSS sg13g2_decap_8
XFILLER_129_547 VDD VSS sg13g2_decap_4
XFILLER_15_1159 VDD VSS sg13g2_decap_8
XFILLER_8_844 VDD VSS sg13g2_decap_8
X_14314_ _14314_/Q clkload20/A _14314_/D _14314_/RESET_B VDD VSS sg13g2_dfrbpq_1
XFILLER_7_35 VDD VSS sg13g2_decap_8
XFILLER_183_130 VDD VSS sg13g2_decap_8
X_13738__2464 _13738_/RESET_B VDD VSS sg13g2_tiehi
X_11526_ _11636_/B _11526_/A _12942_/B VDD VSS sg13g2_xor2_1
XFILLER_102_1129 VDD VSS sg13g2_decap_8
XFILLER_7_343 VDD VSS sg13g2_decap_8
XFILLER_172_815 VDD VSS sg13g2_decap_8
XFILLER_184_675 VDD VSS sg13g2_decap_4
XFILLER_116_219 VDD VSS sg13g2_decap_4
XFILLER_156_399 VDD VSS sg13g2_decap_4
XFILLER_176_1219 VDD VSS sg13g2_decap_8
X_14245_ _14245_/Q clkload16/A _14245_/D _14245_/RESET_B VDD VSS sg13g2_dfrbpq_1
X_11457_ _11457_/Y _11457_/A _11457_/B _11457_/C VDD VSS sg13g2_nand3_1
XFILLER_171_347 VDD VSS sg13g2_fill_2
X_10408_ _10408_/Y _14825_/Q _10406_/A _10544_/C VDD VSS sg13g2_o21ai_1
XFILLER_113_904 VDD VSS sg13g2_decap_4
X_14176_ _14176_/Q _15230_/CLK _14176_/D _14176_/RESET_B VDD VSS sg13g2_dfrbpq_1
XFILLER_125_764 VDD VSS sg13g2_decap_8
X_11388_ _11388_/Y _11403_/S0 _13823_/Q VDD VSS sg13g2_nand2b_1
XFILLER_180_870 VDD VSS sg13g2_fill_2
XFILLER_125_786 VDD VSS sg13g2_decap_8
XFILLER_112_414 VDD VSS sg13g2_decap_8
XFILLER_125_797 VDD VSS sg13g2_fill_1
X_13127_ _15041_/D _13127_/A _13127_/B VDD VSS sg13g2_nor2_1
X_10339_ _10357_/D _10345_/C _10345_/D VDD VSS sg13g2_and2_1
XFILLER_3_571 VDD VSS sg13g2_decap_8
XFILLER_139_1085 VDD VSS sg13g2_decap_8
X_14118__2084 _14118_/RESET_B VDD VSS sg13g2_tiehi
XFILLER_139_1096 VDD VSS sg13g2_fill_1
XFILLER_97_136 VDD VSS sg13g2_decap_8
XFILLER_26_1200 VDD VSS sg13g2_decap_8
XFILLER_100_609 VDD VSS sg13g2_fill_2
X_13058_ _13058_/Y _13058_/A _13058_/B _13058_/C _13058_/D VDD VSS sg13g2_nand4_1
XFILLER_121_970 VDD VSS sg13g2_decap_8
XFILLER_23_4 VDD VSS sg13g2_decap_8
XFILLER_94_810 VDD VSS sg13g2_decap_8
XFILLER_6_1327 VDD VSS sg13g2_decap_8
Xfanout1350 _11890_/S0 fanout1351/X VDD VSS sg13g2_buf_1
X_12009_ _12010_/B _12009_/A _13670_/Q VDD VSS sg13g2_nand2_1
XFILLER_152_1274 VDD VSS sg13g2_decap_4
Xfanout1361 fanout1361/X _11899_/S0 VDD VSS sg13g2_buf_1
XFILLER_38_214 VDD VSS sg13g2_decap_8
XFILLER_26_1277 VDD VSS sg13g2_decap_8
Xfanout1372 _12135_/S0 _12139_/S0 VDD VSS sg13g2_buf_1
XFILLER_152_1296 VDD VSS sg13g2_decap_8
Xfanout1383 _11273_/A1 fanout1388/X VDD VSS sg13g2_buf_1
XFILLER_93_331 VDD VSS sg13g2_decap_8
Xfanout1394 fanout1394/X _13657_/Q VDD VSS sg13g2_buf_1
XFILLER_94_865 VDD VSS sg13g2_decap_8
XFILLER_113_1269 VDD VSS sg13g2_decap_8
XFILLER_96_1209 VDD VSS sg13g2_decap_8
XFILLER_93_397 VDD VSS sg13g2_decap_8
XFILLER_35_932 VDD VSS sg13g2_decap_4
XFILLER_19_494 VDD VSS sg13g2_decap_8
XFILLER_34_442 VDD VSS sg13g2_fill_2
XFILLER_185_1061 VDD VSS sg13g2_decap_8
XFILLER_59_1075 VDD VSS sg13g2_decap_8
XFILLER_61_250 VDD VSS sg13g2_decap_8
XFILLER_50_913 VDD VSS sg13g2_fill_1
XFILLER_62_784 VDD VSS sg13g2_fill_1
XFILLER_61_261 VDD VSS sg13g2_fill_1
XFILLER_50_924 VDD VSS sg13g2_decap_8
XFILLER_34_475 VDD VSS sg13g2_decap_4
X_09220_ _13831_/D _09720_/A0 _13831_/Q _09229_/S VDD VSS sg13g2_mux2_1
XFILLER_179_469 VDD VSS sg13g2_fill_2
XFILLER_146_1089 VDD VSS sg13g2_decap_8
XFILLER_166_119 VDD VSS sg13g2_decap_8
X_09151_ _09151_/Y _09151_/A _09151_/B _09156_/B VDD VSS sg13g2_nand3_1
XFILLER_148_834 VDD VSS sg13g2_decap_8
XFILLER_33_1226 VDD VSS sg13g2_decap_8
XFILLER_147_322 VDD VSS sg13g2_fill_2
XFILLER_175_631 VDD VSS sg13g2_decap_8
XFILLER_72_1286 VDD VSS sg13g2_decap_8
X_08102_ _08103_/C _11384_/A _11454_/A _07879_/A _08102_/A3 _08102_/S0 _08048_/A VDD
+ VSS sg13g2_mux4_1
XFILLER_148_878 VDD VSS sg13g2_fill_1
X_09082_ _09082_/Y _09090_/A _09082_/B _09087_/B VDD VSS sg13g2_nand3_1
X_14328__1874 _14328_/RESET_B VDD VSS sg13g2_tiehi
X_08033_ _08036_/A _08402_/A _08402_/B VDD VSS sg13g2_nor2_1
XFILLER_162_336 VDD VSS sg13g2_fill_1
XFILLER_163_859 VDD VSS sg13g2_fill_2
XFILLER_115_230 VDD VSS sg13g2_fill_1
XFILLER_162_358 VDD VSS sg13g2_decap_4
XFILLER_157_1141 VDD VSS sg13g2_decap_8
XFILLER_116_797 VDD VSS sg13g2_decap_8
XFILLER_118_1125 VDD VSS sg13g2_decap_8
XFILLER_89_648 VDD VSS sg13g2_fill_2
XFILLER_115_296 VDD VSS sg13g2_decap_4
X_09984_ _14567_/D _10083_/A0 _14567_/Q _09990_/S VDD VSS sg13g2_mux2_1
XFILLER_118_1147 VDD VSS sg13g2_decap_8
XFILLER_88_136 VDD VSS sg13g2_decap_8
Xclkbuf_leaf_62_clk_i clkload78/A clkbuf_leaf_64_clk_i/A VDD VSS sg13g2_buf_8
XFILLER_103_469 VDD VSS sg13g2_fill_1
X_08935_ _13717_/D _16879_/A _08934_/X _08935_/S VDD VSS sg13g2_mux2_1
XFILLER_83_1382 VDD VSS sg13g2_decap_8
XFILLER_44_1333 VDD VSS sg13g2_decap_8
XFILLER_135_1461 VDD VSS sg13g2_decap_8
XFILLER_69_361 VDD VSS sg13g2_decap_8
XFILLER_97_681 VDD VSS sg13g2_decap_8
XFILLER_69_372 VDD VSS sg13g2_fill_1
XFILLER_57_512 VDD VSS sg13g2_decap_8
XFILLER_130_288 VDD VSS sg13g2_decap_8
X_15083__2850 _15083_/RESET_B VDD VSS sg13g2_tiehi
X_08866_ _08866_/X _15030_/Q _08873_/A _08865_/Y VDD VSS sg13g2_a21o_1
XFILLER_170_1396 VDD VSS sg13g2_decap_8
XFILLER_84_331 VDD VSS sg13g2_decap_4
XFILLER_85_865 VDD VSS sg13g2_decap_8
XFILLER_131_1358 VDD VSS sg13g2_decap_4
XFILLER_57_567 VDD VSS sg13g2_decap_4
X_07817_ _08527_/A _15010_/Q _07818_/B VDD VSS sg13g2_xor2_1
X_08797_ _08799_/A _10898_/B1 _14755_/Q _08727_/X _15198_/Q _13392_/A2 VDD VSS sg13g2_a221oi_1
Xclkbuf_leaf_77_clk_i clkload82/A clkbuf_leaf_80_clk_i/A VDD VSS sg13g2_buf_8
XFILLER_26_921 VDD VSS sg13g2_decap_8
XFILLER_83_39 VDD VSS sg13g2_decap_8
XFILLER_16_11 VDD VSS sg13g2_decap_8
X_13816__2386 _13816_/RESET_B VDD VSS sg13g2_tiehi
X_07748_ _07748_/Y _11241_/A _07748_/B _13499_/C _13303_/A VDD VSS sg13g2_nand4_1
XFILLER_26_954 VDD VSS sg13g2_decap_8
XFILLER_53_751 VDD VSS sg13g2_decap_8
XFILLER_25_442 VDD VSS sg13g2_decap_4
XFILLER_129_1232 VDD VSS sg13g2_fill_2
X_07679_ _07679_/Y _15084_/Q _15085_/Q _15083_/Q _07679_/D VDD VSS sg13g2_nor4_1
XFILLER_41_913 VDD VSS sg13g2_fill_1
XFILLER_25_464 VDD VSS sg13g2_decap_8
XFILLER_0_1471 VDD VSS sg13g2_decap_8
XFILLER_16_88 VDD VSS sg13g2_decap_8
X_09418_ _14020_/D _09583_/A1 _14020_/Q _09434_/S VDD VSS sg13g2_mux2_1
X_10690_ _14899_/D _10886_/B1 _10876_/A _10689_/Y VDD VSS sg13g2_o21ai_1
XFILLER_55_1440 VDD VSS sg13g2_decap_8
XFILLER_185_406 VDD VSS sg13g2_decap_8
XFILLER_164_1189 VDD VSS sg13g2_decap_8
X_13995__2207 _13995_/RESET_B VDD VSS sg13g2_tiehi
XFILLER_12_147 VDD VSS sg13g2_decap_8
XFILLER_142_1421 VDD VSS sg13g2_decap_4
XFILLER_181_1470 VDD VSS sg13g2_decap_8
XFILLER_16_1435 VDD VSS sg13g2_decap_8
XFILLER_32_21 VDD VSS sg13g2_decap_8
XFILLER_139_834 VDD VSS sg13g2_decap_8
X_09349_ _13953_/D _10077_/A0 _13953_/Q _09364_/S VDD VSS sg13g2_mux2_1
XFILLER_51_1326 VDD VSS sg13g2_decap_8
XFILLER_103_1405 VDD VSS sg13g2_fill_2
XFILLER_90_1386 VDD VSS sg13g2_decap_8
XFILLER_138_333 VDD VSS sg13g2_fill_2
X_12360_ _14989_/D _08048_/A _13282_/A1 _12359_/Y _12356_/Y VDD VSS sg13g2_a22oi_1
XFILLER_103_1449 VDD VSS sg13g2_decap_8
XFILLER_148_54 VDD VSS sg13g2_fill_1
X_11311_ _11311_/Y _11307_/Y _11308_/Y _11310_/Y _11309_/Y _12237_/C VDD VSS sg13g2_a221oi_1
XFILLER_32_98 VDD VSS sg13g2_decap_8
XFILLER_10_1001 VDD VSS sg13g2_decap_8
XFILLER_14_1170 VDD VSS sg13g2_decap_8
XFILLER_181_623 VDD VSS sg13g2_decap_8
Xclkbuf_leaf_15_clk_i _14528_/CLK clkbuf_leaf_4_clk_i/A VDD VSS sg13g2_buf_8
X_12291_ _12292_/B _12291_/A _12291_/B VDD VSS sg13g2_nor2_1
XFILLER_5_847 VDD VSS sg13g2_decap_8
XFILLER_180_133 VDD VSS sg13g2_decap_8
X_14030_ _14030_/Q clkload58/A _14030_/D _14030_/RESET_B VDD VSS sg13g2_dfrbpq_1
XFILLER_107_753 VDD VSS sg13g2_fill_1
X_11242_ _13298_/B _13297_/S _11243_/B VDD VSS sg13g2_nor2_1
XFILLER_107_764 VDD VSS sg13g2_decap_8
XFILLER_153_369 VDD VSS sg13g2_fill_2
XFILLER_175_1230 VDD VSS sg13g2_decap_8
XFILLER_4_357 VDD VSS sg13g2_decap_8
XFILLER_49_1233 VDD VSS sg13g2_decap_8
XFILLER_10_1078 VDD VSS sg13g2_decap_8
XFILLER_84_1135 VDD VSS sg13g2_decap_4
XFILLER_106_263 VDD VSS sg13g2_fill_2
XFILLER_164_42 VDD VSS sg13g2_decap_8
X_11173_ _11173_/Y _11150_/B _11173_/B _11173_/C VDD VSS sg13g2_nand3b_1
XFILLER_79_114 VDD VSS sg13g2_decap_8
XFILLER_62_1411 VDD VSS sg13g2_decap_8
XFILLER_121_244 VDD VSS sg13g2_decap_8
XFILLER_136_1258 VDD VSS sg13g2_fill_1
X_10124_ _14702_/D _10124_/A0 _14702_/Q _10124_/S VDD VSS sg13g2_mux2_1
XFILLER_136_1269 VDD VSS sg13g2_fill_1
XFILLER_94_106 VDD VSS sg13g2_decap_8
XFILLER_0_574 VDD VSS sg13g2_decap_8
X_14932_ _14932_/Q clkload60/A _14932_/D _14932_/RESET_B VDD VSS sg13g2_dfrbpq_1
X_10055_ _14636_/D _10088_/A0 _14636_/Q _10057_/S VDD VSS sg13g2_mux2_1
XFILLER_76_832 VDD VSS sg13g2_decap_8
XFILLER_102_480 VDD VSS sg13g2_decap_8
XFILLER_36_707 VDD VSS sg13g2_fill_1
XFILLER_57_84 VDD VSS sg13g2_decap_8
XFILLER_180_63 VDD VSS sg13g2_decap_8
X_14863_ _14863_/Q clkload90/A _14863_/D _14863_/RESET_B VDD VSS sg13g2_dfrbpq_1
XFILLER_75_364 VDD VSS sg13g2_fill_2
XFILLER_21_1141 VDD VSS sg13g2_decap_8
XFILLER_29_770 VDD VSS sg13g2_fill_1
X_13814_ _13814_/Q _14742_/CLK _13814_/D _13814_/RESET_B VDD VSS sg13g2_dfrbpq_1
XFILLER_63_537 VDD VSS sg13g2_decap_8
XFILLER_5_1393 VDD VSS sg13g2_decap_8
XFILLER_1_1246 VDD VSS sg13g2_decap_8
X_14406__1796 _14406_/RESET_B VDD VSS sg13g2_tiehi
X_14794_ _14794_/Q clkload89/A _14794_/D _14794_/RESET_B VDD VSS sg13g2_dfrbpq_1
XFILLER_90_345 VDD VSS sg13g2_decap_8
XFILLER_182_1201 VDD VSS sg13g2_decap_8
X_13745_ _13745_/Q clkload33/A _13745_/D _13745_/RESET_B VDD VSS sg13g2_dfrbpq_1
XFILLER_50_209 VDD VSS sg13g2_decap_8
XFILLER_186_1392 VDD VSS sg13g2_decap_8
X_10957_ _10957_/Y _10954_/C _11045_/A2 _10985_/B1 VDD VSS sg13g2_a21oi_1
XFILLER_90_389 VDD VSS sg13g2_fill_2
XFILLER_147_1354 VDD VSS sg13g2_decap_8
XFILLER_71_570 VDD VSS sg13g2_decap_4
XFILLER_147_1365 VDD VSS sg13g2_decap_8
XFILLER_56_1248 VDD VSS sg13g2_decap_8
XFILLER_32_935 VDD VSS sg13g2_fill_1
XFILLER_143_1207 VDD VSS sg13g2_fill_2
XFILLER_92_7 VDD VSS sg13g2_decap_8
X_13676_ _13676_/Q clkload57/A _13676_/D _13676_/RESET_B VDD VSS sg13g2_dfrbpq_1
XFILLER_182_1278 VDD VSS sg13g2_decap_8
X_10888_ _10888_/Y _10923_/A _14755_/Q VDD VSS sg13g2_nor2b_1
X_14585__1617 _14585_/RESET_B VDD VSS sg13g2_tiehi
X_12627_ _12627_/X _13967_/Q _13999_/Q _14031_/Q _14063_/Q _12686_/S0 _12686_/S1 VDD
+ VSS sg13g2_mux4_1
XFILLER_129_311 VDD VSS sg13g2_fill_2
X_14621__1581 _14621_/RESET_B VDD VSS sg13g2_tiehi
XFILLER_106_1073 VDD VSS sg13g2_decap_8
XFILLER_129_355 VDD VSS sg13g2_decap_8
XFILLER_8_641 VDD VSS sg13g2_decap_8
XFILLER_184_450 VDD VSS sg13g2_decap_8
X_12558_ _12558_/X _14698_/Q _14730_/Q _13770_/Q _13802_/Q _12616_/S0 _12616_/S1 VDD
+ VSS sg13g2_mux4_1
XFILLER_7_140 VDD VSS sg13g2_decap_8
XFILLER_144_303 VDD VSS sg13g2_decap_8
X_11509_ _11509_/X _14371_/Q _14403_/Q _14467_/Q _14499_/Q _11514_/S0 _11514_/S1 VDD
+ VSS sg13g2_mux4_1
XFILLER_89_1057 VDD VSS sg13g2_decap_4
XFILLER_32_1281 VDD VSS sg13g2_decap_8
XFILLER_144_336 VDD VSS sg13g2_fill_1
X_12489_ _12489_/X _14373_/Q _14405_/Q _14469_/Q _14501_/Q _12494_/S0 _12494_/S1 VDD
+ VSS sg13g2_mux4_1
XFILLER_171_133 VDD VSS sg13g2_decap_8
XFILLER_176_1038 VDD VSS sg13g2_decap_8
XFILLER_67_1311 VDD VSS sg13g2_decap_8
XFILLER_172_678 VDD VSS sg13g2_fill_1
X_14228_ _14228_/Q clkload11/A _14228_/D _14228_/RESET_B VDD VSS sg13g2_dfrbpq_1
XFILLER_119_1401 VDD VSS sg13g2_fill_2
XFILLER_113_701 VDD VSS sg13g2_decap_8
XFILLER_99_924 VDD VSS sg13g2_decap_8
XFILLER_154_1303 VDD VSS sg13g2_decap_8
XFILLER_99_935 VDD VSS sg13g2_fill_1
XFILLER_98_412 VDD VSS sg13g2_decap_8
X_14159_ _14159_/Q clkload39/A _14159_/D _14159_/RESET_B VDD VSS sg13g2_dfrbpq_1
XFILLER_112_222 VDD VSS sg13g2_fill_2
Xfanout609 _08972_/S _09069_/A VDD VSS sg13g2_buf_1
XFILLER_98_91 VDD VSS sg13g2_decap_8
XFILLER_67_1388 VDD VSS sg13g2_decap_8
XFILLER_99_979 VDD VSS sg13g2_fill_1
XFILLER_98_456 VDD VSS sg13g2_fill_1
XFILLER_115_1309 VDD VSS sg13g2_fill_1
XFILLER_140_575 VDD VSS sg13g2_decap_8
XFILLER_39_512 VDD VSS sg13g2_decap_8
X_08720_ _15213_/D _15192_/D _15122_/Q _13652_/S VDD VSS sg13g2_mux2_1
XFILLER_6_1124 VDD VSS sg13g2_decap_8
XFILLER_112_299 VDD VSS sg13g2_decap_8
XFILLER_152_1071 VDD VSS sg13g2_decap_8
XFILLER_78_180 VDD VSS sg13g2_decap_8
XFILLER_66_320 VDD VSS sg13g2_decap_8
XFILLER_26_1074 VDD VSS sg13g2_decap_8
XFILLER_67_854 VDD VSS sg13g2_decap_8
XFILLER_14_0 VDD VSS sg13g2_decap_8
Xfanout1180 _08215_/A3 _08102_/A3 VDD VSS sg13g2_buf_1
XFILLER_66_342 VDD VSS sg13g2_decap_8
Xfanout1191 _12866_/B _13017_/A2 VDD VSS sg13g2_buf_1
X_08651_ _15246_/D _08685_/A1 _08650_/X _08640_/X VDD VSS sg13g2_o21ai_1
XFILLER_26_228 VDD VSS sg13g2_decap_8
X_08582_ _08583_/B _08641_/D _08577_/B _08612_/S VDD VSS sg13g2_a21oi_1
XFILLER_148_1129 VDD VSS sg13g2_decap_8
XFILLER_81_345 VDD VSS sg13g2_decap_8
XFILLER_39_1413 VDD VSS sg13g2_decap_8
XFILLER_179_200 VDD VSS sg13g2_decap_8
XFILLER_179_233 VDD VSS sg13g2_fill_1
XFILLER_126_1427 VDD VSS sg13g2_decap_8
XFILLER_74_1359 VDD VSS sg13g2_decap_8
XFILLER_179_255 VDD VSS sg13g2_decap_4
XFILLER_167_428 VDD VSS sg13g2_decap_8
XFILLER_22_467 VDD VSS sg13g2_fill_2
X_09203_ _10004_/C _09441_/A _13279_/D _09204_/D VDD VSS sg13g2_nor3_1
XFILLER_72_1061 VDD VSS sg13g2_decap_4
X_09134_ _10776_/A _15048_/Q _15245_/Q _09147_/B VDD VSS sg13g2_mux2_1
XFILLER_120_1004 VDD VSS sg13g2_decap_8
XFILLER_33_1056 VDD VSS sg13g2_fill_1
XFILLER_163_601 VDD VSS sg13g2_decap_8
XFILLER_148_686 VDD VSS sg13g2_decap_8
XFILLER_11_1310 VDD VSS sg13g2_decap_8
XFILLER_136_837 VDD VSS sg13g2_fill_1
XFILLER_33_1089 VDD VSS sg13g2_decap_8
X_09065_ _09065_/Y _15235_/Q _09078_/B VDD VSS sg13g2_nand2b_1
XFILLER_118_24 VDD VSS sg13g2_decap_8
X_08016_ _08016_/Y _08241_/A _08015_/Y _08008_/Y VDD VSS sg13g2_a21oi_1
XFILLER_85_1411 VDD VSS sg13g2_decap_8
XFILLER_159_1269 VDD VSS sg13g2_decap_8
XFILLER_144_870 VDD VSS sg13g2_fill_1
XFILLER_11_1387 VDD VSS sg13g2_decap_8
XFILLER_172_1403 VDD VSS sg13g2_decap_8
XFILLER_78_28 VDD VSS sg13g2_decap_8
XFILLER_104_723 VDD VSS sg13g2_decap_8
XFILLER_104_734 VDD VSS sg13g2_fill_1
XFILLER_116_594 VDD VSS sg13g2_decap_8
XFILLER_89_434 VDD VSS sg13g2_decap_4
XFILLER_46_1428 VDD VSS sg13g2_decap_8
XFILLER_103_222 VDD VSS sg13g2_decap_8
X_09967_ _14551_/D _14551_/Q _10099_/A0 _09969_/S VDD VSS sg13g2_mux2_1
XFILLER_44_1130 VDD VSS sg13g2_fill_1
XFILLER_131_586 VDD VSS sg13g2_decap_8
XFILLER_98_990 VDD VSS sg13g2_decap_8
XFILLER_76_128 VDD VSS sg13g2_decap_8
X_08918_ _08918_/X _15042_/Q _14946_/Q _10752_/A VDD VSS sg13g2_mux2_1
XFILLER_58_843 VDD VSS sg13g2_decap_8
XFILLER_135_1291 VDD VSS sg13g2_decap_4
X_09898_ _14484_/D _09931_/A1 _14484_/Q _09898_/S VDD VSS sg13g2_mux2_1
XFILLER_170_1193 VDD VSS sg13g2_decap_8
X_14663__1539 _14663_/RESET_B VDD VSS sg13g2_tiehi
XFILLER_79_1204 VDD VSS sg13g2_decap_8
XFILLER_91_109 VDD VSS sg13g2_fill_1
X_08849_ _08849_/X _15025_/Q _08852_/A _08848_/Y VDD VSS sg13g2_a21o_1
XFILLER_45_504 VDD VSS sg13g2_decap_8
XFILLER_27_21 VDD VSS sg13g2_decap_8
XFILLER_100_984 VDD VSS sg13g2_decap_8
XFILLER_27_32 VDD VSS sg13g2_fill_2
XFILLER_100_995 VDD VSS sg13g2_fill_1
XFILLER_175_4 VDD VSS sg13g2_decap_8
XFILLER_22_1461 VDD VSS sg13g2_decap_8
X_11860_ _11860_/Y _13088_/A _11931_/A2 _11860_/B1 VDD VSS sg13g2_a21oi_1
XFILLER_72_334 VDD VSS sg13g2_decap_8
XFILLER_73_879 VDD VSS sg13g2_decap_8
X_10811_ _10811_/Y _10429_/D _10844_/A _10912_/B1 VDD VSS sg13g2_o21ai_1
X_11791_ _11791_/X _11789_/X _11790_/X _11791_/S VDD VSS sg13g2_mux2_1
XFILLER_92_1437 VDD VSS sg13g2_decap_8
X_13530_ _13530_/Y _13529_/A _13566_/C _08306_/B _13546_/B2 VDD VSS sg13g2_a22oi_1
X_10742_ _14913_/D _11045_/B1 _11052_/B _10741_/Y VDD VSS sg13g2_o21ai_1
XFILLER_13_445 VDD VSS sg13g2_decap_8
XFILLER_13_456 VDD VSS sg13g2_fill_1
XFILLER_43_53 VDD VSS sg13g2_decap_4
XFILLER_40_231 VDD VSS sg13g2_decap_8
XFILLER_129_1095 VDD VSS sg13g2_decap_8
XFILLER_185_203 VDD VSS sg13g2_decap_8
X_15031__2579 _15031_/RESET_B VDD VSS sg13g2_tiehi
XFILLER_51_1101 VDD VSS sg13g2_fill_1
XFILLER_159_42 VDD VSS sg13g2_decap_8
X_13461_ _13461_/Y _08723_/A _08723_/B _13106_/B VDD VSS sg13g2_o21ai_1
X_10673_ _14895_/D _10673_/A VDD VSS sg13g2_inv_1
XFILLER_9_427 VDD VSS sg13g2_decap_8
XFILLER_43_75 VDD VSS sg13g2_decap_8
XFILLER_16_1232 VDD VSS sg13g2_decap_8
XFILLER_41_798 VDD VSS sg13g2_decap_8
XFILLER_90_1172 VDD VSS sg13g2_decap_8
XFILLER_103_1202 VDD VSS sg13g2_decap_8
X_15200_ _15200_/Q _15203_/CLK _15200_/D _15200_/RESET_B VDD VSS sg13g2_dfrbpq_1
X_12412_ _12412_/X _12411_/X _12410_/X _12407_/X _12406_/X _12594_/S0 _12511_/S VDD
+ VSS sg13g2_mux4_1
XFILLER_107_1382 VDD VSS sg13g2_decap_8
X_13392_ _15084_/D _15084_/Q _13392_/A2 _13391_/Y VDD VSS sg13g2_a21o_1
XFILLER_103_1246 VDD VSS sg13g2_decap_8
XFILLER_166_472 VDD VSS sg13g2_fill_2
XFILLER_177_1303 VDD VSS sg13g2_decap_8
X_15131_ _15131_/Q clkload71/A _15131_/D _15131_/RESET_B VDD VSS sg13g2_dfrbpq_1
X_12343_ _12343_/X _14107_/Q _14139_/Q _14171_/Q _14203_/Q _12352_/S0 _12352_/S1 VDD
+ VSS sg13g2_mux4_1
XFILLER_5_644 VDD VSS sg13g2_decap_8
XFILLER_153_144 VDD VSS sg13g2_decap_4
XFILLER_182_976 VDD VSS sg13g2_decap_8
XFILLER_138_1309 VDD VSS sg13g2_decap_8
X_15062_ _15062_/Q _15203_/CLK _15062_/D _15062_/RESET_B VDD VSS sg13g2_dfrbpq_1
X_12274_ _12274_/Y _12274_/A _12274_/B VDD VSS sg13g2_nor2_1
XFILLER_175_74 VDD VSS sg13g2_decap_8
XFILLER_4_154 VDD VSS sg13g2_decap_8
XFILLER_153_177 VDD VSS sg13g2_fill_1
XFILLER_4_14 VDD VSS sg13g2_decap_8
XFILLER_107_583 VDD VSS sg13g2_decap_8
XFILLER_135_892 VDD VSS sg13g2_decap_8
X_14013_ _14013_/Q clkload29/A _14013_/D _14013_/RESET_B VDD VSS sg13g2_dfrbpq_1
X_11225_ _11225_/X _14363_/Q _14395_/Q _14459_/Q _14491_/Q _11218_/S _11228_/S1 VDD
+ VSS sg13g2_mux4_1
XFILLER_141_339 VDD VSS sg13g2_decap_8
XFILLER_122_520 VDD VSS sg13g2_fill_1
XFILLER_136_1033 VDD VSS sg13g2_decap_8
XFILLER_96_905 VDD VSS sg13g2_decap_4
X_11156_ _11156_/Y _14953_/Q _11170_/B VDD VSS sg13g2_nand2_1
XFILLER_1_861 VDD VSS sg13g2_decap_8
XFILLER_7_1400 VDD VSS sg13g2_decap_8
XFILLER_122_575 VDD VSS sg13g2_decap_8
X_10107_ _14685_/D _10140_/A1 _14685_/Q _10134_/S VDD VSS sg13g2_mux2_1
XFILLER_0_371 VDD VSS sg13g2_decap_8
XFILLER_114_1320 VDD VSS sg13g2_decap_8
X_11087_ _11087_/X _11118_/A _11118_/B VDD VSS sg13g2_and2_1
XFILLER_27_1383 VDD VSS sg13g2_decap_8
XFILLER_49_854 VDD VSS sg13g2_decap_8
XFILLER_62_1285 VDD VSS sg13g2_decap_8
XFILLER_7_1477 VDD VSS sg13g2_fill_2
X_14915_ _14915_/Q clkload69/A _14915_/D _14915_/RESET_B VDD VSS sg13g2_dfrbpq_1
X_10038_ _14619_/D _10071_/A0 _14619_/Q _10069_/S VDD VSS sg13g2_mux2_1
XFILLER_76_662 VDD VSS sg13g2_decap_8
XFILLER_49_876 VDD VSS sg13g2_fill_1
XFILLER_49_887 VDD VSS sg13g2_decap_8
XFILLER_23_1269 VDD VSS sg13g2_decap_8
X_14639__1563 _14639_/RESET_B VDD VSS sg13g2_tiehi
XFILLER_97_1337 VDD VSS sg13g2_decap_4
XFILLER_91_621 VDD VSS sg13g2_decap_8
XFILLER_63_312 VDD VSS sg13g2_decap_4
XFILLER_63_323 VDD VSS sg13g2_fill_2
X_14846_ _14846_/Q _14848_/CLK _14846_/D _14846_/RESET_B VDD VSS sg13g2_dfrbpq_1
XFILLER_5_1190 VDD VSS sg13g2_decap_8
XFILLER_1_1043 VDD VSS sg13g2_decap_8
X_14777_ _14777_/Q _15185_/CLK _14777_/D _14777_/RESET_B VDD VSS sg13g2_dfrbpq_1
XFILLER_147_1140 VDD VSS sg13g2_decap_8
XFILLER_17_784 VDD VSS sg13g2_decap_8
X_11989_ _11989_/Y _11989_/A _11989_/B VDD VSS sg13g2_xnor2_1
XFILLER_72_890 VDD VSS sg13g2_decap_8
XFILLER_32_721 VDD VSS sg13g2_decap_8
XFILLER_90_197 VDD VSS sg13g2_fill_2
X_13728_ _13728_/Q _14528_/CLK _13728_/D _13728_/RESET_B VDD VSS sg13g2_dfrbpq_1
XFILLER_31_220 VDD VSS sg13g2_decap_8
XFILLER_143_1015 VDD VSS sg13g2_decap_8
XFILLER_177_726 VDD VSS sg13g2_decap_8
XFILLER_17_1018 VDD VSS sg13g2_decap_8
XFILLER_108_1146 VDD VSS sg13g2_decap_8
XFILLER_182_1075 VDD VSS sg13g2_decap_8
X_13659_ _13659_/Q clkload63/A _13659_/D _13659_/RESET_B VDD VSS sg13g2_dfrbpq_1
XFILLER_73_1381 VDD VSS sg13g2_decap_8
XFILLER_129_130 VDD VSS sg13g2_decap_8
XFILLER_34_1376 VDD VSS sg13g2_decap_8
XFILLER_117_303 VDD VSS sg13g2_decap_8
XFILLER_160_1395 VDD VSS sg13g2_decap_8
XFILLER_9_994 VDD VSS sg13g2_decap_8
XFILLER_118_848 VDD VSS sg13g2_decap_8
XFILLER_145_634 VDD VSS sg13g2_fill_2
XFILLER_129_185 VDD VSS sg13g2_fill_2
XFILLER_173_954 VDD VSS sg13g2_fill_1
XFILLER_117_347 VDD VSS sg13g2_fill_2
XFILLER_145_667 VDD VSS sg13g2_fill_1
XFILLER_160_637 VDD VSS sg13g2_decap_8
XFILLER_63_1005 VDD VSS sg13g2_decap_8
XFILLER_158_1291 VDD VSS sg13g2_decap_8
Xfanout406 _09077_/S _09127_/S VDD VSS sg13g2_buf_1
XFILLER_8_1208 VDD VSS sg13g2_decap_8
XFILLER_67_1185 VDD VSS sg13g2_decap_8
Xfanout417 _12415_/A _12372_/A VDD VSS sg13g2_buf_1
X_09821_ _14409_/D _09920_/A1 _14409_/Q _09832_/S VDD VSS sg13g2_mux2_1
XFILLER_28_1147 VDD VSS sg13g2_decap_8
XFILLER_154_1155 VDD VSS sg13g2_decap_8
Xfanout428 _10030_/S fanout432/X VDD VSS sg13g2_buf_1
XFILLER_98_264 VDD VSS sg13g2_decap_8
XFILLER_87_927 VDD VSS sg13g2_decap_8
XFILLER_101_715 VDD VSS sg13g2_decap_8
Xfanout439 _09828_/S _09822_/S VDD VSS sg13g2_buf_1
XFILLER_59_629 VDD VSS sg13g2_decap_8
XFILLER_113_597 VDD VSS sg13g2_decap_8
XFILLER_98_286 VDD VSS sg13g2_fill_1
X_09752_ _14342_/D _14342_/Q _09752_/A1 _09758_/S VDD VSS sg13g2_mux2_1
XFILLER_100_236 VDD VSS sg13g2_fill_1
XFILLER_80_1363 VDD VSS sg13g2_decap_8
X_08703_ _15184_/D hold3061/X _15184_/Q _10195_/S VDD VSS sg13g2_mux2_1
X_09683_ _14275_/D _09749_/A1 _14275_/Q _09696_/S VDD VSS sg13g2_mux2_1
XFILLER_41_1369 VDD VSS sg13g2_decap_8
XFILLER_94_481 VDD VSS sg13g2_decap_8
XFILLER_54_312 VDD VSS sg13g2_fill_2
X_08634_ _08640_/C _08659_/A _08333_/Y _08652_/B1 VDD VSS sg13g2_o21ai_1
XFILLER_82_643 VDD VSS sg13g2_decap_8
X_13697__2505 _13697_/RESET_B VDD VSS sg13g2_tiehi
XFILLER_39_1210 VDD VSS sg13g2_decap_8
X_08565_ _08581_/A _07862_/Y _08522_/C _08541_/A _08608_/B _08563_/Y VDD VSS sg13g2_a221oi_1
XFILLER_81_164 VDD VSS sg13g2_decap_8
XFILLER_35_592 VDD VSS sg13g2_decap_8
X_08496_ _08497_/B _08434_/B _07829_/B _07950_/Y VDD VSS sg13g2_a21oi_1
XFILLER_165_1273 VDD VSS sg13g2_decap_8
XFILLER_74_1156 VDD VSS sg13g2_decap_8
XFILLER_39_1287 VDD VSS sg13g2_decap_8
XFILLER_168_748 VDD VSS sg13g2_decap_8
XFILLER_52_1410 VDD VSS sg13g2_decap_8
XFILLER_167_225 VDD VSS sg13g2_decap_8
XFILLER_22_264 VDD VSS sg13g2_fill_1
XFILLER_126_1279 VDD VSS sg13g2_decap_8
XFILLER_183_707 VDD VSS sg13g2_decap_8
X_14077__2125 _14077_/RESET_B VDD VSS sg13g2_tiehi
XFILLER_109_804 VDD VSS sg13g2_decap_8
XFILLER_155_409 VDD VSS sg13g2_decap_8
XFILLER_10_448 VDD VSS sg13g2_decap_8
XFILLER_148_461 VDD VSS sg13g2_decap_8
XFILLER_13_67 VDD VSS sg13g2_decap_8
XFILLER_148_472 VDD VSS sg13g2_fill_1
XFILLER_182_228 VDD VSS sg13g2_decap_8
XFILLER_109_848 VDD VSS sg13g2_decap_8
X_09117_ _09117_/Y _09151_/A _09117_/B _09117_/C VDD VSS sg13g2_nand3_1
XFILLER_135_111 VDD VSS sg13g2_decap_8
XFILLER_159_1011 VDD VSS sg13g2_decap_8
XFILLER_135_122 VDD VSS sg13g2_fill_2
XFILLER_159_1022 VDD VSS sg13g2_fill_1
XFILLER_129_89 VDD VSS sg13g2_decap_8
X_09048_ _10720_/B _09060_/S _15035_/Q _09047_/Y VDD VSS sg13g2_o21ai_1
XFILLER_135_155 VDD VSS sg13g2_decap_8
XFILLER_123_306 VDD VSS sg13g2_fill_1
X_14717__1485 _14717_/RESET_B VDD VSS sg13g2_tiehi
XFILLER_11_1184 VDD VSS sg13g2_decap_8
XFILLER_163_497 VDD VSS sg13g2_fill_1
XFILLER_172_1200 VDD VSS sg13g2_decap_8
XFILLER_176_1380 VDD VSS sg13g2_decap_8
XFILLER_85_1274 VDD VSS sg13g2_decap_8
XFILLER_46_1225 VDD VSS sg13g2_decap_8
XFILLER_2_658 VDD VSS sg13g2_decap_8
XFILLER_132_851 VDD VSS sg13g2_decap_8
X_11010_ _11012_/B _11010_/A _11010_/B _11010_/C VDD VSS sg13g2_nand3_1
XFILLER_150_158 VDD VSS sg13g2_decap_8
XFILLER_132_884 VDD VSS sg13g2_decap_8
XFILLER_81_1138 VDD VSS sg13g2_fill_1
XFILLER_1_168 VDD VSS sg13g2_decap_8
XFILLER_133_1228 VDD VSS sg13g2_decap_4
XFILLER_172_1277 VDD VSS sg13g2_decap_8
Xfanout940 _10647_/A _15205_/Q VDD VSS sg13g2_buf_1
Xfanout951 _12936_/B _13558_/C VDD VSS sg13g2_buf_1
Xfanout962 _13506_/A _15128_/Q VDD VSS sg13g2_buf_1
Xfanout973 _12976_/B _13106_/B VDD VSS sg13g2_buf_1
XFILLER_58_640 VDD VSS sg13g2_decap_8
XFILLER_161_21 VDD VSS sg13g2_decap_8
Xfanout984 _08369_/B _08391_/A VDD VSS sg13g2_buf_1
XFILLER_38_53 VDD VSS sg13g2_decap_8
Xfanout995 _10843_/C _13345_/B VDD VSS sg13g2_buf_1
X_12961_ _12962_/B _12961_/A _12988_/C _12961_/C VDD VSS sg13g2_nand3_1
XFILLER_46_813 VDD VSS sg13g2_decap_8
XFILLER_45_301 VDD VSS sg13g2_decap_8
X_14700_ _14700_/Q clkload53/A _14700_/D _14700_/RESET_B VDD VSS sg13g2_dfrbpq_1
XFILLER_85_481 VDD VSS sg13g2_decap_4
XFILLER_18_548 VDD VSS sg13g2_decap_8
X_11912_ _11913_/B _11912_/A _11912_/B VDD VSS sg13g2_nor2_1
XFILLER_2_1330 VDD VSS sg13g2_decap_8
XFILLER_161_98 VDD VSS sg13g2_decap_8
X_12892_ _12894_/B _14900_/Q _13687_/Q VDD VSS sg13g2_xor2_1
X_14892__2783 _14892_/RESET_B VDD VSS sg13g2_tiehi
XFILLER_79_1067 VDD VSS sg13g2_fill_1
XFILLER_73_665 VDD VSS sg13g2_decap_4
XFILLER_166_0 VDD VSS sg13g2_decap_8
X_14287__1915 _14287_/RESET_B VDD VSS sg13g2_tiehi
X_14631_ _14631_/Q _14727_/CLK _14631_/D _14631_/RESET_B VDD VSS sg13g2_dfrbpq_1
XFILLER_72_153 VDD VSS sg13g2_decap_8
XFILLER_57_1310 VDD VSS sg13g2_decap_8
X_11843_ _11910_/B _11843_/A _13675_/Q VDD VSS sg13g2_xnor2_1
XFILLER_33_518 VDD VSS sg13g2_decap_4
XFILLER_166_1048 VDD VSS sg13g2_decap_8
XFILLER_54_52 VDD VSS sg13g2_decap_8
XFILLER_183_1351 VDD VSS sg13g2_decap_8
XFILLER_14_743 VDD VSS sg13g2_decap_8
X_14562_ _14562_/Q clkload7/A _14562_/D _14562_/RESET_B VDD VSS sg13g2_dfrbpq_1
XFILLER_92_1245 VDD VSS sg13g2_decap_8
X_11774_ _11774_/Y _11774_/A _11776_/B VDD VSS sg13g2_nand2_1
XFILLER_92_1256 VDD VSS sg13g2_fill_2
XFILLER_13_242 VDD VSS sg13g2_decap_8
XFILLER_158_203 VDD VSS sg13g2_decap_8
XFILLER_57_1387 VDD VSS sg13g2_decap_8
X_13513_ _15136_/D _15136_/Q _13533_/A _13515_/S VDD VSS sg13g2_mux2_1
X_10725_ _10725_/Y _10725_/A _10725_/B VDD VSS sg13g2_nor2_1
X_14493_ _14493_/Q clkload31/A _14493_/D _14493_/RESET_B VDD VSS sg13g2_dfrbpq_1
XFILLER_9_224 VDD VSS sg13g2_decap_8
XFILLER_186_567 VDD VSS sg13g2_decap_8
XFILLER_139_450 VDD VSS sg13g2_decap_8
X_13444_ _13444_/Y _13444_/A _13444_/B _13444_/C VDD VSS sg13g2_nor3_1
X_10656_ _10658_/B _14891_/Q _10663_/D VDD VSS sg13g2_nor2_1
XFILLER_127_634 VDD VSS sg13g2_decap_4
XFILLER_142_1092 VDD VSS sg13g2_decap_8
XFILLER_177_1100 VDD VSS sg13g2_decap_8
Xclkload16 clkload16/Y clkload16/A VDD VSS sg13g2_inv_2
XFILLER_166_280 VDD VSS sg13g2_decap_8
X_13375_ _13378_/C _15124_/Q _13388_/B VDD VSS sg13g2_nand2_1
Xclkload27 clkload27/Y clkload27/A VDD VSS sg13g2_inv_2
X_10587_ _10587_/Y _12963_/A _10594_/D _10499_/C VDD VSS sg13g2_o21ai_1
XFILLER_166_291 VDD VSS sg13g2_fill_1
XFILLER_186_84 VDD VSS sg13g2_decap_8
Xclkload38 clkload38/Y clkload38/A VDD VSS sg13g2_inv_4
XFILLER_6_942 VDD VSS sg13g2_decap_8
XFILLER_115_807 VDD VSS sg13g2_decap_8
Xclkload49 clkload49/Y clkload49/A VDD VSS sg13g2_inv_1
XFILLER_154_453 VDD VSS sg13g2_fill_2
XFILLER_155_976 VDD VSS sg13g2_fill_1
X_15114_ _15114_/Q _15165_/CLK _15114_/D _15114_/RESET_B VDD VSS sg13g2_dfrbpq_1
X_12326_ _12326_/Y _12328_/A1 _13882_/Q _12326_/B1 VDD VSS sg13g2_a21oi_1
XFILLER_5_441 VDD VSS sg13g2_decap_8
XFILLER_115_829 VDD VSS sg13g2_decap_8
XFILLER_29_1401 VDD VSS sg13g2_decap_8
XFILLER_142_637 VDD VSS sg13g2_decap_8
XFILLER_177_1177 VDD VSS sg13g2_decap_8
XFILLER_138_1139 VDD VSS sg13g2_fill_2
XFILLER_142_648 VDD VSS sg13g2_fill_1
X_15045_ _15045_/Q clkload81/A _15045_/D _15045_/RESET_B VDD VSS sg13g2_dfrbpq_1
XFILLER_68_1461 VDD VSS sg13g2_decap_8
XFILLER_181_294 VDD VSS sg13g2_decap_8
X_12257_ _12257_/Y _12186_/A _13944_/Q _12257_/B1 VDD VSS sg13g2_a21oi_1
XFILLER_155_1431 VDD VSS sg13g2_decap_8
X_13775__2427 _13775_/RESET_B VDD VSS sg13g2_tiehi
XFILLER_116_1404 VDD VSS sg13g2_decap_8
XFILLER_79_93 VDD VSS sg13g2_decap_8
X_11208_ _11209_/B _11206_/Y _11204_/Y _11207_/Y VDD VSS sg13g2_o21ai_1
XFILLER_96_702 VDD VSS sg13g2_decap_8
X_12188_ _12188_/Y _12188_/A _12188_/B _12308_/C VDD VSS sg13g2_nand3_1
X_13811__2391 _13811_/RESET_B VDD VSS sg13g2_tiehi
XFILLER_96_724 VDD VSS sg13g2_fill_1
XFILLER_64_1358 VDD VSS sg13g2_decap_8
XFILLER_29_1478 VDD VSS sg13g2_fill_1
XFILLER_150_681 VDD VSS sg13g2_decap_8
XFILLER_150_692 VDD VSS sg13g2_fill_1
X_15164__2540 _15164_/RESET_B VDD VSS sg13g2_tiehi
XFILLER_95_212 VDD VSS sg13g2_fill_1
XFILLER_68_437 VDD VSS sg13g2_decap_8
X_11139_ _11139_/Y _11190_/C _11163_/A _11139_/B1 VDD VSS sg13g2_a21oi_1
XFILLER_96_768 VDD VSS sg13g2_decap_8
XFILLER_27_1180 VDD VSS sg13g2_decap_8
XFILLER_95_278 VDD VSS sg13g2_decap_8
XFILLER_7_1274 VDD VSS sg13g2_decap_8
XFILLER_77_982 VDD VSS sg13g2_decap_8
XFILLER_55_109 VDD VSS sg13g2_decap_8
XFILLER_110_1003 VDD VSS sg13g2_decap_8
XFILLER_77_993 VDD VSS sg13g2_fill_2
XFILLER_49_684 VDD VSS sg13g2_decap_8
XFILLER_37_835 VDD VSS sg13g2_fill_1
X_14155__2047 _14155_/RESET_B VDD VSS sg13g2_tiehi
XFILLER_3_1138 VDD VSS sg13g2_decap_8
XFILLER_36_312 VDD VSS sg13g2_fill_1
X_13990__2212 _13990_/RESET_B VDD VSS sg13g2_tiehi
XFILLER_52_805 VDD VSS sg13g2_decap_8
XFILLER_93_1009 VDD VSS sg13g2_decap_8
XFILLER_91_462 VDD VSS sg13g2_decap_8
XFILLER_36_367 VDD VSS sg13g2_fill_1
X_14829_ _14829_/Q _14893_/CLK _14829_/D _14829_/RESET_B VDD VSS sg13g2_dfrbpq_1
XFILLER_64_698 VDD VSS sg13g2_decap_8
XFILLER_36_389 VDD VSS sg13g2_decap_8
XFILLER_17_570 VDD VSS sg13g2_decap_8
XFILLER_91_484 VDD VSS sg13g2_decap_8
X_08350_ _08352_/A _07934_/Y _08350_/B VDD VSS sg13g2_nand2b_1
XFILLER_162_1402 VDD VSS sg13g2_decap_8
XFILLER_75_1454 VDD VSS sg13g2_decap_8
XFILLER_51_348 VDD VSS sg13g2_fill_2
XFILLER_177_501 VDD VSS sg13g2_decap_8
XFILLER_32_562 VDD VSS sg13g2_decap_8
X_08281_ _08281_/Y _08363_/S1 _08207_/X _08279_/X VDD VSS sg13g2_a21oi_1
XFILLER_32_573 VDD VSS sg13g2_fill_2
XFILLER_60_893 VDD VSS sg13g2_decap_8
XFILLER_81_0 VDD VSS sg13g2_decap_8
XFILLER_20_768 VDD VSS sg13g2_decap_8
XFILLER_146_921 VDD VSS sg13g2_decap_8
XFILLER_34_1173 VDD VSS sg13g2_decap_8
XFILLER_160_1192 VDD VSS sg13g2_decap_8
XFILLER_9_791 VDD VSS sg13g2_decap_8
XFILLER_118_656 VDD VSS sg13g2_decap_8
XFILLER_118_667 VDD VSS sg13g2_fill_2
X_14962__2648 _14962_/RESET_B VDD VSS sg13g2_tiehi
XFILLER_12_1460 VDD VSS sg13g2_decap_8
XFILLER_145_464 VDD VSS sg13g2_decap_8
XFILLER_160_401 VDD VSS sg13g2_fill_1
XFILLER_172_261 VDD VSS sg13g2_decap_8
XFILLER_69_1269 VDD VSS sg13g2_decap_8
XFILLER_133_637 VDD VSS sg13g2_decap_8
XFILLER_161_957 VDD VSS sg13g2_decap_8
XFILLER_160_445 VDD VSS sg13g2_decap_8
XFILLER_114_851 VDD VSS sg13g2_decap_8
XFILLER_99_540 VDD VSS sg13g2_fill_2
XFILLER_82_1414 VDD VSS sg13g2_decap_8
XFILLER_114_862 VDD VSS sg13g2_fill_1
XFILLER_119_1050 VDD VSS sg13g2_decap_4
X_14365__1837 _14365_/RESET_B VDD VSS sg13g2_tiehi
Xfanout203 _10157_/A1 _09925_/A1 VDD VSS sg13g2_buf_1
Xfanout214 _10405_/C _10414_/B VDD VSS sg13g2_buf_1
XFILLER_8_1005 VDD VSS sg13g2_decap_8
XFILLER_141_670 VDD VSS sg13g2_fill_1
XFILLER_59_415 VDD VSS sg13g2_decap_8
Xfanout225 _09921_/A1 _09622_/A0 VDD VSS sg13g2_buf_1
XFILLER_99_584 VDD VSS sg13g2_fill_2
Xfanout236 _12271_/A fanout242/X VDD VSS sg13g2_buf_1
XFILLER_101_523 VDD VSS sg13g2_decap_8
XFILLER_119_1094 VDD VSS sg13g2_decap_8
Xfanout247 _10151_/A1 fanout250/X VDD VSS sg13g2_buf_1
X_09804_ _14393_/D _09903_/A0 _14393_/Q _09804_/S VDD VSS sg13g2_mux2_1
XFILLER_87_746 VDD VSS sg13g2_decap_4
Xfanout258 _09686_/A0 _09752_/A1 VDD VSS sg13g2_buf_1
XFILLER_86_234 VDD VSS sg13g2_decap_8
Xfanout269 _09890_/S _09892_/S VDD VSS sg13g2_buf_1
XFILLER_75_908 VDD VSS sg13g2_fill_1
XFILLER_140_191 VDD VSS sg13g2_decap_8
X_07996_ _07996_/X _15104_/Q _15091_/Q VDD VSS sg13g2_or2_1
XFILLER_74_407 VDD VSS sg13g2_decap_4
XFILLER_45_1291 VDD VSS sg13g2_decap_8
X_09735_ _14326_/D _09933_/A1 _14326_/Q _09739_/S VDD VSS sg13g2_mux2_1
XFILLER_80_1193 VDD VSS sg13g2_decap_8
XFILLER_41_1166 VDD VSS sg13g2_decap_8
XFILLER_28_846 VDD VSS sg13g2_decap_4
XFILLER_55_643 VDD VSS sg13g2_decap_8
X_14580__1622 _14580_/RESET_B VDD VSS sg13g2_tiehi
X_09666_ _14259_/D _10095_/A0 _14259_/Q _09672_/S VDD VSS sg13g2_mux2_1
XFILLER_167_1346 VDD VSS sg13g2_decap_8
X_08617_ _08622_/C _08617_/A _08617_/B VDD VSS sg13g2_nor2_1
XFILLER_55_687 VDD VSS sg13g2_decap_8
XFILLER_54_164 VDD VSS sg13g2_decap_4
XFILLER_131_79 VDD VSS sg13g2_fill_2
X_09597_ _14194_/D _14194_/Q _09630_/A0 _09604_/S VDD VSS sg13g2_mux2_1
XFILLER_27_389 VDD VSS sg13g2_decap_4
XFILLER_42_348 VDD VSS sg13g2_decap_8
XFILLER_39_1040 VDD VSS sg13g2_decap_8
X_08548_ _08548_/Y _08612_/S _08548_/B VDD VSS sg13g2_nand2_1
XFILLER_168_512 VDD VSS sg13g2_fill_2
XFILLER_165_1081 VDD VSS sg13g2_fill_2
XFILLER_23_573 VDD VSS sg13g2_decap_8
X_14200__2002 _14200_/RESET_B VDD VSS sg13g2_tiehi
XFILLER_126_1054 VDD VSS sg13g2_decap_8
X_08479_ _08479_/Y _13555_/A _07949_/C _08190_/A VDD VSS sg13g2_a21oi_1
X_13853__2349 _13853_/RESET_B VDD VSS sg13g2_tiehi
XFILLER_24_77 VDD VSS sg13g2_fill_2
XFILLER_11_746 VDD VSS sg13g2_decap_8
XFILLER_138_4 VDD VSS sg13g2_fill_2
X_14869__2829 _14869_/RESET_B VDD VSS sg13g2_tiehi
X_10510_ _10576_/C _10647_/A _10647_/D _10521_/D VDD VSS sg13g2_and3_1
X_11490_ _11490_/X _14562_/Q _14594_/Q _14626_/Q _14658_/Q _11493_/S0 _07654_/A VDD
+ VSS sg13g2_mux4_1
XFILLER_109_601 VDD VSS sg13g2_decap_8
XFILLER_10_245 VDD VSS sg13g2_decap_8
XFILLER_126_1098 VDD VSS sg13g2_fill_1
XFILLER_17_1371 VDD VSS sg13g2_decap_8
XFILLER_7_728 VDD VSS sg13g2_decap_8
XFILLER_143_1390 VDD VSS sg13g2_fill_2
X_10441_ _14836_/D _10441_/A _10442_/B _10441_/C VDD VSS sg13g2_and3_1
XFILLER_52_1284 VDD VSS sg13g2_decap_8
XFILLER_108_111 VDD VSS sg13g2_fill_2
XFILLER_40_32 VDD VSS sg13g2_fill_1
XFILLER_13_1257 VDD VSS sg13g2_decap_8
XFILLER_6_249 VDD VSS sg13g2_decap_8
XFILLER_156_21 VDD VSS sg13g2_decap_8
XFILLER_136_453 VDD VSS sg13g2_fill_2
XFILLER_100_1238 VDD VSS sg13g2_decap_8
XFILLER_136_464 VDD VSS sg13g2_decap_8
XFILLER_137_987 VDD VSS sg13g2_decap_8
XFILLER_178_1453 VDD VSS sg13g2_decap_8
X_13160_ _13160_/Y _13159_/Y _13160_/B _13160_/C VDD VSS sg13g2_nand3b_1
X_10372_ _14815_/D _14815_/Q _10378_/D _10371_/Y VDD VSS sg13g2_a21oi_1
XFILLER_137_998 VDD VSS sg13g2_fill_2
XFILLER_163_261 VDD VSS sg13g2_decap_8
XFILLER_152_946 VDD VSS sg13g2_decap_8
XFILLER_136_497 VDD VSS sg13g2_fill_2
X_12111_ _12111_/Y _12090_/A _13908_/Q VDD VSS sg13g2_nand2b_1
X_13091_ _13091_/Y _13092_/A _13092_/C _13112_/A VDD VSS sg13g2_a21oi_1
XFILLER_3_956 VDD VSS sg13g2_decap_8
XFILLER_105_851 VDD VSS sg13g2_decap_4
X_12042_ _12042_/X _13970_/Q _14002_/Q _14034_/Q _14066_/Q _12025_/A _12026_/C VDD
+ VSS sg13g2_mux4_1
XFILLER_78_702 VDD VSS sg13g2_fill_2
XFILLER_2_455 VDD VSS sg13g2_decap_8
XFILLER_137_1150 VDD VSS sg13g2_fill_2
XFILLER_46_1033 VDD VSS sg13g2_decap_8
XFILLER_105_895 VDD VSS sg13g2_fill_2
XFILLER_137_1172 VDD VSS sg13g2_decap_4
XFILLER_49_63 VDD VSS sg13g2_decap_8
XFILLER_172_1085 VDD VSS sg13g2_decap_8
XFILLER_172_53 VDD VSS sg13g2_decap_8
XFILLER_46_1088 VDD VSS sg13g2_decap_4
XFILLER_131_191 VDD VSS sg13g2_decap_8
XFILLER_133_1047 VDD VSS sg13g2_fill_2
XFILLER_172_1096 VDD VSS sg13g2_fill_2
XFILLER_19_802 VDD VSS sg13g2_decap_8
Xfanout770 _08426_/A _07629_/Y VDD VSS sg13g2_buf_1
Xfanout781 _08422_/S _07612_/Y VDD VSS sg13g2_buf_1
XFILLER_59_971 VDD VSS sg13g2_fill_1
XFILLER_4_1414 VDD VSS sg13g2_decap_8
XFILLER_150_1350 VDD VSS sg13g2_decap_4
Xfanout792 _12650_/S _12609_/S VDD VSS sg13g2_buf_1
X_13993_ _13993_/Q _14665_/CLK _13993_/D _13993_/RESET_B VDD VSS sg13g2_dfrbpq_1
XFILLER_77_289 VDD VSS sg13g2_decap_8
XFILLER_58_470 VDD VSS sg13g2_decap_8
XFILLER_24_1375 VDD VSS sg13g2_decap_8
XFILLER_98_1432 VDD VSS sg13g2_decap_8
XFILLER_20_1228 VDD VSS sg13g2_decap_8
X_12944_ _12946_/A _12945_/A _12944_/B _12988_/B VDD VSS sg13g2_nand3_1
XFILLER_65_51 VDD VSS sg13g2_decap_4
XFILLER_92_259 VDD VSS sg13g2_decap_8
XFILLER_19_879 VDD VSS sg13g2_fill_1
XFILLER_111_1378 VDD VSS sg13g2_decap_4
XFILLER_74_985 VDD VSS sg13g2_decap_8
XFILLER_34_827 VDD VSS sg13g2_decap_8
XFILLER_185_1446 VDD VSS sg13g2_decap_8
XFILLER_73_473 VDD VSS sg13g2_decap_8
X_12875_ _12875_/Y _12861_/B _12877_/C VDD VSS sg13g2_nand2b_1
Xclkbuf_5_8__f_clk_i clkbuf_leaf_9_clk_i/A clkbuf_4_4_0_clk_i/X VDD VSS sg13g2_buf_16
XFILLER_61_635 VDD VSS sg13g2_decap_8
XFILLER_27_890 VDD VSS sg13g2_decap_8
X_14614_ _14614_/Q clkload45/A _14614_/D _14614_/RESET_B VDD VSS sg13g2_dfrbpq_1
X_11826_ _11826_/Y _11826_/A1 _13932_/Q _11894_/B VDD VSS sg13g2_a21oi_1
XFILLER_159_523 VDD VSS sg13g2_decap_8
XFILLER_57_1184 VDD VSS sg13g2_decap_8
X_14545_ _14545_/Q clkload33/A _14545_/D _14545_/RESET_B VDD VSS sg13g2_dfrbpq_1
XFILLER_14_584 VDD VSS sg13g2_fill_2
X_11757_ _11761_/A _11756_/X _12088_/B VDD VSS sg13g2_nand2b_1
XFILLER_105_1116 VDD VSS sg13g2_decap_4
XFILLER_18_1168 VDD VSS sg13g2_decap_8
X_14443__1759 _14443_/RESET_B VDD VSS sg13g2_tiehi
XFILLER_186_364 VDD VSS sg13g2_decap_8
X_13829__2373 _13829_/RESET_B VDD VSS sg13g2_tiehi
X_10708_ _10708_/Y _14905_/Q _10929_/B VDD VSS sg13g2_nand2_1
X_14476_ _14476_/Q _14508_/CLK _14476_/D _14476_/RESET_B VDD VSS sg13g2_dfrbpq_1
XFILLER_105_1149 VDD VSS sg13g2_fill_2
X_11688_ _11688_/Y _11685_/Y _11687_/X _11901_/B1 VDD VSS sg13g2_o21ai_1
XFILLER_35_1471 VDD VSS sg13g2_decap_4
XFILLER_128_921 VDD VSS sg13g2_decap_8
XFILLER_128_932 VDD VSS sg13g2_fill_2
X_13427_ _13427_/Y _13440_/A _13469_/A _13427_/C VDD VSS sg13g2_nand3_1
XFILLER_31_1335 VDD VSS sg13g2_decap_8
XFILLER_179_1239 VDD VSS sg13g2_decap_8
X_10639_ _10639_/Y _14887_/Q _10642_/C _10655_/B VDD VSS sg13g2_a21oi_1
XFILLER_122_1474 VDD VSS sg13g2_fill_1
XFILLER_155_751 VDD VSS sg13g2_decap_8
XFILLER_115_604 VDD VSS sg13g2_decap_8
XFILLER_155_784 VDD VSS sg13g2_decap_8
X_13358_ _15072_/D _15072_/Q _13470_/A2 _13357_/Y VDD VSS sg13g2_a21o_1
XFILLER_142_434 VDD VSS sg13g2_decap_4
XFILLER_170_743 VDD VSS sg13g2_decap_8
X_12309_ _12310_/A _13978_/Q _14010_/Q _14042_/Q _14074_/Q _12330_/S0 _12307_/C VDD
+ VSS sg13g2_mux4_1
XFILLER_114_136 VDD VSS sg13g2_decap_8
X_13289_ _13290_/D _13300_/C _13289_/B _13289_/C _13289_/D VDD VSS sg13g2_nor4_1
XFILLER_142_456 VDD VSS sg13g2_fill_2
XFILLER_142_478 VDD VSS sg13g2_decap_8
X_15028_ _15028_/Q _15196_/CLK _15028_/D _15028_/RESET_B VDD VSS sg13g2_dfrbpq_1
XFILLER_170_798 VDD VSS sg13g2_fill_1
XFILLER_9_1325 VDD VSS sg13g2_decap_8
XFILLER_69_713 VDD VSS sg13g2_fill_2
XFILLER_68_201 VDD VSS sg13g2_decap_8
XFILLER_29_1275 VDD VSS sg13g2_decap_8
XFILLER_69_746 VDD VSS sg13g2_decap_8
XFILLER_111_843 VDD VSS sg13g2_decap_8
X_07850_ _08646_/A _15016_/Q _07850_/B VDD VSS sg13g2_nand2_1
XFILLER_110_342 VDD VSS sg13g2_decap_8
XFILLER_116_1267 VDD VSS sg13g2_fill_1
XFILLER_68_256 VDD VSS sg13g2_decap_4
XFILLER_84_716 VDD VSS sg13g2_fill_1
XFILLER_111_887 VDD VSS sg13g2_decap_8
XFILLER_68_278 VDD VSS sg13g2_decap_4
X_07781_ _08411_/A _07782_/A _15002_/Q VDD VSS sg13g2_nor2_1
XFILLER_83_215 VDD VSS sg13g2_decap_8
XFILLER_7_1071 VDD VSS sg13g2_decap_8
XFILLER_37_610 VDD VSS sg13g2_fill_2
Xinput3 input3/X input3/A VDD VSS sg13g2_buf_1
XFILLER_42_1464 VDD VSS sg13g2_decap_8
X_09520_ _14119_/D _10150_/A1 _14119_/Q _09533_/S VDD VSS sg13g2_mux2_1
XFILLER_80_900 VDD VSS sg13g2_fill_1
XFILLER_64_451 VDD VSS sg13g2_decap_8
X_09451_ _14052_/D _09583_/A1 _14052_/Q _09467_/S VDD VSS sg13g2_mux2_1
XFILLER_149_1065 VDD VSS sg13g2_fill_1
XFILLER_51_112 VDD VSS sg13g2_decap_8
X_08402_ _08402_/Y _08402_/A _08402_/B _08402_/C _08625_/A VDD VSS sg13g2_nor4_1
XFILLER_80_955 VDD VSS sg13g2_fill_1
XFILLER_52_657 VDD VSS sg13g2_fill_2
X_09382_ _13985_/D _10077_/A0 _13985_/Q _09397_/S VDD VSS sg13g2_mux2_1
XFILLER_75_1251 VDD VSS sg13g2_decap_8
XFILLER_127_1330 VDD VSS sg13g2_decap_4
XFILLER_178_843 VDD VSS sg13g2_decap_8
X_08333_ _08333_/Y _08244_/B _08149_/Y _08241_/Y VDD VSS sg13g2_o21ai_1
XFILLER_51_178 VDD VSS sg13g2_decap_8
XFILLER_127_1363 VDD VSS sg13g2_decap_8
XFILLER_33_893 VDD VSS sg13g2_decap_8
XFILLER_123_1205 VDD VSS sg13g2_decap_8
XFILLER_177_342 VDD VSS sg13g2_decap_8
XFILLER_60_690 VDD VSS sg13g2_fill_2
XFILLER_36_1257 VDD VSS sg13g2_decap_8
XFILLER_177_353 VDD VSS sg13g2_fill_1
XFILLER_162_1276 VDD VSS sg13g2_decap_8
X_08264_ _08264_/Y _07927_/Y _07930_/A _08422_/S VDD VSS sg13g2_a21oi_1
XFILLER_71_1159 VDD VSS sg13g2_decap_8
XFILLER_123_1249 VDD VSS sg13g2_decap_8
XFILLER_177_375 VDD VSS sg13g2_decap_8
X_14419__1783 _14419_/RESET_B VDD VSS sg13g2_tiehi
X_08195_ _08195_/Y _08194_/B _08085_/A _08194_/Y VDD VSS sg13g2_o21ai_1
XFILLER_119_954 VDD VSS sg13g2_fill_1
XFILLER_146_740 VDD VSS sg13g2_decap_4
XFILLER_118_453 VDD VSS sg13g2_decap_8
XFILLER_134_902 VDD VSS sg13g2_decap_8
XFILLER_69_1022 VDD VSS sg13g2_decap_8
XFILLER_118_464 VDD VSS sg13g2_fill_2
XFILLER_145_250 VDD VSS sg13g2_decap_8
XFILLER_106_626 VDD VSS sg13g2_decap_8
XFILLER_133_412 VDD VSS sg13g2_fill_2
XFILLER_146_795 VDD VSS sg13g2_decap_8
XFILLER_156_1003 VDD VSS sg13g2_fill_2
XFILLER_161_721 VDD VSS sg13g2_decap_8
XFILLER_10_35 VDD VSS sg13g2_decap_8
X_14598__1604 _14598_/RESET_B VDD VSS sg13g2_tiehi
XFILLER_105_125 VDD VSS sg13g2_decap_8
XFILLER_133_434 VDD VSS sg13g2_decap_4
XFILLER_133_445 VDD VSS sg13g2_decap_8
XFILLER_161_765 VDD VSS sg13g2_decap_8
XFILLER_0_904 VDD VSS sg13g2_decap_8
XFILLER_82_1211 VDD VSS sg13g2_decap_8
XFILLER_121_618 VDD VSS sg13g2_fill_1
XFILLER_133_478 VDD VSS sg13g2_decap_4
XFILLER_86_1391 VDD VSS sg13g2_decap_8
XFILLER_102_810 VDD VSS sg13g2_fill_2
XFILLER_120_117 VDD VSS sg13g2_decap_8
Xfanout1009 _10037_/A _10070_/A VDD VSS sg13g2_buf_1
XFILLER_173_1372 VDD VSS sg13g2_decap_8
XFILLER_86_28 VDD VSS sg13g2_fill_2
XFILLER_47_1375 VDD VSS sg13g2_decap_8
XFILLER_43_1217 VDD VSS sg13g2_decap_8
XFILLER_87_554 VDD VSS sg13g2_fill_1
XFILLER_82_1288 VDD VSS sg13g2_decap_8
XFILLER_59_245 VDD VSS sg13g2_fill_2
XFILLER_47_407 VDD VSS sg13g2_decap_8
XFILLER_75_727 VDD VSS sg13g2_fill_1
XFILLER_101_386 VDD VSS sg13g2_fill_1
X_07979_ _07979_/Y _07979_/A _07981_/C _07979_/C VDD VSS sg13g2_nand3_1
XFILLER_19_77 VDD VSS sg13g2_decap_8
X_13907__2295 _13907_/RESET_B VDD VSS sg13g2_tiehi
X_09718_ _14309_/D _09916_/A1 _14309_/Q _09729_/S VDD VSS sg13g2_mux2_1
X_10990_ _11009_/C _15116_/Q _10995_/B VDD VSS sg13g2_xnor2_1
XFILLER_56_974 VDD VSS sg13g2_decap_8
XFILLER_76_1004 VDD VSS sg13g2_fill_1
XFILLER_43_613 VDD VSS sg13g2_fill_2
X_09649_ _14242_/D _10145_/A1 _14242_/Q _09663_/S VDD VSS sg13g2_mux2_1
XFILLER_83_782 VDD VSS sg13g2_decap_8
XFILLER_167_1143 VDD VSS sg13g2_decap_8
XFILLER_16_849 VDD VSS sg13g2_decap_8
X_12660_ _12660_/X _14385_/Q _14417_/Q _14481_/Q _14513_/Q _12661_/S0 _12661_/S1 VDD
+ VSS sg13g2_mux4_1
XFILLER_43_668 VDD VSS sg13g2_decap_8
XFILLER_19_1422 VDD VSS sg13g2_decap_8
XFILLER_30_307 VDD VSS sg13g2_decap_8
X_11611_ _11611_/Y _11621_/S0 _14470_/Q VDD VSS sg13g2_nand2b_1
XFILLER_70_487 VDD VSS sg13g2_decap_4
XFILLER_180_1343 VDD VSS sg13g2_decap_8
X_12591_ _12591_/X _13836_/Q _13868_/Q _13900_/Q _13932_/Q _12592_/S0 _12592_/S1 VDD
+ VSS sg13g2_mux4_1
XFILLER_54_1346 VDD VSS sg13g2_decap_8
XFILLER_51_690 VDD VSS sg13g2_decap_8
X_14330_ _14330_/Q _14682_/CLK _14330_/D _14330_/RESET_B VDD VSS sg13g2_dfrbpq_1
XFILLER_11_543 VDD VSS sg13g2_decap_8
XFILLER_129_729 VDD VSS sg13g2_decap_8
X_11542_ _11542_/X _11542_/A _11549_/B VDD VSS sg13g2_and2_1
XFILLER_106_1469 VDD VSS sg13g2_fill_1
XFILLER_183_312 VDD VSS sg13g2_decap_8
XFILLER_7_525 VDD VSS sg13g2_decap_8
XFILLER_129_0 VDD VSS sg13g2_decap_8
X_14261_ _14261_/Q _14677_/CLK _14261_/D _14261_/RESET_B VDD VSS sg13g2_dfrbpq_1
XFILLER_137_740 VDD VSS sg13g2_fill_1
XFILLER_167_53 VDD VSS sg13g2_decap_8
XFILLER_184_868 VDD VSS sg13g2_decap_8
X_11473_ _11473_/X _14689_/Q _14721_/Q _13761_/Q _13793_/Q _11473_/S0 _11473_/S1 VDD
+ VSS sg13g2_mux4_1
XFILLER_52_1081 VDD VSS sg13g2_decap_8
XFILLER_125_902 VDD VSS sg13g2_fill_2
XFILLER_13_1054 VDD VSS sg13g2_decap_8
X_13212_ _13228_/A _14921_/Q _13666_/Q VDD VSS sg13g2_nand2_1
X_10424_ _10521_/C _10647_/A _10429_/D VDD VSS sg13g2_and2_1
XFILLER_109_475 VDD VSS sg13g2_fill_1
XFILLER_125_924 VDD VSS sg13g2_decap_8
XFILLER_171_529 VDD VSS sg13g2_decap_8
XFILLER_178_1250 VDD VSS sg13g2_decap_8
XFILLER_183_389 VDD VSS sg13g2_decap_8
X_14192_ _14192_/Q clkload14/A _14192_/D _14192_/RESET_B VDD VSS sg13g2_dfrbpq_1
XFILLER_87_1133 VDD VSS sg13g2_decap_8
XFILLER_139_1212 VDD VSS sg13g2_fill_1
XFILLER_100_1068 VDD VSS sg13g2_decap_8
X_13143_ _13170_/C _14916_/Q _13671_/Q VDD VSS sg13g2_xnor2_1
X_10355_ _10395_/A _14809_/Q _14810_/Q _14811_/Q VDD VSS sg13g2_nand3_1
XFILLER_98_819 VDD VSS sg13g2_decap_8
XFILLER_48_1139 VDD VSS sg13g2_decap_8
XFILLER_174_1147 VDD VSS sg13g2_decap_8
XFILLER_87_1199 VDD VSS sg13g2_decap_8
XFILLER_3_753 VDD VSS sg13g2_decap_8
XFILLER_65_1431 VDD VSS sg13g2_decap_8
XFILLER_124_478 VDD VSS sg13g2_decap_8
XFILLER_152_798 VDD VSS sg13g2_decap_4
X_13074_ _15037_/D _13067_/Y _13073_/Y _13127_/A VDD VSS sg13g2_a21oi_1
X_10286_ _14789_/D _10286_/A _10288_/B _10365_/C VDD VSS sg13g2_and3_1
XFILLER_97_329 VDD VSS sg13g2_decap_8
XFILLER_2_252 VDD VSS sg13g2_decap_8
XFILLER_111_117 VDD VSS sg13g2_decap_8
XFILLER_183_74 VDD VSS sg13g2_decap_8
XFILLER_78_521 VDD VSS sg13g2_fill_1
X_12025_ _12026_/B _12025_/A _14674_/Q VDD VSS sg13g2_nand2_1
XFILLER_152_1445 VDD VSS sg13g2_decap_8
XFILLER_26_1459 VDD VSS sg13g2_decap_8
XFILLER_93_502 VDD VSS sg13g2_decap_8
XFILLER_78_587 VDD VSS sg13g2_decap_4
XFILLER_4_1211 VDD VSS sg13g2_decap_8
XFILLER_24_1172 VDD VSS sg13g2_decap_8
XFILLER_111_1131 VDD VSS sg13g2_decap_8
XFILLER_19_654 VDD VSS sg13g2_decap_8
X_13976_ _13976_/Q _14514_/CLK _13976_/D _13976_/RESET_B VDD VSS sg13g2_dfrbpq_1
XFILLER_4_1288 VDD VSS sg13g2_decap_8
X_12927_ _12944_/B _12943_/A _12988_/A _12943_/D VDD VSS sg13g2_or3_1
X_14072__2130 _14072_/RESET_B VDD VSS sg13g2_tiehi
XFILLER_74_782 VDD VSS sg13g2_decap_8
XFILLER_185_1243 VDD VSS sg13g2_decap_8
XFILLER_46_495 VDD VSS sg13g2_decap_8
XFILLER_34_635 VDD VSS sg13g2_fill_1
XFILLER_61_421 VDD VSS sg13g2_fill_1
XFILLER_59_1268 VDD VSS sg13g2_decap_8
XFILLER_92_71 VDD VSS sg13g2_decap_8
X_12858_ _12874_/A _12859_/A _13689_/Q VDD VSS sg13g2_and2_1
XFILLER_146_1249 VDD VSS sg13g2_decap_8
XFILLER_22_819 VDD VSS sg13g2_decap_8
XFILLER_92_82 VDD VSS sg13g2_decap_8
X_14676__1526 _14676_/RESET_B VDD VSS sg13g2_tiehi
X_11809_ _11809_/Y _11812_/A1 _14572_/Q VDD VSS sg13g2_nand2b_1
X_12789_ _12789_/X _12785_/X _12784_/X _12781_/X _12780_/X _12789_/S0 _12355_/S VDD
+ VSS sg13g2_mux4_1
XFILLER_14_381 VDD VSS sg13g2_fill_2
X_14712__1490 _14712_/RESET_B VDD VSS sg13g2_tiehi
XFILLER_33_1408 VDD VSS sg13g2_decap_8
XFILLER_72_1468 VDD VSS sg13g2_decap_8
X_14528_ _14528_/Q _14528_/CLK _14528_/D _14528_/RESET_B VDD VSS sg13g2_dfrbpq_1
X_15173__2972 _15173_/RESET_B VDD VSS sg13g2_tiehi
XFILLER_119_217 VDD VSS sg13g2_decap_4
XFILLER_186_161 VDD VSS sg13g2_decap_8
X_14820__2916 _14820_/RESET_B VDD VSS sg13g2_tiehi
X_14459_ _14459_/Q _14491_/CLK _14459_/D _14459_/RESET_B VDD VSS sg13g2_dfrbpq_1
XFILLER_31_1132 VDD VSS sg13g2_decap_8
XFILLER_179_1036 VDD VSS sg13g2_decap_8
XFILLER_122_1260 VDD VSS sg13g2_fill_2
XFILLER_157_1301 VDD VSS sg13g2_decap_8
XFILLER_142_220 VDD VSS sg13g2_decap_8
XFILLER_89_808 VDD VSS sg13g2_decap_8
XFILLER_116_979 VDD VSS sg13g2_decap_8
XFILLER_66_1228 VDD VSS sg13g2_decap_8
XFILLER_89_819 VDD VSS sg13g2_fill_2
Xhold3106 input37/A mem_axi_wready VDD VSS sg13g2_dlygate4sd3_1
XFILLER_44_0 VDD VSS sg13g2_decap_8
XFILLER_157_1378 VDD VSS sg13g2_decap_8
Xhold3117 _13618_/A _13726_/Q VDD VSS sg13g2_dlygate4sd3_1
XFILLER_88_318 VDD VSS sg13g2_fill_2
X_08951_ _08951_/Y _12278_/A _08928_/S _08950_/Y VDD VSS sg13g2_a21oi_1
Xhold3128 _10837_/A _14930_/Q VDD VSS sg13g2_dlygate4sd3_1
XFILLER_69_510 VDD VSS sg13g2_decap_8
Xhold3139 _13626_/A _13734_/Q VDD VSS sg13g2_dlygate4sd3_1
X_07902_ _08074_/B _08063_/A _07903_/B _07884_/Y VDD VSS sg13g2_o21ai_1
X_14282__1920 _14282_/RESET_B VDD VSS sg13g2_tiehi
X_08882_ _08882_/X _08881_/X _11659_/A _08904_/S VDD VSS sg13g2_mux2_1
XFILLER_9_1155 VDD VSS sg13g2_decap_4
XFILLER_97_874 VDD VSS sg13g2_decap_4
XFILLER_5_1008 VDD VSS sg13g2_decap_8
XFILLER_116_1075 VDD VSS sg13g2_decap_8
X_07833_ _07981_/C _08692_/C _12298_/A VDD VSS sg13g2_nand2b_1
XFILLER_9_1199 VDD VSS sg13g2_decap_8
XFILLER_97_896 VDD VSS sg13g2_decap_8
XFILLER_29_418 VDD VSS sg13g2_decap_8
XFILLER_84_524 VDD VSS sg13g2_decap_8
XFILLER_56_226 VDD VSS sg13g2_decap_4
XFILLER_96_395 VDD VSS sg13g2_decap_8
XFILLER_42_1261 VDD VSS sg13g2_decap_8
XFILLER_2_91 VDD VSS sg13g2_decap_8
X_07764_ _15216_/D _15098_/Q _15087_/Q _15074_/Q VDD VSS sg13g2_or3_1
XFILLER_72_708 VDD VSS sg13g2_decap_8
XFILLER_186_1029 VDD VSS sg13g2_decap_8
XFILLER_38_974 VDD VSS sg13g2_decap_8
X_09503_ _14103_/D _10099_/A0 _14103_/Q _09505_/S VDD VSS sg13g2_mux2_1
XFILLER_77_1313 VDD VSS sg13g2_decap_8
XFILLER_71_218 VDD VSS sg13g2_decap_8
XFILLER_129_1403 VDD VSS sg13g2_fill_1
X_07695_ _07696_/C _15079_/Q _15082_/Q _07694_/Y VDD VSS sg13g2_o21ai_1
XFILLER_24_101 VDD VSS sg13g2_decap_8
XFILLER_92_590 VDD VSS sg13g2_decap_8
XFILLER_80_730 VDD VSS sg13g2_decap_8
X_14937__2693 _14937_/RESET_B VDD VSS sg13g2_tiehi
X_09434_ _14036_/D _10130_/A0 _14036_/Q _09434_/S VDD VSS sg13g2_mux2_1
XFILLER_53_977 VDD VSS sg13g2_decap_4
XFILLER_25_668 VDD VSS sg13g2_decap_8
XFILLER_80_774 VDD VSS sg13g2_decap_8
XFILLER_40_605 VDD VSS sg13g2_decap_8
XFILLER_12_329 VDD VSS sg13g2_decap_8
X_09365_ _13969_/D _09961_/A1 _13969_/Q _09372_/S VDD VSS sg13g2_mux2_1
XFILLER_24_189 VDD VSS sg13g2_decap_8
XFILLER_75_1081 VDD VSS sg13g2_decap_8
XFILLER_123_1002 VDD VSS sg13g2_fill_1
X_08316_ _08316_/Y _08275_/A _08303_/Y _08304_/Y VDD VSS sg13g2_o21ai_1
XFILLER_127_1182 VDD VSS sg13g2_decap_8
X_09296_ _13904_/D _13904_/Q _09463_/A0 _09296_/S VDD VSS sg13g2_mux2_1
XFILLER_123_1035 VDD VSS sg13g2_decap_8
XFILLER_177_172 VDD VSS sg13g2_fill_2
XFILLER_36_1087 VDD VSS sg13g2_decap_8
XFILLER_166_846 VDD VSS sg13g2_decap_8
XFILLER_138_548 VDD VSS sg13g2_fill_2
X_13770__2432 _13770_/RESET_B VDD VSS sg13g2_tiehi
X_08247_ _08319_/C _08247_/A _08247_/B _08247_/C VDD VSS sg13g2_nor3_1
XFILLER_14_1352 VDD VSS sg13g2_decap_8
XFILLER_119_751 VDD VSS sg13g2_decap_8
XFILLER_115_6 VDD VSS sg13g2_fill_1
XFILLER_118_250 VDD VSS sg13g2_fill_1
XFILLER_146_570 VDD VSS sg13g2_decap_8
XFILLER_180_315 VDD VSS sg13g2_decap_8
X_08178_ _08178_/Y _08060_/X _08029_/Y _08340_/A _08177_/X VDD VSS sg13g2_a22oi_1
XFILLER_88_1453 VDD VSS sg13g2_decap_8
XFILLER_101_1355 VDD VSS sg13g2_decap_8
XFILLER_175_1412 VDD VSS sg13g2_decap_8
XFILLER_4_539 VDD VSS sg13g2_decap_8
XFILLER_49_1415 VDD VSS sg13g2_decap_8
XFILLER_106_445 VDD VSS sg13g2_fill_1
X_15115__2752 _15115_/RESET_B VDD VSS sg13g2_tiehi
XFILLER_161_551 VDD VSS sg13g2_fill_1
XFILLER_137_89 VDD VSS sg13g2_decap_4
X_10140_ _14717_/D _14717_/Q _10140_/A1 _10167_/S VDD VSS sg13g2_mux2_1
XFILLER_161_573 VDD VSS sg13g2_fill_1
X_14150__2052 _14150_/RESET_B VDD VSS sg13g2_tiehi
X_15166__2532 _15166_/RESET_B VDD VSS sg13g2_tiehi
XFILLER_121_437 VDD VSS sg13g2_decap_8
XFILLER_133_297 VDD VSS sg13g2_decap_8
XFILLER_153_11 VDD VSS sg13g2_decap_8
XFILLER_121_448 VDD VSS sg13g2_fill_1
X_10071_ _14651_/D _10071_/A0 _14651_/Q _10102_/S VDD VSS sg13g2_mux2_1
XFILLER_47_1172 VDD VSS sg13g2_decap_8
XFILLER_0_778 VDD VSS sg13g2_decap_8
XFILLER_130_1017 VDD VSS sg13g2_decap_8
XFILLER_60_1350 VDD VSS sg13g2_decap_8
XFILLER_21_1323 VDD VSS sg13g2_decap_8
X_13830_ _13830_/Q clkload51/A _13830_/D _13830_/RESET_B VDD VSS sg13g2_dfrbpq_1
XFILLER_29_952 VDD VSS sg13g2_decap_8
XFILLER_169_1238 VDD VSS sg13g2_decap_8
XFILLER_90_505 VDD VSS sg13g2_decap_8
XFILLER_1_1428 VDD VSS sg13g2_decap_8
X_13761_ _13761_/Q clkload10/A _13761_/D _13761_/RESET_B VDD VSS sg13g2_dfrbpq_1
Xclkbuf_5_26__f_clk_i clkbuf_leaf_60_clk_i/A clkbuf_4_13_0_clk_i/X VDD VSS sg13g2_buf_16
X_10973_ _10973_/Y _10973_/A _10973_/B VDD VSS sg13g2_nand2_1
XFILLER_15_112 VDD VSS sg13g2_decap_8
XFILLER_95_1457 VDD VSS sg13g2_decap_8
X_12712_ _12712_/X _14581_/Q _14613_/Q _14645_/Q _14677_/Q _12716_/S0 _12716_/S1 VDD
+ VSS sg13g2_mux4_1
XFILLER_55_292 VDD VSS sg13g2_decap_8
XFILLER_44_977 VDD VSS sg13g2_decap_4
X_13692_ _13692_/Q _15214_/CLK _13692_/D _13692_/RESET_B VDD VSS sg13g2_dfrbpq_1
XFILLER_71_796 VDD VSS sg13g2_decap_8
XFILLER_70_262 VDD VSS sg13g2_decap_8
X_12643_ _12643_/X _14256_/Q _14288_/Q _14320_/Q _14352_/Q _12643_/S0 _12643_/S1 VDD
+ VSS sg13g2_mux4_1
XFILLER_12_830 VDD VSS sg13g2_decap_8
XFILLER_180_1140 VDD VSS sg13g2_decap_8
XFILLER_54_1143 VDD VSS sg13g2_decap_8
XFILLER_175_109 VDD VSS sg13g2_decap_8
XFILLER_11_340 VDD VSS sg13g2_decap_8
XFILLER_178_63 VDD VSS sg13g2_decap_8
X_12574_ _12574_/X _13963_/Q _13995_/Q _14027_/Q _14059_/Q _12576_/S0 _12576_/S1 VDD
+ VSS sg13g2_mux4_1
XFILLER_129_526 VDD VSS sg13g2_decap_8
XFILLER_19_1296 VDD VSS sg13g2_decap_8
XFILLER_8_823 VDD VSS sg13g2_decap_8
XFILLER_15_1138 VDD VSS sg13g2_decap_8
XFILLER_7_14 VDD VSS sg13g2_decap_8
X_14313_ _14313_/Q clkload28/A _14313_/D _14313_/RESET_B VDD VSS sg13g2_dfrbpq_1
XFILLER_106_1277 VDD VSS sg13g2_fill_1
X_11525_ _11638_/A _11526_/A _12942_/B VDD VSS sg13g2_nor2_1
XFILLER_7_322 VDD VSS sg13g2_decap_8
XFILLER_184_654 VDD VSS sg13g2_decap_8
X_14360__1842 _14360_/RESET_B VDD VSS sg13g2_tiehi
XFILLER_89_1228 VDD VSS sg13g2_decap_8
XFILLER_32_1463 VDD VSS sg13g2_decap_8
XFILLER_156_378 VDD VSS sg13g2_decap_8
X_14244_ _14244_/Q clkload49/A _14244_/D _14244_/RESET_B VDD VSS sg13g2_dfrbpq_1
X_11456_ _11458_/B _11457_/A _11457_/B _11457_/C VDD VSS sg13g2_a21oi_1
XFILLER_171_326 VDD VSS sg13g2_decap_8
XFILLER_183_186 VDD VSS sg13g2_decap_8
XFILLER_7_399 VDD VSS sg13g2_decap_8
XFILLER_125_743 VDD VSS sg13g2_decap_8
X_10407_ _10407_/Y _14823_/Q _14824_/Q _14825_/Q _10413_/B VDD VSS sg13g2_nand4_1
X_14175_ _14175_/Q _14655_/CLK _14175_/D _14175_/RESET_B VDD VSS sg13g2_dfrbpq_1
X_11387_ _14960_/D _11384_/A _11432_/A2 _11386_/Y VDD VSS sg13g2_a21o_1
XFILLER_124_242 VDD VSS sg13g2_fill_2
XFILLER_3_550 VDD VSS sg13g2_decap_8
X_13126_ _13127_/B _13154_/A1 _13125_/X _13120_/X _13160_/B _13124_/Y VDD VSS sg13g2_a221oi_1
XFILLER_98_627 VDD VSS sg13g2_decap_4
X_10338_ _10345_/D _14803_/Q _14804_/Q _14805_/Q _14806_/Q VDD VSS sg13g2_and4_1
XFILLER_124_286 VDD VSS sg13g2_decap_8
XFILLER_140_735 VDD VSS sg13g2_decap_8
XFILLER_79_830 VDD VSS sg13g2_decap_8
X_13057_ _13058_/B _13057_/A _13057_/B _13057_/C VDD VSS sg13g2_and3_1
XFILLER_117_1351 VDD VSS sg13g2_fill_1
X_10269_ _14784_/D _10269_/A _10299_/B _10365_/C VDD VSS sg13g2_and3_1
XFILLER_6_1306 VDD VSS sg13g2_decap_8
XFILLER_78_351 VDD VSS sg13g2_fill_1
XFILLER_152_1253 VDD VSS sg13g2_decap_8
Xfanout1340 _11678_/S0 _11686_/S0 VDD VSS sg13g2_buf_1
XFILLER_26_1256 VDD VSS sg13g2_decap_8
X_12008_ _12008_/Y _12009_/A _13670_/Q VDD VSS sg13g2_nor2_1
XFILLER_79_896 VDD VSS sg13g2_decap_4
Xfanout1351 fanout1351/X _11899_/S0 VDD VSS sg13g2_buf_1
XFILLER_78_373 VDD VSS sg13g2_decap_8
Xfanout1362 _11365_/A _11368_/S0 VDD VSS sg13g2_buf_1
XFILLER_93_310 VDD VSS sg13g2_fill_2
XFILLER_113_1237 VDD VSS sg13g2_decap_4
Xfanout1373 _12025_/A _12139_/S0 VDD VSS sg13g2_buf_1
XFILLER_61_1169 VDD VSS sg13g2_decap_8
XFILLER_16_4 VDD VSS sg13g2_decap_8
Xfanout1384 _12168_/A _12189_/S0 VDD VSS sg13g2_buf_1
Xfanout1395 _13127_/A _13141_/A VDD VSS sg13g2_buf_1
XFILLER_54_708 VDD VSS sg13g2_fill_1
XFILLER_54_719 VDD VSS sg13g2_decap_8
X_14013__2189 _14013_/RESET_B VDD VSS sg13g2_tiehi
XFILLER_93_376 VDD VSS sg13g2_fill_2
XFILLER_35_911 VDD VSS sg13g2_decap_8
XFILLER_53_218 VDD VSS sg13g2_fill_2
X_13959_ _13959_/Q clkload13/A _13959_/D _13959_/RESET_B VDD VSS sg13g2_dfrbpq_1
XFILLER_4_1085 VDD VSS sg13g2_decap_8
XFILLER_98_1081 VDD VSS sg13g2_decap_8
XFILLER_81_549 VDD VSS sg13g2_decap_4
XFILLER_59_1032 VDD VSS sg13g2_decap_4
XFILLER_185_1040 VDD VSS sg13g2_decap_8
XFILLER_59_1054 VDD VSS sg13g2_decap_8
XFILLER_61_273 VDD VSS sg13g2_decap_4
XFILLER_22_649 VDD VSS sg13g2_decap_8
XFILLER_21_137 VDD VSS sg13g2_decap_8
X_09150_ _09156_/B _14923_/Q _09150_/B _09150_/C _09157_/D VDD VSS sg13g2_nand4_1
XFILLER_33_1205 VDD VSS sg13g2_decap_8
XFILLER_124_1333 VDD VSS sg13g2_decap_4
XFILLER_72_1265 VDD VSS sg13g2_decap_8
XFILLER_37_1385 VDD VSS sg13g2_decap_8
XFILLER_124_1344 VDD VSS sg13g2_decap_8
X_08101_ _08101_/Y _08063_/A _07630_/A _08137_/S1 VDD VSS sg13g2_a21oi_1
X_09081_ _09087_/B _14913_/Q _13088_/A _09103_/C VDD VSS sg13g2_nand3_1
XFILLER_30_693 VDD VSS sg13g2_decap_8
X_08032_ _08032_/Y _08201_/A _08201_/B _08032_/C _08032_/D VDD VSS sg13g2_nor4_1
XFILLER_128_581 VDD VSS sg13g2_fill_2
XFILLER_116_732 VDD VSS sg13g2_fill_2
XFILLER_116_743 VDD VSS sg13g2_fill_2
XFILLER_157_1120 VDD VSS sg13g2_decap_8
XFILLER_89_605 VDD VSS sg13g2_decap_8
XFILLER_116_776 VDD VSS sg13g2_decap_8
XFILLER_171_871 VDD VSS sg13g2_fill_1
XFILLER_115_275 VDD VSS sg13g2_decap_8
XFILLER_130_201 VDD VSS sg13g2_decap_8
X_09983_ _14566_/D _10082_/A0 _14566_/Q _09997_/S VDD VSS sg13g2_mux2_1
XFILLER_88_115 VDD VSS sg13g2_decap_8
XFILLER_66_1069 VDD VSS sg13g2_decap_8
XFILLER_157_1197 VDD VSS sg13g2_decap_8
XFILLER_83_1361 VDD VSS sg13g2_decap_8
XFILLER_44_1312 VDD VSS sg13g2_decap_8
XFILLER_118_1159 VDD VSS sg13g2_decap_8
X_14223__1979 _14223_/RESET_B VDD VSS sg13g2_tiehi
X_08934_ _08934_/X _08933_/X _08934_/A1 _08955_/S VDD VSS sg13g2_mux2_1
XFILLER_130_245 VDD VSS sg13g2_decap_8
XFILLER_135_1440 VDD VSS sg13g2_decap_8
XFILLER_85_800 VDD VSS sg13g2_decap_8
XFILLER_130_267 VDD VSS sg13g2_decap_8
XFILLER_29_204 VDD VSS sg13g2_fill_1
XFILLER_131_1326 VDD VSS sg13g2_decap_4
X_08865_ _08865_/Y _08873_/A _14934_/Q VDD VSS sg13g2_nor2b_1
XFILLER_69_384 VDD VSS sg13g2_decap_8
XFILLER_170_1375 VDD VSS sg13g2_decap_8
XFILLER_85_844 VDD VSS sg13g2_decap_8
XFILLER_29_226 VDD VSS sg13g2_decap_8
XFILLER_44_1389 VDD VSS sg13g2_decap_8
XFILLER_184_9 VDD VSS sg13g2_decap_8
XFILLER_57_546 VDD VSS sg13g2_decap_8
XFILLER_123_47 VDD VSS sg13g2_decap_8
X_07816_ _07816_/X _15010_/Q _07818_/B VDD VSS sg13g2_and2_1
X_08796_ _13683_/D _08796_/A _08796_/B VDD VSS sg13g2_nor2_1
XFILLER_85_888 VDD VSS sg13g2_decap_8
XFILLER_83_18 VDD VSS sg13g2_decap_8
X_13788__2414 _13788_/RESET_B VDD VSS sg13g2_tiehi
X_15144__2692 _15144_/RESET_B VDD VSS sg13g2_tiehi
X_07747_ _13320_/C _13499_/C _13303_/A VDD VSS sg13g2_nand2_1
X_15169__2514 _15169_/RESET_B VDD VSS sg13g2_tiehi
XFILLER_53_730 VDD VSS sg13g2_decap_8
XFILLER_25_421 VDD VSS sg13g2_decap_8
XFILLER_0_1450 VDD VSS sg13g2_decap_8
XFILLER_26_977 VDD VSS sg13g2_fill_1
X_07678_ _07679_/D _13293_/A _13600_/C _13289_/C VDD VSS sg13g2_nand3b_1
XFILLER_26_988 VDD VSS sg13g2_decap_8
XFILLER_168_1293 VDD VSS sg13g2_decap_8
XFILLER_16_67 VDD VSS sg13g2_decap_8
XFILLER_77_1187 VDD VSS sg13g2_decap_8
XFILLER_40_402 VDD VSS sg13g2_decap_8
X_09417_ _14019_/D _09914_/A1 _14019_/Q _09430_/S VDD VSS sg13g2_mux2_1
XFILLER_41_947 VDD VSS sg13g2_fill_1
XFILLER_164_1168 VDD VSS sg13g2_decap_8
XFILLER_12_126 VDD VSS sg13g2_decap_8
XFILLER_90_1332 VDD VSS sg13g2_fill_1
XFILLER_52_295 VDD VSS sg13g2_fill_1
XFILLER_129_1299 VDD VSS sg13g2_fill_2
X_14168__2034 _14168_/RESET_B VDD VSS sg13g2_tiehi
XFILLER_9_609 VDD VSS sg13g2_decap_8
XFILLER_16_1414 VDD VSS sg13g2_decap_8
X_09348_ _13952_/D _10010_/A0 _13952_/Q _09364_/S VDD VSS sg13g2_mux2_1
XFILLER_51_1305 VDD VSS sg13g2_decap_8
XFILLER_179_993 VDD VSS sg13g2_decap_4
X_13683__2529 _13683_/RESET_B VDD VSS sg13g2_tiehi
XFILLER_90_1365 VDD VSS sg13g2_decap_8
XFILLER_139_857 VDD VSS sg13g2_fill_1
XFILLER_142_1477 VDD VSS sg13g2_fill_2
X_09279_ _13887_/D _13887_/Q _09745_/A1 _09292_/S VDD VSS sg13g2_mux2_1
XFILLER_32_77 VDD VSS sg13g2_decap_8
XFILLER_138_367 VDD VSS sg13g2_fill_2
XFILLER_181_602 VDD VSS sg13g2_decap_8
X_11310_ _11310_/Y _11310_/A1 _14525_/Q _12257_/B1 VDD VSS sg13g2_a21oi_1
XFILLER_148_77 VDD VSS sg13g2_fill_1
X_12290_ _12291_/B _12281_/X _12282_/X _12285_/X _12286_/X _12290_/S0 _12263_/C VDD
+ VSS sg13g2_mux4_1
XFILLER_5_826 VDD VSS sg13g2_decap_8
XFILLER_180_112 VDD VSS sg13g2_decap_8
XFILLER_148_99 VDD VSS sg13g2_decap_8
XFILLER_107_743 VDD VSS sg13g2_fill_2
XFILLER_49_1212 VDD VSS sg13g2_decap_8
XFILLER_101_1163 VDD VSS sg13g2_decap_8
X_11241_ _11245_/A _11241_/A _13289_/C _11241_/C VDD VSS sg13g2_nand3_1
XFILLER_4_336 VDD VSS sg13g2_decap_8
XFILLER_10_1057 VDD VSS sg13g2_decap_8
XFILLER_181_679 VDD VSS sg13g2_fill_2
XFILLER_84_1114 VDD VSS sg13g2_decap_8
XFILLER_164_21 VDD VSS sg13g2_decap_8
XFILLER_121_201 VDD VSS sg13g2_fill_1
XFILLER_134_584 VDD VSS sg13g2_decap_8
XFILLER_180_189 VDD VSS sg13g2_decap_8
X_11172_ _11197_/A _11172_/A _11181_/A VDD VSS sg13g2_xnor2_1
XFILLER_171_1117 VDD VSS sg13g2_decap_4
XFILLER_175_1286 VDD VSS sg13g2_decap_8
XFILLER_49_1289 VDD VSS sg13g2_decap_8
XFILLER_121_223 VDD VSS sg13g2_decap_8
X_10123_ _14701_/D _10156_/A1 _14701_/Q _10123_/S VDD VSS sg13g2_mux2_1
XFILLER_164_98 VDD VSS sg13g2_decap_8
XFILLER_0_553 VDD VSS sg13g2_decap_8
XFILLER_121_267 VDD VSS sg13g2_fill_1
X_14931_ _14931_/Q clkload60/A _14931_/D _14931_/RESET_B VDD VSS sg13g2_dfrbpq_1
X_14975__2635 _14975_/RESET_B VDD VSS sg13g2_tiehi
X_10054_ _14635_/D _10087_/A0 _14635_/Q _10063_/S VDD VSS sg13g2_mux2_1
XFILLER_88_682 VDD VSS sg13g2_fill_1
XFILLER_62_1467 VDD VSS sg13g2_decap_8
XFILLER_180_42 VDD VSS sg13g2_decap_8
XFILLER_75_343 VDD VSS sg13g2_decap_8
X_14862_ _14862_/Q clkload90/A _14862_/D _14862_/RESET_B VDD VSS sg13g2_dfrbpq_1
XFILLER_21_1120 VDD VSS sg13g2_decap_8
XFILLER_63_505 VDD VSS sg13g2_decap_8
XFILLER_90_302 VDD VSS sg13g2_fill_2
XFILLER_63_516 VDD VSS sg13g2_decap_8
XFILLER_5_1372 VDD VSS sg13g2_decap_8
XFILLER_17_922 VDD VSS sg13g2_decap_8
X_13813_ _13813_/Q clkload37/A _13813_/D _13813_/RESET_B VDD VSS sg13g2_dfrbpq_1
XFILLER_112_1270 VDD VSS sg13g2_decap_8
XFILLER_1_1225 VDD VSS sg13g2_decap_8
X_14378__1824 _14378_/RESET_B VDD VSS sg13g2_tiehi
XFILLER_169_1068 VDD VSS sg13g2_decap_8
X_14793_ _14793_/Q clkload89/A _14793_/D _14793_/RESET_B VDD VSS sg13g2_dfrbpq_1
XFILLER_21_1197 VDD VSS sg13g2_decap_8
XFILLER_147_1322 VDD VSS sg13g2_decap_8
XFILLER_186_1371 VDD VSS sg13g2_decap_8
X_13744_ _13744_/Q clkload14/A _13744_/D _13744_/RESET_B VDD VSS sg13g2_dfrbpq_1
X_10956_ _10956_/Y _10956_/A _10956_/B _10969_/B VDD VSS sg13g2_nand3_1
XFILLER_91_1107 VDD VSS sg13g2_fill_1
XFILLER_56_1227 VDD VSS sg13g2_decap_8
XFILLER_32_914 VDD VSS sg13g2_decap_8
XFILLER_31_402 VDD VSS sg13g2_fill_1
XFILLER_182_1257 VDD VSS sg13g2_decap_8
X_13675_ _13675_/Q _15188_/CLK _13675_/D _13675_/RESET_B VDD VSS sg13g2_dfrbpq_1
XFILLER_71_593 VDD VSS sg13g2_decap_8
XFILLER_108_1339 VDD VSS sg13g2_decap_8
X_10887_ _14933_/D _10886_/X _10885_/Y _10875_/Y VDD VSS sg13g2_o21ai_1
XFILLER_31_446 VDD VSS sg13g2_fill_1
XFILLER_31_457 VDD VSS sg13g2_decap_8
X_12626_ _12626_/X _14127_/Q _14159_/Q _14191_/Q _14223_/Q _12686_/S0 _12686_/S1 VDD
+ VSS sg13g2_mux4_1
XFILLER_185_930 VDD VSS sg13g2_decap_8
XFILLER_85_7 VDD VSS sg13g2_decap_8
XFILLER_19_1093 VDD VSS sg13g2_decap_8
XFILLER_8_620 VDD VSS sg13g2_decap_8
XFILLER_12_682 VDD VSS sg13g2_decap_8
XFILLER_156_120 VDD VSS sg13g2_fill_1
XFILLER_157_643 VDD VSS sg13g2_decap_8
X_12557_ _12557_/X _13834_/Q _13866_/Q _13898_/Q _13930_/Q _12643_/S0 _12643_/S1 VDD
+ VSS sg13g2_mux4_1
XFILLER_185_985 VDD VSS sg13g2_decap_8
X_11508_ _11508_/X _14691_/Q _14723_/Q _13763_/Q _13795_/Q _11514_/S0 _11514_/S1 VDD
+ VSS sg13g2_mux4_1
XFILLER_32_1260 VDD VSS sg13g2_decap_8
XFILLER_145_849 VDD VSS sg13g2_decap_8
X_12488_ _12488_/X _14693_/Q _14725_/Q _13765_/Q _13797_/Q _12494_/S0 _12494_/S1 VDD
+ VSS sg13g2_mux4_1
XFILLER_8_697 VDD VSS sg13g2_decap_8
XFILLER_171_112 VDD VSS sg13g2_decap_8
X_14227_ _14227_/Q clkload37/A _14227_/D _14227_/RESET_B VDD VSS sg13g2_dfrbpq_1
XFILLER_7_196 VDD VSS sg13g2_decap_8
XFILLER_160_808 VDD VSS sg13g2_decap_8
X_11439_ _11445_/A _12092_/C _11439_/B VDD VSS sg13g2_or2_1
XFILLER_99_903 VDD VSS sg13g2_decap_8
XFILLER_125_562 VDD VSS sg13g2_fill_1
X_13866__2336 _13866_/RESET_B VDD VSS sg13g2_tiehi
XFILLER_158_1473 VDD VSS sg13g2_decap_4
X_14158_ _14158_/Q clkload58/A _14158_/D _14158_/RESET_B VDD VSS sg13g2_dfrbpq_1
XFILLER_99_947 VDD VSS sg13g2_decap_8
XFILLER_98_70 VDD VSS sg13g2_decap_8
XFILLER_67_1367 VDD VSS sg13g2_decap_8
XFILLER_28_1329 VDD VSS sg13g2_decap_8
X_13109_ _13109_/Y _13106_/Y _13107_/Y _13108_/Y VDD VSS sg13g2_a21oi_1
XFILLER_154_1359 VDD VSS sg13g2_decap_8
X_14089_ _14089_/Q _14665_/CLK _14089_/D _14089_/RESET_B VDD VSS sg13g2_dfrbpq_1
XFILLER_100_407 VDD VSS sg13g2_decap_8
XFILLER_6_1103 VDD VSS sg13g2_decap_8
X_14770__2966 _14770_/RESET_B VDD VSS sg13g2_tiehi
XFILLER_26_1042 VDD VSS sg13g2_fill_1
XFILLER_152_1050 VDD VSS sg13g2_decap_8
XFILLER_113_1012 VDD VSS sg13g2_fill_1
XFILLER_67_833 VDD VSS sg13g2_decap_8
XFILLER_121_790 VDD VSS sg13g2_decap_8
Xfanout1170 _11502_/A _14965_/Q VDD VSS sg13g2_buf_1
Xfanout1181 _08102_/A3 _11428_/A VDD VSS sg13g2_buf_1
X_08650_ _08650_/X _08650_/A _08650_/B VDD VSS sg13g2_xor2_1
Xfanout1192 _13017_/A2 _11290_/A VDD VSS sg13g2_buf_1
XFILLER_94_663 VDD VSS sg13g2_fill_2
XFILLER_113_1078 VDD VSS sg13g2_decap_8
XFILLER_93_173 VDD VSS sg13g2_fill_2
XFILLER_148_1108 VDD VSS sg13g2_decap_8
X_08581_ _15242_/D _08581_/A _08581_/B _08581_/C _08581_/D VDD VSS sg13g2_nand4_1
XFILLER_19_292 VDD VSS sg13g2_decap_8
XFILLER_179_212 VDD VSS sg13g2_decap_8
XFILLER_126_1406 VDD VSS sg13g2_decap_8
XFILLER_165_1455 VDD VSS sg13g2_decap_8
XFILLER_74_1338 VDD VSS sg13g2_decap_8
XFILLER_39_1469 VDD VSS sg13g2_decap_8
XFILLER_22_435 VDD VSS sg13g2_decap_8
X_15086__2844 _15086_/RESET_B VDD VSS sg13g2_tiehi
X_09202_ _13818_/D _13818_/Q _10169_/A1 _09202_/S VDD VSS sg13g2_mux2_1
XFILLER_37_1182 VDD VSS sg13g2_decap_8
X_09133_ _09137_/B _13199_/A _09157_/C _14921_/Q VDD VSS sg13g2_a21oi_1
XFILLER_148_665 VDD VSS sg13g2_decap_8
XFILLER_108_507 VDD VSS sg13g2_decap_8
XFILLER_176_985 VDD VSS sg13g2_decap_4
XFILLER_147_164 VDD VSS sg13g2_fill_2
X_09064_ _13771_/D _13771_/Q _10087_/A0 _09127_/S VDD VSS sg13g2_mux2_1
XFILLER_162_123 VDD VSS sg13g2_decap_8
XFILLER_135_348 VDD VSS sg13g2_fill_1
XFILLER_159_1248 VDD VSS sg13g2_decap_8
X_08015_ _08015_/Y _08599_/B _08013_/X _08014_/Y VDD VSS sg13g2_o21ai_1
XFILLER_50_1393 VDD VSS sg13g2_decap_8
XFILLER_11_1366 VDD VSS sg13g2_decap_8
XFILLER_104_702 VDD VSS sg13g2_fill_2
XFILLER_116_573 VDD VSS sg13g2_decap_8
X_14456__1746 _14456_/RESET_B VDD VSS sg13g2_tiehi
XFILLER_89_413 VDD VSS sg13g2_decap_8
XFILLER_46_1407 VDD VSS sg13g2_decap_8
XFILLER_85_1467 VDD VSS sg13g2_decap_8
XFILLER_85_1478 VDD VSS sg13g2_fill_1
XFILLER_104_768 VDD VSS sg13g2_decap_8
XFILLER_172_1459 VDD VSS sg13g2_decap_8
X_09966_ _14550_/D _14550_/Q _09966_/A1 _09970_/S VDD VSS sg13g2_mux2_1
XFILLER_131_565 VDD VSS sg13g2_decap_8
XFILLER_89_479 VDD VSS sg13g2_fill_2
XFILLER_76_107 VDD VSS sg13g2_fill_1
X_08917_ _13711_/D _08935_/S _08915_/Y _08916_/Y VDD VSS sg13g2_a21oi_1
XFILLER_135_1270 VDD VSS sg13g2_decap_8
XFILLER_131_1112 VDD VSS sg13g2_fill_1
X_09897_ _14483_/D _09930_/A1 _14483_/Q _09903_/S VDD VSS sg13g2_mux2_1
XFILLER_170_1172 VDD VSS sg13g2_decap_8
XFILLER_94_39 VDD VSS sg13g2_decap_8
XFILLER_44_1186 VDD VSS sg13g2_decap_8
XFILLER_85_652 VDD VSS sg13g2_decap_8
X_14671__1531 _14671_/RESET_B VDD VSS sg13g2_tiehi
X_08848_ _08848_/Y _08852_/A _14929_/Q VDD VSS sg13g2_nor2b_1
XFILLER_22_1440 VDD VSS sg13g2_decap_8
XFILLER_72_313 VDD VSS sg13g2_decap_8
XFILLER_57_387 VDD VSS sg13g2_decap_8
XFILLER_45_538 VDD VSS sg13g2_decap_8
X_08779_ _08779_/Y _10885_/A1 _15115_/Q _15184_/Q _07719_/X VDD VSS sg13g2_a22oi_1
XFILLER_73_858 VDD VSS sg13g2_decap_8
XFILLER_150_45 VDD VSS sg13g2_decap_8
X_10810_ _10810_/Y _10809_/Y _10807_/Y _10801_/Y VDD VSS sg13g2_a21oi_1
XFILLER_72_357 VDD VSS sg13g2_fill_1
XFILLER_26_763 VDD VSS sg13g2_decap_8
X_11790_ _11790_/X _11783_/X _11784_/X _11787_/X _11788_/X _12108_/B _12118_/C VDD
+ VSS sg13g2_mux4_1
XFILLER_129_1030 VDD VSS sg13g2_fill_1
XFILLER_92_1416 VDD VSS sg13g2_decap_8
XFILLER_41_700 VDD VSS sg13g2_decap_8
XFILLER_14_925 VDD VSS sg13g2_decap_8
XFILLER_13_424 VDD VSS sg13g2_decap_8
X_10741_ _10741_/Y _14913_/Q _11001_/B VDD VSS sg13g2_nand2_1
XFILLER_129_1063 VDD VSS sg13g2_decap_8
XFILLER_43_32 VDD VSS sg13g2_decap_8
XFILLER_25_284 VDD VSS sg13g2_decap_8
XFILLER_80_390 VDD VSS sg13g2_decap_8
XFILLER_41_744 VDD VSS sg13g2_fill_2
X_13944__2258 _13944_/RESET_B VDD VSS sg13g2_tiehi
XFILLER_159_21 VDD VSS sg13g2_decap_8
XFILLER_9_406 VDD VSS sg13g2_decap_8
XFILLER_13_468 VDD VSS sg13g2_decap_8
XFILLER_16_1211 VDD VSS sg13g2_decap_8
X_13460_ _15106_/D _13456_/X _13459_/Y _13458_/Y VDD VSS sg13g2_o21ai_1
XFILLER_186_749 VDD VSS sg13g2_decap_8
X_10672_ _10673_/A _11056_/B1 _10807_/B _10800_/B _14895_/Q VDD VSS sg13g2_a22oi_1
XFILLER_13_479 VDD VSS sg13g2_fill_1
XFILLER_179_790 VDD VSS sg13g2_decap_8
XFILLER_40_265 VDD VSS sg13g2_decap_8
XFILLER_107_1361 VDD VSS sg13g2_decap_8
XFILLER_142_1241 VDD VSS sg13g2_fill_2
X_12411_ _12411_/X _14687_/Q _14719_/Q _13759_/Q _13791_/Q _12411_/S0 _12411_/S1 VDD
+ VSS sg13g2_mux4_1
XFILLER_55_1293 VDD VSS sg13g2_decap_8
XFILLER_139_654 VDD VSS sg13g2_fill_2
XFILLER_185_259 VDD VSS sg13g2_decap_8
X_13391_ _13391_/Y _13391_/A _13494_/B _13391_/C VDD VSS sg13g2_nor3_1
XFILLER_159_98 VDD VSS sg13g2_decap_8
XFILLER_166_451 VDD VSS sg13g2_decap_8
XFILLER_127_816 VDD VSS sg13g2_fill_1
XFILLER_154_602 VDD VSS sg13g2_decap_4
XFILLER_139_687 VDD VSS sg13g2_decap_8
XFILLER_16_1288 VDD VSS sg13g2_decap_8
XFILLER_182_922 VDD VSS sg13g2_decap_8
X_15130_ _15130_/Q _15188_/CLK _15130_/D _15130_/RESET_B VDD VSS sg13g2_dfrbpq_1
XFILLER_142_1296 VDD VSS sg13g2_decap_4
X_12342_ _12342_/X _13947_/Q _13979_/Q _14011_/Q _14043_/Q _12787_/S0 _12787_/S1 VDD
+ VSS sg13g2_mux4_1
XFILLER_51_1179 VDD VSS sg13g2_decap_8
XFILLER_127_849 VDD VSS sg13g2_decap_8
XFILLER_154_624 VDD VSS sg13g2_decap_4
XFILLER_5_623 VDD VSS sg13g2_decap_8
XFILLER_153_123 VDD VSS sg13g2_decap_8
XFILLER_126_359 VDD VSS sg13g2_decap_8
XFILLER_154_668 VDD VSS sg13g2_decap_8
X_15061_ _15061_/Q _15203_/CLK _15061_/D _15061_/RESET_B VDD VSS sg13g2_dfrbpq_1
XFILLER_107_540 VDD VSS sg13g2_fill_2
XFILLER_175_53 VDD VSS sg13g2_decap_8
XFILLER_177_1359 VDD VSS sg13g2_decap_8
XFILLER_181_454 VDD VSS sg13g2_fill_1
X_12273_ _12273_/Y _12273_/A VDD VSS sg13g2_inv_1
XFILLER_4_133 VDD VSS sg13g2_decap_8
XFILLER_135_860 VDD VSS sg13g2_decap_8
XFILLER_141_307 VDD VSS sg13g2_fill_2
X_14012_ _14012_/Q clkload77/A _14012_/D _14012_/RESET_B VDD VSS sg13g2_dfrbpq_1
X_11224_ _11236_/D _12174_/A _11224_/B _11224_/C VDD VSS sg13g2_nor3_1
XFILLER_136_1012 VDD VSS sg13g2_decap_8
XFILLER_134_392 VDD VSS sg13g2_fill_1
XFILLER_1_840 VDD VSS sg13g2_decap_8
X_11155_ _14952_/D _11154_/Y _11153_/Y _11143_/Y VDD VSS sg13g2_o21ai_1
XFILLER_122_565 VDD VSS sg13g2_decap_4
XFILLER_0_350 VDD VSS sg13g2_decap_8
X_14878__2811 _14878_/RESET_B VDD VSS sg13g2_tiehi
X_10106_ _14684_/D _14684_/Q _10136_/S _10105_/X VDD VSS sg13g2_a21o_1
XFILLER_89_991 VDD VSS sg13g2_decap_8
XFILLER_67_118 VDD VSS sg13g2_decap_8
XFILLER_27_1362 VDD VSS sg13g2_decap_8
X_11086_ _11118_/C _11086_/A _11115_/A VDD VSS sg13g2_xnor2_1
XFILLER_95_449 VDD VSS sg13g2_decap_8
XFILLER_7_1456 VDD VSS sg13g2_decap_8
XFILLER_62_1264 VDD VSS sg13g2_decap_8
XFILLER_23_1248 VDD VSS sg13g2_decap_8
X_14914_ _14914_/Q clkload69/A _14914_/D _14914_/RESET_B VDD VSS sg13g2_dfrbpq_1
X_10037_ _10037_/Y _10037_/A _10037_/B _10070_/C VDD VSS sg13g2_nand3_1
X_14501__1701 _14501_/RESET_B VDD VSS sg13g2_tiehi
XFILLER_97_1316 VDD VSS sg13g2_decap_4
XFILLER_91_600 VDD VSS sg13g2_decap_8
XFILLER_48_365 VDD VSS sg13g2_decap_8
XFILLER_110_1218 VDD VSS sg13g2_decap_8
XFILLER_124_90 VDD VSS sg13g2_fill_1
XFILLER_76_685 VDD VSS sg13g2_fill_1
XFILLER_114_1398 VDD VSS sg13g2_decap_8
XFILLER_97_1349 VDD VSS sg13g2_decap_8
X_14845_ _14845_/Q _14848_/CLK _14845_/D _14845_/RESET_B VDD VSS sg13g2_dfrbpq_1
XFILLER_1_1022 VDD VSS sg13g2_decap_8
XFILLER_90_132 VDD VSS sg13g2_decap_4
X_14776_ _14776_/Q _15185_/CLK _14776_/D _14776_/RESET_B VDD VSS sg13g2_dfrbpq_1
X_11988_ _11988_/Y _11986_/A _11988_/B _11989_/A VDD VSS sg13g2_nand3b_1
XFILLER_91_699 VDD VSS sg13g2_fill_1
XFILLER_1_1099 VDD VSS sg13g2_decap_8
X_13727_ _13727_/Q clkload61/A _13727_/D _13727_/RESET_B VDD VSS sg13g2_dfrbpq_1
X_10939_ _10939_/Y _10969_/B _10936_/B _11056_/B1 VDD VSS sg13g2_o21ai_1
XFILLER_177_705 VDD VSS sg13g2_decap_8
XFILLER_108_1125 VDD VSS sg13g2_decap_8
XFILLER_149_429 VDD VSS sg13g2_decap_8
XFILLER_20_917 VDD VSS sg13g2_fill_1
X_14534__1668 _14534_/RESET_B VDD VSS sg13g2_tiehi
X_13658_ _13658_/Q clkload65/A _13658_/D _13658_/RESET_B VDD VSS sg13g2_dfrbpq_1
XFILLER_73_1360 VDD VSS sg13g2_decap_8
XFILLER_32_777 VDD VSS sg13g2_decap_8
Xclkbuf_leaf_61_clk_i _14682_/CLK clkbuf_leaf_64_clk_i/A VDD VSS sg13g2_buf_8
XFILLER_176_237 VDD VSS sg13g2_fill_1
XFILLER_83_4 VDD VSS sg13g2_decap_8
XFILLER_176_248 VDD VSS sg13g2_decap_8
XFILLER_13_991 VDD VSS sg13g2_decap_8
X_12609_ _12609_/X _12607_/X _12608_/X _12609_/S VDD VSS sg13g2_mux2_1
XFILLER_34_1355 VDD VSS sg13g2_decap_8
XFILLER_118_805 VDD VSS sg13g2_fill_2
XFILLER_158_974 VDD VSS sg13g2_decap_8
X_13589_ _13589_/Y _15003_/Q _13592_/A2 _13569_/S _15019_/Q _13541_/X VDD VSS sg13g2_a221oi_1
XFILLER_160_1374 VDD VSS sg13g2_decap_8
X_14788__2948 _14788_/RESET_B VDD VSS sg13g2_tiehi
XFILLER_9_973 VDD VSS sg13g2_decap_8
XFILLER_117_326 VDD VSS sg13g2_decap_8
XFILLER_121_1358 VDD VSS sg13g2_fill_1
XFILLER_172_432 VDD VSS sg13g2_fill_1
XFILLER_8_494 VDD VSS sg13g2_decap_8
XFILLER_173_988 VDD VSS sg13g2_decap_8
Xclkbuf_leaf_76_clk_i _15185_/CLK clkbuf_leaf_92_clk_i/A VDD VSS sg13g2_buf_8
XFILLER_144_178 VDD VSS sg13g2_fill_2
XFILLER_172_487 VDD VSS sg13g2_decap_8
XFILLER_132_329 VDD VSS sg13g2_decap_8
XFILLER_158_1270 VDD VSS sg13g2_decap_8
XFILLER_99_733 VDD VSS sg13g2_decap_4
XFILLER_98_210 VDD VSS sg13g2_decap_8
XFILLER_67_1164 VDD VSS sg13g2_decap_8
XFILLER_28_1126 VDD VSS sg13g2_decap_8
Xfanout407 _09127_/S _08965_/Y VDD VSS sg13g2_buf_1
X_09820_ _14408_/D _09919_/A1 _14408_/Q _09822_/S VDD VSS sg13g2_mux2_1
XFILLER_87_906 VDD VSS sg13g2_decap_8
Xfanout418 _12372_/A _12348_/Y VDD VSS sg13g2_buf_1
XFILLER_99_777 VDD VSS sg13g2_decap_8
XFILLER_98_243 VDD VSS sg13g2_decap_8
XFILLER_59_608 VDD VSS sg13g2_fill_2
XFILLER_119_1265 VDD VSS sg13g2_decap_4
XFILLER_140_351 VDD VSS sg13g2_decap_8
Xfanout429 _10024_/S fanout432/X VDD VSS sg13g2_buf_1
XFILLER_141_896 VDD VSS sg13g2_decap_4
XFILLER_150_1009 VDD VSS sg13g2_decap_8
X_09751_ _14341_/D _14341_/Q _09916_/A1 _09762_/S VDD VSS sg13g2_mux2_1
XFILLER_80_1342 VDD VSS sg13g2_decap_8
XFILLER_58_129 VDD VSS sg13g2_decap_8
XFILLER_140_395 VDD VSS sg13g2_decap_8
XFILLER_132_1432 VDD VSS sg13g2_decap_4
X_08702_ _15249_/D _08700_/Y _08701_/Y _08694_/Y VDD VSS sg13g2_o21ai_1
X_09682_ _14274_/D _10145_/A1 _14274_/Q _09696_/S VDD VSS sg13g2_mux2_1
XFILLER_41_1348 VDD VSS sg13g2_decap_8
XFILLER_39_354 VDD VSS sg13g2_decap_4
XFILLER_55_814 VDD VSS sg13g2_fill_2
XFILLER_104_49 VDD VSS sg13g2_decap_8
XFILLER_66_151 VDD VSS sg13g2_decap_8
X_08633_ _15245_/D _08633_/A _08633_/B _08633_/C VDD VSS sg13g2_nand3_1
Xclkbuf_leaf_14_clk_i clkload15/A clkbuf_leaf_4_clk_i/A VDD VSS sg13g2_buf_8
XFILLER_54_346 VDD VSS sg13g2_decap_8
XFILLER_82_666 VDD VSS sg13g2_fill_1
XFILLER_54_357 VDD VSS sg13g2_fill_1
X_08564_ _08581_/D _15013_/Q _07861_/B _08674_/B1 VDD VSS sg13g2_o21ai_1
XFILLER_54_368 VDD VSS sg13g2_decap_8
XFILLER_78_1282 VDD VSS sg13g2_decap_8
XFILLER_63_880 VDD VSS sg13g2_decap_8
XFILLER_35_571 VDD VSS sg13g2_decap_8
XFILLER_63_891 VDD VSS sg13g2_fill_1
XFILLER_165_1252 VDD VSS sg13g2_decap_8
X_08495_ _08495_/Y _08447_/B _08574_/C _08494_/Y VDD VSS sg13g2_a21oi_1
XFILLER_39_1266 VDD VSS sg13g2_decap_8
XFILLER_22_221 VDD VSS sg13g2_decap_8
XFILLER_126_1236 VDD VSS sg13g2_fill_2
XFILLER_23_766 VDD VSS sg13g2_fill_1
Xclkbuf_leaf_29_clk_i clkload40/A clkbuf_leaf_30_clk_i/A VDD VSS sg13g2_buf_8
XFILLER_149_930 VDD VSS sg13g2_decap_8
XFILLER_11_939 VDD VSS sg13g2_decap_8
XFILLER_161_1149 VDD VSS sg13g2_decap_8
XFILLER_23_799 VDD VSS sg13g2_decap_8
XFILLER_10_427 VDD VSS sg13g2_decap_8
XFILLER_148_440 VDD VSS sg13g2_fill_2
XFILLER_13_46 VDD VSS sg13g2_decap_8
XFILLER_182_207 VDD VSS sg13g2_decap_8
XFILLER_52_1466 VDD VSS sg13g2_decap_8
XFILLER_13_1439 VDD VSS sg13g2_decap_8
X_09116_ _09117_/C _13189_/A _13156_/A _13142_/A _09136_/B VDD VSS sg13g2_nand4_1
XFILLER_129_46 VDD VSS sg13g2_decap_8
XFILLER_136_624 VDD VSS sg13g2_decap_8
X_14689__1513 _14689_/RESET_B VDD VSS sg13g2_tiehi
X_09047_ _09047_/Y _15232_/Q _09060_/S VDD VSS sg13g2_nand2b_1
XFILLER_50_1190 VDD VSS sg13g2_decap_8
XFILLER_11_1163 VDD VSS sg13g2_decap_8
XFILLER_159_1056 VDD VSS sg13g2_decap_8
XFILLER_123_318 VDD VSS sg13g2_fill_1
XFILLER_151_638 VDD VSS sg13g2_fill_1
XFILLER_159_1089 VDD VSS sg13g2_fill_2
XFILLER_85_1253 VDD VSS sg13g2_decap_8
XFILLER_46_1204 VDD VSS sg13g2_decap_8
XFILLER_132_830 VDD VSS sg13g2_fill_2
XFILLER_89_221 VDD VSS sg13g2_fill_1
XFILLER_2_637 VDD VSS sg13g2_decap_8
XFILLER_116_392 VDD VSS sg13g2_decap_8
XFILLER_150_137 VDD VSS sg13g2_decap_8
X_15042__2564 _15042_/RESET_B VDD VSS sg13g2_tiehi
XFILLER_137_1365 VDD VSS sg13g2_decap_8
XFILLER_1_147 VDD VSS sg13g2_decap_8
XFILLER_145_78 VDD VSS sg13g2_fill_1
XFILLER_78_928 VDD VSS sg13g2_decap_8
XFILLER_172_1256 VDD VSS sg13g2_decap_8
XFILLER_78_939 VDD VSS sg13g2_fill_2
XFILLER_104_587 VDD VSS sg13g2_decap_8
Xfanout930 _13160_/B _13303_/A VDD VSS sg13g2_buf_1
Xfanout941 _13566_/B _13558_/B VDD VSS sg13g2_buf_1
XFILLER_131_384 VDD VSS sg13g2_decap_8
Xfanout952 _13558_/C _15202_/Q VDD VSS sg13g2_buf_1
X_09949_ _14533_/D _14533_/Q _10081_/A0 _09957_/S VDD VSS sg13g2_mux2_1
Xfanout963 _13481_/A _15127_/Q VDD VSS sg13g2_buf_1
XFILLER_38_32 VDD VSS sg13g2_decap_8
Xfanout974 _13273_/B _13150_/B VDD VSS sg13g2_buf_1
Xfanout985 _08391_/A _08190_/A VDD VSS sg13g2_buf_1
XFILLER_86_961 VDD VSS sg13g2_fill_1
X_12960_ _12960_/Y _12961_/A _12961_/C _12988_/C VDD VSS sg13g2_a21oi_1
Xfanout996 _13345_/B _13279_/B VDD VSS sg13g2_buf_1
XFILLER_92_419 VDD VSS sg13g2_decap_8
XFILLER_85_460 VDD VSS sg13g2_decap_8
XFILLER_79_1013 VDD VSS sg13g2_decap_8
XFILLER_18_527 VDD VSS sg13g2_decap_8
X_11911_ _11912_/B _12056_/A _12056_/B VDD VSS sg13g2_nand2_1
XFILLER_58_696 VDD VSS sg13g2_decap_8
XFILLER_57_173 VDD VSS sg13g2_decap_8
XFILLER_161_77 VDD VSS sg13g2_decap_8
X_12891_ _12925_/A _14900_/Q _13687_/Q VDD VSS sg13g2_nand2_1
XFILLER_46_869 VDD VSS sg13g2_decap_8
XFILLER_72_132 VDD VSS sg13g2_decap_8
X_14630_ _14630_/Q clkload52/A _14630_/D _14630_/RESET_B VDD VSS sg13g2_dfrbpq_1
XFILLER_166_1027 VDD VSS sg13g2_fill_2
X_11842_ _11867_/A _11843_/A _13675_/Q VDD VSS sg13g2_nand2_1
XFILLER_79_1079 VDD VSS sg13g2_decap_8
XFILLER_54_31 VDD VSS sg13g2_decap_8
XFILLER_96_1371 VDD VSS sg13g2_decap_8
XFILLER_2_1386 VDD VSS sg13g2_decap_8
XFILLER_183_1330 VDD VSS sg13g2_decap_8
XFILLER_148_1450 VDD VSS sg13g2_decap_8
XFILLER_14_722 VDD VSS sg13g2_decap_8
XFILLER_92_1224 VDD VSS sg13g2_decap_8
XFILLER_72_187 VDD VSS sg13g2_decap_4
XFILLER_159_0 VDD VSS sg13g2_decap_8
X_14561_ _14561_/Q clkload6/A _14561_/D _14561_/RESET_B VDD VSS sg13g2_dfrbpq_1
XFILLER_60_338 VDD VSS sg13g2_fill_2
X_11773_ _11776_/B _11773_/A _11773_/B _11773_/C _11773_/D VDD VSS sg13g2_nor4_1
XFILLER_13_221 VDD VSS sg13g2_decap_8
XFILLER_57_1366 VDD VSS sg13g2_decap_8
X_13512_ _15135_/D _15135_/Q _07629_/A _13512_/S VDD VSS sg13g2_mux2_1
X_10724_ _14908_/D _10724_/A VDD VSS sg13g2_inv_1
X_14492_ _14492_/Q clkload76/A _14492_/D _14492_/RESET_B VDD VSS sg13g2_dfrbpq_1
XFILLER_9_203 VDD VSS sg13g2_decap_8
XFILLER_186_546 VDD VSS sg13g2_decap_8
XFILLER_13_298 VDD VSS sg13g2_decap_8
X_13443_ _15103_/D _15103_/Q _13470_/A2 _13442_/Y VDD VSS sg13g2_a21o_1
X_10655_ _14890_/D _10663_/D _10655_/B _10655_/C VDD VSS sg13g2_nor3_1
XFILLER_16_1085 VDD VSS sg13g2_decap_8
XFILLER_103_1044 VDD VSS sg13g2_fill_2
X_13374_ _15077_/D _13361_/C _13444_/A _13372_/Y VDD VSS sg13g2_o21ai_1
Xclkload17 clkload17/Y clkload17/A VDD VSS sg13g2_inv_1
XFILLER_6_921 VDD VSS sg13g2_decap_8
XFILLER_139_495 VDD VSS sg13g2_decap_8
XFILLER_186_63 VDD VSS sg13g2_decap_8
Xclkload28 clkload28/Y clkload28/A VDD VSS sg13g2_inv_1
X_10586_ _10597_/D _12963_/A _14872_/Q _14871_/Q _10586_/D VDD VSS sg13g2_and4_1
XFILLER_10_994 VDD VSS sg13g2_decap_8
XFILLER_154_432 VDD VSS sg13g2_decap_8
X_15113_ _15113_/Q _15165_/CLK _15113_/D _15113_/RESET_B VDD VSS sg13g2_dfrbpq_1
Xclkload39 clkload39/Y clkload39/A VDD VSS sg13g2_inv_2
XFILLER_5_420 VDD VSS sg13g2_decap_8
XFILLER_103_1077 VDD VSS sg13g2_decap_8
X_12325_ _12325_/Y _12328_/A1 _13850_/Q VDD VSS sg13g2_nand2b_1
XFILLER_177_1156 VDD VSS sg13g2_decap_8
XFILLER_6_998 VDD VSS sg13g2_decap_8
XFILLER_68_1440 VDD VSS sg13g2_decap_8
XFILLER_181_273 VDD VSS sg13g2_decap_8
X_15044_ _15044_/Q _15240_/CLK _15044_/D _15044_/RESET_B VDD VSS sg13g2_dfrbpq_1
XFILLER_155_1410 VDD VSS sg13g2_decap_8
X_12256_ _12256_/Y _12186_/A _13912_/Q VDD VSS sg13g2_nand2b_1
XFILLER_5_497 VDD VSS sg13g2_decap_8
XFILLER_79_72 VDD VSS sg13g2_decap_8
XFILLER_48_7 VDD VSS sg13g2_decap_8
X_11207_ _11207_/Y _11205_/A _13419_/A2 _11207_/B1 VDD VSS sg13g2_a21oi_1
XFILLER_64_1337 VDD VSS sg13g2_decap_8
XFILLER_29_1457 VDD VSS sg13g2_decap_8
X_12187_ _12188_/B _12187_/A _12187_/B _12187_/C VDD VSS sg13g2_nand3_1
XFILLER_69_928 VDD VSS sg13g2_fill_2
XFILLER_68_405 VDD VSS sg13g2_fill_1
XFILLER_123_896 VDD VSS sg13g2_decap_8
XFILLER_151_1329 VDD VSS sg13g2_fill_2
X_11138_ _11138_/Y _11163_/A _11138_/B _11138_/C VDD VSS sg13g2_nand3b_1
XFILLER_110_546 VDD VSS sg13g2_decap_8
XFILLER_7_1253 VDD VSS sg13g2_decap_8
XFILLER_77_961 VDD VSS sg13g2_decap_8
XFILLER_114_1140 VDD VSS sg13g2_decap_8
X_11069_ _11069_/Y _11078_/B _11069_/B VDD VSS sg13g2_xnor2_1
XFILLER_23_1045 VDD VSS sg13g2_decap_8
XFILLER_3_1117 VDD VSS sg13g2_decap_8
XFILLER_114_1184 VDD VSS sg13g2_decap_8
XFILLER_36_335 VDD VSS sg13g2_decap_8
XFILLER_92_964 VDD VSS sg13g2_fill_1
XFILLER_36_346 VDD VSS sg13g2_fill_2
XFILLER_149_1236 VDD VSS sg13g2_decap_8
XFILLER_64_677 VDD VSS sg13g2_decap_8
X_14828_ _14828_/Q _14893_/CLK _14828_/D _14828_/RESET_B VDD VSS sg13g2_dfrbpq_1
XFILLER_92_997 VDD VSS sg13g2_decap_8
XFILLER_184_1149 VDD VSS sg13g2_decap_8
XFILLER_75_1433 VDD VSS sg13g2_decap_8
X_14759_ _14759_/Q _15188_/CLK _14759_/D _14759_/RESET_B VDD VSS sg13g2_dfrbpq_1
XFILLER_32_530 VDD VSS sg13g2_decap_8
XFILLER_36_1439 VDD VSS sg13g2_decap_8
XFILLER_20_703 VDD VSS sg13g2_fill_1
X_08280_ _08280_/X _08363_/S1 _08207_/X _08279_/X VDD VSS sg13g2_a21o_1
XFILLER_162_1458 VDD VSS sg13g2_decap_8
XFILLER_162_1469 VDD VSS sg13g2_fill_1
XFILLER_177_557 VDD VSS sg13g2_decap_4
XFILLER_20_747 VDD VSS sg13g2_decap_8
XFILLER_146_900 VDD VSS sg13g2_fill_2
XFILLER_34_1152 VDD VSS sg13g2_decap_8
XFILLER_158_771 VDD VSS sg13g2_decap_8
XFILLER_160_1171 VDD VSS sg13g2_decap_8
XFILLER_9_770 VDD VSS sg13g2_decap_8
XFILLER_121_1133 VDD VSS sg13g2_decap_8
XFILLER_118_635 VDD VSS sg13g2_decap_8
XFILLER_146_944 VDD VSS sg13g2_decap_8
XFILLER_146_955 VDD VSS sg13g2_decap_8
XFILLER_8_291 VDD VSS sg13g2_decap_8
XFILLER_173_763 VDD VSS sg13g2_fill_2
XFILLER_161_914 VDD VSS sg13g2_fill_1
X_14970__2640 _14970_/RESET_B VDD VSS sg13g2_tiehi
XFILLER_69_1248 VDD VSS sg13g2_decap_8
XFILLER_161_936 VDD VSS sg13g2_decap_8
XFILLER_160_413 VDD VSS sg13g2_decap_8
XFILLER_173_796 VDD VSS sg13g2_decap_8
XFILLER_117_189 VDD VSS sg13g2_fill_1
XFILLER_156_1229 VDD VSS sg13g2_fill_1
XFILLER_132_159 VDD VSS sg13g2_decap_8
XFILLER_160_468 VDD VSS sg13g2_fill_1
Xfanout204 _10057_/A0 _09925_/A1 VDD VSS sg13g2_buf_1
XFILLER_99_563 VDD VSS sg13g2_decap_8
XFILLER_5_91 VDD VSS sg13g2_decap_8
Xfanout215 _09989_/A0 _10088_/A0 VDD VSS sg13g2_buf_1
XFILLER_87_714 VDD VSS sg13g2_decap_8
XFILLER_114_885 VDD VSS sg13g2_decap_8
Xfanout226 _09622_/A0 _10086_/A0 VDD VSS sg13g2_buf_1
XFILLER_113_373 VDD VSS sg13g2_decap_8
Xfanout237 _11978_/B1 fanout242/X VDD VSS sg13g2_buf_1
X_09803_ _14392_/D _09935_/A1 _14392_/Q _09804_/S VDD VSS sg13g2_mux2_1
XFILLER_99_596 VDD VSS sg13g2_decap_8
XFILLER_59_438 VDD VSS sg13g2_fill_1
Xfanout248 _09620_/A0 fanout250/X VDD VSS sg13g2_buf_1
Xfanout259 _09917_/A1 _09752_/A1 VDD VSS sg13g2_buf_1
X_07995_ _08275_/B _15104_/Q _15091_/Q VDD VSS sg13g2_nor2_1
XFILLER_59_449 VDD VSS sg13g2_decap_8
XFILLER_45_1270 VDD VSS sg13g2_decap_8
XFILLER_101_568 VDD VSS sg13g2_decap_8
X_09734_ _14325_/D _09767_/A1 _14325_/Q _09738_/S VDD VSS sg13g2_mux2_1
XFILLER_80_1172 VDD VSS sg13g2_decap_8
XFILLER_101_579 VDD VSS sg13g2_fill_2
XFILLER_28_803 VDD VSS sg13g2_decap_8
XFILLER_74_419 VDD VSS sg13g2_decap_8
XFILLER_68_983 VDD VSS sg13g2_decap_8
XFILLER_41_1145 VDD VSS sg13g2_decap_8
XFILLER_95_780 VDD VSS sg13g2_decap_8
XFILLER_83_931 VDD VSS sg13g2_decap_4
XFILLER_132_1295 VDD VSS sg13g2_decap_8
X_09665_ _14258_/D _09929_/A1 _14258_/Q _09672_/S VDD VSS sg13g2_mux2_1
XFILLER_28_869 VDD VSS sg13g2_decap_8
XFILLER_167_1325 VDD VSS sg13g2_decap_8
X_08616_ _08616_/Y _08668_/A _08616_/B VDD VSS sg13g2_nand2b_1
XFILLER_76_1219 VDD VSS sg13g2_decap_8
XFILLER_54_143 VDD VSS sg13g2_decap_8
XFILLER_82_463 VDD VSS sg13g2_decap_8
X_09596_ _14193_/D _14193_/Q _09928_/A1 _09604_/S VDD VSS sg13g2_mux2_1
XFILLER_83_997 VDD VSS sg13g2_decap_8
XFILLER_91_18 VDD VSS sg13g2_decap_8
XFILLER_42_316 VDD VSS sg13g2_fill_1
X_14862__2843 _14862_/RESET_B VDD VSS sg13g2_tiehi
X_08547_ _08547_/Y _13566_/A _11983_/A _08497_/A VDD VSS sg13g2_a21oi_1
XFILLER_152_7 VDD VSS sg13g2_decap_8
XFILLER_35_390 VDD VSS sg13g2_decap_8
XFILLER_165_1060 VDD VSS sg13g2_decap_8
XFILLER_126_1033 VDD VSS sg13g2_decap_8
X_08478_ _08478_/Y _13555_/A _07949_/C _08447_/B VDD VSS sg13g2_o21ai_1
XFILLER_11_725 VDD VSS sg13g2_decap_8
X_14026__2176 _14026_/RESET_B VDD VSS sg13g2_tiehi
XFILLER_10_224 VDD VSS sg13g2_decap_8
XFILLER_17_1350 VDD VSS sg13g2_decap_8
X_13861__2341 _13861_/RESET_B VDD VSS sg13g2_tiehi
XFILLER_50_393 VDD VSS sg13g2_decap_8
XFILLER_7_707 VDD VSS sg13g2_decap_8
XFILLER_11_769 VDD VSS sg13g2_decap_8
XFILLER_52_1263 VDD VSS sg13g2_decap_8
X_14895__2777 _14895_/RESET_B VDD VSS sg13g2_tiehi
X_10440_ _10442_/B _14836_/Q _14835_/Q _10443_/D VDD VSS sg13g2_nand3_1
XFILLER_40_11 VDD VSS sg13g2_decap_8
XFILLER_109_635 VDD VSS sg13g2_decap_8
XFILLER_13_1236 VDD VSS sg13g2_decap_8
XFILLER_183_549 VDD VSS sg13g2_decap_8
XFILLER_6_228 VDD VSS sg13g2_decap_8
XFILLER_136_421 VDD VSS sg13g2_decap_8
XFILLER_100_1206 VDD VSS sg13g2_decap_4
XFILLER_164_752 VDD VSS sg13g2_decap_8
XFILLER_178_1432 VDD VSS sg13g2_decap_8
X_10371_ _10371_/Y _14815_/Q _10378_/D _10630_/C VDD VSS sg13g2_o21ai_1
XFILLER_152_925 VDD VSS sg13g2_decap_8
XFILLER_124_627 VDD VSS sg13g2_decap_4
X_12110_ _12110_/Y _12112_/A1 _13876_/Q _12114_/S1 VDD VSS sg13g2_a21oi_1
XFILLER_3_935 VDD VSS sg13g2_decap_8
XFILLER_124_649 VDD VSS sg13g2_decap_8
XFILLER_139_1449 VDD VSS sg13g2_fill_1
XFILLER_156_77 VDD VSS sg13g2_decap_4
XFILLER_174_1329 VDD VSS sg13g2_decap_8
X_13090_ _13092_/C _14911_/Q _13676_/Q _13077_/X VDD VSS sg13g2_a21oi_1
XFILLER_2_434 VDD VSS sg13g2_decap_8
XFILLER_46_1012 VDD VSS sg13g2_decap_8
X_12041_ _12041_/Y _12037_/Y _12038_/Y _12040_/Y _12039_/Y _12036_/B VDD VSS sg13g2_a221oi_1
XFILLER_85_1094 VDD VSS sg13g2_fill_2
XFILLER_49_42 VDD VSS sg13g2_decap_8
XFILLER_172_1053 VDD VSS sg13g2_decap_8
XFILLER_172_32 VDD VSS sg13g2_decap_8
XFILLER_104_384 VDD VSS sg13g2_decap_8
XFILLER_77_224 VDD VSS sg13g2_decap_4
Xfanout760 _08177_/S fanout767/X VDD VSS sg13g2_buf_1
XFILLER_77_246 VDD VSS sg13g2_fill_1
Xfanout771 _08431_/C _08452_/C VDD VSS sg13g2_buf_1
Xfanout782 _08612_/S _08649_/S VDD VSS sg13g2_buf_1
XFILLER_77_268 VDD VSS sg13g2_decap_8
X_13992_ _13992_/Q clkload16/A _13992_/D _13992_/RESET_B VDD VSS sg13g2_dfrbpq_1
XFILLER_24_1354 VDD VSS sg13g2_decap_8
Xfanout793 _12609_/S _12705_/S1 VDD VSS sg13g2_buf_1
XFILLER_1_49 VDD VSS sg13g2_decap_8
XFILLER_20_1207 VDD VSS sg13g2_decap_8
X_12943_ _12961_/A _12943_/A _12988_/A _12988_/B _12943_/D VDD VSS sg13g2_or4_1
XFILLER_74_964 VDD VSS sg13g2_decap_8
XFILLER_111_1368 VDD VSS sg13g2_decap_4
XFILLER_185_1425 VDD VSS sg13g2_decap_8
XFILLER_46_666 VDD VSS sg13g2_fill_2
X_14236__1966 _14236_/RESET_B VDD VSS sg13g2_tiehi
XFILLER_73_463 VDD VSS sg13g2_fill_2
X_12874_ _12878_/A _12874_/A _12876_/A _12877_/C VDD VSS sg13g2_or3_1
XFILLER_61_614 VDD VSS sg13g2_decap_8
X_15088__2836 _15088_/RESET_B VDD VSS sg13g2_tiehi
XFILLER_2_1183 VDD VSS sg13g2_decap_8
X_14613_ _14613_/Q _14677_/CLK _14613_/D _14613_/RESET_B VDD VSS sg13g2_dfrbpq_1
X_11825_ _11825_/Y _11826_/A1 _13900_/Q VDD VSS sg13g2_nand2b_1
XFILLER_33_349 VDD VSS sg13g2_decap_8
XFILLER_92_1032 VDD VSS sg13g2_fill_1
XFILLER_14_541 VDD VSS sg13g2_fill_1
XFILLER_57_1163 VDD VSS sg13g2_decap_8
X_14544_ _14544_/Q clkload15/A _14544_/D _14544_/RESET_B VDD VSS sg13g2_dfrbpq_1
XFILLER_60_168 VDD VSS sg13g2_decap_8
XFILLER_14_563 VDD VSS sg13g2_decap_8
X_11756_ _11756_/X _13834_/Q _13866_/Q _11756_/S VDD VSS sg13g2_mux2_1
XFILLER_18_1147 VDD VSS sg13g2_decap_8
XFILLER_53_1038 VDD VSS sg13g2_decap_8
XFILLER_186_343 VDD VSS sg13g2_decap_8
XFILLER_92_1098 VDD VSS sg13g2_fill_1
XFILLER_144_1166 VDD VSS sg13g2_decap_8
X_10707_ _14904_/D _10985_/B1 _10923_/B _10706_/Y VDD VSS sg13g2_o21ai_1
XFILLER_41_382 VDD VSS sg13g2_fill_2
XFILLER_105_1128 VDD VSS sg13g2_decap_8
X_14475_ _14475_/Q clkload11/A _14475_/D _14475_/RESET_B VDD VSS sg13g2_dfrbpq_1
XFILLER_35_1450 VDD VSS sg13g2_decap_8
XFILLER_128_900 VDD VSS sg13g2_decap_8
X_14451__1751 _14451_/RESET_B VDD VSS sg13g2_tiehi
X_11687_ _11687_/X _11687_/A _11696_/B VDD VSS sg13g2_and2_1
XFILLER_31_1314 VDD VSS sg13g2_decap_8
XFILLER_179_1218 VDD VSS sg13g2_decap_8
X_13426_ _15095_/D _13444_/B _13425_/Y _13423_/Y VDD VSS sg13g2_o21ai_1
X_10638_ _10640_/A _14886_/Q _10633_/C _14887_/Q VDD VSS sg13g2_a21oi_1
XFILLER_70_1385 VDD VSS sg13g2_decap_8
XFILLER_127_432 VDD VSS sg13g2_decap_4
XFILLER_128_966 VDD VSS sg13g2_decap_8
XFILLER_10_791 VDD VSS sg13g2_decap_8
X_13357_ _13357_/Y _13401_/C _13401_/B _13429_/A _13361_/C VDD VSS sg13g2_nor4_1
X_10569_ _14868_/D _10576_/C _10576_/D _10557_/B _07621_/Y _10608_/B VDD VSS sg13g2_a221oi_1
XFILLER_143_925 VDD VSS sg13g2_decap_8
XFILLER_182_571 VDD VSS sg13g2_fill_1
XFILLER_114_104 VDD VSS sg13g2_decap_8
X_12308_ _12308_/Y _12308_/A _12308_/B _12308_/C VDD VSS sg13g2_nand3_1
XFILLER_6_795 VDD VSS sg13g2_decap_8
XFILLER_154_295 VDD VSS sg13g2_decap_4
X_13288_ _13289_/D _15204_/Q _13506_/A VDD VSS sg13g2_nand2b_1
XFILLER_143_969 VDD VSS sg13g2_decap_8
X_13724__2478 _13724_/RESET_B VDD VSS sg13g2_tiehi
XFILLER_5_294 VDD VSS sg13g2_decap_8
X_15027_ _15027_/Q _15196_/CLK _15027_/D _15027_/RESET_B VDD VSS sg13g2_dfrbpq_1
X_12239_ _12239_/Y _12239_/A _12253_/B VDD VSS sg13g2_nand2_1
XFILLER_9_1304 VDD VSS sg13g2_decap_8
XFILLER_111_800 VDD VSS sg13g2_decap_8
XFILLER_29_1254 VDD VSS sg13g2_decap_8
XFILLER_116_1213 VDD VSS sg13g2_decap_8
XFILLER_68_224 VDD VSS sg13g2_fill_1
XFILLER_99_1208 VDD VSS sg13g2_fill_2
XFILLER_7_1050 VDD VSS sg13g2_decap_8
X_07780_ _07797_/B _08318_/C _08318_/D VDD VSS sg13g2_or2_1
XFILLER_42_1443 VDD VSS sg13g2_decap_8
XFILLER_84_739 VDD VSS sg13g2_decap_8
X_14104__2098 _14104_/RESET_B VDD VSS sg13g2_tiehi
Xinput4 input4/X input4/A VDD VSS sg13g2_buf_1
XFILLER_36_110 VDD VSS sg13g2_fill_1
XFILLER_37_644 VDD VSS sg13g2_decap_8
XFILLER_37_655 VDD VSS sg13g2_fill_1
X_09450_ _14051_/D _09749_/A1 _14051_/Q _09463_/S VDD VSS sg13g2_mux2_1
XFILLER_92_772 VDD VSS sg13g2_decap_8
XFILLER_24_316 VDD VSS sg13g2_fill_1
X_08401_ _08625_/A _15097_/Q _15092_/Q _08483_/A1 VDD VSS sg13g2_o21ai_1
XFILLER_36_187 VDD VSS sg13g2_decap_8
X_14988__2622 _14988_/RESET_B VDD VSS sg13g2_tiehi
X_09381_ _13984_/D _10010_/A0 _13984_/Q _09397_/S VDD VSS sg13g2_mux2_1
XFILLER_75_1230 VDD VSS sg13g2_decap_8
XFILLER_101_39 VDD VSS sg13g2_decap_8
XFILLER_80_978 VDD VSS sg13g2_decap_4
XFILLER_178_822 VDD VSS sg13g2_decap_8
XFILLER_51_157 VDD VSS sg13g2_decap_8
X_08332_ _08335_/C _08270_/B _08157_/X _08331_/Y VDD VSS sg13g2_o21ai_1
XFILLER_71_1105 VDD VSS sg13g2_decap_4
XFILLER_127_1342 VDD VSS sg13g2_fill_1
XFILLER_177_310 VDD VSS sg13g2_decap_4
XFILLER_36_1236 VDD VSS sg13g2_decap_8
XFILLER_32_360 VDD VSS sg13g2_decap_8
XFILLER_162_1255 VDD VSS sg13g2_decap_8
XFILLER_71_1138 VDD VSS sg13g2_decap_8
X_08263_ _08263_/Y _07929_/B _08263_/B VDD VSS sg13g2_nand2b_1
XFILLER_127_1397 VDD VSS sg13g2_decap_8
XFILLER_178_899 VDD VSS sg13g2_decap_8
XFILLER_137_229 VDD VSS sg13g2_fill_1
X_15056__2530 _15056_/RESET_B VDD VSS sg13g2_tiehi
X_08194_ _08194_/Y _08081_/X _08194_/B VDD VSS sg13g2_nand2b_1
XFILLER_158_590 VDD VSS sg13g2_decap_8
XFILLER_69_1001 VDD VSS sg13g2_decap_8
XFILLER_119_988 VDD VSS sg13g2_fill_1
XFILLER_161_700 VDD VSS sg13g2_decap_8
XFILLER_119_999 VDD VSS sg13g2_decap_4
XFILLER_10_14 VDD VSS sg13g2_decap_8
XFILLER_133_402 VDD VSS sg13g2_fill_2
XFILLER_105_104 VDD VSS sg13g2_decap_8
XFILLER_145_284 VDD VSS sg13g2_fill_1
XFILLER_156_1026 VDD VSS sg13g2_decap_8
XFILLER_134_969 VDD VSS sg13g2_decap_8
XFILLER_126_25 VDD VSS sg13g2_decap_4
XFILLER_160_232 VDD VSS sg13g2_decap_4
XFILLER_133_457 VDD VSS sg13g2_decap_8
XFILLER_86_1370 VDD VSS sg13g2_decap_8
X_14314__1888 _14314_/RESET_B VDD VSS sg13g2_tiehi
XFILLER_173_1351 VDD VSS sg13g2_decap_8
XFILLER_47_1354 VDD VSS sg13g2_decap_8
XFILLER_59_213 VDD VSS sg13g2_decap_4
XFILLER_114_693 VDD VSS sg13g2_decap_8
XFILLER_160_298 VDD VSS sg13g2_decap_8
XFILLER_82_1267 VDD VSS sg13g2_decap_8
XFILLER_87_544 VDD VSS sg13g2_fill_1
XFILLER_102_855 VDD VSS sg13g2_fill_1
XFILLER_48_909 VDD VSS sg13g2_fill_1
XFILLER_87_577 VDD VSS sg13g2_fill_1
XFILLER_19_56 VDD VSS sg13g2_decap_8
X_07978_ _07978_/Y _07905_/D _07960_/Y _07979_/A VDD VSS sg13g2_o21ai_1
X_14493__1709 _14493_/RESET_B VDD VSS sg13g2_tiehi
XFILLER_56_920 VDD VSS sg13g2_decap_8
X_13879__2323 _13879_/RESET_B VDD VSS sg13g2_tiehi
X_09717_ _14308_/D _09882_/A0 _14308_/Q _09725_/S VDD VSS sg13g2_mux2_1
XFILLER_27_110 VDD VSS sg13g2_decap_4
XFILLER_142_68 VDD VSS sg13g2_decap_8
XFILLER_56_953 VDD VSS sg13g2_decap_8
XFILLER_167_1100 VDD VSS sg13g2_decap_8
XFILLER_16_817 VDD VSS sg13g2_decap_4
XFILLER_83_761 VDD VSS sg13g2_decap_8
X_09648_ _14241_/D _09714_/A0 _14241_/Q _09663_/S VDD VSS sg13g2_mux2_1
XFILLER_35_11 VDD VSS sg13g2_decap_8
XFILLER_27_154 VDD VSS sg13g2_decap_4
XFILLER_15_305 VDD VSS sg13g2_fill_2
XFILLER_15_316 VDD VSS sg13g2_fill_2
XFILLER_82_282 VDD VSS sg13g2_fill_1
X_14783__2953 _14783_/RESET_B VDD VSS sg13g2_tiehi
XFILLER_70_433 VDD VSS sg13g2_decap_8
XFILLER_43_647 VDD VSS sg13g2_decap_8
XFILLER_42_124 VDD VSS sg13g2_decap_4
XFILLER_15_349 VDD VSS sg13g2_decap_8
XFILLER_169_800 VDD VSS sg13g2_fill_2
XFILLER_19_1401 VDD VSS sg13g2_decap_8
X_09579_ _14176_/D _14176_/Q _09612_/A0 _09590_/S VDD VSS sg13g2_mux2_1
XFILLER_93_1330 VDD VSS sg13g2_decap_8
XFILLER_71_967 VDD VSS sg13g2_fill_2
XFILLER_93_1341 VDD VSS sg13g2_fill_2
XFILLER_150_4 VDD VSS sg13g2_decap_8
XFILLER_167_1199 VDD VSS sg13g2_decap_8
X_11610_ _11610_/Y _11621_/S0 _14406_/Q _11391_/B VDD VSS sg13g2_a21oi_1
XFILLER_180_1322 VDD VSS sg13g2_decap_8
XFILLER_54_1325 VDD VSS sg13g2_decap_8
XFILLER_24_872 VDD VSS sg13g2_fill_2
X_12590_ _12590_/X _13740_/Q _14092_/Q _14444_/Q _14540_/Q _12590_/S0 _12590_/S1 VDD
+ VSS sg13g2_mux4_1
XFILLER_145_1453 VDD VSS sg13g2_decap_8
XFILLER_23_371 VDD VSS sg13g2_decap_8
XFILLER_11_522 VDD VSS sg13g2_decap_8
XFILLER_169_866 VDD VSS sg13g2_fill_1
XFILLER_19_1478 VDD VSS sg13g2_fill_1
X_11541_ _11542_/A _13732_/Q _14084_/Q _14436_/Q _14532_/Q _11551_/A1 _11532_/C VDD
+ VSS sg13g2_mux4_1
XFILLER_7_504 VDD VSS sg13g2_decap_8
XFILLER_156_527 VDD VSS sg13g2_decap_8
XFILLER_180_1399 VDD VSS sg13g2_decap_8
XFILLER_109_410 VDD VSS sg13g2_fill_2
XFILLER_156_538 VDD VSS sg13g2_fill_1
XFILLER_167_32 VDD VSS sg13g2_decap_8
XFILLER_184_847 VDD VSS sg13g2_decap_8
X_14260_ _14260_/Q clkload15/A _14260_/D _14260_/RESET_B VDD VSS sg13g2_dfrbpq_1
X_11472_ _11472_/X _13825_/Q _13857_/Q _13889_/Q _13921_/Q _11473_/S0 _11473_/S1 VDD
+ VSS sg13g2_mux4_1
XFILLER_11_599 VDD VSS sg13g2_decap_8
XFILLER_13_1033 VDD VSS sg13g2_decap_8
X_13211_ _15047_/D _13266_/A _13211_/B VDD VSS sg13g2_nor2_1
XFILLER_171_508 VDD VSS sg13g2_decap_8
XFILLER_183_368 VDD VSS sg13g2_decap_8
X_10423_ _14830_/D _10423_/A _10423_/B _10423_/C VDD VSS sg13g2_and3_1
X_14191_ _14191_/Q clkload35/A _14191_/D _14191_/RESET_B VDD VSS sg13g2_dfrbpq_1
XFILLER_100_1036 VDD VSS sg13g2_decap_8
XFILLER_152_711 VDD VSS sg13g2_decap_8
XFILLER_164_582 VDD VSS sg13g2_decap_8
X_13142_ _13174_/A _13142_/A _13671_/Q VDD VSS sg13g2_nand2_1
XFILLER_125_958 VDD VSS sg13g2_fill_2
X_10354_ _10360_/C _14811_/Q _10353_/B VDD VSS sg13g2_nor2b_1
XFILLER_174_1126 VDD VSS sg13g2_decap_8
XFILLER_3_732 VDD VSS sg13g2_decap_8
XFILLER_30_1391 VDD VSS sg13g2_decap_8
XFILLER_65_1410 VDD VSS sg13g2_decap_8
XFILLER_4_0 VDD VSS sg13g2_decap_8
XFILLER_2_231 VDD VSS sg13g2_decap_8
XFILLER_183_53 VDD VSS sg13g2_decap_8
X_13073_ _13073_/Y _13154_/A1 _13072_/X _13071_/Y VDD VSS sg13g2_a21oi_1
X_10285_ _10288_/B _14788_/Q _14789_/Q _10305_/A _10305_/B VDD VSS sg13g2_nand4_1
XFILLER_151_276 VDD VSS sg13g2_decap_8
X_12024_ _12026_/A _12025_/A _14642_/Q VDD VSS sg13g2_nand2b_1
XFILLER_105_693 VDD VSS sg13g2_decap_8
XFILLER_152_1424 VDD VSS sg13g2_decap_8
X_13692__2511 _13692_/RESET_B VDD VSS sg13g2_tiehi
XFILLER_26_1438 VDD VSS sg13g2_decap_8
XFILLER_120_641 VDD VSS sg13g2_decap_8
XFILLER_78_555 VDD VSS sg13g2_decap_4
XFILLER_38_408 VDD VSS sg13g2_decap_4
XFILLER_19_600 VDD VSS sg13g2_decap_8
XFILLER_120_696 VDD VSS sg13g2_decap_8
XFILLER_19_611 VDD VSS sg13g2_decap_8
Xfanout590 _11792_/B _11433_/B VDD VSS sg13g2_buf_1
XFILLER_24_1151 VDD VSS sg13g2_decap_8
XFILLER_19_633 VDD VSS sg13g2_decap_8
X_14469__1733 _14469_/RESET_B VDD VSS sg13g2_tiehi
XFILLER_93_547 VDD VSS sg13g2_fill_2
XFILLER_65_238 VDD VSS sg13g2_fill_1
XFILLER_47_942 VDD VSS sg13g2_decap_8
XFILLER_98_1230 VDD VSS sg13g2_decap_4
X_13975_ _13975_/Q clkload43/A _13975_/D _13975_/RESET_B VDD VSS sg13g2_dfrbpq_1
XFILLER_4_1267 VDD VSS sg13g2_decap_8
XFILLER_185_1222 VDD VSS sg13g2_decap_8
X_12926_ _12928_/B _14901_/Q _13686_/Q _12989_/B VDD VSS sg13g2_o21ai_1
XFILLER_46_474 VDD VSS sg13g2_decap_8
XFILLER_18_176 VDD VSS sg13g2_fill_1
XFILLER_59_1247 VDD VSS sg13g2_decap_8
XFILLER_18_198 VDD VSS sg13g2_decap_8
XFILLER_92_50 VDD VSS sg13g2_decap_8
XFILLER_34_658 VDD VSS sg13g2_decap_8
XFILLER_146_1228 VDD VSS sg13g2_decap_4
X_12857_ _12861_/A _12846_/Y _12848_/X _12847_/X VDD VSS sg13g2_a21oi_1
XFILLER_34_669 VDD VSS sg13g2_fill_1
XFILLER_185_1299 VDD VSS sg13g2_decap_8
XFILLER_62_989 VDD VSS sg13g2_decap_8
XFILLER_21_308 VDD VSS sg13g2_decap_8
X_11808_ _11808_/Y _11808_/A _11822_/B VDD VSS sg13g2_nand2_1
XFILLER_14_360 VDD VSS sg13g2_decap_8
X_12788_ _12788_/X _12787_/X _12786_/X _12783_/X _12782_/X _12788_/S0 _12355_/S VDD
+ VSS sg13g2_mux4_1
XFILLER_72_1447 VDD VSS sg13g2_decap_8
XFILLER_30_831 VDD VSS sg13g2_decap_8
XFILLER_186_140 VDD VSS sg13g2_decap_8
X_14527_ _14527_/Q clkload61/A _14527_/D _14527_/RESET_B VDD VSS sg13g2_dfrbpq_1
X_11739_ _11743_/A _11738_/X _11967_/B VDD VSS sg13g2_nand2b_1
XFILLER_30_842 VDD VSS sg13g2_fill_1
X_14458_ _14458_/Q clkload77/A _14458_/D _14458_/RESET_B VDD VSS sg13g2_dfrbpq_1
XFILLER_31_1122 VDD VSS sg13g2_fill_2
XFILLER_70_1182 VDD VSS sg13g2_decap_8
XFILLER_128_752 VDD VSS sg13g2_decap_8
X_13409_ _13409_/Y _13507_/B _15092_/Q VDD VSS sg13g2_nor2b_1
X_14389_ _14389_/Q _14677_/CLK _14389_/D _14389_/RESET_B VDD VSS sg13g2_dfrbpq_1
XFILLER_122_1294 VDD VSS sg13g2_decap_4
XFILLER_155_571 VDD VSS sg13g2_fill_2
XFILLER_183_880 VDD VSS sg13g2_decap_8
X_13957__2245 _13957_/RESET_B VDD VSS sg13g2_tiehi
XFILLER_31_1188 VDD VSS sg13g2_decap_8
XFILLER_115_424 VDD VSS sg13g2_decap_8
XFILLER_143_733 VDD VSS sg13g2_fill_1
XFILLER_66_1207 VDD VSS sg13g2_decap_8
XFILLER_127_295 VDD VSS sg13g2_fill_2
XFILLER_6_592 VDD VSS sg13g2_decap_8
XFILLER_115_468 VDD VSS sg13g2_decap_8
XFILLER_157_1357 VDD VSS sg13g2_decap_8
XFILLER_118_1319 VDD VSS sg13g2_fill_2
Xhold3107 hold3107/X _10214_/Y VDD VSS sg13g2_dlygate4sd3_1
X_08950_ _08950_/Y _08948_/Y _08949_/Y _08955_/S VDD VSS sg13g2_a21oi_1
Xhold3118 _13641_/A _13749_/Q VDD VSS sg13g2_dlygate4sd3_1
XFILLER_143_799 VDD VSS sg13g2_decap_8
Xhold3129 _13631_/A _13739_/Q VDD VSS sg13g2_dlygate4sd3_1
XFILLER_170_596 VDD VSS sg13g2_decap_8
X_07901_ _07904_/C _08073_/A _08073_/C _08073_/B VDD VSS sg13g2_a21oi_1
XFILLER_37_0 VDD VSS sg13g2_decap_8
XFILLER_9_1134 VDD VSS sg13g2_decap_8
XFILLER_130_449 VDD VSS sg13g2_decap_8
X_08881_ _08881_/X _15034_/Q _14938_/Q _10725_/A VDD VSS sg13g2_mux2_1
XFILLER_155_1081 VDD VSS sg13g2_decap_8
XFILLER_155_1092 VDD VSS sg13g2_fill_2
XFILLER_116_1054 VDD VSS sg13g2_decap_8
X_07832_ _07834_/B _08692_/C _12298_/A VDD VSS sg13g2_nor2b_1
XFILLER_9_1178 VDD VSS sg13g2_decap_8
XFILLER_111_674 VDD VSS sg13g2_decap_8
XFILLER_111_685 VDD VSS sg13g2_fill_1
XFILLER_96_374 VDD VSS sg13g2_fill_2
XFILLER_42_1240 VDD VSS sg13g2_decap_8
XFILLER_111_696 VDD VSS sg13g2_decap_8
XFILLER_99_1038 VDD VSS sg13g2_decap_4
XFILLER_2_70 VDD VSS sg13g2_decap_8
XFILLER_133_1390 VDD VSS sg13g2_decap_8
X_07763_ _15204_/D _07744_/B _07738_/Y _07762_/Y VDD VSS sg13g2_o21ai_1
XFILLER_84_558 VDD VSS sg13g2_decap_8
XFILLER_186_1008 VDD VSS sg13g2_decap_8
X_09502_ _14102_/D _09966_/A1 _14102_/Q _09506_/S VDD VSS sg13g2_mux2_1
XFILLER_65_761 VDD VSS sg13g2_decap_8
X_07694_ _07694_/Y _11241_/A _08832_/D _07674_/Y VDD VSS sg13g2_a21oi_1
XFILLER_25_614 VDD VSS sg13g2_decap_8
XFILLER_25_625 VDD VSS sg13g2_fill_1
XFILLER_168_1475 VDD VSS sg13g2_decap_4
X_09433_ _14035_/D _10162_/A1 _14035_/Q _09438_/S VDD VSS sg13g2_mux2_1
XFILLER_53_956 VDD VSS sg13g2_decap_8
XFILLER_25_647 VDD VSS sg13g2_decap_8
XFILLER_77_1369 VDD VSS sg13g2_decap_8
XFILLER_52_433 VDD VSS sg13g2_fill_2
XFILLER_24_135 VDD VSS sg13g2_decap_8
XFILLER_12_308 VDD VSS sg13g2_decap_8
X_09364_ _13968_/D _09463_/A0 _13968_/Q _09364_/S VDD VSS sg13g2_mux2_1
XFILLER_75_1060 VDD VSS sg13g2_decap_8
XFILLER_80_797 VDD VSS sg13g2_fill_2
X_08315_ _08315_/Y _08315_/A _08315_/B _08315_/C VDD VSS sg13g2_nor3_1
XANTENNA_20 _09292_/S VDD VSS sg13g2_antennanp
XFILLER_177_151 VDD VSS sg13g2_decap_8
X_09295_ _13903_/D _13903_/Q _09827_/A0 _09304_/S VDD VSS sg13g2_mux2_1
XFILLER_166_825 VDD VSS sg13g2_decap_8
XFILLER_138_527 VDD VSS sg13g2_decap_8
XFILLER_162_1085 VDD VSS sg13g2_decap_8
X_08246_ _08246_/Y _08334_/A1 _08243_/Y _08244_/Y _08245_/Y _08240_/Y VDD VSS sg13g2_a221oi_1
XFILLER_14_1331 VDD VSS sg13g2_decap_8
XFILLER_20_374 VDD VSS sg13g2_decap_8
XFILLER_123_1069 VDD VSS sg13g2_decap_8
XFILLER_53_1391 VDD VSS sg13g2_decap_8
XFILLER_165_368 VDD VSS sg13g2_decap_8
X_08177_ _08177_/X _08042_/X _08059_/X _08177_/S VDD VSS sg13g2_mux2_1
XFILLER_88_1432 VDD VSS sg13g2_decap_8
XFILLER_101_1334 VDD VSS sg13g2_decap_8
XFILLER_4_518 VDD VSS sg13g2_decap_8
XFILLER_10_1239 VDD VSS sg13g2_decap_8
XFILLER_119_796 VDD VSS sg13g2_decap_8
XFILLER_134_722 VDD VSS sg13g2_fill_2
XFILLER_137_35 VDD VSS sg13g2_fill_1
XFILLER_134_733 VDD VSS sg13g2_fill_2
X_14547__1655 _14547_/RESET_B VDD VSS sg13g2_tiehi
XFILLER_118_295 VDD VSS sg13g2_decap_8
XFILLER_161_530 VDD VSS sg13g2_decap_8
XFILLER_173_390 VDD VSS sg13g2_fill_1
XFILLER_106_457 VDD VSS sg13g2_fill_1
XFILLER_97_28 VDD VSS sg13g2_decap_4
XFILLER_175_1468 VDD VSS sg13g2_fill_2
XFILLER_121_416 VDD VSS sg13g2_decap_8
XFILLER_47_1151 VDD VSS sg13g2_decap_8
XFILLER_0_735 VDD VSS sg13g2_decap_4
X_10070_ _10070_/Y _10070_/A _10070_/B _10070_/C VDD VSS sg13g2_nand3_1
XFILLER_114_490 VDD VSS sg13g2_fill_2
XFILLER_153_34 VDD VSS sg13g2_fill_1
XFILLER_88_853 VDD VSS sg13g2_decap_8
XFILLER_0_757 VDD VSS sg13g2_decap_8
XFILLER_134_1143 VDD VSS sg13g2_decap_4
XFILLER_48_706 VDD VSS sg13g2_decap_8
XFILLER_87_352 VDD VSS sg13g2_decap_8
XFILLER_48_717 VDD VSS sg13g2_fill_1
XFILLER_130_983 VDD VSS sg13g2_decap_8
XFILLER_101_151 VDD VSS sg13g2_fill_2
XFILLER_102_685 VDD VSS sg13g2_decap_4
XFILLER_25_1460 VDD VSS sg13g2_decap_8
XFILLER_21_1302 VDD VSS sg13g2_decap_8
XFILLER_112_1430 VDD VSS sg13g2_decap_8
XFILLER_169_1217 VDD VSS sg13g2_decap_8
XFILLER_75_547 VDD VSS sg13g2_decap_8
XFILLER_1_1407 VDD VSS sg13g2_decap_8
X_13760_ _13760_/Q clkload23/A _13760_/D _13760_/RESET_B VDD VSS sg13g2_dfrbpq_1
X_10972_ _14939_/D _10971_/Y _10970_/Y _10959_/Y VDD VSS sg13g2_o21ai_1
XFILLER_29_997 VDD VSS sg13g2_decap_4
XFILLER_21_1379 VDD VSS sg13g2_decap_8
XFILLER_95_1436 VDD VSS sg13g2_decap_8
X_12711_ _12711_/X _13845_/Q _13877_/Q _13909_/Q _13941_/Q _12711_/S0 _12711_/S1 VDD
+ VSS sg13g2_mux4_1
XFILLER_71_742 VDD VSS sg13g2_fill_1
XFILLER_56_1409 VDD VSS sg13g2_decap_8
X_13691_ _13691_/Q _15212_/CLK _13691_/D _13691_/RESET_B VDD VSS sg13g2_dfrbpq_1
XFILLER_182_1439 VDD VSS sg13g2_decap_8
XFILLER_70_241 VDD VSS sg13g2_decap_8
XFILLER_54_1100 VDD VSS sg13g2_decap_8
X_12642_ _12642_/X _14384_/Q _14416_/Q _14480_/Q _14512_/Q _12643_/S0 _12643_/S1 VDD
+ VSS sg13g2_mux4_1
XFILLER_15_179 VDD VSS sg13g2_fill_2
XFILLER_58_1280 VDD VSS sg13g2_decap_8
XFILLER_62_42 VDD VSS sg13g2_decap_8
XFILLER_141_0 VDD VSS sg13g2_decap_8
XFILLER_62_64 VDD VSS sg13g2_decap_8
XFILLER_178_42 VDD VSS sg13g2_decap_8
XFILLER_19_1275 VDD VSS sg13g2_decap_8
X_12573_ _12573_/X _14123_/Q _14155_/Q _14187_/Q _14219_/Q _12576_/S0 _12576_/S1 VDD
+ VSS sg13g2_mux4_1
XFILLER_15_1117 VDD VSS sg13g2_decap_8
XFILLER_8_802 VDD VSS sg13g2_decap_8
XFILLER_141_1136 VDD VSS sg13g2_decap_8
XFILLER_157_836 VDD VSS sg13g2_decap_8
XFILLER_184_622 VDD VSS sg13g2_decap_8
XFILLER_7_301 VDD VSS sg13g2_decap_8
XFILLER_180_1196 VDD VSS sg13g2_decap_8
X_14312_ _14312_/Q clkload21/A _14312_/D _14312_/RESET_B VDD VSS sg13g2_dfrbpq_1
X_11524_ _11527_/A _11502_/A _13685_/Q _11505_/X VDD VSS sg13g2_a21oi_1
XFILLER_54_1199 VDD VSS sg13g2_decap_8
XFILLER_106_1267 VDD VSS sg13g2_decap_4
XFILLER_141_1169 VDD VSS sg13g2_decap_8
XFILLER_32_1442 VDD VSS sg13g2_decap_8
XFILLER_11_396 VDD VSS sg13g2_decap_8
X_14243_ _14243_/Q clkload17/A _14243_/D _14243_/RESET_B VDD VSS sg13g2_dfrbpq_1
XFILLER_8_879 VDD VSS sg13g2_decap_8
XFILLER_171_305 VDD VSS sg13g2_decap_8
X_11455_ _11457_/C _11430_/B _11430_/A _11427_/X VDD VSS sg13g2_a21o_1
XFILLER_183_165 VDD VSS sg13g2_decap_8
XFILLER_125_711 VDD VSS sg13g2_decap_8
XFILLER_7_378 VDD VSS sg13g2_decap_8
XFILLER_109_273 VDD VSS sg13g2_decap_8
XFILLER_137_582 VDD VSS sg13g2_decap_8
XFILLER_109_284 VDD VSS sg13g2_fill_1
X_10406_ _14824_/D _10406_/A _10623_/A _10406_/C VDD VSS sg13g2_nor3_1
XFILLER_171_349 VDD VSS sg13g2_fill_1
X_14174_ _14174_/Q _14526_/CLK _14174_/D _14174_/RESET_B VDD VSS sg13g2_dfrbpq_1
XFILLER_124_221 VDD VSS sg13g2_decap_8
X_11386_ _11386_/Y _11860_/B1 _11385_/Y _11380_/Y _11381_/Y _11432_/A2 VDD VSS sg13g2_a221oi_1
XFILLER_98_606 VDD VSS sg13g2_fill_2
XFILLER_180_872 VDD VSS sg13g2_fill_1
X_13125_ _13125_/X input16/X _13264_/A2 _13272_/B1 VDD VSS sg13g2_a21o_1
X_10337_ _14805_/D _10337_/A _10337_/B _10337_/C VDD VSS sg13g2_and3_1
XFILLER_112_449 VDD VSS sg13g2_decap_8
X_13056_ _15036_/D _13043_/Y _13055_/Y _13127_/A VDD VSS sg13g2_a21oi_1
XFILLER_152_1221 VDD VSS sg13g2_decap_8
X_10268_ _10299_/B _14782_/Q _14783_/Q _14784_/Q _10268_/D VDD VSS sg13g2_nand4_1
XFILLER_61_1104 VDD VSS sg13g2_decap_8
XFILLER_152_1232 VDD VSS sg13g2_fill_2
XFILLER_65_1284 VDD VSS sg13g2_decap_8
XFILLER_61_1115 VDD VSS sg13g2_fill_2
XFILLER_26_1235 VDD VSS sg13g2_decap_8
XFILLER_117_1363 VDD VSS sg13g2_fill_2
Xfanout1330 _11786_/S0 _11788_/S0 VDD VSS sg13g2_buf_1
X_12007_ _12053_/A _12009_/A _12298_/B VDD VSS sg13g2_nor2_1
XFILLER_79_875 VDD VSS sg13g2_decap_8
XFILLER_117_1374 VDD VSS sg13g2_decap_8
Xfanout1341 _11692_/A _11686_/S0 VDD VSS sg13g2_buf_1
XFILLER_87_94 VDD VSS sg13g2_decap_8
Xfanout1352 _11617_/A1 _11621_/S0 VDD VSS sg13g2_buf_1
XFILLER_61_1148 VDD VSS sg13g2_decap_8
XFILLER_113_1227 VDD VSS sg13g2_fill_2
X_10199_ _15181_/D hold3087/X _13389_/A _10203_/S VDD VSS sg13g2_mux2_1
XFILLER_93_300 VDD VSS sg13g2_fill_2
XFILLER_66_525 VDD VSS sg13g2_fill_2
Xfanout1363 _11368_/S0 _11812_/A1 VDD VSS sg13g2_buf_1
Xfanout1374 _12139_/S0 _12140_/S0 VDD VSS sg13g2_buf_1
XFILLER_94_845 VDD VSS sg13g2_fill_1
Xfanout1385 _12189_/S0 fanout1388/X VDD VSS sg13g2_buf_1
Xfanout1396 _13266_/A _13507_/A VDD VSS sg13g2_buf_1
XFILLER_38_249 VDD VSS sg13g2_fill_2
XFILLER_93_366 VDD VSS sg13g2_decap_4
XFILLER_4_1064 VDD VSS sg13g2_decap_8
XFILLER_47_772 VDD VSS sg13g2_fill_2
X_14021__2181 _14021_/RESET_B VDD VSS sg13g2_tiehi
X_13958_ _13958_/Q _14510_/CLK _13958_/D _13958_/RESET_B VDD VSS sg13g2_dfrbpq_1
X_12909_ _12909_/Y _12925_/A _12925_/B _12909_/C VDD VSS sg13g2_nand3_1
X_13889_ _13889_/Q _14723_/CLK _13889_/D _13889_/RESET_B VDD VSS sg13g2_dfrbpq_1
XFILLER_50_904 VDD VSS sg13g2_decap_8
X_14625__1577 _14625_/RESET_B VDD VSS sg13g2_tiehi
XFILLER_146_1047 VDD VSS sg13g2_decap_8
XFILLER_185_1096 VDD VSS sg13g2_decap_8
XFILLER_62_797 VDD VSS sg13g2_decap_8
XFILLER_76_1380 VDD VSS sg13g2_decap_8
XFILLER_21_116 VDD VSS sg13g2_decap_8
X_14907__2753 _14907_/RESET_B VDD VSS sg13g2_tiehi
XFILLER_72_1244 VDD VSS sg13g2_decap_8
XFILLER_37_1364 VDD VSS sg13g2_decap_8
XFILLER_175_600 VDD VSS sg13g2_decap_8
XFILLER_163_1394 VDD VSS sg13g2_decap_8
X_08100_ _08104_/C _08200_/A _08199_/B _08200_/C VDD VSS sg13g2_nor3_1
X_09080_ _09082_/B _13088_/A _09103_/C _14913_/Q VDD VSS sg13g2_a21o_1
XFILLER_30_672 VDD VSS sg13g2_decap_8
XFILLER_147_357 VDD VSS sg13g2_decap_8
XFILLER_175_666 VDD VSS sg13g2_decap_8
X_08031_ _08032_/D _08270_/B _08177_/S _08031_/C VDD VSS sg13g2_nor3_1
XFILLER_174_154 VDD VSS sg13g2_decap_8
XFILLER_104_917 VDD VSS sg13g2_decap_8
XFILLER_115_243 VDD VSS sg13g2_fill_2
XFILLER_143_552 VDD VSS sg13g2_fill_2
XFILLER_104_928 VDD VSS sg13g2_fill_1
XFILLER_115_254 VDD VSS sg13g2_decap_8
XFILLER_103_405 VDD VSS sg13g2_fill_2
XFILLER_171_883 VDD VSS sg13g2_decap_8
X_09982_ _14565_/D _10081_/A0 _14565_/Q _09990_/S VDD VSS sg13g2_mux2_1
XFILLER_131_725 VDD VSS sg13g2_decap_8
XFILLER_143_596 VDD VSS sg13g2_decap_8
XFILLER_157_1176 VDD VSS sg13g2_decap_8
XFILLER_83_1340 VDD VSS sg13g2_decap_8
XFILLER_130_224 VDD VSS sg13g2_decap_8
XFILLER_153_1029 VDD VSS sg13g2_decap_8
X_08933_ _08933_/X _15047_/Q _14951_/Q _08936_/S VDD VSS sg13g2_mux2_1
XFILLER_103_449 VDD VSS sg13g2_decap_8
X_14231__1971 _14231_/RESET_B VDD VSS sg13g2_tiehi
XFILLER_112_972 VDD VSS sg13g2_decap_8
XFILLER_170_1354 VDD VSS sg13g2_decap_8
X_08864_ _13699_/D _16861_/A _08863_/X _08876_/S VDD VSS sg13g2_mux2_1
XFILLER_85_823 VDD VSS sg13g2_decap_8
XFILLER_44_1368 VDD VSS sg13g2_decap_8
XFILLER_96_171 VDD VSS sg13g2_decap_4
X_07815_ _07815_/X _15010_/Q _11936_/A VDD VSS sg13g2_or2_1
XFILLER_79_1409 VDD VSS sg13g2_decap_8
X_08795_ _08796_/B _13683_/Q _08810_/B VDD VSS sg13g2_nor2_1
XFILLER_84_355 VDD VSS sg13g2_fill_2
X_15118__2746 _15118_/RESET_B VDD VSS sg13g2_tiehi
X_07746_ _07750_/B _13481_/A _15124_/Q _07746_/C VDD VSS sg13g2_nor3_1
XFILLER_44_219 VDD VSS sg13g2_decap_8
XFILLER_77_1122 VDD VSS sg13g2_decap_8
XFILLER_65_580 VDD VSS sg13g2_fill_1
XFILLER_77_1133 VDD VSS sg13g2_fill_1
XFILLER_168_1272 VDD VSS sg13g2_decap_8
XFILLER_16_46 VDD VSS sg13g2_decap_8
X_07677_ _07677_/Y _13600_/C _07677_/B _07677_/C _07721_/A VDD VSS sg13g2_nand4_1
XFILLER_77_1166 VDD VSS sg13g2_decap_8
XFILLER_41_904 VDD VSS sg13g2_decap_8
XFILLER_53_775 VDD VSS sg13g2_decap_8
X_09416_ _14018_/D _09614_/A0 _14018_/Q _09430_/S VDD VSS sg13g2_mux2_1
XFILLER_73_1019 VDD VSS sg13g2_decap_4
XFILLER_38_1139 VDD VSS sg13g2_decap_8
XFILLER_12_105 VDD VSS sg13g2_decap_8
XFILLER_80_583 VDD VSS sg13g2_decap_8
XFILLER_129_1278 VDD VSS sg13g2_decap_8
XFILLER_40_436 VDD VSS sg13g2_decap_8
XFILLER_179_972 VDD VSS sg13g2_decap_8
X_09347_ _13951_/D _10075_/A0 _13951_/Q _09368_/S VDD VSS sg13g2_mux2_1
XFILLER_90_1344 VDD VSS sg13g2_decap_8
XFILLER_8_109 VDD VSS sg13g2_decap_8
XFILLER_103_1407 VDD VSS sg13g2_fill_1
XFILLER_178_493 VDD VSS sg13g2_decap_4
X_09278_ _13886_/D _13886_/Q _09744_/A1 _09292_/S VDD VSS sg13g2_mux2_1
XFILLER_32_56 VDD VSS sg13g2_decap_8
XFILLER_138_346 VDD VSS sg13g2_decap_8
XFILLER_154_806 VDD VSS sg13g2_decap_8
X_08229_ _08229_/Y _08229_/A _08229_/B _08229_/C VDD VSS sg13g2_nand3_1
XFILLER_5_805 VDD VSS sg13g2_decap_8
XFILLER_113_4 VDD VSS sg13g2_decap_4
XFILLER_147_880 VDD VSS sg13g2_decap_8
XFILLER_101_1142 VDD VSS sg13g2_decap_8
XFILLER_107_722 VDD VSS sg13g2_decap_8
XFILLER_4_315 VDD VSS sg13g2_decap_8
X_11240_ _11248_/A _12799_/A _15123_/Q _11239_/Y VDD VSS sg13g2_a21oi_1
XFILLER_10_1036 VDD VSS sg13g2_decap_8
XFILLER_181_658 VDD VSS sg13g2_decap_8
X_14063__2139 _14063_/RESET_B VDD VSS sg13g2_tiehi
XFILLER_180_168 VDD VSS sg13g2_decap_8
XFILLER_106_265 VDD VSS sg13g2_fill_1
X_11171_ _11186_/A _11181_/A _11171_/B VDD VSS sg13g2_nand2_1
XFILLER_107_799 VDD VSS sg13g2_decap_8
XFILLER_175_1265 VDD VSS sg13g2_decap_8
XFILLER_49_1268 VDD VSS sg13g2_decap_8
XFILLER_161_382 VDD VSS sg13g2_decap_8
X_10122_ _14700_/D _10155_/A1 _14700_/Q _10124_/S VDD VSS sg13g2_mux2_1
XFILLER_164_77 VDD VSS sg13g2_decap_8
XFILLER_0_532 VDD VSS sg13g2_decap_8
XFILLER_79_149 VDD VSS sg13g2_decap_8
X_15002__2608 _15002_/RESET_B VDD VSS sg13g2_tiehi
X_14703__1499 _14703_/RESET_B VDD VSS sg13g2_tiehi
XFILLER_88_661 VDD VSS sg13g2_decap_8
XFILLER_62_1446 VDD VSS sg13g2_decap_8
XFILLER_121_279 VDD VSS sg13g2_decap_8
X_14930_ _14930_/Q _14930_/CLK _14930_/D _14930_/RESET_B VDD VSS sg13g2_dfrbpq_1
X_10053_ _14634_/D _10086_/A0 _14634_/Q _10057_/S VDD VSS sg13g2_mux2_1
XFILLER_76_812 VDD VSS sg13g2_fill_1
XFILLER_48_503 VDD VSS sg13g2_fill_2
XFILLER_102_460 VDD VSS sg13g2_fill_1
XFILLER_180_21 VDD VSS sg13g2_decap_8
XFILLER_87_182 VDD VSS sg13g2_fill_2
X_14861_ _14861_/Q clkload90/A _14861_/D _14861_/RESET_B VDD VSS sg13g2_dfrbpq_1
XFILLER_5_1351 VDD VSS sg13g2_decap_8
XFILLER_48_569 VDD VSS sg13g2_decap_4
XFILLER_1_1204 VDD VSS sg13g2_decap_8
X_13812_ _13812_/Q clkload15/A _13812_/D _13812_/RESET_B VDD VSS sg13g2_dfrbpq_1
XFILLER_180_98 VDD VSS sg13g2_decap_8
XFILLER_91_837 VDD VSS sg13g2_decap_4
X_14792_ _14792_/Q clkload89/A _14792_/D _14792_/RESET_B VDD VSS sg13g2_dfrbpq_1
XFILLER_99_1380 VDD VSS sg13g2_fill_1
XFILLER_147_1301 VDD VSS sg13g2_decap_8
XFILLER_186_1350 VDD VSS sg13g2_decap_8
XFILLER_21_1176 VDD VSS sg13g2_decap_8
XFILLER_44_731 VDD VSS sg13g2_decap_8
XFILLER_16_433 VDD VSS sg13g2_decap_4
XFILLER_44_742 VDD VSS sg13g2_fill_2
X_13743_ _13743_/Q _15162_/CLK _13743_/D _13743_/RESET_B VDD VSS sg13g2_dfrbpq_1
X_10955_ _10956_/B _10954_/C _10965_/C _10953_/Y VDD VSS sg13g2_a21o_1
XFILLER_56_1206 VDD VSS sg13g2_decap_8
XFILLER_182_1236 VDD VSS sg13g2_decap_8
XFILLER_44_786 VDD VSS sg13g2_decap_8
XFILLER_108_1318 VDD VSS sg13g2_decap_8
XFILLER_73_85 VDD VSS sg13g2_decap_8
XFILLER_44_797 VDD VSS sg13g2_decap_8
X_13674_ _13674_/Q _15188_/CLK _13674_/D _13674_/RESET_B VDD VSS sg13g2_dfrbpq_1
X_10886_ _10886_/X _10897_/A _10886_/A2 _10886_/B1 VDD VSS sg13g2_a21o_1
XFILLER_32_948 VDD VSS sg13g2_decap_8
XFILLER_176_419 VDD VSS sg13g2_fill_1
X_12625_ _15008_/D _12625_/A _12625_/B VDD VSS sg13g2_nor2_1
XFILLER_157_611 VDD VSS sg13g2_decap_8
XFILLER_12_661 VDD VSS sg13g2_decap_8
X_14273__1929 _14273_/RESET_B VDD VSS sg13g2_tiehi
XFILLER_106_1053 VDD VSS sg13g2_decap_8
X_12556_ _12569_/A _12639_/A1 _12779_/A2 _08383_/B VDD VSS sg13g2_a21oi_1
XFILLER_185_964 VDD VSS sg13g2_decap_8
XFILLER_78_7 VDD VSS sg13g2_decap_8
X_11507_ _11507_/X _13827_/Q _13859_/Q _13891_/Q _13923_/Q _11514_/S0 _11514_/S1 VDD
+ VSS sg13g2_mux4_1
XFILLER_117_519 VDD VSS sg13g2_decap_8
XFILLER_11_193 VDD VSS sg13g2_decap_8
X_12487_ _12487_/X _13829_/Q _13861_/Q _13893_/Q _13925_/Q _12494_/S0 _12494_/S1 VDD
+ VSS sg13g2_mux4_1
XFILLER_8_676 VDD VSS sg13g2_decap_8
XFILLER_184_485 VDD VSS sg13g2_decap_8
XFILLER_7_175 VDD VSS sg13g2_decap_8
X_14226_ _14226_/Q clkload40/A _14226_/D _14226_/RESET_B VDD VSS sg13g2_dfrbpq_1
X_11438_ _11439_/B _14240_/Q _14272_/Q _14304_/Q _14336_/Q _12105_/A1 _12103_/B1 VDD
+ VSS sg13g2_mux4_1
XFILLER_172_669 VDD VSS sg13g2_decap_8
XFILLER_158_1452 VDD VSS sg13g2_decap_8
XFILLER_153_872 VDD VSS sg13g2_decap_8
X_14039__2163 _14039_/RESET_B VDD VSS sg13g2_tiehi
X_14157_ _14157_/Q _14637_/CLK _14157_/D _14157_/RESET_B VDD VSS sg13g2_dfrbpq_1
XFILLER_67_1346 VDD VSS sg13g2_decap_8
XFILLER_153_883 VDD VSS sg13g2_fill_2
X_11369_ _11369_/Y _11367_/Y _11366_/Y _11359_/B _11368_/X VDD VSS sg13g2_a22oi_1
XFILLER_28_1308 VDD VSS sg13g2_decap_8
XFILLER_113_725 VDD VSS sg13g2_decap_8
XFILLER_125_585 VDD VSS sg13g2_decap_8
XFILLER_4_882 VDD VSS sg13g2_decap_8
XFILLER_180_691 VDD VSS sg13g2_fill_1
XFILLER_112_224 VDD VSS sg13g2_fill_1
XFILLER_154_1338 VDD VSS sg13g2_decap_8
X_13108_ _13108_/Y _14786_/Q _13164_/A2 _13275_/B1 VDD VSS sg13g2_o21ai_1
XFILLER_98_447 VDD VSS sg13g2_decap_8
X_14088_ _14088_/Q _14728_/CLK _14088_/D _14088_/RESET_B VDD VSS sg13g2_dfrbpq_1
X_13039_ _13057_/C _14909_/Q _13678_/Q VDD VSS sg13g2_nand2_1
XFILLER_67_812 VDD VSS sg13g2_decap_8
XFILLER_117_1171 VDD VSS sg13g2_decap_8
XFILLER_113_1024 VDD VSS sg13g2_decap_8
Xfanout1160 _08362_/A3 _11591_/A VDD VSS sg13g2_buf_1
Xfanout1171 _08219_/A _08278_/A3 VDD VSS sg13g2_buf_1
XFILLER_94_642 VDD VSS sg13g2_decap_8
XFILLER_6_1159 VDD VSS sg13g2_decap_8
Xfanout1182 _11428_/A _14961_/Q VDD VSS sg13g2_buf_1
Xfanout1193 _12900_/C _11290_/A VDD VSS sg13g2_buf_1
XFILLER_67_889 VDD VSS sg13g2_decap_8
XFILLER_93_152 VDD VSS sg13g2_decap_8
XFILLER_96_1019 VDD VSS sg13g2_decap_8
XFILLER_82_826 VDD VSS sg13g2_decap_8
X_08580_ _08581_/B _08641_/D _08578_/Y _08579_/Y VDD VSS sg13g2_o21ai_1
XFILLER_81_314 VDD VSS sg13g2_decap_8
XFILLER_130_1371 VDD VSS sg13g2_decap_8
XFILLER_19_271 VDD VSS sg13g2_decap_8
XFILLER_81_325 VDD VSS sg13g2_fill_1
XFILLER_78_1464 VDD VSS sg13g2_decap_8
XFILLER_74_1317 VDD VSS sg13g2_decap_8
XFILLER_165_1434 VDD VSS sg13g2_decap_8
XFILLER_39_1448 VDD VSS sg13g2_decap_8
XFILLER_62_572 VDD VSS sg13g2_fill_2
XFILLER_34_263 VDD VSS sg13g2_decap_4
X_09201_ _13817_/D _13817_/Q _10168_/A1 _09202_/S VDD VSS sg13g2_mux2_1
XFILLER_179_279 VDD VSS sg13g2_decap_8
XFILLER_10_609 VDD VSS sg13g2_decap_8
XFILLER_37_1161 VDD VSS sg13g2_decap_8
XFILLER_50_789 VDD VSS sg13g2_decap_8
XFILLER_31_970 VDD VSS sg13g2_decap_8
X_09132_ _13781_/D _13781_/Q _09899_/A0 _09153_/S VDD VSS sg13g2_mux2_1
XFILLER_33_1025 VDD VSS sg13g2_decap_8
XFILLER_124_1142 VDD VSS sg13g2_decap_8
XFILLER_163_1191 VDD VSS sg13g2_decap_8
XFILLER_148_644 VDD VSS sg13g2_decap_8
XFILLER_176_953 VDD VSS sg13g2_fill_1
X_14249__1953 _14249_/RESET_B VDD VSS sg13g2_tiehi
XFILLER_33_1036 VDD VSS sg13g2_fill_2
XFILLER_147_143 VDD VSS sg13g2_decap_8
X_15147__2686 _15147_/RESET_B VDD VSS sg13g2_tiehi
XFILLER_120_1028 VDD VSS sg13g2_decap_8
XFILLER_136_828 VDD VSS sg13g2_decap_8
X_09063_ _09063_/X _09069_/A _09060_/X _09062_/Y VDD VSS sg13g2_a21o_1
XFILLER_135_305 VDD VSS sg13g2_decap_8
XFILLER_135_316 VDD VSS sg13g2_fill_1
XFILLER_162_102 VDD VSS sg13g2_decap_8
XFILLER_159_1227 VDD VSS sg13g2_decap_8
XFILLER_50_1372 VDD VSS sg13g2_decap_8
X_08014_ _08014_/Y _08011_/X _08599_/B VDD VSS sg13g2_nand2b_1
XFILLER_11_1345 VDD VSS sg13g2_decap_8
XFILLER_102_1473 VDD VSS sg13g2_decap_4
XFILLER_2_819 VDD VSS sg13g2_decap_8
XFILLER_85_1446 VDD VSS sg13g2_decap_8
XFILLER_1_329 VDD VSS sg13g2_decap_8
XFILLER_143_393 VDD VSS sg13g2_decap_4
XFILLER_172_1438 VDD VSS sg13g2_decap_8
X_09965_ _14549_/D _14549_/Q _10097_/A0 _09969_/S VDD VSS sg13g2_mux2_1
X_08916_ _08916_/Y _08835_/A _08835_/B _16873_/A VDD VSS sg13g2_a21oi_1
XFILLER_112_780 VDD VSS sg13g2_decap_8
X_09896_ _14482_/D _09929_/A1 _14482_/Q _09903_/S VDD VSS sg13g2_mux2_1
XFILLER_94_18 VDD VSS sg13g2_decap_8
XFILLER_44_1165 VDD VSS sg13g2_decap_8
XFILLER_85_631 VDD VSS sg13g2_decap_8
XFILLER_69_182 VDD VSS sg13g2_fill_2
XFILLER_100_964 VDD VSS sg13g2_decap_8
X_08847_ _13694_/D _16856_/A _08846_/Y _08861_/S VDD VSS sg13g2_mux2_1
XFILLER_40_1029 VDD VSS sg13g2_decap_8
XFILLER_131_1168 VDD VSS sg13g2_fill_2
X_13737__2465 _13737_/RESET_B VDD VSS sg13g2_tiehi
XFILLER_17_219 VDD VSS sg13g2_decap_8
XFILLER_79_1239 VDD VSS sg13g2_decap_8
XFILLER_73_837 VDD VSS sg13g2_decap_8
XFILLER_150_24 VDD VSS sg13g2_decap_8
X_08778_ _08778_/Y _13678_/Q _08787_/B VDD VSS sg13g2_nor2_1
XFILLER_84_185 VDD VSS sg13g2_decap_4
X_07729_ _07742_/B _15105_/Q _13051_/B _13106_/B _13249_/B VDD VSS sg13g2_nor4_1
XFILLER_26_742 VDD VSS sg13g2_decap_8
XFILLER_72_369 VDD VSS sg13g2_decap_8
XFILLER_13_403 VDD VSS sg13g2_decap_8
XFILLER_168_1091 VDD VSS sg13g2_decap_4
X_10740_ _11033_/B _10740_/A1 _09079_/Y _08907_/Y VDD VSS sg13g2_o21ai_1
XFILLER_81_881 VDD VSS sg13g2_decap_8
XFILLER_43_11 VDD VSS sg13g2_decap_8
XFILLER_25_263 VDD VSS sg13g2_decap_8
XFILLER_41_723 VDD VSS sg13g2_fill_2
XFILLER_26_797 VDD VSS sg13g2_decap_8
X_14117__2085 _14117_/RESET_B VDD VSS sg13g2_tiehi
XFILLER_41_756 VDD VSS sg13g2_fill_2
XFILLER_186_728 VDD VSS sg13g2_decap_8
X_13952__2250 _13952_/RESET_B VDD VSS sg13g2_tiehi
XFILLER_90_1130 VDD VSS sg13g2_decap_8
X_10671_ _10671_/Y _13300_/B _13356_/B VDD VSS sg13g2_nand2b_1
XFILLER_40_244 VDD VSS sg13g2_decap_8
XFILLER_107_1340 VDD VSS sg13g2_decap_8
XFILLER_55_1272 VDD VSS sg13g2_decap_8
XFILLER_142_1231 VDD VSS sg13g2_decap_4
XFILLER_185_238 VDD VSS sg13g2_decap_8
X_12410_ _12410_/X _13823_/Q _13855_/Q _13887_/Q _13919_/Q _12411_/S0 _12411_/S1 VDD
+ VSS sg13g2_mux4_1
XFILLER_139_633 VDD VSS sg13g2_decap_8
XFILLER_159_77 VDD VSS sg13g2_decap_8
XFILLER_166_430 VDD VSS sg13g2_decap_8
XFILLER_178_290 VDD VSS sg13g2_decap_8
X_13390_ _15083_/D _15083_/Q _13390_/A2 _13389_/Y VDD VSS sg13g2_a21o_1
XFILLER_139_666 VDD VSS sg13g2_decap_8
XFILLER_16_1267 VDD VSS sg13g2_decap_8
XFILLER_51_1158 VDD VSS sg13g2_decap_8
X_12341_ _14988_/D _12302_/Y _12340_/Y _12298_/Y VDD VSS sg13g2_a21oi_1
XFILLER_5_602 VDD VSS sg13g2_decap_8
XFILLER_166_485 VDD VSS sg13g2_decap_8
XFILLER_153_102 VDD VSS sg13g2_decap_8
XFILLER_154_647 VDD VSS sg13g2_decap_8
XFILLER_175_32 VDD VSS sg13g2_decap_8
XFILLER_177_1338 VDD VSS sg13g2_decap_8
X_15060_ _15060_/Q clkload73/A _15060_/D _15060_/RESET_B VDD VSS sg13g2_dfrbpq_1
XFILLER_4_112 VDD VSS sg13g2_decap_8
XFILLER_126_349 VDD VSS sg13g2_decap_4
X_12272_ _12273_/A _12272_/A _12231_/A VDD VSS sg13g2_nor2b_1
XFILLER_142_809 VDD VSS sg13g2_decap_8
XFILLER_181_466 VDD VSS sg13g2_decap_8
X_14011_ _14011_/Q clkload79/A _14011_/D _14011_/RESET_B VDD VSS sg13g2_dfrbpq_1
X_11223_ _11224_/C _11231_/S _11223_/B _11223_/C VDD VSS sg13g2_nor3_1
XFILLER_5_679 VDD VSS sg13g2_decap_8
XFILLER_141_319 VDD VSS sg13g2_fill_2
XFILLER_181_488 VDD VSS sg13g2_decap_8
XFILLER_175_1051 VDD VSS sg13g2_decap_8
XFILLER_49_1054 VDD VSS sg13g2_fill_1
XFILLER_162_691 VDD VSS sg13g2_decap_8
XFILLER_4_189 VDD VSS sg13g2_decap_8
XFILLER_4_49 VDD VSS sg13g2_decap_8
XFILLER_122_544 VDD VSS sg13g2_decap_8
X_11154_ _11154_/Y _11206_/B1 _11180_/C _11154_/B1 VDD VSS sg13g2_o21ai_1
XFILLER_136_1046 VDD VSS sg13g2_decap_8
XFILLER_161_190 VDD VSS sg13g2_decap_8
XFILLER_136_1057 VDD VSS sg13g2_fill_1
XFILLER_110_717 VDD VSS sg13g2_fill_2
X_10105_ _10105_/X _10105_/A _10105_/B _10105_/C _10105_/D VDD VSS sg13g2_and4_1
XFILLER_27_1341 VDD VSS sg13g2_decap_8
XFILLER_89_981 VDD VSS sg13g2_decap_4
X_11085_ _11085_/Y _11172_/A _11115_/A VDD VSS sg13g2_nor2_1
XFILLER_7_1435 VDD VSS sg13g2_decap_8
XFILLER_62_1243 VDD VSS sg13g2_decap_8
XFILLER_1_896 VDD VSS sg13g2_decap_8
XFILLER_76_620 VDD VSS sg13g2_decap_8
XFILLER_68_96 VDD VSS sg13g2_decap_8
XFILLER_23_1227 VDD VSS sg13g2_decap_8
XFILLER_153_1393 VDD VSS sg13g2_decap_8
X_14913_ _14913_/Q clkload69/A _14913_/D _14913_/RESET_B VDD VSS sg13g2_dfrbpq_1
X_10036_ _14618_/D _10102_/A0 _14618_/Q _10036_/S VDD VSS sg13g2_mux2_1
XFILLER_76_642 VDD VSS sg13g2_fill_2
XFILLER_114_1355 VDD VSS sg13g2_decap_8
XFILLER_64_815 VDD VSS sg13g2_fill_1
XFILLER_75_152 VDD VSS sg13g2_decap_8
XFILLER_1_1001 VDD VSS sg13g2_decap_8
X_14327__1875 _14327_/RESET_B VDD VSS sg13g2_tiehi
X_14844_ _14844_/Q _14848_/CLK _14844_/D _14844_/RESET_B VDD VSS sg13g2_dfrbpq_1
XFILLER_36_539 VDD VSS sg13g2_decap_8
XFILLER_84_84 VDD VSS sg13g2_decap_8
Xclkbuf_5_10__f_clk_i clkbuf_leaf_28_clk_i/A clkbuf_4_5_0_clk_i/X VDD VSS sg13g2_buf_16
X_14775_ _14775_/Q _15185_/CLK _14775_/D _14775_/RESET_B VDD VSS sg13g2_dfrbpq_1
XFILLER_63_369 VDD VSS sg13g2_fill_1
X_11987_ _11989_/B _11936_/A _13129_/B _11988_/B VDD VSS sg13g2_o21ai_1
XFILLER_1_1078 VDD VSS sg13g2_decap_8
X_13726_ _13726_/Q clkload60/A _13726_/D _13726_/RESET_B VDD VSS sg13g2_dfrbpq_1
XFILLER_44_583 VDD VSS sg13g2_decap_8
XFILLER_182_1033 VDD VSS sg13g2_fill_1
X_10938_ _10938_/Y _10937_/Y _11014_/A _10935_/Y _10934_/Y _11045_/A2 VDD VSS sg13g2_a221oi_1
XFILLER_56_1036 VDD VSS sg13g2_fill_2
XFILLER_71_380 VDD VSS sg13g2_decap_8
XFILLER_143_1006 VDD VSS sg13g2_decap_4
XFILLER_147_1186 VDD VSS sg13g2_decap_8
XFILLER_149_408 VDD VSS sg13g2_decap_8
XFILLER_32_756 VDD VSS sg13g2_decap_8
X_13657_ _13657_/Q clkload65/A _13657_/D _13657_/RESET_B VDD VSS sg13g2_dfrbpq_1
X_14542__1660 _14542_/RESET_B VDD VSS sg13g2_tiehi
X_10869_ _10869_/Y _11043_/A _10869_/B VDD VSS sg13g2_nor2_1
XFILLER_20_929 VDD VSS sg13g2_decap_8
XFILLER_13_970 VDD VSS sg13g2_decap_8
XFILLER_34_1334 VDD VSS sg13g2_decap_8
XFILLER_31_277 VDD VSS sg13g2_fill_1
XFILLER_125_1462 VDD VSS sg13g2_decap_8
X_12608_ _12608_/X _12602_/X _12606_/X _12601_/X _12605_/X _12608_/S0 _12608_/S1 VDD
+ VSS sg13g2_mux4_1
XFILLER_160_1353 VDD VSS sg13g2_decap_8
X_13588_ _15161_/D _13587_/B _13586_/Y _13587_/Y VDD VSS sg13g2_a21oi_1
XFILLER_9_952 VDD VSS sg13g2_decap_8
XFILLER_173_901 VDD VSS sg13g2_decap_4
XFILLER_121_1326 VDD VSS sg13g2_decap_8
XFILLER_30_1209 VDD VSS sg13g2_decap_8
XFILLER_121_1337 VDD VSS sg13g2_fill_1
XFILLER_129_165 VDD VSS sg13g2_decap_4
X_14796__2940 _14796_/RESET_B VDD VSS sg13g2_tiehi
X_12539_ _12539_/X _12537_/X _12538_/X _12623_/S VDD VSS sg13g2_mux2_1
XFILLER_185_794 VDD VSS sg13g2_decap_8
XFILLER_8_473 VDD VSS sg13g2_decap_8
XFILLER_129_187 VDD VSS sg13g2_fill_1
XFILLER_145_636 VDD VSS sg13g2_fill_1
XFILLER_184_282 VDD VSS sg13g2_decap_8
XFILLER_117_349 VDD VSS sg13g2_fill_1
XFILLER_67_1110 VDD VSS sg13g2_decap_4
XFILLER_172_466 VDD VSS sg13g2_decap_8
X_13815__2387 _13815_/RESET_B VDD VSS sg13g2_tiehi
X_14209_ _14209_/Q clkload9/A _14209_/D _14209_/RESET_B VDD VSS sg13g2_dfrbpq_1
XFILLER_99_712 VDD VSS sg13g2_decap_8
XFILLER_67_1143 VDD VSS sg13g2_decap_8
X_15189_ _15189_/Q _15214_/CLK _15189_/D _15189_/RESET_B VDD VSS sg13g2_dfrbpq_1
XFILLER_141_831 VDD VSS sg13g2_decap_8
XFILLER_119_1244 VDD VSS sg13g2_fill_1
XFILLER_140_330 VDD VSS sg13g2_decap_8
Xfanout408 _09084_/S _08965_/Y VDD VSS sg13g2_buf_1
Xfanout419 _11181_/A _10785_/Y VDD VSS sg13g2_buf_1
XFILLER_141_875 VDD VSS sg13g2_decap_8
XFILLER_80_1321 VDD VSS sg13g2_decap_8
X_13994__2208 _13994_/RESET_B VDD VSS sg13g2_tiehi
X_09750_ _14340_/D _14340_/Q _09882_/A0 _09758_/S VDD VSS sg13g2_mux2_1
XFILLER_86_428 VDD VSS sg13g2_decap_8
XFILLER_45_1452 VDD VSS sg13g2_decap_8
XFILLER_132_1411 VDD VSS sg13g2_decap_8
XFILLER_100_227 VDD VSS sg13g2_decap_8
X_08701_ _08701_/Y _07835_/Y _08699_/Y _08588_/B VDD VSS sg13g2_o21ai_1
XFILLER_67_642 VDD VSS sg13g2_decap_8
XFILLER_41_1327 VDD VSS sg13g2_decap_8
X_09681_ _14273_/D _09714_/A0 _14273_/Q _09696_/S VDD VSS sg13g2_mux2_1
XFILLER_104_28 VDD VSS sg13g2_decap_8
XFILLER_55_804 VDD VSS sg13g2_decap_4
XFILLER_80_1398 VDD VSS sg13g2_decap_8
XFILLER_67_664 VDD VSS sg13g2_decap_8
XFILLER_132_1477 VDD VSS sg13g2_fill_2
XFILLER_95_984 VDD VSS sg13g2_fill_1
XFILLER_94_461 VDD VSS sg13g2_decap_8
X_08632_ _08633_/A _08641_/A _08630_/Y _08631_/Y VDD VSS sg13g2_o21ai_1
XFILLER_95_995 VDD VSS sg13g2_fill_2
XFILLER_54_325 VDD VSS sg13g2_decap_8
X_08563_ _08563_/Y _08621_/A _08407_/Y _08562_/Y VDD VSS sg13g2_a21oi_1
XFILLER_70_818 VDD VSS sg13g2_decap_8
XFILLER_78_1261 VDD VSS sg13g2_decap_8
XFILLER_165_1231 VDD VSS sg13g2_decap_8
XFILLER_23_712 VDD VSS sg13g2_fill_2
XFILLER_39_1245 VDD VSS sg13g2_decap_8
X_08494_ _08494_/Y _08494_/A _08494_/B VDD VSS sg13g2_nor2_1
XFILLER_11_918 VDD VSS sg13g2_decap_8
XFILLER_161_1128 VDD VSS sg13g2_decap_8
XFILLER_50_564 VDD VSS sg13g2_decap_8
XFILLER_10_406 VDD VSS sg13g2_decap_8
XFILLER_13_25 VDD VSS sg13g2_decap_8
XFILLER_52_1445 VDD VSS sg13g2_decap_8
XFILLER_50_597 VDD VSS sg13g2_decap_8
XFILLER_13_1418 VDD VSS sg13g2_decap_8
XFILLER_136_603 VDD VSS sg13g2_decap_8
X_09115_ _09117_/B _13156_/A _09150_/B _13189_/A VDD VSS sg13g2_a21o_1
XFILLER_108_305 VDD VSS sg13g2_fill_1
XFILLER_164_967 VDD VSS sg13g2_fill_2
XFILLER_175_293 VDD VSS sg13g2_decap_8
X_09046_ _13768_/D _13768_/Q _10084_/A0 _09084_/S VDD VSS sg13g2_mux2_1
XFILLER_135_135 VDD VSS sg13g2_fill_2
XFILLER_117_850 VDD VSS sg13g2_decap_8
XFILLER_11_1142 VDD VSS sg13g2_decap_8
XFILLER_151_617 VDD VSS sg13g2_decap_8
XFILLER_89_1390 VDD VSS sg13g2_decap_8
X_14405__1797 _14405_/RESET_B VDD VSS sg13g2_tiehi
XFILLER_85_1232 VDD VSS sg13g2_decap_8
XFILLER_2_616 VDD VSS sg13g2_decap_8
XFILLER_116_371 VDD VSS sg13g2_decap_8
XFILLER_144_680 VDD VSS sg13g2_decap_8
XFILLER_1_126 VDD VSS sg13g2_decap_8
XFILLER_137_1344 VDD VSS sg13g2_decap_8
XFILLER_78_907 VDD VSS sg13g2_decap_8
XFILLER_172_1235 VDD VSS sg13g2_decap_8
XFILLER_133_1208 VDD VSS sg13g2_decap_4
Xfanout920 _13312_/A _13048_/B VDD VSS sg13g2_buf_1
XFILLER_131_363 VDD VSS sg13g2_decap_8
Xfanout931 _13303_/A _15207_/Q VDD VSS sg13g2_buf_1
XFILLER_49_119 VDD VSS sg13g2_decap_8
Xfanout942 _13592_/A2 _13558_/B VDD VSS sg13g2_buf_1
X_09948_ _14532_/D _14532_/Q _10147_/A1 _09964_/S VDD VSS sg13g2_mux2_1
XFILLER_38_11 VDD VSS sg13g2_decap_8
Xfanout953 _13459_/B _15200_/Q VDD VSS sg13g2_buf_1
XFILLER_89_299 VDD VSS sg13g2_fill_2
X_14584__1618 _14584_/RESET_B VDD VSS sg13g2_tiehi
Xfanout964 _12348_/A _15125_/Q VDD VSS sg13g2_buf_1
XFILLER_86_940 VDD VSS sg13g2_decap_8
Xfanout975 _13234_/B _13150_/B VDD VSS sg13g2_buf_1
XFILLER_135_1090 VDD VSS sg13g2_decap_8
Xfanout986 _08190_/A _08229_/B VDD VSS sg13g2_buf_1
X_14620__1582 _14620_/RESET_B VDD VSS sg13g2_tiehi
Xfanout997 _11139_/B1 _07720_/C VDD VSS sg13g2_buf_1
X_09879_ _14465_/D _09912_/A1 _14465_/Q _09894_/S VDD VSS sg13g2_mux2_1
XFILLER_18_506 VDD VSS sg13g2_decap_8
XFILLER_86_984 VDD VSS sg13g2_fill_1
XFILLER_58_675 VDD VSS sg13g2_decap_8
XFILLER_161_56 VDD VSS sg13g2_decap_8
XFILLER_86_995 VDD VSS sg13g2_decap_8
XFILLER_100_783 VDD VSS sg13g2_decap_8
X_11910_ _12056_/B _11910_/A _11910_/B _11910_/C VDD VSS sg13g2_nor3_1
XFILLER_46_848 VDD VSS sg13g2_decap_8
X_12890_ _12894_/A _12875_/Y _12861_/A _12889_/Y VDD VSS sg13g2_o21ai_1
XFILLER_72_111 VDD VSS sg13g2_decap_8
XFILLER_45_336 VDD VSS sg13g2_decap_8
XFILLER_79_1058 VDD VSS sg13g2_decap_8
XFILLER_166_1017 VDD VSS sg13g2_decap_4
XFILLER_22_1293 VDD VSS sg13g2_decap_8
X_11841_ _11845_/C _11770_/A _13064_/B _13676_/Q _11798_/A _11779_/Y VDD VSS sg13g2_a221oi_1
XFILLER_96_1350 VDD VSS sg13g2_decap_8
XFILLER_2_1365 VDD VSS sg13g2_decap_8
XFILLER_73_678 VDD VSS sg13g2_decap_4
XFILLER_14_701 VDD VSS sg13g2_decap_8
XFILLER_72_166 VDD VSS sg13g2_decap_8
XFILLER_60_306 VDD VSS sg13g2_decap_8
XFILLER_60_317 VDD VSS sg13g2_decap_8
XFILLER_109_1413 VDD VSS sg13g2_decap_4
XFILLER_13_200 VDD VSS sg13g2_decap_8
X_14560_ _14560_/Q clkload24/A _14560_/D _14560_/RESET_B VDD VSS sg13g2_dfrbpq_1
X_11772_ _11772_/Y _14971_/Q _13679_/Q _13678_/Q _11726_/A _11771_/Y VDD VSS sg13g2_a221oi_1
XFILLER_57_1345 VDD VSS sg13g2_decap_8
XFILLER_144_1304 VDD VSS sg13g2_fill_1
XFILLER_54_87 VDD VSS sg13g2_fill_2
XFILLER_18_1329 VDD VSS sg13g2_decap_8
X_13511_ _15134_/D _15134_/Q _13525_/A _13515_/S VDD VSS sg13g2_mux2_1
X_10723_ _10724_/A _14908_/Q _10973_/B _11056_/B1 _11015_/C VDD VSS sg13g2_a22oi_1
XFILLER_53_1209 VDD VSS sg13g2_decap_8
XFILLER_183_1386 VDD VSS sg13g2_decap_8
XFILLER_186_525 VDD VSS sg13g2_decap_8
X_14491_ _14491_/Q _14491_/CLK _14491_/D _14491_/RESET_B VDD VSS sg13g2_dfrbpq_1
XFILLER_110_71 VDD VSS sg13g2_decap_8
XFILLER_13_277 VDD VSS sg13g2_decap_8
XFILLER_110_82 VDD VSS sg13g2_decap_8
X_13442_ _13442_/Y _13442_/A _13442_/B _13444_/C VDD VSS sg13g2_nor3_1
X_10654_ _10663_/D _10654_/A _10654_/B VDD VSS sg13g2_nor2_1
XFILLER_155_901 VDD VSS sg13g2_fill_2
XFILLER_9_259 VDD VSS sg13g2_decap_8
XFILLER_16_1064 VDD VSS sg13g2_decap_8
XFILLER_173_208 VDD VSS sg13g2_decap_4
XFILLER_103_1023 VDD VSS sg13g2_decap_8
XFILLER_6_900 VDD VSS sg13g2_decap_8
XFILLER_154_400 VDD VSS sg13g2_decap_8
XFILLER_186_42 VDD VSS sg13g2_decap_8
X_13373_ _13444_/A _13401_/C _13401_/B _13438_/B VDD VSS sg13g2_nand3_1
XFILLER_10_973 VDD VSS sg13g2_decap_8
XFILLER_154_411 VDD VSS sg13g2_decap_8
XFILLER_167_794 VDD VSS sg13g2_decap_4
X_10585_ _14872_/D _10591_/C _10591_/D _10581_/Y VDD VSS sg13g2_a21oi_1
Xclkload18 clkload18/Y clkload18/A VDD VSS sg13g2_inv_2
XFILLER_155_956 VDD VSS sg13g2_decap_8
Xclkload29 clkload29/Y clkload29/A VDD VSS sg13g2_inv_1
XFILLER_126_124 VDD VSS sg13g2_fill_1
X_15112_ _15112_/Q _15165_/CLK _15112_/D _15112_/RESET_B VDD VSS sg13g2_dfrbpq_1
XFILLER_155_967 VDD VSS sg13g2_decap_8
X_12324_ _12324_/X _12324_/A _12324_/B VDD VSS sg13g2_and2_1
XFILLER_126_146 VDD VSS sg13g2_decap_4
XFILLER_177_1135 VDD VSS sg13g2_decap_8
XFILLER_182_764 VDD VSS sg13g2_fill_2
XFILLER_181_252 VDD VSS sg13g2_decap_8
XFILLER_6_977 VDD VSS sg13g2_decap_8
XFILLER_142_628 VDD VSS sg13g2_decap_4
XFILLER_154_488 VDD VSS sg13g2_fill_2
XFILLER_170_937 VDD VSS sg13g2_decap_8
X_15043_ _15043_/Q _15240_/CLK _15043_/D _15043_/RESET_B VDD VSS sg13g2_dfrbpq_1
X_15070__2888 _15070_/RESET_B VDD VSS sg13g2_tiehi
X_12255_ _12255_/Y _12186_/A _13880_/Q _12187_/C VDD VSS sg13g2_a21oi_1
XFILLER_5_476 VDD VSS sg13g2_decap_8
XFILLER_107_360 VDD VSS sg13g2_decap_4
XFILLER_154_499 VDD VSS sg13g2_decap_8
XFILLER_79_51 VDD VSS sg13g2_decap_8
XFILLER_135_680 VDD VSS sg13g2_fill_1
XFILLER_141_127 VDD VSS sg13g2_decap_8
X_11206_ _11206_/Y _11191_/A _11205_/X _11206_/B1 VDD VSS sg13g2_o21ai_1
XFILLER_64_1316 VDD VSS sg13g2_decap_8
XFILLER_29_1436 VDD VSS sg13g2_decap_8
XFILLER_141_149 VDD VSS sg13g2_fill_1
XFILLER_123_864 VDD VSS sg13g2_decap_8
X_12186_ _12187_/B _12186_/A _13942_/Q VDD VSS sg13g2_nand2_1
XFILLER_122_341 VDD VSS sg13g2_decap_4
XFILLER_155_1466 VDD VSS sg13g2_decap_4
XFILLER_151_1308 VDD VSS sg13g2_decap_8
XFILLER_116_1439 VDD VSS sg13g2_fill_2
X_11137_ _11152_/B _11163_/A _11190_/C VDD VSS sg13g2_nor2_1
XFILLER_122_396 VDD VSS sg13g2_decap_8
XFILLER_1_693 VDD VSS sg13g2_decap_8
XFILLER_7_1232 VDD VSS sg13g2_decap_8
XFILLER_135_90 VDD VSS sg13g2_decap_8
XFILLER_23_1002 VDD VSS sg13g2_decap_8
XFILLER_95_247 VDD VSS sg13g2_decap_4
XFILLER_23_1013 VDD VSS sg13g2_fill_1
XFILLER_23_1024 VDD VSS sg13g2_decap_8
X_11068_ _11097_/C _11068_/A _11068_/B _11068_/C VDD VSS sg13g2_nand3_1
XFILLER_49_653 VDD VSS sg13g2_decap_8
XFILLER_114_1163 VDD VSS sg13g2_decap_8
X_10019_ _14601_/D _10152_/A1 _14601_/Q _10023_/S VDD VSS sg13g2_mux2_1
XFILLER_95_94 VDD VSS sg13g2_fill_1
XFILLER_92_921 VDD VSS sg13g2_fill_1
XFILLER_64_612 VDD VSS sg13g2_decap_8
XFILLER_48_163 VDD VSS sg13g2_fill_2
XFILLER_63_100 VDD VSS sg13g2_fill_2
XFILLER_110_1038 VDD VSS sg13g2_decap_4
X_14827_ _14827_/Q clkload86/A _14827_/D _14827_/RESET_B VDD VSS sg13g2_dfrbpq_1
XFILLER_40_1382 VDD VSS sg13g2_decap_8
XFILLER_36_358 VDD VSS sg13g2_decap_8
XFILLER_184_1128 VDD VSS sg13g2_decap_8
XFILLER_24_509 VDD VSS sg13g2_decap_8
XFILLER_75_1412 VDD VSS sg13g2_decap_8
XFILLER_149_1259 VDD VSS sg13g2_decap_4
XFILLER_45_881 VDD VSS sg13g2_fill_2
X_14758_ _14758_/Q clkload63/A _14758_/D _14758_/RESET_B VDD VSS sg13g2_dfrbpq_1
XFILLER_36_1418 VDD VSS sg13g2_decap_8
X_13709_ _16871_/A _14602_/CLK _13709_/D _13709_/RESET_B VDD VSS sg13g2_dfrbpq_1
XFILLER_162_1437 VDD VSS sg13g2_decap_8
XFILLER_177_536 VDD VSS sg13g2_decap_8
X_14689_ _14689_/Q clkload10/A _14689_/D _14689_/RESET_B VDD VSS sg13g2_dfrbpq_1
XFILLER_20_726 VDD VSS sg13g2_decap_8
XFILLER_34_1131 VDD VSS sg13g2_decap_8
XFILLER_160_1150 VDD VSS sg13g2_decap_8
XFILLER_118_614 VDD VSS sg13g2_decap_8
XFILLER_117_113 VDD VSS sg13g2_decap_8
XFILLER_8_270 VDD VSS sg13g2_decap_8
XFILLER_69_1227 VDD VSS sg13g2_decap_8
XFILLER_121_1189 VDD VSS sg13g2_decap_8
XFILLER_173_775 VDD VSS sg13g2_decap_8
XFILLER_156_1208 VDD VSS sg13g2_decap_8
XFILLER_145_488 VDD VSS sg13g2_decap_8
XFILLER_172_296 VDD VSS sg13g2_decap_8
XFILLER_5_70 VDD VSS sg13g2_decap_8
Xfanout205 _09626_/A0 _09925_/A1 VDD VSS sg13g2_buf_1
XFILLER_113_352 VDD VSS sg13g2_decap_8
Xfanout216 _10088_/A0 _09070_/Y VDD VSS sg13g2_buf_1
XFILLER_82_1449 VDD VSS sg13g2_decap_8
Xfanout227 _10153_/A1 _10086_/A0 VDD VSS sg13g2_buf_1
X_09802_ _14391_/D _09934_/A1 _14391_/Q _09804_/S VDD VSS sg13g2_mux2_1
XFILLER_99_586 VDD VSS sg13g2_fill_1
Xfanout238 _11723_/A2 _11768_/B1 VDD VSS sg13g2_buf_1
XFILLER_115_38 VDD VSS sg13g2_decap_8
Xfanout249 _09919_/A1 fanout250/X VDD VSS sg13g2_buf_1
X_07994_ _07994_/X _15100_/Q _15089_/Q VDD VSS sg13g2_or2_1
XFILLER_113_396 VDD VSS sg13g2_decap_8
X_09733_ _14324_/D _10096_/A0 _14324_/Q _09733_/S VDD VSS sg13g2_mux2_1
XFILLER_68_962 VDD VSS sg13g2_decap_8
XFILLER_86_269 VDD VSS sg13g2_decap_8
XFILLER_132_1263 VDD VSS sg13g2_fill_1
XFILLER_83_910 VDD VSS sg13g2_decap_8
XFILLER_83_921 VDD VSS sg13g2_fill_1
XFILLER_27_314 VDD VSS sg13g2_decap_8
X_09664_ _14257_/D _09895_/A0 _14257_/Q _09672_/S VDD VSS sg13g2_mux2_1
XFILLER_167_1304 VDD VSS sg13g2_decap_8
XFILLER_83_965 VDD VSS sg13g2_decap_4
X_15045__2558 _15045_/RESET_B VDD VSS sg13g2_tiehi
X_08615_ _15244_/D _08615_/A _08615_/B _08615_/C VDD VSS sg13g2_nand3_1
XFILLER_83_976 VDD VSS sg13g2_decap_8
XFILLER_131_48 VDD VSS sg13g2_decap_8
X_09595_ _14192_/D _14192_/Q _09762_/A1 _09599_/S VDD VSS sg13g2_mux2_1
XFILLER_70_615 VDD VSS sg13g2_fill_2
X_08546_ _08546_/Y _13566_/A _11983_/A _08529_/Y VDD VSS sg13g2_o21ai_1
XFILLER_23_520 VDD VSS sg13g2_fill_2
XFILLER_78_1091 VDD VSS sg13g2_decap_8
XFILLER_126_1012 VDD VSS sg13g2_decap_8
XFILLER_24_35 VDD VSS sg13g2_decap_8
X_08477_ _08477_/Y _08443_/Y _07807_/C _08476_/Y VDD VSS sg13g2_a21oi_1
XFILLER_51_862 VDD VSS sg13g2_decap_8
XFILLER_39_1075 VDD VSS sg13g2_decap_4
XFILLER_11_704 VDD VSS sg13g2_decap_8
XFILLER_24_57 VDD VSS sg13g2_fill_2
XFILLER_10_203 VDD VSS sg13g2_decap_8
XFILLER_50_372 VDD VSS sg13g2_decap_8
XFILLER_24_79 VDD VSS sg13g2_fill_1
XFILLER_138_6 VDD VSS sg13g2_fill_1
XFILLER_52_1242 VDD VSS sg13g2_decap_8
XFILLER_155_208 VDD VSS sg13g2_fill_2
XFILLER_13_1215 VDD VSS sg13g2_decap_8
XFILLER_136_400 VDD VSS sg13g2_decap_8
XFILLER_6_207 VDD VSS sg13g2_decap_8
XFILLER_108_113 VDD VSS sg13g2_fill_1
XFILLER_148_282 VDD VSS sg13g2_fill_1
XFILLER_178_1411 VDD VSS sg13g2_decap_8
X_14638__1564 _14638_/RESET_B VDD VSS sg13g2_tiehi
X_10370_ _14814_/D _10378_/D _10608_/B _10370_/C VDD VSS sg13g2_nor3_1
XFILLER_87_1349 VDD VSS sg13g2_decap_8
XFILLER_156_56 VDD VSS sg13g2_decap_8
XFILLER_174_1308 VDD VSS sg13g2_decap_8
X_09029_ _09031_/C _14905_/Q _12957_/A _10702_/A _09030_/D VDD VSS sg13g2_and4_1
XFILLER_40_89 VDD VSS sg13g2_decap_8
XFILLER_3_914 VDD VSS sg13g2_decap_8
XFILLER_2_413 VDD VSS sg13g2_decap_8
XFILLER_123_127 VDD VSS sg13g2_fill_2
X_12040_ _12040_/Y _12040_/A1 _14226_/Q _12233_/B VDD VSS sg13g2_a21oi_1
XFILLER_6_4 VDD VSS sg13g2_decap_8
XFILLER_85_1073 VDD VSS sg13g2_decap_4
XFILLER_49_21 VDD VSS sg13g2_decap_8
XFILLER_172_1032 VDD VSS sg13g2_fill_2
XFILLER_172_11 VDD VSS sg13g2_decap_8
XFILLER_104_363 VDD VSS sg13g2_decap_8
XFILLER_77_203 VDD VSS sg13g2_decap_8
XFILLER_160_992 VDD VSS sg13g2_decap_8
XFILLER_46_1068 VDD VSS sg13g2_decap_8
XFILLER_133_1038 VDD VSS sg13g2_fill_1
Xfanout750 _13412_/C _13307_/B VDD VSS sg13g2_buf_1
XFILLER_78_759 VDD VSS sg13g2_decap_8
XFILLER_49_98 VDD VSS sg13g2_decap_8
Xclkbuf_leaf_60_clk_i clkload77/A clkbuf_leaf_60_clk_i/A VDD VSS sg13g2_buf_8
Xfanout761 _08198_/S _08199_/B VDD VSS sg13g2_buf_1
XFILLER_150_1330 VDD VSS sg13g2_fill_1
Xfanout772 _08544_/C _08617_/A VDD VSS sg13g2_buf_1
XFILLER_59_962 VDD VSS sg13g2_decap_8
XFILLER_24_1333 VDD VSS sg13g2_decap_8
XFILLER_115_1461 VDD VSS sg13g2_decap_8
XFILLER_172_88 VDD VSS sg13g2_decap_8
XFILLER_1_28 VDD VSS sg13g2_decap_8
X_13991_ _13991_/Q clkload13/A _13991_/D _13991_/RESET_B VDD VSS sg13g2_dfrbpq_1
Xfanout783 _08649_/S _07612_/Y VDD VSS sg13g2_buf_1
XFILLER_63_1393 VDD VSS sg13g2_decap_8
XFILLER_111_1303 VDD VSS sg13g2_fill_2
Xfanout794 _12567_/S _12705_/S1 VDD VSS sg13g2_buf_1
XFILLER_19_826 VDD VSS sg13g2_decap_8
XFILLER_46_612 VDD VSS sg13g2_decap_8
XFILLER_111_1325 VDD VSS sg13g2_fill_2
XFILLER_18_314 VDD VSS sg13g2_fill_2
X_12942_ _12988_/B _14903_/Q _12942_/B VDD VSS sg13g2_xnor2_1
XFILLER_4_1449 VDD VSS sg13g2_decap_8
XFILLER_92_239 VDD VSS sg13g2_fill_2
XFILLER_185_1404 VDD VSS sg13g2_decap_8
XFILLER_171_0 VDD VSS sg13g2_decap_8
XFILLER_18_347 VDD VSS sg13g2_decap_8
XFILLER_98_1467 VDD VSS sg13g2_decap_8
XFILLER_98_1478 VDD VSS sg13g2_fill_1
XFILLER_59_1429 VDD VSS sg13g2_decap_8
X_12873_ _12877_/C _14899_/Q _13688_/Q VDD VSS sg13g2_xor2_1
XFILLER_65_86 VDD VSS sg13g2_decap_8
XFILLER_22_1090 VDD VSS sg13g2_decap_8
XFILLER_2_1162 VDD VSS sg13g2_decap_8
Xclkbuf_leaf_75_clk_i clkload85/A clkbuf_leaf_75_clk_i/A VDD VSS sg13g2_buf_8
X_14612_ _14612_/Q _15005_/CLK _14612_/D _14612_/RESET_B VDD VSS sg13g2_dfrbpq_1
XFILLER_60_103 VDD VSS sg13g2_fill_1
X_11824_ _11824_/Y _11826_/A1 _13868_/Q _11374_/C VDD VSS sg13g2_a21oi_1
XFILLER_92_1011 VDD VSS sg13g2_decap_8
XFILLER_45_199 VDD VSS sg13g2_decap_8
XFILLER_60_136 VDD VSS sg13g2_fill_1
XFILLER_57_1142 VDD VSS sg13g2_decap_8
XFILLER_18_1126 VDD VSS sg13g2_decap_8
X_14543_ _14543_/Q clkload34/A _14543_/D _14543_/RESET_B VDD VSS sg13g2_dfrbpq_1
X_11755_ _11755_/Y _11752_/Y _11754_/X _11559_/C VDD VSS sg13g2_o21ai_1
XFILLER_92_1066 VDD VSS sg13g2_fill_2
XFILLER_183_1183 VDD VSS sg13g2_decap_8
XFILLER_186_322 VDD VSS sg13g2_decap_8
XFILLER_81_63 VDD VSS sg13g2_decap_4
XFILLER_109_1265 VDD VSS sg13g2_fill_1
XFILLER_144_1145 VDD VSS sg13g2_decap_8
XFILLER_92_1077 VDD VSS sg13g2_decap_8
XFILLER_41_361 VDD VSS sg13g2_decap_8
XFILLER_109_1287 VDD VSS sg13g2_fill_2
X_10706_ _10706_/Y _12957_/A _10929_/B VDD VSS sg13g2_nand2_1
X_14474_ _14474_/Q clkload20/A _14474_/D _14474_/RESET_B VDD VSS sg13g2_dfrbpq_1
X_11686_ _11687_/A _14248_/Q _14280_/Q _14312_/Q _14344_/Q _11686_/S0 _11693_/C VDD
+ VSS sg13g2_mux4_1
XFILLER_122_1410 VDD VSS sg13g2_decap_8
XFILLER_146_219 VDD VSS sg13g2_decap_8
X_13425_ _13425_/Y _13469_/A _15130_/Q _13469_/C VDD VSS sg13g2_nand3_1
XFILLER_70_1364 VDD VSS sg13g2_decap_8
XFILLER_127_411 VDD VSS sg13g2_decap_8
XFILLER_186_399 VDD VSS sg13g2_decap_8
X_10637_ _14886_/D _10642_/C _10637_/B VDD VSS sg13g2_nor2_1
XFILLER_128_945 VDD VSS sg13g2_fill_2
XFILLER_10_770 VDD VSS sg13g2_decap_8
XFILLER_139_282 VDD VSS sg13g2_decap_8
X_13356_ _13361_/C _13499_/C _13356_/B _13507_/B VDD VSS sg13g2_nand3_1
X_10568_ _10591_/C _10579_/B _10579_/C VDD VSS sg13g2_and2_1
XFILLER_170_712 VDD VSS sg13g2_decap_8
Xclkbuf_leaf_13_clk_i _15005_/CLK clkload2/A VDD VSS sg13g2_buf_8
XFILLER_6_774 VDD VSS sg13g2_decap_8
XFILLER_154_274 VDD VSS sg13g2_decap_8
X_12307_ _12308_/B _12307_/A _12307_/B _12307_/C VDD VSS sg13g2_nand3_1
X_13287_ _13291_/B _13287_/A _13287_/B _13287_/C VDD VSS sg13g2_or3_1
X_13696__2506 _13696_/RESET_B VDD VSS sg13g2_tiehi
X_10499_ _14853_/D _10499_/A _10499_/B _10499_/C VDD VSS sg13g2_and3_1
XFILLER_5_273 VDD VSS sg13g2_decap_8
XFILLER_142_458 VDD VSS sg13g2_fill_1
X_15026_ _15026_/Q _15196_/CLK _15026_/D _15026_/RESET_B VDD VSS sg13g2_dfrbpq_1
XFILLER_130_609 VDD VSS sg13g2_decap_8
X_13732__2470 _13732_/RESET_B VDD VSS sg13g2_tiehi
X_12238_ _12239_/A _13976_/Q _14008_/Q _14040_/Q _14072_/Q _12017_/A _12236_/C VDD
+ VSS sg13g2_mux4_1
XFILLER_29_1233 VDD VSS sg13g2_decap_8
XFILLER_68_1293 VDD VSS sg13g2_decap_8
XFILLER_64_1124 VDD VSS sg13g2_fill_1
XFILLER_151_970 VDD VSS sg13g2_decap_8
XFILLER_69_715 VDD VSS sg13g2_fill_1
XFILLER_151_981 VDD VSS sg13g2_fill_1
XFILLER_123_683 VDD VSS sg13g2_decap_4
X_12169_ _12170_/B _12169_/A _12169_/B _12169_/C VDD VSS sg13g2_nand3_1
XFILLER_2_980 VDD VSS sg13g2_decap_8
XFILLER_122_171 VDD VSS sg13g2_fill_2
XFILLER_151_1116 VDD VSS sg13g2_decap_8
Xclkbuf_leaf_28_clk_i clkload35/A clkbuf_leaf_28_clk_i/A VDD VSS sg13g2_buf_8
XFILLER_111_867 VDD VSS sg13g2_decap_4
XFILLER_1_490 VDD VSS sg13g2_decap_8
XFILLER_42_1422 VDD VSS sg13g2_decap_8
XFILLER_96_567 VDD VSS sg13g2_decap_8
XFILLER_96_578 VDD VSS sg13g2_fill_2
X_14076__2126 _14076_/RESET_B VDD VSS sg13g2_tiehi
XFILLER_96_589 VDD VSS sg13g2_fill_2
Xinput5 input5/X input5/A VDD VSS sg13g2_buf_1
X_14112__2090 _14112_/RESET_B VDD VSS sg13g2_tiehi
XFILLER_110_399 VDD VSS sg13g2_decap_8
XFILLER_65_943 VDD VSS sg13g2_decap_8
XFILLER_76_280 VDD VSS sg13g2_decap_8
XFILLER_25_807 VDD VSS sg13g2_fill_2
XFILLER_149_1023 VDD VSS sg13g2_fill_2
XFILLER_25_818 VDD VSS sg13g2_fill_1
XFILLER_24_306 VDD VSS sg13g2_decap_4
XFILLER_91_261 VDD VSS sg13g2_fill_2
XFILLER_36_166 VDD VSS sg13g2_decap_8
X_08400_ _08400_/Y _08600_/B _08659_/A VDD VSS sg13g2_nor2b_1
XFILLER_64_486 VDD VSS sg13g2_decap_8
X_14716__1486 _14716_/RESET_B VDD VSS sg13g2_tiehi
X_09380_ _13983_/D _10075_/A0 _13983_/Q _09401_/S VDD VSS sg13g2_mux2_1
XFILLER_80_946 VDD VSS sg13g2_fill_1
XFILLER_64_497 VDD VSS sg13g2_fill_1
XFILLER_101_18 VDD VSS sg13g2_decap_8
XFILLER_149_1078 VDD VSS sg13g2_decap_8
XFILLER_52_659 VDD VSS sg13g2_fill_1
XFILLER_178_801 VDD VSS sg13g2_decap_8
XFILLER_51_136 VDD VSS sg13g2_decap_8
X_08331_ _08331_/Y _08147_/Y _08244_/B _08027_/Y VDD VSS sg13g2_a21oi_1
XFILLER_166_1381 VDD VSS sg13g2_decap_8
XFILLER_36_1215 VDD VSS sg13g2_decap_8
XFILLER_162_1234 VDD VSS sg13g2_decap_8
XFILLER_75_1286 VDD VSS sg13g2_decap_8
X_14832__2903 _14832_/RESET_B VDD VSS sg13g2_tiehi
X_08262_ _08262_/Y _08256_/Y _08257_/Y _08252_/Y _08334_/A1 _08261_/Y VDD VSS sg13g2_a221oi_1
XFILLER_178_878 VDD VSS sg13g2_decap_8
XFILLER_137_208 VDD VSS sg13g2_decap_8
XFILLER_118_400 VDD VSS sg13g2_fill_1
X_08193_ _08193_/Y _07890_/B _08191_/Y _08192_/Y VDD VSS sg13g2_a21oi_1
XFILLER_118_411 VDD VSS sg13g2_decap_8
X_14865__2837 _14865_/RESET_B VDD VSS sg13g2_tiehi
XFILLER_118_488 VDD VSS sg13g2_fill_2
XFILLER_133_414 VDD VSS sg13g2_fill_1
XFILLER_134_937 VDD VSS sg13g2_decap_8
XFILLER_160_200 VDD VSS sg13g2_decap_8
XFILLER_12_1292 VDD VSS sg13g2_decap_8
XFILLER_126_15 VDD VSS sg13g2_fill_1
X_14286__1916 _14286_/RESET_B VDD VSS sg13g2_tiehi
XFILLER_173_1330 VDD VSS sg13g2_decap_8
XFILLER_47_1333 VDD VSS sg13g2_decap_8
XFILLER_114_661 VDD VSS sg13g2_decap_8
XFILLER_160_266 VDD VSS sg13g2_decap_8
X_14322__1880 _14322_/RESET_B VDD VSS sg13g2_tiehi
XFILLER_114_672 VDD VSS sg13g2_fill_2
XFILLER_0_939 VDD VSS sg13g2_decap_8
XFILLER_82_1246 VDD VSS sg13g2_decap_8
XFILLER_99_383 VDD VSS sg13g2_decap_4
XFILLER_113_171 VDD VSS sg13g2_decap_4
XFILLER_134_1336 VDD VSS sg13g2_decap_8
XFILLER_99_394 VDD VSS sg13g2_fill_2
XFILLER_134_1369 VDD VSS sg13g2_decap_8
XFILLER_19_35 VDD VSS sg13g2_decap_8
XFILLER_142_14 VDD VSS sg13g2_fill_1
XFILLER_75_718 VDD VSS sg13g2_decap_8
X_07977_ _07977_/Y _08577_/B _07866_/Y _07976_/X VDD VSS sg13g2_a21oi_1
XFILLER_142_47 VDD VSS sg13g2_decap_8
X_09716_ _14307_/D _09749_/A1 _14307_/Q _09729_/S VDD VSS sg13g2_mux2_1
XFILLER_132_1071 VDD VSS sg13g2_decap_4
XFILLER_67_291 VDD VSS sg13g2_decap_8
XFILLER_55_442 VDD VSS sg13g2_fill_2
X_09647_ _14240_/D _10143_/A1 _14240_/Q _09667_/S VDD VSS sg13g2_mux2_1
XFILLER_3_1460 VDD VSS sg13g2_decap_8
XFILLER_76_1017 VDD VSS sg13g2_decap_8
XFILLER_82_261 VDD VSS sg13g2_decap_8
XFILLER_70_412 VDD VSS sg13g2_decap_8
XFILLER_55_486 VDD VSS sg13g2_fill_2
XFILLER_71_946 VDD VSS sg13g2_fill_1
XFILLER_128_1129 VDD VSS sg13g2_decap_8
XFILLER_167_1178 VDD VSS sg13g2_decap_8
X_09578_ _14175_/D _14175_/Q _09910_/A1 _09589_/S VDD VSS sg13g2_mux2_1
XFILLER_42_136 VDD VSS sg13g2_fill_2
XFILLER_58_1462 VDD VSS sg13g2_decap_8
XFILLER_24_851 VDD VSS sg13g2_decap_4
XFILLER_180_1301 VDD VSS sg13g2_decap_8
XFILLER_54_1304 VDD VSS sg13g2_decap_8
XFILLER_35_89 VDD VSS sg13g2_fill_2
XFILLER_145_1432 VDD VSS sg13g2_decap_8
X_08529_ _08529_/Y _08566_/C _08495_/Y _08567_/C VDD VSS sg13g2_o21ai_1
X_13774__2428 _13774_/RESET_B VDD VSS sg13g2_tiehi
XFILLER_11_501 VDD VSS sg13g2_decap_8
XFILLER_19_1457 VDD VSS sg13g2_decap_8
XFILLER_143_4 VDD VSS sg13g2_decap_4
XFILLER_106_1416 VDD VSS sg13g2_fill_2
XFILLER_168_344 VDD VSS sg13g2_decap_8
X_13810__2392 _13810_/RESET_B VDD VSS sg13g2_tiehi
X_11540_ _11540_/Y _11536_/Y _11537_/Y _11539_/Y _11538_/Y _11549_/B VDD VSS sg13g2_a221oi_1
XFILLER_180_1378 VDD VSS sg13g2_decap_8
XFILLER_167_11 VDD VSS sg13g2_decap_8
XFILLER_184_826 VDD VSS sg13g2_decap_8
XFILLER_51_44 VDD VSS sg13g2_fill_1
XFILLER_13_1012 VDD VSS sg13g2_decap_8
X_11471_ _11471_/X _13729_/Q _14081_/Q _14433_/Q _14529_/Q _11493_/S0 _07654_/A VDD
+ VSS sg13g2_mux4_1
XFILLER_11_578 VDD VSS sg13g2_decap_8
XFILLER_137_731 VDD VSS sg13g2_decap_8
XFILLER_183_347 VDD VSS sg13g2_decap_8
X_13210_ _13211_/B _13265_/A1 _13205_/X _13204_/Y _13307_/A _13209_/Y VDD VSS sg13g2_a221oi_1
X_10422_ _10423_/B _14828_/Q _14829_/Q _14830_/Q _10422_/D VDD VSS sg13g2_nand4_1
X_14190_ _14190_/Q _14670_/CLK _14190_/D _14190_/RESET_B VDD VSS sg13g2_dfrbpq_1
XFILLER_164_561 VDD VSS sg13g2_decap_8
XFILLER_167_88 VDD VSS sg13g2_decap_8
X_14154__2048 _14154_/RESET_B VDD VSS sg13g2_tiehi
XFILLER_13_1089 VDD VSS sg13g2_decap_8
XFILLER_124_414 VDD VSS sg13g2_decap_4
XFILLER_137_797 VDD VSS sg13g2_fill_2
X_13141_ _15042_/D _13141_/A _13141_/B VDD VSS sg13g2_nor2_1
X_10353_ _14810_/D _10353_/A _10353_/B _10557_/C VDD VSS sg13g2_and3_1
XFILLER_48_1108 VDD VSS sg13g2_decap_8
XFILLER_3_711 VDD VSS sg13g2_decap_8
XFILLER_30_1370 VDD VSS sg13g2_decap_8
XFILLER_109_499 VDD VSS sg13g2_decap_8
XFILLER_174_1105 VDD VSS sg13g2_decap_8
XFILLER_178_1285 VDD VSS sg13g2_decap_8
XFILLER_2_210 VDD VSS sg13g2_decap_8
XFILLER_183_32 VDD VSS sg13g2_decap_8
X_13072_ _13072_/X input11/X _13272_/A2 _13272_/B1 VDD VSS sg13g2_a21o_1
XFILLER_112_609 VDD VSS sg13g2_decap_4
X_10284_ _10284_/Y _14788_/Q _14789_/Q _10305_/A _10305_/B VDD VSS sg13g2_nand4_1
XFILLER_152_1403 VDD VSS sg13g2_decap_8
X_12023_ _12027_/A _12022_/X _12233_/B VDD VSS sg13g2_nand2b_1
XFILLER_3_788 VDD VSS sg13g2_decap_8
XFILLER_65_1466 VDD VSS sg13g2_decap_4
XFILLER_26_1417 VDD VSS sg13g2_decap_8
XFILLER_2_287 VDD VSS sg13g2_decap_8
XFILLER_104_171 VDD VSS sg13g2_fill_1
XFILLER_113_1409 VDD VSS sg13g2_fill_1
XFILLER_120_675 VDD VSS sg13g2_decap_8
XFILLER_63_1190 VDD VSS sg13g2_decap_8
Xfanout580 _13275_/B1 _13297_/A0 VDD VSS sg13g2_buf_1
XFILLER_76_63 VDD VSS sg13g2_decap_8
Xfanout591 _11433_/B _11931_/A2 VDD VSS sg13g2_buf_1
XFILLER_115_1291 VDD VSS sg13g2_decap_8
X_13974_ _13974_/Q clkload45/A _13974_/D _13974_/RESET_B VDD VSS sg13g2_dfrbpq_1
XFILLER_4_1246 VDD VSS sg13g2_decap_8
XFILLER_47_954 VDD VSS sg13g2_fill_2
XFILLER_150_1193 VDD VSS sg13g2_fill_2
XFILLER_58_291 VDD VSS sg13g2_fill_2
XFILLER_185_1201 VDD VSS sg13g2_decap_8
XFILLER_98_1253 VDD VSS sg13g2_decap_8
XFILLER_18_144 VDD VSS sg13g2_fill_2
X_12925_ _12989_/B _12925_/A _12925_/B _12925_/C VDD VSS sg13g2_nand3_1
XFILLER_98_1264 VDD VSS sg13g2_fill_1
XFILLER_62_902 VDD VSS sg13g2_fill_1
XFILLER_46_453 VDD VSS sg13g2_decap_8
XFILLER_98_1275 VDD VSS sg13g2_fill_1
XFILLER_62_913 VDD VSS sg13g2_fill_2
XFILLER_59_1226 VDD VSS sg13g2_decap_8
XFILLER_19_689 VDD VSS sg13g2_decap_8
X_14961__2649 _14961_/RESET_B VDD VSS sg13g2_tiehi
XFILLER_94_1139 VDD VSS sg13g2_decap_8
XFILLER_33_114 VDD VSS sg13g2_decap_8
X_12856_ _15024_/D _12855_/Y _12850_/X _12984_/A VDD VSS sg13g2_a21oi_1
XFILLER_185_1278 VDD VSS sg13g2_decap_8
XFILLER_178_119 VDD VSS sg13g2_decap_8
X_11807_ _11808_/A _13964_/Q _13996_/Q _14028_/Q _14060_/Q _11804_/A _11805_/C VDD
+ VSS sg13g2_mux4_1
XFILLER_33_169 VDD VSS sg13g2_decap_8
XFILLER_159_322 VDD VSS sg13g2_decap_4
X_12787_ _12787_/X _14714_/Q _14746_/Q _13786_/Q _13818_/Q _12787_/S0 _12787_/S1 VDD
+ VSS sg13g2_mux4_1
XFILLER_72_1426 VDD VSS sg13g2_decap_8
X_14364__1838 _14364_/RESET_B VDD VSS sg13g2_tiehi
XFILLER_42_670 VDD VSS sg13g2_fill_1
XFILLER_30_810 VDD VSS sg13g2_decap_8
XFILLER_15_895 VDD VSS sg13g2_fill_2
X_14526_ _14526_/Q _14526_/CLK _14526_/D _14526_/RESET_B VDD VSS sg13g2_dfrbpq_1
XFILLER_14_394 VDD VSS sg13g2_decap_8
X_11738_ _11738_/X _14570_/Q _14602_/Q _11759_/A VDD VSS sg13g2_mux2_1
XFILLER_30_854 VDD VSS sg13g2_fill_2
XFILLER_31_1101 VDD VSS sg13g2_decap_8
XFILLER_147_539 VDD VSS sg13g2_decap_8
XFILLER_159_399 VDD VSS sg13g2_fill_2
X_14457_ _14457_/Q clkload44/A _14457_/D _14457_/RESET_B VDD VSS sg13g2_dfrbpq_1
XFILLER_70_1161 VDD VSS sg13g2_decap_8
XFILLER_30_887 VDD VSS sg13g2_decap_8
X_11669_ _11669_/Y _11665_/Y _11666_/Y _11668_/Y _11667_/Y _11696_/B VDD VSS sg13g2_a221oi_1
XFILLER_128_731 VDD VSS sg13g2_decap_8
XFILLER_186_196 VDD VSS sg13g2_decap_8
XFILLER_122_1262 VDD VSS sg13g2_fill_1
X_13408_ _15091_/D _13444_/A _13396_/D _13407_/Y VDD VSS sg13g2_o21ai_1
XFILLER_116_904 VDD VSS sg13g2_fill_2
XFILLER_122_1273 VDD VSS sg13g2_decap_8
X_14388_ _14388_/Q _15005_/CLK _14388_/D _14388_/RESET_B VDD VSS sg13g2_dfrbpq_1
XFILLER_31_1167 VDD VSS sg13g2_decap_8
XFILLER_115_403 VDD VSS sg13g2_decap_8
XFILLER_128_786 VDD VSS sg13g2_fill_1
XFILLER_143_712 VDD VSS sg13g2_decap_8
XFILLER_116_948 VDD VSS sg13g2_decap_4
X_13339_ _13341_/A _13652_/S _13502_/B _15175_/D _13351_/B VDD VSS sg13g2_or4_1
XFILLER_6_571 VDD VSS sg13g2_decap_8
XFILLER_157_1336 VDD VSS sg13g2_decap_8
XFILLER_170_542 VDD VSS sg13g2_decap_8
XFILLER_115_458 VDD VSS sg13g2_decap_4
XFILLER_131_907 VDD VSS sg13g2_fill_2
Xhold3108 input27/A mem_axi_rdata[30] VDD VSS sg13g2_dlygate4sd3_1
XFILLER_130_406 VDD VSS sg13g2_decap_8
XFILLER_124_970 VDD VSS sg13g2_decap_8
XFILLER_170_575 VDD VSS sg13g2_decap_8
Xhold3119 _13644_/A _13752_/Q VDD VSS sg13g2_dlygate4sd3_1
XFILLER_142_277 VDD VSS sg13g2_fill_2
XFILLER_9_1113 VDD VSS sg13g2_decap_8
XFILLER_130_428 VDD VSS sg13g2_decap_8
X_15009_ _15009_/Q clkload38/A _15009_/D _15009_/RESET_B VDD VSS sg13g2_dfrbpq_1
X_07900_ _07900_/Y _07903_/B _07900_/B VDD VSS sg13g2_nand2b_1
XFILLER_97_821 VDD VSS sg13g2_decap_8
XFILLER_116_1011 VDD VSS sg13g2_fill_2
X_08880_ _13703_/D _16865_/A _08879_/X _08935_/S VDD VSS sg13g2_mux2_1
XFILLER_97_843 VDD VSS sg13g2_decap_8
XFILLER_123_491 VDD VSS sg13g2_decap_8
XFILLER_111_653 VDD VSS sg13g2_decap_8
XFILLER_116_1044 VDD VSS sg13g2_decap_4
XFILLER_110_130 VDD VSS sg13g2_decap_8
X_07831_ _07979_/C _08048_/B _08692_/C VDD VSS sg13g2_nand2b_1
XFILLER_110_141 VDD VSS sg13g2_fill_1
XFILLER_84_504 VDD VSS sg13g2_fill_1
XFILLER_38_910 VDD VSS sg13g2_fill_2
XFILLER_110_163 VDD VSS sg13g2_decap_8
X_07762_ _07762_/Y _13596_/B _15204_/Q _07754_/Y VDD VSS sg13g2_a21oi_1
XFILLER_110_196 VDD VSS sg13g2_decap_8
XFILLER_49_291 VDD VSS sg13g2_fill_1
X_09501_ _14101_/D _10097_/A0 _14101_/Q _09505_/S VDD VSS sg13g2_mux2_1
XFILLER_42_1296 VDD VSS sg13g2_decap_8
XFILLER_112_28 VDD VSS sg13g2_decap_8
X_07693_ _07696_/B _15084_/Q _07701_/B VDD VSS sg13g2_nand2_1
XFILLER_168_1454 VDD VSS sg13g2_decap_8
XFILLER_77_1348 VDD VSS sg13g2_decap_8
X_09432_ _14034_/D _09630_/A0 _14034_/Q _09438_/S VDD VSS sg13g2_mux2_1
XFILLER_37_497 VDD VSS sg13g2_fill_1
XFILLER_164_1329 VDD VSS sg13g2_decap_8
XFILLER_169_119 VDD VSS sg13g2_decap_8
X_09363_ _13967_/D _09860_/A1 _13967_/Q _09372_/S VDD VSS sg13g2_mux2_1
XFILLER_127_1151 VDD VSS sg13g2_fill_2
X_08314_ _08350_/B _08315_/B _07776_/Y _08287_/Y _07779_/Y _07773_/Y VDD VSS sg13g2_a221oi_1
XFILLER_36_1045 VDD VSS sg13g2_fill_2
XFILLER_177_130 VDD VSS sg13g2_decap_8
X_09294_ _13902_/D _13902_/Q _10157_/A1 _09294_/S VDD VSS sg13g2_mux2_1
XANTENNA_10 _16869_/A VDD VSS sg13g2_antennanp
XFILLER_138_506 VDD VSS sg13g2_decap_8
XANTENNA_21 _09661_/S VDD VSS sg13g2_antennanp
XFILLER_178_686 VDD VSS sg13g2_fill_2
XFILLER_20_342 VDD VSS sg13g2_decap_4
XFILLER_14_1310 VDD VSS sg13g2_decap_8
XFILLER_177_174 VDD VSS sg13g2_fill_1
X_08245_ _08245_/Y _08452_/C _08021_/A _08027_/Y VDD VSS sg13g2_a21oi_1
XFILLER_53_1370 VDD VSS sg13g2_decap_8
XFILLER_177_185 VDD VSS sg13g2_fill_2
XFILLER_165_347 VDD VSS sg13g2_fill_2
XFILLER_105_1471 VDD VSS sg13g2_decap_4
XFILLER_21_25 VDD VSS sg13g2_decap_8
XFILLER_88_1411 VDD VSS sg13g2_decap_8
X_08176_ _08187_/C _08188_/B _08142_/A _08175_/Y _07876_/A _08174_/Y VDD VSS sg13g2_a221oi_1
XFILLER_10_1218 VDD VSS sg13g2_decap_8
XFILLER_14_1387 VDD VSS sg13g2_decap_8
XFILLER_106_414 VDD VSS sg13g2_decap_8
XFILLER_107_959 VDD VSS sg13g2_fill_2
XFILLER_108_7 VDD VSS sg13g2_fill_1
XFILLER_134_767 VDD VSS sg13g2_decap_4
XFILLER_175_1447 VDD VSS sg13g2_decap_8
XFILLER_136_1409 VDD VSS sg13g2_decap_8
XFILLER_47_1130 VDD VSS sg13g2_decap_8
XFILLER_0_714 VDD VSS sg13g2_decap_8
XFILLER_115_981 VDD VSS sg13g2_decap_8
XFILLER_86_1190 VDD VSS sg13g2_decap_8
XFILLER_88_843 VDD VSS sg13g2_fill_1
XFILLER_82_1043 VDD VSS sg13g2_decap_4
XFILLER_134_1122 VDD VSS sg13g2_decap_8
XFILLER_138_1291 VDD VSS sg13g2_decap_4
XFILLER_87_331 VDD VSS sg13g2_decap_8
XFILLER_153_46 VDD VSS sg13g2_decap_8
XFILLER_134_1166 VDD VSS sg13g2_decap_8
XFILLER_48_729 VDD VSS sg13g2_decap_8
XFILLER_134_1188 VDD VSS sg13g2_decap_8
X_13828__2374 _13828_/RESET_B VDD VSS sg13g2_tiehi
XFILLER_87_386 VDD VSS sg13g2_decap_8
XFILLER_101_185 VDD VSS sg13g2_decap_8
XFILLER_28_431 VDD VSS sg13g2_decap_8
XFILLER_60_1385 VDD VSS sg13g2_decap_8
XFILLER_21_1358 VDD VSS sg13g2_decap_8
XFILLER_44_913 VDD VSS sg13g2_decap_8
X_10971_ _10971_/Y _10969_/B _11015_/C _11056_/B1 VDD VSS sg13g2_o21ai_1
XFILLER_95_1415 VDD VSS sg13g2_decap_8
XFILLER_83_570 VDD VSS sg13g2_decap_4
XFILLER_55_261 VDD VSS sg13g2_decap_8
XFILLER_56_795 VDD VSS sg13g2_decap_8
XFILLER_16_637 VDD VSS sg13g2_decap_4
X_12710_ _12710_/X _14709_/Q _14741_/Q _13781_/Q _13813_/Q _12716_/S0 _12716_/S1 VDD
+ VSS sg13g2_mux4_1
XFILLER_44_946 VDD VSS sg13g2_decap_8
XFILLER_83_592 VDD VSS sg13g2_fill_1
X_13690_ _13690_/Q _15214_/CLK _13690_/D _13690_/RESET_B VDD VSS sg13g2_dfrbpq_1
XFILLER_70_220 VDD VSS sg13g2_decap_8
XFILLER_182_1418 VDD VSS sg13g2_decap_8
XFILLER_15_147 VDD VSS sg13g2_decap_4
XFILLER_71_776 VDD VSS sg13g2_decap_4
XFILLER_43_467 VDD VSS sg13g2_fill_2
X_12641_ _12641_/X _14704_/Q _14736_/Q _13776_/Q _13808_/Q _12647_/S0 _12647_/S1 VDD
+ VSS sg13g2_mux4_1
XFILLER_12_810 VDD VSS sg13g2_decap_8
XFILLER_145_1251 VDD VSS sg13g2_decap_8
XFILLER_178_21 VDD VSS sg13g2_decap_8
XFILLER_19_1254 VDD VSS sg13g2_decap_8
XFILLER_106_1213 VDD VSS sg13g2_decap_8
XFILLER_157_804 VDD VSS sg13g2_decap_8
XFILLER_106_1224 VDD VSS sg13g2_fill_2
X_12572_ _12572_/X _13739_/Q _14091_/Q _14443_/Q _14539_/Q _12576_/S0 _12576_/S1 VDD
+ VSS sg13g2_mux4_1
XFILLER_184_601 VDD VSS sg13g2_decap_8
XFILLER_12_865 VDD VSS sg13g2_decap_8
XFILLER_156_303 VDD VSS sg13g2_decap_8
XFILLER_50_1009 VDD VSS sg13g2_decap_4
XFILLER_12_876 VDD VSS sg13g2_fill_1
XFILLER_134_0 VDD VSS sg13g2_fill_2
XFILLER_180_1175 VDD VSS sg13g2_decap_8
X_14311_ _14311_/Q clkload12/A _14311_/D _14311_/RESET_B VDD VSS sg13g2_dfrbpq_1
XFILLER_54_1178 VDD VSS sg13g2_decap_8
X_11523_ _11566_/A _11526_/A _11934_/B VDD VSS sg13g2_nor2_1
XFILLER_32_1421 VDD VSS sg13g2_decap_8
XFILLER_11_375 VDD VSS sg13g2_decap_8
XFILLER_156_336 VDD VSS sg13g2_decap_8
XFILLER_178_98 VDD VSS sg13g2_decap_8
XFILLER_8_858 VDD VSS sg13g2_decap_8
XFILLER_7_49 VDD VSS sg13g2_decap_8
XFILLER_144_509 VDD VSS sg13g2_decap_8
XFILLER_183_144 VDD VSS sg13g2_decap_8
X_14242_ _14242_/Q _14722_/CLK _14242_/D _14242_/RESET_B VDD VSS sg13g2_dfrbpq_1
XFILLER_109_241 VDD VSS sg13g2_decap_8
X_11454_ _11457_/B _11454_/A _13688_/Q VDD VSS sg13g2_nand2_1
XFILLER_7_357 VDD VSS sg13g2_decap_8
XFILLER_172_829 VDD VSS sg13g2_decap_8
XFILLER_124_200 VDD VSS sg13g2_decap_8
X_10405_ _10406_/A _14823_/Q _14824_/Q _10405_/C _10414_/C VDD VSS sg13g2_and4_1
X_14173_ _14173_/Q clkload29/A _14173_/D _14173_/RESET_B VDD VSS sg13g2_dfrbpq_1
X_11385_ _11385_/Y _11385_/A _11385_/B VDD VSS sg13g2_xnor2_1
XFILLER_178_1082 VDD VSS sg13g2_decap_8
XFILLER_124_244 VDD VSS sg13g2_fill_1
XFILLER_139_1044 VDD VSS sg13g2_decap_8
X_13124_ _13124_/Y _13121_/Y _13122_/Y _13123_/Y VDD VSS sg13g2_a21oi_1
XFILLER_140_704 VDD VSS sg13g2_decap_4
X_10336_ _10337_/B _14803_/Q _14804_/Q _14805_/Q _10336_/D VDD VSS sg13g2_nand4_1
XFILLER_112_428 VDD VSS sg13g2_decap_8
XFILLER_127_91 VDD VSS sg13g2_decap_8
XFILLER_152_1200 VDD VSS sg13g2_decap_4
XFILLER_3_585 VDD VSS sg13g2_decap_8
X_13055_ _13055_/Y _13154_/A1 _13050_/X _13054_/Y VDD VSS sg13g2_a21oi_1
X_10267_ _10269_/A _14783_/Q _10262_/Y _14784_/Q VDD VSS sg13g2_a21o_1
XFILLER_140_759 VDD VSS sg13g2_decap_8
XFILLER_65_1263 VDD VSS sg13g2_decap_8
XFILLER_26_1214 VDD VSS sg13g2_decap_8
XFILLER_79_854 VDD VSS sg13g2_decap_8
Xfanout1320 _11493_/S0 fanout1329/X VDD VSS sg13g2_buf_1
XFILLER_87_73 VDD VSS sg13g2_decap_8
X_12006_ _14979_/D _12006_/A _12006_/B VDD VSS sg13g2_nand2_1
XFILLER_94_802 VDD VSS sg13g2_fill_2
XFILLER_113_1206 VDD VSS sg13g2_decap_8
Xfanout1331 _12090_/A _11788_/S0 VDD VSS sg13g2_buf_1
XFILLER_39_718 VDD VSS sg13g2_decap_8
XFILLER_121_984 VDD VSS sg13g2_decap_8
Xfanout1342 _11686_/S0 fanout1351/X VDD VSS sg13g2_buf_1
X_10198_ _14756_/D _15199_/D _14756_/Q _10202_/S VDD VSS sg13g2_mux2_1
XFILLER_117_1386 VDD VSS sg13g2_decap_8
Xfanout1353 _11621_/S0 fanout1361/X VDD VSS sg13g2_buf_1
XFILLER_94_824 VDD VSS sg13g2_decap_8
Xfanout1364 _11812_/A1 _11899_/S0 VDD VSS sg13g2_buf_1
XFILLER_120_483 VDD VSS sg13g2_decap_8
Xfanout1375 _12235_/A _12259_/S0 VDD VSS sg13g2_buf_1
XFILLER_38_228 VDD VSS sg13g2_decap_8
X_14418__1784 _14418_/RESET_B VDD VSS sg13g2_tiehi
XFILLER_66_548 VDD VSS sg13g2_decap_8
Xfanout1386 _11277_/S fanout1388/X VDD VSS sg13g2_buf_1
Xfanout1397 _13507_/A _13155_/A VDD VSS sg13g2_buf_1
XFILLER_93_345 VDD VSS sg13g2_decap_8
XFILLER_66_559 VDD VSS sg13g2_fill_1
XFILLER_94_879 VDD VSS sg13g2_decap_8
XFILLER_4_1043 VDD VSS sg13g2_decap_8
X_13957_ _13957_/Q clkload17/A _13957_/D _13957_/RESET_B VDD VSS sg13g2_dfrbpq_1
XFILLER_93_378 VDD VSS sg13g2_fill_1
XFILLER_81_529 VDD VSS sg13g2_decap_4
XFILLER_34_401 VDD VSS sg13g2_fill_2
XFILLER_185_1020 VDD VSS sg13g2_decap_8
XFILLER_74_581 VDD VSS sg13g2_decap_8
XFILLER_46_272 VDD VSS sg13g2_decap_8
X_12908_ _12910_/A _12925_/A _12925_/B _12909_/C VDD VSS sg13g2_a21oi_1
XFILLER_146_1004 VDD VSS sg13g2_fill_1
X_13888_ _13888_/Q _15230_/CLK _13888_/D _13888_/RESET_B VDD VSS sg13g2_dfrbpq_1
X_14597__1605 _14597_/RESET_B VDD VSS sg13g2_tiehi
XFILLER_35_979 VDD VSS sg13g2_decap_8
XFILLER_185_1075 VDD VSS sg13g2_decap_8
XFILLER_179_439 VDD VSS sg13g2_fill_2
X_12839_ _12840_/B _12836_/Y _12838_/Y _12828_/Y _12983_/A1 _12832_/Y VDD VSS sg13g2_a221oi_1
XFILLER_50_938 VDD VSS sg13g2_fill_1
XFILLER_72_1223 VDD VSS sg13g2_decap_8
XFILLER_37_1343 VDD VSS sg13g2_decap_8
XFILLER_14_180 VDD VSS sg13g2_decap_8
XFILLER_163_1373 VDD VSS sg13g2_decap_8
XFILLER_30_651 VDD VSS sg13g2_decap_8
X_14509_ _14509_/Q clkload26/A _14509_/D _14509_/RESET_B VDD VSS sg13g2_dfrbpq_1
XFILLER_148_848 VDD VSS sg13g2_fill_2
XFILLER_175_645 VDD VSS sg13g2_decap_8
XFILLER_174_133 VDD VSS sg13g2_decap_8
X_08030_ _08030_/Y _08544_/C _08377_/B VDD VSS sg13g2_nand2_1
XFILLER_159_1409 VDD VSS sg13g2_decap_8
Xinput30 input30/X input30/A VDD VSS sg13g2_buf_1
XFILLER_128_561 VDD VSS sg13g2_fill_1
XFILLER_122_1081 VDD VSS sg13g2_decap_8
X_13906__2296 _13906_/RESET_B VDD VSS sg13g2_tiehi
XFILLER_128_583 VDD VSS sg13g2_fill_1
XFILLER_116_734 VDD VSS sg13g2_fill_1
XFILLER_143_520 VDD VSS sg13g2_fill_2
XFILLER_143_531 VDD VSS sg13g2_decap_8
XFILLER_131_704 VDD VSS sg13g2_decap_8
XFILLER_107_28 VDD VSS sg13g2_fill_2
XFILLER_157_1155 VDD VSS sg13g2_decap_8
X_09981_ _14564_/D _10147_/A1 _14564_/Q _09997_/S VDD VSS sg13g2_mux2_1
XFILLER_143_575 VDD VSS sg13g2_decap_8
XFILLER_153_1008 VDD VSS sg13g2_fill_2
XFILLER_103_428 VDD VSS sg13g2_decap_8
XFILLER_118_1139 VDD VSS sg13g2_fill_2
XFILLER_170_383 VDD VSS sg13g2_decap_8
XFILLER_48_1461 VDD VSS sg13g2_decap_8
X_08932_ _13716_/D _16878_/A _08931_/X _08932_/S VDD VSS sg13g2_mux2_1
XFILLER_112_951 VDD VSS sg13g2_decap_8
X_15111__2760 _15111_/RESET_B VDD VSS sg13g2_tiehi
XFILLER_170_1333 VDD VSS sg13g2_decap_8
XFILLER_83_1396 VDD VSS sg13g2_decap_8
XFILLER_44_1347 VDD VSS sg13g2_decap_8
XFILLER_131_1306 VDD VSS sg13g2_fill_2
X_08863_ _08863_/X _08862_/X _11502_/A _08875_/S VDD VSS sg13g2_mux2_1
XFILLER_96_150 VDD VSS sg13g2_decap_8
XFILLER_57_526 VDD VSS sg13g2_fill_2
XFILLER_97_695 VDD VSS sg13g2_decap_8
X_07814_ _08567_/B _08522_/A _08548_/B VDD VSS sg13g2_nand2_1
X_08794_ _08796_/A _10885_/A1 _14756_/Q _08727_/X _15199_/Q _13392_/A2 VDD VSS sg13g2_a221oi_1
XFILLER_85_879 VDD VSS sg13g2_decap_4
XFILLER_72_507 VDD VSS sg13g2_decap_8
X_07745_ _15208_/D _07741_/Y _07746_/C _07740_/Y VDD VSS sg13g2_o21ai_1
XFILLER_42_1093 VDD VSS sg13g2_decap_8
XFILLER_84_389 VDD VSS sg13g2_decap_8
XFILLER_38_784 VDD VSS sg13g2_decap_8
XFILLER_65_570 VDD VSS sg13g2_fill_1
XFILLER_26_935 VDD VSS sg13g2_fill_1
XFILLER_38_795 VDD VSS sg13g2_fill_1
XFILLER_168_1251 VDD VSS sg13g2_decap_8
XFILLER_16_25 VDD VSS sg13g2_decap_8
XFILLER_129_1213 VDD VSS sg13g2_decap_4
XFILLER_77_1145 VDD VSS sg13g2_decap_8
X_07676_ _07721_/A _15079_/Q _15082_/Q _15080_/Q VDD VSS sg13g2_nor3_1
XFILLER_26_968 VDD VSS sg13g2_fill_2
X_09415_ _14017_/D _09714_/A0 _14017_/Q _09430_/S VDD VSS sg13g2_mux2_1
XFILLER_52_253 VDD VSS sg13g2_fill_2
XFILLER_129_1257 VDD VSS sg13g2_decap_8
XFILLER_53_787 VDD VSS sg13g2_decap_8
XFILLER_179_940 VDD VSS sg13g2_fill_1
XFILLER_52_286 VDD VSS sg13g2_decap_8
X_09346_ _13950_/D _09942_/A1 _13950_/Q _09368_/S VDD VSS sg13g2_mux2_1
XFILLER_55_1454 VDD VSS sg13g2_decap_8
XFILLER_178_472 VDD VSS sg13g2_decap_8
XFILLER_16_1449 VDD VSS sg13g2_decap_8
XFILLER_32_35 VDD VSS sg13g2_decap_8
XFILLER_139_848 VDD VSS sg13g2_decap_8
X_09277_ _13885_/D _13885_/Q _09875_/A0 _09304_/S VDD VSS sg13g2_mux2_1
XFILLER_166_656 VDD VSS sg13g2_decap_8
X_08228_ _08229_/A _07909_/Y _07921_/Y _07889_/A VDD VSS sg13g2_o21ai_1
XFILLER_165_155 VDD VSS sg13g2_decap_8
XFILLER_101_1121 VDD VSS sg13g2_decap_8
XFILLER_165_177 VDD VSS sg13g2_decap_8
XFILLER_10_1015 VDD VSS sg13g2_decap_8
XFILLER_119_583 VDD VSS sg13g2_decap_4
XFILLER_14_1184 VDD VSS sg13g2_decap_8
XFILLER_181_637 VDD VSS sg13g2_decap_8
XFILLER_119_594 VDD VSS sg13g2_decap_8
XFILLER_134_520 VDD VSS sg13g2_decap_8
X_08159_ _08166_/B _08158_/X _08397_/A _08359_/B2 _08150_/X VDD VSS sg13g2_a22oi_1
XFILLER_88_1263 VDD VSS sg13g2_decap_8
XFILLER_134_542 VDD VSS sg13g2_decap_8
XFILLER_180_147 VDD VSS sg13g2_decap_8
XFILLER_106_4 VDD VSS sg13g2_decap_8
XFILLER_134_553 VDD VSS sg13g2_fill_1
X_14071__2131 _14071_/RESET_B VDD VSS sg13g2_tiehi
XFILLER_107_778 VDD VSS sg13g2_decap_8
XFILLER_175_1244 VDD VSS sg13g2_decap_8
X_11170_ _11170_/Y _11170_/A _11170_/B VDD VSS sg13g2_nand2_1
XFILLER_49_1247 VDD VSS sg13g2_decap_8
XFILLER_162_884 VDD VSS sg13g2_decap_4
XFILLER_164_56 VDD VSS sg13g2_decap_8
X_10121_ _14699_/D _10154_/A1 _14699_/Q _10130_/S VDD VSS sg13g2_mux2_1
XFILLER_0_511 VDD VSS sg13g2_decap_8
XFILLER_79_128 VDD VSS sg13g2_decap_8
X_14675__1527 _14675_/RESET_B VDD VSS sg13g2_tiehi
XFILLER_88_640 VDD VSS sg13g2_decap_8
XFILLER_62_1425 VDD VSS sg13g2_decap_8
X_10052_ _14633_/D _10152_/A1 _14633_/Q _10063_/S VDD VSS sg13g2_mux2_1
X_15010__2600 _15010_/RESET_B VDD VSS sg13g2_tiehi
XFILLER_23_1409 VDD VSS sg13g2_decap_8
X_14711__1491 _14711_/RESET_B VDD VSS sg13g2_tiehi
XFILLER_57_32 VDD VSS sg13g2_fill_1
XFILLER_0_588 VDD VSS sg13g2_decap_8
XFILLER_103_995 VDD VSS sg13g2_fill_1
XFILLER_87_161 VDD VSS sg13g2_decap_8
XFILLER_57_43 VDD VSS sg13g2_decap_8
XFILLER_76_846 VDD VSS sg13g2_decap_4
XFILLER_102_494 VDD VSS sg13g2_decap_8
X_14860_ _14860_/Q clkload90/A _14860_/D _14860_/RESET_B VDD VSS sg13g2_dfrbpq_1
XFILLER_5_1330 VDD VSS sg13g2_decap_8
XFILLER_169_1015 VDD VSS sg13g2_fill_1
X_13811_ _13811_/Q clkload39/A _13811_/D _13811_/RESET_B VDD VSS sg13g2_dfrbpq_1
XFILLER_91_816 VDD VSS sg13g2_decap_8
XFILLER_60_1182 VDD VSS sg13g2_decap_8
XFILLER_57_98 VDD VSS sg13g2_decap_4
XFILLER_180_77 VDD VSS sg13g2_decap_8
X_14791_ _14791_/Q clkload89/A _14791_/D _14791_/RESET_B VDD VSS sg13g2_dfrbpq_1
XFILLER_21_1155 VDD VSS sg13g2_decap_8
XFILLER_56_581 VDD VSS sg13g2_decap_4
X_13742_ _13742_/Q _14602_/CLK _13742_/D _13742_/RESET_B VDD VSS sg13g2_dfrbpq_1
XFILLER_17_968 VDD VSS sg13g2_decap_8
X_10954_ _10967_/A _10954_/A _10954_/B _10954_/C _10954_/D VDD VSS sg13g2_nor4_1
XFILLER_43_220 VDD VSS sg13g2_decap_8
XFILLER_182_1215 VDD VSS sg13g2_decap_8
XFILLER_44_765 VDD VSS sg13g2_decap_8
X_13673_ _13673_/Q _15188_/CLK _13673_/D _13673_/RESET_B VDD VSS sg13g2_dfrbpq_1
X_10885_ _10885_/Y _10885_/A1 _10883_/X _10884_/Y VDD VSS sg13g2_a21oi_1
XFILLER_147_1379 VDD VSS sg13g2_decap_8
XFILLER_31_437 VDD VSS sg13g2_decap_8
X_12624_ _12625_/B _13674_/Q _12777_/A2 _12623_/X _12624_/B2 _12624_/C1 VDD VSS sg13g2_a221oi_1
XFILLER_12_640 VDD VSS sg13g2_decap_8
XFILLER_106_1021 VDD VSS sg13g2_fill_1
XFILLER_145_1092 VDD VSS sg13g2_fill_1
X_14281__1921 _14281_/RESET_B VDD VSS sg13g2_tiehi
XFILLER_40_971 VDD VSS sg13g2_decap_8
XFILLER_185_943 VDD VSS sg13g2_decap_8
X_12555_ _15003_/D _12555_/A _12555_/B VDD VSS sg13g2_nor2_1
XFILLER_89_1005 VDD VSS sg13g2_decap_8
XFILLER_11_172 VDD VSS sg13g2_decap_8
XFILLER_106_1087 VDD VSS sg13g2_decap_8
X_11506_ _11506_/Y _11636_/A _11506_/B VDD VSS sg13g2_xnor2_1
XFILLER_8_655 VDD VSS sg13g2_decap_8
XFILLER_129_369 VDD VSS sg13g2_decap_8
XFILLER_156_155 VDD VSS sg13g2_decap_8
XFILLER_184_464 VDD VSS sg13g2_decap_8
XFILLER_156_166 VDD VSS sg13g2_fill_2
X_12486_ _12499_/A _12570_/A1 _12570_/A2 _08276_/B VDD VSS sg13g2_a21oi_1
XFILLER_144_317 VDD VSS sg13g2_decap_8
XFILLER_172_626 VDD VSS sg13g2_fill_1
XFILLER_7_154 VDD VSS sg13g2_decap_8
XFILLER_22_90 VDD VSS sg13g2_decap_4
X_14225_ _14225_/Q clkload34/A _14225_/D _14225_/RESET_B VDD VSS sg13g2_dfrbpq_1
X_11437_ _11445_/C _11436_/X _11971_/C VDD VSS sg13g2_nand2b_1
XFILLER_32_1295 VDD VSS sg13g2_decap_8
XFILLER_158_1431 VDD VSS sg13g2_decap_8
XFILLER_171_147 VDD VSS sg13g2_decap_8
XFILLER_153_851 VDD VSS sg13g2_decap_8
XFILLER_67_1325 VDD VSS sg13g2_decap_8
XFILLER_125_553 VDD VSS sg13g2_decap_8
X_14156_ _14156_/Q clkload50/A _14156_/D _14156_/RESET_B VDD VSS sg13g2_dfrbpq_1
XFILLER_4_861 VDD VSS sg13g2_decap_8
XFILLER_113_715 VDD VSS sg13g2_fill_2
X_11368_ _11368_/X _14238_/Q _14270_/Q _14302_/Q _14334_/Q _11368_/S0 _11368_/S1 VDD
+ VSS sg13g2_mux4_1
XFILLER_119_1437 VDD VSS sg13g2_decap_8
XFILLER_154_1317 VDD VSS sg13g2_decap_8
XFILLER_98_426 VDD VSS sg13g2_decap_8
XFILLER_119_1448 VDD VSS sg13g2_fill_2
XFILLER_140_523 VDD VSS sg13g2_decap_8
X_13107_ _13107_/Y _14818_/Q _13068_/B _13219_/B1 _14882_/Q _13219_/C1 VDD VSS sg13g2_a221oi_1
X_10319_ _14799_/D _13087_/A _10319_/B _10319_/C VDD VSS sg13g2_nor3_1
X_14087_ _14087_/Q _14727_/CLK _14087_/D _14087_/RESET_B VDD VSS sg13g2_dfrbpq_1
XFILLER_3_382 VDD VSS sg13g2_decap_8
X_11299_ _11299_/Y _11295_/Y _11296_/Y _11298_/Y _11297_/Y _12108_/B VDD VSS sg13g2_a221oi_1
X_13038_ _13057_/B _14909_/Q _13678_/Q VDD VSS sg13g2_or2_1
XFILLER_21_4 VDD VSS sg13g2_decap_8
Xfanout1150 _11726_/A _08457_/A3 VDD VSS sg13g2_buf_1
XFILLER_94_621 VDD VSS sg13g2_decap_8
XFILLER_39_526 VDD VSS sg13g2_decap_8
XFILLER_6_1138 VDD VSS sg13g2_decap_8
Xfanout1161 _11591_/A _14968_/Q VDD VSS sg13g2_buf_1
XFILLER_152_1085 VDD VSS sg13g2_decap_8
Xfanout1172 _08278_/A3 _11483_/A VDD VSS sg13g2_buf_1
XFILLER_26_1088 VDD VSS sg13g2_decap_8
Xfanout1183 _08142_/C _07893_/B VDD VSS sg13g2_buf_1
XFILLER_93_131 VDD VSS sg13g2_decap_8
XFILLER_67_868 VDD VSS sg13g2_fill_2
Xfanout1194 _12997_/A _11290_/A VDD VSS sg13g2_buf_1
XFILLER_94_665 VDD VSS sg13g2_fill_1
XFILLER_66_356 VDD VSS sg13g2_decap_8
XFILLER_130_1350 VDD VSS sg13g2_decap_8
X_14989_ _14989_/Q _15240_/CLK _14989_/D _14989_/RESET_B VDD VSS sg13g2_dfrbpq_1
XFILLER_93_175 VDD VSS sg13g2_fill_1
XFILLER_93_186 VDD VSS sg13g2_decap_8
XFILLER_78_1443 VDD VSS sg13g2_decap_8
XFILLER_47_581 VDD VSS sg13g2_fill_2
XFILLER_35_732 VDD VSS sg13g2_decap_4
XFILLER_165_1413 VDD VSS sg13g2_decap_8
XFILLER_39_1427 VDD VSS sg13g2_decap_8
XFILLER_34_242 VDD VSS sg13g2_decap_8
XFILLER_50_702 VDD VSS sg13g2_fill_1
X_15019__2591 _15019_/RESET_B VDD VSS sg13g2_tiehi
XFILLER_90_893 VDD VSS sg13g2_fill_1
X_09200_ _13816_/D _13816_/Q _10167_/A1 _09200_/S VDD VSS sg13g2_mux2_1
XFILLER_97_0 VDD VSS sg13g2_decap_8
XFILLER_37_1140 VDD VSS sg13g2_decap_8
XFILLER_72_1031 VDD VSS sg13g2_fill_1
XFILLER_163_1170 VDD VSS sg13g2_decap_8
XFILLER_33_1004 VDD VSS sg13g2_decap_8
XFILLER_148_623 VDD VSS sg13g2_decap_8
X_09131_ _09131_/X _09137_/A _10772_/A _09130_/Y VDD VSS sg13g2_a21o_1
XFILLER_147_111 VDD VSS sg13g2_decap_4
XFILLER_136_807 VDD VSS sg13g2_decap_8
X_09062_ _09062_/Y _13064_/A _09089_/C _09061_/Y VDD VSS sg13g2_a21oi_1
XFILLER_15_1460 VDD VSS sg13g2_decap_8
XFILLER_147_166 VDD VSS sg13g2_fill_1
XFILLER_163_615 VDD VSS sg13g2_decap_4
XFILLER_8_81 VDD VSS sg13g2_decap_8
XFILLER_50_1351 VDD VSS sg13g2_decap_8
XFILLER_159_1206 VDD VSS sg13g2_decap_8
XFILLER_11_1324 VDD VSS sg13g2_decap_8
XFILLER_147_188 VDD VSS sg13g2_decap_4
X_08013_ _08013_/X _08928_/A1 _08931_/A1 _08934_/A1 _08012_/B _08046_/B _07627_/A
+ VDD VSS sg13g2_mux4_1
XFILLER_102_1452 VDD VSS sg13g2_decap_8
XFILLER_118_38 VDD VSS sg13g2_decap_4
XFILLER_116_531 VDD VSS sg13g2_decap_8
XFILLER_116_542 VDD VSS sg13g2_fill_1
XFILLER_85_1425 VDD VSS sg13g2_decap_8
XFILLER_131_501 VDD VSS sg13g2_decap_8
XFILLER_1_308 VDD VSS sg13g2_decap_8
XFILLER_143_372 VDD VSS sg13g2_decap_8
XFILLER_171_681 VDD VSS sg13g2_decap_8
XFILLER_172_1417 VDD VSS sg13g2_decap_8
X_14930__2707 _14930_/RESET_B VDD VSS sg13g2_tiehi
X_09964_ _14548_/D _14548_/Q _10063_/A0 _09964_/S VDD VSS sg13g2_mux2_1
XFILLER_89_448 VDD VSS sg13g2_decap_4
XFILLER_103_258 VDD VSS sg13g2_decap_4
XFILLER_134_37 VDD VSS sg13g2_fill_2
X_08915_ _08915_/Y _08915_/A1 _08922_/S _08914_/Y VDD VSS sg13g2_a21oi_1
XFILLER_83_1182 VDD VSS sg13g2_fill_2
XFILLER_100_910 VDD VSS sg13g2_decap_8
X_09895_ _14481_/D _09895_/A0 _14481_/Q _09903_/S VDD VSS sg13g2_mux2_1
XFILLER_83_1193 VDD VSS sg13g2_decap_8
XFILLER_100_921 VDD VSS sg13g2_fill_1
XFILLER_40_1008 VDD VSS sg13g2_decap_8
X_08846_ _08846_/Y _08843_/B _08845_/Y _08843_/Y VDD VSS sg13g2_o21ai_1
XFILLER_58_857 VDD VSS sg13g2_decap_8
XFILLER_131_1147 VDD VSS sg13g2_fill_2
XFILLER_73_805 VDD VSS sg13g2_decap_8
XFILLER_79_1218 VDD VSS sg13g2_decap_8
XFILLER_45_518 VDD VSS sg13g2_fill_2
X_08777_ _13677_/D _08728_/Y _08776_/Y _08775_/Y VDD VSS sg13g2_a21oi_1
XFILLER_85_698 VDD VSS sg13g2_decap_8
XFILLER_22_1475 VDD VSS sg13g2_decap_4
XFILLER_27_68 VDD VSS sg13g2_fill_1
XFILLER_26_721 VDD VSS sg13g2_decap_8
X_07728_ _07728_/X _13206_/B _13273_/B _07728_/C VDD VSS sg13g2_or3_1
XFILLER_72_348 VDD VSS sg13g2_decap_8
XFILLER_27_79 VDD VSS sg13g2_decap_8
XFILLER_168_1070 VDD VSS sg13g2_decap_8
XFILLER_53_551 VDD VSS sg13g2_decap_4
XFILLER_25_242 VDD VSS sg13g2_decap_8
X_07659_ _07659_/Y _14763_/Q _07658_/X VDD VSS sg13g2_nor2b_1
X_14089__2113 _14089_/RESET_B VDD VSS sg13g2_tiehi
XFILLER_0_1282 VDD VSS sg13g2_decap_8
XFILLER_186_707 VDD VSS sg13g2_decap_8
XFILLER_129_1087 VDD VSS sg13g2_fill_2
X_10670_ _10670_/Y _13300_/B _13507_/A VDD VSS sg13g2_nor2_1
XFILLER_55_1251 VDD VSS sg13g2_decap_8
XFILLER_185_217 VDD VSS sg13g2_decap_8
XFILLER_41_779 VDD VSS sg13g2_decap_8
XFILLER_146_1390 VDD VSS sg13g2_fill_2
XFILLER_167_932 VDD VSS sg13g2_decap_8
XFILLER_159_56 VDD VSS sg13g2_decap_8
XFILLER_181_1281 VDD VSS sg13g2_decap_8
X_09329_ _13936_/D _09463_/A0 _13936_/Q _09329_/S VDD VSS sg13g2_mux2_1
XFILLER_43_89 VDD VSS sg13g2_decap_8
XFILLER_142_1243 VDD VSS sg13g2_fill_1
XFILLER_16_1246 VDD VSS sg13g2_decap_8
XFILLER_22_993 VDD VSS sg13g2_decap_8
XFILLER_90_1186 VDD VSS sg13g2_fill_2
XFILLER_51_1137 VDD VSS sg13g2_decap_8
XFILLER_103_1216 VDD VSS sg13g2_decap_8
XFILLER_138_133 VDD VSS sg13g2_decap_8
XFILLER_127_807 VDD VSS sg13g2_decap_8
XFILLER_107_1396 VDD VSS sg13g2_decap_8
XFILLER_167_987 VDD VSS sg13g2_fill_2
X_14729__1473 _14729_/RESET_B VDD VSS sg13g2_tiehi
X_12340_ _12340_/Y _12340_/A VDD VSS sg13g2_inv_1
XFILLER_175_11 VDD VSS sg13g2_decap_8
XFILLER_177_1317 VDD VSS sg13g2_decap_8
XFILLER_126_339 VDD VSS sg13g2_fill_2
X_12271_ _12297_/A _12271_/A _12278_/A VDD VSS sg13g2_nand2_1
XFILLER_5_658 VDD VSS sg13g2_decap_8
XFILLER_107_553 VDD VSS sg13g2_decap_8
X_14010_ _14010_/Q clkload78/A _14010_/D _14010_/RESET_B VDD VSS sg13g2_dfrbpq_1
X_11222_ _11223_/C _12308_/C _11222_/B VDD VSS sg13g2_nor2_1
XFILLER_175_88 VDD VSS sg13g2_decap_8
XFILLER_4_168 VDD VSS sg13g2_decap_8
XFILLER_134_372 VDD VSS sg13g2_decap_8
XFILLER_4_28 VDD VSS sg13g2_decap_8
XFILLER_107_597 VDD VSS sg13g2_decap_8
X_11153_ _11153_/Y _11152_/Y _11151_/A _11151_/Y _11150_/Y _11193_/A2 VDD VSS sg13g2_a221oi_1
XFILLER_27_1320 VDD VSS sg13g2_decap_8
XFILLER_89_960 VDD VSS sg13g2_decap_8
X_10104_ _14683_/D _10138_/A1 _14683_/Q _10136_/S VDD VSS sg13g2_mux2_1
XFILLER_95_407 VDD VSS sg13g2_decap_8
XFILLER_62_1222 VDD VSS sg13g2_decap_8
XFILLER_1_875 VDD VSS sg13g2_decap_8
X_11084_ _11084_/Y _14948_/Q _11102_/B VDD VSS sg13g2_nand2_1
XFILLER_7_1414 VDD VSS sg13g2_decap_8
XFILLER_122_589 VDD VSS sg13g2_decap_8
XFILLER_103_781 VDD VSS sg13g2_decap_8
XFILLER_153_1372 VDD VSS sg13g2_decap_8
XFILLER_23_1206 VDD VSS sg13g2_decap_8
XFILLER_49_835 VDD VSS sg13g2_fill_2
XFILLER_0_385 VDD VSS sg13g2_decap_8
XFILLER_114_1334 VDD VSS sg13g2_decap_8
X_14912_ _14912_/Q clkload57/A _14912_/D _14912_/RESET_B VDD VSS sg13g2_dfrbpq_1
X_10035_ _14617_/D _10101_/A0 _14617_/Q _10035_/S VDD VSS sg13g2_mux2_1
XFILLER_27_1397 VDD VSS sg13g2_decap_8
XFILLER_49_868 VDD VSS sg13g2_fill_2
X_14299__1903 _14299_/RESET_B VDD VSS sg13g2_tiehi
XFILLER_62_1299 VDD VSS sg13g2_decap_8
XFILLER_76_676 VDD VSS sg13g2_decap_8
X_14843_ _14843_/Q _14848_/CLK _14843_/D _14843_/RESET_B VDD VSS sg13g2_dfrbpq_1
XFILLER_91_635 VDD VSS sg13g2_decap_8
XFILLER_91_646 VDD VSS sg13g2_fill_2
XFILLER_16_220 VDD VSS sg13g2_decap_8
X_14774_ _14774_/Q clkload66/A _14774_/D _14774_/RESET_B VDD VSS sg13g2_dfrbpq_1
XFILLER_1_1057 VDD VSS sg13g2_decap_8
X_11986_ _11986_/Y _11986_/A _11986_/B VDD VSS sg13g2_nor2_1
X_13725_ _13725_/Q clkload29/A _13725_/D _13725_/RESET_B VDD VSS sg13g2_dfrbpq_1
XFILLER_44_562 VDD VSS sg13g2_decap_8
X_10937_ _10937_/Y _10954_/B _10937_/B VDD VSS sg13g2_xnor2_1
XFILLER_90_178 VDD VSS sg13g2_fill_1
XFILLER_56_1026 VDD VSS sg13g2_fill_2
XFILLER_147_1154 VDD VSS sg13g2_decap_4
XFILLER_32_735 VDD VSS sg13g2_decap_8
X_13656_ _15122_/D _15192_/D _15122_/Q _13656_/S VDD VSS sg13g2_mux2_1
XFILLER_31_234 VDD VSS sg13g2_decap_8
XFILLER_143_1029 VDD VSS sg13g2_decap_8
X_10868_ _10869_/B _10890_/A _10890_/B _10868_/C VDD VSS sg13g2_nor3_1
XFILLER_31_245 VDD VSS sg13g2_fill_1
XFILLER_182_1089 VDD VSS sg13g2_decap_8
XFILLER_34_1313 VDD VSS sg13g2_decap_8
XFILLER_125_1441 VDD VSS sg13g2_decap_8
XFILLER_129_100 VDD VSS sg13g2_fill_2
X_12607_ _12607_/X _12600_/X _12604_/X _12599_/X _12603_/X _12608_/S0 _12608_/S1 VDD
+ VSS sg13g2_mux4_1
XFILLER_160_1332 VDD VSS sg13g2_decap_8
XFILLER_9_931 VDD VSS sg13g2_decap_8
X_13587_ _13587_/Y _15161_/Q _13587_/B VDD VSS sg13g2_nor2_1
XFILLER_73_1395 VDD VSS sg13g2_decap_8
X_10799_ _14926_/D _10824_/C1 _10798_/X _10796_/Y VDD VSS sg13g2_o21ai_1
X_15082__2852 _15082_/RESET_B VDD VSS sg13g2_tiehi
XFILLER_129_144 VDD VSS sg13g2_decap_8
XFILLER_185_773 VDD VSS sg13g2_decap_8
X_12538_ _12538_/X _12536_/X _12535_/X _12532_/X _12531_/X _12622_/S0 _12567_/S VDD
+ VSS sg13g2_mux4_1
XFILLER_8_452 VDD VSS sg13g2_decap_8
XFILLER_173_924 VDD VSS sg13g2_fill_2
XFILLER_184_261 VDD VSS sg13g2_decap_8
XFILLER_117_317 VDD VSS sg13g2_decap_4
XFILLER_121_1349 VDD VSS sg13g2_decap_8
XFILLER_69_1409 VDD VSS sg13g2_decap_8
XFILLER_69_4 VDD VSS sg13g2_decap_8
XFILLER_126_840 VDD VSS sg13g2_decap_8
XFILLER_144_136 VDD VSS sg13g2_decap_8
XFILLER_172_445 VDD VSS sg13g2_decap_8
X_13787__2415 _13787_/RESET_B VDD VSS sg13g2_tiehi
X_12469_ _12469_/X _12467_/X _12468_/X _12650_/S VDD VSS sg13g2_mux2_1
XFILLER_32_1092 VDD VSS sg13g2_decap_8
XFILLER_126_851 VDD VSS sg13g2_fill_2
XFILLER_160_607 VDD VSS sg13g2_fill_1
X_14208_ _14208_/Q _15230_/CLK _14208_/D _14208_/RESET_B VDD VSS sg13g2_dfrbpq_1
X_15188_ _15188_/Q _15188_/CLK _15188_/D _15188_/RESET_B VDD VSS sg13g2_dfrbpq_1
XFILLER_153_670 VDD VSS sg13g2_fill_2
X_14139_ _14139_/Q clkload79/A _14139_/D _14139_/RESET_B VDD VSS sg13g2_dfrbpq_1
Xfanout409 _09153_/S _09167_/S VDD VSS sg13g2_buf_1
XFILLER_119_1256 VDD VSS sg13g2_decap_4
XFILLER_67_1199 VDD VSS sg13g2_decap_8
XFILLER_45_1431 VDD VSS sg13g2_decap_8
XFILLER_154_1169 VDD VSS sg13g2_decap_8
XFILLER_100_206 VDD VSS sg13g2_decap_8
XFILLER_101_729 VDD VSS sg13g2_decap_8
X_14167__2035 _14167_/RESET_B VDD VSS sg13g2_tiehi
XFILLER_39_301 VDD VSS sg13g2_decap_8
XFILLER_95_930 VDD VSS sg13g2_decap_8
XFILLER_41_1306 VDD VSS sg13g2_decap_8
XFILLER_39_312 VDD VSS sg13g2_fill_1
X_08700_ _08700_/Y _08698_/X _08697_/Y _08695_/Y _08696_/Y _07974_/D VDD VSS sg13g2_a221oi_1
X_09680_ _14272_/D _10143_/A1 _14272_/Q _09700_/S VDD VSS sg13g2_mux2_1
XFILLER_80_1377 VDD VSS sg13g2_decap_8
XFILLER_12_0 VDD VSS sg13g2_decap_8
X_08631_ _08631_/Y _08641_/A _08630_/Y _08039_/A VDD VSS sg13g2_a21oi_1
XFILLER_67_687 VDD VSS sg13g2_decap_4
XFILLER_94_495 VDD VSS sg13g2_decap_8
X_08562_ _08562_/Y _08030_/Y _08488_/B _08561_/Y VDD VSS sg13g2_o21ai_1
XFILLER_78_1240 VDD VSS sg13g2_decap_8
XFILLER_165_1210 VDD VSS sg13g2_decap_8
XFILLER_82_679 VDD VSS sg13g2_decap_8
XFILLER_23_702 VDD VSS sg13g2_fill_1
XFILLER_39_1224 VDD VSS sg13g2_decap_8
XFILLER_81_178 VDD VSS sg13g2_fill_1
X_08493_ _08494_/B _15008_/Q _08470_/B _13555_/A _08493_/B2 VDD VSS sg13g2_a22oi_1
XFILLER_126_1205 VDD VSS sg13g2_decap_8
XFILLER_126_1216 VDD VSS sg13g2_fill_2
XFILLER_50_543 VDD VSS sg13g2_fill_2
XFILLER_165_1287 VDD VSS sg13g2_decap_8
XFILLER_167_206 VDD VSS sg13g2_decap_8
XFILLER_91_1451 VDD VSS sg13g2_decap_8
XFILLER_52_1424 VDD VSS sg13g2_decap_8
XFILLER_167_239 VDD VSS sg13g2_decap_8
X_14974__2636 _14974_/RESET_B VDD VSS sg13g2_tiehi
XFILLER_31_790 VDD VSS sg13g2_fill_2
X_09114_ _10762_/B _09147_/B _15045_/Q _09113_/Y VDD VSS sg13g2_o21ai_1
XFILLER_109_818 VDD VSS sg13g2_decap_8
XFILLER_149_987 VDD VSS sg13g2_fill_2
XFILLER_176_795 VDD VSS sg13g2_decap_8
XFILLER_89_19 VDD VSS sg13g2_decap_4
XFILLER_11_1121 VDD VSS sg13g2_decap_8
X_09045_ _09045_/Y _09074_/B1 _10716_/B _09044_/X VDD VSS sg13g2_o21ai_1
X_14377__1825 _14377_/RESET_B VDD VSS sg13g2_tiehi
XFILLER_85_1211 VDD VSS sg13g2_decap_8
XFILLER_102_1282 VDD VSS sg13g2_decap_8
XFILLER_135_169 VDD VSS sg13g2_decap_8
XFILLER_116_350 VDD VSS sg13g2_decap_8
XFILLER_117_884 VDD VSS sg13g2_decap_8
XFILLER_104_512 VDD VSS sg13g2_decap_4
XFILLER_11_1198 VDD VSS sg13g2_decap_8
XFILLER_1_105 VDD VSS sg13g2_decap_8
XFILLER_137_1323 VDD VSS sg13g2_decap_8
XFILLER_172_1214 VDD VSS sg13g2_decap_8
XFILLER_176_1394 VDD VSS sg13g2_decap_8
XFILLER_104_545 VDD VSS sg13g2_fill_2
XFILLER_131_331 VDD VSS sg13g2_fill_1
XFILLER_85_1288 VDD VSS sg13g2_decap_8
XFILLER_46_1239 VDD VSS sg13g2_decap_8
Xfanout910 _12725_/S0 _12752_/S0 VDD VSS sg13g2_buf_1
Xfanout921 _13048_/B _13289_/B VDD VSS sg13g2_buf_1
XFILLER_132_898 VDD VSS sg13g2_decap_4
Xfanout932 _12570_/A2 _12639_/A2 VDD VSS sg13g2_buf_1
X_09947_ _14531_/D _14531_/Q _10113_/A0 _09957_/S VDD VSS sg13g2_mux2_1
Xfanout943 _12997_/B _13601_/B VDD VSS sg13g2_buf_1
Xfanout954 _13438_/B _13429_/A VDD VSS sg13g2_buf_1
X_14592__1610 _14592_/RESET_B VDD VSS sg13g2_tiehi
Xfanout965 _12346_/A _15120_/Q VDD VSS sg13g2_buf_1
Xfanout976 _13150_/B _13106_/B VDD VSS sg13g2_buf_1
XFILLER_57_120 VDD VSS sg13g2_decap_8
Xfanout987 _08497_/A _08698_/B VDD VSS sg13g2_buf_1
X_09878_ _14464_/D _09911_/A1 _14464_/Q _09894_/S VDD VSS sg13g2_mux2_1
XFILLER_58_654 VDD VSS sg13g2_decap_8
XFILLER_161_35 VDD VSS sg13g2_decap_8
Xfanout998 _11191_/A _07720_/C VDD VSS sg13g2_buf_1
XFILLER_38_67 VDD VSS sg13g2_decap_8
X_08829_ _08830_/C _15055_/Q _10174_/B _08832_/D VDD VSS sg13g2_nor3_1
XFILLER_46_827 VDD VSS sg13g2_decap_8
XFILLER_45_315 VDD VSS sg13g2_decap_8
XFILLER_79_1037 VDD VSS sg13g2_decap_8
XFILLER_22_1272 VDD VSS sg13g2_decap_8
XFILLER_57_197 VDD VSS sg13g2_decap_8
X_11840_ _11907_/B _11770_/A _13064_/B _13676_/Q _11798_/A VDD VSS sg13g2_a22oi_1
XFILLER_2_1344 VDD VSS sg13g2_decap_8
XFILLER_61_808 VDD VSS sg13g2_decap_8
XFILLER_166_1029 VDD VSS sg13g2_fill_1
XFILLER_26_540 VDD VSS sg13g2_decap_8
XFILLER_57_1324 VDD VSS sg13g2_decap_8
XFILLER_26_573 VDD VSS sg13g2_fill_2
X_11771_ _11771_/Y _11771_/A _11771_/B _11773_/C VDD VSS sg13g2_nor3_1
XFILLER_54_66 VDD VSS sg13g2_decap_8
X_13865__2337 _13865_/RESET_B VDD VSS sg13g2_tiehi
XFILLER_41_510 VDD VSS sg13g2_fill_2
XFILLER_18_1308 VDD VSS sg13g2_decap_8
XFILLER_183_1365 VDD VSS sg13g2_decap_8
X_13510_ _15133_/D _15133_/Q _13510_/A1 _13512_/S VDD VSS sg13g2_mux2_1
XFILLER_186_504 VDD VSS sg13g2_decap_8
X_10722_ _10722_/Y _10725_/A _10720_/B _08885_/Y VDD VSS sg13g2_o21ai_1
XFILLER_41_543 VDD VSS sg13g2_fill_2
X_14490_ _14490_/Q _14682_/CLK _14490_/D _14490_/RESET_B VDD VSS sg13g2_dfrbpq_1
XFILLER_110_50 VDD VSS sg13g2_decap_8
XFILLER_13_256 VDD VSS sg13g2_decap_8
XFILLER_158_217 VDD VSS sg13g2_decap_8
X_13441_ _15102_/D _13421_/Y _13438_/Y _13440_/Y VDD VSS sg13g2_o21ai_1
X_10653_ _10654_/B _10653_/A _10653_/B _10653_/C _10653_/D VDD VSS sg13g2_nand4_1
XFILLER_70_32 VDD VSS sg13g2_decap_8
XFILLER_16_1043 VDD VSS sg13g2_decap_8
XFILLER_9_238 VDD VSS sg13g2_decap_8
XFILLER_186_21 VDD VSS sg13g2_decap_8
XFILLER_139_464 VDD VSS sg13g2_decap_8
XFILLER_167_773 VDD VSS sg13g2_decap_8
XFILLER_10_952 VDD VSS sg13g2_decap_8
XFILLER_166_250 VDD VSS sg13g2_fill_2
X_13372_ _13372_/Y _13437_/A _13407_/B _15077_/Q VDD VSS sg13g2_nand3_1
X_10584_ _10606_/A _14872_/Q _14871_/Q _10584_/C VDD VSS sg13g2_nand3_1
XFILLER_70_87 VDD VSS sg13g2_fill_1
Xclkload19 clkload19/Y clkload19/A VDD VSS sg13g2_inv_2
XFILLER_155_946 VDD VSS sg13g2_decap_4
X_15111_ _15111_/Q _15165_/CLK _15111_/D _15111_/RESET_B VDD VSS sg13g2_dfrbpq_1
XFILLER_177_1114 VDD VSS sg13g2_decap_8
X_12323_ _12324_/A _14266_/Q _14298_/Q _14330_/Q _14362_/Q _12330_/S0 _12307_/C VDD
+ VSS sg13g2_mux4_1
XFILLER_182_743 VDD VSS sg13g2_decap_8
XFILLER_181_231 VDD VSS sg13g2_decap_8
XFILLER_186_98 VDD VSS sg13g2_decap_8
XFILLER_6_956 VDD VSS sg13g2_decap_8
XFILLER_142_607 VDD VSS sg13g2_decap_8
XFILLER_154_467 VDD VSS sg13g2_decap_8
XFILLER_182_776 VDD VSS sg13g2_decap_8
XFILLER_120_1371 VDD VSS sg13g2_decap_8
XFILLER_154_478 VDD VSS sg13g2_fill_1
X_15042_ _15042_/Q _15212_/CLK _15042_/D _15042_/RESET_B VDD VSS sg13g2_dfrbpq_1
XFILLER_5_455 VDD VSS sg13g2_decap_8
X_12254_ _12254_/Y _12186_/A _13848_/Q VDD VSS sg13g2_nand2b_1
XFILLER_108_895 VDD VSS sg13g2_decap_8
XFILLER_123_821 VDD VSS sg13g2_decap_8
XFILLER_29_1415 VDD VSS sg13g2_decap_8
X_11205_ _11205_/X _11205_/A _11205_/B VDD VSS sg13g2_xor2_1
XFILLER_68_1475 VDD VSS sg13g2_decap_4
XFILLER_122_320 VDD VSS sg13g2_decap_8
XFILLER_155_1445 VDD VSS sg13g2_decap_8
X_12185_ _12187_/A _12186_/A _13910_/Q VDD VSS sg13g2_nand2b_1
XFILLER_116_1418 VDD VSS sg13g2_decap_8
XFILLER_110_504 VDD VSS sg13g2_decap_8
X_11136_ _11136_/Y _11146_/B _11136_/B VDD VSS sg13g2_xnor2_1
XFILLER_7_1211 VDD VSS sg13g2_decap_8
XFILLER_1_672 VDD VSS sg13g2_decap_8
XFILLER_89_790 VDD VSS sg13g2_decap_4
XFILLER_77_930 VDD VSS sg13g2_decap_8
XFILLER_77_941 VDD VSS sg13g2_fill_1
XFILLER_49_632 VDD VSS sg13g2_decap_8
XFILLER_0_182 VDD VSS sg13g2_decap_8
XFILLER_110_559 VDD VSS sg13g2_decap_8
X_11067_ _11067_/Y _11118_/A _11088_/A _11066_/Y VDD VSS sg13g2_a21oi_1
XFILLER_95_51 VDD VSS sg13g2_fill_2
XFILLER_27_1194 VDD VSS sg13g2_decap_8
XFILLER_48_142 VDD VSS sg13g2_decap_8
XFILLER_37_805 VDD VSS sg13g2_fill_1
X_10018_ _14600_/D _10084_/A0 _14600_/Q _10024_/S VDD VSS sg13g2_mux2_1
XFILLER_7_1288 VDD VSS sg13g2_decap_8
XFILLER_36_304 VDD VSS sg13g2_decap_4
XFILLER_110_1017 VDD VSS sg13g2_decap_8
XFILLER_49_698 VDD VSS sg13g2_decap_8
XFILLER_92_933 VDD VSS sg13g2_fill_2
XFILLER_149_1205 VDD VSS sg13g2_fill_1
XFILLER_92_944 VDD VSS sg13g2_fill_2
XFILLER_91_421 VDD VSS sg13g2_decap_8
XFILLER_48_197 VDD VSS sg13g2_decap_8
XFILLER_40_1361 VDD VSS sg13g2_decap_8
XFILLER_184_1107 VDD VSS sg13g2_decap_8
X_14826_ _14826_/Q _14893_/CLK _14826_/D _14826_/RESET_B VDD VSS sg13g2_dfrbpq_1
XFILLER_64_657 VDD VSS sg13g2_fill_2
XFILLER_52_819 VDD VSS sg13g2_decap_8
XFILLER_45_860 VDD VSS sg13g2_decap_8
XFILLER_91_476 VDD VSS sg13g2_fill_2
XFILLER_63_178 VDD VSS sg13g2_decap_8
XFILLER_51_318 VDD VSS sg13g2_decap_8
X_14757_ _14757_/Q clkload63/A _14757_/D _14757_/RESET_B VDD VSS sg13g2_dfrbpq_1
XFILLER_17_584 VDD VSS sg13g2_decap_8
X_11969_ _11970_/B _11969_/A _13936_/Q VDD VSS sg13g2_nand2_1
XFILLER_91_498 VDD VSS sg13g2_decap_8
XFILLER_45_893 VDD VSS sg13g2_decap_8
XFILLER_32_510 VDD VSS sg13g2_decap_8
XFILLER_17_595 VDD VSS sg13g2_fill_2
X_14455__1747 _14455_/RESET_B VDD VSS sg13g2_tiehi
XFILLER_162_1416 VDD VSS sg13g2_decap_8
X_13708_ _16870_/A _14602_/CLK _13708_/D _13708_/RESET_B VDD VSS sg13g2_dfrbpq_1
XFILLER_75_1468 VDD VSS sg13g2_decap_8
XFILLER_149_206 VDD VSS sg13g2_decap_4
XFILLER_177_515 VDD VSS sg13g2_decap_8
X_14688_ _14688_/Q clkload23/A _14688_/D _14688_/RESET_B VDD VSS sg13g2_dfrbpq_1
XFILLER_149_239 VDD VSS sg13g2_decap_4
X_13639_ _13747_/D _13639_/A VDD VSS sg13g2_buf_1
XFILLER_73_1192 VDD VSS sg13g2_decap_8
XFILLER_146_902 VDD VSS sg13g2_fill_1
XFILLER_164_209 VDD VSS sg13g2_decap_8
XFILLER_125_1293 VDD VSS sg13g2_decap_8
XFILLER_145_401 VDD VSS sg13g2_fill_2
XFILLER_157_261 VDD VSS sg13g2_decap_8
XFILLER_146_935 VDD VSS sg13g2_fill_2
XFILLER_34_1187 VDD VSS sg13g2_decap_8
XFILLER_185_581 VDD VSS sg13g2_decap_8
XFILLER_30_1029 VDD VSS sg13g2_decap_4
XFILLER_145_423 VDD VSS sg13g2_fill_1
X_14670__1532 _14670_/RESET_B VDD VSS sg13g2_tiehi
XFILLER_69_1206 VDD VSS sg13g2_decap_8
XFILLER_172_220 VDD VSS sg13g2_decap_4
XFILLER_161_905 VDD VSS sg13g2_decap_8
XFILLER_105_309 VDD VSS sg13g2_decap_8
XFILLER_12_1474 VDD VSS sg13g2_decap_4
XFILLER_145_478 VDD VSS sg13g2_decap_4
X_15192__2800 _15192_/RESET_B VDD VSS sg13g2_tiehi
XFILLER_114_821 VDD VSS sg13g2_fill_2
XFILLER_119_1020 VDD VSS sg13g2_decap_8
XFILLER_160_459 VDD VSS sg13g2_decap_8
XFILLER_141_640 VDD VSS sg13g2_decap_8
XFILLER_82_1428 VDD VSS sg13g2_decap_8
Xfanout206 _09925_/A1 _09083_/Y VDD VSS sg13g2_buf_1
XFILLER_119_1064 VDD VSS sg13g2_fill_2
Xfanout217 _10155_/A1 _09070_/Y VDD VSS sg13g2_buf_1
X_09801_ _14390_/D _09933_/A1 _14390_/Q _09805_/S VDD VSS sg13g2_mux2_1
Xfanout228 _10086_/A0 _09058_/Y VDD VSS sg13g2_buf_1
XFILLER_8_1019 VDD VSS sg13g2_decap_8
XFILLER_59_429 VDD VSS sg13g2_decap_8
XFILLER_119_1086 VDD VSS sg13g2_decap_4
X_13943__2259 _13943_/RESET_B VDD VSS sg13g2_tiehi
Xfanout239 _11768_/B1 _11432_/A2 VDD VSS sg13g2_buf_1
X_07993_ _07993_/Y _15100_/Q _15089_/Q VDD VSS sg13g2_nor2_1
XFILLER_101_537 VDD VSS sg13g2_decap_8
XFILLER_68_941 VDD VSS sg13g2_decap_8
X_09732_ _14323_/D _10095_/A0 _14323_/Q _09738_/S VDD VSS sg13g2_mux2_1
XFILLER_86_248 VDD VSS sg13g2_decap_8
XFILLER_41_1103 VDD VSS sg13g2_decap_8
XFILLER_171_1280 VDD VSS sg13g2_decap_8
XFILLER_67_462 VDD VSS sg13g2_fill_1
X_09663_ _14256_/D _09762_/A1 _14256_/Q _09663_/S VDD VSS sg13g2_mux2_1
XFILLER_54_101 VDD VSS sg13g2_fill_2
XFILLER_83_944 VDD VSS sg13g2_decap_8
X_08614_ _08615_/B _08641_/B _08612_/X _08613_/Y VDD VSS sg13g2_o21ai_1
XFILLER_94_292 VDD VSS sg13g2_decap_8
XFILLER_55_657 VDD VSS sg13g2_decap_4
X_09594_ _14191_/D _14191_/Q _09594_/A1 _09604_/S VDD VSS sg13g2_mux2_1
XFILLER_42_307 VDD VSS sg13g2_fill_1
X_08545_ _08545_/X _08545_/A _08545_/B _08545_/C _08545_/D VDD VSS sg13g2_and4_1
XFILLER_78_1070 VDD VSS sg13g2_decap_8
XFILLER_24_14 VDD VSS sg13g2_decap_8
XFILLER_23_532 VDD VSS sg13g2_fill_2
XFILLER_39_1054 VDD VSS sg13g2_decap_8
X_08476_ _08476_/Y _08476_/A _08497_/A VDD VSS sg13g2_nand2_1
XFILLER_50_340 VDD VSS sg13g2_decap_8
XFILLER_168_548 VDD VSS sg13g2_decap_8
XFILLER_23_587 VDD VSS sg13g2_decap_8
XFILLER_126_1068 VDD VSS sg13g2_decap_8
XFILLER_52_1221 VDD VSS sg13g2_decap_8
XFILLER_104_1311 VDD VSS sg13g2_decap_4
XFILLER_149_762 VDD VSS sg13g2_decap_4
XFILLER_10_259 VDD VSS sg13g2_decap_8
XFILLER_137_924 VDD VSS sg13g2_fill_1
XFILLER_17_1385 VDD VSS sg13g2_decap_8
XFILLER_148_261 VDD VSS sg13g2_decap_8
XFILLER_104_1355 VDD VSS sg13g2_fill_1
XFILLER_52_1298 VDD VSS sg13g2_decap_8
X_14500__1702 _14500_/RESET_B VDD VSS sg13g2_tiehi
XFILLER_87_1328 VDD VSS sg13g2_decap_8
XFILLER_156_35 VDD VSS sg13g2_decap_8
XFILLER_136_478 VDD VSS sg13g2_fill_1
XFILLER_178_1467 VDD VSS sg13g2_decap_8
X_09028_ _09031_/B _14905_/Q _09024_/B VDD VSS sg13g2_nor2b_1
XFILLER_178_1478 VDD VSS sg13g2_fill_1
XFILLER_163_275 VDD VSS sg13g2_fill_2
XFILLER_117_692 VDD VSS sg13g2_decap_8
XFILLER_172_1011 VDD VSS sg13g2_decap_8
XFILLER_104_342 VDD VSS sg13g2_decap_8
XFILLER_132_651 VDD VSS sg13g2_decap_8
XFILLER_176_1191 VDD VSS sg13g2_decap_8
XFILLER_160_971 VDD VSS sg13g2_decap_8
XFILLER_2_469 VDD VSS sg13g2_decap_8
XFILLER_46_1047 VDD VSS sg13g2_decap_8
XFILLER_133_1017 VDD VSS sg13g2_decap_8
XFILLER_78_738 VDD VSS sg13g2_decap_8
XFILLER_137_1197 VDD VSS sg13g2_decap_8
X_14533__1669 _14533_/RESET_B VDD VSS sg13g2_tiehi
Xclkbuf_leaf_9_clk_i _14665_/CLK clkbuf_leaf_9_clk_i/A VDD VSS sg13g2_buf_8
Xfanout740 _12233_/B _12257_/B1 VDD VSS sg13g2_buf_1
XFILLER_49_77 VDD VSS sg13g2_decap_8
X_13919__2283 _13919_/RESET_B VDD VSS sg13g2_tiehi
Xfanout751 _13307_/B _07653_/Y VDD VSS sg13g2_buf_1
XFILLER_24_1312 VDD VSS sg13g2_decap_8
XFILLER_172_67 VDD VSS sg13g2_decap_8
Xfanout762 _08199_/B fanout767/X VDD VSS sg13g2_buf_1
XFILLER_63_1372 VDD VSS sg13g2_decap_8
X_13990_ _13990_/Q _14510_/CLK _13990_/D _13990_/RESET_B VDD VSS sg13g2_dfrbpq_1
Xfanout773 _08617_/A _08452_/C VDD VSS sg13g2_buf_1
XFILLER_105_50 VDD VSS sg13g2_fill_2
Xfanout784 _10969_/B _10797_/C VDD VSS sg13g2_buf_1
Xfanout795 _12511_/S _12705_/S1 VDD VSS sg13g2_buf_1
XFILLER_4_1428 VDD VSS sg13g2_decap_8
X_12941_ _15029_/D _12984_/A _12941_/B VDD VSS sg13g2_nor2_1
XFILLER_86_782 VDD VSS sg13g2_decap_8
XFILLER_105_83 VDD VSS sg13g2_decap_8
XFILLER_74_933 VDD VSS sg13g2_decap_8
XFILLER_58_484 VDD VSS sg13g2_decap_8
XFILLER_100_581 VDD VSS sg13g2_decap_8
X_14787__2949 _14787_/RESET_B VDD VSS sg13g2_tiehi
XFILLER_74_944 VDD VSS sg13g2_fill_1
XFILLER_24_1389 VDD VSS sg13g2_decap_8
XFILLER_98_1446 VDD VSS sg13g2_decap_8
XFILLER_85_292 VDD VSS sg13g2_fill_1
XFILLER_59_1408 VDD VSS sg13g2_decap_8
X_12872_ _12872_/X _14899_/Q _13688_/Q VDD VSS sg13g2_and2_1
XFILLER_2_1141 VDD VSS sg13g2_decap_8
XFILLER_74_999 VDD VSS sg13g2_fill_2
XFILLER_164_0 VDD VSS sg13g2_decap_8
X_14611_ _14611_/Q clkload37/A _14611_/D _14611_/RESET_B VDD VSS sg13g2_dfrbpq_1
X_11823_ _11823_/Y _11826_/A1 _13836_/Q VDD VSS sg13g2_nand2b_1
XFILLER_73_487 VDD VSS sg13g2_decap_8
XFILLER_45_178 VDD VSS sg13g2_decap_8
XFILLER_57_1121 VDD VSS sg13g2_decap_8
XFILLER_61_649 VDD VSS sg13g2_decap_8
XFILLER_109_1222 VDD VSS sg13g2_decap_8
XFILLER_18_1105 VDD VSS sg13g2_decap_8
X_14542_ _14542_/Q clkload58/A _14542_/D _14542_/RESET_B VDD VSS sg13g2_dfrbpq_1
XFILLER_121_93 VDD VSS sg13g2_decap_8
XFILLER_183_1162 VDD VSS sg13g2_decap_8
X_11754_ _11754_/X _11754_/A _11875_/B VDD VSS sg13g2_and2_1
XFILLER_92_1045 VDD VSS sg13g2_decap_8
XFILLER_148_1293 VDD VSS sg13g2_decap_8
XFILLER_186_301 VDD VSS sg13g2_decap_8
X_14838__2891 _14838_/RESET_B VDD VSS sg13g2_tiehi
XFILLER_81_42 VDD VSS sg13g2_decap_8
XFILLER_57_1198 VDD VSS sg13g2_decap_8
X_10705_ _10936_/D _09021_/X _10710_/A2 _08869_/Y VDD VSS sg13g2_a21o_1
X_14473_ _14473_/Q clkload30/A _14473_/D _14473_/RESET_B VDD VSS sg13g2_dfrbpq_1
X_11685_ _11685_/Y _11681_/Y _11682_/Y _11684_/Y _11683_/Y _11696_/B VDD VSS sg13g2_a221oi_1
XFILLER_70_1343 VDD VSS sg13g2_decap_8
XFILLER_161_1471 VDD VSS sg13g2_decap_4
XFILLER_186_378 VDD VSS sg13g2_decap_8
X_13424_ _13444_/C _13469_/A _15130_/Q VDD VSS sg13g2_nand2_1
X_10636_ _10642_/C _10636_/A _10636_/B VDD VSS sg13g2_nor2_1
XFILLER_14_91 VDD VSS sg13g2_decap_8
XFILLER_155_732 VDD VSS sg13g2_fill_2
XFILLER_31_1349 VDD VSS sg13g2_decap_8
X_13355_ _13469_/C _13401_/C _13401_/B _13391_/A VDD VSS sg13g2_nor3_1
X_10567_ _10579_/C _10567_/A _10567_/B _10567_/C _10567_/D VDD VSS sg13g2_nor4_1
XFILLER_143_905 VDD VSS sg13g2_fill_1
XFILLER_155_765 VDD VSS sg13g2_fill_2
XFILLER_6_753 VDD VSS sg13g2_decap_8
XFILLER_182_562 VDD VSS sg13g2_decap_8
X_12306_ _12307_/B _12306_/A _14234_/Q VDD VSS sg13g2_nand2_1
XFILLER_155_798 VDD VSS sg13g2_decap_8
XFILLER_5_252 VDD VSS sg13g2_decap_8
XFILLER_142_415 VDD VSS sg13g2_decap_8
XFILLER_170_724 VDD VSS sg13g2_decap_8
X_13286_ _13287_/B _13297_/S _07751_/Y _07710_/Y VDD VSS sg13g2_o21ai_1
XFILLER_53_7 VDD VSS sg13g2_decap_8
X_10498_ _10499_/B _14853_/Q _14852_/Q _10513_/D _10498_/D VDD VSS sg13g2_nand4_1
X_15025_ _15025_/Q _15196_/CLK _15025_/D _15025_/RESET_B VDD VSS sg13g2_dfrbpq_1
XFILLER_29_1212 VDD VSS sg13g2_decap_8
X_12237_ _12237_/Y _12237_/A _12237_/B _12237_/C VDD VSS sg13g2_nand3_1
XFILLER_68_1272 VDD VSS sg13g2_decap_8
XFILLER_9_1339 VDD VSS sg13g2_decap_8
X_12168_ _12169_/B _12168_/A _14678_/Q VDD VSS sg13g2_nand2_1
XFILLER_68_215 VDD VSS sg13g2_decap_8
XFILLER_64_1169 VDD VSS sg13g2_decap_8
XFILLER_29_1289 VDD VSS sg13g2_decap_8
XFILLER_42_1401 VDD VSS sg13g2_decap_8
XFILLER_111_857 VDD VSS sg13g2_decap_8
X_11119_ _11119_/Y _11119_/A _11119_/B VDD VSS sg13g2_nor2_1
XFILLER_81_1461 VDD VSS sg13g2_decap_8
X_14509__1693 _14509_/RESET_B VDD VSS sg13g2_tiehi
XFILLER_110_356 VDD VSS sg13g2_decap_4
X_12099_ _12099_/Y _12095_/Y _12096_/Y _12098_/Y _12097_/Y _12101_/B VDD VSS sg13g2_a221oi_1
XFILLER_49_462 VDD VSS sg13g2_decap_4
Xinput6 input6/X input6/A VDD VSS sg13g2_buf_1
XFILLER_83_229 VDD VSS sg13g2_decap_8
XFILLER_7_1085 VDD VSS sg13g2_decap_8
XFILLER_77_793 VDD VSS sg13g2_decap_8
XFILLER_42_1478 VDD VSS sg13g2_fill_1
XFILLER_36_101 VDD VSS sg13g2_decap_8
XFILLER_36_145 VDD VSS sg13g2_decap_8
XFILLER_64_465 VDD VSS sg13g2_decap_8
X_14688__1514 _14688_/RESET_B VDD VSS sg13g2_tiehi
XFILLER_18_882 VDD VSS sg13g2_decap_8
X_14809_ _14809_/Q clkload85/A _14809_/D _14809_/RESET_B VDD VSS sg13g2_dfrbpq_1
XFILLER_91_284 VDD VSS sg13g2_fill_2
XFILLER_166_1360 VDD VSS sg13g2_decap_8
X_08330_ _08330_/Y _08544_/C _08484_/C _08329_/Y VDD VSS sg13g2_o21ai_1
XFILLER_162_1213 VDD VSS sg13g2_decap_8
XFILLER_75_1265 VDD VSS sg13g2_decap_8
XFILLER_178_857 VDD VSS sg13g2_decap_8
XFILLER_20_513 VDD VSS sg13g2_decap_8
X_08261_ _08261_/Y _08539_/B1 _08590_/B _08260_/Y VDD VSS sg13g2_o21ai_1
XFILLER_127_1377 VDD VSS sg13g2_decap_8
XFILLER_123_1219 VDD VSS sg13g2_decap_8
XFILLER_165_507 VDD VSS sg13g2_decap_4
XFILLER_20_557 VDD VSS sg13g2_fill_1
XFILLER_177_389 VDD VSS sg13g2_decap_8
X_08192_ _08192_/Y _07890_/B _08191_/Y _08499_/B1 VDD VSS sg13g2_o21ai_1
XFILLER_119_935 VDD VSS sg13g2_fill_2
XFILLER_134_916 VDD VSS sg13g2_decap_8
XFILLER_69_1036 VDD VSS sg13g2_decap_4
XFILLER_12_1271 VDD VSS sg13g2_decap_8
XFILLER_69_1058 VDD VSS sg13g2_fill_2
XFILLER_161_735 VDD VSS sg13g2_decap_8
X_14891__2785 _14891_/RESET_B VDD VSS sg13g2_tiehi
XFILLER_127_990 VDD VSS sg13g2_fill_2
XFILLER_10_49 VDD VSS sg13g2_decap_8
XFILLER_105_139 VDD VSS sg13g2_decap_8
XFILLER_47_1312 VDD VSS sg13g2_decap_8
XFILLER_114_640 VDD VSS sg13g2_decap_8
XFILLER_161_779 VDD VSS sg13g2_decap_8
XFILLER_82_1225 VDD VSS sg13g2_decap_8
XFILLER_0_918 VDD VSS sg13g2_decap_8
XFILLER_142_971 VDD VSS sg13g2_fill_2
XFILLER_99_362 VDD VSS sg13g2_decap_8
XFILLER_101_312 VDD VSS sg13g2_fill_2
XFILLER_173_1386 VDD VSS sg13g2_decap_8
XFILLER_47_1389 VDD VSS sg13g2_decap_8
XFILLER_102_846 VDD VSS sg13g2_decap_8
XFILLER_141_492 VDD VSS sg13g2_fill_2
XFILLER_19_14 VDD VSS sg13g2_decap_8
X_07976_ _07976_/X _07976_/A _07976_/B _07976_/C VDD VSS sg13g2_or3_1
XFILLER_101_367 VDD VSS sg13g2_decap_4
XFILLER_142_26 VDD VSS sg13g2_decap_8
XFILLER_74_207 VDD VSS sg13g2_decap_8
XFILLER_132_1050 VDD VSS sg13g2_decap_8
X_09715_ _14306_/D _09814_/A0 _14306_/Q _09729_/S VDD VSS sg13g2_mux2_1
XFILLER_68_771 VDD VSS sg13g2_fill_1
XFILLER_67_270 VDD VSS sg13g2_decap_8
XFILLER_83_741 VDD VSS sg13g2_fill_1
X_09646_ _14239_/D _09745_/A1 _14239_/Q _09659_/S VDD VSS sg13g2_mux2_1
XFILLER_71_925 VDD VSS sg13g2_decap_8
XFILLER_43_627 VDD VSS sg13g2_decap_8
XFILLER_128_1108 VDD VSS sg13g2_decap_8
XFILLER_167_1157 VDD VSS sg13g2_decap_8
X_09577_ _14174_/D _14174_/Q _10074_/A0 _09589_/S VDD VSS sg13g2_mux2_1
XFILLER_58_1441 VDD VSS sg13g2_decap_8
XFILLER_82_295 VDD VSS sg13g2_decap_8
XFILLER_24_830 VDD VSS sg13g2_decap_8
XFILLER_145_1411 VDD VSS sg13g2_decap_8
X_08528_ _08567_/C _07815_/X _07822_/B _07816_/X VDD VSS sg13g2_a21oi_1
XFILLER_42_159 VDD VSS sg13g2_decap_8
XFILLER_19_1436 VDD VSS sg13g2_decap_8
X_13782__2420 _13782_/RESET_B VDD VSS sg13g2_tiehi
XFILLER_24_885 VDD VSS sg13g2_decap_8
XFILLER_180_1357 VDD VSS sg13g2_decap_8
X_08459_ _08459_/Y _08281_/Y _08212_/A _08539_/B1 VDD VSS sg13g2_a21oi_1
XFILLER_184_805 VDD VSS sg13g2_decap_8
XFILLER_106_1439 VDD VSS sg13g2_decap_8
XFILLER_11_557 VDD VSS sg13g2_decap_8
XFILLER_168_378 VDD VSS sg13g2_decap_8
XFILLER_52_1040 VDD VSS sg13g2_decap_8
XFILLER_137_710 VDD VSS sg13g2_decap_8
X_11470_ _11470_/X _14561_/Q _14593_/Q _14625_/Q _14657_/Q _11473_/S0 _11473_/S1 VDD
+ VSS sg13g2_mux4_1
XFILLER_104_1130 VDD VSS sg13g2_decap_4
XFILLER_17_1182 VDD VSS sg13g2_decap_8
XFILLER_183_326 VDD VSS sg13g2_decap_8
XFILLER_109_412 VDD VSS sg13g2_fill_1
XFILLER_177_890 VDD VSS sg13g2_decap_8
XFILLER_7_539 VDD VSS sg13g2_decap_8
X_10421_ _10423_/A _14830_/Q _10421_/B VDD VSS sg13g2_nand2b_1
XFILLER_104_1163 VDD VSS sg13g2_decap_8
XFILLER_167_67 VDD VSS sg13g2_decap_8
XFILLER_52_1095 VDD VSS sg13g2_decap_8
XFILLER_13_1068 VDD VSS sg13g2_decap_8
X_14162__2040 _14162_/RESET_B VDD VSS sg13g2_tiehi
XFILLER_137_787 VDD VSS sg13g2_fill_2
X_13140_ _13141_/B _13154_/A1 _13136_/X _13139_/Y _13297_/A0 _13135_/Y VDD VSS sg13g2_a221oi_1
XFILLER_125_938 VDD VSS sg13g2_decap_8
XFILLER_178_1264 VDD VSS sg13g2_decap_8
X_10352_ _10353_/B _14809_/Q _14810_/Q _10352_/C VDD VSS sg13g2_nand3_1
XFILLER_139_1226 VDD VSS sg13g2_fill_1
XFILLER_183_11 VDD VSS sg13g2_decap_8
XFILLER_139_1248 VDD VSS sg13g2_decap_4
XFILLER_139_1259 VDD VSS sg13g2_decap_8
X_13071_ _13071_/Y _13068_/Y _13069_/Y _13070_/Y VDD VSS sg13g2_a21oi_1
X_10283_ _10286_/A _14788_/Q _10311_/A _14789_/Q VDD VSS sg13g2_a21o_1
XFILLER_3_767 VDD VSS sg13g2_decap_8
XFILLER_65_1445 VDD VSS sg13g2_decap_8
XFILLER_105_673 VDD VSS sg13g2_decap_8
X_12022_ _12022_/X _14578_/Q _14610_/Q _12025_/A VDD VSS sg13g2_mux2_1
XFILLER_2_266 VDD VSS sg13g2_decap_8
XFILLER_183_88 VDD VSS sg13g2_decap_8
XFILLER_61_1309 VDD VSS sg13g2_decap_8
XFILLER_152_1459 VDD VSS sg13g2_decap_8
XFILLER_116_93 VDD VSS sg13g2_decap_8
XFILLER_76_42 VDD VSS sg13g2_decap_8
Xfanout570 _08110_/D _08036_/B VDD VSS sg13g2_buf_1
Xfanout581 _13297_/A0 _12808_/Y VDD VSS sg13g2_buf_1
Xfanout592 _11931_/A2 _12338_/A2 VDD VSS sg13g2_buf_1
XFILLER_8_1383 VDD VSS sg13g2_decap_8
XFILLER_19_624 VDD VSS sg13g2_decap_4
X_13973_ _13973_/Q _14677_/CLK _13973_/D _13973_/RESET_B VDD VSS sg13g2_dfrbpq_1
XFILLER_98_1210 VDD VSS sg13g2_decap_8
XFILLER_4_1225 VDD VSS sg13g2_decap_8
XFILLER_150_1172 VDD VSS sg13g2_decap_8
XFILLER_18_123 VDD VSS sg13g2_decap_8
XFILLER_46_432 VDD VSS sg13g2_decap_8
XFILLER_24_1186 VDD VSS sg13g2_decap_8
X_12924_ _12943_/D _12925_/A _12925_/B _12925_/C VDD VSS sg13g2_and3_1
XFILLER_74_752 VDD VSS sg13g2_decap_4
XFILLER_59_1205 VDD VSS sg13g2_decap_8
XFILLER_19_668 VDD VSS sg13g2_decap_8
XFILLER_73_251 VDD VSS sg13g2_fill_1
XFILLER_47_999 VDD VSS sg13g2_decap_8
XFILLER_111_1178 VDD VSS sg13g2_decap_8
XFILLER_94_1118 VDD VSS sg13g2_decap_8
XFILLER_34_616 VDD VSS sg13g2_decap_8
XFILLER_98_1298 VDD VSS sg13g2_fill_2
XFILLER_74_796 VDD VSS sg13g2_decap_8
XFILLER_185_1257 VDD VSS sg13g2_decap_8
X_12855_ _12855_/Y _12845_/Y _12983_/A1 _12854_/Y VDD VSS sg13g2_a21oi_1
XFILLER_62_947 VDD VSS sg13g2_fill_1
XFILLER_73_284 VDD VSS sg13g2_decap_8
X_11806_ _11806_/Y _11806_/A _11806_/B _11898_/C VDD VSS sg13g2_nand3_1
XFILLER_72_1405 VDD VSS sg13g2_decap_8
XFILLER_159_301 VDD VSS sg13g2_decap_8
X_12786_ _12786_/X _13850_/Q _13882_/Q _13914_/Q _13946_/Q _12786_/S0 _12786_/S1 VDD
+ VSS sg13g2_mux4_1
XFILLER_92_96 VDD VSS sg13g2_decap_8
X_14525_ _14525_/Q clkload32/A _14525_/D _14525_/RESET_B VDD VSS sg13g2_dfrbpq_1
XFILLER_159_345 VDD VSS sg13g2_decap_8
X_14372__1830 _14372_/RESET_B VDD VSS sg13g2_tiehi
X_11737_ _11737_/Y _11734_/Y _11736_/X _11559_/C VDD VSS sg13g2_o21ai_1
XFILLER_30_866 VDD VSS sg13g2_decap_8
X_14456_ _14456_/Q _14742_/CLK _14456_/D _14456_/RESET_B VDD VSS sg13g2_dfrbpq_1
XFILLER_186_175 VDD VSS sg13g2_decap_8
X_11668_ _11668_/Y _11686_/S0 _13928_/Q _11529_/B VDD VSS sg13g2_a21oi_1
XFILLER_35_1282 VDD VSS sg13g2_decap_8
X_13407_ _13407_/Y _13437_/A _13407_/B _15091_/Q VDD VSS sg13g2_nand3_1
X_10619_ _14881_/D _10619_/A _10626_/B _10619_/C VDD VSS sg13g2_and3_1
X_14387_ _14387_/Q _15160_/CLK _14387_/D _14387_/RESET_B VDD VSS sg13g2_dfrbpq_1
XFILLER_31_1146 VDD VSS sg13g2_decap_8
X_11599_ _11599_/Y _11599_/A _11599_/B _11898_/C VDD VSS sg13g2_nand3_1
XFILLER_116_927 VDD VSS sg13g2_decap_8
XFILLER_6_550 VDD VSS sg13g2_decap_8
XFILLER_155_573 VDD VSS sg13g2_fill_1
X_13338_ _13351_/B _13338_/A _13486_/B _15169_/D VDD VSS sg13g2_nand3_1
XFILLER_157_1315 VDD VSS sg13g2_decap_8
XFILLER_109_990 VDD VSS sg13g2_fill_1
XFILLER_143_746 VDD VSS sg13g2_decap_8
X_13269_ _13269_/Y _13270_/A _13270_/B _13270_/C VDD VSS sg13g2_a21oi_1
Xhold3109 hold3109/X _14795_/Q VDD VSS sg13g2_dlygate4sd3_1
X_15008_ _15008_/Q _15230_/CLK _15008_/D _15008_/RESET_B VDD VSS sg13g2_dfrbpq_1
XFILLER_29_1053 VDD VSS sg13g2_decap_8
XFILLER_123_470 VDD VSS sg13g2_decap_8
XFILLER_69_524 VDD VSS sg13g2_decap_8
X_07830_ _07834_/A _12298_/A _08692_/C VDD VSS sg13g2_nor2b_1
XFILLER_97_888 VDD VSS sg13g2_fill_2
X_14025__2177 _14025_/RESET_B VDD VSS sg13g2_tiehi
X_13860__2342 _13860_/RESET_B VDD VSS sg13g2_tiehi
XFILLER_116_1089 VDD VSS sg13g2_decap_8
X_07761_ _14766_/D _13596_/B _07761_/B VDD VSS sg13g2_and2_1
XFILLER_84_538 VDD VSS sg13g2_decap_8
XFILLER_49_270 VDD VSS sg13g2_decap_8
XFILLER_42_1275 VDD VSS sg13g2_decap_8
X_09500_ _14100_/D _10063_/A0 _14100_/Q _09500_/S VDD VSS sg13g2_mux2_1
X_07692_ _07701_/B _07690_/A _11241_/C _07679_/D VDD VSS sg13g2_a21oi_1
XFILLER_168_1433 VDD VSS sg13g2_decap_8
XFILLER_38_988 VDD VSS sg13g2_decap_4
XFILLER_80_711 VDD VSS sg13g2_decap_8
XFILLER_77_1327 VDD VSS sg13g2_decap_8
XFILLER_37_476 VDD VSS sg13g2_decap_8
X_09431_ _14033_/D _09961_/A1 _14033_/Q _09438_/S VDD VSS sg13g2_mux2_1
XFILLER_65_796 VDD VSS sg13g2_decap_8
XFILLER_164_1308 VDD VSS sg13g2_decap_8
XFILLER_24_115 VDD VSS sg13g2_fill_2
XFILLER_18_690 VDD VSS sg13g2_decap_4
XFILLER_80_744 VDD VSS sg13g2_fill_2
XFILLER_52_435 VDD VSS sg13g2_fill_1
X_09362_ _13966_/D _10057_/A0 _13966_/Q _09362_/S VDD VSS sg13g2_mux2_1
XFILLER_40_619 VDD VSS sg13g2_decap_8
XFILLER_80_799 VDD VSS sg13g2_fill_1
X_08313_ _15229_/D _08539_/B1 _08625_/B _08312_/Y VDD VSS sg13g2_o21ai_1
X_09293_ _13901_/D _13901_/Q _09891_/A0 _09296_/S VDD VSS sg13g2_mux2_1
XANTENNA_11 _16872_/A VDD VSS sg13g2_antennanp
XFILLER_166_805 VDD VSS sg13g2_fill_2
XFILLER_20_321 VDD VSS sg13g2_decap_8
XANTENNA_22 _09560_/S VDD VSS sg13g2_antennanp
XFILLER_127_1196 VDD VSS sg13g2_decap_8
X_08244_ _08244_/Y _08008_/B _08244_/B VDD VSS sg13g2_nand2b_1
XFILLER_165_326 VDD VSS sg13g2_decap_8
XFILLER_105_1450 VDD VSS sg13g2_decap_8
XFILLER_101_1303 VDD VSS sg13g2_decap_8
X_08175_ _08175_/Y _08188_/B _08432_/A2 _08654_/B VDD VSS sg13g2_o21ai_1
XFILLER_101_1314 VDD VSS sg13g2_fill_1
XFILLER_107_905 VDD VSS sg13g2_decap_8
XFILLER_14_1366 VDD VSS sg13g2_decap_8
XFILLER_107_916 VDD VSS sg13g2_fill_1
XFILLER_107_927 VDD VSS sg13g2_decap_4
XFILLER_134_702 VDD VSS sg13g2_decap_8
XFILLER_146_584 VDD VSS sg13g2_fill_2
XFILLER_88_1467 VDD VSS sg13g2_decap_8
XFILLER_101_1369 VDD VSS sg13g2_decap_8
XFILLER_134_746 VDD VSS sg13g2_decap_8
XFILLER_173_381 VDD VSS sg13g2_decap_8
XFILLER_175_1426 VDD VSS sg13g2_decap_8
XFILLER_88_1478 VDD VSS sg13g2_fill_1
XFILLER_84_1309 VDD VSS sg13g2_decap_8
XFILLER_49_1429 VDD VSS sg13g2_decap_8
X_14235__1967 _14235_/RESET_B VDD VSS sg13g2_tiehi
XFILLER_122_908 VDD VSS sg13g2_fill_1
Xclkbuf_leaf_74_clk_i _14848_/CLK clkbuf_leaf_75_clk_i/A VDD VSS sg13g2_buf_8
Xoutput140 mem_axi_wvalid _07662_/Y VDD VSS sg13g2_buf_1
XFILLER_121_407 VDD VSS sg13g2_decap_4
XFILLER_82_1022 VDD VSS sg13g2_decap_8
XFILLER_134_1101 VDD VSS sg13g2_fill_2
XFILLER_138_1270 VDD VSS sg13g2_decap_8
XFILLER_142_790 VDD VSS sg13g2_decap_8
XFILLER_153_25 VDD VSS sg13g2_decap_8
XFILLER_114_492 VDD VSS sg13g2_fill_1
XFILLER_102_643 VDD VSS sg13g2_fill_2
XFILLER_173_1183 VDD VSS sg13g2_decap_8
XFILLER_47_1186 VDD VSS sg13g2_decap_8
XFILLER_101_131 VDD VSS sg13g2_decap_4
XFILLER_88_888 VDD VSS sg13g2_decap_8
XFILLER_101_164 VDD VSS sg13g2_decap_8
X_14450__1752 _14450_/RESET_B VDD VSS sg13g2_tiehi
Xclkbuf_leaf_89_clk_i _15196_/CLK clkbuf_leaf_92_clk_i/A VDD VSS sg13g2_buf_8
X_07959_ _07959_/Y _07961_/B VDD VSS sg13g2_inv_1
XFILLER_60_1364 VDD VSS sg13g2_decap_8
XFILLER_21_1337 VDD VSS sg13g2_decap_8
XFILLER_29_966 VDD VSS sg13g2_decap_4
XFILLER_112_1454 VDD VSS sg13g2_decap_8
XFILLER_112_1465 VDD VSS sg13g2_fill_1
X_10970_ _10970_/Y _11017_/A1 _10964_/Y _10969_/Y VDD VSS sg13g2_a21oi_1
XFILLER_90_519 VDD VSS sg13g2_decap_8
XFILLER_56_774 VDD VSS sg13g2_decap_8
X_09629_ _14225_/D _09928_/A1 _14225_/Q _09637_/S VDD VSS sg13g2_mux2_1
Xclkbuf_leaf_12_clk_i clkload31/A clkload2/A VDD VSS sg13g2_buf_8
XFILLER_15_126 VDD VSS sg13g2_decap_8
XFILLER_71_755 VDD VSS sg13g2_decap_8
X_12640_ _12640_/X _13840_/Q _13872_/Q _13904_/Q _13936_/Q _12647_/S0 _12647_/S1 VDD
+ VSS sg13g2_mux4_1
XFILLER_62_11 VDD VSS sg13g2_decap_8
XFILLER_93_1140 VDD VSS sg13g2_fill_2
X_13723__2479 _13723_/RESET_B VDD VSS sg13g2_tiehi
XFILLER_145_1230 VDD VSS sg13g2_decap_8
XFILLER_19_1233 VDD VSS sg13g2_decap_8
XFILLER_70_276 VDD VSS sg13g2_fill_2
XFILLER_169_643 VDD VSS sg13g2_decap_8
XFILLER_24_682 VDD VSS sg13g2_decap_8
X_12571_ _12571_/X _14571_/Q _14603_/Q _14635_/Q _14667_/Q _12576_/S0 _12576_/S1 VDD
+ VSS sg13g2_mux4_1
XFILLER_12_844 VDD VSS sg13g2_decap_8
XFILLER_129_507 VDD VSS sg13g2_decap_4
XFILLER_180_1154 VDD VSS sg13g2_decap_8
XFILLER_23_181 VDD VSS sg13g2_decap_8
XFILLER_54_1157 VDD VSS sg13g2_decap_8
XFILLER_141_1116 VDD VSS sg13g2_decap_8
X_14310_ _14310_/Q clkload52/A _14310_/D _14310_/RESET_B VDD VSS sg13g2_dfrbpq_1
XFILLER_62_88 VDD VSS sg13g2_decap_8
XFILLER_168_164 VDD VSS sg13g2_decap_8
X_11522_ _14965_/D _11502_/A _11768_/B1 _11521_/Y VDD VSS sg13g2_a21o_1
XFILLER_32_1400 VDD VSS sg13g2_decap_8
XFILLER_11_354 VDD VSS sg13g2_decap_8
XFILLER_178_77 VDD VSS sg13g2_decap_8
Xclkbuf_leaf_27_clk_i clkload39/A clkbuf_leaf_30_clk_i/A VDD VSS sg13g2_buf_8
XFILLER_71_1460 VDD VSS sg13g2_decap_8
XFILLER_8_837 VDD VSS sg13g2_decap_8
XFILLER_7_28 VDD VSS sg13g2_decap_8
XFILLER_183_123 VDD VSS sg13g2_decap_8
XFILLER_127_0 VDD VSS sg13g2_decap_8
X_14241_ _14241_/Q clkload9/A _14241_/D _14241_/RESET_B VDD VSS sg13g2_dfrbpq_1
XFILLER_7_336 VDD VSS sg13g2_decap_8
XFILLER_172_808 VDD VSS sg13g2_decap_8
XFILLER_184_668 VDD VSS sg13g2_decap_8
X_11453_ _11457_/A _11454_/A _13688_/Q VDD VSS sg13g2_or2_1
XFILLER_184_679 VDD VSS sg13g2_fill_1
X_14103__2099 _14103_/RESET_B VDD VSS sg13g2_tiehi
XFILLER_32_1477 VDD VSS sg13g2_fill_2
X_10404_ _10406_/C _14823_/Q _10413_/B _14824_/Q VDD VSS sg13g2_a21oi_1
X_14172_ _14172_/Q _14588_/CLK _14172_/D _14172_/RESET_B VDD VSS sg13g2_dfrbpq_1
X_11384_ _11385_/B _11384_/A _13690_/Q VDD VSS sg13g2_xnor2_1
XFILLER_178_1061 VDD VSS sg13g2_decap_8
XFILLER_125_757 VDD VSS sg13g2_decap_8
X_13123_ _13123_/Y _14787_/Q _13164_/A2 _13275_/B1 VDD VSS sg13g2_o21ai_1
XFILLER_113_908 VDD VSS sg13g2_fill_1
XFILLER_180_863 VDD VSS sg13g2_decap_8
X_10335_ _10337_/A _14805_/Q _10335_/B VDD VSS sg13g2_nand2b_1
XFILLER_11_81 VDD VSS sg13g2_decap_8
XFILLER_125_779 VDD VSS sg13g2_decap_8
XFILLER_98_619 VDD VSS sg13g2_fill_2
XFILLER_112_407 VDD VSS sg13g2_decap_8
X_14987__2623 _14987_/RESET_B VDD VSS sg13g2_tiehi
XFILLER_3_564 VDD VSS sg13g2_decap_8
XFILLER_106_982 VDD VSS sg13g2_decap_8
XFILLER_139_1078 VDD VSS sg13g2_decap_8
X_13054_ _13054_/Y _13164_/A2 _13052_/Y _13053_/Y VDD VSS sg13g2_a21oi_1
XFILLER_65_1242 VDD VSS sg13g2_decap_8
XFILLER_140_749 VDD VSS sg13g2_decap_4
X_10266_ _14783_/D _10278_/C _12812_/A _10266_/C VDD VSS sg13g2_nor3_1
XFILLER_156_1392 VDD VSS sg13g2_decap_8
Xfanout1310 _12288_/S1 _12283_/S1 VDD VSS sg13g2_buf_1
X_12005_ _12006_/B _11458_/A _11989_/Y _12004_/Y VDD VSS sg13g2_o21ai_1
Xfanout1321 _11473_/S0 fanout1329/X VDD VSS sg13g2_buf_1
XFILLER_117_1365 VDD VSS sg13g2_fill_1
XFILLER_121_963 VDD VSS sg13g2_decap_8
Xfanout1332 _12087_/S _11788_/S0 VDD VSS sg13g2_buf_1
XFILLER_120_451 VDD VSS sg13g2_fill_2
Xfanout1343 _11551_/A1 _11555_/S0 VDD VSS sg13g2_buf_1
X_10197_ _15199_/D input27/X _15199_/Q _10203_/S VDD VSS sg13g2_mux2_1
XFILLER_152_1267 VDD VSS sg13g2_decap_8
Xfanout1354 _11403_/S0 fanout1361/X VDD VSS sg13g2_buf_1
XFILLER_113_1229 VDD VSS sg13g2_fill_1
Xfanout1365 _11899_/S0 fanout1394/X VDD VSS sg13g2_buf_1
XFILLER_66_527 VDD VSS sg13g2_fill_1
Xfanout1376 _12017_/A _12259_/S0 VDD VSS sg13g2_buf_1
XFILLER_93_324 VDD VSS sg13g2_decap_8
XFILLER_8_1180 VDD VSS sg13g2_decap_8
Xfanout1387 _11282_/S0 fanout1388/X VDD VSS sg13g2_buf_1
XFILLER_94_858 VDD VSS sg13g2_decap_8
XFILLER_4_1022 VDD VSS sg13g2_decap_8
Xfanout1398 _13155_/A _13141_/A VDD VSS sg13g2_buf_1
XFILLER_19_432 VDD VSS sg13g2_decap_8
XFILLER_47_752 VDD VSS sg13g2_fill_2
X_13956_ _13956_/Q clkload49/A _13956_/D _13956_/RESET_B VDD VSS sg13g2_dfrbpq_1
XFILLER_47_774 VDD VSS sg13g2_fill_1
XFILLER_35_925 VDD VSS sg13g2_decap_8
XFILLER_19_487 VDD VSS sg13g2_decap_8
XFILLER_35_936 VDD VSS sg13g2_fill_2
X_12907_ _12909_/C _12943_/A _12925_/C VDD VSS sg13g2_nand2b_1
XFILLER_4_1099 VDD VSS sg13g2_decap_8
X_13887_ _13887_/Q _14495_/CLK _13887_/D _13887_/RESET_B VDD VSS sg13g2_dfrbpq_1
XFILLER_185_1054 VDD VSS sg13g2_decap_8
XFILLER_34_435 VDD VSS sg13g2_decap_8
XFILLER_59_1068 VDD VSS sg13g2_decap_8
XFILLER_61_243 VDD VSS sg13g2_decap_8
X_12838_ _12838_/Y _12838_/A _13134_/C VDD VSS sg13g2_nor2b_1
XFILLER_62_777 VDD VSS sg13g2_decap_8
XFILLER_34_479 VDD VSS sg13g2_fill_1
XFILLER_72_1202 VDD VSS sg13g2_decap_8
XFILLER_37_1322 VDD VSS sg13g2_decap_8
X_14313__1889 _14313_/RESET_B VDD VSS sg13g2_tiehi
XFILLER_99_4 VDD VSS sg13g2_decap_8
XFILLER_124_1303 VDD VSS sg13g2_decap_4
XFILLER_163_1352 VDD VSS sg13g2_decap_8
XFILLER_148_805 VDD VSS sg13g2_decap_4
X_12769_ _12769_/X _14713_/Q _14745_/Q _13785_/Q _13817_/Q _12773_/S0 _12773_/S1 VDD
+ VSS sg13g2_mux4_1
XFILLER_159_142 VDD VSS sg13g2_decap_8
XFILLER_148_827 VDD VSS sg13g2_decap_8
XFILLER_33_1219 VDD VSS sg13g2_decap_8
XFILLER_147_315 VDD VSS sg13g2_decap_8
X_14508_ _14508_/Q _14508_/CLK _14508_/D _14508_/RESET_B VDD VSS sg13g2_dfrbpq_1
XFILLER_72_1279 VDD VSS sg13g2_decap_8
XFILLER_37_1399 VDD VSS sg13g2_decap_8
XFILLER_124_1358 VDD VSS sg13g2_fill_2
XFILLER_174_112 VDD VSS sg13g2_decap_8
Xinput20 input20/X input20/A VDD VSS sg13g2_buf_1
XFILLER_128_540 VDD VSS sg13g2_decap_8
X_14439_ _14439_/Q _14727_/CLK _14439_/D _14439_/RESET_B VDD VSS sg13g2_dfrbpq_1
Xinput31 input31/X input31/A VDD VSS sg13g2_buf_1
X_13878__2324 _13878_/RESET_B VDD VSS sg13g2_tiehi
XFILLER_116_713 VDD VSS sg13g2_fill_2
XFILLER_122_1093 VDD VSS sg13g2_decap_8
XFILLER_155_381 VDD VSS sg13g2_decap_8
XFILLER_183_690 VDD VSS sg13g2_decap_8
XFILLER_115_223 VDD VSS sg13g2_decap_8
XFILLER_116_757 VDD VSS sg13g2_fill_1
XFILLER_157_1134 VDD VSS sg13g2_fill_2
Xclkbuf_5_1__f_clk_i clkload0/A clkbuf_4_0_0_clk_i/X VDD VSS sg13g2_buf_16
XFILLER_143_554 VDD VSS sg13g2_fill_1
XFILLER_171_863 VDD VSS sg13g2_fill_2
X_09980_ _14563_/D _10113_/A0 _14563_/Q _09990_/S VDD VSS sg13g2_mux2_1
XFILLER_118_1118 VDD VSS sg13g2_decap_8
XFILLER_48_1440 VDD VSS sg13g2_decap_8
XFILLER_42_0 VDD VSS sg13g2_decap_8
X_14782__2954 _14782_/RESET_B VDD VSS sg13g2_tiehi
X_08931_ _08931_/X _08930_/X _08931_/A1 _08955_/S VDD VSS sg13g2_mux2_1
XFILLER_115_289 VDD VSS sg13g2_decap_8
XFILLER_130_215 VDD VSS sg13g2_decap_4
XFILLER_88_129 VDD VSS sg13g2_decap_8
XFILLER_170_1312 VDD VSS sg13g2_decap_8
XFILLER_83_1375 VDD VSS sg13g2_decap_8
XFILLER_44_1326 VDD VSS sg13g2_decap_8
XFILLER_135_1454 VDD VSS sg13g2_decap_8
X_08862_ _08862_/X _15029_/Q _14933_/Q _10675_/A VDD VSS sg13g2_mux2_1
XFILLER_111_451 VDD VSS sg13g2_fill_1
XFILLER_57_505 VDD VSS sg13g2_decap_8
X_07813_ _07954_/B _08522_/A _08548_/B VDD VSS sg13g2_and2_1
XFILLER_111_495 VDD VSS sg13g2_decap_8
XFILLER_170_1389 VDD VSS sg13g2_decap_8
X_08793_ _13682_/D _08790_/Y _08791_/Y _08792_/Y VDD VSS sg13g2_a21oi_1
XFILLER_85_858 VDD VSS sg13g2_decap_8
XFILLER_84_324 VDD VSS sg13g2_decap_8
X_07744_ _07746_/C _07748_/B _07744_/B _07744_/C _07744_/D VDD VSS sg13g2_nand4_1
XFILLER_38_763 VDD VSS sg13g2_decap_4
XFILLER_37_251 VDD VSS sg13g2_fill_2
XFILLER_168_1230 VDD VSS sg13g2_decap_8
XFILLER_26_947 VDD VSS sg13g2_decap_8
X_07675_ _07677_/C _15078_/Q _15081_/Q VDD VSS sg13g2_nor2_1
XFILLER_52_210 VDD VSS sg13g2_decap_8
XFILLER_37_284 VDD VSS sg13g2_fill_1
XFILLER_53_744 VDD VSS sg13g2_decap_8
XFILLER_25_435 VDD VSS sg13g2_decap_8
XFILLER_129_1225 VDD VSS sg13g2_decap_8
XFILLER_25_446 VDD VSS sg13g2_fill_1
X_09414_ _14016_/D _10010_/A0 _14016_/Q _09430_/S VDD VSS sg13g2_mux2_1
XFILLER_25_457 VDD VSS sg13g2_decap_8
XFILLER_0_1464 VDD VSS sg13g2_decap_8
XFILLER_40_416 VDD VSS sg13g2_fill_2
XFILLER_55_1433 VDD VSS sg13g2_decap_8
X_15159__2662 _15159_/RESET_B VDD VSS sg13g2_tiehi
X_09345_ _13949_/D _10040_/A0 _13949_/Q _09372_/S VDD VSS sg13g2_mux2_1
XFILLER_90_1324 VDD VSS sg13g2_fill_2
XFILLER_142_1414 VDD VSS sg13g2_decap_8
XFILLER_178_451 VDD VSS sg13g2_decap_8
XFILLER_181_1463 VDD VSS sg13g2_decap_8
XFILLER_139_827 VDD VSS sg13g2_decap_8
XFILLER_142_1425 VDD VSS sg13g2_fill_2
XFILLER_16_1428 VDD VSS sg13g2_decap_8
XFILLER_32_14 VDD VSS sg13g2_decap_8
XFILLER_51_1319 VDD VSS sg13g2_decap_8
XFILLER_166_624 VDD VSS sg13g2_decap_4
XFILLER_20_140 VDD VSS sg13g2_decap_8
XFILLER_21_663 VDD VSS sg13g2_fill_1
X_09276_ _13884_/D _13884_/Q _09742_/A1 _09306_/S VDD VSS sg13g2_mux2_1
XFILLER_90_1379 VDD VSS sg13g2_decap_8
XFILLER_165_123 VDD VSS sg13g2_decap_8
XFILLER_20_173 VDD VSS sg13g2_decap_4
X_08227_ _08227_/Y _07888_/B _14995_/Q _08247_/C VDD VSS sg13g2_a21oi_1
XFILLER_120_7 VDD VSS sg13g2_fill_2
XFILLER_148_47 VDD VSS sg13g2_decap_8
XFILLER_101_1100 VDD VSS sg13g2_decap_8
XFILLER_14_1163 VDD VSS sg13g2_decap_8
XFILLER_181_616 VDD VSS sg13g2_decap_8
X_14468__1734 _14468_/RESET_B VDD VSS sg13g2_tiehi
X_08158_ _08158_/X _08005_/X _08019_/B _08018_/X _08031_/C _08256_/B _08198_/S VDD
+ VSS sg13g2_mux4_1
XFILLER_180_126 VDD VSS sg13g2_decap_8
XFILLER_146_381 VDD VSS sg13g2_decap_4
XFILLER_175_1223 VDD VSS sg13g2_decap_8
XFILLER_49_1226 VDD VSS sg13g2_decap_8
XFILLER_101_1177 VDD VSS sg13g2_fill_2
XFILLER_162_863 VDD VSS sg13g2_decap_4
XFILLER_161_340 VDD VSS sg13g2_fill_2
X_08089_ _08090_/C _07900_/B _07903_/B _07883_/A _08089_/B2 VDD VSS sg13g2_a22oi_1
XFILLER_84_1128 VDD VSS sg13g2_decap_8
XFILLER_136_1207 VDD VSS sg13g2_fill_2
XFILLER_84_1139 VDD VSS sg13g2_fill_1
XFILLER_164_35 VDD VSS sg13g2_decap_8
XFILLER_79_107 VDD VSS sg13g2_decap_8
XFILLER_161_373 VDD VSS sg13g2_decap_4
X_10120_ _14698_/D _10153_/A1 _14698_/Q _10124_/S VDD VSS sg13g2_mux2_1
XFILLER_62_1404 VDD VSS sg13g2_decap_8
XFILLER_121_237 VDD VSS sg13g2_decap_8
X_10051_ _14632_/D _10084_/A0 _14632_/Q _10057_/S VDD VSS sg13g2_mux2_1
XFILLER_87_140 VDD VSS sg13g2_fill_2
XFILLER_57_11 VDD VSS sg13g2_decap_8
XFILLER_0_567 VDD VSS sg13g2_decap_8
XFILLER_48_505 VDD VSS sg13g2_fill_1
XFILLER_102_473 VDD VSS sg13g2_decap_8
XFILLER_87_184 VDD VSS sg13g2_fill_1
XFILLER_75_335 VDD VSS sg13g2_fill_2
XFILLER_29_730 VDD VSS sg13g2_fill_1
XFILLER_180_56 VDD VSS sg13g2_decap_8
XFILLER_60_1161 VDD VSS sg13g2_decap_8
X_13810_ _13810_/Q _14743_/CLK _13810_/D _13810_/RESET_B VDD VSS sg13g2_dfrbpq_1
XFILLER_75_357 VDD VSS sg13g2_decap_8
XFILLER_25_1292 VDD VSS sg13g2_decap_8
XFILLER_21_1134 VDD VSS sg13g2_decap_8
X_14790_ _14790_/Q clkload89/A _14790_/D _14790_/RESET_B VDD VSS sg13g2_dfrbpq_1
XFILLER_5_1386 VDD VSS sg13g2_decap_8
XFILLER_56_560 VDD VSS sg13g2_decap_8
XFILLER_112_1284 VDD VSS sg13g2_decap_4
XFILLER_1_1239 VDD VSS sg13g2_decap_8
X_13741_ _13741_/Q clkload18/A _13741_/D _13741_/RESET_B VDD VSS sg13g2_dfrbpq_1
X_10953_ _10953_/Y _10954_/C _10965_/C _11014_/A VDD VSS sg13g2_o21ai_1
X_13956__2246 _13956_/RESET_B VDD VSS sg13g2_tiehi
XFILLER_147_1336 VDD VSS sg13g2_decap_4
XFILLER_186_1385 VDD VSS sg13g2_decap_8
X_13672_ _13672_/Q clkload70/A _13672_/D _13672_/RESET_B VDD VSS sg13g2_dfrbpq_1
XFILLER_71_563 VDD VSS sg13g2_decap_8
X_10884_ _10884_/Y _10898_/B1 _10878_/Y _10797_/C VDD VSS sg13g2_o21ai_1
XFILLER_71_574 VDD VSS sg13g2_fill_1
XFILLER_32_928 VDD VSS sg13g2_decap_8
X_12623_ _12623_/X _12622_/X _12621_/X _12623_/S VDD VSS sg13g2_mux2_1
XFILLER_43_298 VDD VSS sg13g2_decap_8
XFILLER_106_1000 VDD VSS sg13g2_fill_1
X_15058__2524 _15058_/RESET_B VDD VSS sg13g2_tiehi
XFILLER_40_950 VDD VSS sg13g2_decap_8
XFILLER_129_304 VDD VSS sg13g2_decap_8
X_12554_ _12555_/B _13679_/Q _12651_/A2 _12553_/X _12386_/A _12651_/C1 VDD VSS sg13g2_a221oi_1
XFILLER_11_151 VDD VSS sg13g2_decap_8
XFILLER_106_1066 VDD VSS sg13g2_decap_8
XFILLER_8_634 VDD VSS sg13g2_decap_8
XFILLER_129_348 VDD VSS sg13g2_decap_8
XFILLER_12_696 VDD VSS sg13g2_decap_8
XFILLER_157_657 VDD VSS sg13g2_fill_1
XFILLER_184_443 VDD VSS sg13g2_decap_8
X_11505_ _11505_/X _11636_/A _11506_/B VDD VSS sg13g2_and2_1
XFILLER_145_808 VDD VSS sg13g2_fill_2
X_14903__2761 _14903_/RESET_B VDD VSS sg13g2_tiehi
X_12485_ _14998_/D _12485_/A _12485_/B VDD VSS sg13g2_nor2_1
XFILLER_7_133 VDD VSS sg13g2_decap_8
XFILLER_185_999 VDD VSS sg13g2_decap_8
X_14224_ _14224_/Q _14637_/CLK _14224_/D _14224_/RESET_B VDD VSS sg13g2_dfrbpq_1
XFILLER_32_1274 VDD VSS sg13g2_decap_8
X_11436_ _11436_/X _14368_/Q _14400_/Q _14464_/Q _14496_/Q _12105_/A1 _12103_/B1 VDD
+ VSS sg13g2_mux4_1
XFILLER_158_1410 VDD VSS sg13g2_decap_8
XFILLER_171_126 VDD VSS sg13g2_decap_8
XFILLER_67_1304 VDD VSS sg13g2_decap_8
XFILLER_153_841 VDD VSS sg13g2_decap_4
XFILLER_138_80 VDD VSS sg13g2_decap_8
XFILLER_138_91 VDD VSS sg13g2_fill_1
X_14155_ _14155_/Q _14729_/CLK _14155_/D _14155_/RESET_B VDD VSS sg13g2_dfrbpq_1
XFILLER_99_917 VDD VSS sg13g2_decap_8
XFILLER_4_840 VDD VSS sg13g2_decap_8
X_11367_ _11367_/Y _11362_/Y _11363_/Y _11359_/B VDD VSS sg13g2_a21oi_1
XFILLER_98_405 VDD VSS sg13g2_decap_8
X_13106_ _13106_/Y _14850_/Q _13106_/B VDD VSS sg13g2_nand2_1
X_14936__2695 _14936_/RESET_B VDD VSS sg13g2_tiehi
X_10318_ _10319_/C _10342_/A _14799_/Q _10327_/B _10327_/C VDD VSS sg13g2_and4_1
XFILLER_98_84 VDD VSS sg13g2_decap_8
XFILLER_3_361 VDD VSS sg13g2_decap_8
XFILLER_113_749 VDD VSS sg13g2_decap_4
X_14086_ _14086_/Q _14724_/CLK _14086_/D _14086_/RESET_B VDD VSS sg13g2_dfrbpq_1
X_11298_ _11298_/Y _11315_/A1 _13917_/Q _12088_/B VDD VSS sg13g2_a21oi_1
XFILLER_140_568 VDD VSS sg13g2_decap_8
X_13037_ _13037_/Y _14909_/Q _13678_/Q VDD VSS sg13g2_nor2_1
X_10249_ _10251_/A _14778_/Q _10255_/D _10343_/C VDD VSS sg13g2_o21ai_1
XFILLER_79_663 VDD VSS sg13g2_decap_4
XFILLER_152_1042 VDD VSS sg13g2_decap_4
XFILLER_78_140 VDD VSS sg13g2_fill_1
XFILLER_39_505 VDD VSS sg13g2_decap_8
XFILLER_6_1117 VDD VSS sg13g2_decap_8
XFILLER_154_90 VDD VSS sg13g2_decap_8
Xfanout1140 _07949_/C _08493_/B2 VDD VSS sg13g2_buf_1
XFILLER_79_685 VDD VSS sg13g2_fill_1
XFILLER_152_1064 VDD VSS sg13g2_decap_8
Xfanout1151 _08457_/A3 _14972_/Q VDD VSS sg13g2_buf_1
XFILLER_66_313 VDD VSS sg13g2_decap_8
Xfanout1162 _08276_/A _07778_/A VDD VSS sg13g2_buf_1
XFILLER_67_847 VDD VSS sg13g2_decap_8
XFILLER_39_538 VDD VSS sg13g2_fill_1
XFILLER_93_110 VDD VSS sg13g2_decap_8
XFILLER_66_335 VDD VSS sg13g2_decap_8
Xfanout1173 _11483_/A _14964_/Q VDD VSS sg13g2_buf_1
XFILLER_78_195 VDD VSS sg13g2_decap_8
Xfanout1184 _07893_/B _11384_/A VDD VSS sg13g2_buf_1
Xfanout1195 _11290_/A _12911_/B VDD VSS sg13g2_buf_1
XFILLER_43_1392 VDD VSS sg13g2_decap_8
X_14988_ _14988_/Q clkload46/A _14988_/D _14988_/RESET_B VDD VSS sg13g2_dfrbpq_1
XFILLER_78_1422 VDD VSS sg13g2_decap_8
XFILLER_75_880 VDD VSS sg13g2_fill_1
XFILLER_75_891 VDD VSS sg13g2_decap_8
XFILLER_81_338 VDD VSS sg13g2_decap_8
X_13939_ _13939_/Q clkload39/A _13939_/D _13939_/RESET_B VDD VSS sg13g2_dfrbpq_1
XFILLER_39_1406 VDD VSS sg13g2_decap_8
X_14546__1656 _14546_/RESET_B VDD VSS sg13g2_tiehi
XFILLER_90_861 VDD VSS sg13g2_decap_8
X_15114__2754 _15114_/RESET_B VDD VSS sg13g2_tiehi
XFILLER_179_226 VDD VSS sg13g2_decap_8
XFILLER_165_1469 VDD VSS sg13g2_fill_1
XFILLER_16_980 VDD VSS sg13g2_decap_8
XFILLER_179_259 VDD VSS sg13g2_fill_2
XFILLER_50_747 VDD VSS sg13g2_decap_8
X_09130_ _09130_/Y _13199_/A _09157_/C _09129_/Y VDD VSS sg13g2_a21oi_1
XFILLER_72_1054 VDD VSS sg13g2_decap_8
XFILLER_72_1065 VDD VSS sg13g2_fill_2
XFILLER_37_1196 VDD VSS sg13g2_decap_8
XFILLER_72_1087 VDD VSS sg13g2_fill_2
X_09061_ _09061_/Y _13064_/A _09089_/C _09074_/B1 VDD VSS sg13g2_o21ai_1
XFILLER_8_60 VDD VSS sg13g2_decap_8
XFILLER_50_1330 VDD VSS sg13g2_decap_8
XFILLER_148_679 VDD VSS sg13g2_decap_8
XFILLER_30_493 VDD VSS sg13g2_decap_8
XFILLER_11_1303 VDD VSS sg13g2_decap_8
XFILLER_102_1431 VDD VSS sg13g2_decap_8
X_08012_ _08012_/Y _08054_/B _08012_/B VDD VSS sg13g2_nand2_1
XFILLER_85_1404 VDD VSS sg13g2_decap_8
XFILLER_144_852 VDD VSS sg13g2_decap_8
XFILLER_171_660 VDD VSS sg13g2_decap_8
XFILLER_104_716 VDD VSS sg13g2_decap_8
XFILLER_116_587 VDD VSS sg13g2_decap_8
XFILLER_89_427 VDD VSS sg13g2_decap_8
X_09963_ _14547_/D _14547_/Q _09963_/A1 _09969_/S VDD VSS sg13g2_mux2_1
XFILLER_170_192 VDD VSS sg13g2_decap_8
X_08914_ _08914_/Y _08912_/Y _08913_/Y _08922_/S VDD VSS sg13g2_a21oi_1
XFILLER_83_1172 VDD VSS sg13g2_decap_4
XFILLER_44_1123 VDD VSS sg13g2_decap_8
XFILLER_131_579 VDD VSS sg13g2_decap_8
XFILLER_135_1251 VDD VSS sg13g2_decap_8
X_09894_ _14480_/D _09960_/A1 _14480_/Q _09894_/S VDD VSS sg13g2_mux2_1
XFILLER_58_836 VDD VSS sg13g2_decap_8
XFILLER_135_1284 VDD VSS sg13g2_decap_8
X_08845_ _08845_/Y _15024_/Q _08844_/A _08844_/Y VDD VSS sg13g2_a21oi_1
XFILLER_97_493 VDD VSS sg13g2_decap_8
XFILLER_170_1186 VDD VSS sg13g2_decap_8
XFILLER_61_1470 VDD VSS sg13g2_decap_8
XFILLER_85_666 VDD VSS sg13g2_fill_2
XFILLER_27_14 VDD VSS sg13g2_decap_8
XFILLER_100_977 VDD VSS sg13g2_decap_8
X_08776_ _08776_/Y _10885_/A1 _15116_/Q _15185_/Q _07719_/X VDD VSS sg13g2_a22oi_1
XFILLER_22_1454 VDD VSS sg13g2_decap_8
XFILLER_72_327 VDD VSS sg13g2_decap_8
X_07727_ _13082_/B _13206_/B _13273_/B _07728_/C VDD VSS sg13g2_nor3_1
XFILLER_65_390 VDD VSS sg13g2_decap_8
XFILLER_168_7 VDD VSS sg13g2_decap_8
XFILLER_81_861 VDD VSS sg13g2_fill_2
XFILLER_26_777 VDD VSS sg13g2_decap_4
X_07658_ _07658_/X _14749_/Q _10210_/D VDD VSS sg13g2_and2_1
XFILLER_0_1261 VDD VSS sg13g2_decap_8
XFILLER_41_714 VDD VSS sg13g2_decap_4
XFILLER_41_725 VDD VSS sg13g2_fill_1
XFILLER_13_438 VDD VSS sg13g2_decap_8
XFILLER_55_1230 VDD VSS sg13g2_decap_8
XFILLER_129_1077 VDD VSS sg13g2_decap_4
XFILLER_43_46 VDD VSS sg13g2_decap_8
XFILLER_25_298 VDD VSS sg13g2_decap_8
XFILLER_94_1290 VDD VSS sg13g2_fill_2
XFILLER_139_602 VDD VSS sg13g2_decap_8
XFILLER_43_57 VDD VSS sg13g2_fill_1
XFILLER_159_35 VDD VSS sg13g2_decap_8
XFILLER_181_1260 VDD VSS sg13g2_decap_8
XFILLER_22_950 VDD VSS sg13g2_fill_1
XFILLER_43_68 VDD VSS sg13g2_decap_8
XFILLER_16_1225 VDD VSS sg13g2_decap_8
X_09328_ _13935_/D _09827_/A0 _13935_/Q _09337_/S VDD VSS sg13g2_mux2_1
XFILLER_90_1165 VDD VSS sg13g2_decap_8
XFILLER_167_955 VDD VSS sg13g2_fill_2
XFILLER_107_1375 VDD VSS sg13g2_decap_8
X_09259_ _13868_/D _13868_/Q _10155_/A1 _09259_/S VDD VSS sg13g2_mux2_1
XFILLER_166_465 VDD VSS sg13g2_decap_8
XFILLER_126_318 VDD VSS sg13g2_decap_8
XFILLER_182_936 VDD VSS sg13g2_fill_2
X_12270_ _14986_/D _12270_/A _12270_/B VDD VSS sg13g2_nor2_1
XFILLER_5_637 VDD VSS sg13g2_decap_8
XFILLER_119_381 VDD VSS sg13g2_decap_8
XFILLER_153_137 VDD VSS sg13g2_decap_8
XFILLER_182_969 VDD VSS sg13g2_decap_8
XFILLER_153_148 VDD VSS sg13g2_fill_1
X_14020__2182 _14020_/RESET_B VDD VSS sg13g2_tiehi
X_11221_ _11222_/B _13723_/Q _14075_/Q _14427_/Q _14523_/Q _11221_/S0 _11228_/S1 VDD
+ VSS sg13g2_mux4_1
XFILLER_175_67 VDD VSS sg13g2_decap_8
XFILLER_4_147 VDD VSS sg13g2_decap_8
XFILLER_134_362 VDD VSS sg13g2_decap_8
XFILLER_108_61 VDD VSS sg13g2_decap_4
XFILLER_136_1004 VDD VSS sg13g2_fill_2
X_11152_ _11152_/Y _11164_/B _11152_/B VDD VSS sg13g2_xnor2_1
XFILLER_136_1026 VDD VSS sg13g2_decap_8
X_14624__1578 _14624_/RESET_B VDD VSS sg13g2_tiehi
XFILLER_62_1201 VDD VSS sg13g2_decap_8
XFILLER_1_854 VDD VSS sg13g2_decap_8
X_10103_ _10103_/Y _10105_/C _10105_/D _10105_/B VDD VSS sg13g2_nand3_1
XFILLER_110_719 VDD VSS sg13g2_fill_1
X_11083_ _14947_/D _11082_/Y _11081_/Y _11074_/Y VDD VSS sg13g2_o21ai_1
XFILLER_153_1351 VDD VSS sg13g2_decap_8
XFILLER_0_364 VDD VSS sg13g2_decap_8
XFILLER_103_771 VDD VSS sg13g2_decap_4
XFILLER_114_1313 VDD VSS sg13g2_decap_8
XFILLER_88_471 VDD VSS sg13g2_decap_8
XFILLER_27_1376 VDD VSS sg13g2_decap_8
X_14911_ _14911_/Q _15228_/CLK _14911_/D _14911_/RESET_B VDD VSS sg13g2_dfrbpq_1
X_10034_ _14616_/D _10100_/A0 _14616_/Q _10036_/S VDD VSS sg13g2_mux2_1
XFILLER_49_847 VDD VSS sg13g2_decap_8
XFILLER_62_1278 VDD VSS sg13g2_decap_8
XFILLER_48_335 VDD VSS sg13g2_fill_2
X_14842_ _14842_/Q _14848_/CLK _14842_/D _14842_/RESET_B VDD VSS sg13g2_dfrbpq_1
XFILLER_91_614 VDD VSS sg13g2_decap_8
XFILLER_63_316 VDD VSS sg13g2_fill_2
XFILLER_5_1183 VDD VSS sg13g2_decap_8
XFILLER_17_722 VDD VSS sg13g2_decap_4
XFILLER_112_1081 VDD VSS sg13g2_decap_8
XFILLER_29_593 VDD VSS sg13g2_decap_8
XFILLER_1_1036 VDD VSS sg13g2_decap_8
X_14773_ _14773_/Q clkload66/A _14773_/D _14773_/RESET_B VDD VSS sg13g2_dfrbpq_1
X_11985_ _11988_/B _12055_/A _11917_/A _11986_/B VDD VSS sg13g2_o21ai_1
XFILLER_147_1111 VDD VSS sg13g2_decap_8
X_13724_ _13724_/Q clkload77/A _13724_/D _13724_/RESET_B VDD VSS sg13g2_dfrbpq_1
X_10936_ _10965_/C _10936_/A _10936_/B _10936_/C _10936_/D VDD VSS sg13g2_nand4_1
XFILLER_147_1133 VDD VSS sg13g2_decap_8
XFILLER_17_91 VDD VSS sg13g2_decap_8
XFILLER_186_1182 VDD VSS sg13g2_decap_8
XFILLER_72_883 VDD VSS sg13g2_decap_8
XFILLER_32_714 VDD VSS sg13g2_decap_8
XFILLER_17_799 VDD VSS sg13g2_decap_8
XFILLER_95_1087 VDD VSS sg13g2_decap_8
XFILLER_182_1046 VDD VSS sg13g2_decap_8
XFILLER_31_213 VDD VSS sg13g2_decap_8
XFILLER_177_719 VDD VSS sg13g2_decap_8
XFILLER_182_1068 VDD VSS sg13g2_decap_8
X_13655_ _15121_/D _15191_/D _15121_/Q _13655_/S VDD VSS sg13g2_mux2_1
X_10867_ _10867_/Y _10890_/A _10868_/C _10890_/B VDD VSS sg13g2_o21ai_1
XFILLER_108_1139 VDD VSS sg13g2_decap_8
XFILLER_38_1461 VDD VSS sg13g2_decap_8
XFILLER_125_1420 VDD VSS sg13g2_fill_1
XFILLER_160_1311 VDD VSS sg13g2_decap_8
XFILLER_9_910 VDD VSS sg13g2_decap_8
X_12606_ _12606_/X _14253_/Q _14285_/Q _14317_/Q _14349_/Q _12643_/S0 _12643_/S1 VDD
+ VSS sg13g2_mux4_1
X_14230__1972 _14230_/RESET_B VDD VSS sg13g2_tiehi
XFILLER_73_1374 VDD VSS sg13g2_decap_8
X_13586_ _13586_/Y _15002_/Q _13566_/B _13569_/S _15018_/Q _13537_/X VDD VSS sg13g2_a221oi_1
X_10798_ _10798_/X _10807_/B _10798_/B VDD VSS sg13g2_xor2_1
XFILLER_129_123 VDD VSS sg13g2_decap_8
XFILLER_169_292 VDD VSS sg13g2_fill_2
XFILLER_185_752 VDD VSS sg13g2_decap_8
XFILLER_8_431 VDD VSS sg13g2_decap_8
XFILLER_157_454 VDD VSS sg13g2_decap_4
X_12537_ _12537_/X _12534_/X _12533_/X _12530_/X _12529_/X _12622_/S0 _12567_/S VDD
+ VSS sg13g2_mux4_1
XFILLER_34_1369 VDD VSS sg13g2_decap_8
XFILLER_12_493 VDD VSS sg13g2_decap_8
XFILLER_184_240 VDD VSS sg13g2_decap_8
XFILLER_160_1388 VDD VSS sg13g2_decap_8
XFILLER_9_987 VDD VSS sg13g2_decap_8
XFILLER_145_627 VDD VSS sg13g2_decap_8
XFILLER_157_487 VDD VSS sg13g2_decap_4
X_15064__2974 _15064_/RESET_B VDD VSS sg13g2_tiehi
X_12468_ _12468_/X _12466_/X _12465_/X _12462_/X _12461_/X _12608_/S1 _12455_/S VDD
+ VSS sg13g2_mux4_1
XFILLER_32_1071 VDD VSS sg13g2_decap_8
XFILLER_126_863 VDD VSS sg13g2_fill_1
X_14207_ _14207_/Q _14655_/CLK _14207_/D _14207_/RESET_B VDD VSS sg13g2_dfrbpq_1
X_11419_ _11420_/B _11419_/A _11419_/B _11419_/C VDD VSS sg13g2_nand3_1
XFILLER_160_619 VDD VSS sg13g2_fill_1
X_15143__2694 _15143_/RESET_B VDD VSS sg13g2_tiehi
X_15187_ _15187_/Q clkload82/A _15187_/D _15187_/RESET_B VDD VSS sg13g2_dfrbpq_1
X_12399_ _12400_/B _12397_/X _12398_/X _12595_/S VDD VSS sg13g2_mux2_1
X_14138_ _14138_/Q _14682_/CLK _14138_/D _14138_/RESET_B VDD VSS sg13g2_dfrbpq_1
XFILLER_158_1284 VDD VSS sg13g2_decap_8
XFILLER_98_224 VDD VSS sg13g2_fill_1
XFILLER_67_1178 VDD VSS sg13g2_decap_8
XFILLER_45_1410 VDD VSS sg13g2_decap_8
XFILLER_154_1148 VDD VSS sg13g2_decap_8
XFILLER_84_1470 VDD VSS sg13g2_fill_2
XFILLER_101_708 VDD VSS sg13g2_decap_8
XFILLER_98_257 VDD VSS sg13g2_decap_8
X_14069_ _14069_/Q clkload41/A _14069_/D _14069_/RESET_B VDD VSS sg13g2_dfrbpq_1
XFILLER_171_1462 VDD VSS sg13g2_decap_8
XFILLER_171_1473 VDD VSS sg13g2_fill_2
XFILLER_80_1356 VDD VSS sg13g2_decap_8
XFILLER_79_482 VDD VSS sg13g2_decap_8
XFILLER_94_430 VDD VSS sg13g2_decap_8
X_08630_ _08630_/Y _08649_/S _08629_/Y _08628_/Y VDD VSS sg13g2_o21ai_1
XFILLER_95_997 VDD VSS sg13g2_fill_1
XFILLER_54_305 VDD VSS sg13g2_decap_8
X_08561_ _08561_/Y _13533_/A _08600_/B _08561_/C VDD VSS sg13g2_nor3_1
XFILLER_39_1203 VDD VSS sg13g2_decap_8
XFILLER_81_157 VDD VSS sg13g2_decap_8
XFILLER_23_714 VDD VSS sg13g2_fill_1
X_08492_ _08574_/C _07950_/A _07949_/B _07807_/C _08476_/A VDD VSS sg13g2_a22oi_1
XFILLER_62_360 VDD VSS sg13g2_fill_1
XFILLER_78_1296 VDD VSS sg13g2_decap_8
XFILLER_35_585 VDD VSS sg13g2_fill_2
XFILLER_50_522 VDD VSS sg13g2_decap_8
XFILLER_165_1266 VDD VSS sg13g2_decap_8
XFILLER_74_1149 VDD VSS sg13g2_decap_8
XFILLER_161_1108 VDD VSS sg13g2_fill_2
XFILLER_91_1430 VDD VSS sg13g2_decap_8
XFILLER_52_1403 VDD VSS sg13g2_decap_8
XFILLER_148_421 VDD VSS sg13g2_decap_8
XFILLER_149_944 VDD VSS sg13g2_fill_1
X_15001__2609 _15001_/RESET_B VDD VSS sg13g2_tiehi
X_09113_ _09113_/Y _15242_/Q _09147_/B VDD VSS sg13g2_nand2b_1
XFILLER_148_454 VDD VSS sg13g2_decap_8
XFILLER_175_240 VDD VSS sg13g2_decap_8
XFILLER_11_1100 VDD VSS sg13g2_decap_8
XFILLER_135_104 VDD VSS sg13g2_decap_8
XFILLER_159_1004 VDD VSS sg13g2_decap_8
X_09044_ _09044_/X _09069_/A _09044_/B _09056_/C VDD VSS sg13g2_or3_1
XFILLER_117_841 VDD VSS sg13g2_decap_4
XFILLER_102_1261 VDD VSS sg13g2_decap_8
XFILLER_135_148 VDD VSS sg13g2_decap_8
XFILLER_11_1177 VDD VSS sg13g2_decap_8
XFILLER_172_980 VDD VSS sg13g2_decap_8
XFILLER_176_1373 VDD VSS sg13g2_decap_8
XFILLER_46_1218 VDD VSS sg13g2_decap_8
XFILLER_132_844 VDD VSS sg13g2_decap_8
XFILLER_85_1267 VDD VSS sg13g2_fill_2
XFILLER_89_235 VDD VSS sg13g2_fill_1
Xfanout900 _12674_/S0 _12717_/S0 VDD VSS sg13g2_buf_1
Xfanout911 _12752_/S0 fanout915/X VDD VSS sg13g2_buf_1
Xfanout922 _13289_/B _15209_/Q VDD VSS sg13g2_buf_1
XFILLER_137_1379 VDD VSS sg13g2_fill_2
X_09946_ _14530_/D _14530_/Q _10045_/A0 _09957_/S VDD VSS sg13g2_mux2_1
Xfanout933 _12639_/A2 _12779_/A2 VDD VSS sg13g2_buf_1
Xfanout944 _13601_/B _13558_/B VDD VSS sg13g2_buf_1
XFILLER_98_780 VDD VSS sg13g2_decap_8
Xfanout955 _13429_/A _13391_/A VDD VSS sg13g2_buf_1
Xfanout966 _12895_/B _15108_/Q VDD VSS sg13g2_buf_1
XFILLER_100_730 VDD VSS sg13g2_decap_8
XFILLER_161_14 VDD VSS sg13g2_decap_8
Xfanout977 _13106_/B _15107_/Q VDD VSS sg13g2_buf_1
X_09877_ _14463_/D _09910_/A1 _14463_/Q _09890_/S VDD VSS sg13g2_mux2_1
XFILLER_85_430 VDD VSS sg13g2_decap_8
XFILLER_38_46 VDD VSS sg13g2_decap_8
XFILLER_100_741 VDD VSS sg13g2_fill_2
Xfanout988 _08698_/B _08229_/B VDD VSS sg13g2_buf_1
XFILLER_85_441 VDD VSS sg13g2_fill_1
Xfanout999 _07720_/C _13279_/B VDD VSS sg13g2_buf_1
X_08828_ _08828_/Y _14766_/Q _13155_/A VDD VSS sg13g2_nor2_1
XFILLER_85_474 VDD VSS sg13g2_decap_8
XFILLER_22_1251 VDD VSS sg13g2_decap_8
XFILLER_85_485 VDD VSS sg13g2_fill_2
XFILLER_79_1027 VDD VSS sg13g2_decap_4
XFILLER_2_1323 VDD VSS sg13g2_decap_8
X_08759_ _13671_/D _08765_/A1 _08757_/Y _08758_/Y VDD VSS sg13g2_a21oi_1
XFILLER_73_658 VDD VSS sg13g2_decap_8
XFILLER_73_669 VDD VSS sg13g2_fill_1
XFILLER_72_146 VDD VSS sg13g2_decap_8
XFILLER_57_1303 VDD VSS sg13g2_decap_8
XFILLER_54_45 VDD VSS sg13g2_decap_8
X_11770_ _11910_/A _11770_/A _13064_/B VDD VSS sg13g2_xnor2_1
XFILLER_96_1385 VDD VSS sg13g2_fill_2
XFILLER_183_1344 VDD VSS sg13g2_decap_8
X_14038__2164 _14038_/RESET_B VDD VSS sg13g2_tiehi
XFILLER_148_1464 VDD VSS sg13g2_decap_4
XFILLER_14_736 VDD VSS sg13g2_decap_8
XFILLER_92_1238 VDD VSS sg13g2_decap_8
X_10721_ _10965_/B _14939_/Q _10740_/A1 _10720_/Y VDD VSS sg13g2_a21oi_1
XFILLER_54_89 VDD VSS sg13g2_fill_1
XFILLER_41_522 VDD VSS sg13g2_decap_8
XFILLER_13_235 VDD VSS sg13g2_decap_8
X_13440_ _13440_/Y _13440_/A _13469_/A _15102_/Q VDD VSS sg13g2_nand3_1
X_10652_ _10653_/D _10652_/A _10652_/B _10652_/C _10652_/D VDD VSS sg13g2_nor4_1
XFILLER_9_217 VDD VSS sg13g2_decap_8
XFILLER_16_1022 VDD VSS sg13g2_decap_8
XFILLER_142_1041 VDD VSS sg13g2_fill_2
XFILLER_10_931 VDD VSS sg13g2_decap_8
XFILLER_139_443 VDD VSS sg13g2_decap_8
XFILLER_155_903 VDD VSS sg13g2_fill_1
X_13371_ _15076_/D _13361_/C _13442_/A _13369_/Y VDD VSS sg13g2_o21ai_1
X_10583_ _10594_/D _14872_/Q _14871_/Q _10591_/C _10583_/D VDD VSS sg13g2_and4_1
XFILLER_127_627 VDD VSS sg13g2_decap_8
XFILLER_16_1099 VDD VSS sg13g2_decap_8
XFILLER_182_722 VDD VSS sg13g2_decap_8
X_15110_ _15110_/Q _15165_/CLK _15110_/D _15110_/RESET_B VDD VSS sg13g2_dfrbpq_1
X_12322_ _12322_/Y _12318_/Y _12319_/Y _12321_/Y _12320_/Y _12324_/B VDD VSS sg13g2_a221oi_1
XFILLER_127_638 VDD VSS sg13g2_fill_2
XFILLER_181_210 VDD VSS sg13g2_decap_8
XFILLER_6_935 VDD VSS sg13g2_decap_8
XFILLER_33_1380 VDD VSS sg13g2_decap_8
XFILLER_186_77 VDD VSS sg13g2_decap_8
XFILLER_154_446 VDD VSS sg13g2_decap_8
XFILLER_86_1009 VDD VSS sg13g2_decap_4
XFILLER_120_1350 VDD VSS sg13g2_fill_1
XFILLER_5_434 VDD VSS sg13g2_decap_8
X_15041_ _15041_/Q clkload69/A _15041_/D _15041_/RESET_B VDD VSS sg13g2_dfrbpq_1
XFILLER_108_863 VDD VSS sg13g2_decap_4
X_12253_ _12253_/X _12253_/A _12253_/B VDD VSS sg13g2_and2_1
XFILLER_120_1383 VDD VSS sg13g2_fill_1
XFILLER_182_799 VDD VSS sg13g2_decap_8
XFILLER_135_671 VDD VSS sg13g2_decap_8
XFILLER_68_1454 VDD VSS sg13g2_decap_8
XFILLER_181_287 VDD VSS sg13g2_decap_8
X_11204_ _11204_/Y _11203_/Y _11201_/A _11201_/Y _11202_/Y _11151_/A VDD VSS sg13g2_a221oi_1
XFILLER_155_1424 VDD VSS sg13g2_decap_8
X_12184_ _12188_/A _12183_/X _12184_/B VDD VSS sg13g2_nand2b_1
XFILLER_134_181 VDD VSS sg13g2_decap_8
XFILLER_79_86 VDD VSS sg13g2_decap_8
X_11135_ _11136_/B _11172_/A _11147_/A _11128_/Y VDD VSS sg13g2_o21ai_1
XFILLER_122_365 VDD VSS sg13g2_decap_4
XFILLER_1_651 VDD VSS sg13g2_decap_8
X_15085__2846 _15085_/RESET_B VDD VSS sg13g2_tiehi
XFILLER_95_205 VDD VSS sg13g2_decap_8
XFILLER_0_161 VDD VSS sg13g2_decap_8
XFILLER_135_81 VDD VSS sg13g2_fill_1
XFILLER_62_1042 VDD VSS sg13g2_fill_1
X_11066_ _11066_/Y _11118_/A _11088_/A _11139_/B1 VDD VSS sg13g2_o21ai_1
XFILLER_27_1173 VDD VSS sg13g2_decap_8
XFILLER_88_290 VDD VSS sg13g2_decap_8
XFILLER_7_1267 VDD VSS sg13g2_decap_8
XFILLER_77_975 VDD VSS sg13g2_decap_8
X_14248__1954 _14248_/RESET_B VDD VSS sg13g2_tiehi
X_10017_ _14599_/D _10083_/A0 _14599_/Q _10023_/S VDD VSS sg13g2_mux2_1
XFILLER_92_912 VDD VSS sg13g2_decap_8
XFILLER_62_1097 VDD VSS sg13g2_decap_8
XFILLER_49_677 VDD VSS sg13g2_decap_8
XFILLER_23_1059 VDD VSS sg13g2_decap_4
XFILLER_40_1340 VDD VSS sg13g2_decap_8
XFILLER_63_102 VDD VSS sg13g2_fill_1
X_14825_ _14825_/Q _14893_/CLK _14825_/D _14825_/RESET_B VDD VSS sg13g2_dfrbpq_1
XFILLER_151_80 VDD VSS sg13g2_decap_8
XFILLER_17_563 VDD VSS sg13g2_decap_8
X_14756_ _14756_/Q clkload57/A _14756_/D _14756_/RESET_B VDD VSS sg13g2_dfrbpq_1
X_11968_ _11970_/A _11969_/A _13904_/Q VDD VSS sg13g2_nand2b_1
XFILLER_75_1447 VDD VSS sg13g2_decap_8
X_13707_ _16869_/A _14602_/CLK _13707_/D _13707_/RESET_B VDD VSS sg13g2_dfrbpq_1
X_10919_ _10920_/B _10904_/B _10945_/B _10945_/A VDD VSS sg13g2_a21oi_1
XFILLER_32_544 VDD VSS sg13g2_decap_8
X_14687_ _14687_/Q clkload51/A _14687_/D _14687_/RESET_B VDD VSS sg13g2_dfrbpq_1
X_11899_ _11900_/A _13966_/Q _13998_/Q _14030_/Q _14062_/Q _11899_/S0 _11366_/C VDD
+ VSS sg13g2_mux4_1
XFILLER_32_555 VDD VSS sg13g2_decap_8
X_13638_ _13746_/D _13638_/A VDD VSS sg13g2_buf_1
XFILLER_73_1171 VDD VSS sg13g2_decap_8
XFILLER_158_741 VDD VSS sg13g2_decap_8
XFILLER_158_752 VDD VSS sg13g2_fill_2
XFILLER_146_914 VDD VSS sg13g2_decap_8
XFILLER_34_1166 VDD VSS sg13g2_decap_8
XFILLER_185_560 VDD VSS sg13g2_decap_8
X_13569_ _13569_/X _14996_/Q _15012_/Q _13569_/S VDD VSS sg13g2_mux2_1
XFILLER_160_1185 VDD VSS sg13g2_decap_8
XFILLER_9_784 VDD VSS sg13g2_decap_8
XFILLER_118_649 VDD VSS sg13g2_decap_8
XFILLER_146_969 VDD VSS sg13g2_decap_4
X_13736__2466 _13736_/RESET_B VDD VSS sg13g2_tiehi
XFILLER_12_1453 VDD VSS sg13g2_decap_8
XFILLER_145_457 VDD VSS sg13g2_decap_8
X_15239_ _15239_/Q _15240_/CLK _15239_/D _15239_/RESET_B VDD VSS sg13g2_dfrbpq_1
XFILLER_160_427 VDD VSS sg13g2_decap_8
XFILLER_160_438 VDD VSS sg13g2_decap_8
XFILLER_99_533 VDD VSS sg13g2_decap_8
XFILLER_82_1407 VDD VSS sg13g2_decap_8
XFILLER_114_844 VDD VSS sg13g2_decap_8
XFILLER_125_192 VDD VSS sg13g2_decap_8
XFILLER_119_1043 VDD VSS sg13g2_decap_8
XFILLER_119_1054 VDD VSS sg13g2_fill_1
Xfanout207 _10023_/A0 _10089_/A0 VDD VSS sg13g2_buf_1
X_09800_ _14389_/D _09899_/A0 _14389_/Q _09804_/S VDD VSS sg13g2_mux2_1
Xfanout218 _09923_/A1 _09070_/Y VDD VSS sg13g2_buf_1
XFILLER_99_577 VDD VSS sg13g2_fill_2
XFILLER_59_408 VDD VSS sg13g2_decap_8
Xfanout229 _09953_/A1 _09656_/A0 VDD VSS sg13g2_buf_1
X_07992_ _15250_/D _13653_/S _07991_/A _07988_/Y VDD VSS sg13g2_a21oi_1
XFILLER_114_899 VDD VSS sg13g2_fill_2
X_14116__2086 _14116_/RESET_B VDD VSS sg13g2_tiehi
XFILLER_87_739 VDD VSS sg13g2_decap_8
X_13951__2251 _13951_/RESET_B VDD VSS sg13g2_tiehi
XFILLER_68_920 VDD VSS sg13g2_fill_2
XFILLER_86_227 VDD VSS sg13g2_decap_8
XFILLER_80_1142 VDD VSS sg13g2_fill_2
XFILLER_140_184 VDD VSS sg13g2_decap_8
X_09731_ _14322_/D _09929_/A1 _14322_/Q _09738_/S VDD VSS sg13g2_mux2_1
XFILLER_79_290 VDD VSS sg13g2_decap_4
XFILLER_45_1284 VDD VSS sg13g2_decap_8
Xclkbuf_4_14_0_clk_i clkbuf_4_14_0_clk_i/X clkbuf_0_clk_i/X VDD VSS sg13g2_buf_8
XFILLER_67_441 VDD VSS sg13g2_decap_8
XFILLER_80_1186 VDD VSS sg13g2_decap_8
X_09662_ _14255_/D _10158_/A1 _14255_/Q _09672_/S VDD VSS sg13g2_mux2_1
XFILLER_68_997 VDD VSS sg13g2_decap_8
XFILLER_41_1159 VDD VSS sg13g2_decap_8
XFILLER_28_839 VDD VSS sg13g2_decap_8
XFILLER_94_271 VDD VSS sg13g2_decap_8
XFILLER_82_411 VDD VSS sg13g2_fill_1
X_08613_ _08613_/Y _08641_/B _08612_/X _08039_/A VDD VSS sg13g2_a21oi_1
X_09593_ _14190_/D _14190_/Q _09626_/A0 _09593_/S VDD VSS sg13g2_mux2_1
XFILLER_27_349 VDD VSS sg13g2_fill_2
XFILLER_167_1339 VDD VSS sg13g2_decap_8
XFILLER_54_157 VDD VSS sg13g2_decap_8
X_08544_ _08545_/D _08544_/A _08544_/B _08544_/C VDD VSS sg13g2_nand3_1
XFILLER_82_477 VDD VSS sg13g2_fill_1
XFILLER_70_617 VDD VSS sg13g2_fill_1
XFILLER_54_168 VDD VSS sg13g2_fill_1
XFILLER_39_1011 VDD VSS sg13g2_decap_8
XFILLER_39_1033 VDD VSS sg13g2_decap_8
XFILLER_51_842 VDD VSS sg13g2_fill_2
XFILLER_168_505 VDD VSS sg13g2_decap_8
X_08475_ _08475_/Y _08475_/A _08475_/B _08475_/C _08475_/D VDD VSS sg13g2_nor4_1
XFILLER_165_1074 VDD VSS sg13g2_decap_8
XFILLER_23_566 VDD VSS sg13g2_decap_8
XFILLER_126_1047 VDD VSS sg13g2_decap_8
XFILLER_52_1200 VDD VSS sg13g2_decap_8
XFILLER_11_739 VDD VSS sg13g2_fill_2
XFILLER_149_741 VDD VSS sg13g2_decap_8
X_14877__2813 _14877_/RESET_B VDD VSS sg13g2_tiehi
XFILLER_10_238 VDD VSS sg13g2_decap_8
XFILLER_137_903 VDD VSS sg13g2_fill_2
XFILLER_17_1364 VDD VSS sg13g2_decap_8
XFILLER_183_508 VDD VSS sg13g2_decap_8
XFILLER_91_1293 VDD VSS sg13g2_decap_8
XFILLER_143_1383 VDD VSS sg13g2_decap_8
XFILLER_52_1277 VDD VSS sg13g2_decap_8
XFILLER_108_104 VDD VSS sg13g2_decap_8
XFILLER_137_936 VDD VSS sg13g2_decap_4
XFILLER_40_25 VDD VSS sg13g2_decap_8
XFILLER_109_649 VDD VSS sg13g2_decap_4
XFILLER_136_435 VDD VSS sg13g2_fill_2
XFILLER_156_14 VDD VSS sg13g2_decap_8
XFILLER_164_766 VDD VSS sg13g2_decap_4
XFILLER_178_1446 VDD VSS sg13g2_decap_8
XFILLER_139_1408 VDD VSS sg13g2_fill_2
X_14326__1876 _14326_/RESET_B VDD VSS sg13g2_tiehi
X_09027_ _09027_/X _15032_/Q _15229_/Q _09027_/S VDD VSS sg13g2_mux2_1
XFILLER_105_811 VDD VSS sg13g2_decap_4
XFILLER_117_671 VDD VSS sg13g2_decap_8
XFILLER_152_939 VDD VSS sg13g2_decap_8
XFILLER_123_129 VDD VSS sg13g2_fill_1
XFILLER_3_949 VDD VSS sg13g2_decap_8
XFILLER_85_1042 VDD VSS sg13g2_decap_4
XFILLER_105_844 VDD VSS sg13g2_decap_8
XFILLER_176_1170 VDD VSS sg13g2_decap_8
XFILLER_105_855 VDD VSS sg13g2_fill_2
XFILLER_2_448 VDD VSS sg13g2_decap_8
XFILLER_137_1143 VDD VSS sg13g2_decap_8
XFILLER_46_1026 VDD VSS sg13g2_decap_8
XFILLER_172_1034 VDD VSS sg13g2_fill_1
XFILLER_105_888 VDD VSS sg13g2_decap_8
XFILLER_137_1165 VDD VSS sg13g2_decap_8
XFILLER_137_1176 VDD VSS sg13g2_fill_1
XFILLER_49_56 VDD VSS sg13g2_decap_8
XFILLER_131_162 VDD VSS sg13g2_decap_8
Xfanout730 _11283_/B _12258_/C1 VDD VSS sg13g2_buf_1
XFILLER_172_46 VDD VSS sg13g2_decap_8
Xfanout741 _12257_/B1 _12112_/B1 VDD VSS sg13g2_buf_1
XFILLER_63_1351 VDD VSS sg13g2_decap_8
XFILLER_104_398 VDD VSS sg13g2_decap_8
X_14541__1661 _14541_/RESET_B VDD VSS sg13g2_tiehi
Xfanout752 _11172_/A _11185_/A VDD VSS sg13g2_buf_1
X_09929_ _14514_/D _14514_/Q _09929_/A1 _09936_/S VDD VSS sg13g2_mux2_1
Xfanout763 _08511_/S _08597_/B VDD VSS sg13g2_buf_1
Xfanout774 _08452_/C _07629_/Y VDD VSS sg13g2_buf_1
XFILLER_4_1407 VDD VSS sg13g2_decap_8
XFILLER_150_1343 VDD VSS sg13g2_decap_8
Xfanout785 _11044_/C _10797_/C VDD VSS sg13g2_buf_1
XFILLER_111_1305 VDD VSS sg13g2_fill_1
XFILLER_150_1354 VDD VSS sg13g2_fill_2
Xfanout796 _12705_/S1 _15214_/Q VDD VSS sg13g2_buf_1
X_12940_ _12941_/B _12983_/A1 _12939_/Y _12928_/X _12878_/D _12932_/Y VDD VSS sg13g2_a221oi_1
XFILLER_65_11 VDD VSS sg13g2_fill_2
XFILLER_58_463 VDD VSS sg13g2_decap_8
XFILLER_24_1368 VDD VSS sg13g2_decap_8
XFILLER_98_1425 VDD VSS sg13g2_decap_8
X_14795__2941 _14795_/RESET_B VDD VSS sg13g2_tiehi
XFILLER_65_44 VDD VSS sg13g2_decap_8
XFILLER_2_1120 VDD VSS sg13g2_decap_8
X_12871_ _15025_/D _12984_/A _12871_/B VDD VSS sg13g2_nor2_1
XFILLER_74_978 VDD VSS sg13g2_decap_8
XFILLER_185_1439 VDD VSS sg13g2_decap_8
X_14610_ _14610_/Q clkload36/A _14610_/D _14610_/RESET_B VDD VSS sg13g2_dfrbpq_1
XFILLER_57_1100 VDD VSS sg13g2_decap_8
X_11822_ _11822_/X _11822_/A _11822_/B VDD VSS sg13g2_and2_1
XFILLER_61_628 VDD VSS sg13g2_decap_8
XFILLER_27_883 VDD VSS sg13g2_decap_8
X_13814__2388 _13814_/RESET_B VDD VSS sg13g2_tiehi
Xclkbuf_5_29__f_clk_i clkbuf_leaf_75_clk_i/A clkbuf_4_14_0_clk_i/X VDD VSS sg13g2_buf_16
XFILLER_109_1201 VDD VSS sg13g2_decap_8
XFILLER_54_680 VDD VSS sg13g2_decap_4
XFILLER_2_1197 VDD VSS sg13g2_decap_8
XFILLER_183_1141 VDD VSS sg13g2_decap_8
X_14541_ _14541_/Q clkload18/A _14541_/D _14541_/RESET_B VDD VSS sg13g2_dfrbpq_1
X_11753_ _11754_/A _14250_/Q _14282_/Q _14314_/Q _14346_/Q _11741_/A _11742_/C VDD
+ VSS sg13g2_mux4_1
XFILLER_81_21 VDD VSS sg13g2_decap_8
XFILLER_26_393 VDD VSS sg13g2_decap_8
XFILLER_41_330 VDD VSS sg13g2_decap_8
XFILLER_57_1177 VDD VSS sg13g2_decap_8
X_10704_ _10923_/B _09021_/X _08873_/A _08869_/Y VDD VSS sg13g2_a21oi_1
XFILLER_14_577 VDD VSS sg13g2_decap_8
XFILLER_109_1278 VDD VSS sg13g2_decap_4
X_14472_ _14472_/Q clkload20/A _14472_/D _14472_/RESET_B VDD VSS sg13g2_dfrbpq_1
X_11684_ _11684_/Y _11692_/A _14504_/Q _11529_/B VDD VSS sg13g2_a21oi_1
XFILLER_70_1322 VDD VSS sg13g2_decap_8
XFILLER_186_357 VDD VSS sg13g2_decap_8
XFILLER_161_1450 VDD VSS sg13g2_decap_8
X_13993__2209 _13993_/RESET_B VDD VSS sg13g2_tiehi
XFILLER_14_70 VDD VSS sg13g2_decap_8
X_13423_ _13423_/Y _13440_/A _13469_/A _13423_/C VDD VSS sg13g2_nand3_1
X_10635_ _10636_/B _14886_/Q _14885_/Q _14884_/Q _14883_/Q VDD VSS sg13g2_nand4_1
XFILLER_35_1464 VDD VSS sg13g2_decap_8
XFILLER_128_914 VDD VSS sg13g2_decap_8
XFILLER_31_1328 VDD VSS sg13g2_decap_8
XFILLER_128_947 VDD VSS sg13g2_fill_1
XFILLER_154_210 VDD VSS sg13g2_decap_8
X_13354_ _13364_/B _13401_/C _13401_/B VDD VSS sg13g2_nor2_1
XFILLER_122_1467 VDD VSS sg13g2_decap_8
XFILLER_155_744 VDD VSS sg13g2_decap_8
X_10566_ _10567_/D _14868_/Q _14867_/Q _14866_/Q _14862_/Q VDD VSS sg13g2_nand4_1
XFILLER_70_1399 VDD VSS sg13g2_decap_8
XFILLER_6_732 VDD VSS sg13g2_decap_8
XFILLER_182_541 VDD VSS sg13g2_decap_8
X_12305_ _12307_/A _12306_/A _14202_/Q VDD VSS sg13g2_nand2b_1
XFILLER_5_231 VDD VSS sg13g2_decap_8
XFILLER_155_777 VDD VSS sg13g2_decap_8
XFILLER_142_405 VDD VSS sg13g2_fill_1
X_13285_ _13287_/C _13481_/A _07744_/D _13284_/Y VDD VSS sg13g2_a21oi_1
XFILLER_143_939 VDD VSS sg13g2_decap_8
X_10497_ _10499_/A _14853_/Q _10497_/B VDD VSS sg13g2_nand2b_1
XFILLER_120_1180 VDD VSS sg13g2_fill_1
XFILLER_108_682 VDD VSS sg13g2_fill_1
XFILLER_136_991 VDD VSS sg13g2_fill_1
XFILLER_68_1251 VDD VSS sg13g2_decap_8
XFILLER_114_129 VDD VSS sg13g2_decap_8
X_15024_ _15024_/Q clkload65/A _15024_/D _15024_/RESET_B VDD VSS sg13g2_dfrbpq_1
X_12236_ _12237_/B _12236_/A _12236_/B _12236_/C VDD VSS sg13g2_nand3_1
XFILLER_142_449 VDD VSS sg13g2_decap_8
XFILLER_107_181 VDD VSS sg13g2_decap_8
XFILLER_46_7 VDD VSS sg13g2_decap_8
XFILLER_9_1318 VDD VSS sg13g2_decap_8
XFILLER_111_814 VDD VSS sg13g2_decap_4
XFILLER_123_674 VDD VSS sg13g2_decap_4
X_12167_ _12169_/A _12168_/A _14646_/Q VDD VSS sg13g2_nand2b_1
XFILLER_29_1268 VDD VSS sg13g2_decap_8
XFILLER_150_471 VDD VSS sg13g2_decap_8
XFILLER_69_739 VDD VSS sg13g2_decap_8
XFILLER_111_836 VDD VSS sg13g2_decap_8
XFILLER_81_1440 VDD VSS sg13g2_decap_8
XFILLER_110_324 VDD VSS sg13g2_fill_2
X_11118_ _11119_/B _11118_/A _11118_/B _11118_/C _11118_/D VDD VSS sg13g2_nand4_1
XFILLER_110_335 VDD VSS sg13g2_decap_8
X_12098_ _12098_/Y _12100_/S0 _14676_/Q _12088_/B VDD VSS sg13g2_a21oi_1
XFILLER_84_709 VDD VSS sg13g2_fill_2
XFILLER_77_750 VDD VSS sg13g2_decap_8
XFILLER_7_1064 VDD VSS sg13g2_decap_8
XFILLER_77_761 VDD VSS sg13g2_fill_2
X_11049_ _11064_/D _11185_/A _11068_/C VDD VSS sg13g2_xnor2_1
XFILLER_77_772 VDD VSS sg13g2_decap_8
XFILLER_42_1457 VDD VSS sg13g2_decap_8
XFILLER_65_923 VDD VSS sg13g2_fill_1
Xinput7 input7/X input7/A VDD VSS sg13g2_buf_1
XFILLER_92_753 VDD VSS sg13g2_fill_2
XFILLER_64_444 VDD VSS sg13g2_decap_8
XFILLER_149_1036 VDD VSS sg13g2_fill_2
XFILLER_18_861 VDD VSS sg13g2_decap_8
X_14808_ _14808_/Q clkload85/A _14808_/D _14808_/RESET_B VDD VSS sg13g2_dfrbpq_1
XFILLER_92_786 VDD VSS sg13g2_decap_4
XFILLER_91_263 VDD VSS sg13g2_fill_1
XFILLER_52_639 VDD VSS sg13g2_decap_4
X_14404__1798 _14404_/RESET_B VDD VSS sg13g2_tiehi
XFILLER_75_1244 VDD VSS sg13g2_decap_8
XFILLER_33_842 VDD VSS sg13g2_fill_2
X_14739_ _14739_/Q clkload39/A _14739_/D _14739_/RESET_B VDD VSS sg13g2_dfrbpq_1
XFILLER_127_1334 VDD VSS sg13g2_fill_1
X_15041__2566 _15041_/RESET_B VDD VSS sg13g2_tiehi
XFILLER_178_836 VDD VSS sg13g2_decap_8
XFILLER_127_1356 VDD VSS sg13g2_decap_8
X_08260_ _08260_/Y _08318_/B _08359_/A2 _08259_/Y VDD VSS sg13g2_a21oi_1
XFILLER_33_886 VDD VSS sg13g2_decap_8
XFILLER_177_335 VDD VSS sg13g2_decap_8
XFILLER_32_374 VDD VSS sg13g2_decap_4
XFILLER_162_1269 VDD VSS sg13g2_decap_8
XFILLER_119_903 VDD VSS sg13g2_fill_1
X_14583__1619 _14583_/RESET_B VDD VSS sg13g2_tiehi
X_08191_ _08191_/Y _07922_/Y _08190_/A _08190_/Y VDD VSS sg13g2_a21oi_1
XFILLER_20_569 VDD VSS sg13g2_decap_4
X_13969__2233 _13969_/RESET_B VDD VSS sg13g2_tiehi
XFILLER_146_733 VDD VSS sg13g2_decap_8
XFILLER_146_744 VDD VSS sg13g2_fill_2
XFILLER_9_581 VDD VSS sg13g2_decap_8
XFILLER_118_446 VDD VSS sg13g2_decap_8
XFILLER_69_1015 VDD VSS sg13g2_decap_8
XFILLER_145_243 VDD VSS sg13g2_decap_8
XFILLER_12_1250 VDD VSS sg13g2_decap_8
XFILLER_146_788 VDD VSS sg13g2_decap_8
XFILLER_161_714 VDD VSS sg13g2_decap_8
XFILLER_10_28 VDD VSS sg13g2_decap_8
XFILLER_105_118 VDD VSS sg13g2_decap_8
XFILLER_133_427 VDD VSS sg13g2_decap_8
XFILLER_133_438 VDD VSS sg13g2_fill_1
XFILLER_82_1204 VDD VSS sg13g2_decap_8
XFILLER_99_341 VDD VSS sg13g2_decap_8
XFILLER_86_1384 VDD VSS sg13g2_decap_8
XFILLER_102_803 VDD VSS sg13g2_decap_8
XFILLER_173_1365 VDD VSS sg13g2_decap_8
XFILLER_47_1368 VDD VSS sg13g2_decap_8
XFILLER_99_396 VDD VSS sg13g2_fill_1
X_07975_ _07979_/A _07976_/A _07976_/B _07976_/C VDD VSS sg13g2_nor3_1
XFILLER_56_901 VDD VSS sg13g2_decap_8
X_09714_ _14305_/D _09714_/A0 _14305_/Q _09729_/S VDD VSS sg13g2_mux2_1
XFILLER_101_379 VDD VSS sg13g2_decap_8
XFILLER_28_647 VDD VSS sg13g2_decap_8
X_09645_ _14238_/D _09744_/A1 _14238_/Q _09659_/S VDD VSS sg13g2_mux2_1
XFILLER_56_967 VDD VSS sg13g2_decap_8
XFILLER_55_444 VDD VSS sg13g2_fill_1
XFILLER_167_1114 VDD VSS sg13g2_fill_1
XFILLER_83_775 VDD VSS sg13g2_decap_8
XFILLER_43_606 VDD VSS sg13g2_decap_8
XFILLER_167_1136 VDD VSS sg13g2_decap_8
XFILLER_35_25 VDD VSS sg13g2_decap_4
X_09576_ _14173_/D _14173_/Q _09743_/A1 _09590_/S VDD VSS sg13g2_mux2_1
XFILLER_58_1420 VDD VSS sg13g2_decap_8
XFILLER_55_488 VDD VSS sg13g2_fill_1
XFILLER_36_691 VDD VSS sg13g2_decap_8
XFILLER_184_1450 VDD VSS sg13g2_decap_8
X_08527_ _08566_/C _08527_/A _08527_/B VDD VSS sg13g2_nand2_1
XFILLER_70_447 VDD VSS sg13g2_fill_2
XFILLER_19_1415 VDD VSS sg13g2_decap_8
XFILLER_51_661 VDD VSS sg13g2_decap_8
XFILLER_180_1336 VDD VSS sg13g2_decap_8
XFILLER_54_1339 VDD VSS sg13g2_decap_8
X_15066__2900 _15066_/RESET_B VDD VSS sg13g2_tiehi
X_08458_ _08458_/X _08362_/X _08457_/X _08597_/B VDD VSS sg13g2_mux2_1
XFILLER_106_1418 VDD VSS sg13g2_fill_1
XFILLER_145_1467 VDD VSS sg13g2_fill_2
XFILLER_51_683 VDD VSS sg13g2_decap_8
XFILLER_11_536 VDD VSS sg13g2_decap_8
XFILLER_156_508 VDD VSS sg13g2_fill_1
XFILLER_17_1161 VDD VSS sg13g2_decap_8
XFILLER_183_305 VDD VSS sg13g2_decap_8
X_08389_ _08394_/B _08415_/A _08389_/B VDD VSS sg13g2_nor2_1
XFILLER_109_402 VDD VSS sg13g2_fill_2
XFILLER_7_518 VDD VSS sg13g2_decap_8
XFILLER_167_46 VDD VSS sg13g2_decap_8
X_14559__1643 _14559_/RESET_B VDD VSS sg13g2_tiehi
X_10420_ _14829_/D _10420_/A _10421_/B _10423_/C VDD VSS sg13g2_and3_1
XFILLER_52_1074 VDD VSS sg13g2_decap_8
XFILLER_136_210 VDD VSS sg13g2_decap_8
XFILLER_13_1047 VDD VSS sg13g2_decap_8
XFILLER_109_468 VDD VSS sg13g2_decap_8
XFILLER_178_1243 VDD VSS sg13g2_decap_8
XFILLER_139_1205 VDD VSS sg13g2_decap_8
X_10351_ _10353_/A _14809_/Q _10352_/C _14810_/Q VDD VSS sg13g2_a21o_1
XFILLER_137_799 VDD VSS sg13g2_fill_1
XFILLER_139_1238 VDD VSS sg13g2_decap_4
X_15239__3030 _15239_/RESET_B VDD VSS sg13g2_tiehi
X_13070_ _13070_/Y _14783_/Q _13164_/A2 _13275_/B1 VDD VSS sg13g2_o21ai_1
XFILLER_105_630 VDD VSS sg13g2_decap_8
X_10282_ _14788_/D _10282_/A _10281_/Y VDD VSS sg13g2_nor2b_1
XFILLER_3_746 VDD VSS sg13g2_decap_8
XFILLER_65_1424 VDD VSS sg13g2_decap_8
X_12021_ _12021_/Y _12021_/A _12036_/B VDD VSS sg13g2_nand2_1
XFILLER_2_245 VDD VSS sg13g2_decap_8
XFILLER_183_67 VDD VSS sg13g2_decap_8
XFILLER_116_50 VDD VSS sg13g2_decap_8
XFILLER_152_1438 VDD VSS sg13g2_decap_8
XFILLER_76_21 VDD VSS sg13g2_decap_8
XFILLER_78_569 VDD VSS sg13g2_fill_2
Xfanout560 _13469_/B fanout565/X VDD VSS sg13g2_buf_1
XFILLER_8_1362 VDD VSS sg13g2_decap_8
Xfanout571 _08036_/B _08637_/B VDD VSS sg13g2_buf_1
XFILLER_4_1204 VDD VSS sg13g2_decap_8
Xfanout582 _12900_/A _13600_/B VDD VSS sg13g2_buf_1
XFILLER_150_1151 VDD VSS sg13g2_decap_8
X_13972_ _13972_/Q _15005_/CLK _13972_/D _13972_/RESET_B VDD VSS sg13g2_dfrbpq_1
Xfanout593 _12294_/A2 _12338_/A2 VDD VSS sg13g2_buf_1
XFILLER_59_783 VDD VSS sg13g2_fill_1
XFILLER_101_880 VDD VSS sg13g2_decap_8
XFILLER_18_102 VDD VSS sg13g2_decap_8
XFILLER_93_539 VDD VSS sg13g2_fill_2
XFILLER_74_720 VDD VSS sg13g2_fill_1
XFILLER_46_411 VDD VSS sg13g2_decap_8
XFILLER_24_1165 VDD VSS sg13g2_decap_8
XFILLER_101_891 VDD VSS sg13g2_fill_1
XFILLER_46_422 VDD VSS sg13g2_fill_2
XFILLER_19_647 VDD VSS sg13g2_decap_8
XFILLER_47_956 VDD VSS sg13g2_fill_1
X_12923_ _12988_/A _14902_/Q _13685_/Q VDD VSS sg13g2_xnor2_1
XFILLER_74_742 VDD VSS sg13g2_fill_2
XFILLER_58_293 VDD VSS sg13g2_fill_1
XFILLER_150_1195 VDD VSS sg13g2_fill_1
XFILLER_18_146 VDD VSS sg13g2_fill_1
XFILLER_132_60 VDD VSS sg13g2_decap_8
XFILLER_62_915 VDD VSS sg13g2_fill_1
XFILLER_185_1236 VDD VSS sg13g2_decap_8
X_12854_ _12854_/Y _12851_/Y _12852_/Y _12853_/Y VDD VSS sg13g2_a21oi_1
XFILLER_92_42 VDD VSS sg13g2_decap_4
XFILLER_46_488 VDD VSS sg13g2_decap_8
XFILLER_92_64 VDD VSS sg13g2_decap_8
X_11805_ _11806_/B _11805_/A _11805_/B _11805_/C VDD VSS sg13g2_nand3_1
XFILLER_15_853 VDD VSS sg13g2_decap_4
X_14759__2980 _14759_/RESET_B VDD VSS sg13g2_tiehi
X_12785_ _12785_/X _13754_/Q _14106_/Q _14458_/Q _14554_/Q _12787_/S0 _12787_/S1 VDD
+ VSS sg13g2_mux4_1
XFILLER_148_1080 VDD VSS sg13g2_fill_1
XFILLER_42_661 VDD VSS sg13g2_decap_8
X_14524_ _14524_/Q _14588_/CLK _14524_/D _14524_/RESET_B VDD VSS sg13g2_dfrbpq_1
XFILLER_109_1053 VDD VSS sg13g2_decap_4
XFILLER_14_374 VDD VSS sg13g2_decap_8
X_11736_ _11736_/X _11736_/A _11875_/B VDD VSS sg13g2_and2_1
XFILLER_109_1075 VDD VSS sg13g2_fill_1
XFILLER_186_154 VDD VSS sg13g2_decap_8
XFILLER_30_856 VDD VSS sg13g2_fill_1
X_14455_ _14455_/Q clkload41/A _14455_/D _14455_/RESET_B VDD VSS sg13g2_dfrbpq_1
XFILLER_35_1261 VDD VSS sg13g2_decap_8
X_11667_ _11667_/Y _11678_/S0 _13896_/Q VDD VSS sg13g2_nand2b_1
XFILLER_179_1007 VDD VSS sg13g2_decap_4
XFILLER_174_338 VDD VSS sg13g2_fill_2
XFILLER_179_1029 VDD VSS sg13g2_decap_8
X_13406_ _15090_/D _13442_/A _13396_/D _13405_/Y VDD VSS sg13g2_o21ai_1
XFILLER_122_1253 VDD VSS sg13g2_decap_8
X_10618_ _10619_/A _10651_/D _14880_/Q _14879_/Q _10629_/C VDD VSS sg13g2_nand4_1
X_14386_ _14386_/Q _14546_/CLK _14386_/D _14386_/RESET_B VDD VSS sg13g2_dfrbpq_1
X_11598_ _11599_/B _11598_/A _11598_/B _11805_/C VDD VSS sg13g2_nand3_1
XFILLER_70_1196 VDD VSS sg13g2_decap_8
X_13337_ _13338_/A _13485_/B _15171_/D VDD VSS sg13g2_nor2b_1
X_10549_ _10567_/C _14865_/Q _14864_/Q _14863_/Q VDD VSS sg13g2_nand3_1
XFILLER_183_894 VDD VSS sg13g2_decap_8
XFILLER_142_213 VDD VSS sg13g2_decap_8
XFILLER_182_382 VDD VSS sg13g2_decap_8
XFILLER_115_438 VDD VSS sg13g2_fill_2
XFILLER_131_909 VDD VSS sg13g2_fill_1
X_13268_ _13270_/B _14924_/Q _13663_/Q _13259_/A VDD VSS sg13g2_o21ai_1
XFILLER_29_1010 VDD VSS sg13g2_fill_2
XFILLER_124_961 VDD VSS sg13g2_fill_2
X_14861__2845 _14861_/RESET_B VDD VSS sg13g2_tiehi
X_15007_ _15007_/Q _15230_/CLK _15007_/D _15007_/RESET_B VDD VSS sg13g2_dfrbpq_1
X_12219_ _12219_/X _12205_/X _12206_/X _12219_/S VDD VSS sg13g2_mux2_1
XFILLER_69_503 VDD VSS sg13g2_decap_8
XFILLER_68_1092 VDD VSS sg13g2_decap_8
XFILLER_29_1043 VDD VSS sg13g2_decap_4
X_13199_ _13199_/X _13199_/A _13667_/Q VDD VSS sg13g2_and2_1
XFILLER_9_1148 VDD VSS sg13g2_decap_8
XFILLER_110_110 VDD VSS sg13g2_decap_4
XFILLER_9_1159 VDD VSS sg13g2_fill_1
XFILLER_150_290 VDD VSS sg13g2_decap_8
XFILLER_97_867 VDD VSS sg13g2_decap_8
XFILLER_97_878 VDD VSS sg13g2_fill_1
XFILLER_84_517 VDD VSS sg13g2_decap_8
X_07760_ _15205_/D _13356_/B _07759_/Y _07754_/Y VDD VSS sg13g2_a21oi_1
XFILLER_38_912 VDD VSS sg13g2_fill_1
XFILLER_96_388 VDD VSS sg13g2_decap_8
XFILLER_56_219 VDD VSS sg13g2_decap_8
XFILLER_42_1254 VDD VSS sg13g2_decap_8
XFILLER_77_580 VDD VSS sg13g2_fill_1
X_14894__2779 _14894_/RESET_B VDD VSS sg13g2_tiehi
XFILLER_2_84 VDD VSS sg13g2_decap_8
XFILLER_168_1412 VDD VSS sg13g2_decap_8
X_07691_ _07691_/Y _12812_/A _11241_/A _08832_/D VDD VSS sg13g2_o21ai_1
XFILLER_77_1306 VDD VSS sg13g2_decap_8
X_14637__1565 _14637_/RESET_B VDD VSS sg13g2_tiehi
X_09430_ _14032_/D _09463_/A0 _14032_/Q _09430_/S VDD VSS sg13g2_mux2_1
XFILLER_52_403 VDD VSS sg13g2_fill_2
XFILLER_92_583 VDD VSS sg13g2_decap_8
XFILLER_64_274 VDD VSS sg13g2_decap_4
X_09361_ _13965_/D _10089_/A0 _13965_/Q _09364_/S VDD VSS sg13g2_mux2_1
XFILLER_127_1120 VDD VSS sg13g2_decap_8
XFILLER_162_1000 VDD VSS sg13g2_decap_8
XFILLER_80_789 VDD VSS sg13g2_fill_2
XFILLER_127_1131 VDD VSS sg13g2_fill_2
X_08312_ _08312_/Y _08312_/A _08312_/B _08312_/C _08312_/D VDD VSS sg13g2_nor4_1
XFILLER_75_1074 VDD VSS sg13g2_decap_8
XFILLER_127_1153 VDD VSS sg13g2_fill_1
X_09292_ _13900_/D _13900_/Q _10155_/A1 _09292_/S VDD VSS sg13g2_mux2_1
XFILLER_20_300 VDD VSS sg13g2_decap_8
XFILLER_75_1096 VDD VSS sg13g2_decap_8
XFILLER_36_1047 VDD VSS sg13g2_fill_1
XANTENNA_12 _16875_/A VDD VSS sg13g2_antennanp
XFILLER_127_1175 VDD VSS sg13g2_decap_8
XANTENNA_23 fanout480/X VDD VSS sg13g2_antennanp
X_08243_ _08243_/Y _08241_/A _08015_/Y _08241_/Y VDD VSS sg13g2_o21ai_1
XFILLER_123_1028 VDD VSS sg13g2_decap_8
XFILLER_165_305 VDD VSS sg13g2_decap_8
XFILLER_177_165 VDD VSS sg13g2_decap_8
Xclkbuf_leaf_8_clk_i _14729_/CLK clkbuf_leaf_8_clk_i/A VDD VSS sg13g2_buf_8
XFILLER_166_839 VDD VSS sg13g2_decap_8
XFILLER_162_1099 VDD VSS sg13g2_decap_8
XFILLER_177_187 VDD VSS sg13g2_fill_1
XFILLER_119_744 VDD VSS sg13g2_decap_8
XFILLER_140_1342 VDD VSS sg13g2_decap_8
XFILLER_14_1345 VDD VSS sg13g2_decap_8
XFILLER_165_349 VDD VSS sg13g2_fill_1
X_08174_ _08174_/Y _08174_/A _08600_/B _08514_/A VDD VSS sg13g2_nor3_1
XFILLER_20_399 VDD VSS sg13g2_decap_4
XFILLER_146_563 VDD VSS sg13g2_fill_2
XFILLER_180_308 VDD VSS sg13g2_decap_8
XFILLER_88_1446 VDD VSS sg13g2_decap_8
XFILLER_101_1348 VDD VSS sg13g2_decap_8
XFILLER_175_1405 VDD VSS sg13g2_decap_8
XFILLER_49_1408 VDD VSS sg13g2_decap_8
XFILLER_106_438 VDD VSS sg13g2_decap_8
XFILLER_161_544 VDD VSS sg13g2_decap_8
Xoutput130 mem_axi_wdata[4] _15136_/Q VDD VSS sg13g2_buf_1
Xoutput141 trap _14766_/Q VDD VSS sg13g2_buf_1
XFILLER_82_1001 VDD VSS sg13g2_decap_8
XFILLER_114_460 VDD VSS sg13g2_decap_8
XFILLER_173_1162 VDD VSS sg13g2_decap_8
XFILLER_47_1165 VDD VSS sg13g2_decap_8
XFILLER_87_322 VDD VSS sg13g2_decap_4
XFILLER_101_110 VDD VSS sg13g2_decap_8
XFILLER_88_867 VDD VSS sg13g2_decap_4
XFILLER_130_964 VDD VSS sg13g2_decap_8
XFILLER_87_366 VDD VSS sg13g2_fill_1
XFILLER_60_1343 VDD VSS sg13g2_decap_8
X_07958_ _07961_/B _07958_/A _07958_/B VDD VSS sg13g2_and2_1
XFILLER_25_1474 VDD VSS sg13g2_fill_1
XFILLER_21_1316 VDD VSS sg13g2_decap_8
XFILLER_29_945 VDD VSS sg13g2_decap_8
XFILLER_112_1444 VDD VSS sg13g2_decap_4
X_07889_ _07890_/B _07889_/A _08229_/C VDD VSS sg13g2_nand2_1
XFILLER_83_550 VDD VSS sg13g2_decap_8
XFILLER_16_606 VDD VSS sg13g2_fill_2
XFILLER_15_105 VDD VSS sg13g2_decap_8
X_09628_ _14224_/D _09762_/A1 _14224_/Q _09632_/S VDD VSS sg13g2_mux2_1
XFILLER_71_723 VDD VSS sg13g2_fill_1
XFILLER_28_499 VDD VSS sg13g2_decap_8
XFILLER_55_285 VDD VSS sg13g2_decap_8
XFILLER_102_41 VDD VSS sg13g2_decap_8
XFILLER_3_1292 VDD VSS sg13g2_decap_8
XFILLER_110_1190 VDD VSS sg13g2_decap_8
X_13695__2507 _13695_/RESET_B VDD VSS sg13g2_tiehi
XFILLER_19_1212 VDD VSS sg13g2_decap_8
X_09559_ _14157_/D _10023_/A0 _14157_/Q _09562_/S VDD VSS sg13g2_mux2_1
XFILLER_70_255 VDD VSS sg13g2_decap_8
XFILLER_43_469 VDD VSS sg13g2_fill_1
XFILLER_169_622 VDD VSS sg13g2_decap_8
XFILLER_24_661 VDD VSS sg13g2_decap_8
X_13731__2471 _13731_/RESET_B VDD VSS sg13g2_tiehi
XFILLER_54_1114 VDD VSS sg13g2_fill_2
X_12570_ _12583_/A _12570_/A1 _12570_/A2 _15005_/Q VDD VSS sg13g2_a21oi_1
XFILLER_58_1294 VDD VSS sg13g2_decap_8
XFILLER_180_1133 VDD VSS sg13g2_decap_8
XFILLER_62_56 VDD VSS sg13g2_decap_4
XFILLER_51_480 VDD VSS sg13g2_fill_1
XFILLER_11_333 VDD VSS sg13g2_decap_8
XFILLER_129_519 VDD VSS sg13g2_decap_8
XFILLER_178_56 VDD VSS sg13g2_decap_8
XFILLER_19_1289 VDD VSS sg13g2_decap_8
X_11521_ _11521_/Y _11520_/Y _11519_/Y _11506_/Y _11722_/B2 _11768_/B1 VDD VSS sg13g2_a221oi_1
XFILLER_8_816 VDD VSS sg13g2_decap_8
XFILLER_183_102 VDD VSS sg13g2_decap_8
XFILLER_184_636 VDD VSS sg13g2_decap_8
XFILLER_7_315 VDD VSS sg13g2_decap_8
XFILLER_184_647 VDD VSS sg13g2_decap_8
XFILLER_109_210 VDD VSS sg13g2_decap_8
X_14240_ _14240_/Q clkload25/A _14240_/D _14240_/RESET_B VDD VSS sg13g2_dfrbpq_1
X_11452_ _11463_/A _11454_/A _13688_/Q VDD VSS sg13g2_nor2_1
X_14075__2127 _14075_/RESET_B VDD VSS sg13g2_tiehi
XFILLER_32_1456 VDD VSS sg13g2_decap_8
X_14111__2091 _14111_/RESET_B VDD VSS sg13g2_tiehi
X_10403_ _14823_/D _14823_/Q _10400_/Y _10402_/Y VDD VSS sg13g2_a21oi_1
XFILLER_171_319 VDD VSS sg13g2_decap_8
X_14171_ _14171_/Q clkload78/A _14171_/D _14171_/RESET_B VDD VSS sg13g2_dfrbpq_1
XFILLER_183_179 VDD VSS sg13g2_decap_8
X_11383_ _11383_/Y _11384_/A _13690_/Q VDD VSS sg13g2_nand2_1
XFILLER_125_736 VDD VSS sg13g2_decap_8
XFILLER_137_596 VDD VSS sg13g2_decap_8
XFILLER_11_60 VDD VSS sg13g2_decap_8
X_13122_ _13122_/Y _14883_/Q _13219_/B1 _13219_/C1 VDD VSS sg13g2_a21oi_1
X_10334_ _14804_/D _10334_/A _10335_/B _10337_/C VDD VSS sg13g2_and3_1
XFILLER_124_235 VDD VSS sg13g2_decap_8
XFILLER_152_555 VDD VSS sg13g2_decap_8
XFILLER_3_543 VDD VSS sg13g2_decap_8
XFILLER_106_961 VDD VSS sg13g2_decap_8
X_14715__1487 _14715_/RESET_B VDD VSS sg13g2_tiehi
XFILLER_65_1221 VDD VSS sg13g2_decap_8
XFILLER_2_0 VDD VSS sg13g2_decap_8
X_13053_ _13053_/Y _14782_/Q _13164_/A2 _13275_/B1 VDD VSS sg13g2_o21ai_1
XFILLER_124_279 VDD VSS sg13g2_decap_8
X_10265_ _10278_/C _10265_/A _10265_/B _10265_/C _10265_/D VDD VSS sg13g2_nor4_1
XFILLER_79_823 VDD VSS sg13g2_decap_8
XFILLER_156_1371 VDD VSS sg13g2_decap_8
XFILLER_117_1333 VDD VSS sg13g2_fill_1
Xpicorv32_macro_1440 mem_axi_arprot[1] VDD VSS sg13g2_tielo
Xfanout1300 _11368_/S1 fanout1319/X VDD VSS sg13g2_buf_1
X_12004_ _12004_/Y _12002_/Y _12003_/Y _12126_/A VDD VSS sg13g2_a21oi_1
XFILLER_87_53 VDD VSS sg13g2_decap_4
XFILLER_117_1344 VDD VSS sg13g2_decap_8
Xfanout1311 _12283_/S1 _12140_/S1 VDD VSS sg13g2_buf_1
Xfanout1322 _11649_/S0 _11972_/S0 VDD VSS sg13g2_buf_1
X_10196_ _14755_/D _15198_/D _14755_/Q _13650_/S VDD VSS sg13g2_mux2_1
XFILLER_26_1249 VDD VSS sg13g2_decap_8
XFILLER_152_1246 VDD VSS sg13g2_decap_8
Xfanout1333 _11788_/S0 fanout1339/X VDD VSS sg13g2_buf_1
XFILLER_65_1298 VDD VSS sg13g2_decap_8
Xfanout1344 _11531_/A _11555_/S0 VDD VSS sg13g2_buf_1
XFILLER_79_889 VDD VSS sg13g2_decap_8
XFILLER_78_366 VDD VSS sg13g2_decap_8
Xfanout1355 _11418_/A fanout1361/X VDD VSS sg13g2_buf_1
Xfanout1366 _11328_/S0 fanout1371/X VDD VSS sg13g2_buf_1
XFILLER_4_1001 VDD VSS sg13g2_decap_8
XFILLER_66_539 VDD VSS sg13g2_fill_1
XFILLER_19_411 VDD VSS sg13g2_decap_8
Xfanout1377 _12259_/S0 _12286_/S0 VDD VSS sg13g2_buf_1
XFILLER_59_580 VDD VSS sg13g2_decap_4
Xfanout390 fanout390/X _09013_/Y VDD VSS sg13g2_buf_1
Xfanout1388 fanout1388/X _11221_/S0 VDD VSS sg13g2_buf_1
XFILLER_47_731 VDD VSS sg13g2_decap_8
Xfanout1399 _13141_/A _07625_/Y VDD VSS sg13g2_buf_1
X_13955_ _13955_/Q clkload9/A _13955_/D _13955_/RESET_B VDD VSS sg13g2_dfrbpq_1
XFILLER_46_230 VDD VSS sg13g2_fill_1
XFILLER_59_1003 VDD VSS sg13g2_fill_2
XFILLER_4_1078 VDD VSS sg13g2_decap_8
X_12906_ _12925_/C _14901_/Q _13686_/Q VDD VSS sg13g2_nand2_1
XFILLER_62_723 VDD VSS sg13g2_decap_4
XFILLER_59_1036 VDD VSS sg13g2_fill_1
X_13886_ _13886_/Q _14526_/CLK _13886_/D _13886_/RESET_B VDD VSS sg13g2_dfrbpq_1
XFILLER_59_1047 VDD VSS sg13g2_decap_8
X_12837_ _12838_/A _14895_/Q _13692_/Q _12836_/C VDD VSS sg13g2_a21oi_1
XFILLER_37_1301 VDD VSS sg13g2_decap_8
X_14285__1917 _14285_/RESET_B VDD VSS sg13g2_tiehi
XFILLER_62_789 VDD VSS sg13g2_decap_4
XFILLER_61_266 VDD VSS sg13g2_decap_8
XFILLER_163_1331 VDD VSS sg13g2_decap_8
XFILLER_61_277 VDD VSS sg13g2_fill_2
X_14321__1881 _14321_/RESET_B VDD VSS sg13g2_tiehi
XFILLER_76_1394 VDD VSS sg13g2_decap_8
X_12768_ _12768_/X _13849_/Q _13881_/Q _13913_/Q _13945_/Q _12768_/S0 _12768_/S1 VDD
+ VSS sg13g2_mux4_1
XFILLER_124_1326 VDD VSS sg13g2_decap_8
XFILLER_72_1258 VDD VSS sg13g2_decap_8
XFILLER_37_1378 VDD VSS sg13g2_decap_8
X_14507_ _14507_/Q clkload11/A _14507_/D _14507_/RESET_B VDD VSS sg13g2_dfrbpq_1
XFILLER_175_614 VDD VSS sg13g2_decap_8
X_11719_ _11719_/Y _11858_/A _11719_/B VDD VSS sg13g2_nor2_1
X_12699_ _12699_/X _14260_/Q _14292_/Q _14324_/Q _14356_/Q _12699_/S0 _12699_/S1 VDD
+ VSS sg13g2_mux4_1
XFILLER_147_338 VDD VSS sg13g2_fill_2
XFILLER_35_1080 VDD VSS sg13g2_decap_4
XFILLER_30_686 VDD VSS sg13g2_decap_8
X_14438_ _14438_/Q _14724_/CLK _14438_/D _14438_/RESET_B VDD VSS sg13g2_dfrbpq_1
Xinput10 input10/X input10/A VDD VSS sg13g2_buf_1
Xinput21 input21/X input21/A VDD VSS sg13g2_buf_1
Xinput32 input32/X input32/A VDD VSS sg13g2_buf_1
XFILLER_174_168 VDD VSS sg13g2_fill_1
XFILLER_128_574 VDD VSS sg13g2_decap_8
XFILLER_174_179 VDD VSS sg13g2_decap_4
XFILLER_155_360 VDD VSS sg13g2_decap_8
XFILLER_156_894 VDD VSS sg13g2_decap_8
X_14369_ _14369_/Q clkload8/A _14369_/D _14369_/RESET_B VDD VSS sg13g2_dfrbpq_1
XFILLER_115_202 VDD VSS sg13g2_decap_8
XFILLER_7_882 VDD VSS sg13g2_decap_8
XFILLER_143_522 VDD VSS sg13g2_fill_1
XFILLER_171_842 VDD VSS sg13g2_decap_8
XFILLER_116_769 VDD VSS sg13g2_decap_8
XFILLER_115_268 VDD VSS sg13g2_decap_8
XFILLER_88_108 VDD VSS sg13g2_decap_8
XFILLER_171_897 VDD VSS sg13g2_decap_8
X_08930_ _08930_/X _15046_/Q _14950_/Q _10767_/A VDD VSS sg13g2_mux2_1
XFILLER_131_739 VDD VSS sg13g2_fill_1
XFILLER_83_1354 VDD VSS sg13g2_decap_8
XFILLER_44_1305 VDD VSS sg13g2_decap_8
XFILLER_135_1422 VDD VSS sg13g2_decap_8
XFILLER_130_238 VDD VSS sg13g2_decap_8
XFILLER_135_1433 VDD VSS sg13g2_fill_2
X_13773__2429 _13773_/RESET_B VDD VSS sg13g2_tiehi
XFILLER_69_333 VDD VSS sg13g2_fill_1
X_08861_ _13698_/D _16860_/A _08860_/X _08861_/S VDD VSS sg13g2_mux2_1
XFILLER_131_1319 VDD VSS sg13g2_decap_8
XFILLER_170_1368 VDD VSS sg13g2_decap_8
X_07812_ _08548_/B _13566_/A _07812_/B VDD VSS sg13g2_nand2_1
XFILLER_69_377 VDD VSS sg13g2_decap_8
X_08792_ _08792_/Y _13682_/Q _13469_/B VDD VSS sg13g2_nor2_1
XFILLER_85_837 VDD VSS sg13g2_decap_8
XFILLER_57_539 VDD VSS sg13g2_decap_8
X_07743_ _07744_/D _12348_/A _15217_/Q _15126_/Q VDD VSS sg13g2_nor3_1
XFILLER_38_742 VDD VSS sg13g2_decap_8
XFILLER_65_561 VDD VSS sg13g2_decap_8
X_14153__2049 _14153_/RESET_B VDD VSS sg13g2_tiehi
X_07674_ _07674_/Y _13600_/C _07677_/B VDD VSS sg13g2_nand2_1
XFILLER_93_892 VDD VSS sg13g2_decap_8
XFILLER_53_723 VDD VSS sg13g2_decap_8
XFILLER_25_414 VDD VSS sg13g2_decap_8
XFILLER_0_1443 VDD VSS sg13g2_decap_8
XFILLER_37_296 VDD VSS sg13g2_decap_8
XFILLER_20_1382 VDD VSS sg13g2_decap_8
X_09413_ _14015_/D _10075_/A0 _14015_/Q _09434_/S VDD VSS sg13g2_mux2_1
XFILLER_168_1286 VDD VSS sg13g2_decap_8
XFILLER_94_1461 VDD VSS sg13g2_decap_8
XFILLER_55_1412 VDD VSS sg13g2_decap_8
XFILLER_52_255 VDD VSS sg13g2_fill_1
XFILLER_12_119 VDD VSS sg13g2_decap_8
X_09344_ _13948_/D _09841_/A1 _13948_/Q _09374_/S VDD VSS sg13g2_mux2_1
XFILLER_80_597 VDD VSS sg13g2_decap_8
XFILLER_34_992 VDD VSS sg13g2_decap_8
XFILLER_181_1442 VDD VSS sg13g2_decap_8
XFILLER_16_1407 VDD VSS sg13g2_decap_8
XFILLER_179_986 VDD VSS sg13g2_decap_8
XFILLER_90_1358 VDD VSS sg13g2_decap_8
XFILLER_138_305 VDD VSS sg13g2_decap_8
X_13691__2513 _13691_/RESET_B VDD VSS sg13g2_tiehi
X_09275_ _13883_/D _13883_/Q _09906_/A1 _09306_/S VDD VSS sg13g2_mux2_1
XFILLER_165_102 VDD VSS sg13g2_decap_8
X_08226_ _08247_/C _08203_/A _08203_/B _07909_/B _07910_/A _08188_/Y VDD VSS sg13g2_a221oi_1
XFILLER_14_1142 VDD VSS sg13g2_decap_8
XFILLER_5_819 VDD VSS sg13g2_decap_8
XFILLER_180_105 VDD VSS sg13g2_decap_8
X_08157_ _08157_/X _08005_/X _08018_/X _08198_/S VDD VSS sg13g2_mux2_1
XFILLER_146_360 VDD VSS sg13g2_decap_8
XFILLER_88_1243 VDD VSS sg13g2_fill_1
XFILLER_140_1194 VDD VSS sg13g2_decap_8
XFILLER_147_894 VDD VSS sg13g2_decap_8
XFILLER_107_736 VDD VSS sg13g2_decap_8
XFILLER_175_1202 VDD VSS sg13g2_decap_8
XFILLER_4_329 VDD VSS sg13g2_decap_8
XFILLER_49_1205 VDD VSS sg13g2_decap_8
XFILLER_101_1156 VDD VSS sg13g2_decap_8
XFILLER_162_842 VDD VSS sg13g2_decap_8
XFILLER_179_1393 VDD VSS sg13g2_decap_8
XFILLER_84_1107 VDD VSS sg13g2_decap_8
X_08088_ _08088_/Y _08079_/S _08089_/B2 _08422_/S VDD VSS sg13g2_a21oi_1
XFILLER_164_14 VDD VSS sg13g2_decap_8
XFILLER_161_352 VDD VSS sg13g2_decap_8
XFILLER_122_739 VDD VSS sg13g2_decap_4
XFILLER_175_1279 VDD VSS sg13g2_decap_8
XFILLER_115_780 VDD VSS sg13g2_decap_8
XFILLER_161_396 VDD VSS sg13g2_decap_8
X_10050_ _14631_/D _10083_/A0 _14631_/Q _10059_/S VDD VSS sg13g2_mux2_1
XFILLER_0_546 VDD VSS sg13g2_decap_8
XFILLER_103_953 VDD VSS sg13g2_decap_8
XFILLER_102_441 VDD VSS sg13g2_fill_2
X_14363__1839 _14363_/RESET_B VDD VSS sg13g2_tiehi
X_13749__2453 _13749_/RESET_B VDD VSS sg13g2_tiehi
XFILLER_88_675 VDD VSS sg13g2_decap_8
XFILLER_180_35 VDD VSS sg13g2_decap_8
XFILLER_87_196 VDD VSS sg13g2_decap_8
XFILLER_25_1271 VDD VSS sg13g2_decap_8
XFILLER_112_1241 VDD VSS sg13g2_decap_8
XFILLER_5_1365 VDD VSS sg13g2_decap_8
XFILLER_112_1263 VDD VSS sg13g2_decap_8
XFILLER_17_915 VDD VSS sg13g2_decap_8
XFILLER_1_1218 VDD VSS sg13g2_decap_8
Xclkbuf_leaf_109_clk_i clkload59/A clkbuf_leaf_84_clk_i/A VDD VSS sg13g2_buf_8
XFILLER_84_881 VDD VSS sg13g2_decap_8
X_13740_ _13740_/Q _14670_/CLK _13740_/D _13740_/RESET_B VDD VSS sg13g2_dfrbpq_1
X_10952_ _11015_/A _10954_/A _10954_/B _10954_/C _10954_/D VDD VSS sg13g2_nor4_1
XFILLER_28_274 VDD VSS sg13g2_decap_4
XFILLER_147_1315 VDD VSS sg13g2_decap_8
XFILLER_186_1364 VDD VSS sg13g2_decap_8
X_14129__2073 _14129_/RESET_B VDD VSS sg13g2_tiehi
XFILLER_73_55 VDD VSS sg13g2_fill_2
XFILLER_32_907 VDD VSS sg13g2_decap_8
X_13671_ _13671_/Q _15188_/CLK _13671_/D _13671_/RESET_B VDD VSS sg13g2_dfrbpq_1
X_10883_ _10883_/X _10890_/C _10883_/B VDD VSS sg13g2_xor2_1
XFILLER_43_255 VDD VSS sg13g2_decap_4
XFILLER_31_406 VDD VSS sg13g2_fill_2
XFILLER_71_586 VDD VSS sg13g2_decap_8
X_12622_ _12622_/X _12618_/X _12617_/X _12614_/X _12613_/X _12622_/S0 _12567_/S VDD
+ VSS sg13g2_mux4_1
XFILLER_19_1042 VDD VSS sg13g2_fill_2
XFILLER_185_923 VDD VSS sg13g2_decap_8
XFILLER_11_130 VDD VSS sg13g2_decap_8
XFILLER_145_1083 VDD VSS sg13g2_decap_4
X_12553_ _12553_/X _12551_/X _12552_/X _12609_/S VDD VSS sg13g2_mux2_1
XFILLER_8_613 VDD VSS sg13g2_decap_8
XFILLER_12_675 VDD VSS sg13g2_decap_8
XFILLER_184_422 VDD VSS sg13g2_decap_8
X_11504_ _11506_/B _11777_/A _11777_/C VDD VSS sg13g2_nor2_1
XFILLER_7_112 VDD VSS sg13g2_decap_8
XFILLER_138_850 VDD VSS sg13g2_fill_2
XFILLER_185_978 VDD VSS sg13g2_decap_8
X_12484_ _12485_/B _12942_/B _12596_/A2 _12483_/X _12415_/A _12596_/C1 VDD VSS sg13g2_a221oi_1
XFILLER_32_1253 VDD VSS sg13g2_decap_8
X_14223_ _14223_/Q clkload35/A _14223_/D _14223_/RESET_B VDD VSS sg13g2_dfrbpq_1
XFILLER_171_105 VDD VSS sg13g2_decap_8
X_11435_ _11435_/X _13952_/Q _13984_/Q _14016_/Q _14048_/Q _12112_/A1 _12103_/B1 VDD
+ VSS sg13g2_mux4_1
XFILLER_184_499 VDD VSS sg13g2_decap_8
XFILLER_7_189 VDD VSS sg13g2_decap_8
XFILLER_165_691 VDD VSS sg13g2_decap_8
X_14154_ _14154_/Q clkload19/A _14154_/D _14154_/RESET_B VDD VSS sg13g2_dfrbpq_1
X_11366_ _11366_/Y _11366_/A _11366_/B _11366_/C VDD VSS sg13g2_nand3_1
XFILLER_158_1466 VDD VSS sg13g2_decap_8
XFILLER_180_661 VDD VSS sg13g2_decap_8
XFILLER_98_63 VDD VSS sg13g2_decap_8
XFILLER_3_340 VDD VSS sg13g2_decap_8
XFILLER_158_1477 VDD VSS sg13g2_fill_2
X_13105_ _13105_/X input14/X _13264_/A2 _13272_/B1 VDD VSS sg13g2_a21o_1
X_10317_ _10319_/B _10342_/A _10342_/C _14799_/Q VDD VSS sg13g2_a21oi_1
X_14085_ _14085_/Q _14725_/CLK _14085_/D _14085_/RESET_B VDD VSS sg13g2_dfrbpq_1
X_11297_ _11297_/Y _11315_/A1 _13885_/Q VDD VSS sg13g2_nand2b_1
XFILLER_4_896 VDD VSS sg13g2_decap_8
XFILLER_26_1002 VDD VSS sg13g2_decap_8
XFILLER_79_642 VDD VSS sg13g2_decap_8
XFILLER_65_1062 VDD VSS sg13g2_decap_8
X_13036_ _15035_/D _13027_/Y _13035_/Y _13127_/A VDD VSS sg13g2_a21oi_1
X_10248_ _14777_/D _10255_/D _10490_/A _10248_/C VDD VSS sg13g2_nor3_1
Xfanout1130 _11936_/A _08919_/A1 VDD VSS sg13g2_buf_1
XFILLER_78_152 VDD VSS sg13g2_decap_8
X_14339__1863 _14339_/RESET_B VDD VSS sg13g2_tiehi
Xfanout1141 _08493_/B2 _11843_/A VDD VSS sg13g2_buf_1
XFILLER_67_826 VDD VSS sg13g2_decap_8
XFILLER_121_783 VDD VSS sg13g2_decap_8
Xfanout1152 _07790_/A _11705_/A VDD VSS sg13g2_buf_1
X_10179_ _10179_/Y _10182_/A _10179_/B VDD VSS sg13g2_nand2_1
XFILLER_78_174 VDD VSS sg13g2_fill_2
Xfanout1163 _07778_/A _11570_/A VDD VSS sg13g2_buf_1
Xfanout1174 _07888_/B _08253_/A1 VDD VSS sg13g2_buf_1
Xfanout1185 _11384_/A _14960_/Q VDD VSS sg13g2_buf_1
XFILLER_94_656 VDD VSS sg13g2_decap_8
XFILLER_43_1371 VDD VSS sg13g2_decap_8
Xfanout1196 _12911_/B _13602_/A VDD VSS sg13g2_buf_1
X_14987_ _14987_/Q clkload46/A _14987_/D _14987_/RESET_B VDD VSS sg13g2_dfrbpq_1
XFILLER_78_1401 VDD VSS sg13g2_decap_8
XFILLER_93_166 VDD VSS sg13g2_decap_8
X_13938_ _13938_/Q _14514_/CLK _13938_/D _13938_/RESET_B VDD VSS sg13g2_dfrbpq_1
XFILLER_47_583 VDD VSS sg13g2_fill_1
XFILLER_19_285 VDD VSS sg13g2_decap_8
XFILLER_78_1478 VDD VSS sg13g2_fill_1
X_13869_ _13869_/Q clkload24/A _13869_/D _13869_/RESET_B VDD VSS sg13g2_dfrbpq_1
XFILLER_165_1448 VDD VSS sg13g2_decap_8
XFILLER_16_970 VDD VSS sg13g2_decap_4
XFILLER_179_238 VDD VSS sg13g2_decap_4
X_15218__3009 _15218_/RESET_B VDD VSS sg13g2_tiehi
Xclkbuf_leaf_73_clk_i clkload84/A clkbuf_leaf_75_clk_i/A VDD VSS sg13g2_buf_8
XFILLER_76_1191 VDD VSS sg13g2_decap_8
XFILLER_72_1022 VDD VSS sg13g2_fill_2
XFILLER_34_299 VDD VSS sg13g2_fill_1
XFILLER_37_1175 VDD VSS sg13g2_decap_8
X_15129__2722 _15129_/RESET_B VDD VSS sg13g2_tiehi
XFILLER_31_984 VDD VSS sg13g2_fill_1
XFILLER_30_461 VDD VSS sg13g2_decap_8
X_09060_ _09060_/X _15037_/Q _15234_/Q _09060_/S VDD VSS sg13g2_mux2_1
XFILLER_148_658 VDD VSS sg13g2_decap_8
XFILLER_102_1410 VDD VSS sg13g2_decap_8
XFILLER_147_157 VDD VSS sg13g2_decap_8
XFILLER_176_989 VDD VSS sg13g2_fill_2
X_13827__2375 _13827_/RESET_B VDD VSS sg13g2_tiehi
Xclkbuf_leaf_88_clk_i _14526_/CLK clkbuf_leaf_94_clk_i/A VDD VSS sg13g2_buf_8
X_08011_ _08011_/X _07845_/B _08653_/B _08673_/B _08048_/B _08046_/B _07627_/A VDD
+ VSS sg13g2_mux4_1
XFILLER_116_500 VDD VSS sg13g2_decap_8
XFILLER_162_116 VDD VSS sg13g2_decap_8
XFILLER_50_1386 VDD VSS sg13g2_decap_8
XFILLER_11_1359 VDD VSS sg13g2_decap_8
XFILLER_116_566 VDD VSS sg13g2_decap_8
XFILLER_89_406 VDD VSS sg13g2_decap_8
Xclkbuf_leaf_11_clk_i clkload30/A clkload2/A VDD VSS sg13g2_buf_8
XFILLER_131_525 VDD VSS sg13g2_decap_8
XFILLER_170_160 VDD VSS sg13g2_fill_1
X_09962_ _14546_/D _14546_/Q _10094_/A0 _09969_/S VDD VSS sg13g2_mux2_1
XFILLER_131_558 VDD VSS sg13g2_decap_8
X_08913_ _08913_/Y _10735_/A _14945_/Q VDD VSS sg13g2_nand2_1
X_09893_ _14479_/D _10158_/A1 _14479_/Q _09903_/S VDD VSS sg13g2_mux2_1
XFILLER_48_1293 VDD VSS sg13g2_decap_8
XFILLER_83_1184 VDD VSS sg13g2_fill_1
XFILLER_135_1263 VDD VSS sg13g2_decap_8
XFILLER_170_1165 VDD VSS sg13g2_decap_8
X_08844_ _08844_/Y _08844_/A _14928_/Q VDD VSS sg13g2_nor2b_1
XFILLER_84_100 VDD VSS sg13g2_fill_1
XFILLER_112_794 VDD VSS sg13g2_decap_8
XFILLER_44_1179 VDD VSS sg13g2_decap_8
XFILLER_111_282 VDD VSS sg13g2_fill_1
Xclkbuf_leaf_26_clk_i _15162_/CLK clkbuf_leaf_28_clk_i/A VDD VSS sg13g2_buf_8
XFILLER_85_645 VDD VSS sg13g2_decap_8
XFILLER_84_122 VDD VSS sg13g2_decap_8
XFILLER_131_1149 VDD VSS sg13g2_fill_1
XFILLER_22_1433 VDD VSS sg13g2_decap_8
X_08775_ _08775_/Y _13064_/B _08787_/B VDD VSS sg13g2_nor2_1
XFILLER_72_306 VDD VSS sg13g2_decap_8
XFILLER_150_38 VDD VSS sg13g2_decap_8
X_07726_ _07735_/C _07726_/A _07726_/B _07726_/C _07726_/D VDD VSS sg13g2_nand4_1
XFILLER_25_200 VDD VSS sg13g2_decap_8
XFILLER_26_756 VDD VSS sg13g2_decap_8
XFILLER_0_1240 VDD VSS sg13g2_decap_8
XFILLER_92_1409 VDD VSS sg13g2_decap_8
X_07657_ _10210_/D _15165_/Q _15164_/Q _15167_/Q _15166_/Q VDD VSS sg13g2_nor4_1
XFILLER_81_873 VDD VSS sg13g2_fill_2
XFILLER_13_417 VDD VSS sg13g2_decap_8
XFILLER_81_895 VDD VSS sg13g2_decap_8
XFILLER_25_277 VDD VSS sg13g2_decap_8
XFILLER_43_25 VDD VSS sg13g2_decap_8
XFILLER_90_1111 VDD VSS sg13g2_fill_1
XFILLER_107_1310 VDD VSS sg13g2_fill_2
XFILLER_159_14 VDD VSS sg13g2_decap_8
XFILLER_142_1201 VDD VSS sg13g2_fill_2
XFILLER_16_1204 VDD VSS sg13g2_decap_8
XFILLER_179_783 VDD VSS sg13g2_decap_8
X_09327_ _13934_/D _10157_/A1 _13934_/Q _09327_/S VDD VSS sg13g2_mux2_1
XFILLER_40_258 VDD VSS sg13g2_decap_8
XFILLER_107_1354 VDD VSS sg13g2_decap_8
XFILLER_55_1286 VDD VSS sg13g2_decap_8
XFILLER_139_647 VDD VSS sg13g2_decap_8
XFILLER_90_1188 VDD VSS sg13g2_fill_1
XFILLER_166_444 VDD VSS sg13g2_decap_8
X_09258_ _13867_/D _13867_/Q _09889_/A0 _09267_/S VDD VSS sg13g2_mux2_1
XFILLER_142_1289 VDD VSS sg13g2_decap_8
XFILLER_182_915 VDD VSS sg13g2_decap_8
X_14417__1785 _14417_/RESET_B VDD VSS sg13g2_tiehi
XFILLER_154_628 VDD VSS sg13g2_fill_1
X_08209_ _08209_/X _08209_/A _08234_/B VDD VSS sg13g2_and2_1
XFILLER_5_616 VDD VSS sg13g2_decap_8
XFILLER_166_499 VDD VSS sg13g2_decap_8
X_09189_ _13805_/D _13805_/Q _10156_/A1 _09189_/S VDD VSS sg13g2_mux2_1
XFILLER_153_116 VDD VSS sg13g2_decap_8
XFILLER_111_4 VDD VSS sg13g2_decap_4
XFILLER_181_436 VDD VSS sg13g2_decap_4
XFILLER_175_46 VDD VSS sg13g2_decap_8
X_11220_ _11223_/B _12304_/B _11217_/X _11219_/X VDD VSS sg13g2_a21oi_1
XFILLER_4_126 VDD VSS sg13g2_decap_8
XFILLER_134_341 VDD VSS sg13g2_fill_1
XFILLER_179_1190 VDD VSS sg13g2_decap_8
XFILLER_122_503 VDD VSS sg13g2_fill_2
X_11151_ _11151_/Y _11151_/A _11151_/B VDD VSS sg13g2_nor2_1
XFILLER_175_1065 VDD VSS sg13g2_fill_2
X_14596__1606 _14596_/RESET_B VDD VSS sg13g2_tiehi
XFILLER_1_833 VDD VSS sg13g2_decap_8
X_10102_ _14682_/D _10102_/A0 _14682_/Q _10102_/S VDD VSS sg13g2_mux2_1
XFILLER_122_558 VDD VSS sg13g2_decap_8
XFILLER_110_709 VDD VSS sg13g2_decap_4
X_14632__1570 _14632_/RESET_B VDD VSS sg13g2_tiehi
X_11082_ _11082_/Y _11109_/B _10754_/X _11154_/B1 VDD VSS sg13g2_o21ai_1
XFILLER_66_1382 VDD VSS sg13g2_decap_8
XFILLER_0_343 VDD VSS sg13g2_decap_8
XFILLER_122_569 VDD VSS sg13g2_fill_2
X_14906__2755 _14906_/RESET_B VDD VSS sg13g2_tiehi
XFILLER_88_450 VDD VSS sg13g2_decap_8
XFILLER_27_1355 VDD VSS sg13g2_decap_8
X_14910_ _14910_/Q clkload57/A _14910_/D _14910_/RESET_B VDD VSS sg13g2_dfrbpq_1
X_10033_ _14615_/D _10066_/A0 _14615_/Q _10035_/S VDD VSS sg13g2_mux2_1
XFILLER_76_612 VDD VSS sg13g2_fill_2
XFILLER_49_826 VDD VSS sg13g2_fill_1
XFILLER_7_1449 VDD VSS sg13g2_decap_8
XFILLER_62_1257 VDD VSS sg13g2_decap_8
XFILLER_76_656 VDD VSS sg13g2_fill_2
X_14841_ _14841_/Q _14848_/CLK _14841_/D _14841_/RESET_B VDD VSS sg13g2_dfrbpq_1
XFILLER_97_1309 VDD VSS sg13g2_decap_8
XFILLER_5_1162 VDD VSS sg13g2_decap_8
XFILLER_1_1015 VDD VSS sg13g2_decap_8
X_14772_ _14772_/Q clkload66/A _14772_/D _14772_/RESET_B VDD VSS sg13g2_dfrbpq_1
XFILLER_99_1180 VDD VSS sg13g2_decap_8
XFILLER_57_892 VDD VSS sg13g2_decap_8
X_13905__2297 _13905_/RESET_B VDD VSS sg13g2_tiehi
X_14939__2689 _14939_/RESET_B VDD VSS sg13g2_tiehi
X_11984_ _11986_/B _11914_/A _13673_/Q _13129_/B _11936_/A VDD VSS sg13g2_a22oi_1
XFILLER_90_136 VDD VSS sg13g2_fill_1
XFILLER_84_98 VDD VSS sg13g2_fill_2
XFILLER_186_1161 VDD VSS sg13g2_decap_8
X_13723_ _13723_/Q clkload78/A _13723_/D _13723_/RESET_B VDD VSS sg13g2_dfrbpq_1
XFILLER_17_70 VDD VSS sg13g2_decap_8
X_10935_ _10935_/Y _11014_/A _10935_/B VDD VSS sg13g2_nor2_1
XFILLER_72_862 VDD VSS sg13g2_decap_8
XFILLER_44_597 VDD VSS sg13g2_decap_8
XFILLER_108_1118 VDD VSS sg13g2_decap_8
XFILLER_140_93 VDD VSS sg13g2_decap_4
X_13654_ _15120_/D _15190_/D _12346_/A _13655_/S VDD VSS sg13g2_mux2_1
XFILLER_38_1440 VDD VSS sg13g2_decap_8
X_10866_ _10868_/C _14752_/Q _10691_/X _10857_/A VDD VSS sg13g2_a21oi_1
XFILLER_71_394 VDD VSS sg13g2_decap_8
XFILLER_125_1410 VDD VSS sg13g2_fill_1
XFILLER_73_1353 VDD VSS sg13g2_decap_8
X_12605_ _12605_/X _14381_/Q _14413_/Q _14477_/Q _14509_/Q _12605_/S0 _12605_/S1 VDD
+ VSS sg13g2_mux4_1
XFILLER_169_260 VDD VSS sg13g2_decap_8
XFILLER_158_934 VDD VSS sg13g2_fill_2
X_13585_ _15160_/D _13587_/B _13583_/Y _13584_/Y VDD VSS sg13g2_a21oi_1
XFILLER_13_984 VDD VSS sg13g2_decap_8
XFILLER_185_731 VDD VSS sg13g2_decap_8
X_10797_ _10798_/B _10843_/C _12346_/A _10797_/C VDD VSS sg13g2_nand3_1
XFILLER_8_410 VDD VSS sg13g2_decap_8
XFILLER_34_1348 VDD VSS sg13g2_decap_8
XFILLER_160_1367 VDD VSS sg13g2_decap_8
X_12536_ _12536_/X _14696_/Q _14728_/Q _13768_/Q _13800_/Q _12536_/S0 _12536_/S1 VDD
+ VSS sg13g2_mux4_1
XFILLER_9_966 VDD VSS sg13g2_decap_8
XFILLER_76_7 VDD VSS sg13g2_decap_8
XFILLER_144_116 VDD VSS sg13g2_fill_2
XFILLER_172_425 VDD VSS sg13g2_decap_8
X_12467_ _12467_/X _12464_/X _12463_/X _12460_/X _12459_/X _12608_/S1 _12455_/S VDD
+ VSS sg13g2_mux4_1
XFILLER_8_487 VDD VSS sg13g2_decap_8
XFILLER_184_296 VDD VSS sg13g2_decap_8
X_15117__2748 _15117_/RESET_B VDD VSS sg13g2_tiehi
X_14206_ _14206_/Q _14668_/CLK _14206_/D _14206_/RESET_B VDD VSS sg13g2_dfrbpq_1
XFILLER_125_330 VDD VSS sg13g2_fill_2
X_11418_ _11419_/B _11418_/A _14207_/Q VDD VSS sg13g2_nand2_1
X_15186_ _15186_/Q _15212_/CLK _15186_/D _15186_/RESET_B VDD VSS sg13g2_dfrbpq_1
X_12398_ _12398_/X _12389_/X _12390_/X _12396_/X _12395_/X _12398_/S0 _12705_/S1 VDD
+ VSS sg13g2_mux4_1
XFILLER_113_503 VDD VSS sg13g2_fill_2
XFILLER_119_1214 VDD VSS sg13g2_fill_2
XFILLER_158_1263 VDD VSS sg13g2_decap_8
XFILLER_99_726 VDD VSS sg13g2_decap_8
XFILLER_125_374 VDD VSS sg13g2_decap_4
X_14137_ _14137_/Q clkload44/A _14137_/D _14137_/RESET_B VDD VSS sg13g2_dfrbpq_1
XFILLER_99_737 VDD VSS sg13g2_fill_1
XFILLER_67_1157 VDD VSS sg13g2_decap_8
XFILLER_154_1116 VDD VSS sg13g2_decap_4
X_11349_ _11349_/Y _11812_/A1 _13758_/Q VDD VSS sg13g2_nand2b_1
XFILLER_98_236 VDD VSS sg13g2_decap_8
XFILLER_4_693 VDD VSS sg13g2_decap_8
XFILLER_113_558 VDD VSS sg13g2_fill_1
XFILLER_140_344 VDD VSS sg13g2_decap_8
X_14068_ _14068_/Q _15005_/CLK _14068_/D _14068_/RESET_B VDD VSS sg13g2_dfrbpq_1
XFILLER_141_889 VDD VSS sg13g2_decap_8
XFILLER_171_1441 VDD VSS sg13g2_decap_8
XFILLER_80_1335 VDD VSS sg13g2_decap_8
XFILLER_140_388 VDD VSS sg13g2_decap_8
X_13019_ _13019_/Y _13017_/Y _13018_/Y _12933_/Y VDD VSS sg13g2_o21ai_1
XFILLER_45_1466 VDD VSS sg13g2_decap_4
XFILLER_132_1425 VDD VSS sg13g2_decap_8
XFILLER_132_1436 VDD VSS sg13g2_fill_1
XFILLER_39_347 VDD VSS sg13g2_decap_8
XFILLER_66_144 VDD VSS sg13g2_decap_8
XFILLER_67_678 VDD VSS sg13g2_fill_1
XFILLER_94_475 VDD VSS sg13g2_fill_2
X_08560_ _08561_/C _08621_/A _08621_/B _08560_/C VDD VSS sg13g2_nor3_1
XFILLER_81_125 VDD VSS sg13g2_fill_1
XFILLER_54_339 VDD VSS sg13g2_decap_8
XFILLER_130_1182 VDD VSS sg13g2_fill_2
X_08491_ _08501_/D _08544_/C _08329_/A _08490_/Y VDD VSS sg13g2_o21ai_1
XFILLER_169_1392 VDD VSS sg13g2_decap_8
XFILLER_78_1275 VDD VSS sg13g2_decap_8
XFILLER_63_873 VDD VSS sg13g2_decap_8
XFILLER_35_564 VDD VSS sg13g2_decap_8
X_14070__2132 _14070_/RESET_B VDD VSS sg13g2_tiehi
XFILLER_165_1245 VDD VSS sg13g2_decap_8
XFILLER_23_726 VDD VSS sg13g2_fill_1
XFILLER_90_670 VDD VSS sg13g2_decap_8
XFILLER_50_512 VDD VSS sg13g2_decap_4
XFILLER_39_1259 VDD VSS sg13g2_decap_8
XFILLER_168_709 VDD VSS sg13g2_decap_4
XFILLER_148_400 VDD VSS sg13g2_decap_8
XFILLER_149_923 VDD VSS sg13g2_decap_8
X_14674__1528 _14674_/RESET_B VDD VSS sg13g2_tiehi
XFILLER_50_578 VDD VSS sg13g2_fill_2
XFILLER_13_39 VDD VSS sg13g2_decap_8
X_09112_ _13778_/D _13778_/Q _10094_/A0 _09153_/S VDD VSS sg13g2_mux2_1
X_14710__1492 _14710_/RESET_B VDD VSS sg13g2_tiehi
XFILLER_52_1459 VDD VSS sg13g2_decap_8
Xclkbuf_4_10_0_clk_i clkbuf_4_10_0_clk_i/X clkbuf_0_clk_i/X VDD VSS sg13g2_buf_8
XFILLER_129_39 VDD VSS sg13g2_decap_8
XFILLER_136_617 VDD VSS sg13g2_decap_8
X_09043_ _09056_/C _09043_/A _09043_/B VDD VSS sg13g2_nor2_1
XFILLER_15_1292 VDD VSS sg13g2_decap_8
XFILLER_50_1183 VDD VSS sg13g2_decap_8
XFILLER_159_1049 VDD VSS sg13g2_decap_8
XFILLER_163_458 VDD VSS sg13g2_decap_4
XFILLER_117_864 VDD VSS sg13g2_decap_8
XFILLER_11_1156 VDD VSS sg13g2_decap_8
XFILLER_132_812 VDD VSS sg13g2_decap_8
XFILLER_176_1352 VDD VSS sg13g2_decap_8
XFILLER_85_1246 VDD VSS sg13g2_decap_8
XFILLER_89_214 VDD VSS sg13g2_decap_8
XFILLER_116_385 VDD VSS sg13g2_decap_8
XFILLER_144_694 VDD VSS sg13g2_decap_8
XFILLER_171_480 VDD VSS sg13g2_decap_8
XFILLER_131_344 VDD VSS sg13g2_decap_4
XFILLER_137_1358 VDD VSS sg13g2_fill_2
Xfanout901 _12711_/S0 _12716_/S0 VDD VSS sg13g2_buf_1
XFILLER_172_1249 VDD VSS sg13g2_decap_8
Xfanout912 _12787_/S0 _12786_/S0 VDD VSS sg13g2_buf_1
X_09945_ _14529_/D _14529_/Q _10077_/A0 _09957_/S VDD VSS sg13g2_mux2_1
Xfanout923 _13289_/C _11243_/C VDD VSS sg13g2_buf_1
Xfanout934 _07737_/B _12779_/A2 VDD VSS sg13g2_buf_1
XFILLER_131_377 VDD VSS sg13g2_decap_8
Xfanout945 _13558_/B _15203_/Q VDD VSS sg13g2_buf_1
Xfanout956 _13391_/A _15183_/Q VDD VSS sg13g2_buf_1
XFILLER_38_25 VDD VSS sg13g2_decap_8
Xfanout967 _12947_/B _15108_/Q VDD VSS sg13g2_buf_1
X_09876_ _14462_/D _09909_/A1 _14462_/Q _09890_/S VDD VSS sg13g2_mux2_1
Xfanout978 _12851_/B _13029_/A2 VDD VSS sg13g2_buf_1
XFILLER_97_280 VDD VSS sg13g2_fill_1
X_14280__1922 _14280_/RESET_B VDD VSS sg13g2_tiehi
Xfanout989 _08229_/B _13427_/C VDD VSS sg13g2_buf_1
X_08827_ _13692_/D _08825_/Y _08824_/Y _08826_/Y VDD VSS sg13g2_a21oi_1
XFILLER_85_453 VDD VSS sg13g2_decap_8
XFILLER_180_7 VDD VSS sg13g2_decap_8
XFILLER_79_1006 VDD VSS sg13g2_decap_8
XFILLER_6_1460 VDD VSS sg13g2_decap_8
XFILLER_22_1230 VDD VSS sg13g2_decap_8
XFILLER_58_689 VDD VSS sg13g2_decap_8
XFILLER_57_166 VDD VSS sg13g2_decap_8
XFILLER_2_1302 VDD VSS sg13g2_decap_8
XFILLER_39_881 VDD VSS sg13g2_decap_4
X_08758_ _08758_/Y _13671_/Q _13469_/B VDD VSS sg13g2_nor2_1
XFILLER_72_125 VDD VSS sg13g2_decap_8
X_07709_ _07754_/B _10174_/B _14895_/Q _07708_/Y VDD VSS sg13g2_a21oi_1
XFILLER_96_1364 VDD VSS sg13g2_decap_8
XFILLER_2_1379 VDD VSS sg13g2_decap_8
XFILLER_54_873 VDD VSS sg13g2_fill_2
XFILLER_148_1443 VDD VSS sg13g2_decap_8
XFILLER_14_715 VDD VSS sg13g2_decap_8
XFILLER_183_1323 VDD VSS sg13g2_decap_8
X_08689_ _08690_/C _08692_/C _08048_/B _07993_/Y VDD VSS sg13g2_a21oi_1
XFILLER_92_1217 VDD VSS sg13g2_decap_8
XFILLER_13_214 VDD VSS sg13g2_decap_8
X_10720_ _10720_/Y _10725_/A _10720_/B VDD VSS sg13g2_nor2_1
XFILLER_57_1359 VDD VSS sg13g2_decap_8
XFILLER_41_545 VDD VSS sg13g2_fill_1
XFILLER_41_556 VDD VSS sg13g2_fill_2
XFILLER_16_1001 VDD VSS sg13g2_decap_8
XFILLER_186_539 VDD VSS sg13g2_decap_8
X_10651_ _10652_/D _14886_/Q _14885_/Q _14882_/Q _10651_/D VDD VSS sg13g2_nand4_1
XFILLER_10_910 VDD VSS sg13g2_decap_8
XFILLER_139_422 VDD VSS sg13g2_decap_8
XFILLER_110_96 VDD VSS sg13g2_decap_8
XFILLER_107_1173 VDD VSS sg13g2_decap_4
XFILLER_22_792 VDD VSS sg13g2_decap_8
X_13370_ _13442_/A _13401_/C _13401_/B _13438_/B VDD VSS sg13g2_nand3b_1
X_10582_ _10591_/D _14872_/Q _14871_/Q _14870_/Q _14869_/Q VDD VSS sg13g2_and4_1
XFILLER_70_67 VDD VSS sg13g2_decap_4
XFILLER_166_252 VDD VSS sg13g2_fill_1
XFILLER_16_1078 VDD VSS sg13g2_decap_8
XFILLER_6_914 VDD VSS sg13g2_decap_8
XFILLER_103_1037 VDD VSS sg13g2_decap_8
XFILLER_139_488 VDD VSS sg13g2_decap_8
XFILLER_142_1086 VDD VSS sg13g2_fill_2
XFILLER_186_56 VDD VSS sg13g2_decap_8
X_12321_ _12321_/Y _12330_/S0 _14522_/Q _12304_/B VDD VSS sg13g2_a21oi_1
XFILLER_10_987 VDD VSS sg13g2_decap_8
XFILLER_154_425 VDD VSS sg13g2_decap_8
XFILLER_5_413 VDD VSS sg13g2_decap_8
X_15040_ _15040_/Q _15188_/CLK _15040_/D _15040_/RESET_B VDD VSS sg13g2_dfrbpq_1
XFILLER_177_1149 VDD VSS sg13g2_decap_8
X_12252_ _12253_/A _14264_/Q _14296_/Q _14328_/Q _14360_/Q _12017_/A _12236_/C VDD
+ VSS sg13g2_mux4_1
XFILLER_135_650 VDD VSS sg13g2_decap_8
XFILLER_68_1433 VDD VSS sg13g2_decap_8
XFILLER_181_266 VDD VSS sg13g2_decap_8
XFILLER_79_32 VDD VSS sg13g2_decap_8
XFILLER_102_0 VDD VSS sg13g2_decap_8
XFILLER_120_1395 VDD VSS sg13g2_decap_8
XFILLER_155_1403 VDD VSS sg13g2_decap_8
X_11203_ _11203_/Y _11202_/A _11199_/Y _11202_/Y VDD VSS sg13g2_a21oi_1
XFILLER_134_160 VDD VSS sg13g2_decap_8
X_12183_ _12183_/X _13846_/Q _13878_/Q _12186_/A VDD VSS sg13g2_mux2_1
XFILLER_79_65 VDD VSS sg13g2_decap_8
XFILLER_107_396 VDD VSS sg13g2_decap_8
XFILLER_150_631 VDD VSS sg13g2_fill_2
XFILLER_1_630 VDD VSS sg13g2_decap_8
X_15018__2592 _15018_/RESET_B VDD VSS sg13g2_tiehi
X_15217__3008 _15217_/RESET_B VDD VSS sg13g2_tiehi
X_11134_ _11146_/B _11172_/A _11163_/A VDD VSS sg13g2_xnor2_1
XFILLER_123_889 VDD VSS sg13g2_decap_8
XFILLER_0_140 VDD VSS sg13g2_decap_8
XFILLER_135_60 VDD VSS sg13g2_decap_8
XFILLER_114_1100 VDD VSS sg13g2_decap_8
XFILLER_27_1152 VDD VSS sg13g2_decap_8
X_11065_ _11088_/A _11119_/A _11011_/Y _11063_/Y VDD VSS sg13g2_o21ai_1
XFILLER_110_539 VDD VSS sg13g2_decap_8
XFILLER_7_1246 VDD VSS sg13g2_decap_8
XFILLER_114_1133 VDD VSS sg13g2_decap_8
XFILLER_153_1182 VDD VSS sg13g2_decap_8
Xhold3090 input17/A mem_axi_rdata[21] VDD VSS sg13g2_dlygate4sd3_1
XFILLER_77_954 VDD VSS sg13g2_decap_8
X_10016_ _14598_/D _10082_/A0 _14598_/Q _10030_/S VDD VSS sg13g2_mux2_1
XFILLER_23_1038 VDD VSS sg13g2_decap_8
XFILLER_49_667 VDD VSS sg13g2_decap_4
XFILLER_114_1177 VDD VSS sg13g2_decap_8
X_15146__2688 _15146_/RESET_B VDD VSS sg13g2_tiehi
XFILLER_92_935 VDD VSS sg13g2_fill_1
XFILLER_64_626 VDD VSS sg13g2_decap_4
XFILLER_36_317 VDD VSS sg13g2_fill_1
X_14824_ _14824_/Q _14893_/CLK _14824_/D _14824_/RESET_B VDD VSS sg13g2_dfrbpq_1
XFILLER_36_328 VDD VSS sg13g2_decap_8
XFILLER_92_957 VDD VSS sg13g2_decap_8
XFILLER_29_380 VDD VSS sg13g2_decap_8
XFILLER_149_1229 VDD VSS sg13g2_decap_8
XFILLER_40_1396 VDD VSS sg13g2_decap_8
X_14755_ _14755_/Q clkload65/A _14755_/D _14755_/RESET_B VDD VSS sg13g2_dfrbpq_1
XFILLER_91_478 VDD VSS sg13g2_fill_1
X_11967_ _11971_/A _11966_/X _11967_/B VDD VSS sg13g2_nand2b_1
XFILLER_75_1426 VDD VSS sg13g2_decap_8
XFILLER_44_350 VDD VSS sg13g2_decap_8
X_13706_ _16868_/A clkload55/A _13706_/D _13706_/RESET_B VDD VSS sg13g2_dfrbpq_1
X_10918_ _10945_/B _14756_/Q _10936_/D _10888_/Y VDD VSS sg13g2_a21oi_1
X_14686_ _14686_/Q clkload60/A _14686_/D _14686_/RESET_B VDD VSS sg13g2_dfrbpq_1
X_11898_ _11898_/Y _11898_/A _11898_/B _11898_/C VDD VSS sg13g2_nand3_1
X_13637_ _13745_/D _13637_/A VDD VSS sg13g2_buf_1
XFILLER_73_1150 VDD VSS sg13g2_decap_8
X_10849_ _14930_/D _10849_/A _10849_/B VDD VSS sg13g2_nand2_1
XFILLER_13_792 VDD VSS sg13g2_decap_8
XFILLER_34_1145 VDD VSS sg13g2_decap_8
XFILLER_12_280 VDD VSS sg13g2_decap_8
XFILLER_158_764 VDD VSS sg13g2_decap_8
X_13568_ _15154_/D _15154_/Q _13567_/Y _13590_/B VDD VSS sg13g2_mux2_1
XFILLER_160_1164 VDD VSS sg13g2_decap_8
XFILLER_9_763 VDD VSS sg13g2_decap_8
XFILLER_145_403 VDD VSS sg13g2_fill_1
XFILLER_74_4 VDD VSS sg13g2_decap_8
XFILLER_118_628 VDD VSS sg13g2_decap_8
XFILLER_146_937 VDD VSS sg13g2_fill_1
XFILLER_172_200 VDD VSS sg13g2_decap_8
X_13659__1450 _13659_/RESET_B VDD VSS sg13g2_tiehi
X_12519_ _12519_/X _14567_/Q _14599_/Q _14631_/Q _14663_/Q _12520_/S0 _12520_/S1 VDD
+ VSS sg13g2_mux4_1
XFILLER_157_285 VDD VSS sg13g2_fill_2
XFILLER_12_1432 VDD VSS sg13g2_decap_8
X_13499_ _13499_/Y _13652_/S _13499_/B _13499_/C VDD VSS sg13g2_nand3_1
XFILLER_173_756 VDD VSS sg13g2_decap_8
XFILLER_8_284 VDD VSS sg13g2_decap_8
XFILLER_117_149 VDD VSS sg13g2_fill_1
X_15238_ _15238_/Q _15240_/CLK _15238_/D _15238_/RESET_B VDD VSS sg13g2_dfrbpq_1
XFILLER_161_929 VDD VSS sg13g2_decap_8
XFILLER_173_789 VDD VSS sg13g2_decap_8
XFILLER_114_823 VDD VSS sg13g2_fill_1
XFILLER_154_992 VDD VSS sg13g2_decap_8
XFILLER_5_980 VDD VSS sg13g2_decap_8
XFILLER_126_694 VDD VSS sg13g2_decap_8
XFILLER_158_1060 VDD VSS sg13g2_decap_8
X_15169_ _15169_/Q _15185_/CLK _15169_/D _15169_/RESET_B VDD VSS sg13g2_dfrbpq_1
XFILLER_5_84 VDD VSS sg13g2_decap_8
XFILLER_4_490 VDD VSS sg13g2_decap_8
Xfanout208 _10089_/A0 _09726_/A0 VDD VSS sg13g2_buf_1
XFILLER_87_707 VDD VSS sg13g2_decap_8
X_14088__2114 _14088_/RESET_B VDD VSS sg13g2_tiehi
Xfanout219 _10087_/A0 _10154_/A1 VDD VSS sg13g2_buf_1
X_07991_ _15057_/D _07991_/A VDD VSS sg13g2_inv_1
X_09730_ _14321_/D _09895_/A0 _14321_/Q _09738_/S VDD VSS sg13g2_mux2_1
XFILLER_45_1263 VDD VSS sg13g2_decap_8
XFILLER_95_740 VDD VSS sg13g2_decap_8
XFILLER_132_1233 VDD VSS sg13g2_fill_1
XFILLER_68_976 VDD VSS sg13g2_decap_8
X_09661_ _14254_/D _10124_/A0 _14254_/Q _09661_/S VDD VSS sg13g2_mux2_1
XFILLER_41_1138 VDD VSS sg13g2_decap_8
XFILLER_95_773 VDD VSS sg13g2_decap_8
X_14728__1474 _14728_/RESET_B VDD VSS sg13g2_tiehi
X_08612_ _08612_/X _08611_/Y _08610_/Y _08612_/S VDD VSS sg13g2_mux2_1
XFILLER_55_637 VDD VSS sg13g2_fill_2
XFILLER_54_103 VDD VSS sg13g2_fill_1
XFILLER_167_1318 VDD VSS sg13g2_decap_8
X_09592_ _14189_/D _14189_/Q _10023_/A0 _09599_/S VDD VSS sg13g2_mux2_1
XFILLER_54_136 VDD VSS sg13g2_decap_8
XFILLER_36_851 VDD VSS sg13g2_fill_1
X_08543_ _08545_/C _08553_/A _08522_/C _08542_/Y VDD VSS sg13g2_a21oi_1
XFILLER_36_884 VDD VSS sg13g2_fill_2
XFILLER_63_681 VDD VSS sg13g2_decap_8
XFILLER_51_821 VDD VSS sg13g2_decap_8
XFILLER_23_534 VDD VSS sg13g2_fill_1
X_08474_ _08475_/A _08138_/X _08544_/B _08473_/Y VDD VSS sg13g2_a21o_1
XFILLER_126_1026 VDD VSS sg13g2_decap_8
XFILLER_24_49 VDD VSS sg13g2_decap_4
XFILLER_51_876 VDD VSS sg13g2_fill_2
XFILLER_11_718 VDD VSS sg13g2_decap_8
XFILLER_149_731 VDD VSS sg13g2_fill_2
XFILLER_56_1381 VDD VSS sg13g2_decap_8
XFILLER_17_1343 VDD VSS sg13g2_decap_8
XFILLER_91_1272 VDD VSS sg13g2_decap_8
XFILLER_10_217 VDD VSS sg13g2_decap_8
XFILLER_50_386 VDD VSS sg13g2_decap_8
XFILLER_143_1362 VDD VSS sg13g2_decap_8
XFILLER_52_1256 VDD VSS sg13g2_decap_8
XFILLER_176_561 VDD VSS sg13g2_decap_8
XFILLER_13_1229 VDD VSS sg13g2_decap_8
XFILLER_136_414 VDD VSS sg13g2_decap_8
XFILLER_149_797 VDD VSS sg13g2_decap_8
XFILLER_164_745 VDD VSS sg13g2_decap_8
XFILLER_178_1425 VDD VSS sg13g2_decap_8
X_14298__1904 _14298_/RESET_B VDD VSS sg13g2_tiehi
XFILLER_87_1308 VDD VSS sg13g2_decap_4
X_09026_ _13765_/D _13765_/Q _10081_/A0 _09077_/S VDD VSS sg13g2_mux2_1
XFILLER_152_918 VDD VSS sg13g2_decap_8
XFILLER_102_1081 VDD VSS sg13g2_decap_8
XFILLER_163_277 VDD VSS sg13g2_fill_1
XFILLER_3_928 VDD VSS sg13g2_decap_8
XFILLER_2_427 VDD VSS sg13g2_decap_8
XFILLER_46_1005 VDD VSS sg13g2_decap_8
XFILLER_85_1087 VDD VSS sg13g2_decap_8
XFILLER_49_35 VDD VSS sg13g2_decap_8
XFILLER_172_25 VDD VSS sg13g2_decap_8
XFILLER_63_1330 VDD VSS sg13g2_decap_8
XFILLER_104_377 VDD VSS sg13g2_decap_8
Xfanout720 _11615_/B _11829_/A1 VDD VSS sg13g2_buf_1
XFILLER_77_217 VDD VSS sg13g2_decap_8
Xfanout731 _12324_/B _11266_/B VDD VSS sg13g2_buf_1
XFILLER_115_1420 VDD VSS sg13g2_decap_4
Xfanout742 _12184_/B _12112_/B1 VDD VSS sg13g2_buf_1
X_09928_ _14513_/D _14513_/Q _09928_/A1 _09936_/S VDD VSS sg13g2_mux2_1
XFILLER_77_228 VDD VSS sg13g2_fill_1
Xfanout753 _11185_/A _07652_/Y VDD VSS sg13g2_buf_1
XFILLER_77_239 VDD VSS sg13g2_decap_8
Xfanout764 _08597_/B _08056_/B VDD VSS sg13g2_buf_1
Xfanout775 _08079_/S _13553_/A1 VDD VSS sg13g2_buf_1
XFILLER_58_442 VDD VSS sg13g2_decap_8
XFILLER_105_52 VDD VSS sg13g2_fill_1
Xfanout786 _10797_/C _07751_/B VDD VSS sg13g2_buf_1
XFILLER_24_1347 VDD VSS sg13g2_decap_8
Xfanout797 _12762_/S _12664_/S VDD VSS sg13g2_buf_1
X_09859_ _14446_/D _14446_/Q _10057_/A0 _09859_/S VDD VSS sg13g2_mux2_1
XFILLER_150_1388 VDD VSS sg13g2_decap_4
X_12870_ _12871_/B _12869_/Y _12983_/A1 _12878_/D _12861_/X _12865_/Y VDD VSS sg13g2_a221oi_1
XFILLER_74_957 VDD VSS sg13g2_decap_8
XFILLER_185_1418 VDD VSS sg13g2_decap_8
XFILLER_22_1071 VDD VSS sg13g2_fill_1
X_13786__2416 _13786_/RESET_B VDD VSS sg13g2_tiehi
X_11821_ _11822_/A _14252_/Q _14284_/Q _14316_/Q _14348_/Q _11821_/S0 _11374_/C VDD
+ VSS sg13g2_mux4_1
XFILLER_61_607 VDD VSS sg13g2_decap_8
XFILLER_96_1161 VDD VSS sg13g2_decap_8
XFILLER_2_1176 VDD VSS sg13g2_decap_8
XFILLER_183_1120 VDD VSS sg13g2_decap_8
X_13822__2380 _13822_/RESET_B VDD VSS sg13g2_tiehi
X_14540_ _14540_/Q clkload53/A _14540_/D _14540_/RESET_B VDD VSS sg13g2_dfrbpq_1
XFILLER_92_1025 VDD VSS sg13g2_decap_8
XFILLER_121_73 VDD VSS sg13g2_fill_1
XFILLER_148_1262 VDD VSS sg13g2_decap_8
XFILLER_14_534 VDD VSS sg13g2_decap_8
X_11752_ _11752_/Y _11748_/Y _11749_/Y _11751_/Y _11750_/Y _11875_/B VDD VSS sg13g2_a221oi_1
XFILLER_57_1156 VDD VSS sg13g2_decap_8
XFILLER_14_556 VDD VSS sg13g2_decap_8
X_10703_ _14903_/D _10985_/B1 _10923_/A _10702_/Y VDD VSS sg13g2_o21ai_1
X_14471_ _14471_/Q clkload11/A _14471_/D _14471_/RESET_B VDD VSS sg13g2_dfrbpq_1
XFILLER_70_1301 VDD VSS sg13g2_decap_8
XFILLER_183_1197 VDD VSS sg13g2_decap_8
X_11683_ _11683_/Y _11692_/A _14472_/Q VDD VSS sg13g2_nand2b_1
XFILLER_144_1159 VDD VSS sg13g2_decap_8
XFILLER_186_336 VDD VSS sg13g2_decap_8
XFILLER_41_375 VDD VSS sg13g2_decap_8
XFILLER_35_1443 VDD VSS sg13g2_decap_8
X_13422_ _15094_/D _13490_/D _13421_/Y _13419_/Y VDD VSS sg13g2_o21ai_1
X_14166__2036 _14166_/RESET_B VDD VSS sg13g2_tiehi
X_10634_ _10637_/B _14886_/Q _10633_/C _10630_/C VDD VSS sg13g2_o21ai_1
XFILLER_31_1307 VDD VSS sg13g2_decap_8
XFILLER_122_1424 VDD VSS sg13g2_decap_8
XFILLER_155_701 VDD VSS sg13g2_decap_8
XFILLER_139_263 VDD VSS sg13g2_decap_4
XFILLER_155_712 VDD VSS sg13g2_fill_2
XFILLER_70_1378 VDD VSS sg13g2_decap_8
XFILLER_127_425 VDD VSS sg13g2_decap_8
X_13353_ _13353_/Y _13507_/A _13507_/B VDD VSS sg13g2_nor2_1
XFILLER_6_711 VDD VSS sg13g2_decap_8
XFILLER_128_959 VDD VSS sg13g2_decap_8
X_10565_ _10576_/D _10567_/C _10565_/B _10565_/C _10565_/D VDD VSS sg13g2_nor4_1
XFILLER_10_784 VDD VSS sg13g2_decap_8
XFILLER_127_436 VDD VSS sg13g2_fill_1
XFILLER_139_296 VDD VSS sg13g2_fill_2
XFILLER_182_531 VDD VSS sg13g2_fill_1
XFILLER_5_210 VDD VSS sg13g2_decap_8
X_12304_ _12308_/A _12303_/X _12304_/B VDD VSS sg13g2_nand2b_1
XFILLER_127_469 VDD VSS sg13g2_fill_2
XFILLER_143_918 VDD VSS sg13g2_decap_8
X_13284_ _13284_/Y _11241_/C _13284_/B _13297_/S VDD VSS sg13g2_nand3b_1
X_10496_ _14852_/D _10497_/B _10499_/C _10496_/C VDD VSS sg13g2_and3_1
XFILLER_6_788 VDD VSS sg13g2_decap_8
XFILLER_68_1230 VDD VSS sg13g2_decap_8
XFILLER_154_288 VDD VSS sg13g2_decap_8
X_15023_ _15023_/Q clkload65/A _15023_/D _15023_/RESET_B VDD VSS sg13g2_dfrbpq_1
XFILLER_107_160 VDD VSS sg13g2_decap_8
XFILLER_120_1192 VDD VSS sg13g2_decap_8
X_12235_ _12236_/B _12235_/A _14232_/Q VDD VSS sg13g2_nand2_1
XFILLER_108_694 VDD VSS sg13g2_decap_8
XFILLER_5_287 VDD VSS sg13g2_decap_8
XFILLER_123_653 VDD VSS sg13g2_decap_4
XFILLER_69_707 VDD VSS sg13g2_fill_1
XFILLER_29_1247 VDD VSS sg13g2_decap_8
XFILLER_116_1206 VDD VSS sg13g2_decap_8
X_12166_ _12170_/A _12165_/X _12233_/B VDD VSS sg13g2_nand2b_1
XFILLER_39_7 VDD VSS sg13g2_decap_8
X_11117_ _11117_/Y _11138_/B _11138_/C _11139_/B1 VDD VSS sg13g2_a21oi_1
XFILLER_2_994 VDD VSS sg13g2_decap_8
X_12097_ _12097_/Y _12100_/S0 _14644_/Q VDD VSS sg13g2_nand2b_1
XFILLER_7_1043 VDD VSS sg13g2_decap_8
XFILLER_42_1436 VDD VSS sg13g2_decap_8
X_11048_ _11048_/Y _14945_/Q _11048_/B VDD VSS sg13g2_nand2_1
X_14973__2637 _14973_/RESET_B VDD VSS sg13g2_tiehi
Xinput8 input8/X input8/A VDD VSS sg13g2_buf_1
XFILLER_92_732 VDD VSS sg13g2_decap_8
XFILLER_37_637 VDD VSS sg13g2_fill_2
XFILLER_65_957 VDD VSS sg13g2_decap_4
XFILLER_76_294 VDD VSS sg13g2_fill_2
XFILLER_91_231 VDD VSS sg13g2_fill_2
XFILLER_92_765 VDD VSS sg13g2_decap_8
X_14807_ _14807_/Q clkload85/A _14807_/D _14807_/RESET_B VDD VSS sg13g2_dfrbpq_1
XFILLER_40_1193 VDD VSS sg13g2_decap_8
XFILLER_149_1048 VDD VSS sg13g2_fill_2
XFILLER_17_350 VDD VSS sg13g2_decap_8
X_14376__1826 _14376_/RESET_B VDD VSS sg13g2_tiehi
X_12999_ _12999_/Y _12996_/Y _12998_/Y _12933_/Y VDD VSS sg13g2_o21ai_1
XFILLER_79_1381 VDD VSS sg13g2_decap_8
XFILLER_91_286 VDD VSS sg13g2_fill_1
XFILLER_75_1223 VDD VSS sg13g2_decap_8
X_14412__1790 _14412_/RESET_B VDD VSS sg13g2_tiehi
X_14738_ _14738_/Q _14743_/CLK _14738_/D _14738_/RESET_B VDD VSS sg13g2_dfrbpq_1
XFILLER_178_815 VDD VSS sg13g2_decap_8
XFILLER_44_191 VDD VSS sg13g2_decap_8
XFILLER_177_303 VDD VSS sg13g2_decap_8
XFILLER_166_1395 VDD VSS sg13g2_decap_8
XFILLER_36_1229 VDD VSS sg13g2_decap_8
XFILLER_32_353 VDD VSS sg13g2_decap_8
XFILLER_162_1248 VDD VSS sg13g2_decap_8
X_14669_ _14669_/Q clkload26/A _14669_/D _14669_/RESET_B VDD VSS sg13g2_dfrbpq_1
X_08190_ _08190_/Y _08190_/A _08190_/B VDD VSS sg13g2_nor2_1
X_14591__1611 _14591_/RESET_B VDD VSS sg13g2_tiehi
XFILLER_119_937 VDD VSS sg13g2_fill_1
XFILLER_9_560 VDD VSS sg13g2_decap_8
XFILLER_158_583 VDD VSS sg13g2_decap_8
XFILLER_118_436 VDD VSS sg13g2_decap_4
XFILLER_127_992 VDD VSS sg13g2_fill_1
XFILLER_156_1019 VDD VSS sg13g2_decap_8
XFILLER_114_620 VDD VSS sg13g2_decap_4
XFILLER_160_225 VDD VSS sg13g2_decap_8
XFILLER_160_236 VDD VSS sg13g2_fill_2
XFILLER_86_1363 VDD VSS sg13g2_decap_8
XFILLER_126_29 VDD VSS sg13g2_fill_2
XFILLER_99_331 VDD VSS sg13g2_decap_4
XFILLER_113_130 VDD VSS sg13g2_decap_8
X_13864__2338 _13864_/RESET_B VDD VSS sg13g2_tiehi
XFILLER_173_1344 VDD VSS sg13g2_decap_8
XFILLER_47_1347 VDD VSS sg13g2_decap_8
XFILLER_113_141 VDD VSS sg13g2_fill_2
XFILLER_114_686 VDD VSS sg13g2_decap_8
XFILLER_59_217 VDD VSS sg13g2_fill_1
XFILLER_101_314 VDD VSS sg13g2_fill_1
XFILLER_87_537 VDD VSS sg13g2_decap_8
XFILLER_113_185 VDD VSS sg13g2_fill_2
XFILLER_141_494 VDD VSS sg13g2_fill_1
X_07974_ _07976_/B _08697_/B _08698_/A _07974_/C _07974_/D VDD VSS sg13g2_and4_1
XFILLER_45_1060 VDD VSS sg13g2_decap_8
X_09713_ _14304_/D _10143_/A1 _14304_/Q _09733_/S VDD VSS sg13g2_mux2_1
XFILLER_19_49 VDD VSS sg13g2_decap_8
XFILLER_56_913 VDD VSS sg13g2_decap_8
XFILLER_55_401 VDD VSS sg13g2_decap_8
XFILLER_110_881 VDD VSS sg13g2_decap_8
XFILLER_110_892 VDD VSS sg13g2_decap_8
X_09644_ _14237_/D _09743_/A1 _14237_/Q _09667_/S VDD VSS sg13g2_mux2_1
XFILLER_27_114 VDD VSS sg13g2_fill_2
XFILLER_82_231 VDD VSS sg13g2_decap_8
XFILLER_27_147 VDD VSS sg13g2_decap_8
XFILLER_82_242 VDD VSS sg13g2_fill_2
XFILLER_3_1474 VDD VSS sg13g2_decap_4
XFILLER_27_158 VDD VSS sg13g2_fill_1
X_09575_ _14172_/D _14172_/Q _09841_/A1 _09605_/S VDD VSS sg13g2_mux2_1
XFILLER_110_1372 VDD VSS sg13g2_fill_1
XFILLER_82_275 VDD VSS sg13g2_decap_8
XFILLER_70_426 VDD VSS sg13g2_decap_8
XFILLER_42_117 VDD VSS sg13g2_decap_8
XFILLER_36_670 VDD VSS sg13g2_decap_8
XFILLER_93_1323 VDD VSS sg13g2_decap_8
X_08526_ _08535_/B _08526_/A _08526_/B _08526_/C VDD VSS sg13g2_and3_1
XFILLER_58_1476 VDD VSS sg13g2_fill_2
XFILLER_51_640 VDD VSS sg13g2_fill_2
XFILLER_24_865 VDD VSS sg13g2_decap_8
XFILLER_180_1315 VDD VSS sg13g2_decap_8
X_13660__2990 _13660_/RESET_B VDD VSS sg13g2_tiehi
XFILLER_54_1318 VDD VSS sg13g2_decap_8
XFILLER_145_1446 VDD VSS sg13g2_decap_8
XFILLER_168_314 VDD VSS sg13g2_fill_2
XFILLER_106_1408 VDD VSS sg13g2_decap_4
XFILLER_23_364 VDD VSS sg13g2_decap_8
X_08457_ _08457_/X _11843_/A _08900_/A1 _08465_/A3 _08457_/A3 _08686_/S0 _08669_/B1
+ VDD VSS sg13g2_mux4_1
XFILLER_11_515 VDD VSS sg13g2_decap_8
XFILLER_169_859 VDD VSS sg13g2_decap_8
X_15216__3007 _15216_/RESET_B VDD VSS sg13g2_tiehi
XFILLER_50_161 VDD VSS sg13g2_fill_2
XFILLER_17_1140 VDD VSS sg13g2_decap_8
X_08388_ _08388_/Y _08374_/Y _08375_/Y _08387_/Y VDD VSS sg13g2_o21ai_1
XFILLER_91_1091 VDD VSS sg13g2_decap_8
XFILLER_167_25 VDD VSS sg13g2_decap_8
XFILLER_177_870 VDD VSS sg13g2_fill_2
XFILLER_149_583 VDD VSS sg13g2_fill_1
XFILLER_13_1026 VDD VSS sg13g2_decap_8
XFILLER_178_1222 VDD VSS sg13g2_decap_8
XFILLER_164_542 VDD VSS sg13g2_decap_8
XFILLER_152_704 VDD VSS sg13g2_decap_8
X_10350_ _14809_/D _10350_/A _10350_/B _10557_/C VDD VSS sg13g2_and3_1
XFILLER_164_575 VDD VSS sg13g2_decap_8
X_09009_ _10697_/A _15029_/Q _15226_/Q _09027_/S VDD VSS sg13g2_mux2_1
XFILLER_3_725 VDD VSS sg13g2_decap_8
XFILLER_30_1384 VDD VSS sg13g2_decap_8
XFILLER_174_1119 VDD VSS sg13g2_decap_8
X_10281_ _10281_/Y _14786_/Q _14787_/Q _14788_/Q _10281_/D VDD VSS sg13g2_nand4_1
XFILLER_178_1299 VDD VSS sg13g2_decap_8
XFILLER_65_1403 VDD VSS sg13g2_decap_8
XFILLER_117_491 VDD VSS sg13g2_decap_8
XFILLER_133_940 VDD VSS sg13g2_decap_8
XFILLER_151_236 VDD VSS sg13g2_decap_4
XFILLER_2_224 VDD VSS sg13g2_decap_8
XFILLER_133_951 VDD VSS sg13g2_fill_1
XFILLER_183_46 VDD VSS sg13g2_decap_8
X_12020_ _12021_/A _14706_/Q _14738_/Q _13778_/Q _13810_/Q _12025_/A _12026_/C VDD
+ VSS sg13g2_mux4_1
XFILLER_151_269 VDD VSS sg13g2_decap_8
X_14454__1748 _14454_/RESET_B VDD VSS sg13g2_tiehi
XFILLER_132_472 VDD VSS sg13g2_decap_8
XFILLER_152_1417 VDD VSS sg13g2_decap_8
XFILLER_160_781 VDD VSS sg13g2_fill_2
XFILLER_120_634 VDD VSS sg13g2_decap_8
XFILLER_78_548 VDD VSS sg13g2_decap_8
XFILLER_8_1341 VDD VSS sg13g2_decap_8
XFILLER_78_559 VDD VSS sg13g2_fill_2
Xfanout550 _09074_/B1 _09024_/A VDD VSS sg13g2_buf_1
XFILLER_28_1280 VDD VSS sg13g2_decap_8
Xfanout561 _13482_/B fanout565/X VDD VSS sg13g2_buf_1
Xfanout572 _08359_/B2 _08334_/A1 VDD VSS sg13g2_buf_1
XFILLER_59_762 VDD VSS sg13g2_decap_8
X_13971_ _13971_/Q clkload36/A _13971_/D _13971_/RESET_B VDD VSS sg13g2_dfrbpq_1
Xfanout583 _13600_/B _13567_/A2 VDD VSS sg13g2_buf_1
XFILLER_24_1144 VDD VSS sg13g2_decap_8
XFILLER_120_689 VDD VSS sg13g2_decap_8
Xfanout594 _12338_/A2 _11288_/Y VDD VSS sg13g2_buf_1
XFILLER_76_77 VDD VSS sg13g2_fill_2
XFILLER_98_1223 VDD VSS sg13g2_decap_8
X_12922_ _12945_/A _14902_/Q _13685_/Q VDD VSS sg13g2_nand2_1
XFILLER_98_1234 VDD VSS sg13g2_fill_1
XFILLER_100_380 VDD VSS sg13g2_decap_4
XFILLER_185_1215 VDD VSS sg13g2_decap_8
XFILLER_92_21 VDD VSS sg13g2_decap_8
XFILLER_46_467 VDD VSS sg13g2_decap_8
X_12853_ _12853_/Y _14770_/Q _12918_/A2 _12918_/B1 VDD VSS sg13g2_o21ai_1
XFILLER_61_404 VDD VSS sg13g2_decap_4
X_11804_ _11805_/B _11804_/A _14220_/Q VDD VSS sg13g2_nand2_1
XFILLER_33_128 VDD VSS sg13g2_decap_4
X_12784_ _12784_/X _14586_/Q _14618_/Q _14650_/Q _14682_/Q _12787_/S0 _12787_/S1 VDD
+ VSS sg13g2_mux4_1
XFILLER_109_1032 VDD VSS sg13g2_decap_8
XFILLER_14_353 VDD VSS sg13g2_decap_8
X_14523_ _14523_/Q clkload78/A _14523_/D _14523_/RESET_B VDD VSS sg13g2_dfrbpq_1
X_11735_ _11736_/A _13962_/Q _13994_/Q _14026_/Q _14058_/Q _11756_/S _11963_/S1 VDD
+ VSS sg13g2_mux4_1
XFILLER_41_161 VDD VSS sg13g2_decap_8
XFILLER_30_824 VDD VSS sg13g2_decap_8
XFILLER_186_133 VDD VSS sg13g2_decap_8
XFILLER_35_1240 VDD VSS sg13g2_decap_8
X_14454_ _14454_/Q clkload75/A _14454_/D _14454_/RESET_B VDD VSS sg13g2_dfrbpq_1
X_11666_ _11666_/Y _11678_/S0 _13864_/Q _11693_/C VDD VSS sg13g2_a21oi_1
XFILLER_122_1221 VDD VSS sg13g2_decap_8
X_13405_ _13405_/Y _13437_/A _13405_/B _15090_/Q VDD VSS sg13g2_nand3_1
X_10617_ _10619_/C _10651_/D _10622_/C VDD VSS sg13g2_or2_1
XFILLER_70_1175 VDD VSS sg13g2_decap_8
X_14385_ _14385_/Q _14417_/CLK _14385_/D _14385_/RESET_B VDD VSS sg13g2_dfrbpq_1
XFILLER_128_745 VDD VSS sg13g2_decap_8
XFILLER_167_391 VDD VSS sg13g2_decap_8
X_11597_ _11598_/B _11804_/A _14214_/Q VDD VSS sg13g2_nand2_1
XFILLER_10_581 VDD VSS sg13g2_decap_8
XFILLER_122_1287 VDD VSS sg13g2_decap_8
X_13336_ _13485_/B hold3049/X _15172_/Q _13336_/S VDD VSS sg13g2_mux2_1
XFILLER_183_873 VDD VSS sg13g2_decap_8
X_10548_ _14864_/D _10556_/D _10608_/B _10548_/C VDD VSS sg13g2_nor3_1
XFILLER_41_91 VDD VSS sg13g2_fill_2
XFILLER_122_1298 VDD VSS sg13g2_fill_2
XFILLER_182_361 VDD VSS sg13g2_decap_8
XFILLER_115_417 VDD VSS sg13g2_decap_8
XFILLER_127_288 VDD VSS sg13g2_decap_8
XFILLER_170_523 VDD VSS sg13g2_fill_1
XFILLER_6_585 VDD VSS sg13g2_decap_8
X_13267_ _13270_/C _14925_/Q _13662_/Q VDD VSS sg13g2_xnor2_1
X_10479_ _10505_/B _13084_/A _14847_/Q VDD VSS sg13g2_and2_1
XFILLER_170_556 VDD VSS sg13g2_fill_1
X_15006_ _15006_/Q _15188_/CLK _15006_/D _15006_/RESET_B VDD VSS sg13g2_dfrbpq_1
XFILLER_68_1071 VDD VSS sg13g2_fill_2
XFILLER_29_1022 VDD VSS sg13g2_decap_8
X_12218_ _12223_/B _12217_/Y _12208_/Y _12217_/A _12216_/X _12263_/C VDD VSS sg13g2_a221oi_1
XFILLER_124_984 VDD VSS sg13g2_fill_2
XFILLER_170_589 VDD VSS sg13g2_decap_8
X_13198_ _15046_/D _13191_/Y _13197_/Y _13155_/A VDD VSS sg13g2_a21oi_1
XFILLER_9_1127 VDD VSS sg13g2_decap_8
XFILLER_97_835 VDD VSS sg13g2_decap_4
XFILLER_111_623 VDD VSS sg13g2_decap_4
XFILLER_151_792 VDD VSS sg13g2_decap_8
XFILLER_155_1074 VDD VSS sg13g2_decap_8
X_12149_ _14983_/D _12149_/A _12149_/B VDD VSS sg13g2_nand2_1
XFILLER_69_548 VDD VSS sg13g2_fill_2
XFILLER_2_791 VDD VSS sg13g2_decap_8
XFILLER_111_667 VDD VSS sg13g2_decap_8
XFILLER_116_1069 VDD VSS sg13g2_fill_2
XFILLER_42_1233 VDD VSS sg13g2_decap_8
XFILLER_81_1293 VDD VSS sg13g2_decap_8
XFILLER_38_924 VDD VSS sg13g2_decap_4
XFILLER_110_177 VDD VSS sg13g2_fill_2
XFILLER_2_63 VDD VSS sg13g2_decap_8
XFILLER_133_1383 VDD VSS sg13g2_decap_8
X_07690_ _07690_/X _07690_/A _11241_/C VDD VSS sg13g2_and2_1
XFILLER_65_754 VDD VSS sg13g2_decap_8
XFILLER_64_231 VDD VSS sg13g2_fill_2
XFILLER_25_607 VDD VSS sg13g2_decap_8
XFILLER_92_562 VDD VSS sg13g2_decap_8
XFILLER_53_938 VDD VSS sg13g2_decap_8
XFILLER_168_1468 VDD VSS sg13g2_decap_8
XFILLER_53_949 VDD VSS sg13g2_decap_8
XFILLER_52_426 VDD VSS sg13g2_decap_8
XFILLER_80_746 VDD VSS sg13g2_fill_1
XFILLER_24_128 VDD VSS sg13g2_decap_8
X_09360_ _13964_/D _09989_/A0 _13964_/Q _09362_/S VDD VSS sg13g2_mux2_1
XFILLER_75_1053 VDD VSS sg13g2_decap_8
X_08311_ _08312_/C _08616_/B _08334_/A1 VDD VSS sg13g2_nor2b_1
XFILLER_166_1192 VDD VSS sg13g2_decap_8
X_09291_ _13899_/D _13899_/Q _09889_/A0 _09300_/S VDD VSS sg13g2_mux2_1
XANTENNA_13 _16883_/A VDD VSS sg13g2_antennanp
XFILLER_166_818 VDD VSS sg13g2_decap_8
XFILLER_177_144 VDD VSS sg13g2_decap_8
X_08242_ _08688_/B _08242_/A _08244_/B VDD VSS sg13g2_nand2_1
XANTENNA_24 fanout480/X VDD VSS sg13g2_antennanp
XFILLER_162_1078 VDD VSS sg13g2_decap_8
XFILLER_119_712 VDD VSS sg13g2_decap_8
X_13918__2284 _13918_/RESET_B VDD VSS sg13g2_tiehi
XFILLER_140_1321 VDD VSS sg13g2_decap_8
XFILLER_14_1324 VDD VSS sg13g2_decap_8
XFILLER_118_200 VDD VSS sg13g2_decap_8
XFILLER_20_367 VDD VSS sg13g2_decap_8
XFILLER_53_1384 VDD VSS sg13g2_decap_8
XFILLER_177_199 VDD VSS sg13g2_fill_2
X_08173_ _08514_/A _08340_/B _08234_/B VDD VSS sg13g2_nand2_1
XFILLER_21_39 VDD VSS sg13g2_decap_4
XFILLER_88_1425 VDD VSS sg13g2_decap_8
XFILLER_101_1327 VDD VSS sg13g2_decap_8
XFILLER_174_862 VDD VSS sg13g2_fill_2
XFILLER_137_28 VDD VSS sg13g2_decap_8
XFILLER_146_586 VDD VSS sg13g2_fill_1
XFILLER_173_361 VDD VSS sg13g2_fill_2
XFILLER_133_203 VDD VSS sg13g2_fill_1
XFILLER_118_288 VDD VSS sg13g2_decap_8
XFILLER_161_523 VDD VSS sg13g2_decap_8
Xoutput120 mem_axi_wdata[24] _15156_/Q VDD VSS sg13g2_buf_1
XFILLER_47_1100 VDD VSS sg13g2_decap_8
Xoutput131 mem_axi_wdata[5] _15137_/Q VDD VSS sg13g2_buf_1
XFILLER_173_1141 VDD VSS sg13g2_decap_8
XFILLER_47_1144 VDD VSS sg13g2_decap_8
XFILLER_0_728 VDD VSS sg13g2_decap_8
XFILLER_115_995 VDD VSS sg13g2_decap_8
XFILLER_87_301 VDD VSS sg13g2_decap_8
XFILLER_114_483 VDD VSS sg13g2_decap_8
XFILLER_102_645 VDD VSS sg13g2_fill_1
XFILLER_134_1136 VDD VSS sg13g2_decap_8
XFILLER_134_1147 VDD VSS sg13g2_fill_1
XFILLER_87_345 VDD VSS sg13g2_decap_8
XFILLER_130_976 VDD VSS sg13g2_decap_8
XFILLER_60_1322 VDD VSS sg13g2_decap_8
XFILLER_102_678 VDD VSS sg13g2_decap_8
XFILLER_102_689 VDD VSS sg13g2_fill_1
X_07957_ _07958_/A _08567_/A _07956_/Y _07950_/Y _07829_/A _07954_/Y VDD VSS sg13g2_a221oi_1
XFILLER_25_1453 VDD VSS sg13g2_decap_8
XFILLER_112_1423 VDD VSS sg13g2_decap_8
XFILLER_151_1472 VDD VSS sg13g2_decap_8
X_07888_ _08229_/C _08203_/B _07888_/B VDD VSS sg13g2_nand2_1
XFILLER_46_47 VDD VSS sg13g2_fill_2
XFILLER_60_1399 VDD VSS sg13g2_decap_8
X_09627_ _14223_/D _10125_/A0 _14223_/Q _09637_/S VDD VSS sg13g2_mux2_1
XFILLER_95_1429 VDD VSS sg13g2_decap_8
XFILLER_55_275 VDD VSS sg13g2_decap_4
XFILLER_3_1271 VDD VSS sg13g2_decap_8
XFILLER_71_735 VDD VSS sg13g2_decap_8
X_09558_ _14156_/D _10088_/A0 _14156_/Q _09560_/S VDD VSS sg13g2_mux2_1
XFILLER_70_234 VDD VSS sg13g2_decap_8
XFILLER_169_601 VDD VSS sg13g2_decap_8
XFILLER_58_1273 VDD VSS sg13g2_decap_8
XFILLER_180_1112 VDD VSS sg13g2_decap_8
X_08509_ _08517_/B _08668_/A _08170_/X _08652_/B1 VDD VSS sg13g2_o21ai_1
XFILLER_52_971 VDD VSS sg13g2_decap_8
XFILLER_70_278 VDD VSS sg13g2_fill_1
XFILLER_12_824 VDD VSS sg13g2_fill_2
X_09489_ _14089_/D _09953_/A1 _14089_/Q _09493_/S VDD VSS sg13g2_mux2_1
XFILLER_93_1186 VDD VSS sg13g2_decap_8
XFILLER_11_312 VDD VSS sg13g2_decap_8
XFILLER_145_1265 VDD VSS sg13g2_decap_4
XFILLER_168_133 VDD VSS sg13g2_decap_4
XFILLER_178_35 VDD VSS sg13g2_decap_8
XFILLER_19_1268 VDD VSS sg13g2_decap_8
X_11520_ _11520_/Y _14902_/Q _11433_/B _11722_/B2 VDD VSS sg13g2_a21oi_1
XFILLER_51_492 VDD VSS sg13g2_decap_8
XFILLER_157_818 VDD VSS sg13g2_fill_1
XFILLER_141_1129 VDD VSS sg13g2_decap_8
XFILLER_157_829 VDD VSS sg13g2_decap_8
XFILLER_184_615 VDD VSS sg13g2_decap_8
XFILLER_180_1189 VDD VSS sg13g2_decap_8
X_14508__1694 _14508_/RESET_B VDD VSS sg13g2_tiehi
XFILLER_137_520 VDD VSS sg13g2_fill_2
XFILLER_168_199 VDD VSS sg13g2_decap_8
X_11451_ _11451_/Y _11450_/Y _11448_/X _11433_/Y VDD VSS sg13g2_o21ai_1
XFILLER_32_1435 VDD VSS sg13g2_decap_8
XFILLER_11_389 VDD VSS sg13g2_decap_8
XFILLER_137_542 VDD VSS sg13g2_decap_8
XFILLER_183_158 VDD VSS sg13g2_decap_8
X_10402_ _10402_/Y _14823_/Q _10413_/B _10544_/C VDD VSS sg13g2_o21ai_1
XFILLER_125_704 VDD VSS sg13g2_decap_8
XFILLER_178_1030 VDD VSS sg13g2_decap_8
X_14170_ _14170_/Q _14682_/CLK _14170_/D _14170_/RESET_B VDD VSS sg13g2_dfrbpq_1
XFILLER_109_266 VDD VSS sg13g2_decap_8
XFILLER_137_575 VDD VSS sg13g2_decap_8
X_11382_ _11385_/A _11339_/B _11335_/X _11336_/A VDD VSS sg13g2_a21oi_1
XFILLER_124_214 VDD VSS sg13g2_decap_8
X_13121_ _13121_/Y _14819_/Q _13219_/A2 _13150_/B _10513_/D VDD VSS sg13g2_a22oi_1
X_10333_ _10335_/B _14803_/Q _14804_/Q _10405_/C _10345_/C VDD VSS sg13g2_nand4_1
X_14687__1515 _14687_/RESET_B VDD VSS sg13g2_tiehi
XFILLER_3_522 VDD VSS sg13g2_decap_8
XFILLER_30_1181 VDD VSS sg13g2_decap_8
XFILLER_65_1200 VDD VSS sg13g2_decap_8
XFILLER_178_1096 VDD VSS sg13g2_decap_8
XFILLER_139_1058 VDD VSS sg13g2_decap_4
X_13052_ _13052_/Y _10504_/C _13150_/B _12947_/B _14878_/Q _13051_/X VDD VSS sg13g2_a221oi_1
XFILLER_156_1350 VDD VSS sg13g2_decap_8
X_10264_ _10266_/C _14782_/Q _10268_/D _14783_/Q VDD VSS sg13g2_a21oi_1
XFILLER_121_910 VDD VSS sg13g2_decap_4
XFILLER_87_32 VDD VSS sg13g2_decap_8
X_12003_ _12003_/Y _13142_/A _12294_/A2 _12156_/A VDD VSS sg13g2_a21oi_1
XFILLER_3_599 VDD VSS sg13g2_decap_8
XFILLER_121_943 VDD VSS sg13g2_decap_8
Xpicorv32_macro_1441 mem_axi_awaddr[0] VDD VSS sg13g2_tielo
Xfanout1301 _11997_/S1 _12038_/B1 VDD VSS sg13g2_buf_1
XFILLER_132_280 VDD VSS sg13g2_decap_8
Xfanout1312 _12140_/S1 fanout1319/X VDD VSS sg13g2_buf_1
X_10195_ _15198_/D input25/X _15198_/Q _10195_/S VDD VSS sg13g2_mux2_1
XFILLER_78_334 VDD VSS sg13g2_decap_8
XFILLER_65_1277 VDD VSS sg13g2_decap_8
XFILLER_26_1228 VDD VSS sg13g2_decap_8
XFILLER_117_1356 VDD VSS sg13g2_decap_8
XFILLER_121_954 VDD VSS sg13g2_fill_1
X_14831__2905 _14831_/RESET_B VDD VSS sg13g2_tiehi
Xfanout1323 _11969_/A _11972_/S0 VDD VSS sg13g2_buf_1
XFILLER_79_868 VDD VSS sg13g2_decap_8
Xfanout1334 _11315_/A1 _12100_/S0 VDD VSS sg13g2_buf_1
XFILLER_87_87 VDD VSS sg13g2_decap_8
Xfanout1345 _11555_/S0 fanout1351/X VDD VSS sg13g2_buf_1
Xfanout1356 _11804_/A _11814_/S0 VDD VSS sg13g2_buf_1
Xfanout1367 _11310_/A1 fanout1371/X VDD VSS sg13g2_buf_1
XFILLER_94_838 VDD VSS sg13g2_decap_8
Xfanout380 _09261_/S _09241_/Y VDD VSS sg13g2_buf_1
Xfanout1378 _12288_/S0 _12215_/S0 VDD VSS sg13g2_buf_1
Xfanout391 _10045_/A0 _10145_/A1 VDD VSS sg13g2_buf_1
Xfanout1389 _12306_/A _12330_/S0 VDD VSS sg13g2_buf_1
X_13954_ _13954_/Q _14727_/CLK _13954_/D _13954_/RESET_B VDD VSS sg13g2_dfrbpq_1
XFILLER_98_1020 VDD VSS sg13g2_decap_8
XFILLER_93_359 VDD VSS sg13g2_decap_8
XFILLER_4_1057 VDD VSS sg13g2_decap_8
XFILLER_98_1053 VDD VSS sg13g2_fill_1
XFILLER_47_765 VDD VSS sg13g2_decap_8
X_12905_ _12943_/A _14901_/Q _13686_/Q VDD VSS sg13g2_nor2_1
XFILLER_47_787 VDD VSS sg13g2_fill_2
X_13885_ _13885_/Q clkload31/A _13885_/D _13885_/RESET_B VDD VSS sg13g2_dfrbpq_1
X_14864__2839 _14864_/RESET_B VDD VSS sg13g2_tiehi
XFILLER_185_1034 VDD VSS sg13g2_fill_2
XFILLER_74_595 VDD VSS sg13g2_decap_8
XFILLER_61_212 VDD VSS sg13g2_decap_8
XFILLER_46_286 VDD VSS sg13g2_decap_4
XFILLER_61_223 VDD VSS sg13g2_fill_2
X_12836_ _12836_/Y _14895_/Q _12836_/B _12836_/C VDD VSS sg13g2_nand3_1
XFILLER_15_640 VDD VSS sg13g2_decap_8
XFILLER_163_1310 VDD VSS sg13g2_decap_8
XFILLER_185_1089 VDD VSS sg13g2_decap_8
Xclkbuf_5_13__f_clk_i clkbuf_leaf_38_clk_i/A clkbuf_4_6_0_clk_i/X VDD VSS sg13g2_buf_16
XFILLER_76_1373 VDD VSS sg13g2_decap_8
XFILLER_21_109 VDD VSS sg13g2_decap_8
X_12767_ _12767_/X _13753_/Q _14105_/Q _14457_/Q _14553_/Q _12773_/S0 _12773_/S1 VDD
+ VSS sg13g2_mux4_1
XFILLER_72_1237 VDD VSS sg13g2_decap_8
XFILLER_70_790 VDD VSS sg13g2_decap_8
XFILLER_37_1357 VDD VSS sg13g2_decap_8
X_14506_ _14506_/Q clkload19/A _14506_/D _14506_/RESET_B VDD VSS sg13g2_dfrbpq_1
X_11718_ _11718_/X _11710_/X _11711_/X _11714_/X _11715_/X _12101_/B _12118_/C VDD
+ VSS sg13g2_mux4_1
XFILLER_14_194 VDD VSS sg13g2_decap_8
XFILLER_163_1387 VDD VSS sg13g2_decap_8
X_12698_ _12698_/X _14388_/Q _14420_/Q _14484_/Q _14516_/Q _12698_/S0 _12698_/S1 VDD
+ VSS sg13g2_mux4_1
XFILLER_30_665 VDD VSS sg13g2_decap_8
XFILLER_159_199 VDD VSS sg13g2_decap_8
X_14437_ _14437_/Q _14725_/CLK _14437_/D _14437_/RESET_B VDD VSS sg13g2_dfrbpq_1
XFILLER_175_659 VDD VSS sg13g2_decap_8
Xinput11 input11/X input11/A VDD VSS sg13g2_buf_1
X_11649_ _11649_/X _14375_/Q _14407_/Q _14471_/Q _14503_/Q _11649_/S0 _11649_/S1 VDD
+ VSS sg13g2_mux4_1
Xinput22 input22/X input22/A VDD VSS sg13g2_buf_1
XFILLER_174_147 VDD VSS sg13g2_decap_8
Xinput33 input33/X input33/A VDD VSS sg13g2_buf_1
X_14368_ _14368_/Q clkload23/A _14368_/D _14368_/RESET_B VDD VSS sg13g2_dfrbpq_1
XFILLER_7_861 VDD VSS sg13g2_decap_8
X_14948__2671 _14948_/RESET_B VDD VSS sg13g2_tiehi
XFILLER_13_1390 VDD VSS sg13g2_decap_8
X_13319_ _15063_/D _13324_/A _13319_/B VDD VSS sg13g2_nor2_1
XFILLER_6_382 VDD VSS sg13g2_decap_8
XFILLER_143_545 VDD VSS sg13g2_decap_8
XFILLER_157_1136 VDD VSS sg13g2_fill_1
X_14299_ _14299_/Q _14491_/CLK _14299_/D _14299_/RESET_B VDD VSS sg13g2_dfrbpq_1
XFILLER_100_1360 VDD VSS sg13g2_fill_1
XFILLER_171_876 VDD VSS sg13g2_decap_8
XFILLER_131_718 VDD VSS sg13g2_decap_8
XFILLER_157_1169 VDD VSS sg13g2_decap_8
XFILLER_143_589 VDD VSS sg13g2_decap_8
XFILLER_83_1333 VDD VSS sg13g2_decap_8
XFILLER_170_397 VDD VSS sg13g2_fill_2
XFILLER_48_1475 VDD VSS sg13g2_decap_4
XFILLER_124_792 VDD VSS sg13g2_fill_2
X_08860_ _08860_/X _08859_/X _11483_/A _08875_/S VDD VSS sg13g2_mux2_1
XFILLER_111_431 VDD VSS sg13g2_fill_2
X_13781__2421 _13781_/RESET_B VDD VSS sg13g2_tiehi
XFILLER_112_965 VDD VSS sg13g2_decap_8
X_15215__3006 _15215_/RESET_B VDD VSS sg13g2_tiehi
XFILLER_170_1347 VDD VSS sg13g2_decap_8
X_07811_ _08522_/A _13566_/A _07812_/B VDD VSS sg13g2_or2_1
XFILLER_97_676 VDD VSS sg13g2_fill_1
XFILLER_111_464 VDD VSS sg13g2_decap_4
XFILLER_112_998 VDD VSS sg13g2_decap_8
X_08791_ _08791_/Y _13499_/C _15176_/Q _15119_/Q _07720_/C _13390_/A2 VDD VSS sg13g2_a221oi_1
XFILLER_96_164 VDD VSS sg13g2_decap_8
X_07742_ _07744_/C _13297_/S _07742_/B VDD VSS sg13g2_and2_1
XFILLER_84_348 VDD VSS sg13g2_decap_8
XFILLER_37_220 VDD VSS sg13g2_decap_8
X_15126__2730 _15126_/RESET_B VDD VSS sg13g2_tiehi
XFILLER_93_871 VDD VSS sg13g2_decap_8
XFILLER_77_1115 VDD VSS sg13g2_decap_8
X_07673_ _07677_/B _15055_/Q _13312_/A VDD VSS sg13g2_nor2b_1
X_14161__2041 _14161_/RESET_B VDD VSS sg13g2_tiehi
XFILLER_0_1422 VDD VSS sg13g2_decap_8
XFILLER_20_1361 VDD VSS sg13g2_decap_8
XFILLER_168_1265 VDD VSS sg13g2_decap_8
XFILLER_16_39 VDD VSS sg13g2_decap_8
X_09412_ _14014_/D _09942_/A1 _14014_/Q _09434_/S VDD VSS sg13g2_mux2_1
XFILLER_92_392 VDD VSS sg13g2_fill_1
XFILLER_80_532 VDD VSS sg13g2_fill_1
XFILLER_77_1159 VDD VSS sg13g2_decap_8
XFILLER_94_1440 VDD VSS sg13g2_decap_8
XFILLER_53_768 VDD VSS sg13g2_decap_8
XFILLER_181_1421 VDD VSS sg13g2_decap_8
X_09343_ _13947_/D _10138_/A1 _13947_/Q _09374_/S VDD VSS sg13g2_mux2_1
XFILLER_34_971 VDD VSS sg13g2_decap_8
XFILLER_21_610 VDD VSS sg13g2_fill_1
XFILLER_90_1326 VDD VSS sg13g2_fill_1
XFILLER_40_429 VDD VSS sg13g2_decap_8
XFILLER_90_1337 VDD VSS sg13g2_decap_8
XFILLER_55_1468 VDD VSS sg13g2_decap_8
X_09274_ _09294_/S _09307_/B _09806_/B _09707_/C VDD VSS sg13g2_nor3_1
XFILLER_142_1449 VDD VSS sg13g2_fill_1
XFILLER_178_486 VDD VSS sg13g2_decap_8
XFILLER_178_497 VDD VSS sg13g2_fill_1
XFILLER_138_339 VDD VSS sg13g2_decap_8
XFILLER_14_1121 VDD VSS sg13g2_decap_8
X_08225_ _08233_/B _08224_/X _08397_/A _08359_/B2 _08214_/X VDD VSS sg13g2_a22oi_1
XFILLER_32_49 VDD VSS sg13g2_decap_8
XFILLER_53_1181 VDD VSS sg13g2_decap_8
XFILLER_119_542 VDD VSS sg13g2_fill_2
XFILLER_165_169 VDD VSS sg13g2_decap_4
X_08156_ _08166_/C _08188_/A _08142_/A _08155_/Y _07869_/X _08154_/Y VDD VSS sg13g2_a221oi_1
XFILLER_107_715 VDD VSS sg13g2_decap_8
XFILLER_162_810 VDD VSS sg13g2_fill_1
XFILLER_4_308 VDD VSS sg13g2_decap_8
XFILLER_101_1135 VDD VSS sg13g2_decap_8
XFILLER_113_8 VDD VSS sg13g2_fill_2
XFILLER_162_821 VDD VSS sg13g2_decap_8
XFILLER_10_1029 VDD VSS sg13g2_decap_8
XFILLER_14_1198 VDD VSS sg13g2_decap_8
XFILLER_179_1372 VDD VSS sg13g2_decap_8
X_08087_ _08087_/X _08085_/A _08079_/X _08086_/B _08081_/X _08241_/A _08452_/D VDD
+ VSS sg13g2_mux4_1
XFILLER_101_1179 VDD VSS sg13g2_fill_1
XFILLER_175_1258 VDD VSS sg13g2_decap_8
XFILLER_122_718 VDD VSS sg13g2_decap_8
XFILLER_0_525 VDD VSS sg13g2_decap_8
XFILLER_103_932 VDD VSS sg13g2_decap_8
XFILLER_114_280 VDD VSS sg13g2_decap_8
XFILLER_88_654 VDD VSS sg13g2_decap_8
X_14371__1831 _14371_/RESET_B VDD VSS sg13g2_tiehi
XFILLER_87_142 VDD VSS sg13g2_fill_1
XFILLER_76_805 VDD VSS sg13g2_decap_8
XFILLER_62_1439 VDD VSS sg13g2_decap_8
XFILLER_102_453 VDD VSS sg13g2_decap_8
XFILLER_130_762 VDD VSS sg13g2_decap_8
XFILLER_130_773 VDD VSS sg13g2_fill_1
XFILLER_180_14 VDD VSS sg13g2_decap_8
X_08989_ _08989_/X _08972_/S _08985_/X _08988_/Y VDD VSS sg13g2_a21o_1
XFILLER_87_175 VDD VSS sg13g2_decap_8
XFILLER_25_1250 VDD VSS sg13g2_decap_8
X_15172__2976 _15172_/RESET_B VDD VSS sg13g2_tiehi
XFILLER_75_337 VDD VSS sg13g2_fill_1
XFILLER_112_1220 VDD VSS sg13g2_decap_8
XFILLER_5_1344 VDD VSS sg13g2_decap_8
XFILLER_60_1196 VDD VSS sg13g2_decap_8
X_10951_ _10956_/A _11004_/A _10949_/Y _10950_/Y VDD VSS sg13g2_o21ai_1
XFILLER_186_1343 VDD VSS sg13g2_decap_8
XFILLER_21_1169 VDD VSS sg13g2_decap_8
XFILLER_95_1237 VDD VSS sg13g2_fill_2
XFILLER_16_437 VDD VSS sg13g2_fill_2
XFILLER_71_521 VDD VSS sg13g2_fill_1
XFILLER_83_392 VDD VSS sg13g2_decap_8
X_13670_ _13670_/Q clkload70/A _13670_/D _13670_/RESET_B VDD VSS sg13g2_dfrbpq_1
X_10882_ _10883_/B _14753_/Q _10871_/A _10869_/B VDD VSS sg13g2_a21oi_1
XFILLER_182_1229 VDD VSS sg13g2_decap_8
XFILLER_44_779 VDD VSS sg13g2_decap_8
XFILLER_19_1010 VDD VSS sg13g2_fill_1
XFILLER_73_78 VDD VSS sg13g2_decap_8
X_12621_ _12621_/X _12620_/X _12619_/X _12616_/X _12615_/X _12622_/S0 _12567_/S VDD
+ VSS sg13g2_mux4_1
XFILLER_25_993 VDD VSS sg13g2_decap_8
XFILLER_24_481 VDD VSS sg13g2_decap_8
XFILLER_185_902 VDD VSS sg13g2_decap_8
XFILLER_157_604 VDD VSS sg13g2_decap_8
X_12552_ _12552_/X _12550_/X _12549_/X _12546_/X _12545_/X _12705_/S0 _12706_/S VDD
+ VSS sg13g2_mux4_1
XFILLER_12_654 VDD VSS sg13g2_decap_8
XFILLER_184_401 VDD VSS sg13g2_decap_8
XFILLER_132_0 VDD VSS sg13g2_decap_8
X_11503_ _11777_/C _11461_/A _13687_/Q _13686_/Q _11483_/A _11463_/Y VDD VSS sg13g2_a221oi_1
XFILLER_40_985 VDD VSS sg13g2_decap_4
XFILLER_185_957 VDD VSS sg13g2_decap_8
XFILLER_36_1390 VDD VSS sg13g2_decap_8
X_14024__2178 _14024_/RESET_B VDD VSS sg13g2_tiehi
X_12483_ _12483_/X _12481_/X _12482_/X _12623_/S VDD VSS sg13g2_mux2_1
XFILLER_32_1232 VDD VSS sg13g2_decap_8
XFILLER_89_1019 VDD VSS sg13g2_decap_4
XFILLER_11_186 VDD VSS sg13g2_decap_8
XFILLER_71_1292 VDD VSS sg13g2_decap_8
X_14222_ _14222_/Q _14670_/CLK _14222_/D _14222_/RESET_B VDD VSS sg13g2_dfrbpq_1
XFILLER_8_669 VDD VSS sg13g2_decap_8
XFILLER_184_478 VDD VSS sg13g2_decap_8
X_11434_ _11434_/X _14112_/Q _14144_/Q _14176_/Q _14208_/Q _12112_/A1 _12103_/B1 VDD
+ VSS sg13g2_mux4_1
XFILLER_7_168 VDD VSS sg13g2_decap_8
X_14153_ _14153_/Q clkload28/A _14153_/D _14153_/RESET_B VDD VSS sg13g2_dfrbpq_1
X_11365_ _11366_/B _11365_/A _14494_/Q VDD VSS sg13g2_nand2_1
XFILLER_158_1445 VDD VSS sg13g2_decap_8
XFILLER_98_42 VDD VSS sg13g2_decap_8
XFILLER_153_865 VDD VSS sg13g2_decap_8
XFILLER_180_651 VDD VSS sg13g2_decap_4
XFILLER_67_1339 VDD VSS sg13g2_decap_8
X_13104_ _13104_/Y _13104_/A _13104_/B VDD VSS sg13g2_xnor2_1
XFILLER_125_578 VDD VSS sg13g2_decap_8
X_10316_ _14798_/D _10342_/A _10342_/C _10315_/Y VDD VSS sg13g2_a21oi_1
XFILLER_4_875 VDD VSS sg13g2_decap_8
X_14084_ _14084_/Q _14724_/CLK _14084_/D _14084_/RESET_B VDD VSS sg13g2_dfrbpq_1
X_11296_ _11296_/Y _11315_/A1 _13853_/Q _12100_/S1 VDD VSS sg13g2_a21oi_1
XFILLER_106_792 VDD VSS sg13g2_fill_2
XFILLER_140_537 VDD VSS sg13g2_decap_4
XFILLER_79_621 VDD VSS sg13g2_decap_8
X_13035_ _13035_/Y _13034_/Y _13048_/B _13031_/Y VDD VSS sg13g2_a21oi_1
XFILLER_117_1131 VDD VSS sg13g2_decap_8
XFILLER_156_1180 VDD VSS sg13g2_decap_8
X_10247_ _10255_/D _14775_/Q _14776_/Q _14777_/Q _10247_/D VDD VSS sg13g2_and4_1
XFILLER_3_396 VDD VSS sg13g2_decap_8
XFILLER_67_805 VDD VSS sg13g2_decap_8
XFILLER_121_762 VDD VSS sg13g2_decap_8
Xfanout1120 _08931_/A1 _14982_/Q VDD VSS sg13g2_buf_1
XFILLER_117_1164 VDD VSS sg13g2_decap_8
Xfanout1131 _07818_/B _08919_/A1 VDD VSS sg13g2_buf_1
Xfanout1142 _11843_/A _14975_/Q VDD VSS sg13g2_buf_1
XFILLER_113_1017 VDD VSS sg13g2_decap_8
Xfanout1153 _11705_/A _14971_/Q VDD VSS sg13g2_buf_1
X_10178_ _10182_/A _10178_/A _10185_/B _10184_/C VDD VSS sg13g2_nand3_1
XFILLER_94_635 VDD VSS sg13g2_decap_8
XFILLER_43_1350 VDD VSS sg13g2_decap_8
Xclkbuf_leaf_7_clk_i clkload13/A clkbuf_leaf_8_clk_i/A VDD VSS sg13g2_buf_8
Xfanout1164 _11570_/A _14967_/Q VDD VSS sg13g2_buf_1
Xfanout1175 _08253_/A1 _11461_/A VDD VSS sg13g2_buf_1
XFILLER_152_1099 VDD VSS sg13g2_decap_8
Xfanout1186 _07630_/A _07879_/A VDD VSS sg13g2_buf_1
Xfanout1197 _13602_/A _14958_/Q VDD VSS sg13g2_buf_1
XFILLER_93_145 VDD VSS sg13g2_decap_8
X_14986_ _14986_/Q clkload46/A _14986_/D _14986_/RESET_B VDD VSS sg13g2_dfrbpq_1
XFILLER_82_819 VDD VSS sg13g2_decap_8
XFILLER_19_242 VDD VSS sg13g2_fill_2
XFILLER_130_1364 VDD VSS sg13g2_decap_8
XFILLER_81_307 VDD VSS sg13g2_decap_8
XFILLER_19_264 VDD VSS sg13g2_decap_8
X_13937_ _13937_/Q _14417_/CLK _13937_/D _13937_/RESET_B VDD VSS sg13g2_dfrbpq_1
XFILLER_78_1457 VDD VSS sg13g2_decap_8
XFILLER_165_1427 VDD VSS sg13g2_decap_8
X_13868_ _13868_/Q _14508_/CLK _13868_/D _13868_/RESET_B VDD VSS sg13g2_dfrbpq_1
X_14234__1968 _14234_/RESET_B VDD VSS sg13g2_tiehi
XFILLER_90_874 VDD VSS sg13g2_decap_8
XFILLER_34_256 VDD VSS sg13g2_decap_8
X_12819_ _12819_/Y _14768_/Q _12918_/A2 _12918_/B1 VDD VSS sg13g2_o21ai_1
XFILLER_76_1170 VDD VSS sg13g2_decap_8
X_13799_ _13799_/Q clkload5/A _13799_/D _13799_/RESET_B VDD VSS sg13g2_dfrbpq_1
X_15165__2536 _15165_/RESET_B VDD VSS sg13g2_tiehi
XFILLER_128_1271 VDD VSS sg13g2_decap_8
XFILLER_37_1154 VDD VSS sg13g2_decap_8
XFILLER_128_1282 VDD VSS sg13g2_fill_2
XFILLER_31_963 VDD VSS sg13g2_decap_8
XFILLER_30_440 VDD VSS sg13g2_decap_8
XFILLER_163_1184 VDD VSS sg13g2_decap_8
XFILLER_33_1018 VDD VSS sg13g2_decap_8
XFILLER_148_637 VDD VSS sg13g2_decap_8
X_13799__2403 _13799_/RESET_B VDD VSS sg13g2_tiehi
XFILLER_147_136 VDD VSS sg13g2_decap_8
X_15155__2670 _15155_/RESET_B VDD VSS sg13g2_tiehi
X_08010_ _08010_/Y _08054_/B _08653_/B VDD VSS sg13g2_nand2_1
XFILLER_129_873 VDD VSS sg13g2_decap_4
XFILLER_15_1474 VDD VSS sg13g2_decap_4
XFILLER_8_95 VDD VSS sg13g2_decap_8
XFILLER_50_1365 VDD VSS sg13g2_decap_8
XFILLER_11_1338 VDD VSS sg13g2_decap_8
XFILLER_102_1466 VDD VSS sg13g2_decap_8
XFILLER_156_692 VDD VSS sg13g2_decap_8
XFILLER_102_1477 VDD VSS sg13g2_fill_2
XFILLER_128_394 VDD VSS sg13g2_decap_8
XFILLER_155_180 VDD VSS sg13g2_decap_8
XFILLER_85_1439 VDD VSS sg13g2_decap_8
X_09961_ _14545_/D _14545_/Q _09961_/A1 _09969_/S VDD VSS sg13g2_mux2_1
X_14179__2023 _14179_/RESET_B VDD VSS sg13g2_tiehi
XFILLER_143_386 VDD VSS sg13g2_decap_8
XFILLER_171_695 VDD VSS sg13g2_decap_8
XFILLER_83_1141 VDD VSS sg13g2_decap_4
X_08912_ _08912_/Y _10697_/C _08977_/C _15041_/Q VDD VSS sg13g2_nand3_1
XFILLER_98_941 VDD VSS sg13g2_decap_8
XFILLER_48_1272 VDD VSS sg13g2_decap_8
XFILLER_174_1280 VDD VSS sg13g2_decap_8
X_09892_ _14478_/D _09925_/A1 _14478_/Q _09892_/S VDD VSS sg13g2_mux2_1
XFILLER_85_602 VDD VSS sg13g2_fill_2
XFILLER_69_153 VDD VSS sg13g2_fill_2
XFILLER_112_773 VDD VSS sg13g2_decap_8
X_08843_ _08843_/Y _11384_/A _08843_/B VDD VSS sg13g2_nand2_1
XFILLER_44_1158 VDD VSS sg13g2_decap_8
XFILLER_22_1412 VDD VSS sg13g2_decap_8
XFILLER_100_957 VDD VSS sg13g2_decap_8
X_08774_ _13676_/D _08728_/Y _08773_/Y _08772_/Y VDD VSS sg13g2_a21oi_1
XFILLER_73_819 VDD VSS sg13g2_decap_4
XFILLER_38_562 VDD VSS sg13g2_decap_8
X_07725_ _07726_/D _15089_/Q _15086_/Q _15076_/Q _15074_/Q VDD VSS sg13g2_nor4_1
XFILLER_66_893 VDD VSS sg13g2_decap_4
XFILLER_81_830 VDD VSS sg13g2_decap_4
XFILLER_26_735 VDD VSS sg13g2_decap_8
X_07656_ _07656_/Y _11957_/A VDD VSS sg13g2_inv_1
XFILLER_129_1024 VDD VSS sg13g2_fill_2
XFILLER_168_1084 VDD VSS sg13g2_decap_8
XFILLER_25_256 VDD VSS sg13g2_decap_8
XFILLER_168_1095 VDD VSS sg13g2_fill_2
XFILLER_179_740 VDD VSS sg13g2_decap_8
X_14986__2624 _14986_/RESET_B VDD VSS sg13g2_tiehi
XFILLER_0_1296 VDD VSS sg13g2_decap_8
XFILLER_179_751 VDD VSS sg13g2_fill_1
XFILLER_167_902 VDD VSS sg13g2_fill_2
XFILLER_179_762 VDD VSS sg13g2_decap_8
XFILLER_90_1123 VDD VSS sg13g2_decap_8
XFILLER_22_941 VDD VSS sg13g2_decap_8
X_09326_ _13933_/D _09891_/A0 _13933_/Q _09329_/S VDD VSS sg13g2_mux2_1
XFILLER_55_1265 VDD VSS sg13g2_decap_8
XFILLER_139_626 VDD VSS sg13g2_decap_8
XFILLER_142_1235 VDD VSS sg13g2_fill_1
XFILLER_166_423 VDD VSS sg13g2_decap_8
XFILLER_167_957 VDD VSS sg13g2_fill_1
XFILLER_178_283 VDD VSS sg13g2_decap_8
XFILLER_181_1295 VDD VSS sg13g2_decap_8
X_09257_ _13866_/D _13866_/Q _09622_/A0 _09263_/S VDD VSS sg13g2_mux2_1
X_14389__1813 _14389_/RESET_B VDD VSS sg13g2_tiehi
XFILLER_154_618 VDD VSS sg13g2_fill_1
X_08208_ _08209_/A _08452_/A _08207_/X _08301_/S VDD VSS sg13g2_mux2_1
XFILLER_166_478 VDD VSS sg13g2_decap_8
XFILLER_147_670 VDD VSS sg13g2_fill_1
X_09188_ _13804_/D _13804_/Q _10155_/A1 _09190_/S VDD VSS sg13g2_mux2_1
XFILLER_107_512 VDD VSS sg13g2_decap_8
XFILLER_175_25 VDD VSS sg13g2_decap_8
XFILLER_4_105 VDD VSS sg13g2_decap_8
XFILLER_107_523 VDD VSS sg13g2_fill_1
X_08139_ _08182_/B _08142_/C _08340_/A VDD VSS sg13g2_nor2_1
XFILLER_181_459 VDD VSS sg13g2_decap_8
XFILLER_104_4 VDD VSS sg13g2_decap_8
XFILLER_107_567 VDD VSS sg13g2_fill_1
XFILLER_135_876 VDD VSS sg13g2_fill_2
XFILLER_150_802 VDD VSS sg13g2_fill_2
X_11150_ _11150_/Y _11150_/A _11150_/B VDD VSS sg13g2_nand2_1
XFILLER_136_1006 VDD VSS sg13g2_fill_1
XFILLER_161_161 VDD VSS sg13g2_decap_4
XFILLER_1_812 VDD VSS sg13g2_decap_8
XFILLER_161_183 VDD VSS sg13g2_decap_8
X_10101_ _14681_/D _10101_/A0 _14681_/Q _10101_/S VDD VSS sg13g2_mux2_1
XFILLER_66_1361 VDD VSS sg13g2_decap_8
XFILLER_0_322 VDD VSS sg13g2_decap_8
XFILLER_150_868 VDD VSS sg13g2_decap_4
X_11081_ _11081_/Y _11139_/B1 _11077_/Y _11080_/Y VDD VSS sg13g2_a21oi_1
XFILLER_89_952 VDD VSS sg13g2_decap_4
XFILLER_27_1334 VDD VSS sg13g2_decap_8
XFILLER_118_1462 VDD VSS sg13g2_decap_8
XFILLER_89_974 VDD VSS sg13g2_decap_8
XFILLER_68_67 VDD VSS sg13g2_fill_1
XFILLER_89_985 VDD VSS sg13g2_fill_2
XFILLER_62_1236 VDD VSS sg13g2_decap_8
XFILLER_1_889 VDD VSS sg13g2_decap_8
X_10032_ _14614_/D _10098_/A0 _14614_/Q _10036_/S VDD VSS sg13g2_mux2_1
XFILLER_7_1428 VDD VSS sg13g2_decap_8
XFILLER_68_89 VDD VSS sg13g2_decap_8
XFILLER_103_795 VDD VSS sg13g2_decap_8
XFILLER_153_1386 VDD VSS sg13g2_decap_8
XFILLER_0_399 VDD VSS sg13g2_decap_8
XFILLER_114_1348 VDD VSS sg13g2_decap_8
XFILLER_48_337 VDD VSS sg13g2_fill_1
XFILLER_124_62 VDD VSS sg13g2_fill_1
X_14840_ _14840_/Q _14848_/CLK _14840_/D _14840_/RESET_B VDD VSS sg13g2_dfrbpq_1
XFILLER_75_145 VDD VSS sg13g2_decap_8
XFILLER_5_1141 VDD VSS sg13g2_decap_8
XFILLER_29_551 VDD VSS sg13g2_fill_1
XFILLER_124_95 VDD VSS sg13g2_fill_1
XFILLER_57_871 VDD VSS sg13g2_decap_8
X_13877__2325 _13877_/RESET_B VDD VSS sg13g2_tiehi
X_14771_ _14771_/Q clkload66/A _14771_/D _14771_/RESET_B VDD VSS sg13g2_dfrbpq_1
X_11983_ _12055_/C _11983_/A _13671_/Q VDD VSS sg13g2_xnor2_1
XFILLER_84_77 VDD VSS sg13g2_decap_8
XFILLER_186_1140 VDD VSS sg13g2_decap_8
XFILLER_56_381 VDD VSS sg13g2_decap_8
X_13722_ _16884_/A _15228_/CLK _13722_/D _13722_/RESET_B VDD VSS sg13g2_dfrbpq_1
XFILLER_72_841 VDD VSS sg13g2_decap_8
X_10934_ _10934_/Y _10946_/A _10934_/B _10948_/D VDD VSS sg13g2_nand3_1
XFILLER_140_50 VDD VSS sg13g2_decap_8
XFILLER_182_1026 VDD VSS sg13g2_decap_8
XFILLER_44_576 VDD VSS sg13g2_decap_8
X_13653_ _15119_/D _15189_/D _15119_/Q _13653_/S VDD VSS sg13g2_mux2_1
X_14781__2955 _14781_/RESET_B VDD VSS sg13g2_tiehi
X_10865_ _10865_/Y _10865_/A _10865_/B VDD VSS sg13g2_nand2_1
XFILLER_73_1332 VDD VSS sg13g2_decap_8
XFILLER_32_749 VDD VSS sg13g2_decap_8
XFILLER_125_1400 VDD VSS sg13g2_fill_2
XFILLER_158_902 VDD VSS sg13g2_decap_4
X_12604_ _12604_/X _14701_/Q _14733_/Q _13773_/Q _13805_/Q _12605_/S0 _12605_/S1 VDD
+ VSS sg13g2_mux4_1
XFILLER_185_710 VDD VSS sg13g2_decap_8
X_13584_ _13584_/Y _15160_/Q _13587_/B VDD VSS sg13g2_nor2_1
X_10796_ _10796_/Y _10796_/A _10800_/B VDD VSS sg13g2_nand2_1
XFILLER_34_1327 VDD VSS sg13g2_decap_8
X_15110__2762 _15110_/RESET_B VDD VSS sg13g2_tiehi
XFILLER_125_1455 VDD VSS sg13g2_decap_8
X_15214__3005 _15214_/RESET_B VDD VSS sg13g2_tiehi
XFILLER_160_1346 VDD VSS sg13g2_decap_8
X_12535_ _12535_/X _13832_/Q _13864_/Q _13896_/Q _13928_/Q _12536_/S0 _12536_/S1 VDD
+ VSS sg13g2_mux4_1
XFILLER_9_945 VDD VSS sg13g2_decap_8
XFILLER_121_1319 VDD VSS sg13g2_decap_8
XFILLER_173_905 VDD VSS sg13g2_fill_2
XFILLER_129_158 VDD VSS sg13g2_decap_8
XFILLER_129_169 VDD VSS sg13g2_fill_2
XFILLER_185_787 VDD VSS sg13g2_decap_8
XFILLER_8_466 VDD VSS sg13g2_decap_8
XFILLER_184_275 VDD VSS sg13g2_decap_8
X_12466_ _12466_/X _13955_/Q _13987_/Q _14019_/Q _14051_/Q _12466_/S0 _12466_/S1 VDD
+ VSS sg13g2_mux4_1
XFILLER_138_692 VDD VSS sg13g2_decap_8
X_14205_ _14205_/Q clkload32/A _14205_/D _14205_/RESET_B VDD VSS sg13g2_dfrbpq_1
X_11417_ _11419_/A _11418_/A _14175_/Q VDD VSS sg13g2_nand2b_1
XFILLER_172_459 VDD VSS sg13g2_decap_8
X_15185_ _15185_/Q _15185_/CLK _15185_/D _15185_/RESET_B VDD VSS sg13g2_dfrbpq_1
XFILLER_67_1103 VDD VSS sg13g2_decap_8
X_12397_ _12397_/X _12392_/X _12394_/X _12391_/X _12393_/X _12567_/S _12398_/S0 VDD
+ VSS sg13g2_mux4_1
XFILLER_67_1114 VDD VSS sg13g2_fill_2
XFILLER_125_342 VDD VSS sg13g2_decap_8
XFILLER_158_1242 VDD VSS sg13g2_decap_8
XFILLER_181_960 VDD VSS sg13g2_decap_8
XFILLER_99_705 VDD VSS sg13g2_decap_8
XFILLER_181_971 VDD VSS sg13g2_fill_1
XFILLER_67_1136 VDD VSS sg13g2_decap_8
XFILLER_141_813 VDD VSS sg13g2_fill_2
X_14136_ _14136_/Q _14514_/CLK _14136_/D _14136_/RESET_B VDD VSS sg13g2_dfrbpq_1
XFILLER_141_824 VDD VSS sg13g2_fill_2
X_11348_ _11348_/Y _11368_/S0 _14718_/Q _11366_/C VDD VSS sg13g2_a21oi_1
XFILLER_4_672 VDD VSS sg13g2_decap_8
XFILLER_113_526 VDD VSS sg13g2_decap_4
XFILLER_10_1393 VDD VSS sg13g2_decap_8
XFILLER_113_537 VDD VSS sg13g2_fill_1
XFILLER_140_323 VDD VSS sg13g2_decap_8
XFILLER_152_194 VDD VSS sg13g2_decap_8
XFILLER_171_1420 VDD VSS sg13g2_decap_8
X_14067_ _14067_/Q _15160_/CLK _14067_/D _14067_/RESET_B VDD VSS sg13g2_dfrbpq_1
X_11279_ _11279_/Y _11277_/S _14204_/Q _12184_/B VDD VSS sg13g2_a21oi_1
XFILLER_3_193 VDD VSS sg13g2_decap_8
XFILLER_45_1445 VDD VSS sg13g2_decap_8
XFILLER_132_1404 VDD VSS sg13g2_decap_8
X_13018_ _13018_/Y input25/X _12795_/Y _12937_/Y VDD VSS sg13g2_o21ai_1
XFILLER_67_624 VDD VSS sg13g2_decap_8
XFILLER_67_635 VDD VSS sg13g2_decap_8
XFILLER_66_112 VDD VSS sg13g2_decap_4
XFILLER_67_657 VDD VSS sg13g2_decap_8
XFILLER_95_977 VDD VSS sg13g2_decap_8
XFILLER_94_454 VDD VSS sg13g2_decap_8
XFILLER_55_808 VDD VSS sg13g2_fill_2
XFILLER_54_318 VDD VSS sg13g2_decap_8
X_14467__1735 _14467_/RESET_B VDD VSS sg13g2_tiehi
X_14969_ _14969_/Q clkload56/A _14969_/D _14969_/RESET_B VDD VSS sg13g2_dfrbpq_1
XFILLER_75_690 VDD VSS sg13g2_decap_8
XFILLER_169_1371 VDD VSS sg13g2_decap_8
XFILLER_78_1254 VDD VSS sg13g2_decap_8
XFILLER_63_852 VDD VSS sg13g2_decap_8
X_08490_ _08490_/Y _08489_/Y _08488_/Y _08539_/B1 VDD VSS sg13g2_a21oi_1
XFILLER_165_1224 VDD VSS sg13g2_decap_8
XFILLER_39_1238 VDD VSS sg13g2_decap_8
XFILLER_35_587 VDD VSS sg13g2_fill_1
XFILLER_90_693 VDD VSS sg13g2_decap_8
XFILLER_95_0 VDD VSS sg13g2_decap_8
XFILLER_50_557 VDD VSS sg13g2_decap_8
XFILLER_176_710 VDD VSS sg13g2_decap_8
XFILLER_13_18 VDD VSS sg13g2_decap_8
X_14682__1520 _14682_/RESET_B VDD VSS sg13g2_tiehi
XFILLER_31_760 VDD VSS sg13g2_decap_8
X_09111_ _09111_/Y _09151_/A _10757_/B _09110_/X VDD VSS sg13g2_o21ai_1
XFILLER_52_1438 VDD VSS sg13g2_decap_8
XFILLER_31_771 VDD VSS sg13g2_fill_2
XFILLER_164_916 VDD VSS sg13g2_fill_2
X_09042_ _09043_/B _14907_/Q _14906_/Q VDD VSS sg13g2_nand2_1
XFILLER_15_1271 VDD VSS sg13g2_decap_8
XFILLER_117_810 VDD VSS sg13g2_fill_2
XFILLER_175_286 VDD VSS sg13g2_decap_8
XFILLER_50_1162 VDD VSS sg13g2_decap_8
XFILLER_135_128 VDD VSS sg13g2_decap_8
XFILLER_11_1135 VDD VSS sg13g2_decap_8
Xclkbuf_leaf_108_clk_i clkload55/A clkbuf_leaf_18_clk_i/A VDD VSS sg13g2_buf_8
XFILLER_176_1331 VDD VSS sg13g2_decap_8
XFILLER_89_1383 VDD VSS sg13g2_decap_8
XFILLER_85_1225 VDD VSS sg13g2_decap_8
XFILLER_2_609 VDD VSS sg13g2_decap_8
XFILLER_102_1296 VDD VSS sg13g2_decap_8
XFILLER_116_364 VDD VSS sg13g2_decap_8
XFILLER_144_673 VDD VSS sg13g2_decap_8
X_13955__2247 _13955_/RESET_B VDD VSS sg13g2_tiehi
XFILLER_117_898 VDD VSS sg13g2_decap_8
XFILLER_1_119 VDD VSS sg13g2_decap_8
XFILLER_137_1337 VDD VSS sg13g2_decap_8
XFILLER_172_1228 VDD VSS sg13g2_decap_8
Xfanout902 _12675_/S0 _12716_/S0 VDD VSS sg13g2_buf_1
X_09944_ _14528_/D _14528_/Q _10010_/A0 _09957_/S VDD VSS sg13g2_mux2_1
Xfanout913 _12352_/S0 _12786_/S0 VDD VSS sg13g2_buf_1
XFILLER_131_356 VDD VSS sg13g2_decap_8
Xfanout924 _11243_/C _15208_/Q VDD VSS sg13g2_buf_1
Xfanout935 _12779_/A2 _15206_/Q VDD VSS sg13g2_buf_1
Xfanout946 _13566_/C _13552_/C VDD VSS sg13g2_buf_1
Xfanout957 _13401_/B _13389_/B VDD VSS sg13g2_buf_1
X_09875_ _14461_/D _09875_/A0 _14461_/Q _09898_/S VDD VSS sg13g2_mux2_1
Xfanout968 _07728_/C _13028_/B VDD VSS sg13g2_buf_1
XFILLER_112_581 VDD VSS sg13g2_decap_8
XFILLER_85_421 VDD VSS sg13g2_decap_4
XFILLER_135_1083 VDD VSS sg13g2_decap_8
Xfanout979 _13029_/A2 _13051_/B VDD VSS sg13g2_buf_1
X_08826_ _08826_/Y _12836_/B _13482_/B VDD VSS sg13g2_nor2_1
XFILLER_57_134 VDD VSS sg13g2_fill_1
XFILLER_161_49 VDD VSS sg13g2_decap_8
XFILLER_100_776 VDD VSS sg13g2_decap_8
XFILLER_113_1370 VDD VSS sg13g2_decap_8
X_08757_ _08757_/Y _13343_/B _11288_/A _15191_/Q VDD VSS sg13g2_o21ai_1
XFILLER_96_1310 VDD VSS sg13g2_decap_4
XFILLER_72_104 VDD VSS sg13g2_decap_8
XFILLER_45_329 VDD VSS sg13g2_decap_8
XFILLER_113_1381 VDD VSS sg13g2_fill_2
XFILLER_173_7 VDD VSS sg13g2_decap_8
XFILLER_85_498 VDD VSS sg13g2_decap_8
XFILLER_73_649 VDD VSS sg13g2_decap_4
XFILLER_22_1286 VDD VSS sg13g2_decap_8
X_07708_ _07708_/Y _07708_/A _07708_/B _07708_/C VDD VSS sg13g2_nor3_1
XFILLER_96_1343 VDD VSS sg13g2_decap_8
XFILLER_54_25 VDD VSS sg13g2_fill_2
XFILLER_2_1358 VDD VSS sg13g2_decap_8
XFILLER_183_1302 VDD VSS sg13g2_decap_8
X_08688_ _08693_/A _08688_/A _08688_/B _08688_/C _08688_/D VDD VSS sg13g2_nand4_1
XFILLER_96_1387 VDD VSS sg13g2_fill_1
XFILLER_57_1338 VDD VSS sg13g2_decap_8
X_14909__2749 _14909_/RESET_B VDD VSS sg13g2_tiehi
XFILLER_53_362 VDD VSS sg13g2_fill_2
X_07639_ _10237_/B _14774_/Q VDD VSS sg13g2_inv_1
XFILLER_81_682 VDD VSS sg13g2_decap_8
XFILLER_80_170 VDD VSS sg13g2_decap_8
XFILLER_0_1093 VDD VSS sg13g2_decap_8
XFILLER_183_1379 VDD VSS sg13g2_decap_8
XFILLER_186_518 VDD VSS sg13g2_decap_8
X_10650_ _10652_/C _14890_/Q _14889_/Q _14888_/Q _14887_/Q VDD VSS sg13g2_nand4_1
XFILLER_110_64 VDD VSS sg13g2_decap_8
XFILLER_142_1010 VDD VSS sg13g2_decap_8
XFILLER_55_1062 VDD VSS sg13g2_decap_4
X_09309_ _13916_/D _09742_/A1 _13916_/Q _09339_/S VDD VSS sg13g2_mux2_1
XFILLER_181_1092 VDD VSS sg13g2_decap_8
XFILLER_70_46 VDD VSS sg13g2_decap_8
X_10581_ _10581_/Y _14872_/Q _10580_/A _10499_/C VDD VSS sg13g2_o21ai_1
XFILLER_16_1057 VDD VSS sg13g2_decap_8
XFILLER_103_1016 VDD VSS sg13g2_decap_8
XFILLER_186_35 VDD VSS sg13g2_decap_8
X_12320_ _12320_/Y _12330_/S0 _14490_/Q VDD VSS sg13g2_nand2b_1
XFILLER_10_966 VDD VSS sg13g2_decap_8
XFILLER_167_787 VDD VSS sg13g2_decap_8
XFILLER_177_1128 VDD VSS sg13g2_decap_8
XFILLER_182_757 VDD VSS sg13g2_decap_8
X_12251_ _12251_/Y _12247_/Y _12248_/Y _12250_/Y _12249_/Y _12253_/B VDD VSS sg13g2_a221oi_1
XFILLER_68_1412 VDD VSS sg13g2_decap_8
XFILLER_181_245 VDD VSS sg13g2_decap_8
XFILLER_79_11 VDD VSS sg13g2_fill_2
XFILLER_107_353 VDD VSS sg13g2_decap_8
X_11202_ _11202_/Y _11202_/A _11205_/A VDD VSS sg13g2_xnor2_1
XFILLER_5_469 VDD VSS sg13g2_decap_8
XFILLER_107_364 VDD VSS sg13g2_fill_2
XFILLER_150_610 VDD VSS sg13g2_decap_8
X_12182_ _12182_/Y _12179_/Y _12181_/X _11231_/S VDD VSS sg13g2_o21ai_1
XFILLER_123_835 VDD VSS sg13g2_decap_4
X_14545__1657 _14545_/RESET_B VDD VSS sg13g2_tiehi
XFILLER_64_1309 VDD VSS sg13g2_decap_8
XFILLER_29_1429 VDD VSS sg13g2_decap_8
XFILLER_122_334 VDD VSS sg13g2_decap_8
X_11133_ _11133_/Y _11133_/A _11133_/B VDD VSS sg13g2_nand2_1
XFILLER_155_1459 VDD VSS sg13g2_decap_8
Xclkbuf_leaf_72_clk_i clkload83/A clkbuf_leaf_75_clk_i/A VDD VSS sg13g2_buf_8
XFILLER_27_1131 VDD VSS sg13g2_decap_8
XFILLER_77_911 VDD VSS sg13g2_decap_8
XFILLER_122_389 VDD VSS sg13g2_decap_8
XFILLER_153_1150 VDD VSS sg13g2_decap_8
X_14799__2937 _14799_/RESET_B VDD VSS sg13g2_tiehi
X_11064_ _11119_/A _11064_/A _11064_/B _11064_/C _11064_/D VDD VSS sg13g2_nand4_1
XFILLER_95_21 VDD VSS sg13g2_decap_8
XFILLER_7_1225 VDD VSS sg13g2_decap_8
XFILLER_1_686 VDD VSS sg13g2_decap_8
XFILLER_95_32 VDD VSS sg13g2_fill_1
XFILLER_49_624 VDD VSS sg13g2_decap_4
XFILLER_118_1292 VDD VSS sg13g2_decap_8
Xhold3080 input12/A mem_axi_rdata[17] VDD VSS sg13g2_dlygate4sd3_1
XFILLER_49_646 VDD VSS sg13g2_decap_8
Xhold3091 hold3091/X input17/X VDD VSS sg13g2_dlygate4sd3_1
X_10015_ _14597_/D _10081_/A0 _14597_/Q _10023_/S VDD VSS sg13g2_mux2_1
XFILLER_76_432 VDD VSS sg13g2_decap_8
XFILLER_0_196 VDD VSS sg13g2_decap_8
XFILLER_95_87 VDD VSS sg13g2_decap_8
XFILLER_64_605 VDD VSS sg13g2_decap_8
Xclkbuf_leaf_87_clk_i clkload60/A clkbuf_leaf_96_clk_i/A VDD VSS sg13g2_buf_8
X_14823_ _14823_/Q _14893_/CLK _14823_/D _14823_/RESET_B VDD VSS sg13g2_dfrbpq_1
XFILLER_151_60 VDD VSS sg13g2_decap_8
XFILLER_63_137 VDD VSS sg13g2_decap_4
XFILLER_40_1375 VDD VSS sg13g2_decap_8
X_14754_ _14754_/Q clkload64/A _14754_/D _14754_/RESET_B VDD VSS sg13g2_dfrbpq_1
X_11966_ _11966_/X _13840_/Q _13872_/Q _11969_/A VDD VSS sg13g2_mux2_1
XFILLER_75_1405 VDD VSS sg13g2_decap_8
XFILLER_45_874 VDD VSS sg13g2_decap_8
XFILLER_72_660 VDD VSS sg13g2_decap_8
XFILLER_60_811 VDD VSS sg13g2_decap_8
X_13705_ _16867_/A _14602_/CLK _13705_/D _13705_/RESET_B VDD VSS sg13g2_dfrbpq_1
X_10917_ _10948_/C _15119_/Q _10954_/A VDD VSS sg13g2_xor2_1
X_14685_ _14685_/Q clkload30/A _14685_/D _14685_/RESET_B VDD VSS sg13g2_dfrbpq_1
Xclkbuf_leaf_10_clk_i clkload28/A clkbuf_leaf_9_clk_i/A VDD VSS sg13g2_buf_8
X_11897_ _11898_/B _11897_/A _11897_/B _11897_/C VDD VSS sg13g2_nand3_1
X_13636_ _13744_/D _13636_/A VDD VSS sg13g2_buf_1
XFILLER_177_529 VDD VSS sg13g2_decap_8
X_10848_ _10849_/B _10797_/C _10851_/C _10847_/Y VDD VSS sg13g2_o21ai_1
XFILLER_20_719 VDD VSS sg13g2_decap_8
XFILLER_13_771 VDD VSS sg13g2_decap_8
XFILLER_38_1293 VDD VSS sg13g2_decap_8
XFILLER_34_1124 VDD VSS sg13g2_decap_8
XFILLER_160_1143 VDD VSS sg13g2_decap_8
X_13567_ _13567_/Y _08203_/B _13567_/A2 _13566_/Y VDD VSS sg13g2_a21oi_1
X_10779_ _10779_/Y _14921_/Q _11133_/B VDD VSS sg13g2_nand2_1
XFILLER_9_742 VDD VSS sg13g2_decap_8
XFILLER_118_607 VDD VSS sg13g2_decap_8
Xclkbuf_leaf_25_clk_i clkload34/A clkbuf_leaf_28_clk_i/A VDD VSS sg13g2_buf_8
X_12518_ _12518_/X _14247_/Q _14279_/Q _14311_/Q _14343_/Q _12576_/S0 _12576_/S1 VDD
+ VSS sg13g2_mux4_1
XFILLER_117_106 VDD VSS sg13g2_decap_8
XFILLER_12_1411 VDD VSS sg13g2_decap_8
XFILLER_157_275 VDD VSS sg13g2_decap_4
X_13498_ _15127_/D _13498_/A VDD VSS sg13g2_inv_1
XFILLER_8_263 VDD VSS sg13g2_decap_8
XFILLER_139_990 VDD VSS sg13g2_decap_8
XFILLER_185_595 VDD VSS sg13g2_decap_8
XFILLER_67_4 VDD VSS sg13g2_decap_8
X_15237_ _15237_/Q clkload69/A _15237_/D _15237_/RESET_B VDD VSS sg13g2_dfrbpq_1
X_12449_ _12449_/X _14114_/Q _14146_/Q _14178_/Q _14210_/Q _12520_/S0 _12520_/S1 VDD
+ VSS sg13g2_mux4_1
XFILLER_161_919 VDD VSS sg13g2_decap_4
XFILLER_126_673 VDD VSS sg13g2_fill_1
XFILLER_172_289 VDD VSS sg13g2_decap_8
X_15168_ _16854_/A clkload65/A _15168_/D _15168_/RESET_B VDD VSS sg13g2_dfrbpq_1
XFILLER_125_161 VDD VSS sg13g2_decap_8
XFILLER_113_312 VDD VSS sg13g2_fill_2
X_15174__2902 _15174_/RESET_B VDD VSS sg13g2_tiehi
XFILLER_5_63 VDD VSS sg13g2_decap_8
XFILLER_10_1190 VDD VSS sg13g2_decap_8
X_14119_ _14119_/Q _14727_/CLK _14119_/D _14119_/RESET_B VDD VSS sg13g2_dfrbpq_1
XFILLER_113_345 VDD VSS sg13g2_decap_8
XFILLER_141_654 VDD VSS sg13g2_decap_4
X_15099_ _15099_/Q clkload72/A _15099_/D _15099_/RESET_B VDD VSS sg13g2_dfrbpq_1
Xfanout209 _09891_/A0 _10156_/A1 VDD VSS sg13g2_buf_1
X_07990_ _07991_/A _08832_/D _13324_/A _11664_/A _11241_/A VDD VSS sg13g2_or4_1
XFILLER_99_579 VDD VSS sg13g2_fill_1
XFILLER_140_153 VDD VSS sg13g2_decap_4
XFILLER_45_1242 VDD VSS sg13g2_decap_8
XFILLER_113_389 VDD VSS sg13g2_decap_8
XFILLER_68_922 VDD VSS sg13g2_fill_1
XFILLER_80_1144 VDD VSS sg13g2_fill_1
XFILLER_68_955 VDD VSS sg13g2_decap_8
XFILLER_39_112 VDD VSS sg13g2_decap_8
XFILLER_41_1117 VDD VSS sg13g2_decap_4
X_09660_ _14253_/D _09726_/A0 _14253_/Q _09663_/S VDD VSS sg13g2_mux2_1
XFILLER_171_1294 VDD VSS sg13g2_decap_8
XFILLER_83_903 VDD VSS sg13g2_decap_8
XFILLER_10_0 VDD VSS sg13g2_decap_8
X_08611_ _08611_/Y _07864_/Y _07960_/Y _07964_/Y VDD VSS sg13g2_o21ai_1
XFILLER_82_402 VDD VSS sg13g2_decap_8
XFILLER_27_307 VDD VSS sg13g2_decap_8
XFILLER_39_178 VDD VSS sg13g2_fill_1
X_09591_ _14188_/D _14188_/Q _10088_/A0 _09593_/S VDD VSS sg13g2_mux2_1
XFILLER_83_958 VDD VSS sg13g2_decap_8
XFILLER_83_969 VDD VSS sg13g2_fill_2
XFILLER_82_435 VDD VSS sg13g2_decap_4
X_15053__2542 _15053_/RESET_B VDD VSS sg13g2_tiehi
X_08542_ _08542_/Y _07808_/Y _08001_/C _08541_/Y VDD VSS sg13g2_o21ai_1
XFILLER_70_608 VDD VSS sg13g2_decap_8
XFILLER_51_800 VDD VSS sg13g2_decap_8
XFILLER_23_513 VDD VSS sg13g2_decap_8
XFILLER_78_1084 VDD VSS sg13g2_decap_8
XFILLER_165_1043 VDD VSS sg13g2_fill_2
X_08473_ _08473_/Y _08472_/X _08001_/C _08494_/A VDD VSS sg13g2_a21oi_1
XFILLER_63_693 VDD VSS sg13g2_fill_1
XFILLER_126_1005 VDD VSS sg13g2_decap_8
XFILLER_165_1054 VDD VSS sg13g2_fill_2
XFILLER_24_28 VDD VSS sg13g2_decap_8
XFILLER_62_192 VDD VSS sg13g2_decap_8
XFILLER_51_855 VDD VSS sg13g2_decap_8
XFILLER_39_1068 VDD VSS sg13g2_decap_8
XFILLER_56_1360 VDD VSS sg13g2_decap_8
XFILLER_149_710 VDD VSS sg13g2_decap_8
XFILLER_17_1322 VDD VSS sg13g2_decap_8
X_14623__1579 _14623_/RESET_B VDD VSS sg13g2_tiehi
XFILLER_50_354 VDD VSS sg13g2_decap_4
XFILLER_50_365 VDD VSS sg13g2_decap_8
XFILLER_182_1390 VDD VSS sg13g2_decap_8
XFILLER_148_220 VDD VSS sg13g2_decap_8
XFILLER_52_1235 VDD VSS sg13g2_decap_8
XFILLER_13_1208 VDD VSS sg13g2_decap_8
XFILLER_164_713 VDD VSS sg13g2_decap_4
XFILLER_178_1404 VDD VSS sg13g2_decap_8
XFILLER_17_1399 VDD VSS sg13g2_decap_8
XFILLER_148_275 VDD VSS sg13g2_decap_8
XFILLER_136_437 VDD VSS sg13g2_fill_1
X_09025_ _09025_/X _09031_/A _09021_/X _09024_/X VDD VSS sg13g2_a21o_1
XFILLER_156_49 VDD VSS sg13g2_decap_8
XFILLER_3_907 VDD VSS sg13g2_decap_8
XFILLER_2_406 VDD VSS sg13g2_decap_8
XFILLER_104_301 VDD VSS sg13g2_decap_8
XFILLER_144_481 VDD VSS sg13g2_decap_8
XFILLER_132_632 VDD VSS sg13g2_decap_8
XFILLER_137_1123 VDD VSS sg13g2_decap_4
XFILLER_116_183 VDD VSS sg13g2_fill_2
XFILLER_85_1066 VDD VSS sg13g2_decap_8
XFILLER_49_14 VDD VSS sg13g2_decap_8
XFILLER_131_120 VDD VSS sg13g2_decap_8
XFILLER_172_1025 VDD VSS sg13g2_decap_8
Xclkbuf_4_8_0_clk_i clkbuf_4_8_0_clk_i/X clkbuf_0_clk_i/X VDD VSS sg13g2_buf_8
XFILLER_104_356 VDD VSS sg13g2_decap_8
XFILLER_160_985 VDD VSS sg13g2_decap_8
Xfanout710 _11973_/B fanout725/X VDD VSS sg13g2_buf_1
XFILLER_59_900 VDD VSS sg13g2_decap_4
Xfanout721 _11422_/B _11829_/A1 VDD VSS sg13g2_buf_1
Xfanout732 _11266_/B _12258_/C1 VDD VSS sg13g2_buf_1
XFILLER_28_1462 VDD VSS sg13g2_decap_8
X_09927_ _14512_/D _14512_/Q _09960_/A1 _09927_/S VDD VSS sg13g2_mux2_1
Xfanout743 _12304_/B _12112_/B1 VDD VSS sg13g2_buf_1
XFILLER_28_1473 VDD VSS sg13g2_fill_2
XFILLER_113_890 VDD VSS sg13g2_decap_4
Xfanout754 _11014_/A _11043_/A VDD VSS sg13g2_buf_1
XFILLER_58_421 VDD VSS sg13g2_decap_8
Xfanout765 _08452_/D _08056_/B VDD VSS sg13g2_buf_1
XFILLER_59_955 VDD VSS sg13g2_decap_8
XFILLER_24_1326 VDD VSS sg13g2_decap_8
XFILLER_115_1454 VDD VSS sg13g2_decap_8
Xfanout776 _13553_/A1 _07627_/Y VDD VSS sg13g2_buf_1
XFILLER_63_1386 VDD VSS sg13g2_decap_8
XFILLER_100_540 VDD VSS sg13g2_fill_2
X_15213__3004 _15213_/RESET_B VDD VSS sg13g2_tiehi
Xfanout787 _11109_/B _07751_/B VDD VSS sg13g2_buf_1
X_09858_ _14445_/D _14445_/Q _10023_/A0 _09858_/S VDD VSS sg13g2_mux2_1
Xfanout798 _12664_/S _12355_/S VDD VSS sg13g2_buf_1
XFILLER_86_774 VDD VSS sg13g2_fill_2
XFILLER_65_13 VDD VSS sg13g2_fill_1
X_15081__2854 _15081_/RESET_B VDD VSS sg13g2_tiehi
XFILLER_86_796 VDD VSS sg13g2_fill_2
X_08809_ _08811_/A _10843_/C _14751_/Q _08727_/X _15194_/Q _13392_/A2 VDD VSS sg13g2_a221oi_1
XFILLER_58_498 VDD VSS sg13g2_decap_4
XFILLER_100_595 VDD VSS sg13g2_decap_8
XFILLER_105_97 VDD VSS sg13g2_decap_8
XFILLER_22_1050 VDD VSS sg13g2_decap_8
X_09789_ _14378_/D _09921_/A1 _14378_/Q _09789_/S VDD VSS sg13g2_mux2_1
XFILLER_73_424 VDD VSS sg13g2_decap_8
X_11820_ _11820_/Y _11816_/Y _11817_/Y _11819_/Y _11818_/Y _11822_/B VDD VSS sg13g2_a221oi_1
XFILLER_22_1083 VDD VSS sg13g2_decap_8
XFILLER_2_1155 VDD VSS sg13g2_decap_8
X_15096__2810 _15096_/RESET_B VDD VSS sg13g2_tiehi
XFILLER_54_660 VDD VSS sg13g2_fill_2
XFILLER_121_52 VDD VSS sg13g2_decap_8
XFILLER_92_1004 VDD VSS sg13g2_decap_8
XFILLER_82_980 VDD VSS sg13g2_decap_8
X_15167__2528 _15167_/RESET_B VDD VSS sg13g2_tiehi
X_11751_ _11751_/Y _11741_/A _14506_/Q _12088_/B VDD VSS sg13g2_a21oi_1
XFILLER_57_1135 VDD VSS sg13g2_decap_8
XFILLER_60_129 VDD VSS sg13g2_decap_8
XFILLER_18_1119 VDD VSS sg13g2_decap_8
X_10702_ _10702_/Y _10702_/A _10973_/B VDD VSS sg13g2_nand2_1
XFILLER_42_866 VDD VSS sg13g2_decap_4
XFILLER_183_1176 VDD VSS sg13g2_decap_8
X_14470_ _14470_/Q _14655_/CLK _14470_/D _14470_/RESET_B VDD VSS sg13g2_dfrbpq_1
XFILLER_92_1059 VDD VSS sg13g2_fill_2
XFILLER_186_315 VDD VSS sg13g2_decap_8
X_11682_ _11682_/Y _11692_/A _14408_/Q _11693_/C VDD VSS sg13g2_a21oi_1
XFILLER_81_56 VDD VSS sg13g2_decap_8
XFILLER_41_354 VDD VSS sg13g2_decap_8
XFILLER_74_1471 VDD VSS sg13g2_decap_4
XFILLER_35_1422 VDD VSS sg13g2_decap_8
X_13421_ _13421_/Y _13459_/B _13421_/B _13459_/C VDD VSS sg13g2_nand3b_1
X_10633_ _14885_/D _10655_/B _10633_/B _10633_/C VDD VSS sg13g2_nor3_1
XFILLER_122_1403 VDD VSS sg13g2_decap_8
XFILLER_139_242 VDD VSS sg13g2_decap_8
XFILLER_70_1357 VDD VSS sg13g2_decap_8
XFILLER_122_1436 VDD VSS sg13g2_decap_4
XFILLER_127_404 VDD VSS sg13g2_decap_8
X_13352_ _15071_/D _15071_/Q _13655_/S _13351_/Y VDD VSS sg13g2_a21o_1
XFILLER_10_763 VDD VSS sg13g2_decap_8
XFILLER_139_275 VDD VSS sg13g2_decap_8
X_10564_ _10565_/D _14860_/Q _14859_/Q _13218_/A _10564_/D VDD VSS sg13g2_nand4_1
X_12303_ _12303_/X _14138_/Q _14170_/Q _12306_/A VDD VSS sg13g2_mux2_1
X_13283_ _13291_/A _13283_/A _13287_/A VDD VSS sg13g2_nand2_1
XFILLER_154_256 VDD VSS sg13g2_fill_1
XFILLER_170_705 VDD VSS sg13g2_decap_8
X_10495_ _10497_/B _14852_/Q _10513_/D _14850_/Q _10495_/D VDD VSS sg13g2_nand4_1
XFILLER_6_767 VDD VSS sg13g2_decap_8
XFILLER_154_267 VDD VSS sg13g2_decap_8
X_15022_ _15022_/Q _15185_/CLK _15022_/D _15022_/RESET_B VDD VSS sg13g2_dfrbpq_1
X_12234_ _12236_/A _12235_/A _14200_/Q VDD VSS sg13g2_nand2b_1
XFILLER_5_266 VDD VSS sg13g2_decap_8
XFILLER_142_429 VDD VSS sg13g2_fill_1
XFILLER_170_738 VDD VSS sg13g2_fill_1
XFILLER_155_1201 VDD VSS sg13g2_decap_8
XFILLER_159_1381 VDD VSS sg13g2_decap_8
XFILLER_151_941 VDD VSS sg13g2_fill_1
XFILLER_30_93 VDD VSS sg13g2_fill_1
XFILLER_29_1226 VDD VSS sg13g2_decap_8
XFILLER_68_1286 VDD VSS sg13g2_decap_8
XFILLER_146_82 VDD VSS sg13g2_fill_2
XFILLER_151_963 VDD VSS sg13g2_decap_8
X_12165_ _12165_/X _14582_/Q _14614_/Q _12168_/A VDD VSS sg13g2_mux2_1
XFILLER_2_973 VDD VSS sg13g2_decap_8
X_11116_ _11190_/C _11138_/B _11138_/C VDD VSS sg13g2_nand2_1
XFILLER_110_326 VDD VSS sg13g2_fill_1
X_12096_ _12096_/Y _12100_/S0 _14612_/Q _12100_/S1 VDD VSS sg13g2_a21oi_1
XFILLER_1_483 VDD VSS sg13g2_decap_8
XFILLER_96_549 VDD VSS sg13g2_fill_1
XFILLER_7_1022 VDD VSS sg13g2_decap_8
XFILLER_42_1415 VDD VSS sg13g2_decap_8
XFILLER_81_1475 VDD VSS sg13g2_decap_4
X_11047_ _14944_/D _07616_/Y _10671_/Y _11046_/Y VDD VSS sg13g2_o21ai_1
XFILLER_162_81 VDD VSS sg13g2_decap_8
Xinput9 input9/X input9/A VDD VSS sg13g2_buf_1
XFILLER_65_936 VDD VSS sg13g2_decap_8
XFILLER_7_1099 VDD VSS sg13g2_decap_8
XFILLER_76_273 VDD VSS sg13g2_decap_8
XFILLER_92_755 VDD VSS sg13g2_fill_1
XFILLER_149_1016 VDD VSS sg13g2_decap_8
XFILLER_40_1172 VDD VSS sg13g2_decap_8
X_14806_ _14806_/Q _15185_/CLK _14806_/D _14806_/RESET_B VDD VSS sg13g2_dfrbpq_1
XFILLER_91_254 VDD VSS sg13g2_decap_8
XFILLER_79_1360 VDD VSS sg13g2_decap_8
XFILLER_36_159 VDD VSS sg13g2_decap_8
XFILLER_75_1202 VDD VSS sg13g2_decap_8
XFILLER_64_479 VDD VSS sg13g2_decap_8
X_12998_ _12998_/Y input24/X _12997_/Y _12937_/Y VDD VSS sg13g2_o21ai_1
XFILLER_92_799 VDD VSS sg13g2_fill_1
XFILLER_18_896 VDD VSS sg13g2_decap_8
XFILLER_73_991 VDD VSS sg13g2_decap_8
XFILLER_45_682 VDD VSS sg13g2_decap_8
X_14737_ _14737_/Q _15139_/CLK _14737_/D _14737_/RESET_B VDD VSS sg13g2_dfrbpq_1
XFILLER_45_693 VDD VSS sg13g2_fill_1
X_11949_ _11953_/A _11948_/X _11967_/B VDD VSS sg13g2_nand2b_1
XFILLER_166_1374 VDD VSS sg13g2_decap_8
XFILLER_36_1208 VDD VSS sg13g2_decap_8
XFILLER_162_1227 VDD VSS sg13g2_decap_8
XFILLER_75_1279 VDD VSS sg13g2_decap_8
X_14668_ _14668_/Q _14668_/CLK _14668_/D _14668_/RESET_B VDD VSS sg13g2_dfrbpq_1
XFILLER_20_527 VDD VSS sg13g2_fill_1
X_13619_ _13727_/D _13619_/A VDD VSS sg13g2_buf_1
X_14599_ _14599_/Q _14727_/CLK _14599_/D _14599_/RESET_B VDD VSS sg13g2_dfrbpq_1
XFILLER_146_702 VDD VSS sg13g2_fill_1
XFILLER_186_882 VDD VSS sg13g2_decap_8
XFILLER_145_201 VDD VSS sg13g2_fill_1
XFILLER_185_392 VDD VSS sg13g2_decap_8
X_14873__2821 _14873_/RESET_B VDD VSS sg13g2_tiehi
XFILLER_103_1391 VDD VSS sg13g2_decap_8
XFILLER_58_0 VDD VSS sg13g2_decap_8
XFILLER_12_1285 VDD VSS sg13g2_decap_8
XFILLER_86_1342 VDD VSS sg13g2_decap_8
XFILLER_126_470 VDD VSS sg13g2_fill_1
XFILLER_161_749 VDD VSS sg13g2_fill_2
XFILLER_99_310 VDD VSS sg13g2_decap_8
XFILLER_138_1421 VDD VSS sg13g2_fill_2
XFILLER_126_492 VDD VSS sg13g2_decap_4
XFILLER_142_952 VDD VSS sg13g2_fill_2
XFILLER_173_1323 VDD VSS sg13g2_decap_8
XFILLER_47_1326 VDD VSS sg13g2_decap_8
XFILLER_160_259 VDD VSS sg13g2_decap_8
XFILLER_114_654 VDD VSS sg13g2_decap_8
X_14037__2165 _14037_/RESET_B VDD VSS sg13g2_tiehi
X_13872__2330 _13872_/RESET_B VDD VSS sg13g2_tiehi
XFILLER_82_1239 VDD VSS sg13g2_decap_8
XFILLER_142_996 VDD VSS sg13g2_decap_8
XFILLER_99_376 VDD VSS sg13g2_decap_8
XFILLER_99_387 VDD VSS sg13g2_fill_2
X_07973_ _07974_/C _08663_/A _08678_/A _07971_/Y VDD VSS sg13g2_o21ai_1
XFILLER_19_28 VDD VSS sg13g2_decap_8
X_09712_ _14303_/D _09910_/A1 _14303_/Q _09725_/S VDD VSS sg13g2_mux2_1
XFILLER_132_1042 VDD VSS sg13g2_decap_4
XFILLER_132_1064 VDD VSS sg13g2_decap_8
X_09643_ _14236_/D _09907_/A1 _14236_/Q _09673_/S VDD VSS sg13g2_mux2_1
XFILLER_95_582 VDD VSS sg13g2_fill_1
XFILLER_132_1075 VDD VSS sg13g2_fill_1
XFILLER_67_284 VDD VSS sg13g2_decap_8
XFILLER_82_210 VDD VSS sg13g2_decap_8
XFILLER_23_1381 VDD VSS sg13g2_decap_8
XFILLER_3_1453 VDD VSS sg13g2_decap_8
X_09574_ _14171_/D _14171_/Q _10071_/A0 _09605_/S VDD VSS sg13g2_mux2_1
XFILLER_97_1460 VDD VSS sg13g2_fill_1
XFILLER_82_254 VDD VSS sg13g2_decap_8
XFILLER_55_479 VDD VSS sg13g2_decap_8
XFILLER_93_1302 VDD VSS sg13g2_decap_8
XFILLER_71_939 VDD VSS sg13g2_decap_8
XFILLER_70_405 VDD VSS sg13g2_decap_8
X_08525_ _08526_/A _08209_/X _08544_/B _08521_/X _08036_/B _08524_/Y VDD VSS sg13g2_a221oi_1
XFILLER_70_449 VDD VSS sg13g2_fill_1
XFILLER_58_1455 VDD VSS sg13g2_decap_8
XFILLER_24_844 VDD VSS sg13g2_decap_8
XFILLER_145_1425 VDD VSS sg13g2_decap_8
X_08456_ _08461_/C _08692_/A _11843_/A _08456_/C VDD VSS sg13g2_nand3_1
XFILLER_143_8 VDD VSS sg13g2_fill_2
XFILLER_145_1469 VDD VSS sg13g2_fill_1
XFILLER_24_899 VDD VSS sg13g2_decap_4
XFILLER_184_819 VDD VSS sg13g2_decap_8
X_08387_ _08387_/Y _08541_/A _08382_/X _08380_/Y _08036_/B _08386_/Y VDD VSS sg13g2_a221oi_1
XFILLER_50_195 VDD VSS sg13g2_decap_8
XFILLER_149_562 VDD VSS sg13g2_decap_8
XFILLER_109_404 VDD VSS sg13g2_fill_1
XFILLER_13_1005 VDD VSS sg13g2_decap_8
XFILLER_52_1054 VDD VSS sg13g2_fill_1
XFILLER_137_724 VDD VSS sg13g2_decap_8
XFILLER_143_1193 VDD VSS sg13g2_decap_8
XFILLER_17_1196 VDD VSS sg13g2_decap_8
XFILLER_176_381 VDD VSS sg13g2_fill_1
XFILLER_178_1201 VDD VSS sg13g2_decap_8
X_14247__1955 _14247_/RESET_B VDD VSS sg13g2_tiehi
XFILLER_104_1177 VDD VSS sg13g2_fill_2
XFILLER_109_459 VDD VSS sg13g2_decap_4
XFILLER_125_908 VDD VSS sg13g2_decap_8
XFILLER_124_407 VDD VSS sg13g2_decap_8
XFILLER_3_704 VDD VSS sg13g2_decap_8
XFILLER_30_1363 VDD VSS sg13g2_decap_8
XFILLER_139_1218 VDD VSS sg13g2_fill_2
X_09008_ _13762_/D _13762_/Q _10045_/A0 _09077_/S VDD VSS sg13g2_mux2_1
XFILLER_178_1278 VDD VSS sg13g2_decap_8
XFILLER_164_598 VDD VSS sg13g2_decap_8
X_10280_ _10282_/A _14788_/Q _10311_/A _10365_/C VDD VSS sg13g2_o21ai_1
XFILLER_2_203 VDD VSS sg13g2_decap_8
XFILLER_117_481 VDD VSS sg13g2_decap_4
XFILLER_183_25 VDD VSS sg13g2_decap_8
X_13702__2500 _13702_/RESET_B VDD VSS sg13g2_tiehi
XFILLER_65_1459 VDD VSS sg13g2_decap_8
XFILLER_105_687 VDD VSS sg13g2_fill_1
X_14462__1740 _14462_/RESET_B VDD VSS sg13g2_tiehi
XFILLER_8_1320 VDD VSS sg13g2_decap_8
XFILLER_132_495 VDD VSS sg13g2_fill_2
Xfanout540 _09907_/A1 _10105_/A VDD VSS sg13g2_buf_1
Xfanout551 _09090_/A _09024_/A VDD VSS sg13g2_buf_1
XFILLER_59_741 VDD VSS sg13g2_decap_8
XFILLER_115_1240 VDD VSS sg13g2_decap_8
XFILLER_120_668 VDD VSS sg13g2_decap_8
Xfanout562 _13507_/B _13388_/B VDD VSS sg13g2_buf_1
XFILLER_115_1251 VDD VSS sg13g2_fill_1
X_13970_ _13970_/Q clkload40/A _13970_/D _13970_/RESET_B VDD VSS sg13g2_dfrbpq_1
Xfanout573 _08334_/A1 _08381_/A VDD VSS sg13g2_buf_1
XFILLER_76_56 VDD VSS sg13g2_decap_8
XFILLER_63_1183 VDD VSS sg13g2_decap_8
XFILLER_58_240 VDD VSS sg13g2_decap_8
Xfanout584 _13567_/A2 _12794_/X VDD VSS sg13g2_buf_1
Xfanout595 _10973_/B _11001_/B VDD VSS sg13g2_buf_1
XFILLER_115_1284 VDD VSS sg13g2_fill_2
XFILLER_8_1397 VDD VSS sg13g2_decap_8
X_12921_ _15028_/D _12984_/A _12921_/B VDD VSS sg13g2_nor2_1
XFILLER_4_1239 VDD VSS sg13g2_decap_8
XFILLER_86_593 VDD VSS sg13g2_decap_8
XFILLER_73_210 VDD VSS sg13g2_fill_2
XFILLER_150_1186 VDD VSS sg13g2_decap_8
XFILLER_98_1246 VDD VSS sg13g2_decap_8
XFILLER_74_744 VDD VSS sg13g2_fill_1
XFILLER_18_137 VDD VSS sg13g2_decap_8
XFILLER_46_446 VDD VSS sg13g2_decap_8
XFILLER_59_1219 VDD VSS sg13g2_decap_8
X_13735__2467 _13735_/RESET_B VDD VSS sg13g2_tiehi
X_12852_ _12852_/Y _14834_/Q _12879_/B _12895_/B _14866_/Q _12930_/C1 VDD VSS sg13g2_a221oi_1
XFILLER_132_95 VDD VSS sg13g2_decap_8
XFILLER_33_107 VDD VSS sg13g2_decap_8
X_11803_ _11805_/A _11804_/A _14188_/Q VDD VSS sg13g2_nand2b_1
X_12783_ _12783_/X _14266_/Q _14298_/Q _14330_/Q _14362_/Q _12787_/S0 _12787_/S1 VDD
+ VSS sg13g2_mux4_1
XFILLER_73_298 VDD VSS sg13g2_decap_8
XFILLER_14_321 VDD VSS sg13g2_fill_1
XFILLER_148_1071 VDD VSS sg13g2_decap_8
XFILLER_14_332 VDD VSS sg13g2_decap_8
X_14522_ _14522_/Q clkload80/A _14522_/D _14522_/RESET_B VDD VSS sg13g2_dfrbpq_1
X_11734_ _11734_/Y _11730_/Y _11731_/Y _11733_/Y _11732_/Y _11875_/B VDD VSS sg13g2_a221oi_1
XFILLER_72_1419 VDD VSS sg13g2_decap_8
XFILLER_25_60 VDD VSS sg13g2_decap_4
XFILLER_159_315 VDD VSS sg13g2_decap_8
XFILLER_30_803 VDD VSS sg13g2_decap_8
XFILLER_159_326 VDD VSS sg13g2_fill_2
XFILLER_186_112 VDD VSS sg13g2_decap_8
XFILLER_70_983 VDD VSS sg13g2_decap_4
XFILLER_70_994 VDD VSS sg13g2_fill_2
XFILLER_14_387 VDD VSS sg13g2_decap_8
XFILLER_159_359 VDD VSS sg13g2_fill_1
X_14115__2087 _14115_/RESET_B VDD VSS sg13g2_tiehi
X_14453_ _14453_/Q clkload41/A _14453_/D _14453_/RESET_B VDD VSS sg13g2_dfrbpq_1
X_11665_ _11665_/Y _11678_/S0 _13832_/Q VDD VSS sg13g2_nand2b_1
XFILLER_30_847 VDD VSS sg13g2_decap_8
XFILLER_122_1200 VDD VSS sg13g2_decap_8
X_13950__2252 _13950_/RESET_B VDD VSS sg13g2_tiehi
X_13404_ _15089_/D _13435_/A _13396_/D _13403_/Y VDD VSS sg13g2_o21ai_1
X_10616_ _14880_/D _07620_/Y _10611_/A _10615_/Y VDD VSS sg13g2_a21oi_1
XFILLER_70_1154 VDD VSS sg13g2_decap_8
XFILLER_128_724 VDD VSS sg13g2_decap_8
XFILLER_161_1282 VDD VSS sg13g2_decap_8
XFILLER_186_189 VDD VSS sg13g2_decap_8
X_14384_ _14384_/Q _14637_/CLK _14384_/D _14384_/RESET_B VDD VSS sg13g2_dfrbpq_1
X_11596_ _11598_/A _11804_/A _14182_/Q VDD VSS sg13g2_nand2b_1
XFILLER_35_1296 VDD VSS sg13g2_decap_8
XFILLER_10_560 VDD VSS sg13g2_decap_8
XFILLER_183_852 VDD VSS sg13g2_decap_8
X_13335_ _13486_/B hold3052/X _15170_/Q _13336_/S VDD VSS sg13g2_mux2_1
XFILLER_182_340 VDD VSS sg13g2_decap_8
X_10547_ _10556_/D _14864_/Q _14863_/Q _13273_/A _10547_/D VDD VSS sg13g2_and4_1
XFILLER_143_705 VDD VSS sg13g2_decap_8
X_14999__2611 _14999_/RESET_B VDD VSS sg13g2_tiehi
XFILLER_6_564 VDD VSS sg13g2_decap_8
XFILLER_157_1329 VDD VSS sg13g2_decap_8
X_13266_ _15051_/D _13266_/A _13266_/B VDD VSS sg13g2_nor2_1
XFILLER_51_7 VDD VSS sg13g2_fill_2
XFILLER_170_535 VDD VSS sg13g2_decap_8
X_10478_ _14847_/D _10487_/A _10478_/B _10489_/D VDD VSS sg13g2_nor3_1
XFILLER_29_1001 VDD VSS sg13g2_fill_1
X_15005_ _15005_/Q _15005_/CLK _15005_/D _15005_/RESET_B VDD VSS sg13g2_dfrbpq_1
X_12217_ _12217_/Y _12217_/A _12217_/B VDD VSS sg13g2_nor2_1
XFILLER_124_963 VDD VSS sg13g2_fill_1
XFILLER_170_568 VDD VSS sg13g2_decap_8
X_13197_ _13197_/Y _13196_/Y _13262_/B1 _13192_/X _13265_/A1 VDD VSS sg13g2_a22oi_1
XFILLER_9_1106 VDD VSS sg13g2_decap_8
XFILLER_123_451 VDD VSS sg13g2_decap_8
XFILLER_97_814 VDD VSS sg13g2_decap_8
XFILLER_111_602 VDD VSS sg13g2_decap_4
XFILLER_116_1004 VDD VSS sg13g2_decap_8
XFILLER_29_1067 VDD VSS sg13g2_fill_2
XFILLER_123_484 VDD VSS sg13g2_decap_8
X_12148_ _12149_/B _11458_/A _12132_/Y _12147_/Y VDD VSS sg13g2_o21ai_1
XFILLER_69_538 VDD VSS sg13g2_fill_2
XFILLER_2_770 VDD VSS sg13g2_decap_8
XFILLER_116_1037 VDD VSS sg13g2_decap_8
XFILLER_110_123 VDD VSS sg13g2_decap_8
XFILLER_116_1048 VDD VSS sg13g2_fill_1
XFILLER_96_346 VDD VSS sg13g2_fill_1
XFILLER_173_91 VDD VSS sg13g2_decap_8
XFILLER_1_280 VDD VSS sg13g2_decap_8
XFILLER_42_1212 VDD VSS sg13g2_decap_8
XFILLER_81_1272 VDD VSS sg13g2_decap_8
X_12079_ _12079_/Y _14918_/Q _12294_/A2 _12156_/A VDD VSS sg13g2_a21oi_1
XFILLER_2_42 VDD VSS sg13g2_decap_8
XFILLER_133_1362 VDD VSS sg13g2_decap_8
XFILLER_110_189 VDD VSS sg13g2_decap_8
XFILLER_77_593 VDD VSS sg13g2_decap_8
XFILLER_49_284 VDD VSS sg13g2_decap_8
XFILLER_42_1289 VDD VSS sg13g2_decap_8
XFILLER_168_1447 VDD VSS sg13g2_decap_8
X_14325__1877 _14325_/RESET_B VDD VSS sg13g2_tiehi
XFILLER_46_991 VDD VSS sg13g2_decap_8
XFILLER_79_1190 VDD VSS sg13g2_decap_8
XFILLER_127_1100 VDD VSS sg13g2_fill_1
XFILLER_75_1032 VDD VSS sg13g2_decap_8
XFILLER_45_490 VDD VSS sg13g2_decap_8
X_08310_ _08616_/B _08212_/A _08126_/B _08688_/B VDD VSS sg13g2_o21ai_1
XFILLER_166_1171 VDD VSS sg13g2_decap_8
X_09290_ _13898_/D _13898_/Q _09622_/A0 _09296_/S VDD VSS sg13g2_mux2_1
XFILLER_127_1144 VDD VSS sg13g2_decap_8
XFILLER_177_123 VDD VSS sg13g2_decap_8
XFILLER_60_471 VDD VSS sg13g2_fill_2
X_08241_ _08241_/Y _08241_/A _08397_/B VDD VSS sg13g2_nand2_1
XANTENNA_14 _07658_/X VDD VSS sg13g2_antennanp
XANTENNA_25 fanout486/X VDD VSS sg13g2_antennanp
XFILLER_178_679 VDD VSS sg13g2_decap_8
XFILLER_14_1303 VDD VSS sg13g2_decap_8
XFILLER_20_335 VDD VSS sg13g2_decap_8
XFILLER_159_871 VDD VSS sg13g2_decap_8
X_14540__1662 _14540_/RESET_B VDD VSS sg13g2_tiehi
XFILLER_53_1363 VDD VSS sg13g2_decap_8
X_08172_ _08340_/B _08431_/A _08171_/X _08428_/S VDD VSS sg13g2_mux2_1
X_15212__3003 _15212_/RESET_B VDD VSS sg13g2_tiehi
XFILLER_105_1464 VDD VSS sg13g2_decap_8
XFILLER_21_18 VDD VSS sg13g2_decap_8
XFILLER_88_1404 VDD VSS sg13g2_decap_8
XFILLER_140_1388 VDD VSS sg13g2_decap_8
X_14794__2942 _14794_/RESET_B VDD VSS sg13g2_tiehi
XFILLER_106_407 VDD VSS sg13g2_decap_8
XFILLER_134_716 VDD VSS sg13g2_fill_2
XFILLER_161_502 VDD VSS sg13g2_decap_8
XFILLER_12_1082 VDD VSS sg13g2_decap_8
Xoutput110 mem_axi_wdata[15] _15147_/Q VDD VSS sg13g2_buf_1
Xoutput121 mem_axi_wdata[25] _15157_/Q VDD VSS sg13g2_buf_1
Xoutput132 mem_axi_wdata[6] _15138_/Q VDD VSS sg13g2_buf_1
XFILLER_173_1120 VDD VSS sg13g2_decap_8
XFILLER_47_1123 VDD VSS sg13g2_decap_8
X_13813__2389 _13813_/RESET_B VDD VSS sg13g2_tiehi
XFILLER_0_707 VDD VSS sg13g2_decap_8
XFILLER_115_974 VDD VSS sg13g2_decap_8
XFILLER_142_760 VDD VSS sg13g2_fill_2
XFILLER_86_1183 VDD VSS sg13g2_decap_8
XFILLER_82_1036 VDD VSS sg13g2_decap_8
XFILLER_134_1115 VDD VSS sg13g2_decap_8
XFILLER_138_1284 VDD VSS sg13g2_decap_8
XFILLER_82_1047 VDD VSS sg13g2_fill_2
XFILLER_138_1295 VDD VSS sg13g2_fill_2
XFILLER_153_39 VDD VSS sg13g2_decap_8
X_14837__2893 _14837_/RESET_B VDD VSS sg13g2_tiehi
XFILLER_173_1197 VDD VSS sg13g2_decap_8
XFILLER_64_1470 VDD VSS sg13g2_decap_8
XFILLER_60_1301 VDD VSS sg13g2_decap_8
XFILLER_134_1159 VDD VSS sg13g2_decap_8
XFILLER_25_1432 VDD VSS sg13g2_decap_8
X_07956_ _07956_/Y _13566_/A _11983_/A VDD VSS sg13g2_nor2b_1
XFILLER_151_1451 VDD VSS sg13g2_decap_8
XFILLER_87_379 VDD VSS sg13g2_decap_8
XFILLER_101_178 VDD VSS sg13g2_decap_8
X_07887_ _07889_/A _08203_/A _14995_/Q VDD VSS sg13g2_nand2_1
XFILLER_60_1378 VDD VSS sg13g2_decap_8
XFILLER_55_232 VDD VSS sg13g2_fill_1
XFILLER_95_1408 VDD VSS sg13g2_decap_8
XFILLER_44_906 VDD VSS sg13g2_decap_8
XFILLER_16_608 VDD VSS sg13g2_fill_1
X_09626_ _14222_/D _09626_/A0 _14222_/Q _09626_/S VDD VSS sg13g2_mux2_1
XFILLER_55_254 VDD VSS sg13g2_decap_8
XFILLER_3_1250 VDD VSS sg13g2_decap_8
XFILLER_56_788 VDD VSS sg13g2_decap_8
XFILLER_44_939 VDD VSS sg13g2_decap_8
XFILLER_83_585 VDD VSS sg13g2_decap_8
X_09557_ _14155_/D _09590_/A1 _14155_/Q _09566_/S VDD VSS sg13g2_mux2_1
XFILLER_58_1252 VDD VSS sg13g2_decap_8
XFILLER_71_769 VDD VSS sg13g2_decap_8
XFILLER_52_950 VDD VSS sg13g2_decap_8
XFILLER_149_1380 VDD VSS sg13g2_decap_8
X_08508_ _08517_/A _07818_/Y _08506_/Y _08507_/Y VDD VSS sg13g2_o21ai_1
XFILLER_62_25 VDD VSS sg13g2_decap_8
XFILLER_102_87 VDD VSS sg13g2_fill_2
XFILLER_12_803 VDD VSS sg13g2_decap_8
XFILLER_184_1282 VDD VSS sg13g2_decap_8
X_09488_ _14088_/D _10084_/A0 _14088_/Q _09494_/S VDD VSS sg13g2_mux2_1
XFILLER_145_1244 VDD VSS sg13g2_decap_8
XFILLER_168_112 VDD VSS sg13g2_decap_8
XFILLER_178_14 VDD VSS sg13g2_decap_8
XFILLER_19_1247 VDD VSS sg13g2_decap_8
XFILLER_106_1206 VDD VSS sg13g2_decap_8
XFILLER_51_471 VDD VSS sg13g2_decap_8
XFILLER_169_657 VDD VSS sg13g2_decap_8
XFILLER_93_1198 VDD VSS sg13g2_decap_8
XFILLER_24_696 VDD VSS sg13g2_decap_8
X_08439_ _08439_/Y _08574_/A _08438_/Y _08395_/A VDD VSS sg13g2_a21oi_1
XFILLER_12_858 VDD VSS sg13g2_decap_8
XFILLER_180_1168 VDD VSS sg13g2_decap_8
XFILLER_23_195 VDD VSS sg13g2_decap_8
XFILLER_32_1414 VDD VSS sg13g2_decap_8
XFILLER_11_368 VDD VSS sg13g2_decap_8
XFILLER_156_329 VDD VSS sg13g2_decap_8
X_11450_ _11450_/Y _11717_/A _11449_/X _11425_/B VDD VSS sg13g2_o21ai_1
XFILLER_71_1474 VDD VSS sg13g2_decap_4
XFILLER_183_137 VDD VSS sg13g2_decap_8
X_10401_ _14822_/D _10413_/B _10623_/A _10401_/C VDD VSS sg13g2_nor3_1
X_11381_ _11381_/Y _10681_/A _11931_/A2 _11837_/A1 VDD VSS sg13g2_a21oi_1
XFILLER_165_885 VDD VSS sg13g2_fill_1
XFILLER_139_1004 VDD VSS sg13g2_fill_2
X_13120_ _13120_/X _13120_/A _13170_/A VDD VSS sg13g2_xor2_1
X_10332_ _10334_/A _14803_/Q _10336_/D _14804_/Q VDD VSS sg13g2_a21o_1
XFILLER_3_501 VDD VSS sg13g2_decap_8
XFILLER_30_1160 VDD VSS sg13g2_decap_8
XFILLER_178_1075 VDD VSS sg13g2_decap_8
XFILLER_106_941 VDD VSS sg13g2_decap_8
XFILLER_139_1037 VDD VSS sg13g2_decap_8
X_13051_ _13051_/X _14814_/Q _13051_/B VDD VSS sg13g2_and2_1
XFILLER_69_1381 VDD VSS sg13g2_decap_8
XFILLER_11_95 VDD VSS sg13g2_decap_8
X_10263_ _14782_/D _14782_/Q _10268_/D _10261_/Y VDD VSS sg13g2_a21oi_1
XFILLER_87_11 VDD VSS sg13g2_decap_8
XFILLER_127_84 VDD VSS sg13g2_decap_8
X_14403__1799 _14403_/RESET_B VDD VSS sg13g2_tiehi
XFILLER_3_578 VDD VSS sg13g2_decap_8
XFILLER_106_996 VDD VSS sg13g2_decap_4
X_12002_ _12002_/Y _11330_/S _11998_/X _12001_/Y VDD VSS sg13g2_o21ai_1
XFILLER_65_1256 VDD VSS sg13g2_decap_8
XFILLER_26_1207 VDD VSS sg13g2_decap_8
Xfanout1302 _11328_/S1 _12038_/B1 VDD VSS sg13g2_buf_1
XFILLER_79_847 VDD VSS sg13g2_decap_8
Xpicorv32_macro_1442 mem_axi_awaddr[1] VDD VSS sg13g2_tielo
X_10194_ _14754_/D _15197_/D _14754_/Q _10202_/S VDD VSS sg13g2_mux2_1
Xfanout1313 _12169_/C _12187_/C VDD VSS sg13g2_buf_1
Xfanout1324 _11972_/S0 fanout1329/X VDD VSS sg13g2_buf_1
Xfanout1335 _12100_/S0 fanout1339/X VDD VSS sg13g2_buf_1
XFILLER_121_977 VDD VSS sg13g2_decap_8
Xfanout1346 _11759_/A _11741_/A VDD VSS sg13g2_buf_1
XFILLER_94_817 VDD VSS sg13g2_decap_8
Xfanout1357 _11826_/A1 _11821_/S0 VDD VSS sg13g2_buf_1
XFILLER_120_476 VDD VSS sg13g2_decap_8
Xfanout370 _09296_/S _09292_/S VDD VSS sg13g2_buf_1
Xfanout1368 _11997_/S0 fanout1371/X VDD VSS sg13g2_buf_1
Xfanout381 _09189_/S _09196_/S VDD VSS sg13g2_buf_1
Xfanout1379 _12215_/S0 _12286_/S0 VDD VSS sg13g2_buf_1
X_13968__2234 _13968_/RESET_B VDD VSS sg13g2_tiehi
Xfanout392 _09614_/A0 _10145_/A1 VDD VSS sg13g2_buf_1
XFILLER_93_338 VDD VSS sg13g2_decap_8
XFILLER_8_1194 VDD VSS sg13g2_decap_8
X_13953_ _13953_/Q clkload6/A _13953_/D _13953_/RESET_B VDD VSS sg13g2_dfrbpq_1
X_15055__2534 _15055_/RESET_B VDD VSS sg13g2_tiehi
XFILLER_59_593 VDD VSS sg13g2_decap_4
XFILLER_4_1036 VDD VSS sg13g2_decap_8
XFILLER_46_210 VDD VSS sg13g2_fill_2
XFILLER_19_446 VDD VSS sg13g2_decap_8
XFILLER_74_541 VDD VSS sg13g2_decap_8
X_12904_ _15027_/D _12984_/A _12904_/B VDD VSS sg13g2_nor2_1
XFILLER_185_1013 VDD VSS sg13g2_decap_8
X_13884_ _13884_/Q clkload76/A _13884_/D _13884_/RESET_B VDD VSS sg13g2_dfrbpq_1
XFILLER_46_265 VDD VSS sg13g2_decap_8
X_12835_ _12836_/C _12835_/A _13691_/Q VDD VSS sg13g2_xor2_1
X_14890__2787 _14890_/RESET_B VDD VSS sg13g2_tiehi
XFILLER_185_1068 VDD VSS sg13g2_decap_8
XFILLER_36_81 VDD VSS sg13g2_decap_8
XFILLER_128_1420 VDD VSS sg13g2_decap_8
XFILLER_76_1352 VDD VSS sg13g2_decap_8
XFILLER_43_950 VDD VSS sg13g2_decap_8
XFILLER_61_257 VDD VSS sg13g2_decap_4
XFILLER_14_140 VDD VSS sg13g2_decap_8
XFILLER_159_112 VDD VSS sg13g2_fill_2
X_12766_ _12766_/X _14585_/Q _14617_/Q _14649_/Q _14681_/Q _12773_/S0 _12773_/S1 VDD
+ VSS sg13g2_mux4_1
XFILLER_72_1216 VDD VSS sg13g2_decap_8
XFILLER_37_1336 VDD VSS sg13g2_decap_8
XFILLER_163_1366 VDD VSS sg13g2_decap_8
X_14505_ _14505_/Q clkload30/A _14505_/D _14505_/RESET_B VDD VSS sg13g2_dfrbpq_1
X_11717_ _11719_/B _11717_/A _11717_/B VDD VSS sg13g2_nor2_1
XFILLER_30_633 VDD VSS sg13g2_decap_4
X_12697_ _12697_/X _13972_/Q _14004_/Q _14036_/Q _14068_/Q _12699_/S0 _12699_/S1 VDD
+ VSS sg13g2_mux4_1
XFILLER_30_644 VDD VSS sg13g2_decap_8
XFILLER_159_167 VDD VSS sg13g2_decap_8
XFILLER_175_638 VDD VSS sg13g2_decap_8
XFILLER_35_1060 VDD VSS sg13g2_fill_1
X_14436_ _14436_/Q _14724_/CLK _14436_/D _14436_/RESET_B VDD VSS sg13g2_dfrbpq_1
X_11648_ _11648_/X _14247_/Q _14279_/Q _14311_/Q _14343_/Q _11786_/S0 _11786_/S1 VDD
+ VSS sg13g2_mux4_1
XFILLER_156_830 VDD VSS sg13g2_fill_1
XFILLER_174_126 VDD VSS sg13g2_decap_8
Xinput12 input12/X input12/A VDD VSS sg13g2_buf_1
Xinput23 input23/X input23/A VDD VSS sg13g2_buf_1
XFILLER_122_1052 VDD VSS sg13g2_decap_8
XFILLER_168_91 VDD VSS sg13g2_decap_8
Xinput34 input34/X input34/A VDD VSS sg13g2_buf_1
XFILLER_7_840 VDD VSS sg13g2_decap_8
XFILLER_128_554 VDD VSS sg13g2_decap_8
XFILLER_122_1074 VDD VSS sg13g2_decap_8
X_14367_ _14367_/Q _14508_/CLK _14367_/D _14367_/RESET_B VDD VSS sg13g2_dfrbpq_1
X_11579_ _11579_/X _14373_/Q _14405_/Q _14469_/Q _14501_/Q _11580_/S0 _11580_/S1 VDD
+ VSS sg13g2_mux4_1
XFILLER_171_811 VDD VSS sg13g2_decap_8
XFILLER_143_513 VDD VSS sg13g2_decap_8
XFILLER_171_822 VDD VSS sg13g2_fill_2
XFILLER_6_361 VDD VSS sg13g2_decap_8
X_13318_ _13319_/B _15110_/Q _13306_/B _13309_/Y _15063_/Q VDD VSS sg13g2_a22oi_1
XFILLER_155_395 VDD VSS sg13g2_decap_8
X_14298_ _14298_/Q _14682_/CLK _14298_/D _14298_/RESET_B VDD VSS sg13g2_dfrbpq_1
XFILLER_157_1148 VDD VSS sg13g2_decap_8
XFILLER_143_568 VDD VSS sg13g2_decap_8
XFILLER_83_1312 VDD VSS sg13g2_decap_8
XFILLER_100_1383 VDD VSS sg13g2_fill_2
XFILLER_112_900 VDD VSS sg13g2_decap_8
X_13249_ _13251_/B _14892_/Q _13249_/B VDD VSS sg13g2_nand2_1
XFILLER_97_600 VDD VSS sg13g2_decap_8
XFILLER_48_1454 VDD VSS sg13g2_decap_8
XFILLER_124_771 VDD VSS sg13g2_decap_8
XFILLER_170_376 VDD VSS sg13g2_decap_8
XFILLER_174_1462 VDD VSS sg13g2_decap_8
XFILLER_174_1473 VDD VSS sg13g2_fill_2
XFILLER_97_633 VDD VSS sg13g2_fill_1
XFILLER_170_1326 VDD VSS sg13g2_decap_8
XFILLER_123_292 VDD VSS sg13g2_decap_4
XFILLER_83_1389 VDD VSS sg13g2_decap_8
X_07810_ _08567_/A _15012_/Q _12009_/A VDD VSS sg13g2_xnor2_1
XFILLER_135_1468 VDD VSS sg13g2_fill_2
XFILLER_96_143 VDD VSS sg13g2_decap_8
X_08790_ _08790_/Y _13481_/A _13482_/A _13459_/B VDD VSS sg13g2_o21ai_1
XFILLER_69_368 VDD VSS sg13g2_decap_4
XFILLER_97_688 VDD VSS sg13g2_decap_8
XFILLER_57_519 VDD VSS sg13g2_decap_8
X_07741_ _07741_/Y _15124_/Q _13481_/A VDD VSS sg13g2_nand2b_1
XFILLER_38_722 VDD VSS sg13g2_fill_2
X_14558__1644 _14558_/RESET_B VDD VSS sg13g2_tiehi
XFILLER_93_850 VDD VSS sg13g2_decap_8
XFILLER_42_1086 VDD VSS sg13g2_decap_8
X_15098__2802 _15098_/RESET_B VDD VSS sg13g2_tiehi
X_07672_ _07672_/X _07665_/X _07670_/Y _07667_/Y VDD VSS sg13g2_a21o_1
XFILLER_38_777 VDD VSS sg13g2_decap_8
XFILLER_0_1401 VDD VSS sg13g2_decap_8
XFILLER_26_928 VDD VSS sg13g2_decap_8
XFILLER_168_1244 VDD VSS sg13g2_decap_8
XFILLER_20_1340 VDD VSS sg13g2_decap_8
XFILLER_16_18 VDD VSS sg13g2_decap_8
X_09411_ _14013_/D _10040_/A0 _14013_/Q _09438_/S VDD VSS sg13g2_mux2_1
XFILLER_80_511 VDD VSS sg13g2_decap_8
XFILLER_77_1138 VDD VSS sg13g2_decap_8
XFILLER_53_758 VDD VSS sg13g2_fill_2
XFILLER_181_1400 VDD VSS sg13g2_decap_8
XFILLER_52_246 VDD VSS sg13g2_decap_8
XFILLER_0_1478 VDD VSS sg13g2_fill_1
X_09342_ _09342_/Y _10105_/B _09441_/D VDD VSS sg13g2_nand2_1
XFILLER_179_933 VDD VSS sg13g2_decap_8
XFILLER_55_1447 VDD VSS sg13g2_decap_8
X_09273_ _13882_/D _13882_/Q _09904_/A0 _09273_/S VDD VSS sg13g2_mux2_1
XFILLER_178_465 VDD VSS sg13g2_decap_8
XFILLER_181_1477 VDD VSS sg13g2_fill_2
XFILLER_32_28 VDD VSS sg13g2_decap_8
XFILLER_14_1100 VDD VSS sg13g2_decap_8
X_08224_ _08224_/X _08119_/X _08128_/X _08129_/X _08132_/X _08428_/S _08234_/B VDD
+ VSS sg13g2_mux4_1
XFILLER_18_1280 VDD VSS sg13g2_decap_8
XFILLER_53_1160 VDD VSS sg13g2_decap_8
XFILLER_105_1250 VDD VSS sg13g2_decap_8
XFILLER_165_148 VDD VSS sg13g2_decap_8
X_08155_ _08155_/Y _08188_/A _08432_/A2 _08654_/B VDD VSS sg13g2_o21ai_1
XFILLER_101_1114 VDD VSS sg13g2_decap_8
XFILLER_10_1008 VDD VSS sg13g2_decap_8
XFILLER_14_1177 VDD VSS sg13g2_decap_8
XFILLER_174_671 VDD VSS sg13g2_fill_1
XFILLER_179_1351 VDD VSS sg13g2_decap_8
XFILLER_119_587 VDD VSS sg13g2_fill_2
XFILLER_134_513 VDD VSS sg13g2_decap_8
XFILLER_161_310 VDD VSS sg13g2_fill_2
X_08086_ _08270_/A _08198_/S _08086_/B VDD VSS sg13g2_nand2_1
XFILLER_134_535 VDD VSS sg13g2_decap_8
XFILLER_175_1237 VDD VSS sg13g2_decap_8
XFILLER_162_877 VDD VSS sg13g2_decap_8
XFILLER_162_888 VDD VSS sg13g2_fill_2
XFILLER_88_600 VDD VSS sg13g2_fill_1
XFILLER_0_504 VDD VSS sg13g2_decap_8
XFILLER_103_911 VDD VSS sg13g2_decap_8
XFILLER_164_49 VDD VSS sg13g2_decap_8
X_14758__2981 _14758_/RESET_B VDD VSS sg13g2_tiehi
XFILLER_138_1070 VDD VSS sg13g2_fill_1
XFILLER_88_633 VDD VSS sg13g2_decap_8
XFILLER_62_1418 VDD VSS sg13g2_decap_8
XFILLER_87_154 VDD VSS sg13g2_decap_8
XFILLER_57_25 VDD VSS sg13g2_decap_8
XFILLER_130_785 VDD VSS sg13g2_decap_8
X_08988_ _08988_/Y _09031_/A _08988_/B _08988_/C VDD VSS sg13g2_nor3_1
XFILLER_76_839 VDD VSS sg13g2_decap_8
XFILLER_102_487 VDD VSS sg13g2_decap_8
XFILLER_5_1323 VDD VSS sg13g2_decap_8
XFILLER_69_891 VDD VSS sg13g2_fill_2
XFILLER_151_1270 VDD VSS sg13g2_decap_8
XFILLER_116_1390 VDD VSS sg13g2_decap_8
XFILLER_169_1008 VDD VSS sg13g2_decap_8
X_07939_ _07939_/Y _08315_/B _07776_/Y _07773_/Y VDD VSS sg13g2_a21oi_1
XFILLER_151_1281 VDD VSS sg13g2_fill_1
XFILLER_60_1175 VDD VSS sg13g2_decap_8
XFILLER_21_1148 VDD VSS sg13g2_decap_8
X_10950_ _10950_/Y _10949_/Y _11004_/A _11014_/A VDD VSS sg13g2_a21oi_1
XFILLER_95_1205 VDD VSS sg13g2_decap_8
XFILLER_186_1322 VDD VSS sg13g2_decap_8
XFILLER_56_574 VDD VSS sg13g2_decap_8
XFILLER_83_371 VDD VSS sg13g2_decap_8
XFILLER_56_585 VDD VSS sg13g2_fill_2
XFILLER_43_213 VDD VSS sg13g2_decap_8
XFILLER_113_86 VDD VSS sg13g2_fill_2
X_09609_ _14205_/D _09875_/A0 _14205_/Q _09623_/S VDD VSS sg13g2_mux2_1
XFILLER_182_1208 VDD VSS sg13g2_decap_8
X_10881_ _10890_/C _14754_/Q _10897_/A VDD VSS sg13g2_xor2_1
XFILLER_186_1399 VDD VSS sg13g2_decap_8
X_12620_ _12620_/X _14702_/Q _14734_/Q _13774_/Q _13806_/Q _12620_/S0 _12620_/S1 VDD
+ VSS sg13g2_mux4_1
XFILLER_31_408 VDD VSS sg13g2_fill_1
XFILLER_24_460 VDD VSS sg13g2_decap_8
XFILLER_58_1082 VDD VSS sg13g2_decap_8
XFILLER_169_443 VDD VSS sg13g2_fill_1
XFILLER_19_1044 VDD VSS sg13g2_fill_1
X_12551_ _12551_/X _12548_/X _12547_/X _12544_/X _12543_/X _12705_/S0 _12706_/S VDD
+ VSS sg13g2_mux4_1
XFILLER_12_633 VDD VSS sg13g2_decap_8
XFILLER_40_964 VDD VSS sg13g2_decap_8
X_11502_ _11636_/A _11502_/A _13685_/Q VDD VSS sg13g2_xor2_1
X_12482_ _12482_/X _12480_/X _12479_/X _12476_/X _12475_/X _12622_/S0 _12567_/S VDD
+ VSS sg13g2_mux4_1
XFILLER_32_1211 VDD VSS sg13g2_decap_8
XFILLER_11_165 VDD VSS sg13g2_decap_8
XFILLER_71_1271 VDD VSS sg13g2_decap_8
X_13667__2561 _13667_/RESET_B VDD VSS sg13g2_tiehi
X_14032__2170 _14032_/RESET_B VDD VSS sg13g2_tiehi
XFILLER_8_648 VDD VSS sg13g2_decap_8
XFILLER_138_852 VDD VSS sg13g2_fill_1
XFILLER_156_148 VDD VSS sg13g2_decap_8
XFILLER_184_457 VDD VSS sg13g2_decap_8
XFILLER_125_0 VDD VSS sg13g2_decap_8
X_14221_ _14221_/Q clkload18/A _14221_/D _14221_/RESET_B VDD VSS sg13g2_dfrbpq_1
X_11433_ _11433_/Y _14899_/Q _11433_/B VDD VSS sg13g2_nand2_1
XFILLER_7_147 VDD VSS sg13g2_decap_8
XFILLER_137_351 VDD VSS sg13g2_fill_1
XFILLER_32_1288 VDD VSS sg13g2_decap_8
XFILLER_22_94 VDD VSS sg13g2_fill_1
X_14152_ _14152_/Q clkload20/A _14152_/D _14152_/RESET_B VDD VSS sg13g2_dfrbpq_1
XFILLER_158_1424 VDD VSS sg13g2_decap_8
X_11364_ _11366_/A _11365_/A _14462_/Q VDD VSS sg13g2_nand2b_1
XFILLER_137_395 VDD VSS sg13g2_decap_8
XFILLER_180_630 VDD VSS sg13g2_decap_8
XFILLER_67_1318 VDD VSS sg13g2_decap_8
X_14636__1566 _14636_/RESET_B VDD VSS sg13g2_tiehi
XFILLER_113_708 VDD VSS sg13g2_fill_2
X_13103_ _13104_/B _14912_/Q _13675_/Q _13091_/Y VDD VSS sg13g2_a21oi_1
X_14918__2731 _14918_/RESET_B VDD VSS sg13g2_tiehi
X_10315_ _10315_/Y _10342_/A _10342_/C _10322_/C VDD VSS sg13g2_o21ai_1
XFILLER_4_854 VDD VSS sg13g2_decap_8
X_14083_ _14083_/Q _14723_/CLK _14083_/D _14083_/RESET_B VDD VSS sg13g2_dfrbpq_1
X_11295_ _11295_/Y _11315_/A1 _13821_/Q VDD VSS sg13g2_nand2b_1
XFILLER_98_419 VDD VSS sg13g2_decap_8
XFILLER_79_600 VDD VSS sg13g2_decap_8
X_13034_ _13034_/Y _13032_/Y _13033_/Y _12933_/Y VDD VSS sg13g2_o21ai_1
XFILLER_98_98 VDD VSS sg13g2_decap_8
XFILLER_3_375 VDD VSS sg13g2_decap_8
X_10246_ _10248_/C _14776_/Q _10250_/D _14777_/Q VDD VSS sg13g2_a21oi_1
XFILLER_105_292 VDD VSS sg13g2_decap_8
XFILLER_121_741 VDD VSS sg13g2_decap_8
Xfanout1110 _07845_/B _12203_/A VDD VSS sg13g2_buf_1
Xfanout1121 _07861_/B _08928_/A1 VDD VSS sg13g2_buf_1
Xfanout1132 _08919_/A1 _14978_/Q VDD VSS sg13g2_buf_1
X_10177_ _10184_/C _13600_/C _14766_/Q VDD VSS sg13g2_nand2_1
XFILLER_39_519 VDD VSS sg13g2_decap_8
Xfanout1143 _07945_/B _08900_/A1 VDD VSS sg13g2_buf_1
Xfanout1154 _07782_/A _11659_/A VDD VSS sg13g2_buf_1
XFILLER_152_1078 VDD VSS sg13g2_decap_8
Xfanout1165 _08258_/C _07771_/A VDD VSS sg13g2_buf_1
XFILLER_78_187 VDD VSS sg13g2_decap_4
XFILLER_66_327 VDD VSS sg13g2_fill_2
Xfanout1176 _11461_/A _14963_/Q VDD VSS sg13g2_buf_1
XFILLER_14_7 VDD VSS sg13g2_decap_8
XFILLER_93_124 VDD VSS sg13g2_decap_8
XFILLER_66_349 VDD VSS sg13g2_decap_8
X_14985_ _14985_/Q clkload47/A _14985_/D _14985_/RESET_B VDD VSS sg13g2_dfrbpq_1
Xfanout1187 _07879_/A _11335_/A VDD VSS sg13g2_buf_1
X_15211__3002 _15211_/RESET_B VDD VSS sg13g2_tiehi
Xfanout1198 _07903_/B _13601_/A VDD VSS sg13g2_buf_1
X_13936_ _13936_/Q _14704_/CLK _13936_/D _13936_/RESET_B VDD VSS sg13g2_dfrbpq_1
XFILLER_78_1436 VDD VSS sg13g2_decap_8
XFILLER_35_725 VDD VSS sg13g2_decap_8
XFILLER_34_202 VDD VSS sg13g2_decap_8
XFILLER_170_81 VDD VSS sg13g2_decap_8
XFILLER_165_1406 VDD VSS sg13g2_decap_8
XFILLER_90_831 VDD VSS sg13g2_decap_4
XFILLER_74_393 VDD VSS sg13g2_decap_8
XFILLER_62_533 VDD VSS sg13g2_decap_4
X_13867_ _13867_/Q clkload12/A _13867_/D _13867_/RESET_B VDD VSS sg13g2_dfrbpq_1
XFILLER_34_235 VDD VSS sg13g2_decap_8
XFILLER_179_207 VDD VSS sg13g2_fill_1
X_14242__1960 _14242_/RESET_B VDD VSS sg13g2_tiehi
X_12818_ _12818_/Y _14800_/Q _12851_/B _12879_/B _14832_/Q _12930_/C1 VDD VSS sg13g2_a221oi_1
XFILLER_72_1002 VDD VSS sg13g2_fill_1
XFILLER_16_994 VDD VSS sg13g2_decap_8
X_13798_ _13798_/Q clkload51/A _13798_/D _13798_/RESET_B VDD VSS sg13g2_dfrbpq_1
XFILLER_37_1133 VDD VSS sg13g2_decap_8
XFILLER_128_1250 VDD VSS sg13g2_decap_8
XFILLER_72_1024 VDD VSS sg13g2_fill_1
XFILLER_163_1163 VDD VSS sg13g2_decap_8
X_12749_ _12750_/B _13665_/Q _12749_/A2 _12748_/X _12749_/B2 _12749_/C1 VDD VSS sg13g2_a221oi_1
XFILLER_148_616 VDD VSS sg13g2_decap_8
XFILLER_147_104 VDD VSS sg13g2_decap_8
XFILLER_124_1158 VDD VSS sg13g2_decap_8
XFILLER_15_1453 VDD VSS sg13g2_decap_8
XFILLER_163_608 VDD VSS sg13g2_decap_8
XFILLER_8_74 VDD VSS sg13g2_decap_8
XFILLER_50_1344 VDD VSS sg13g2_decap_8
X_14419_ _14419_/Q clkload36/A _14419_/D _14419_/RESET_B VDD VSS sg13g2_dfrbpq_1
XFILLER_128_351 VDD VSS sg13g2_fill_1
XFILLER_11_1317 VDD VSS sg13g2_decap_8
XFILLER_102_1445 VDD VSS sg13g2_decap_8
XFILLER_128_362 VDD VSS sg13g2_decap_8
XFILLER_128_373 VDD VSS sg13g2_fill_1
XFILLER_129_896 VDD VSS sg13g2_decap_8
XFILLER_85_1418 VDD VSS sg13g2_decap_8
XFILLER_171_641 VDD VSS sg13g2_fill_2
XFILLER_144_866 VDD VSS sg13g2_decap_4
XFILLER_143_354 VDD VSS sg13g2_fill_1
XFILLER_143_365 VDD VSS sg13g2_decap_8
XFILLER_171_674 VDD VSS sg13g2_decap_8
X_09960_ _14544_/D _14544_/Q _09960_/A1 _09964_/S VDD VSS sg13g2_mux2_1
XFILLER_83_1120 VDD VSS sg13g2_decap_8
X_13694__2508 _13694_/RESET_B VDD VSS sg13g2_tiehi
XFILLER_48_1251 VDD VSS sg13g2_decap_8
XFILLER_103_229 VDD VSS sg13g2_decap_4
X_08911_ _13710_/D _08932_/S _08909_/Y _08910_/Y VDD VSS sg13g2_a21oi_1
X_13730__2472 _13730_/RESET_B VDD VSS sg13g2_tiehi
X_09891_ _14477_/D _09891_/A0 _14477_/Q _09898_/S VDD VSS sg13g2_mux2_1
XFILLER_97_430 VDD VSS sg13g2_decap_8
XFILLER_100_903 VDD VSS sg13g2_decap_8
X_08842_ _13693_/D _08841_/Y _16855_/A _08842_/S VDD VSS sg13g2_mux2_1
XFILLER_97_463 VDD VSS sg13g2_fill_2
XFILLER_98_997 VDD VSS sg13g2_decap_8
X_08773_ _08773_/Y _13345_/B _15117_/Q _15186_/Q _07719_/X VDD VSS sg13g2_a22oi_1
XFILLER_57_349 VDD VSS sg13g2_fill_2
X_14074__2128 _14074_/RESET_B VDD VSS sg13g2_tiehi
XFILLER_66_850 VDD VSS sg13g2_fill_2
XFILLER_27_28 VDD VSS sg13g2_decap_4
X_07724_ _07726_/C _15073_/Q _15072_/Q _15071_/Q _15083_/Q VDD VSS sg13g2_nor4_1
XFILLER_22_1468 VDD VSS sg13g2_decap_8
XFILLER_26_714 VDD VSS sg13g2_decap_8
X_14110__2092 _14110_/RESET_B VDD VSS sg13g2_tiehi
XFILLER_65_360 VDD VSS sg13g2_decap_8
XFILLER_65_371 VDD VSS sg13g2_fill_1
XFILLER_93_691 VDD VSS sg13g2_decap_8
XFILLER_38_596 VDD VSS sg13g2_fill_2
X_07655_ _07655_/Y _11971_/C VDD VSS sg13g2_inv_1
XFILLER_168_1063 VDD VSS sg13g2_decap_8
XFILLER_25_235 VDD VSS sg13g2_decap_8
XFILLER_81_875 VDD VSS sg13g2_fill_1
XFILLER_80_363 VDD VSS sg13g2_fill_1
XFILLER_0_1275 VDD VSS sg13g2_decap_8
XFILLER_94_1260 VDD VSS sg13g2_fill_2
XFILLER_59_1380 VDD VSS sg13g2_decap_8
X_14714__1488 _14714_/RESET_B VDD VSS sg13g2_tiehi
X_09325_ _13932_/D _10155_/A1 _13932_/Q _09325_/S VDD VSS sg13g2_mux2_1
XFILLER_55_1244 VDD VSS sg13g2_decap_8
XFILLER_40_238 VDD VSS sg13g2_fill_2
XFILLER_142_1203 VDD VSS sg13g2_fill_1
XFILLER_146_1383 VDD VSS sg13g2_decap_8
XFILLER_167_925 VDD VSS sg13g2_decap_8
XFILLER_159_49 VDD VSS sg13g2_decap_8
XFILLER_181_1274 VDD VSS sg13g2_decap_8
XFILLER_16_1239 VDD VSS sg13g2_decap_8
X_09256_ _13865_/D _13865_/Q _09920_/A1 _09267_/S VDD VSS sg13g2_mux2_1
XFILLER_90_1179 VDD VSS sg13g2_decap_8
XFILLER_138_126 VDD VSS sg13g2_decap_8
XFILLER_103_1209 VDD VSS sg13g2_decap_8
XFILLER_107_1389 VDD VSS sg13g2_decap_8
X_08207_ _08207_/X _07888_/B _07910_/B _08215_/A3 _07893_/B _08023_/A _07884_/A VDD
+ VSS sg13g2_mux4_1
X_09187_ _13803_/D _13803_/Q _09889_/A0 _09196_/S VDD VSS sg13g2_mux2_1
XFILLER_135_822 VDD VSS sg13g2_decap_8
XFILLER_147_682 VDD VSS sg13g2_decap_4
X_08138_ _08138_/X _08138_/A _08301_/S _08234_/B VDD VSS sg13g2_and3_1
XFILLER_88_1042 VDD VSS sg13g2_decap_8
XFILLER_134_321 VDD VSS sg13g2_fill_1
XFILLER_107_546 VDD VSS sg13g2_decap_8
X_08069_ _08431_/A _08037_/B _08063_/Y _08669_/B1 VDD VSS sg13g2_a21oi_1
XFILLER_122_516 VDD VSS sg13g2_decap_4
XFILLER_135_899 VDD VSS sg13g2_fill_2
X_10100_ _14680_/D _10100_/A0 _14680_/Q _10102_/S VDD VSS sg13g2_mux2_1
XFILLER_66_1340 VDD VSS sg13g2_decap_8
XFILLER_0_301 VDD VSS sg13g2_decap_8
XFILLER_134_398 VDD VSS sg13g2_fill_2
X_14284__1918 _14284_/RESET_B VDD VSS sg13g2_tiehi
X_11080_ _11080_/Y _11139_/B1 _11079_/Y _11109_/B VDD VSS sg13g2_o21ai_1
XFILLER_27_1313 VDD VSS sg13g2_decap_8
XFILLER_103_730 VDD VSS sg13g2_fill_1
XFILLER_108_97 VDD VSS sg13g2_decap_8
XFILLER_62_1215 VDD VSS sg13g2_decap_8
XFILLER_1_868 VDD VSS sg13g2_decap_8
XFILLER_7_1407 VDD VSS sg13g2_decap_8
X_14320__1882 _14320_/RESET_B VDD VSS sg13g2_tiehi
X_10031_ _14613_/D _10097_/A0 _14613_/Q _10035_/S VDD VSS sg13g2_mux2_1
XFILLER_153_1365 VDD VSS sg13g2_decap_8
XFILLER_76_614 VDD VSS sg13g2_fill_1
XFILLER_0_378 VDD VSS sg13g2_decap_8
XFILLER_114_1327 VDD VSS sg13g2_decap_8
XFILLER_124_41 VDD VSS sg13g2_decap_8
XFILLER_130_582 VDD VSS sg13g2_decap_8
XFILLER_5_1120 VDD VSS sg13g2_decap_8
XFILLER_76_669 VDD VSS sg13g2_decap_8
X_14770_ _14770_/Q clkload66/A _14770_/D _14770_/RESET_B VDD VSS sg13g2_dfrbpq_1
XFILLER_91_628 VDD VSS sg13g2_decap_8
XFILLER_112_1062 VDD VSS sg13g2_decap_8
X_11982_ _11989_/A _11983_/A _13671_/Q VDD VSS sg13g2_xor2_1
XFILLER_5_1197 VDD VSS sg13g2_decap_8
XFILLER_16_213 VDD VSS sg13g2_decap_8
XFILLER_112_1095 VDD VSS sg13g2_decap_8
X_13721_ _16883_/A _15228_/CLK _13721_/D _13721_/RESET_B VDD VSS sg13g2_dfrbpq_1
XFILLER_44_533 VDD VSS sg13g2_fill_2
X_10933_ _10935_/B _10946_/A _10934_/B _10948_/D VDD VSS sg13g2_a21oi_1
XFILLER_44_555 VDD VSS sg13g2_decap_8
XFILLER_71_352 VDD VSS sg13g2_fill_1
XFILLER_147_1147 VDD VSS sg13g2_decap_8
XFILLER_186_1196 VDD VSS sg13g2_decap_8
X_13652_ _15118_/D _15187_/D _15118_/Q _13652_/S VDD VSS sg13g2_mux2_1
X_10864_ _10890_/B _14753_/Q _10871_/A VDD VSS sg13g2_xnor2_1
XFILLER_72_897 VDD VSS sg13g2_decap_4
XFILLER_32_728 VDD VSS sg13g2_decap_8
XFILLER_147_1158 VDD VSS sg13g2_fill_1
XFILLER_73_1311 VDD VSS sg13g2_decap_8
XFILLER_31_227 VDD VSS sg13g2_decap_8
XFILLER_13_942 VDD VSS sg13g2_fill_1
X_12603_ _12603_/X _13837_/Q _13869_/Q _13901_/Q _13933_/Q _12605_/S0 _12605_/S1 VDD
+ VSS sg13g2_mux4_1
XFILLER_34_1306 VDD VSS sg13g2_decap_8
X_13583_ _13583_/Y _15001_/Q _13566_/B _13569_/S _15017_/Q _13533_/X VDD VSS sg13g2_a221oi_1
X_10795_ _14925_/D _11207_/B1 _11205_/A _10792_/Y VDD VSS sg13g2_o21ai_1
XFILLER_12_441 VDD VSS sg13g2_decap_8
XFILLER_158_936 VDD VSS sg13g2_fill_1
XFILLER_160_1325 VDD VSS sg13g2_decap_8
XFILLER_9_924 VDD VSS sg13g2_decap_8
XFILLER_73_1388 VDD VSS sg13g2_decap_8
XFILLER_33_60 VDD VSS sg13g2_fill_1
X_12534_ _12534_/X _13736_/Q _14088_/Q _14440_/Q _14536_/Q _12536_/S0 _12536_/S1 VDD
+ VSS sg13g2_mux4_1
XFILLER_33_71 VDD VSS sg13g2_decap_8
XFILLER_129_137 VDD VSS sg13g2_decap_8
XFILLER_185_766 VDD VSS sg13g2_decap_8
XFILLER_8_445 VDD VSS sg13g2_decap_8
XFILLER_173_917 VDD VSS sg13g2_decap_8
XFILLER_184_254 VDD VSS sg13g2_decap_8
XFILLER_172_405 VDD VSS sg13g2_decap_8
X_12465_ _12465_/X _14115_/Q _14147_/Q _14179_/Q _14211_/Q _12466_/S0 _12466_/S1 VDD
+ VSS sg13g2_mux4_1
XFILLER_138_671 VDD VSS sg13g2_decap_8
XFILLER_166_980 VDD VSS sg13g2_decap_8
XFILLER_173_939 VDD VSS sg13g2_fill_1
XFILLER_144_118 VDD VSS sg13g2_fill_1
XFILLER_123_1191 VDD VSS sg13g2_decap_8
XFILLER_144_129 VDD VSS sg13g2_decap_8
XFILLER_166_991 VDD VSS sg13g2_fill_2
XFILLER_172_438 VDD VSS sg13g2_decap_8
X_14204_ _14204_/Q _14588_/CLK _14204_/D _14204_/RESET_B VDD VSS sg13g2_dfrbpq_1
XFILLER_126_833 VDD VSS sg13g2_decap_8
X_11416_ _11420_/A _11415_/X _11802_/B VDD VSS sg13g2_nand2b_1
XFILLER_32_1085 VDD VSS sg13g2_decap_8
XFILLER_158_1221 VDD VSS sg13g2_decap_8
X_15184_ _15184_/Q clkload82/A _15184_/D _15184_/RESET_B VDD VSS sg13g2_dfrbpq_1
X_12396_ _12396_/X _14238_/Q _14270_/Q _14302_/Q _14334_/Q _12614_/S0 _12614_/S1 VDD
+ VSS sg13g2_mux4_1
XFILLER_153_652 VDD VSS sg13g2_decap_8
X_14135_ _14135_/Q clkload43/A _14135_/D _14135_/RESET_B VDD VSS sg13g2_dfrbpq_1
X_11347_ _11347_/Y _11368_/S0 _14686_/Q VDD VSS sg13g2_nand2b_1
XFILLER_4_651 VDD VSS sg13g2_decap_8
XFILLER_119_1216 VDD VSS sg13g2_fill_1
XFILLER_10_1372 VDD VSS sg13g2_decap_8
XFILLER_140_313 VDD VSS sg13g2_fill_2
XFILLER_165_81 VDD VSS sg13g2_decap_8
XFILLER_158_1298 VDD VSS sg13g2_decap_8
XFILLER_3_172 VDD VSS sg13g2_decap_8
XFILLER_106_590 VDD VSS sg13g2_decap_8
X_14066_ _14066_/Q _14546_/CLK _14066_/D _14066_/RESET_B VDD VSS sg13g2_dfrbpq_1
X_11278_ _11278_/Y _11277_/S _14172_/Q VDD VSS sg13g2_nand2b_1
XFILLER_141_869 VDD VSS sg13g2_fill_1
XFILLER_45_1424 VDD VSS sg13g2_decap_8
X_15158__2664 _15158_/RESET_B VDD VSS sg13g2_tiehi
X_13017_ _13017_/Y _12900_/A _13017_/A2 input8/X VDD VSS sg13g2_a21oi_1
X_10229_ _14771_/D _10237_/A _10237_/C _10228_/Y VDD VSS sg13g2_a21oi_1
XFILLER_121_560 VDD VSS sg13g2_decap_8
XFILLER_95_923 VDD VSS sg13g2_decap_8
XFILLER_121_571 VDD VSS sg13g2_fill_2
XFILLER_79_496 VDD VSS sg13g2_decap_8
XFILLER_0_890 VDD VSS sg13g2_decap_8
XFILLER_58_90 VDD VSS sg13g2_decap_8
XFILLER_181_91 VDD VSS sg13g2_decap_8
X_14968_ _14968_/Q clkload58/A _14968_/D _14968_/RESET_B VDD VSS sg13g2_dfrbpq_1
XFILLER_94_488 VDD VSS sg13g2_decap_8
XFILLER_130_1162 VDD VSS sg13g2_decap_8
XFILLER_63_820 VDD VSS sg13g2_decap_4
XFILLER_169_1350 VDD VSS sg13g2_decap_8
XFILLER_78_1233 VDD VSS sg13g2_decap_8
XFILLER_130_1184 VDD VSS sg13g2_fill_1
X_13919_ _13919_/Q _14495_/CLK _13919_/D _13919_/RESET_B VDD VSS sg13g2_dfrbpq_1
XFILLER_47_393 VDD VSS sg13g2_decap_8
XFILLER_165_1203 VDD VSS sg13g2_decap_8
X_14899_ _14899_/Q clkload60/A _14899_/D _14899_/RESET_B VDD VSS sg13g2_dfrbpq_1
XFILLER_39_1217 VDD VSS sg13g2_decap_8
XFILLER_35_599 VDD VSS sg13g2_decap_8
XFILLER_50_536 VDD VSS sg13g2_decap_8
XFILLER_91_1444 VDD VSS sg13g2_decap_8
XFILLER_52_1417 VDD VSS sg13g2_decap_8
X_09110_ _09110_/X _13156_/A _09150_/B _09109_/Y VDD VSS sg13g2_a21o_1
XFILLER_88_0 VDD VSS sg13g2_decap_8
X_13748__2454 _13748_/RESET_B VDD VSS sg13g2_tiehi
XFILLER_31_783 VDD VSS sg13g2_decap_8
XFILLER_176_766 VDD VSS sg13g2_fill_1
X_09041_ _09044_/B _14906_/Q _09031_/C _14907_/Q VDD VSS sg13g2_a21oi_1
XFILLER_30_282 VDD VSS sg13g2_fill_1
XFILLER_148_468 VDD VSS sg13g2_decap_4
XFILLER_15_1250 VDD VSS sg13g2_decap_8
XFILLER_175_254 VDD VSS sg13g2_decap_4
XFILLER_176_788 VDD VSS sg13g2_decap_8
XFILLER_11_1114 VDD VSS sg13g2_decap_8
XFILLER_129_671 VDD VSS sg13g2_decap_4
XFILLER_135_118 VDD VSS sg13g2_decap_4
XFILLER_159_1018 VDD VSS sg13g2_decap_4
XFILLER_141_1291 VDD VSS sg13g2_decap_4
XFILLER_144_630 VDD VSS sg13g2_fill_2
XFILLER_176_1310 VDD VSS sg13g2_decap_8
XFILLER_89_1362 VDD VSS sg13g2_decap_8
XFILLER_85_1204 VDD VSS sg13g2_decap_8
XFILLER_102_1275 VDD VSS sg13g2_decap_8
XFILLER_116_343 VDD VSS sg13g2_decap_8
XFILLER_144_652 VDD VSS sg13g2_decap_8
XFILLER_104_505 VDD VSS sg13g2_decap_8
XFILLER_104_516 VDD VSS sg13g2_fill_2
XFILLER_137_1316 VDD VSS sg13g2_decap_8
X_14128__2074 _14128_/RESET_B VDD VSS sg13g2_tiehi
XFILLER_172_1207 VDD VSS sg13g2_decap_8
XFILLER_104_538 VDD VSS sg13g2_decap_8
XFILLER_176_1387 VDD VSS sg13g2_decap_8
XFILLER_132_858 VDD VSS sg13g2_fill_2
X_09943_ _14527_/D _14527_/Q _10142_/A1 _09964_/S VDD VSS sg13g2_mux2_1
Xfanout903 _12716_/S0 _12717_/S0 VDD VSS sg13g2_buf_1
Xfanout914 _12786_/S0 fanout915/X VDD VSS sg13g2_buf_1
Xfanout925 _13079_/C _13134_/C VDD VSS sg13g2_buf_1
XFILLER_86_901 VDD VSS sg13g2_decap_8
Xfanout936 _13297_/S _13300_/C VDD VSS sg13g2_buf_1
XFILLER_86_912 VDD VSS sg13g2_fill_1
Xfanout947 _13545_/B _13552_/C VDD VSS sg13g2_buf_1
X_09874_ _14460_/D _09907_/A1 _14460_/Q _09904_/S VDD VSS sg13g2_mux2_1
XFILLER_135_1062 VDD VSS sg13g2_decap_8
Xfanout958 _13389_/B _15182_/Q VDD VSS sg13g2_buf_1
XFILLER_57_102 VDD VSS sg13g2_fill_2
X_15057__2526 _15057_/RESET_B VDD VSS sg13g2_tiehi
Xfanout969 _13219_/B1 _13028_/B VDD VSS sg13g2_buf_1
XFILLER_97_271 VDD VSS sg13g2_decap_8
XFILLER_58_647 VDD VSS sg13g2_decap_8
XFILLER_161_28 VDD VSS sg13g2_decap_8
X_08825_ _08825_/Y _07720_/C _12346_/A _08727_/D _15177_/Q _13390_/A2 VDD VSS sg13g2_a221oi_1
XFILLER_86_967 VDD VSS sg13g2_decap_4
XFILLER_61_1281 VDD VSS sg13g2_decap_8
X_14902__2763 _14902_/RESET_B VDD VSS sg13g2_tiehi
XFILLER_45_308 VDD VSS sg13g2_decap_8
X_08756_ _13670_/D _08765_/A1 _08754_/Y _08755_/Y VDD VSS sg13g2_a21oi_1
XFILLER_22_1265 VDD VSS sg13g2_decap_8
XFILLER_2_1337 VDD VSS sg13g2_decap_8
X_07707_ _07708_/C _12997_/B _15201_/Q VDD VSS sg13g2_nor2_1
XFILLER_166_7 VDD VSS sg13g2_decap_8
X_08687_ _08687_/X _08465_/X _08537_/X _08621_/C _08686_/X _08056_/B _08617_/A VDD
+ VSS sg13g2_mux4_1
XFILLER_57_1317 VDD VSS sg13g2_decap_8
XFILLER_53_341 VDD VSS sg13g2_decap_8
XFILLER_54_875 VDD VSS sg13g2_fill_1
XFILLER_54_59 VDD VSS sg13g2_decap_8
XFILLER_53_352 VDD VSS sg13g2_fill_2
X_07638_ _07638_/Y _14773_/Q VDD VSS sg13g2_inv_1
XFILLER_96_1399 VDD VSS sg13g2_decap_8
XFILLER_0_1072 VDD VSS sg13g2_decap_8
XFILLER_183_1358 VDD VSS sg13g2_decap_8
Xclkbuf_4_4_0_clk_i clkbuf_4_4_0_clk_i/X clkbuf_0_clk_i/X VDD VSS sg13g2_buf_8
XFILLER_41_536 VDD VSS sg13g2_decap_8
X_14935__2697 _14935_/RESET_B VDD VSS sg13g2_tiehi
XFILLER_110_43 VDD VSS sg13g2_decap_8
XFILLER_13_249 VDD VSS sg13g2_decap_8
XFILLER_167_711 VDD VSS sg13g2_decap_8
XFILLER_167_722 VDD VSS sg13g2_fill_1
XFILLER_181_1071 VDD VSS sg13g2_decap_8
X_09308_ _13915_/D _09906_/A1 _13915_/Q _09339_/S VDD VSS sg13g2_mux2_1
XFILLER_70_25 VDD VSS sg13g2_decap_8
XFILLER_16_1036 VDD VSS sg13g2_decap_8
X_10580_ _14871_/D _10580_/A _10595_/B _10580_/C VDD VSS sg13g2_nor3_1
XFILLER_186_14 VDD VSS sg13g2_decap_8
X_14338__1864 _14338_/RESET_B VDD VSS sg13g2_tiehi
XFILLER_10_945 VDD VSS sg13g2_decap_8
XFILLER_139_457 VDD VSS sg13g2_decap_8
XFILLER_166_243 VDD VSS sg13g2_decap_8
XFILLER_167_766 VDD VSS sg13g2_decap_8
Xclkbuf_leaf_6_clk_i clkload12/A clkbuf_leaf_8_clk_i/A VDD VSS sg13g2_buf_8
X_09239_ _13850_/D _10169_/A1 _13850_/Q _09239_/S VDD VSS sg13g2_mux2_1
XFILLER_155_939 VDD VSS sg13g2_decap_8
XFILLER_142_1099 VDD VSS sg13g2_decap_8
XFILLER_177_1107 VDD VSS sg13g2_decap_8
XFILLER_148_991 VDD VSS sg13g2_fill_2
XFILLER_166_287 VDD VSS sg13g2_decap_4
XFILLER_182_736 VDD VSS sg13g2_decap_8
XFILLER_181_224 VDD VSS sg13g2_decap_8
X_15210__3001 _15210_/RESET_B VDD VSS sg13g2_tiehi
X_12250_ _12250_/Y _12259_/S0 _14520_/Q _12233_/B VDD VSS sg13g2_a21oi_1
XFILLER_6_949 VDD VSS sg13g2_decap_8
XFILLER_33_1394 VDD VSS sg13g2_decap_8
XFILLER_5_448 VDD VSS sg13g2_decap_8
X_11201_ _11201_/Y _11201_/A _11201_/B VDD VSS sg13g2_nand2_1
X_12181_ _12181_/X _12181_/A _12190_/B VDD VSS sg13g2_and2_1
XFILLER_163_983 VDD VSS sg13g2_fill_1
XFILLER_29_1408 VDD VSS sg13g2_decap_8
XFILLER_68_1468 VDD VSS sg13g2_decap_8
XFILLER_122_313 VDD VSS sg13g2_decap_8
XFILLER_135_696 VDD VSS sg13g2_fill_1
XFILLER_150_633 VDD VSS sg13g2_fill_1
XFILLER_155_1438 VDD VSS sg13g2_decap_8
X_11132_ _14950_/D _11131_/Y _11130_/Y _11113_/Y VDD VSS sg13g2_o21ai_1
X_15113__2756 _15113_/RESET_B VDD VSS sg13g2_tiehi
XFILLER_150_655 VDD VSS sg13g2_fill_1
XFILLER_96_709 VDD VSS sg13g2_decap_8
XFILLER_150_666 VDD VSS sg13g2_fill_1
XFILLER_7_1204 VDD VSS sg13g2_decap_8
XFILLER_1_665 VDD VSS sg13g2_decap_8
X_11063_ _11063_/Y _11060_/X _11035_/Y _11062_/Y VDD VSS sg13g2_a21oi_1
XFILLER_150_688 VDD VSS sg13g2_decap_4
XFILLER_89_783 VDD VSS sg13g2_decap_8
XFILLER_118_1271 VDD VSS sg13g2_decap_8
Xhold3070 input5/A mem_axi_rdata[10] VDD VSS sg13g2_dlygate4sd3_1
XFILLER_0_175 VDD VSS sg13g2_decap_8
XFILLER_103_582 VDD VSS sg13g2_decap_8
XFILLER_131_891 VDD VSS sg13g2_decap_8
Xhold3081 hold3081/X input12/X VDD VSS sg13g2_dlygate4sd3_1
X_10014_ _14596_/D _10147_/A1 _14596_/Q _10030_/S VDD VSS sg13g2_mux2_1
Xhold3092 input16/A mem_axi_rdata[20] VDD VSS sg13g2_dlygate4sd3_1
XFILLER_27_1187 VDD VSS sg13g2_decap_8
XFILLER_48_135 VDD VSS sg13g2_decap_8
XFILLER_77_989 VDD VSS sg13g2_decap_4
X_14822_ _14822_/Q clkload86/A _14822_/D _14822_/RESET_B VDD VSS sg13g2_dfrbpq_1
XFILLER_92_926 VDD VSS sg13g2_decap_8
XFILLER_91_403 VDD VSS sg13g2_fill_1
XFILLER_36_308 VDD VSS sg13g2_fill_1
XFILLER_131_1460 VDD VSS sg13g2_decap_8
X_13826__2376 _13826_/RESET_B VDD VSS sg13g2_tiehi
XFILLER_91_414 VDD VSS sg13g2_fill_2
XFILLER_40_1354 VDD VSS sg13g2_decap_8
XFILLER_17_522 VDD VSS sg13g2_decap_4
X_14753_ _14753_/Q _15196_/CLK _14753_/D _14753_/RESET_B VDD VSS sg13g2_dfrbpq_1
X_11965_ _11965_/Y _11962_/Y _11964_/X _11446_/A VDD VSS sg13g2_o21ai_1
XFILLER_45_853 VDD VSS sg13g2_decap_8
XFILLER_151_94 VDD VSS sg13g2_decap_4
XFILLER_91_469 VDD VSS sg13g2_decap_8
XFILLER_17_577 VDD VSS sg13g2_decap_8
X_13704_ _16866_/A clkload55/A _13704_/D _13704_/RESET_B VDD VSS sg13g2_dfrbpq_1
X_10916_ _10920_/A _15119_/Q _10954_/A VDD VSS sg13g2_xnor2_1
X_14684_ _14684_/Q _15052_/CLK _14684_/D _14684_/RESET_B VDD VSS sg13g2_dfrbpq_1
XFILLER_162_1409 VDD VSS sg13g2_decap_8
X_11896_ _11897_/B _11896_/A _14222_/Q VDD VSS sg13g2_nand2_1
XFILLER_72_694 VDD VSS sg13g2_decap_8
XFILLER_177_508 VDD VSS sg13g2_decap_8
X_13635_ _13743_/D _13635_/A VDD VSS sg13g2_buf_1
X_10847_ _10847_/Y _10843_/Y _10846_/Y _10886_/B1 VDD VSS sg13g2_a21oi_1
XFILLER_44_81 VDD VSS sg13g2_decap_8
XFILLER_13_750 VDD VSS sg13g2_decap_8
XFILLER_38_1272 VDD VSS sg13g2_decap_8
XFILLER_32_569 VDD VSS sg13g2_decap_4
XFILLER_164_1280 VDD VSS sg13g2_decap_8
XFILLER_9_721 VDD VSS sg13g2_decap_8
X_13566_ _13566_/Y _13566_/A _13566_/B _13566_/C VDD VSS sg13g2_nor3_1
XFILLER_81_7 VDD VSS sg13g2_decap_8
XFILLER_73_1185 VDD VSS sg13g2_decap_8
XFILLER_157_232 VDD VSS sg13g2_decap_4
X_10778_ _11180_/C _14952_/Q _08943_/A _10776_/X VDD VSS sg13g2_a21o_1
XFILLER_40_580 VDD VSS sg13g2_decap_4
XFILLER_125_1286 VDD VSS sg13g2_decap_8
XFILLER_146_928 VDD VSS sg13g2_decap_8
XFILLER_157_254 VDD VSS sg13g2_decap_8
X_12517_ _12517_/X _14375_/Q _14407_/Q _14471_/Q _14503_/Q _12520_/S0 _12520_/S1 VDD
+ VSS sg13g2_mux4_1
XFILLER_8_242 VDD VSS sg13g2_decap_8
XFILLER_185_574 VDD VSS sg13g2_decap_8
XFILLER_145_416 VDD VSS sg13g2_decap_8
X_13497_ _13498_/A _13481_/A _13656_/S _15174_/D _13487_/Y VDD VSS sg13g2_a22oi_1
XFILLER_157_287 VDD VSS sg13g2_fill_1
XFILLER_160_1199 VDD VSS sg13g2_decap_8
XFILLER_9_798 VDD VSS sg13g2_decap_8
XFILLER_145_438 VDD VSS sg13g2_decap_4
XFILLER_172_224 VDD VSS sg13g2_fill_1
X_15236_ _15236_/Q clkload69/A _15236_/D _15236_/RESET_B VDD VSS sg13g2_dfrbpq_1
XFILLER_172_235 VDD VSS sg13g2_decap_4
X_12448_ _12448_/X _14690_/Q _14722_/Q _13762_/Q _13794_/Q _12450_/S0 _12450_/S1 VDD
+ VSS sg13g2_mux4_1
XFILLER_12_1467 VDD VSS sg13g2_decap_8
XFILLER_12_1478 VDD VSS sg13g2_fill_1
XFILLER_114_803 VDD VSS sg13g2_fill_2
XFILLER_125_140 VDD VSS sg13g2_decap_8
XFILLER_176_91 VDD VSS sg13g2_decap_8
X_15167_ _15167_/Q clkload86/A _15167_/D _15167_/RESET_B VDD VSS sg13g2_dfrbpq_1
X_12379_ _12379_/X _14109_/Q _14141_/Q _14173_/Q _14205_/Q _12380_/S0 _12380_/S1 VDD
+ VSS sg13g2_mux4_1
XFILLER_5_42 VDD VSS sg13g2_decap_8
XFILLER_119_1013 VDD VSS sg13g2_decap_8
XFILLER_153_471 VDD VSS sg13g2_fill_1
XFILLER_141_633 VDD VSS sg13g2_decap_8
X_14118_ _14118_/Q clkload50/A _14118_/D _14118_/RESET_B VDD VSS sg13g2_dfrbpq_1
XFILLER_114_858 VDD VSS sg13g2_decap_4
X_15098_ _15098_/Q clkload72/A _15098_/D _15098_/RESET_B VDD VSS sg13g2_dfrbpq_1
XFILLER_68_901 VDD VSS sg13g2_fill_1
XFILLER_45_1221 VDD VSS sg13g2_decap_8
X_14049_ _14049_/Q clkload6/A _14049_/D _14049_/RESET_B VDD VSS sg13g2_dfrbpq_1
XFILLER_68_934 VDD VSS sg13g2_fill_2
XFILLER_136_1382 VDD VSS sg13g2_fill_2
XFILLER_95_731 VDD VSS sg13g2_decap_4
XFILLER_140_198 VDD VSS sg13g2_decap_8
XFILLER_171_1273 VDD VSS sg13g2_decap_8
XFILLER_132_1246 VDD VSS sg13g2_fill_2
XFILLER_45_1298 VDD VSS sg13g2_decap_8
XFILLER_67_455 VDD VSS sg13g2_decap_8
XFILLER_55_606 VDD VSS sg13g2_fill_2
X_08610_ _08610_/Y _08576_/Y _08608_/Y _08643_/A VDD VSS sg13g2_a21oi_1
X_09590_ _14187_/D _14187_/Q _09590_/A1 _09590_/S VDD VSS sg13g2_mux2_1
X_14416__1786 _14416_/RESET_B VDD VSS sg13g2_tiehi
XFILLER_94_285 VDD VSS sg13g2_decap_8
XFILLER_36_820 VDD VSS sg13g2_fill_2
X_08541_ _08541_/Y _08541_/A _12009_/A _15012_/Q VDD VSS sg13g2_nand3_1
XFILLER_78_1063 VDD VSS sg13g2_decap_8
XFILLER_36_886 VDD VSS sg13g2_fill_1
XFILLER_165_1022 VDD VSS sg13g2_decap_8
X_08472_ _08472_/X _15008_/Q _08471_/B _08001_/A VDD VSS sg13g2_a21o_1
XFILLER_35_363 VDD VSS sg13g2_fill_2
XFILLER_62_160 VDD VSS sg13g2_decap_4
XFILLER_50_300 VDD VSS sg13g2_decap_8
XFILLER_39_1047 VDD VSS sg13g2_decap_8
XFILLER_90_480 VDD VSS sg13g2_decap_8
XFILLER_90_491 VDD VSS sg13g2_decap_8
XFILLER_17_1301 VDD VSS sg13g2_decap_8
X_14595__1607 _14595_/RESET_B VDD VSS sg13g2_tiehi
XFILLER_50_333 VDD VSS sg13g2_decap_8
XFILLER_51_878 VDD VSS sg13g2_fill_1
X_14631__1571 _14631_/RESET_B VDD VSS sg13g2_tiehi
XFILLER_52_1214 VDD VSS sg13g2_decap_8
XFILLER_143_1342 VDD VSS sg13g2_fill_2
XFILLER_104_1304 VDD VSS sg13g2_decap_8
XFILLER_149_755 VDD VSS sg13g2_decap_8
XFILLER_104_1315 VDD VSS sg13g2_fill_1
XFILLER_31_580 VDD VSS sg13g2_decap_4
XFILLER_109_608 VDD VSS sg13g2_fill_1
XFILLER_137_917 VDD VSS sg13g2_decap_8
XFILLER_148_243 VDD VSS sg13g2_fill_1
XFILLER_17_1378 VDD VSS sg13g2_decap_8
XFILLER_148_254 VDD VSS sg13g2_decap_8
XFILLER_104_1348 VDD VSS sg13g2_decap_8
XFILLER_143_1397 VDD VSS sg13g2_decap_8
XFILLER_163_202 VDD VSS sg13g2_decap_8
X_09024_ _09024_/X _09024_/A _09024_/B _09024_/C VDD VSS sg13g2_and3_1
XFILLER_156_28 VDD VSS sg13g2_decap_8
XFILLER_145_961 VDD VSS sg13g2_decap_8
XFILLER_145_972 VDD VSS sg13g2_fill_1
XFILLER_163_268 VDD VSS sg13g2_decap_8
X_13904__2298 _13904_/RESET_B VDD VSS sg13g2_tiehi
XFILLER_117_685 VDD VSS sg13g2_decap_8
XFILLER_145_994 VDD VSS sg13g2_decap_8
XFILLER_172_780 VDD VSS sg13g2_decap_8
XFILLER_172_1004 VDD VSS sg13g2_decap_8
XFILLER_176_1184 VDD VSS sg13g2_decap_8
XFILLER_160_964 VDD VSS sg13g2_decap_8
Xfanout700 _10203_/S _13336_/S VDD VSS sg13g2_buf_1
Xfanout711 _11964_/B fanout725/X VDD VSS sg13g2_buf_1
XFILLER_28_1441 VDD VSS sg13g2_decap_8
Xfanout722 _11822_/B _11829_/A1 VDD VSS sg13g2_buf_1
X_09926_ _14511_/D _14511_/Q _10158_/A1 _09936_/S VDD VSS sg13g2_mux2_1
Xfanout733 _12258_/C1 _07655_/Y VDD VSS sg13g2_buf_1
XFILLER_131_176 VDD VSS sg13g2_fill_1
XFILLER_154_1471 VDD VSS sg13g2_decap_4
Xfanout744 _12112_/B1 _07654_/Y VDD VSS sg13g2_buf_1
XFILLER_24_1305 VDD VSS sg13g2_decap_8
Xfanout755 _11043_/A _07753_/D VDD VSS sg13g2_buf_1
XFILLER_63_1365 VDD VSS sg13g2_decap_8
XFILLER_131_198 VDD VSS sg13g2_decap_8
Xfanout766 _08056_/B fanout767/X VDD VSS sg13g2_buf_1
XFILLER_105_43 VDD VSS sg13g2_decap_8
Xfanout777 _08063_/A _08048_/A VDD VSS sg13g2_buf_1
X_09857_ _14444_/D _14444_/Q _09989_/A0 _09859_/S VDD VSS sg13g2_mux2_1
XFILLER_19_809 VDD VSS sg13g2_fill_2
Xfanout788 _11206_/B1 _07751_/B VDD VSS sg13g2_buf_1
XFILLER_74_904 VDD VSS sg13g2_fill_2
Xfanout799 _12355_/S _15214_/Q VDD VSS sg13g2_buf_1
XFILLER_74_926 VDD VSS sg13g2_decap_8
XFILLER_105_76 VDD VSS sg13g2_decap_8
X_08808_ _13687_/D _08808_/A _08808_/B VDD VSS sg13g2_nor2_1
XFILLER_65_25 VDD VSS sg13g2_decap_4
XFILLER_58_477 VDD VSS sg13g2_decap_8
XFILLER_100_574 VDD VSS sg13g2_decap_8
XFILLER_98_1439 VDD VSS sg13g2_decap_8
X_09788_ _14377_/D _09920_/A1 _14377_/Q _09799_/S VDD VSS sg13g2_mux2_1
XFILLER_6_1292 VDD VSS sg13g2_decap_8
XFILLER_2_1134 VDD VSS sg13g2_decap_8
X_08739_ _08739_/Y _08751_/A1 _07720_/B _15197_/Q VDD VSS sg13g2_o21ai_1
XFILLER_73_458 VDD VSS sg13g2_fill_2
XFILLER_26_341 VDD VSS sg13g2_decap_8
XFILLER_57_1114 VDD VSS sg13g2_decap_8
X_15142__2696 _15142_/RESET_B VDD VSS sg13g2_tiehi
X_11750_ _11750_/Y _11741_/A _14474_/Q VDD VSS sg13g2_nand2b_1
XFILLER_27_897 VDD VSS sg13g2_fill_2
XFILLER_109_1215 VDD VSS sg13g2_decap_8
XFILLER_54_694 VDD VSS sg13g2_fill_1
XFILLER_183_1155 VDD VSS sg13g2_decap_8
XFILLER_92_1038 VDD VSS sg13g2_decap_8
XFILLER_148_1286 VDD VSS sg13g2_decap_8
X_10701_ _10923_/A _09016_/B _08873_/A _08865_/Y VDD VSS sg13g2_a21oi_1
XFILLER_81_35 VDD VSS sg13g2_decap_8
XFILLER_74_1450 VDD VSS sg13g2_decap_8
XFILLER_35_1401 VDD VSS sg13g2_decap_8
X_11681_ _11681_/Y _11692_/A _14376_/Q VDD VSS sg13g2_nand2b_1
X_13420_ _13459_/C _15199_/Q _13448_/C VDD VSS sg13g2_and2_1
X_10632_ _10633_/C _14885_/Q _14884_/Q _14883_/Q _10632_/D VDD VSS sg13g2_and4_1
XFILLER_70_1336 VDD VSS sg13g2_decap_8
XFILLER_167_541 VDD VSS sg13g2_decap_8
XFILLER_161_1464 VDD VSS sg13g2_decap_8
XFILLER_167_552 VDD VSS sg13g2_fill_2
XFILLER_10_742 VDD VSS sg13g2_decap_8
XFILLER_14_84 VDD VSS sg13g2_decap_8
XFILLER_128_928 VDD VSS sg13g2_decap_4
X_13351_ _13351_/Y _15183_/D _13351_/B _13351_/C _13351_/D VDD VSS sg13g2_nor4_1
X_10563_ _10565_/C _14866_/Q _13273_/A _14861_/Q VDD VSS sg13g2_nand3_1
XFILLER_155_725 VDD VSS sg13g2_fill_2
XFILLER_182_511 VDD VSS sg13g2_decap_8
X_12302_ _12302_/Y _12299_/Y _12300_/Y _12301_/Y VDD VSS sg13g2_o21ai_1
XFILLER_155_758 VDD VSS sg13g2_decap_8
X_13282_ _13287_/A _13282_/A1 _10671_/Y _07744_/B _07744_/C _13281_/C VDD VSS sg13g2_a221oi_1
X_10494_ _10496_/C _10513_/D _10498_/D _14852_/Q VDD VSS sg13g2_a21o_1
XFILLER_6_746 VDD VSS sg13g2_decap_8
XFILLER_33_1191 VDD VSS sg13g2_decap_8
XFILLER_182_555 VDD VSS sg13g2_decap_8
XFILLER_5_245 VDD VSS sg13g2_decap_8
X_15021_ _15021_/Q clkload87/A _15021_/D _15021_/RESET_B VDD VSS sg13g2_dfrbpq_1
X_12233_ _12237_/A _12232_/X _12233_/B VDD VSS sg13g2_nand2b_1
XFILLER_159_1360 VDD VSS sg13g2_decap_8
XFILLER_163_780 VDD VSS sg13g2_decap_8
XFILLER_182_599 VDD VSS sg13g2_decap_8
XFILLER_29_1205 VDD VSS sg13g2_decap_8
XFILLER_135_482 VDD VSS sg13g2_decap_8
XFILLER_68_1265 VDD VSS sg13g2_decap_8
XFILLER_122_110 VDD VSS sg13g2_decap_4
XFILLER_135_493 VDD VSS sg13g2_fill_2
X_12164_ _12164_/Y _12161_/Y _12163_/X _11231_/S VDD VSS sg13g2_o21ai_1
XFILLER_151_953 VDD VSS sg13g2_fill_1
XFILLER_2_952 VDD VSS sg13g2_decap_8
X_11115_ _11138_/C _11115_/A _11115_/B _11147_/A VDD VSS sg13g2_nor3_1
XFILLER_68_208 VDD VSS sg13g2_decap_8
XFILLER_1_462 VDD VSS sg13g2_decap_8
X_12095_ _12095_/Y _12100_/S0 _14580_/Q VDD VSS sg13g2_nand2b_1
XFILLER_7_1001 VDD VSS sg13g2_decap_8
XFILLER_150_496 VDD VSS sg13g2_decap_8
XFILLER_81_1454 VDD VSS sg13g2_decap_8
XFILLER_110_349 VDD VSS sg13g2_decap_8
X_14673__1529 _14673_/RESET_B VDD VSS sg13g2_tiehi
X_11046_ _11046_/Y _11046_/A _11046_/B VDD VSS sg13g2_nand2_1
XFILLER_162_60 VDD VSS sg13g2_decap_8
XFILLER_49_455 VDD VSS sg13g2_decap_8
XFILLER_7_1078 VDD VSS sg13g2_decap_8
XFILLER_76_252 VDD VSS sg13g2_decap_8
XFILLER_77_786 VDD VSS sg13g2_decap_8
XFILLER_64_403 VDD VSS sg13g2_fill_2
XFILLER_37_639 VDD VSS sg13g2_fill_1
XFILLER_18_831 VDD VSS sg13g2_decap_8
XFILLER_40_1151 VDD VSS sg13g2_decap_8
XFILLER_18_842 VDD VSS sg13g2_fill_1
X_14805_ _14805_/Q clkload85/A _14805_/D _14805_/RESET_B VDD VSS sg13g2_dfrbpq_1
XFILLER_36_138 VDD VSS sg13g2_decap_8
XFILLER_64_458 VDD VSS sg13g2_decap_8
X_12997_ _12997_/Y _12997_/A _12997_/B VDD VSS sg13g2_nand2_1
XFILLER_18_875 VDD VSS sg13g2_decap_8
Xclkbuf_leaf_107_clk_i clkload58/A clkbuf_leaf_84_clk_i/A VDD VSS sg13g2_buf_8
XFILLER_73_970 VDD VSS sg13g2_decap_8
XFILLER_45_661 VDD VSS sg13g2_decap_8
X_14736_ _14736_/Q clkload14/A _14736_/D _14736_/RESET_B VDD VSS sg13g2_dfrbpq_1
XFILLER_51_119 VDD VSS sg13g2_decap_8
X_11948_ _11948_/X _14576_/Q _14608_/Q _12090_/A VDD VSS sg13g2_mux2_1
XFILLER_166_1353 VDD VSS sg13g2_decap_8
XFILLER_60_631 VDD VSS sg13g2_decap_8
XFILLER_162_1206 VDD VSS sg13g2_decap_8
XFILLER_75_1258 VDD VSS sg13g2_decap_8
XFILLER_72_491 VDD VSS sg13g2_fill_1
X_14667_ _14667_/Q clkload13/A _14667_/D _14667_/RESET_B VDD VSS sg13g2_dfrbpq_1
X_11879_ _11879_/Y _11882_/S0 _14638_/Q VDD VSS sg13g2_nand2b_1
XFILLER_177_349 VDD VSS sg13g2_decap_4
X_13618_ _13726_/D _13618_/A VDD VSS sg13g2_buf_1
XFILLER_38_1091 VDD VSS sg13g2_decap_8
XFILLER_158_541 VDD VSS sg13g2_fill_1
X_14598_ _14598_/Q clkload52/A _14598_/D _14598_/RESET_B VDD VSS sg13g2_dfrbpq_1
XFILLER_186_861 VDD VSS sg13g2_decap_8
XFILLER_125_1072 VDD VSS sg13g2_fill_1
XFILLER_173_500 VDD VSS sg13g2_decap_8
X_13549_ _13549_/Y _15005_/Q _13566_/B _13552_/C VDD VSS sg13g2_nor3_1
XFILLER_185_371 VDD VSS sg13g2_decap_8
XFILLER_9_595 VDD VSS sg13g2_decap_8
XFILLER_134_909 VDD VSS sg13g2_decap_8
XFILLER_69_1029 VDD VSS sg13g2_decap_8
XFILLER_51_1291 VDD VSS sg13g2_decap_8
XFILLER_12_1264 VDD VSS sg13g2_decap_8
XFILLER_161_728 VDD VSS sg13g2_decap_8
X_15219_ _15219_/Q clkload63/A _15219_/D _15219_/RESET_B VDD VSS sg13g2_dfrbpq_1
XFILLER_142_931 VDD VSS sg13g2_decap_8
XFILLER_173_1302 VDD VSS sg13g2_decap_8
XFILLER_47_1305 VDD VSS sg13g2_decap_8
Xclkbuf_5_4__f_clk_i clkbuf_5_4__f_clk_i/X clkbuf_4_2_0_clk_i/X VDD VSS sg13g2_buf_16
XFILLER_82_1218 VDD VSS sg13g2_decap_8
XFILLER_99_355 VDD VSS sg13g2_decap_8
XFILLER_86_1398 VDD VSS sg13g2_decap_8
XFILLER_138_1477 VDD VSS sg13g2_fill_2
XFILLER_113_154 VDD VSS sg13g2_decap_8
XFILLER_102_839 VDD VSS sg13g2_decap_8
XFILLER_141_485 VDD VSS sg13g2_decap_8
XFILLER_173_1379 VDD VSS sg13g2_decap_8
X_07972_ _08663_/A _15017_/Q _12203_/A VDD VSS sg13g2_nand2b_1
XFILLER_113_187 VDD VSS sg13g2_fill_1
X_09711_ _14302_/D _09744_/A1 _14302_/Q _09725_/S VDD VSS sg13g2_mux2_1
XFILLER_132_1021 VDD VSS sg13g2_decap_8
XFILLER_142_19 VDD VSS sg13g2_decap_8
X_14649__1553 _14649_/RESET_B VDD VSS sg13g2_tiehi
XFILLER_110_872 VDD VSS sg13g2_decap_4
X_09642_ _14235_/D _10071_/A0 _14235_/Q _09673_/S VDD VSS sg13g2_mux2_1
XFILLER_23_1360 VDD VSS sg13g2_decap_8
XFILLER_3_1432 VDD VSS sg13g2_decap_8
XFILLER_83_756 VDD VSS sg13g2_fill_1
X_09573_ _09573_/X _10037_/A _10037_/B _09606_/C VDD VSS sg13g2_and3_1
XFILLER_71_918 VDD VSS sg13g2_decap_8
XFILLER_83_789 VDD VSS sg13g2_fill_1
XFILLER_97_1472 VDD VSS sg13g2_decap_8
XFILLER_64_970 VDD VSS sg13g2_decap_8
X_08524_ _08524_/Y _08548_/B _08275_/B _08523_/Y VDD VSS sg13g2_o21ai_1
XFILLER_58_1434 VDD VSS sg13g2_decap_8
XFILLER_24_812 VDD VSS sg13g2_decap_4
XFILLER_82_288 VDD VSS sg13g2_decap_8
XFILLER_24_823 VDD VSS sg13g2_decap_8
XFILLER_145_1404 VDD VSS sg13g2_decap_8
XFILLER_184_1464 VDD VSS sg13g2_decap_4
XFILLER_63_491 VDD VSS sg13g2_decap_8
XFILLER_19_1429 VDD VSS sg13g2_decap_8
XFILLER_58_1478 VDD VSS sg13g2_fill_1
XFILLER_51_642 VDD VSS sg13g2_fill_1
X_08455_ _08461_/B _08456_/C _08493_/B2 _08454_/X VDD VSS sg13g2_o21ai_1
XFILLER_168_316 VDD VSS sg13g2_fill_1
XFILLER_24_878 VDD VSS sg13g2_decap_8
X_15017__2593 _15017_/RESET_B VDD VSS sg13g2_tiehi
Xclkbuf_leaf_71_clk_i clkload90/A clkbuf_leaf_71_clk_i/A VDD VSS sg13g2_buf_8
XFILLER_50_163 VDD VSS sg13g2_fill_1
X_15084__2848 _15084_/RESET_B VDD VSS sg13g2_tiehi
X_08386_ _08386_/Y _08412_/B _08385_/Y _08381_/Y VDD VSS sg13g2_o21ai_1
XFILLER_51_697 VDD VSS sg13g2_decap_8
XFILLER_52_1033 VDD VSS sg13g2_decap_8
XFILLER_137_703 VDD VSS sg13g2_decap_8
XFILLER_177_883 VDD VSS sg13g2_decap_8
XFILLER_17_1175 VDD VSS sg13g2_decap_8
XFILLER_183_319 VDD VSS sg13g2_decap_8
XFILLER_104_1134 VDD VSS sg13g2_fill_1
XFILLER_129_7 VDD VSS sg13g2_fill_1
XFILLER_52_1088 VDD VSS sg13g2_decap_8
XFILLER_136_224 VDD VSS sg13g2_fill_1
XFILLER_176_393 VDD VSS sg13g2_decap_4
Xclkbuf_leaf_86_clk_i _14930_/CLK clkbuf_leaf_94_clk_i/A VDD VSS sg13g2_buf_8
XFILLER_30_1342 VDD VSS sg13g2_decap_8
XFILLER_178_1257 VDD VSS sg13g2_decap_8
X_09007_ _09007_/X _09031_/A _09003_/X _09006_/Y VDD VSS sg13g2_a21o_1
XFILLER_136_279 VDD VSS sg13g2_fill_2
XFILLER_105_644 VDD VSS sg13g2_fill_1
XFILLER_132_430 VDD VSS sg13g2_decap_4
XFILLER_65_1438 VDD VSS sg13g2_decap_8
XFILLER_105_666 VDD VSS sg13g2_decap_8
XFILLER_2_259 VDD VSS sg13g2_decap_8
XFILLER_59_720 VDD VSS sg13g2_decap_8
XFILLER_116_64 VDD VSS sg13g2_decap_4
Xfanout530 _12651_/A2 _12777_/A2 VDD VSS sg13g2_buf_1
Xfanout541 _09742_/A1 _10105_/A VDD VSS sg13g2_buf_1
XFILLER_116_86 VDD VSS sg13g2_decap_8
Xfanout552 _09024_/A _09162_/A VDD VSS sg13g2_buf_1
X_09909_ _14494_/D _14494_/Q _09909_/A1 _09921_/S VDD VSS sg13g2_mux2_1
XFILLER_76_35 VDD VSS sg13g2_decap_8
XFILLER_63_1162 VDD VSS sg13g2_decap_8
Xfanout563 _08752_/B _13388_/B VDD VSS sg13g2_buf_1
Xfanout574 _13264_/B1 _13272_/B1 VDD VSS sg13g2_buf_1
XFILLER_93_509 VDD VSS sg13g2_decap_4
XFILLER_8_1376 VDD VSS sg13g2_decap_8
Xfanout585 _13569_/S _13561_/S VDD VSS sg13g2_buf_1
XFILLER_98_1203 VDD VSS sg13g2_decap_8
XFILLER_4_1218 VDD VSS sg13g2_decap_8
X_12920_ _12921_/B _12983_/A1 _12933_/A _12910_/Y _12878_/D _12919_/Y VDD VSS sg13g2_a221oi_1
Xfanout596 _10929_/B _11001_/B VDD VSS sg13g2_buf_1
XFILLER_86_572 VDD VSS sg13g2_decap_8
XFILLER_76_79 VDD VSS sg13g2_fill_1
XFILLER_18_116 VDD VSS sg13g2_decap_8
XFILLER_24_1179 VDD VSS sg13g2_decap_8
XFILLER_111_1138 VDD VSS sg13g2_fill_2
XFILLER_132_30 VDD VSS sg13g2_fill_2
Xclkbuf_leaf_24_clk_i clkload33/A clkbuf_leaf_28_clk_i/A VDD VSS sg13g2_buf_8
XFILLER_41_1460 VDD VSS sg13g2_decap_8
XFILLER_74_756 VDD VSS sg13g2_fill_2
X_12851_ _12851_/Y _14802_/Q _12851_/B VDD VSS sg13g2_nand2_1
XFILLER_74_789 VDD VSS sg13g2_decap_8
X_11802_ _11806_/A _11801_/X _11802_/B VDD VSS sg13g2_nand2b_1
XFILLER_73_277 VDD VSS sg13g2_decap_8
X_12782_ _12782_/X _14394_/Q _14426_/Q _14490_/Q _14522_/Q _12787_/S0 _12787_/S1 VDD
+ VSS sg13g2_mux4_1
X_14521_ _14521_/Q _14745_/CLK _14521_/D _14521_/RESET_B VDD VSS sg13g2_dfrbpq_1
XFILLER_92_89 VDD VSS sg13g2_decap_8
X_11733_ _11733_/Y _11759_/A _14218_/Q _11967_/B VDD VSS sg13g2_a21oi_1
Xclkbuf_leaf_39_clk_i _14745_/CLK clkbuf_leaf_42_clk_i/A VDD VSS sg13g2_buf_8
XFILLER_70_973 VDD VSS sg13g2_decap_4
XFILLER_159_338 VDD VSS sg13g2_decap_8
X_14087__2115 _14087_/RESET_B VDD VSS sg13g2_tiehi
X_14452_ _14452_/Q _15005_/CLK _14452_/D _14452_/RESET_B VDD VSS sg13g2_dfrbpq_1
X_11664_ _11664_/Y _11664_/A _11664_/B VDD VSS sg13g2_nor2_1
XFILLER_161_1261 VDD VSS sg13g2_decap_8
XFILLER_186_168 VDD VSS sg13g2_decap_8
X_13403_ _13403_/Y _13437_/A _13407_/B _15089_/Q VDD VSS sg13g2_nand3_1
X_10615_ _10615_/Y _10614_/A _10614_/B _10626_/B VDD VSS sg13g2_o21ai_1
XFILLER_35_1275 VDD VSS sg13g2_decap_8
XFILLER_126_1392 VDD VSS sg13g2_decap_8
X_14383_ _14383_/Q clkload38/A _14383_/D _14383_/RESET_B VDD VSS sg13g2_dfrbpq_1
X_11595_ _11599_/A _11594_/X _11802_/B VDD VSS sg13g2_nand2b_1
XFILLER_31_1139 VDD VSS sg13g2_decap_8
X_13334_ _15169_/D hold3059/X _15169_/Q _13340_/S VDD VSS sg13g2_mux2_1
XFILLER_182_330 VDD VSS sg13g2_fill_2
X_10546_ _10561_/A _14864_/Q _14863_/Q VDD VSS sg13g2_nand2_1
XFILLER_109_950 VDD VSS sg13g2_fill_1
XFILLER_127_246 VDD VSS sg13g2_fill_2
XFILLER_155_555 VDD VSS sg13g2_decap_4
X_14727__1475 _14727_/RESET_B VDD VSS sg13g2_tiehi
XFILLER_6_543 VDD VSS sg13g2_decap_8
XFILLER_157_60 VDD VSS sg13g2_decap_8
XFILLER_157_1308 VDD VSS sg13g2_decap_8
XFILLER_170_514 VDD VSS sg13g2_fill_1
XFILLER_143_739 VDD VSS sg13g2_decap_8
X_13265_ _13266_/B _13265_/A1 _13264_/X _13259_/Y _13307_/A _13263_/Y VDD VSS sg13g2_a221oi_1
X_10477_ _10489_/D _14847_/Q _10504_/C _10477_/C VDD VSS sg13g2_and3_1
XFILLER_182_396 VDD VSS sg13g2_decap_8
X_15004_ _15004_/Q _15230_/CLK _15004_/D _15004_/RESET_B VDD VSS sg13g2_dfrbpq_1
XFILLER_108_493 VDD VSS sg13g2_decap_8
X_12216_ _12216_/X _12211_/X _12212_/X _12253_/B VDD VSS sg13g2_mux2_1
XFILLER_68_1073 VDD VSS sg13g2_fill_1
XFILLER_44_7 VDD VSS sg13g2_decap_8
X_13196_ _13196_/Y _13196_/A _13196_/B _13196_/C VDD VSS sg13g2_nand3_1
XFILLER_123_463 VDD VSS sg13g2_decap_8
XFILLER_151_772 VDD VSS sg13g2_decap_8
XFILLER_69_517 VDD VSS sg13g2_decap_8
XFILLER_151_783 VDD VSS sg13g2_fill_1
X_12147_ _12147_/Y _12145_/Y _12146_/Y _12126_/A VDD VSS sg13g2_a21oi_1
XFILLER_173_70 VDD VSS sg13g2_decap_8
XFILLER_81_1251 VDD VSS sg13g2_decap_8
XFILLER_155_1098 VDD VSS sg13g2_decap_8
XFILLER_2_21 VDD VSS sg13g2_decap_8
XFILLER_133_1341 VDD VSS sg13g2_decap_8
X_12078_ _12078_/Y _11330_/S _12076_/X _12077_/Y VDD VSS sg13g2_o21ai_1
XFILLER_46_1393 VDD VSS sg13g2_decap_8
X_14876__2815 _14876_/RESET_B VDD VSS sg13g2_tiehi
XFILLER_110_179 VDD VSS sg13g2_fill_1
X_11029_ _11029_/Y _11029_/A _11029_/B _11044_/C VDD VSS sg13g2_nand3_1
XFILLER_65_723 VDD VSS sg13g2_decap_4
XFILLER_42_1268 VDD VSS sg13g2_decap_8
XFILLER_92_531 VDD VSS sg13g2_decap_8
XFILLER_49_296 VDD VSS sg13g2_decap_4
XFILLER_37_436 VDD VSS sg13g2_fill_2
XFILLER_2_98 VDD VSS sg13g2_decap_8
XFILLER_168_1426 VDD VSS sg13g2_decap_8
X_14297__1905 _14297_/RESET_B VDD VSS sg13g2_tiehi
XFILLER_80_704 VDD VSS sg13g2_decap_8
XFILLER_65_789 VDD VSS sg13g2_decap_8
XFILLER_24_108 VDD VSS sg13g2_decap_8
XFILLER_92_597 VDD VSS sg13g2_fill_1
XFILLER_80_737 VDD VSS sg13g2_decap_8
XFILLER_18_683 VDD VSS sg13g2_decap_8
XFILLER_75_1011 VDD VSS sg13g2_decap_8
XFILLER_18_694 VDD VSS sg13g2_fill_2
XFILLER_166_1150 VDD VSS sg13g2_decap_8
X_14719_ _14719_/Q clkload61/A _14719_/D _14719_/RESET_B VDD VSS sg13g2_dfrbpq_1
XFILLER_32_130 VDD VSS sg13g2_fill_1
XFILLER_177_102 VDD VSS sg13g2_decap_8
X_08240_ _08240_/Y _08539_/B1 _08237_/Y _08239_/Y VDD VSS sg13g2_o21ai_1
XFILLER_75_1088 VDD VSS sg13g2_decap_4
XFILLER_20_314 VDD VSS sg13g2_decap_8
XANTENNA_15 _07658_/X VDD VSS sg13g2_antennanp
XANTENNA_26 _12338_/A2 VDD VSS sg13g2_antennanp
XFILLER_127_1189 VDD VSS sg13g2_decap_8
XFILLER_18_1462 VDD VSS sg13g2_decap_8
XFILLER_53_1342 VDD VSS sg13g2_decap_8
XFILLER_18_1473 VDD VSS sg13g2_fill_2
X_08171_ _08171_/X _07893_/B _07630_/A _07910_/B _08215_/A3 _08023_/A _13553_/A1 VDD
+ VSS sg13g2_mux4_1
XFILLER_105_1443 VDD VSS sg13g2_decap_8
XFILLER_146_522 VDD VSS sg13g2_fill_2
XFILLER_70_0 VDD VSS sg13g2_decap_8
XFILLER_119_758 VDD VSS sg13g2_decap_8
XFILLER_14_1359 VDD VSS sg13g2_decap_8
XFILLER_140_1367 VDD VSS sg13g2_decap_8
XFILLER_9_392 VDD VSS sg13g2_decap_8
XFILLER_146_577 VDD VSS sg13g2_decap_8
XFILLER_173_363 VDD VSS sg13g2_fill_1
XFILLER_12_1061 VDD VSS sg13g2_decap_8
XFILLER_173_374 VDD VSS sg13g2_decap_8
XFILLER_175_1419 VDD VSS sg13g2_decap_8
XFILLER_134_739 VDD VSS sg13g2_decap_8
Xoutput100 mem_axi_awaddr[9] _16862_/X VDD VSS sg13g2_buf_1
Xoutput111 mem_axi_wdata[16] _15148_/Q VDD VSS sg13g2_buf_1
X_13785__2417 _13785_/RESET_B VDD VSS sg13g2_tiehi
Xoutput122 mem_axi_wdata[26] _15158_/Q VDD VSS sg13g2_buf_1
XFILLER_115_942 VDD VSS sg13g2_fill_1
Xoutput133 mem_axi_wdata[7] _15139_/Q VDD VSS sg13g2_buf_1
XFILLER_86_1162 VDD VSS sg13g2_decap_8
X_13821__2381 _13821_/RESET_B VDD VSS sg13g2_tiehi
XFILLER_82_1015 VDD VSS sg13g2_decap_8
XFILLER_88_815 VDD VSS sg13g2_decap_8
XFILLER_130_912 VDD VSS sg13g2_fill_1
XFILLER_142_783 VDD VSS sg13g2_decap_8
XFILLER_153_18 VDD VSS sg13g2_decap_8
XFILLER_102_636 VDD VSS sg13g2_decap_8
XFILLER_173_1176 VDD VSS sg13g2_decap_8
XFILLER_47_1179 VDD VSS sg13g2_decap_8
XFILLER_99_196 VDD VSS sg13g2_decap_8
XFILLER_25_1411 VDD VSS sg13g2_decap_8
XFILLER_101_124 VDD VSS sg13g2_decap_8
XFILLER_130_956 VDD VSS sg13g2_fill_2
XFILLER_101_135 VDD VSS sg13g2_fill_2
X_07955_ _07958_/B _15012_/Q _12009_/A VDD VSS sg13g2_nand2b_1
XFILLER_101_157 VDD VSS sg13g2_decap_8
XFILLER_112_1403 VDD VSS sg13g2_decap_4
X_14165__2037 _14165_/RESET_B VDD VSS sg13g2_tiehi
XFILLER_60_1357 VDD VSS sg13g2_decap_8
X_07886_ _07924_/C _08219_/A _13545_/A VDD VSS sg13g2_xor2_1
XFILLER_29_959 VDD VSS sg13g2_decap_8
X_09625_ _14221_/D _10023_/A0 _14221_/Q _09632_/S VDD VSS sg13g2_mux2_1
XFILLER_56_767 VDD VSS sg13g2_decap_8
XFILLER_83_564 VDD VSS sg13g2_fill_1
XFILLER_15_119 VDD VSS sg13g2_decap_8
XFILLER_37_981 VDD VSS sg13g2_fill_1
X_09556_ _14154_/D _09921_/A1 _14154_/Q _09556_/S VDD VSS sg13g2_mux2_1
XFILLER_83_597 VDD VSS sg13g2_decap_8
XFILLER_71_748 VDD VSS sg13g2_decap_8
XFILLER_58_1231 VDD VSS sg13g2_decap_8
XFILLER_55_299 VDD VSS sg13g2_decap_8
XFILLER_93_1122 VDD VSS sg13g2_decap_8
XFILLER_184_1261 VDD VSS sg13g2_decap_8
X_08507_ _08507_/Y _07818_/Y _08506_/Y _08039_/A VDD VSS sg13g2_a21oi_1
XFILLER_24_642 VDD VSS sg13g2_decap_8
XFILLER_145_1223 VDD VSS sg13g2_decap_8
XFILLER_19_1226 VDD VSS sg13g2_decap_8
X_09487_ _14087_/D _10083_/A0 _14087_/Q _09493_/S VDD VSS sg13g2_mux2_1
XFILLER_70_269 VDD VSS sg13g2_decap_8
XFILLER_169_636 VDD VSS sg13g2_decap_8
XFILLER_24_675 VDD VSS sg13g2_decap_8
XFILLER_12_837 VDD VSS sg13g2_decap_8
XFILLER_180_1147 VDD VSS sg13g2_decap_8
XFILLER_23_174 VDD VSS sg13g2_decap_8
X_08438_ _08438_/Y _08436_/Y _08437_/Y _08391_/A _08435_/Y VDD VSS sg13g2_a22oi_1
XFILLER_11_347 VDD VSS sg13g2_decap_8
XFILLER_71_1453 VDD VSS sg13g2_decap_8
XFILLER_183_116 VDD VSS sg13g2_decap_8
X_08369_ _08389_/B _08369_/A _08369_/B VDD VSS sg13g2_nand2_1
XFILLER_149_371 VDD VSS sg13g2_decap_4
XFILLER_7_329 VDD VSS sg13g2_decap_8
XFILLER_137_522 VDD VSS sg13g2_fill_1
XFILLER_177_691 VDD VSS sg13g2_fill_1
XFILLER_109_224 VDD VSS sg13g2_decap_8
X_14972__2638 _14972_/RESET_B VDD VSS sg13g2_tiehi
X_10400_ _10400_/Y _10400_/A _10400_/B _10400_/C _10400_/D VDD VSS sg13g2_nor4_1
X_11380_ _11380_/Y _11360_/Y _11361_/Y _11379_/Y VDD VSS sg13g2_o21ai_1
XFILLER_164_374 VDD VSS sg13g2_fill_1
X_10331_ _14803_/D _10331_/A _10331_/B _10337_/C VDD VSS sg13g2_and3_1
XFILLER_106_920 VDD VSS sg13g2_decap_8
XFILLER_118_791 VDD VSS sg13g2_decap_8
XFILLER_69_1360 VDD VSS sg13g2_decap_8
XFILLER_11_74 VDD VSS sg13g2_decap_8
X_13050_ _13050_/X _15062_/Q _15061_/Q _13050_/C VDD VSS sg13g2_or3_1
X_14375__1827 _14375_/RESET_B VDD VSS sg13g2_tiehi
X_10262_ _10262_/Y _10265_/B _10262_/B VDD VSS sg13g2_nor2_1
XFILLER_3_557 VDD VSS sg13g2_decap_8
XFILLER_105_452 VDD VSS sg13g2_decap_8
XFILLER_106_975 VDD VSS sg13g2_decap_8
XFILLER_65_1235 VDD VSS sg13g2_decap_8
X_14411__1791 _14411_/RESET_B VDD VSS sg13g2_tiehi
X_12001_ _12001_/Y _12223_/A _12001_/B VDD VSS sg13g2_nor2_1
XFILLER_79_837 VDD VSS sg13g2_fill_2
X_10193_ _15197_/D input24/X _15197_/Q _10203_/S VDD VSS sg13g2_mux2_1
XFILLER_120_411 VDD VSS sg13g2_fill_1
XFILLER_133_794 VDD VSS sg13g2_decap_8
XFILLER_156_1385 VDD VSS sg13g2_decap_8
X_15040__2568 _15040_/RESET_B VDD VSS sg13g2_tiehi
Xpicorv32_macro_1443 mem_axi_awprot[0] VDD VSS sg13g2_tielo
Xfanout1303 _12072_/S1 _12038_/B1 VDD VSS sg13g2_buf_1
Xfanout1314 _11282_/S1 _12187_/C VDD VSS sg13g2_buf_1
Xfanout1325 _11514_/S0 fanout1329/X VDD VSS sg13g2_buf_1
Xfanout1336 _11715_/S0 fanout1339/X VDD VSS sg13g2_buf_1
Xfanout1347 _11741_/A fanout1351/X VDD VSS sg13g2_buf_1
XFILLER_120_466 VDD VSS sg13g2_fill_1
Xfanout360 _09500_/S fanout364/X VDD VSS sg13g2_buf_1
Xfanout1358 _11373_/A _11821_/S0 VDD VSS sg13g2_buf_1
Xfanout371 _09300_/S _09292_/S VDD VSS sg13g2_buf_1
Xfanout1369 _12072_/S0 fanout1371/X VDD VSS sg13g2_buf_1
XFILLER_8_1173 VDD VSS sg13g2_decap_8
Xfanout382 _09196_/S _09170_/Y VDD VSS sg13g2_buf_1
XFILLER_4_1015 VDD VSS sg13g2_decap_8
X_13952_ _13952_/Q _14528_/CLK _13952_/D _13952_/RESET_B VDD VSS sg13g2_dfrbpq_1
Xfanout393 _10145_/A1 _09913_/A1 VDD VSS sg13g2_buf_1
XFILLER_120_499 VDD VSS sg13g2_decap_8
XFILLER_143_73 VDD VSS sg13g2_decap_4
XFILLER_19_425 VDD VSS sg13g2_decap_8
X_14590__1612 _14590_/RESET_B VDD VSS sg13g2_tiehi
XFILLER_98_1011 VDD VSS sg13g2_fill_1
XFILLER_74_520 VDD VSS sg13g2_decap_8
XFILLER_47_745 VDD VSS sg13g2_decap_8
X_12903_ _12904_/B _12983_/A1 _12902_/Y _12894_/X _12878_/D _12898_/Y VDD VSS sg13g2_a221oi_1
X_13883_ _13883_/Q _14491_/CLK _13883_/D _13883_/RESET_B VDD VSS sg13g2_dfrbpq_1
XFILLER_35_918 VDD VSS sg13g2_decap_8
XFILLER_47_789 VDD VSS sg13g2_fill_1
XFILLER_98_1088 VDD VSS sg13g2_fill_2
XFILLER_185_1047 VDD VSS sg13g2_decap_8
X_12834_ _12834_/Y _12835_/A _13691_/Q VDD VSS sg13g2_nor2_1
XFILLER_62_737 VDD VSS sg13g2_fill_2
XFILLER_76_1331 VDD VSS sg13g2_decap_8
XFILLER_128_1410 VDD VSS sg13g2_fill_2
XFILLER_61_236 VDD VSS sg13g2_decap_8
XFILLER_37_1315 VDD VSS sg13g2_decap_8
X_12765_ _12778_/A _13400_/B _12779_/A2 _15019_/Q VDD VSS sg13g2_a21oi_1
X_13863__2339 _13863_/RESET_B VDD VSS sg13g2_tiehi
XFILLER_163_1345 VDD VSS sg13g2_decap_8
X_14504_ _14504_/Q clkload20/A _14504_/D _14504_/RESET_B VDD VSS sg13g2_dfrbpq_1
XFILLER_43_995 VDD VSS sg13g2_decap_8
XFILLER_42_472 VDD VSS sg13g2_decap_8
XFILLER_30_612 VDD VSS sg13g2_decap_8
XFILLER_159_135 VDD VSS sg13g2_decap_8
X_11716_ _11717_/B _11708_/X _11709_/X _11712_/X _11713_/X _12101_/B _12118_/C VDD
+ VSS sg13g2_mux4_1
XFILLER_148_809 VDD VSS sg13g2_fill_1
X_12696_ _12696_/X _14132_/Q _14164_/Q _14196_/Q _14228_/Q _12699_/S0 _12699_/S1 VDD
+ VSS sg13g2_mux4_1
XFILLER_174_105 VDD VSS sg13g2_decap_8
X_14435_ _14435_/Q _14723_/CLK _14435_/D _14435_/RESET_B VDD VSS sg13g2_dfrbpq_1
X_11647_ _11647_/X _13735_/Q _14087_/Q _14439_/Q _14535_/Q _11649_/S0 _11649_/S1 VDD
+ VSS sg13g2_mux4_1
XFILLER_52_81 VDD VSS sg13g2_decap_4
XFILLER_161_1080 VDD VSS sg13g2_decap_8
Xinput13 input13/X input13/A VDD VSS sg13g2_buf_1
XFILLER_11_881 VDD VSS sg13g2_fill_2
XFILLER_128_533 VDD VSS sg13g2_decap_8
XFILLER_156_842 VDD VSS sg13g2_decap_4
XFILLER_161_1091 VDD VSS sg13g2_fill_2
XFILLER_168_70 VDD VSS sg13g2_decap_8
Xinput24 input24/X input24/A VDD VSS sg13g2_buf_1
X_14366_ _14366_/Q _14526_/CLK _14366_/D _14366_/RESET_B VDD VSS sg13g2_dfrbpq_1
Xinput35 input35/X input35/A VDD VSS sg13g2_buf_1
X_11578_ _11578_/X _13957_/Q _13989_/Q _14021_/Q _14053_/Q _11580_/S0 _11580_/S1 VDD
+ VSS sg13g2_mux4_1
XFILLER_116_706 VDD VSS sg13g2_decap_8
XFILLER_183_672 VDD VSS sg13g2_decap_8
XFILLER_6_340 VDD VSS sg13g2_decap_8
X_13317_ _15062_/D _15078_/Q _07694_/Y _13316_/X VDD VSS sg13g2_a21o_1
XFILLER_155_374 VDD VSS sg13g2_decap_8
X_10529_ _14858_/D _10529_/A _10529_/B _10626_/B VDD VSS sg13g2_and3_1
XFILLER_115_216 VDD VSS sg13g2_decap_8
XFILLER_157_1116 VDD VSS sg13g2_fill_1
X_14297_ _14297_/Q _14745_/CLK _14297_/D _14297_/RESET_B VDD VSS sg13g2_dfrbpq_1
XFILLER_7_896 VDD VSS sg13g2_decap_8
XFILLER_157_1127 VDD VSS sg13g2_decap_8
XFILLER_171_856 VDD VSS sg13g2_decap_8
XFILLER_182_193 VDD VSS sg13g2_decap_8
Xclkbuf_5_22__f_clk_i clkbuf_leaf_90_clk_i/A clkbuf_4_11_0_clk_i/X VDD VSS sg13g2_buf_16
XFILLER_170_344 VDD VSS sg13g2_fill_1
X_13248_ _13251_/A _14796_/Q _13248_/B VDD VSS sg13g2_nand2_1
XFILLER_48_1433 VDD VSS sg13g2_decap_8
XFILLER_174_1441 VDD VSS sg13g2_decap_8
XFILLER_130_208 VDD VSS sg13g2_decap_8
XFILLER_130_219 VDD VSS sg13g2_fill_1
XFILLER_170_1305 VDD VSS sg13g2_decap_8
XFILLER_123_271 VDD VSS sg13g2_decap_8
XFILLER_170_399 VDD VSS sg13g2_fill_1
X_13179_ _13179_/Y _14855_/Q _13234_/B VDD VSS sg13g2_nand2_1
XFILLER_69_325 VDD VSS sg13g2_fill_1
XFILLER_83_1368 VDD VSS sg13g2_decap_8
XFILLER_44_1319 VDD VSS sg13g2_decap_8
XFILLER_135_1447 VDD VSS sg13g2_decap_8
XFILLER_111_433 VDD VSS sg13g2_fill_1
XFILLER_85_807 VDD VSS sg13g2_fill_2
XFILLER_46_1190 VDD VSS sg13g2_decap_8
XFILLER_38_701 VDD VSS sg13g2_decap_8
XFILLER_84_317 VDD VSS sg13g2_decap_8
XFILLER_133_1160 VDD VSS sg13g2_fill_2
X_07740_ _07740_/Y _07740_/A _13289_/C VDD VSS sg13g2_nand2_1
XFILLER_84_339 VDD VSS sg13g2_fill_2
XFILLER_38_756 VDD VSS sg13g2_decap_8
XFILLER_168_1223 VDD VSS sg13g2_decap_8
X_07671_ _13281_/C _07665_/X _07670_/Y _07667_/Y VDD VSS sg13g2_a21oi_1
X_16869_ _16869_/X _16869_/A VDD VSS sg13g2_buf_1
XFILLER_25_406 VDD VSS sg13g2_decap_4
X_09410_ _14012_/D _09841_/A1 _14012_/Q _09440_/S VDD VSS sg13g2_mux2_1
XFILLER_52_203 VDD VSS sg13g2_decap_8
XFILLER_65_597 VDD VSS sg13g2_decap_8
XFILLER_53_737 VDD VSS sg13g2_decap_8
XFILLER_25_428 VDD VSS sg13g2_decap_8
XFILLER_0_1457 VDD VSS sg13g2_decap_8
XFILLER_80_545 VDD VSS sg13g2_fill_2
XFILLER_179_912 VDD VSS sg13g2_decap_8
XFILLER_20_1396 VDD VSS sg13g2_decap_8
X_09341_ _09441_/D _10037_/A _09606_/C VDD VSS sg13g2_nor2b_1
XFILLER_40_409 VDD VSS sg13g2_decap_8
XFILLER_55_1426 VDD VSS sg13g2_decap_8
XFILLER_90_1317 VDD VSS sg13g2_fill_2
X_14453__1749 _14453_/RESET_B VDD VSS sg13g2_tiehi
XFILLER_178_444 VDD VSS sg13g2_decap_8
XFILLER_181_1456 VDD VSS sg13g2_decap_8
X_13839__2363 _13839_/RESET_B VDD VSS sg13g2_tiehi
X_09272_ _13881_/D _13881_/Q _10168_/A1 _09272_/S VDD VSS sg13g2_mux2_1
XFILLER_166_628 VDD VSS sg13g2_fill_1
XFILLER_20_133 VDD VSS sg13g2_decap_8
X_08223_ _08223_/X _08119_/X _08128_/X _08428_/S VDD VSS sg13g2_mux2_1
XFILLER_165_116 VDD VSS sg13g2_decap_8
XFILLER_20_166 VDD VSS sg13g2_decap_8
XFILLER_140_1131 VDD VSS sg13g2_fill_2
XFILLER_147_842 VDD VSS sg13g2_decap_8
XFILLER_20_177 VDD VSS sg13g2_fill_1
XFILLER_14_1156 VDD VSS sg13g2_decap_8
XFILLER_181_609 VDD VSS sg13g2_decap_8
XFILLER_20_188 VDD VSS sg13g2_fill_2
X_08154_ _08154_/Y _08270_/B _08174_/A _08600_/B _08484_/C VDD VSS sg13g2_nor4_1
XFILLER_179_1330 VDD VSS sg13g2_decap_8
XFILLER_107_706 VDD VSS sg13g2_decap_4
XFILLER_119_566 VDD VSS sg13g2_fill_2
XFILLER_180_119 VDD VSS sg13g2_decap_8
XFILLER_146_374 VDD VSS sg13g2_decap_8
X_08085_ _08270_/C _08085_/A _08194_/B VDD VSS sg13g2_nand2_1
XFILLER_175_1216 VDD VSS sg13g2_decap_8
XFILLER_49_1219 VDD VSS sg13g2_decap_8
XFILLER_161_322 VDD VSS sg13g2_decap_8
XFILLER_162_856 VDD VSS sg13g2_decap_8
XFILLER_173_182 VDD VSS sg13g2_fill_2
XFILLER_164_28 VDD VSS sg13g2_decap_8
XFILLER_161_366 VDD VSS sg13g2_decap_8
XFILLER_114_260 VDD VSS sg13g2_decap_4
XFILLER_115_794 VDD VSS sg13g2_fill_2
XFILLER_87_133 VDD VSS sg13g2_decap_8
XFILLER_102_466 VDD VSS sg13g2_fill_2
X_08987_ _08988_/C _12859_/A _10681_/A _10674_/A VDD VSS sg13g2_and3_1
XFILLER_69_870 VDD VSS sg13g2_decap_8
XFILLER_60_1121 VDD VSS sg13g2_fill_2
XFILLER_5_1302 VDD VSS sg13g2_decap_8
X_07938_ _07938_/Y _07797_/D _07935_/Y _07937_/Y VDD VSS sg13g2_o21ai_1
XFILLER_180_49 VDD VSS sg13g2_decap_8
XFILLER_25_1285 VDD VSS sg13g2_decap_8
XFILLER_21_1127 VDD VSS sg13g2_decap_8
XFILLER_99_1342 VDD VSS sg13g2_fill_1
XFILLER_186_1301 VDD VSS sg13g2_decap_8
XFILLER_28_233 VDD VSS sg13g2_fill_2
XFILLER_112_1255 VDD VSS sg13g2_decap_4
XFILLER_5_1379 VDD VSS sg13g2_decap_8
XFILLER_56_553 VDD VSS sg13g2_decap_8
X_07869_ _07869_/X _07912_/B _08174_/A VDD VSS sg13g2_or2_1
XFILLER_112_1277 VDD VSS sg13g2_decap_8
XFILLER_17_929 VDD VSS sg13g2_fill_1
XFILLER_112_1288 VDD VSS sg13g2_fill_1
XFILLER_73_14 VDD VSS sg13g2_decap_8
X_09608_ _14204_/D _10072_/A0 _14204_/Q _09638_/S VDD VSS sg13g2_mux2_1
XFILLER_95_1239 VDD VSS sg13g2_fill_1
X_10880_ _10880_/Y _10897_/A _14754_/Q VDD VSS sg13g2_nor2b_1
XFILLER_28_299 VDD VSS sg13g2_fill_1
XFILLER_147_1329 VDD VSS sg13g2_decap_8
XFILLER_186_1378 VDD VSS sg13g2_decap_8
XFILLER_71_556 VDD VSS sg13g2_decap_8
XFILLER_19_1001 VDD VSS sg13g2_decap_8
X_09539_ _14138_/D _09638_/A0 _14138_/Q _09539_/S VDD VSS sg13g2_mux2_1
XFILLER_43_269 VDD VSS sg13g2_fill_1
XFILLER_58_1072 VDD VSS sg13g2_decap_4
X_14860__2847 _14860_/RESET_B VDD VSS sg13g2_tiehi
XFILLER_12_612 VDD VSS sg13g2_decap_8
X_12550_ _12550_/X _13961_/Q _13993_/Q _14025_/Q _14057_/Q _12550_/S0 _12550_/S1 VDD
+ VSS sg13g2_mux4_1
XFILLER_40_943 VDD VSS sg13g2_decap_8
X_14429__1773 _14429_/RESET_B VDD VSS sg13g2_tiehi
X_11501_ _14964_/D _11483_/A _11768_/B1 _11500_/Y VDD VSS sg13g2_a21o_1
XFILLER_11_144 VDD VSS sg13g2_decap_8
XFILLER_185_937 VDD VSS sg13g2_fill_2
XFILLER_71_1250 VDD VSS sg13g2_decap_8
X_12481_ _12481_/X _12478_/X _12477_/X _12474_/X _12473_/X _12622_/S0 _12567_/S VDD
+ VSS sg13g2_mux4_1
XFILLER_8_627 VDD VSS sg13g2_decap_8
XFILLER_12_689 VDD VSS sg13g2_decap_8
XFILLER_184_436 VDD VSS sg13g2_decap_8
X_14220_ _14220_/Q clkload53/A _14220_/D _14220_/RESET_B VDD VSS sg13g2_dfrbpq_1
XFILLER_7_126 VDD VSS sg13g2_decap_8
X_11432_ _14961_/D _11428_/A _11432_/A2 _11431_/Y VDD VSS sg13g2_a21o_1
XFILLER_32_1267 VDD VSS sg13g2_decap_8
XFILLER_158_1403 VDD VSS sg13g2_decap_8
XFILLER_165_672 VDD VSS sg13g2_decap_8
XFILLER_171_119 VDD VSS sg13g2_decap_8
X_14151_ _14151_/Q clkload12/A _14151_/D _14151_/RESET_B VDD VSS sg13g2_dfrbpq_1
XFILLER_153_834 VDD VSS sg13g2_decap_8
XFILLER_164_160 VDD VSS sg13g2_fill_1
X_11363_ _11363_/Y _11365_/A _14398_/Q _11366_/C VDD VSS sg13g2_a21oi_1
XFILLER_153_845 VDD VSS sg13g2_fill_1
XFILLER_164_182 VDD VSS sg13g2_decap_4
XFILLER_4_833 VDD VSS sg13g2_decap_8
X_13102_ _13104_/A _14913_/Q _13674_/Q VDD VSS sg13g2_xor2_1
XFILLER_152_344 VDD VSS sg13g2_fill_1
X_10314_ _10400_/A _14796_/Q _14797_/Q _14798_/Q _10327_/B VDD VSS sg13g2_nand4_1
X_14082_ _14082_/Q clkload7/A _14082_/D _14082_/RESET_B VDD VSS sg13g2_dfrbpq_1
X_11294_ _14958_/D _12911_/B _11248_/B _11293_/Y VDD VSS sg13g2_a21o_1
XFILLER_65_1010 VDD VSS sg13g2_decap_8
XFILLER_106_761 VDD VSS sg13g2_decap_8
XFILLER_180_675 VDD VSS sg13g2_decap_4
XFILLER_98_77 VDD VSS sg13g2_decap_8
XFILLER_3_354 VDD VSS sg13g2_decap_8
XFILLER_0_0 VDD VSS sg13g2_decap_8
X_13033_ _13033_/Y input27/X _12997_/Y _12937_/Y VDD VSS sg13g2_o21ai_1
XFILLER_152_399 VDD VSS sg13g2_fill_2
X_10245_ _14776_/D _10245_/A _13087_/A _10245_/C VDD VSS sg13g2_nor3_1
XFILLER_105_271 VDD VSS sg13g2_decap_8
XFILLER_133_591 VDD VSS sg13g2_fill_2
Xfanout1100 _08686_/S0 fanout1103/X VDD VSS sg13g2_buf_1
XFILLER_79_656 VDD VSS sg13g2_decap_8
XFILLER_78_122 VDD VSS sg13g2_fill_1
XFILLER_65_1076 VDD VSS sg13g2_decap_4
Xfanout1111 _12203_/A _14985_/Q VDD VSS sg13g2_buf_1
XFILLER_152_1035 VDD VSS sg13g2_decap_8
Xfanout1122 _12061_/A _08928_/A1 VDD VSS sg13g2_buf_1
X_10176_ _10176_/Y _13613_/B _10174_/Y _10175_/Y VDD VSS sg13g2_a21oi_1
XFILLER_79_667 VDD VSS sg13g2_fill_1
XFILLER_120_241 VDD VSS sg13g2_decap_8
Xfanout1133 _11914_/A _07820_/B VDD VSS sg13g2_buf_1
XFILLER_113_1008 VDD VSS sg13g2_decap_4
XFILLER_152_1057 VDD VSS sg13g2_decap_8
Xfanout1144 _11798_/A _08900_/A1 VDD VSS sg13g2_buf_1
XFILLER_78_166 VDD VSS sg13g2_decap_4
XFILLER_66_306 VDD VSS sg13g2_decap_8
XFILLER_121_797 VDD VSS sg13g2_decap_8
Xfanout1155 _11659_/A _14970_/Q VDD VSS sg13g2_buf_1
XFILLER_93_103 VDD VSS sg13g2_decap_8
XFILLER_19_200 VDD VSS sg13g2_fill_1
Xfanout1166 _07771_/A _11526_/A VDD VSS sg13g2_buf_1
X_13917__2285 _13917_/RESET_B VDD VSS sg13g2_tiehi
X_14984_ _14984_/Q clkload47/A _14984_/D _14984_/RESET_B VDD VSS sg13g2_dfrbpq_1
Xfanout1177 _07910_/B _11454_/A VDD VSS sg13g2_buf_1
Xfanout190 _09928_/A1 fanout191/X VDD VSS sg13g2_buf_1
Xfanout1188 _11335_/A _14959_/Q VDD VSS sg13g2_buf_1
Xfanout1199 _12866_/A _12899_/A VDD VSS sg13g2_buf_1
XFILLER_43_1385 VDD VSS sg13g2_decap_8
X_13935_ _13935_/Q clkload32/A _13935_/D _13935_/RESET_B VDD VSS sg13g2_dfrbpq_1
XFILLER_47_553 VDD VSS sg13g2_fill_1
XFILLER_78_1415 VDD VSS sg13g2_decap_8
XFILLER_170_60 VDD VSS sg13g2_decap_8
XFILLER_90_810 VDD VSS sg13g2_decap_8
XFILLER_62_501 VDD VSS sg13g2_fill_1
XFILLER_19_299 VDD VSS sg13g2_decap_8
X_13866_ _13866_/Q clkload27/A _13866_/D _13866_/RESET_B VDD VSS sg13g2_dfrbpq_1
XFILLER_90_854 VDD VSS sg13g2_decap_8
XFILLER_179_219 VDD VSS sg13g2_decap_8
X_12817_ _12817_/Y _14864_/Q _12895_/B VDD VSS sg13g2_nand2_1
X_13797_ _13797_/Q _14728_/CLK _13797_/D _13797_/RESET_B VDD VSS sg13g2_dfrbpq_1
XFILLER_31_932 VDD VSS sg13g2_decap_8
X_12748_ _12748_/X _12746_/X _12747_/X _12748_/S VDD VSS sg13g2_mux2_1
XFILLER_124_1126 VDD VSS sg13g2_fill_2
XFILLER_37_1189 VDD VSS sg13g2_decap_8
XFILLER_15_1432 VDD VSS sg13g2_decap_8
X_12679_ _12680_/B _13670_/Q _12749_/A2 _12678_/X _12749_/B2 _12749_/C1 VDD VSS sg13g2_a221oi_1
XFILLER_8_53 VDD VSS sg13g2_decap_8
XFILLER_50_1323 VDD VSS sg13g2_decap_8
X_14418_ _14418_/Q _14514_/CLK _14418_/D _14418_/RESET_B VDD VSS sg13g2_dfrbpq_1
XFILLER_102_1424 VDD VSS sg13g2_decap_8
XFILLER_156_661 VDD VSS sg13g2_decap_4
XFILLER_144_812 VDD VSS sg13g2_fill_2
XFILLER_116_514 VDD VSS sg13g2_decap_8
X_14349_ _14349_/Q clkload23/A _14349_/D _14349_/RESET_B VDD VSS sg13g2_dfrbpq_1
XFILLER_183_480 VDD VSS sg13g2_decap_8
XFILLER_143_322 VDD VSS sg13g2_fill_1
XFILLER_144_845 VDD VSS sg13g2_decap_8
XFILLER_7_693 VDD VSS sg13g2_decap_8
XFILLER_104_709 VDD VSS sg13g2_decap_8
XFILLER_170_130 VDD VSS sg13g2_decap_8
XFILLER_171_653 VDD VSS sg13g2_decap_8
XFILLER_48_1230 VDD VSS sg13g2_decap_8
XFILLER_100_1192 VDD VSS sg13g2_decap_8
X_08910_ _08910_/Y _08835_/A _08835_/B _16872_/A VDD VSS sg13g2_a21oi_1
X_09890_ _14476_/D _09923_/A1 _14476_/Q _09890_/S VDD VSS sg13g2_mux2_1
XFILLER_83_1165 VDD VSS sg13g2_decap_8
XFILLER_135_1244 VDD VSS sg13g2_decap_8
XFILLER_83_1176 VDD VSS sg13g2_fill_2
X_08841_ _08841_/Y _08843_/B _08840_/Y _08836_/Y VDD VSS sg13g2_o21ai_1
XFILLER_58_829 VDD VSS sg13g2_decap_8
XFILLER_100_926 VDD VSS sg13g2_decap_4
XFILLER_111_252 VDD VSS sg13g2_fill_2
XFILLER_131_1108 VDD VSS sg13g2_decap_4
XFILLER_135_1277 VDD VSS sg13g2_decap_8
XFILLER_97_486 VDD VSS sg13g2_decap_8
XFILLER_170_1179 VDD VSS sg13g2_decap_8
XFILLER_57_328 VDD VSS sg13g2_fill_1
X_08772_ _08772_/Y _13676_/Q _08810_/B VDD VSS sg13g2_nor2_1
XFILLER_61_1463 VDD VSS sg13g2_decap_8
XFILLER_85_659 VDD VSS sg13g2_decap_8
X_14507__1695 _14507_/RESET_B VDD VSS sg13g2_tiehi
XFILLER_84_136 VDD VSS sg13g2_decap_8
XFILLER_22_1447 VDD VSS sg13g2_decap_8
X_07723_ _07726_/B _13427_/C _15095_/Q _15091_/Q _15090_/Q VDD VSS sg13g2_nor4_1
X_14082__2120 _14082_/RESET_B VDD VSS sg13g2_tiehi
X_07654_ _07654_/Y _07654_/A VDD VSS sg13g2_inv_1
XFILLER_65_383 VDD VSS sg13g2_decap_8
XFILLER_80_320 VDD VSS sg13g2_decap_8
XFILLER_0_1254 VDD VSS sg13g2_decap_8
X_14686__1516 _14686_/RESET_B VDD VSS sg13g2_tiehi
XFILLER_41_707 VDD VSS sg13g2_decap_8
XFILLER_20_1193 VDD VSS sg13g2_decap_8
XFILLER_41_718 VDD VSS sg13g2_fill_1
XFILLER_80_375 VDD VSS sg13g2_decap_8
X_14722__1480 _14722_/RESET_B VDD VSS sg13g2_tiehi
XFILLER_55_1223 VDD VSS sg13g2_decap_8
X_09324_ _13931_/D _09889_/A0 _13931_/Q _09333_/S VDD VSS sg13g2_mux2_1
XFILLER_43_39 VDD VSS sg13g2_decap_8
XFILLER_80_397 VDD VSS sg13g2_decap_8
XFILLER_159_28 VDD VSS sg13g2_decap_8
XFILLER_181_1253 VDD VSS sg13g2_decap_8
XFILLER_16_1218 VDD VSS sg13g2_decap_8
XFILLER_90_1158 VDD VSS sg13g2_decap_8
XFILLER_179_797 VDD VSS sg13g2_decap_4
X_14830__2906 _14830_/RESET_B VDD VSS sg13g2_tiehi
X_09255_ _13864_/D _13864_/Q _10151_/A1 _09259_/S VDD VSS sg13g2_mux2_1
XFILLER_107_1368 VDD VSS sg13g2_decap_8
XFILLER_166_458 VDD VSS sg13g2_decap_8
X_08206_ _08211_/B _15104_/Q _15091_/Q _08247_/A VDD VSS sg13g2_o21ai_1
X_09186_ _13802_/D _13802_/Q _10153_/A1 _09190_/S VDD VSS sg13g2_mux2_1
XFILLER_147_661 VDD VSS sg13g2_decap_8
XFILLER_182_929 VDD VSS sg13g2_decap_8
XFILLER_105_1092 VDD VSS sg13g2_decap_8
XFILLER_119_374 VDD VSS sg13g2_decap_8
X_08137_ _08138_/A _08142_/C _07630_/A _08023_/B _07903_/B _08151_/S1 _08137_/S1 VDD
+ VSS sg13g2_mux4_1
XFILLER_107_536 VDD VSS sg13g2_decap_4
XFILLER_49_1005 VDD VSS sg13g2_decap_4
XFILLER_135_867 VDD VSS sg13g2_fill_1
XFILLER_134_355 VDD VSS sg13g2_decap_8
XFILLER_135_878 VDD VSS sg13g2_fill_1
XFILLER_150_804 VDD VSS sg13g2_fill_1
X_08068_ _08068_/Y _08029_/Y _08066_/Y _08256_/A _08270_/B _08067_/Y VDD VSS sg13g2_a221oi_1
XFILLER_108_54 VDD VSS sg13g2_decap_8
XFILLER_108_65 VDD VSS sg13g2_fill_1
XFILLER_136_1019 VDD VSS sg13g2_decap_8
XFILLER_68_14 VDD VSS sg13g2_decap_4
XFILLER_122_528 VDD VSS sg13g2_fill_2
Xclkbuf_4_0_0_clk_i clkbuf_4_0_0_clk_i/X clkbuf_0_clk_i/X VDD VSS sg13g2_buf_8
XFILLER_1_847 VDD VSS sg13g2_decap_8
X_14292__1910 _14292_/RESET_B VDD VSS sg13g2_tiehi
X_10030_ _14612_/D _10063_/A0 _14612_/Q _10030_/S VDD VSS sg13g2_mux2_1
XFILLER_153_1344 VDD VSS sg13g2_decap_8
XFILLER_66_1396 VDD VSS sg13g2_decap_8
XFILLER_0_357 VDD VSS sg13g2_decap_8
XFILLER_103_764 VDD VSS sg13g2_decap_8
XFILLER_114_1306 VDD VSS sg13g2_decap_8
XFILLER_103_775 VDD VSS sg13g2_fill_2
XFILLER_88_464 VDD VSS sg13g2_decap_8
XFILLER_130_561 VDD VSS sg13g2_decap_8
XFILLER_89_998 VDD VSS sg13g2_decap_8
XFILLER_27_1369 VDD VSS sg13g2_decap_8
XFILLER_9_1290 VDD VSS sg13g2_decap_8
XFILLER_91_607 VDD VSS sg13g2_decap_8
XFILLER_25_1082 VDD VSS sg13g2_decap_8
XFILLER_25_1093 VDD VSS sg13g2_fill_1
XFILLER_17_704 VDD VSS sg13g2_decap_8
X_11981_ _12012_/A _11983_/A _13671_/Q VDD VSS sg13g2_nand2_1
XFILLER_84_46 VDD VSS sg13g2_decap_4
XFILLER_17_715 VDD VSS sg13g2_decap_8
XFILLER_5_1176 VDD VSS sg13g2_decap_8
XFILLER_29_586 VDD VSS sg13g2_decap_8
XFILLER_112_1074 VDD VSS sg13g2_decap_8
XFILLER_1_1029 VDD VSS sg13g2_decap_8
X_13720_ _16882_/A _15228_/CLK _13720_/D _13720_/RESET_B VDD VSS sg13g2_dfrbpq_1
X_10932_ _10948_/D _10946_/B _10932_/B VDD VSS sg13g2_nand2_1
XFILLER_99_1194 VDD VSS sg13g2_decap_8
XFILLER_84_692 VDD VSS sg13g2_fill_2
XFILLER_147_1104 VDD VSS sg13g2_decap_8
XFILLER_95_1036 VDD VSS sg13g2_fill_1
XFILLER_95_1047 VDD VSS sg13g2_fill_1
XFILLER_71_331 VDD VSS sg13g2_decap_8
XFILLER_186_1175 VDD VSS sg13g2_decap_8
XFILLER_17_84 VDD VSS sg13g2_decap_8
X_13651_ _15117_/D _15186_/D _15117_/Q _13651_/S VDD VSS sg13g2_mux2_1
XFILLER_72_876 VDD VSS sg13g2_decap_8
X_10863_ _10863_/X _10871_/A _14753_/Q VDD VSS sg13g2_and2_1
XFILLER_31_206 VDD VSS sg13g2_decap_8
XFILLER_13_921 VDD VSS sg13g2_decap_8
X_12602_ _12602_/X _13965_/Q _13997_/Q _14029_/Q _14061_/Q _12643_/S0 _12643_/S1 VDD
+ VSS sg13g2_mux4_1
XFILLER_38_1454 VDD VSS sg13g2_decap_8
XFILLER_12_420 VDD VSS sg13g2_decap_8
XFILLER_164_1462 VDD VSS sg13g2_decap_8
X_13582_ _15159_/D _13587_/B _13580_/Y _13581_/Y VDD VSS sg13g2_a21oi_1
XFILLER_160_1304 VDD VSS sg13g2_decap_8
XFILLER_164_1473 VDD VSS sg13g2_fill_2
X_10794_ _11205_/A _14956_/Q _08954_/S _10793_/X VDD VSS sg13g2_a21oi_1
XFILLER_9_903 VDD VSS sg13g2_decap_8
XFILLER_73_1367 VDD VSS sg13g2_decap_8
X_13780__2422 _13780_/RESET_B VDD VSS sg13g2_tiehi
X_12533_ _12533_/X _14568_/Q _14600_/Q _14632_/Q _14664_/Q _12536_/S0 _12536_/S1 VDD
+ VSS sg13g2_mux4_1
XFILLER_13_998 VDD VSS sg13g2_decap_8
XFILLER_185_745 VDD VSS sg13g2_decap_8
X_14806__2930 _14806_/RESET_B VDD VSS sg13g2_tiehi
XFILLER_8_424 VDD VSS sg13g2_decap_8
XFILLER_12_486 VDD VSS sg13g2_decap_8
XFILLER_184_233 VDD VSS sg13g2_decap_8
XFILLER_32_1020 VDD VSS sg13g2_decap_8
XFILLER_157_458 VDD VSS sg13g2_fill_2
XFILLER_32_1031 VDD VSS sg13g2_fill_2
XFILLER_145_609 VDD VSS sg13g2_fill_2
X_12464_ _12464_/X _13731_/Q _14083_/Q _14435_/Q _14531_/Q _12466_/S0 _12466_/S1 VDD
+ VSS sg13g2_mux4_1
XFILLER_138_650 VDD VSS sg13g2_decap_8
XFILLER_126_812 VDD VSS sg13g2_decap_8
X_14203_ _14203_/Q clkload79/A _14203_/D _14203_/RESET_B VDD VSS sg13g2_dfrbpq_1
XFILLER_32_1064 VDD VSS sg13g2_decap_8
X_11415_ _11415_/X _14111_/Q _14143_/Q _11418_/A VDD VSS sg13g2_mux2_1
XFILLER_158_1200 VDD VSS sg13g2_decap_8
X_15183_ _15183_/Q _15188_/CLK _15183_/D _15183_/RESET_B VDD VSS sg13g2_dfrbpq_1
X_12395_ _12395_/X _14366_/Q _14398_/Q _14462_/Q _14494_/Q _12614_/S0 _12614_/S1 VDD
+ VSS sg13g2_mux4_1
XFILLER_153_631 VDD VSS sg13g2_decap_8
XFILLER_165_491 VDD VSS sg13g2_decap_8
XFILLER_4_630 VDD VSS sg13g2_decap_8
X_14134_ _14134_/Q clkload75/A _14134_/D _14134_/RESET_B VDD VSS sg13g2_dfrbpq_1
XFILLER_10_1351 VDD VSS sg13g2_decap_8
X_14160__2042 _14160_/RESET_B VDD VSS sg13g2_tiehi
X_11346_ _11346_/Y _11342_/Y _11343_/Y _11345_/Y _11344_/Y _11359_/B VDD VSS sg13g2_a221oi_1
XFILLER_141_815 VDD VSS sg13g2_fill_1
XFILLER_141_826 VDD VSS sg13g2_fill_1
XFILLER_158_1277 VDD VSS sg13g2_decap_8
XFILLER_165_60 VDD VSS sg13g2_decap_8
XFILLER_98_217 VDD VSS sg13g2_decap_8
XFILLER_3_151 VDD VSS sg13g2_decap_8
X_14065_ _14065_/Q clkload33/A _14065_/D _14065_/RESET_B VDD VSS sg13g2_dfrbpq_1
XFILLER_45_1403 VDD VSS sg13g2_decap_8
X_11277_ _11277_/X _14108_/Q _14140_/Q _11277_/S VDD VSS sg13g2_mux2_1
XFILLER_84_1463 VDD VSS sg13g2_decap_8
XFILLER_80_1305 VDD VSS sg13g2_fill_2
XFILLER_140_358 VDD VSS sg13g2_fill_2
X_13016_ _13016_/Y _13013_/Y _13014_/Y _13015_/Y VDD VSS sg13g2_a21oi_1
X_10228_ _10228_/Y _10237_/A _10237_/C _10322_/C VDD VSS sg13g2_o21ai_1
XFILLER_79_453 VDD VSS sg13g2_decap_4
XFILLER_171_1455 VDD VSS sg13g2_decap_8
XFILLER_80_1349 VDD VSS sg13g2_decap_8
XFILLER_79_475 VDD VSS sg13g2_decap_8
XFILLER_121_583 VDD VSS sg13g2_fill_1
X_13690__2515 _13690_/RESET_B VDD VSS sg13g2_tiehi
XFILLER_94_423 VDD VSS sg13g2_decap_8
X_10159_ _14736_/D _14736_/Q _10159_/A1 _10163_/S VDD VSS sg13g2_mux2_1
XFILLER_181_70 VDD VSS sg13g2_decap_8
XFILLER_66_158 VDD VSS sg13g2_fill_2
XFILLER_43_1182 VDD VSS sg13g2_decap_8
X_14967_ _14967_/Q clkload55/A _14967_/D _14967_/RESET_B VDD VSS sg13g2_dfrbpq_1
XFILLER_78_1212 VDD VSS sg13g2_decap_8
X_13918_ _13918_/Q _14526_/CLK _13918_/D _13918_/RESET_B VDD VSS sg13g2_dfrbpq_1
XFILLER_130_1196 VDD VSS sg13g2_decap_8
X_14898_ _14898_/Q _14930_/CLK _14898_/D _14898_/RESET_B VDD VSS sg13g2_dfrbpq_1
X_13849_ _13849_/Q _14745_/CLK _13849_/D _13849_/RESET_B VDD VSS sg13g2_dfrbpq_1
XFILLER_78_1289 VDD VSS sg13g2_decap_8
XFILLER_63_887 VDD VSS sg13g2_decap_4
XFILLER_35_578 VDD VSS sg13g2_decap_8
XFILLER_165_1259 VDD VSS sg13g2_decap_8
XFILLER_90_684 VDD VSS sg13g2_decap_4
XFILLER_16_781 VDD VSS sg13g2_decap_8
XFILLER_91_1423 VDD VSS sg13g2_decap_8
XFILLER_22_228 VDD VSS sg13g2_decap_8
XFILLER_15_280 VDD VSS sg13g2_decap_8
XFILLER_148_414 VDD VSS sg13g2_decap_8
XFILLER_149_937 VDD VSS sg13g2_decap_8
XFILLER_176_734 VDD VSS sg13g2_decap_4
X_14370__1832 _14370_/RESET_B VDD VSS sg13g2_tiehi
XFILLER_30_250 VDD VSS sg13g2_fill_1
XFILLER_30_261 VDD VSS sg13g2_decap_8
XFILLER_148_447 VDD VSS sg13g2_fill_2
XFILLER_175_233 VDD VSS sg13g2_decap_8
X_09040_ _10716_/B _09060_/S _15034_/Q _09039_/Y VDD VSS sg13g2_o21ai_1
XFILLER_164_918 VDD VSS sg13g2_fill_1
XFILLER_117_812 VDD VSS sg13g2_fill_1
XFILLER_163_417 VDD VSS sg13g2_decap_4
XFILLER_163_428 VDD VSS sg13g2_fill_2
XFILLER_89_1341 VDD VSS sg13g2_decap_8
XFILLER_102_1243 VDD VSS sg13g2_fill_2
XFILLER_117_834 VDD VSS sg13g2_decap_8
XFILLER_102_1254 VDD VSS sg13g2_decap_8
XFILLER_156_480 VDD VSS sg13g2_decap_8
XFILLER_8_991 VDD VSS sg13g2_decap_8
XFILLER_50_1197 VDD VSS sg13g2_decap_8
XFILLER_7_490 VDD VSS sg13g2_decap_8
XFILLER_143_141 VDD VSS sg13g2_decap_8
XFILLER_171_461 VDD VSS sg13g2_fill_1
XFILLER_132_826 VDD VSS sg13g2_decap_4
XFILLER_176_1366 VDD VSS sg13g2_decap_8
XFILLER_131_314 VDD VSS sg13g2_decap_4
X_09942_ _14526_/D _14526_/Q _09942_/A1 _09964_/S VDD VSS sg13g2_mux2_1
XFILLER_116_399 VDD VSS sg13g2_decap_8
XFILLER_171_494 VDD VSS sg13g2_decap_8
Xfanout904 _12759_/S0 _12768_/S0 VDD VSS sg13g2_buf_1
Xfanout915 fanout915/X _15210_/Q VDD VSS sg13g2_buf_1
Xfanout926 _12878_/D _13134_/C VDD VSS sg13g2_buf_1
Xfanout937 _13300_/C _15206_/Q VDD VSS sg13g2_buf_1
X_09873_ _14459_/D _09906_/A1 _14459_/Q _09904_/S VDD VSS sg13g2_mux2_1
XFILLER_98_773 VDD VSS sg13g2_decap_8
XFILLER_100_701 VDD VSS sg13g2_fill_1
Xfanout948 _13552_/C _13563_/C VDD VSS sg13g2_buf_1
Xfanout959 _13401_/C _13389_/A VDD VSS sg13g2_buf_1
XFILLER_100_723 VDD VSS sg13g2_decap_8
XFILLER_140_892 VDD VSS sg13g2_decap_4
X_08824_ _08824_/Y _13482_/A _15190_/Q VDD VSS sg13g2_nand2_1
XFILLER_38_39 VDD VSS sg13g2_decap_8
XFILLER_86_957 VDD VSS sg13g2_decap_4
XFILLER_61_1260 VDD VSS sg13g2_decap_8
X_14023__2179 _14023_/RESET_B VDD VSS sg13g2_tiehi
XFILLER_85_467 VDD VSS sg13g2_decap_8
X_08755_ _08755_/Y _13670_/Q _13469_/B VDD VSS sg13g2_nor2_1
XFILLER_22_1244 VDD VSS sg13g2_decap_8
XFILLER_2_1316 VDD VSS sg13g2_decap_8
X_07706_ _07708_/B _12911_/B _15201_/Q _12799_/A VDD VSS sg13g2_a21oi_1
XFILLER_72_139 VDD VSS sg13g2_decap_8
X_08686_ _08686_/X _08048_/B _08673_/B _08653_/B _12203_/A _08686_/S0 _07627_/A VDD
+ VSS sg13g2_mux4_1
XFILLER_38_394 VDD VSS sg13g2_decap_8
XFILLER_54_38 VDD VSS sg13g2_decap_8
XFILLER_96_1378 VDD VSS sg13g2_decap_8
X_07637_ _10237_/A _14771_/Q VDD VSS sg13g2_inv_1
XFILLER_0_1051 VDD VSS sg13g2_decap_8
XFILLER_148_1457 VDD VSS sg13g2_decap_8
XFILLER_14_729 VDD VSS sg13g2_decap_8
XFILLER_183_1337 VDD VSS sg13g2_decap_8
XFILLER_148_1468 VDD VSS sg13g2_fill_2
XFILLER_110_11 VDD VSS sg13g2_fill_1
XFILLER_159_7 VDD VSS sg13g2_decap_8
XFILLER_110_22 VDD VSS sg13g2_decap_8
XFILLER_13_228 VDD VSS sg13g2_decap_8
XFILLER_179_550 VDD VSS sg13g2_decap_8
XFILLER_107_1110 VDD VSS sg13g2_decap_8
XFILLER_179_561 VDD VSS sg13g2_fill_2
XFILLER_16_1015 VDD VSS sg13g2_decap_8
X_09307_ _09327_/S _09938_/D _09307_/B VDD VSS sg13g2_or2_1
XFILLER_142_1034 VDD VSS sg13g2_decap_8
XFILLER_21_250 VDD VSS sg13g2_decap_4
XFILLER_10_924 VDD VSS sg13g2_decap_8
XFILLER_139_436 VDD VSS sg13g2_decap_8
X_09238_ _13849_/D _10168_/A1 _13849_/Q _09238_/S VDD VSS sg13g2_mux2_1
XFILLER_142_1078 VDD VSS sg13g2_decap_4
XFILLER_21_294 VDD VSS sg13g2_decap_8
XFILLER_182_715 VDD VSS sg13g2_decap_8
XFILLER_6_928 VDD VSS sg13g2_decap_8
XFILLER_181_203 VDD VSS sg13g2_decap_8
XFILLER_33_1373 VDD VSS sg13g2_decap_8
XFILLER_108_823 VDD VSS sg13g2_fill_2
XFILLER_119_171 VDD VSS sg13g2_decap_8
XFILLER_154_439 VDD VSS sg13g2_decap_8
X_09169_ _09938_/D _09441_/A _09806_/B _09441_/C VDD VSS sg13g2_nand3_1
XFILLER_5_427 VDD VSS sg13g2_decap_8
XFILLER_79_13 VDD VSS sg13g2_fill_1
XFILLER_108_867 VDD VSS sg13g2_fill_1
X_11200_ _11201_/B _10785_/Y _11185_/B _11171_/B VDD VSS sg13g2_o21ai_1
XFILLER_135_664 VDD VSS sg13g2_decap_8
X_12180_ _12181_/A _14262_/Q _14294_/Q _14326_/Q _14358_/Q _12189_/S0 _12169_/C VDD
+ VSS sg13g2_mux4_1
XFILLER_68_1447 VDD VSS sg13g2_decap_8
XFILLER_79_46 VDD VSS sg13g2_fill_1
XFILLER_163_995 VDD VSS sg13g2_decap_8
XFILLER_155_1417 VDD VSS sg13g2_decap_8
XFILLER_134_174 VDD VSS sg13g2_decap_8
X_11131_ _11131_/Y _11109_/B _10769_/X _11154_/B1 VDD VSS sg13g2_o21ai_1
XFILLER_79_79 VDD VSS sg13g2_decap_8
X_14233__1969 _14233_/RESET_B VDD VSS sg13g2_tiehi
XFILLER_27_1111 VDD VSS sg13g2_fill_2
XFILLER_1_644 VDD VSS sg13g2_decap_8
XFILLER_122_358 VDD VSS sg13g2_decap_8
XFILLER_122_369 VDD VSS sg13g2_fill_1
X_11062_ _11062_/Y _11185_/A _11078_/A _11061_/Y VDD VSS sg13g2_a21oi_1
XFILLER_89_762 VDD VSS sg13g2_decap_8
XFILLER_103_550 VDD VSS sg13g2_fill_1
XFILLER_66_1193 VDD VSS sg13g2_decap_8
XFILLER_0_154 VDD VSS sg13g2_decap_8
XFILLER_135_74 VDD VSS sg13g2_decap_8
Xhold3060 input10/A mem_axi_rdata[15] VDD VSS sg13g2_dlygate4sd3_1
XFILLER_62_1035 VDD VSS sg13g2_decap_8
XFILLER_114_1114 VDD VSS sg13g2_fill_2
XFILLER_27_1166 VDD VSS sg13g2_decap_8
Xhold3071 hold3071/X input5/X VDD VSS sg13g2_dlygate4sd3_1
X_10013_ _14595_/D _10113_/A0 _14595_/Q _10023_/S VDD VSS sg13g2_mux2_1
Xhold3082 input9/A mem_axi_rdata[14] VDD VSS sg13g2_dlygate4sd3_1
XFILLER_88_283 VDD VSS sg13g2_decap_8
Xhold3093 hold3093/X input16/X VDD VSS sg13g2_dlygate4sd3_1
XFILLER_114_1147 VDD VSS sg13g2_decap_8
XFILLER_153_1196 VDD VSS sg13g2_decap_8
XFILLER_77_968 VDD VSS sg13g2_decap_8
XFILLER_92_905 VDD VSS sg13g2_decap_8
X_13798__2404 _13798_/RESET_B VDD VSS sg13g2_tiehi
X_14821_ _14821_/Q _14893_/CLK _14821_/D _14821_/RESET_B VDD VSS sg13g2_dfrbpq_1
XFILLER_185_0 VDD VSS sg13g2_decap_8
XFILLER_40_1333 VDD VSS sg13g2_decap_8
XFILLER_28_61 VDD VSS sg13g2_decap_4
XFILLER_17_501 VDD VSS sg13g2_decap_8
X_14752_ _14752_/Q _15196_/CLK _14752_/D _14752_/RESET_B VDD VSS sg13g2_dfrbpq_1
XFILLER_45_832 VDD VSS sg13g2_decap_8
XFILLER_151_73 VDD VSS sg13g2_decap_8
X_11964_ _11964_/X _11964_/A _11964_/B VDD VSS sg13g2_and2_1
XFILLER_29_394 VDD VSS sg13g2_decap_8
X_13703_ _16865_/A clkload55/A _13703_/D _13703_/RESET_B VDD VSS sg13g2_dfrbpq_1
X_10915_ _10946_/A _10936_/C _15119_/Q VDD VSS sg13g2_nand2_1
X_14683_ _14683_/Q clkload79/A _14683_/D _14683_/RESET_B VDD VSS sg13g2_dfrbpq_1
XFILLER_44_364 VDD VSS sg13g2_fill_2
X_11895_ _11897_/A _11896_/A _14190_/Q VDD VSS sg13g2_nand2b_1
XFILLER_72_684 VDD VSS sg13g2_decap_4
X_14178__2024 _14178_/RESET_B VDD VSS sg13g2_tiehi
X_13634_ _13742_/D _13634_/A VDD VSS sg13g2_buf_1
XFILLER_44_397 VDD VSS sg13g2_decap_8
XFILLER_32_537 VDD VSS sg13g2_decap_8
X_10846_ _10846_/Y _10845_/Y _10897_/D _10886_/A2 VDD VSS sg13g2_a21oi_1
XFILLER_38_1251 VDD VSS sg13g2_decap_8
XFILLER_9_700 VDD VSS sg13g2_decap_8
XFILLER_160_1112 VDD VSS sg13g2_fill_2
XFILLER_73_1164 VDD VSS sg13g2_decap_8
X_13565_ _15153_/D _15153_/Q _13564_/Y _13565_/S VDD VSS sg13g2_mux2_1
X_10777_ _11164_/B _14952_/Q _08943_/A _10776_/X VDD VSS sg13g2_a21oi_1
XFILLER_146_907 VDD VSS sg13g2_decap_8
XFILLER_8_221 VDD VSS sg13g2_decap_8
XFILLER_185_553 VDD VSS sg13g2_decap_8
X_12516_ _12516_/X _14695_/Q _14727_/Q _13767_/Q _13799_/Q _12520_/S0 _12520_/S1 VDD
+ VSS sg13g2_mux4_1
XFILLER_34_1159 VDD VSS sg13g2_decap_8
XFILLER_158_778 VDD VSS sg13g2_fill_1
XFILLER_12_294 VDD VSS sg13g2_decap_8
XFILLER_160_1178 VDD VSS sg13g2_decap_8
X_13496_ _15126_/D _13494_/Y _13495_/Y _13493_/Y VDD VSS sg13g2_o21ai_1
XFILLER_9_777 VDD VSS sg13g2_decap_8
XFILLER_51_1473 VDD VSS sg13g2_decap_4
X_15235_ _15235_/Q clkload54/A _15235_/D _15235_/RESET_B VDD VSS sg13g2_dfrbpq_1
X_12447_ _12447_/X _13826_/Q _13858_/Q _13890_/Q _13922_/Q _12450_/S0 _12450_/S1 VDD
+ VSS sg13g2_mux4_1
XFILLER_12_1446 VDD VSS sg13g2_decap_8
XFILLER_60_92 VDD VSS sg13g2_decap_8
XFILLER_126_631 VDD VSS sg13g2_decap_4
XFILLER_8_298 VDD VSS sg13g2_decap_8
XFILLER_176_70 VDD VSS sg13g2_decap_8
XFILLER_126_653 VDD VSS sg13g2_fill_1
X_15166_ _15166_/Q clkload86/A _15166_/D _15166_/RESET_B VDD VSS sg13g2_dfrbpq_1
XFILLER_5_21 VDD VSS sg13g2_decap_8
X_12378_ _12378_/X _14685_/Q _14717_/Q _13757_/Q _13789_/Q _12703_/S0 _12703_/S1 VDD
+ VSS sg13g2_mux4_1
XFILLER_119_1003 VDD VSS sg13g2_fill_2
XFILLER_99_526 VDD VSS sg13g2_decap_8
XFILLER_114_837 VDD VSS sg13g2_decap_8
X_14117_ _14117_/Q clkload18/A _14117_/D _14117_/RESET_B VDD VSS sg13g2_dfrbpq_1
XFILLER_5_994 VDD VSS sg13g2_decap_8
X_11329_ _11329_/Y _11327_/Y _11326_/Y _12290_/S0 _11328_/X VDD VSS sg13g2_a22oi_1
XFILLER_119_1036 VDD VSS sg13g2_decap_8
XFILLER_125_185 VDD VSS sg13g2_decap_8
XFILLER_180_280 VDD VSS sg13g2_decap_8
X_15097_ _15097_/Q clkload71/A _15097_/D _15097_/RESET_B VDD VSS sg13g2_dfrbpq_1
XFILLER_45_1200 VDD VSS sg13g2_decap_8
X_14209__1993 _14209_/RESET_B VDD VSS sg13g2_tiehi
XFILLER_5_98 VDD VSS sg13g2_decap_8
XFILLER_49_1380 VDD VSS sg13g2_decap_8
X_14048_ _14048_/Q _14528_/CLK _14048_/D _14048_/RESET_B VDD VSS sg13g2_dfrbpq_1
X_14985__2625 _14985_/RESET_B VDD VSS sg13g2_tiehi
XFILLER_84_1282 VDD VSS sg13g2_decap_8
XFILLER_68_913 VDD VSS sg13g2_decap_8
XFILLER_171_1252 VDD VSS sg13g2_decap_8
XFILLER_80_1135 VDD VSS sg13g2_decap_8
XFILLER_79_261 VDD VSS sg13g2_fill_2
XFILLER_95_721 VDD VSS sg13g2_decap_8
XFILLER_45_1277 VDD VSS sg13g2_decap_8
XFILLER_80_1179 VDD VSS sg13g2_decap_8
X_14388__1814 _14388_/RESET_B VDD VSS sg13g2_tiehi
XFILLER_95_787 VDD VSS sg13g2_decap_4
X_08540_ _08545_/B _08621_/A _08538_/X _08539_/Y VDD VSS sg13g2_o21ai_1
XFILLER_48_692 VDD VSS sg13g2_decap_8
XFILLER_165_1001 VDD VSS sg13g2_decap_8
XFILLER_78_1053 VDD VSS sg13g2_decap_4
XFILLER_39_1004 VDD VSS sg13g2_decap_8
XFILLER_35_342 VDD VSS sg13g2_decap_8
X_08471_ _08494_/A _15008_/Q _08471_/B VDD VSS sg13g2_nor2_1
XFILLER_39_1026 VDD VSS sg13g2_decap_8
XFILLER_165_1045 VDD VSS sg13g2_fill_1
XFILLER_51_835 VDD VSS sg13g2_decap_8
XFILLER_1_1393 VDD VSS sg13g2_decap_8
XFILLER_35_397 VDD VSS sg13g2_decap_8
XFILLER_165_1067 VDD VSS sg13g2_decap_8
XFILLER_108_1441 VDD VSS sg13g2_decap_8
XFILLER_56_1395 VDD VSS sg13g2_decap_8
XFILLER_17_1357 VDD VSS sg13g2_decap_8
X_14905__2757 _14905_/RESET_B VDD VSS sg13g2_tiehi
XFILLER_91_1286 VDD VSS sg13g2_decap_8
XFILLER_143_1376 VDD VSS sg13g2_decap_8
XFILLER_137_929 VDD VSS sg13g2_decap_8
XFILLER_176_575 VDD VSS sg13g2_fill_2
XFILLER_40_18 VDD VSS sg13g2_decap_8
XFILLER_136_428 VDD VSS sg13g2_decap_8
X_09023_ _09024_/C _10702_/A _09030_/D _12957_/A VDD VSS sg13g2_a21o_1
XFILLER_117_620 VDD VSS sg13g2_decap_8
XFILLER_164_759 VDD VSS sg13g2_decap_8
XFILLER_178_1439 VDD VSS sg13g2_decap_8
XFILLER_117_642 VDD VSS sg13g2_fill_2
X_13876__2326 _13876_/RESET_B VDD VSS sg13g2_tiehi
XFILLER_85_1002 VDD VSS sg13g2_fill_1
XFILLER_105_804 VDD VSS sg13g2_decap_8
XFILLER_117_664 VDD VSS sg13g2_decap_8
XFILLER_105_815 VDD VSS sg13g2_fill_2
X_13912__2290 _13912_/RESET_B VDD VSS sg13g2_tiehi
XFILLER_85_1035 VDD VSS sg13g2_fill_2
XFILLER_105_837 VDD VSS sg13g2_decap_8
XFILLER_176_1163 VDD VSS sg13g2_decap_8
XFILLER_85_1046 VDD VSS sg13g2_fill_1
XFILLER_46_1019 VDD VSS sg13g2_decap_8
XFILLER_137_1136 VDD VSS sg13g2_decap_8
XFILLER_171_291 VDD VSS sg13g2_decap_8
XFILLER_28_1420 VDD VSS sg13g2_decap_8
Xfanout701 _13477_/S _13479_/S VDD VSS sg13g2_buf_1
X_14780__2956 _14780_/RESET_B VDD VSS sg13g2_tiehi
Xfanout712 _12108_/B _11443_/A VDD VSS sg13g2_buf_1
X_09925_ _14510_/D _14510_/Q _09925_/A1 _09925_/S VDD VSS sg13g2_mux2_1
XFILLER_49_49 VDD VSS sg13g2_decap_8
XFILLER_131_155 VDD VSS sg13g2_decap_8
XFILLER_154_1450 VDD VSS sg13g2_decap_8
Xfanout723 _11829_/A1 _11359_/B VDD VSS sg13g2_buf_1
XFILLER_172_39 VDD VSS sg13g2_decap_8
XFILLER_63_1344 VDD VSS sg13g2_decap_8
Xfanout734 _11967_/B _12088_/B VDD VSS sg13g2_buf_1
Xfanout745 _11045_/A2 _07653_/Y VDD VSS sg13g2_buf_1
Xfanout756 _11151_/A _07753_/D VDD VSS sg13g2_buf_1
Xfanout767 fanout767/X _07631_/Y VDD VSS sg13g2_buf_1
X_09856_ _14443_/D _14443_/Q _10087_/A0 _09865_/S VDD VSS sg13g2_mux2_1
XFILLER_150_1336 VDD VSS sg13g2_decap_8
Xfanout778 _08048_/A _13550_/A1 VDD VSS sg13g2_buf_1
Xfanout789 _07751_/B _15250_/Q VDD VSS sg13g2_buf_1
XFILLER_58_456 VDD VSS sg13g2_decap_8
X_08807_ _08808_/B _13687_/Q _08810_/B VDD VSS sg13g2_nor2_1
XFILLER_86_776 VDD VSS sg13g2_fill_1
X_09787_ _14376_/D _09919_/A1 _14376_/Q _09789_/S VDD VSS sg13g2_mux2_1
XFILLER_86_798 VDD VSS sg13g2_fill_1
XFILLER_6_1271 VDD VSS sg13g2_decap_8
XFILLER_61_1090 VDD VSS sg13g2_fill_2
XFILLER_45_117 VDD VSS sg13g2_decap_8
XFILLER_2_1113 VDD VSS sg13g2_decap_8
XFILLER_113_1180 VDD VSS sg13g2_decap_4
X_08738_ _13664_/D _08765_/A1 _08736_/Y _08737_/Y VDD VSS sg13g2_a21oi_1
XFILLER_26_320 VDD VSS sg13g2_fill_2
XFILLER_27_876 VDD VSS sg13g2_decap_8
XFILLER_121_43 VDD VSS sg13g2_decap_4
X_08669_ _08669_/Y _08048_/A _08673_/B _08669_/B1 VDD VSS sg13g2_a21oi_1
XFILLER_96_1175 VDD VSS sg13g2_fill_2
XFILLER_183_1134 VDD VSS sg13g2_decap_8
XFILLER_81_470 VDD VSS sg13g2_decap_8
XFILLER_41_301 VDD VSS sg13g2_fill_2
XFILLER_81_14 VDD VSS sg13g2_decap_8
XFILLER_26_386 VDD VSS sg13g2_decap_8
XFILLER_157_4 VDD VSS sg13g2_decap_8
X_10700_ _14902_/D _10886_/B1 _10897_/A _10699_/Y VDD VSS sg13g2_o21ai_1
XFILLER_148_1276 VDD VSS sg13g2_decap_4
X_11680_ _11680_/Y _11765_/A _11679_/X _11559_/C VDD VSS sg13g2_a21oi_1
XFILLER_139_200 VDD VSS sg13g2_decap_8
X_10631_ _10633_/B _14885_/Q _10630_/B VDD VSS sg13g2_nor2b_1
XFILLER_70_1315 VDD VSS sg13g2_decap_8
XFILLER_161_1443 VDD VSS sg13g2_decap_8
XFILLER_14_63 VDD VSS sg13g2_decap_8
XFILLER_35_1457 VDD VSS sg13g2_decap_8
XFILLER_10_721 VDD VSS sg13g2_decap_8
XFILLER_128_907 VDD VSS sg13g2_decap_8
X_13350_ _13351_/D _15181_/D _15182_/D VDD VSS sg13g2_or2_1
X_10562_ _10565_/B _14868_/Q _14867_/Q _14856_/Q _14855_/Q VDD VSS sg13g2_nand4_1
XFILLER_154_203 VDD VSS sg13g2_decap_8
X_12301_ _12301_/Y _12299_/Y _12300_/Y _11664_/A VDD VSS sg13g2_a21oi_1
XFILLER_6_725 VDD VSS sg13g2_decap_8
XFILLER_33_1170 VDD VSS sg13g2_decap_8
X_13281_ _15053_/D _13281_/A _13324_/A _13281_/C VDD VSS sg13g2_nor3_1
XFILLER_108_631 VDD VSS sg13g2_decap_8
XFILLER_10_798 VDD VSS sg13g2_decap_8
X_10493_ _14851_/D _10493_/A _10492_/Y VDD VSS sg13g2_nor2b_1
XFILLER_5_224 VDD VSS sg13g2_decap_8
X_15020_ _15020_/Q clkload48/A _15020_/D _15020_/RESET_B VDD VSS sg13g2_dfrbpq_1
X_12232_ _12232_/X _14136_/Q _14168_/Q _12235_/A VDD VSS sg13g2_mux2_1
XFILLER_136_973 VDD VSS sg13g2_decap_4
X_14466__1736 _14466_/RESET_B VDD VSS sg13g2_tiehi
XFILLER_123_601 VDD VSS sg13g2_decap_4
XFILLER_100_0 VDD VSS sg13g2_decap_8
XFILLER_135_461 VDD VSS sg13g2_decap_8
XFILLER_146_40 VDD VSS sg13g2_fill_1
XFILLER_68_1244 VDD VSS sg13g2_decap_8
XFILLER_107_174 VDD VSS sg13g2_decap_8
XFILLER_151_932 VDD VSS sg13g2_decap_8
X_12163_ _12163_/X _12163_/A _12190_/B VDD VSS sg13g2_and2_1
XFILLER_2_931 VDD VSS sg13g2_decap_8
XFILLER_111_807 VDD VSS sg13g2_decap_8
XFILLER_146_95 VDD VSS sg13g2_decap_8
XFILLER_123_667 VDD VSS sg13g2_decap_8
XFILLER_1_441 VDD VSS sg13g2_decap_8
X_11114_ _11114_/X _11097_/Y _10764_/X _10769_/X VDD VSS sg13g2_a21o_1
XFILLER_111_818 VDD VSS sg13g2_fill_2
XFILLER_123_678 VDD VSS sg13g2_fill_1
XFILLER_150_464 VDD VSS sg13g2_decap_8
X_12094_ _12094_/Y _12094_/A _12108_/B VDD VSS sg13g2_nand2_1
XFILLER_81_1433 VDD VSS sg13g2_decap_8
XFILLER_77_721 VDD VSS sg13g2_decap_4
XFILLER_104_892 VDD VSS sg13g2_decap_8
X_11045_ _11046_/B _11052_/B _11045_/A2 _11045_/B1 VDD VSS sg13g2_a21oi_1
XFILLER_49_423 VDD VSS sg13g2_fill_1
X_14681__1521 _14681_/RESET_B VDD VSS sg13g2_tiehi
XFILLER_77_743 VDD VSS sg13g2_decap_8
XFILLER_103_391 VDD VSS sg13g2_decap_8
XFILLER_76_231 VDD VSS sg13g2_decap_8
XFILLER_7_1057 VDD VSS sg13g2_decap_8
XFILLER_65_916 VDD VSS sg13g2_decap_8
XFILLER_92_713 VDD VSS sg13g2_fill_2
XFILLER_18_810 VDD VSS sg13g2_decap_8
XFILLER_92_746 VDD VSS sg13g2_decap_8
XFILLER_64_437 VDD VSS sg13g2_decap_8
X_14804_ _14804_/Q clkload85/A _14804_/D _14804_/RESET_B VDD VSS sg13g2_dfrbpq_1
XFILLER_149_1029 VDD VSS sg13g2_decap_8
XFILLER_18_854 VDD VSS sg13g2_decap_8
X_12996_ _12996_/Y _12900_/A _12997_/A input7/X VDD VSS sg13g2_a21oi_1
XFILLER_92_779 VDD VSS sg13g2_decap_8
XFILLER_166_1332 VDD VSS sg13g2_decap_8
X_14735_ _14735_/Q clkload35/A _14735_/D _14735_/RESET_B VDD VSS sg13g2_dfrbpq_1
X_11947_ _11947_/Y _11944_/Y _11946_/X _11956_/B1 VDD VSS sg13g2_o21ai_1
XFILLER_55_81 VDD VSS sg13g2_decap_8
XFILLER_79_1395 VDD VSS sg13g2_decap_8
XFILLER_75_1237 VDD VSS sg13g2_decap_8
X_13954__2248 _13954_/RESET_B VDD VSS sg13g2_tiehi
XFILLER_32_323 VDD VSS sg13g2_fill_2
X_14666_ _14666_/Q clkload27/A _14666_/D _14666_/RESET_B VDD VSS sg13g2_dfrbpq_1
XFILLER_178_829 VDD VSS sg13g2_decap_8
X_11878_ _11878_/Y _11882_/S0 _14606_/Q _11742_/C VDD VSS sg13g2_a21oi_1
XFILLER_127_1349 VDD VSS sg13g2_decap_8
XFILLER_33_879 VDD VSS sg13g2_decap_8
X_13617_ _13725_/D _13617_/A VDD VSS sg13g2_buf_1
XFILLER_32_367 VDD VSS sg13g2_decap_8
X_10829_ _10831_/C _10818_/A _10818_/B _10823_/C VDD VSS sg13g2_o21ai_1
XFILLER_32_378 VDD VSS sg13g2_fill_1
X_14597_ _14597_/Q _14725_/CLK _14597_/D _14597_/RESET_B VDD VSS sg13g2_dfrbpq_1
XFILLER_125_1040 VDD VSS sg13g2_decap_8
XFILLER_186_840 VDD VSS sg13g2_decap_8
XFILLER_41_890 VDD VSS sg13g2_decap_8
XFILLER_13_592 VDD VSS sg13g2_fill_1
X_13548_ _15147_/D _13554_/S _13546_/Y _13547_/Y VDD VSS sg13g2_a21oi_1
XFILLER_185_350 VDD VSS sg13g2_decap_8
XFILLER_72_4 VDD VSS sg13g2_decap_8
XFILLER_9_574 VDD VSS sg13g2_decap_8
XFILLER_158_597 VDD VSS sg13g2_decap_4
XFILLER_173_534 VDD VSS sg13g2_fill_2
XFILLER_69_1008 VDD VSS sg13g2_decap_8
XFILLER_51_1270 VDD VSS sg13g2_decap_8
XFILLER_145_236 VDD VSS sg13g2_decap_8
X_13479_ _15180_/D hold3067/X _15180_/Q _13479_/S VDD VSS sg13g2_mux2_1
XFILLER_12_1243 VDD VSS sg13g2_decap_8
XFILLER_161_707 VDD VSS sg13g2_decap_8
X_15218_ _15218_/Q _15240_/CLK _15218_/D _15218_/RESET_B VDD VSS sg13g2_dfrbpq_1
XFILLER_127_973 VDD VSS sg13g2_fill_1
XFILLER_177_1450 VDD VSS sg13g2_decap_8
X_15149_ _15149_/Q _15162_/CLK _15149_/D _15149_/RESET_B VDD VSS sg13g2_dfrbpq_1
XFILLER_86_1377 VDD VSS sg13g2_decap_8
XFILLER_5_791 VDD VSS sg13g2_decap_8
XFILLER_173_1358 VDD VSS sg13g2_decap_8
X_07971_ _07971_/Y _15018_/Q _12229_/A VDD VSS sg13g2_nand2b_1
X_09710_ _14301_/D _10140_/A1 _14301_/Q _09733_/S VDD VSS sg13g2_mux2_1
XFILLER_68_743 VDD VSS sg13g2_decap_8
XFILLER_171_1071 VDD VSS sg13g2_decap_8
XFILLER_45_1074 VDD VSS sg13g2_decap_4
XFILLER_110_851 VDD VSS sg13g2_decap_8
XFILLER_95_551 VDD VSS sg13g2_decap_8
XFILLER_28_607 VDD VSS sg13g2_fill_2
X_09641_ _09641_/X _15064_/Q _09740_/B _09806_/B _09641_/D VDD VSS sg13g2_or4_1
XFILLER_83_702 VDD VSS sg13g2_fill_2
XFILLER_56_927 VDD VSS sg13g2_fill_2
XFILLER_3_1411 VDD VSS sg13g2_decap_8
Xclkbuf_leaf_5_clk_i clkload11/A clkbuf_leaf_8_clk_i/A VDD VSS sg13g2_buf_8
XFILLER_167_1107 VDD VSS sg13g2_decap_8
X_09572_ _14170_/D _09638_/A0 _14170_/Q _09572_/S VDD VSS sg13g2_mux2_1
XFILLER_83_768 VDD VSS sg13g2_decap_8
XFILLER_58_1413 VDD VSS sg13g2_decap_8
XFILLER_35_18 VDD VSS sg13g2_decap_8
X_08523_ _08523_/Y _13566_/A _07812_/B _08523_/B1 VDD VSS sg13g2_o21ai_1
XFILLER_35_29 VDD VSS sg13g2_fill_2
X_15197__2780 _15197_/RESET_B VDD VSS sg13g2_tiehi
XFILLER_184_1443 VDD VSS sg13g2_decap_8
XFILLER_63_470 VDD VSS sg13g2_decap_8
XFILLER_19_1408 VDD VSS sg13g2_decap_8
XFILLER_93_1337 VDD VSS sg13g2_decap_4
XFILLER_1_1190 VDD VSS sg13g2_decap_8
X_14544__1658 _14544_/RESET_B VDD VSS sg13g2_tiehi
X_08454_ _08454_/X _15103_/Q _15090_/Q _08454_/C VDD VSS sg13g2_or3_1
XFILLER_169_829 VDD VSS sg13g2_fill_2
XFILLER_51_654 VDD VSS sg13g2_decap_8
XFILLER_180_1329 VDD VSS sg13g2_decap_8
XFILLER_50_142 VDD VSS sg13g2_decap_8
XFILLER_23_378 VDD VSS sg13g2_fill_2
XFILLER_11_529 VDD VSS sg13g2_decap_8
X_08385_ _08385_/Y _15103_/Q _15090_/Q _08385_/C VDD VSS sg13g2_nor3_1
XFILLER_52_1012 VDD VSS sg13g2_decap_8
XFILLER_143_1140 VDD VSS sg13g2_decap_8
XFILLER_56_1192 VDD VSS sg13g2_decap_8
XFILLER_17_1154 VDD VSS sg13g2_decap_8
X_14798__2938 _14798_/RESET_B VDD VSS sg13g2_tiehi
XFILLER_52_1067 VDD VSS sg13g2_decap_8
XFILLER_136_203 VDD VSS sg13g2_decap_8
XFILLER_167_39 VDD VSS sg13g2_decap_8
XFILLER_176_372 VDD VSS sg13g2_decap_8
XFILLER_30_1321 VDD VSS sg13g2_decap_8
XFILLER_164_556 VDD VSS sg13g2_fill_1
XFILLER_178_1236 VDD VSS sg13g2_decap_8
X_09006_ _09006_/Y _09031_/A _09006_/B _09022_/D VDD VSS sg13g2_nor3_1
XFILLER_152_718 VDD VSS sg13g2_fill_2
XFILLER_151_206 VDD VSS sg13g2_decap_8
XFILLER_133_921 VDD VSS sg13g2_fill_1
XFILLER_145_781 VDD VSS sg13g2_decap_4
XFILLER_3_739 VDD VSS sg13g2_decap_8
XFILLER_30_1398 VDD VSS sg13g2_decap_8
XFILLER_65_1417 VDD VSS sg13g2_decap_8
XFILLER_160_740 VDD VSS sg13g2_decap_4
XFILLER_4_7 VDD VSS sg13g2_decap_8
XFILLER_2_238 VDD VSS sg13g2_decap_8
XFILLER_116_43 VDD VSS sg13g2_decap_8
XFILLER_132_486 VDD VSS sg13g2_decap_4
Xfanout520 _13565_/S _13515_/S VDD VSS sg13g2_buf_1
Xfanout531 _12749_/A2 _12777_/A2 VDD VSS sg13g2_buf_1
XFILLER_76_14 VDD VSS sg13g2_decap_8
Xfanout542 _09841_/A1 _10072_/A0 VDD VSS sg13g2_buf_1
XFILLER_104_199 VDD VSS sg13g2_decap_8
XFILLER_120_648 VDD VSS sg13g2_fill_1
X_09908_ _14493_/D _14493_/Q _10073_/A0 _09931_/S VDD VSS sg13g2_mux2_1
XFILLER_101_840 VDD VSS sg13g2_decap_8
Xfanout553 _09151_/A _09158_/A VDD VSS sg13g2_buf_1
XFILLER_8_1355 VDD VSS sg13g2_decap_8
Xfanout564 _13388_/B fanout565/X VDD VSS sg13g2_buf_1
XFILLER_28_1294 VDD VSS sg13g2_decap_8
XFILLER_101_851 VDD VSS sg13g2_fill_2
Xfanout575 _13272_/B1 _13049_/X VDD VSS sg13g2_buf_1
XFILLER_150_1144 VDD VSS sg13g2_decap_8
Xfanout586 _12914_/A _13272_/A2 VDD VSS sg13g2_buf_1
XFILLER_74_702 VDD VSS sg13g2_decap_8
XFILLER_59_776 VDD VSS sg13g2_decap_8
XFILLER_101_873 VDD VSS sg13g2_decap_8
XFILLER_19_618 VDD VSS sg13g2_fill_1
Xfanout597 _11001_/B _11048_/B VDD VSS sg13g2_buf_1
X_09839_ _09839_/Y _09905_/A _10105_/C _09938_/C _09839_/D VDD VSS sg13g2_nor4_1
XFILLER_46_404 VDD VSS sg13g2_decap_8
XFILLER_24_1158 VDD VSS sg13g2_decap_8
XFILLER_47_949 VDD VSS sg13g2_fill_1
X_12850_ _12850_/X _12846_/Y _12848_/X _12849_/Y VDD VSS sg13g2_a21o_1
XFILLER_185_1229 VDD VSS sg13g2_decap_8
X_11801_ _11801_/X _14124_/Q _14156_/Q _11804_/A VDD VSS sg13g2_mux2_1
XFILLER_92_35 VDD VSS sg13g2_decap_8
X_12781_ _12781_/X _13978_/Q _14010_/Q _14042_/Q _14074_/Q _12787_/S0 _12787_/S1 VDD
+ VSS sg13g2_mux4_1
XFILLER_92_57 VDD VSS sg13g2_decap_8
XFILLER_14_312 VDD VSS sg13g2_decap_8
X_15191__2804 _15191_/RESET_B VDD VSS sg13g2_tiehi
X_14520_ _14520_/Q clkload47/A _14520_/D _14520_/RESET_B VDD VSS sg13g2_dfrbpq_1
XFILLER_54_481 VDD VSS sg13g2_decap_8
XFILLER_15_857 VDD VSS sg13g2_fill_1
X_11732_ _11732_/Y _11759_/A _14186_/Q VDD VSS sg13g2_nand2b_1
XFILLER_41_120 VDD VSS sg13g2_decap_4
XFILLER_42_654 VDD VSS sg13g2_decap_8
XFILLER_109_1046 VDD VSS sg13g2_decap_8
XFILLER_14_367 VDD VSS sg13g2_decap_8
XFILLER_42_676 VDD VSS sg13g2_fill_1
XFILLER_109_1057 VDD VSS sg13g2_fill_1
X_14451_ _14451_/Q _15160_/CLK _14451_/D _14451_/RESET_B VDD VSS sg13g2_dfrbpq_1
X_11663_ _11663_/Y _11663_/A _11663_/B _11773_/B VDD VSS sg13g2_nand3_1
XFILLER_70_1101 VDD VSS sg13g2_decap_8
XFILLER_41_175 VDD VSS sg13g2_fill_1
XFILLER_30_838 VDD VSS sg13g2_decap_4
XFILLER_161_1240 VDD VSS sg13g2_decap_8
XFILLER_168_851 VDD VSS sg13g2_fill_1
XFILLER_186_147 VDD VSS sg13g2_decap_8
XFILLER_23_890 VDD VSS sg13g2_decap_8
X_13402_ _15088_/D _13396_/D _13433_/A _13400_/Y VDD VSS sg13g2_o21ai_1
X_10614_ _10622_/C _10614_/A _10614_/B VDD VSS sg13g2_nor2_1
XFILLER_35_1254 VDD VSS sg13g2_decap_8
X_14382_ _14382_/Q _14510_/CLK _14382_/D _14382_/RESET_B VDD VSS sg13g2_dfrbpq_1
X_11594_ _11594_/X _14118_/Q _14150_/Q _11804_/A VDD VSS sg13g2_mux2_1
XFILLER_122_1246 VDD VSS sg13g2_decap_8
XFILLER_155_523 VDD VSS sg13g2_decap_8
X_13333_ _15171_/D hold3047/X _15171_/Q _13340_/S VDD VSS sg13g2_mux2_1
XFILLER_70_1189 VDD VSS sg13g2_decap_8
X_14699__1503 _14699_/RESET_B VDD VSS sg13g2_tiehi
X_10545_ _10548_/C _14864_/Q _10544_/B VDD VSS sg13g2_nor2b_1
XFILLER_6_522 VDD VSS sg13g2_decap_8
XFILLER_10_595 VDD VSS sg13g2_decap_8
XFILLER_109_962 VDD VSS sg13g2_decap_8
XFILLER_183_887 VDD VSS sg13g2_fill_2
X_13264_ _13264_/X input27/X _13264_/A2 _13264_/B1 VDD VSS sg13g2_a21o_1
XFILLER_108_461 VDD VSS sg13g2_decap_4
XFILLER_142_206 VDD VSS sg13g2_decap_8
XFILLER_143_729 VDD VSS sg13g2_decap_4
XFILLER_182_375 VDD VSS sg13g2_decap_8
X_10476_ _10478_/B _10504_/C _10492_/C _14847_/Q VDD VSS sg13g2_a21oi_1
X_15003_ _15003_/Q clkload31/A _15003_/D _15003_/RESET_B VDD VSS sg13g2_dfrbpq_1
X_12215_ _12215_/X _13975_/Q _14007_/Q _14039_/Q _14071_/Q _12215_/S0 _12241_/B1 VDD
+ VSS sg13g2_mux4_1
XFILLER_6_599 VDD VSS sg13g2_decap_8
XFILLER_124_954 VDD VSS sg13g2_decap_8
XFILLER_155_1011 VDD VSS sg13g2_decap_8
X_13195_ _13196_/C _14824_/Q _13206_/B _07728_/C _14888_/Q VDD VSS sg13g2_a22oi_1
XFILLER_135_291 VDD VSS sg13g2_decap_8
XFILLER_151_740 VDD VSS sg13g2_decap_4
XFILLER_29_1036 VDD VSS sg13g2_decap_8
XFILLER_29_1047 VDD VSS sg13g2_fill_2
X_12146_ _12146_/Y _13199_/A _12294_/A2 _12294_/B1 VDD VSS sg13g2_a21oi_1
XFILLER_37_7 VDD VSS sg13g2_decap_8
XFILLER_29_1069 VDD VSS sg13g2_fill_1
XFILLER_110_103 VDD VSS sg13g2_decap_8
XFILLER_116_1028 VDD VSS sg13g2_decap_4
XFILLER_81_1230 VDD VSS sg13g2_decap_8
XFILLER_150_283 VDD VSS sg13g2_decap_8
XFILLER_155_1088 VDD VSS sg13g2_decap_4
XFILLER_133_1320 VDD VSS sg13g2_fill_1
XFILLER_46_1372 VDD VSS sg13g2_decap_8
X_12077_ _12077_/Y _12223_/A _12077_/B VDD VSS sg13g2_nor2_1
XFILLER_96_359 VDD VSS sg13g2_fill_1
XFILLER_65_702 VDD VSS sg13g2_decap_8
X_11028_ _11029_/B _11024_/B _11052_/D _11027_/Y VDD VSS sg13g2_o21ai_1
XFILLER_77_562 VDD VSS sg13g2_fill_2
XFILLER_42_1247 VDD VSS sg13g2_decap_8
XFILLER_49_264 VDD VSS sg13g2_fill_1
XFILLER_37_404 VDD VSS sg13g2_decap_4
XFILLER_92_510 VDD VSS sg13g2_fill_2
XFILLER_2_77 VDD VSS sg13g2_decap_8
XFILLER_133_1397 VDD VSS sg13g2_decap_8
XFILLER_168_1405 VDD VSS sg13g2_decap_8
XFILLER_66_91 VDD VSS sg13g2_decap_8
XFILLER_65_768 VDD VSS sg13g2_fill_2
XFILLER_18_662 VDD VSS sg13g2_decap_8
XFILLER_92_576 VDD VSS sg13g2_decap_8
XFILLER_64_278 VDD VSS sg13g2_fill_1
X_12979_ _12979_/Y _12976_/Y _12977_/Y _12978_/Y VDD VSS sg13g2_a21oi_1
XFILLER_127_1113 VDD VSS sg13g2_decap_8
X_14718_ _14718_/Q clkload60/A _14718_/D _14718_/RESET_B VDD VSS sg13g2_dfrbpq_1
XFILLER_61_952 VDD VSS sg13g2_decap_8
XFILLER_75_1067 VDD VSS sg13g2_decap_8
XFILLER_21_827 VDD VSS sg13g2_fill_1
XFILLER_127_1168 VDD VSS sg13g2_fill_2
XFILLER_18_1441 VDD VSS sg13g2_decap_8
X_14649_ _14649_/Q clkload44/A _14649_/D _14649_/RESET_B VDD VSS sg13g2_dfrbpq_1
XFILLER_53_1321 VDD VSS sg13g2_decap_8
XANTENNA_16 _10163_/S VDD VSS sg13g2_antennanp
XFILLER_144_1460 VDD VSS sg13g2_decap_8
XANTENNA_27 _12338_/A2 VDD VSS sg13g2_antennanp
XFILLER_177_158 VDD VSS sg13g2_decap_8
X_08170_ _08170_/X _08044_/X _08052_/Y _08167_/B _08397_/B _08241_/A _08196_/A1 VDD
+ VSS sg13g2_mux4_1
XFILLER_119_726 VDD VSS sg13g2_fill_2
XFILLER_140_1335 VDD VSS sg13g2_decap_8
XFILLER_14_1338 VDD VSS sg13g2_decap_8
XFILLER_118_214 VDD VSS sg13g2_fill_1
XFILLER_53_1398 VDD VSS sg13g2_decap_8
XFILLER_9_371 VDD VSS sg13g2_decap_8
XFILLER_146_556 VDD VSS sg13g2_decap_8
XFILLER_88_1439 VDD VSS sg13g2_decap_8
XFILLER_12_1040 VDD VSS sg13g2_decap_8
XFILLER_63_0 VDD VSS sg13g2_decap_8
XFILLER_134_729 VDD VSS sg13g2_decap_4
XFILLER_127_770 VDD VSS sg13g2_fill_2
Xoutput101 mem_axi_awvalid _07766_/Y VDD VSS sg13g2_buf_1
XFILLER_161_537 VDD VSS sg13g2_decap_8
Xoutput112 mem_axi_wdata[17] _15149_/Q VDD VSS sg13g2_buf_1
XFILLER_138_1220 VDD VSS sg13g2_decap_8
Xoutput123 mem_axi_wdata[27] _15159_/Q VDD VSS sg13g2_buf_1
Xoutput134 mem_axi_wdata[8] _15140_/Q VDD VSS sg13g2_buf_1
XFILLER_47_1114 VDD VSS sg13g2_decap_4
XFILLER_126_291 VDD VSS sg13g2_decap_4
XFILLER_114_453 VDD VSS sg13g2_decap_8
XFILLER_130_902 VDD VSS sg13g2_fill_1
XFILLER_99_142 VDD VSS sg13g2_decap_8
XFILLER_88_827 VDD VSS sg13g2_fill_2
XFILLER_173_1155 VDD VSS sg13g2_decap_8
XFILLER_47_1158 VDD VSS sg13g2_decap_8
XFILLER_87_315 VDD VSS sg13g2_decap_8
XFILLER_130_935 VDD VSS sg13g2_decap_4
XFILLER_87_326 VDD VSS sg13g2_fill_1
XFILLER_114_497 VDD VSS sg13g2_decap_8
X_07954_ _07954_/Y _08553_/A _07954_/B _07954_/C VDD VSS sg13g2_nor3_1
XFILLER_87_359 VDD VSS sg13g2_decap_8
XFILLER_101_147 VDD VSS sg13g2_decap_4
XFILLER_60_1336 VDD VSS sg13g2_decap_8
XFILLER_25_1467 VDD VSS sg13g2_decap_8
XFILLER_21_1309 VDD VSS sg13g2_decap_8
X_07885_ _07926_/A _13545_/A _08219_/A VDD VSS sg13g2_nor2b_1
XFILLER_110_681 VDD VSS sg13g2_decap_8
XFILLER_112_1437 VDD VSS sg13g2_decap_8
XFILLER_112_1448 VDD VSS sg13g2_fill_1
X_09624_ _14220_/D _10088_/A0 _14220_/Q _09626_/S VDD VSS sg13g2_mux2_1
XFILLER_83_543 VDD VSS sg13g2_decap_8
X_09555_ _14153_/D _09656_/A0 _14153_/Q _09566_/S VDD VSS sg13g2_mux2_1
XFILLER_58_1210 VDD VSS sg13g2_decap_8
XFILLER_3_1285 VDD VSS sg13g2_decap_8
XFILLER_102_34 VDD VSS sg13g2_decap_8
XFILLER_97_1281 VDD VSS sg13g2_decap_8
XFILLER_110_1183 VDD VSS sg13g2_decap_8
XFILLER_184_1240 VDD VSS sg13g2_decap_8
XFILLER_24_621 VDD VSS sg13g2_decap_8
X_08506_ _08506_/Y _08502_/Y _08503_/Y _08505_/Y VDD VSS sg13g2_o21ai_1
XFILLER_19_1205 VDD VSS sg13g2_decap_8
XFILLER_70_248 VDD VSS sg13g2_decap_8
XFILLER_169_615 VDD VSS sg13g2_decap_8
X_09486_ _14086_/D _10082_/A0 _14086_/Q _09500_/S VDD VSS sg13g2_mux2_1
XFILLER_54_1107 VDD VSS sg13g2_decap_8
XFILLER_58_1287 VDD VSS sg13g2_decap_8
XFILLER_180_1126 VDD VSS sg13g2_decap_8
XFILLER_62_49 VDD VSS sg13g2_decap_8
XFILLER_52_985 VDD VSS sg13g2_fill_2
X_08437_ _08437_/Y _15005_/Q _07946_/B _08391_/A VDD VSS sg13g2_a21oi_1
XFILLER_141_7 VDD VSS sg13g2_fill_2
XFILLER_11_326 VDD VSS sg13g2_decap_8
XFILLER_178_49 VDD VSS sg13g2_decap_8
XFILLER_71_1432 VDD VSS sg13g2_decap_8
XFILLER_8_809 VDD VSS sg13g2_decap_8
XFILLER_149_350 VDD VSS sg13g2_decap_8
XFILLER_184_629 VDD VSS sg13g2_decap_8
X_08368_ _08369_/A _07797_/C _08350_/B _07935_/Y VDD VSS sg13g2_o21ai_1
XFILLER_177_670 VDD VSS sg13g2_decap_8
XFILLER_7_308 VDD VSS sg13g2_decap_8
XFILLER_165_843 VDD VSS sg13g2_decap_4
XFILLER_32_1449 VDD VSS sg13g2_decap_8
XFILLER_149_394 VDD VSS sg13g2_decap_8
X_14980__2630 _14980_/RESET_B VDD VSS sg13g2_tiehi
X_08299_ _08312_/D _08318_/C _08297_/Y _08298_/Y VDD VSS sg13g2_a21oi_1
XFILLER_125_718 VDD VSS sg13g2_decap_8
XFILLER_178_1044 VDD VSS sg13g2_decap_8
X_10330_ _10331_/B _10342_/A _14803_/Q _10342_/C _10345_/C VDD VSS sg13g2_nand4_1
XFILLER_139_1006 VDD VSS sg13g2_fill_1
XFILLER_137_589 VDD VSS sg13g2_decap_8
XFILLER_11_53 VDD VSS sg13g2_decap_8
XFILLER_124_228 VDD VSS sg13g2_decap_8
X_10261_ _10261_/Y _14782_/Q _10268_/D _10365_/C VDD VSS sg13g2_o21ai_1
XFILLER_3_536 VDD VSS sg13g2_decap_8
XFILLER_30_1195 VDD VSS sg13g2_decap_8
XFILLER_105_431 VDD VSS sg13g2_decap_8
Xclkbuf_leaf_106_clk_i clkload62/A clkbuf_leaf_96_clk_i/A VDD VSS sg13g2_buf_8
XFILLER_65_1214 VDD VSS sg13g2_decap_8
XFILLER_79_805 VDD VSS sg13g2_fill_2
X_12000_ _12001_/B _12291_/A _12000_/B VDD VSS sg13g2_nor2_1
XFILLER_79_816 VDD VSS sg13g2_decap_8
XFILLER_156_1364 VDD VSS sg13g2_decap_8
X_10192_ _14753_/D _15196_/D _14753_/Q _13651_/S VDD VSS sg13g2_mux2_1
XFILLER_87_46 VDD VSS sg13g2_decap_8
XFILLER_105_486 VDD VSS sg13g2_fill_1
XFILLER_87_57 VDD VSS sg13g2_fill_2
Xpicorv32_macro_1444 mem_axi_awprot[1] VDD VSS sg13g2_tielo
Xfanout1304 _12038_/B1 _12140_/S1 VDD VSS sg13g2_buf_1
XFILLER_152_1228 VDD VSS sg13g2_decap_4
Xfanout1315 _12187_/C fanout1319/X VDD VSS sg13g2_buf_1
XFILLER_132_294 VDD VSS sg13g2_decap_4
XFILLER_152_1239 VDD VSS sg13g2_decap_8
Xfanout1326 _11580_/S0 fanout1329/X VDD VSS sg13g2_buf_1
Xfanout1337 _12112_/A1 _12105_/A1 VDD VSS sg13g2_buf_1
Xfanout350 _09692_/S _09694_/S VDD VSS sg13g2_buf_1
Xfanout1348 _11882_/S0 _11890_/S0 VDD VSS sg13g2_buf_1
Xfanout361 _09494_/S fanout364/X VDD VSS sg13g2_buf_1
XFILLER_8_1152 VDD VSS sg13g2_decap_8
Xfanout1359 _11821_/S0 _11814_/S0 VDD VSS sg13g2_buf_1
XFILLER_87_871 VDD VSS sg13g2_decap_8
XFILLER_59_562 VDD VSS sg13g2_decap_8
XFILLER_19_404 VDD VSS sg13g2_decap_8
Xfanout372 _09292_/S _09294_/S VDD VSS sg13g2_buf_1
X_13951_ _13951_/Q _14655_/CLK _13951_/D _13951_/RESET_B VDD VSS sg13g2_dfrbpq_1
Xfanout383 _09190_/S _09170_/Y VDD VSS sg13g2_buf_1
Xfanout394 _09814_/A0 _09913_/A1 VDD VSS sg13g2_buf_1
XFILLER_46_212 VDD VSS sg13g2_fill_1
XFILLER_115_1094 VDD VSS sg13g2_decap_8
XFILLER_46_223 VDD VSS sg13g2_decap_8
X_12902_ _12902_/Y _12902_/A _12902_/B _12902_/C VDD VSS sg13g2_nand3_1
XFILLER_98_1034 VDD VSS sg13g2_fill_1
XFILLER_86_392 VDD VSS sg13g2_decap_8
X_13882_ _13882_/Q clkload80/A _13882_/D _13882_/RESET_B VDD VSS sg13g2_dfrbpq_1
XFILLER_62_716 VDD VSS sg13g2_decap_8
X_12833_ _12833_/Y _12835_/A _13691_/Q VDD VSS sg13g2_nand2_1
XFILLER_76_1310 VDD VSS sg13g2_decap_8
XFILLER_36_94 VDD VSS sg13g2_decap_8
X_12764_ _15018_/D _12764_/A _12764_/B VDD VSS sg13g2_nor2_1
XFILLER_163_1324 VDD VSS sg13g2_decap_8
XFILLER_76_1387 VDD VSS sg13g2_decap_8
X_14036__2166 _14036_/RESET_B VDD VSS sg13g2_tiehi
X_14503_ _14503_/Q _14704_/CLK _14503_/D _14503_/RESET_B VDD VSS sg13g2_dfrbpq_1
X_14879__2809 _14879_/RESET_B VDD VSS sg13g2_tiehi
X_11715_ _11715_/X _14249_/Q _14281_/Q _14313_/Q _14345_/Q _11715_/S0 _11715_/S1 VDD
+ VSS sg13g2_mux4_1
XFILLER_70_771 VDD VSS sg13g2_decap_8
X_13871__2331 _13871_/RESET_B VDD VSS sg13g2_tiehi
XFILLER_15_698 VDD VSS sg13g2_decap_4
X_12695_ _12708_/A _07737_/A _07737_/B _15014_/Q VDD VSS sg13g2_a21oi_1
XFILLER_175_607 VDD VSS sg13g2_decap_8
X_14434_ _14434_/Q clkload7/A _14434_/D _14434_/RESET_B VDD VSS sg13g2_dfrbpq_1
X_11646_ _11646_/X _14567_/Q _14599_/Q _14631_/Q _14663_/Q _11649_/S0 _11649_/S1 VDD
+ VSS sg13g2_mux4_1
XFILLER_35_1051 VDD VSS sg13g2_decap_8
XFILLER_156_821 VDD VSS sg13g2_decap_8
XFILLER_30_679 VDD VSS sg13g2_decap_8
XFILLER_11_860 VDD VSS sg13g2_decap_8
Xinput14 input14/X input14/A VDD VSS sg13g2_buf_1
XFILLER_122_1043 VDD VSS sg13g2_decap_4
X_14365_ _14365_/Q clkload30/A _14365_/D _14365_/RESET_B VDD VSS sg13g2_dfrbpq_1
Xinput25 input25/X input25/A VDD VSS sg13g2_buf_1
XFILLER_35_1095 VDD VSS sg13g2_decap_8
Xinput36 input36/X input36/A VDD VSS sg13g2_buf_1
X_11577_ _11577_/X _14117_/Q _14149_/Q _14181_/Q _14213_/Q _11580_/S0 _11580_/S1 VDD
+ VSS sg13g2_mux4_1
XFILLER_128_567 VDD VSS sg13g2_decap_8
XFILLER_10_392 VDD VSS sg13g2_decap_8
XFILLER_155_353 VDD VSS sg13g2_decap_8
X_13316_ _13316_/X _15062_/Q _13600_/C _13316_/C VDD VSS sg13g2_and3_1
XFILLER_156_887 VDD VSS sg13g2_decap_8
X_10528_ _10529_/B _14858_/Q _10564_/D _10531_/D VDD VSS sg13g2_nand3_1
XFILLER_7_875 VDD VSS sg13g2_decap_8
X_14296_ _14296_/Q _14514_/CLK _14296_/D _14296_/RESET_B VDD VSS sg13g2_dfrbpq_1
XFILLER_171_835 VDD VSS sg13g2_decap_8
XFILLER_100_1341 VDD VSS sg13g2_decap_8
XFILLER_170_312 VDD VSS sg13g2_fill_1
XFILLER_182_172 VDD VSS sg13g2_decap_8
XFILLER_108_280 VDD VSS sg13g2_decap_8
XFILLER_115_239 VDD VSS sg13g2_decap_4
X_13247_ _13247_/Y _13247_/A _13247_/B _13247_/C _13308_/A VDD VSS sg13g2_nand4_1
XFILLER_87_1461 VDD VSS sg13g2_decap_8
XFILLER_6_396 VDD VSS sg13g2_decap_8
XFILLER_48_1412 VDD VSS sg13g2_decap_8
XFILLER_174_1420 VDD VSS sg13g2_decap_8
X_10459_ _10471_/D _10538_/A _10459_/B _10459_/C _10512_/A VDD VSS sg13g2_nor4_1
X_13178_ _13178_/X input20/X _13264_/A2 _13264_/B1 VDD VSS sg13g2_a21o_1
XFILLER_83_1347 VDD VSS sg13g2_decap_8
XFILLER_111_412 VDD VSS sg13g2_decap_8
XFILLER_35_4 VDD VSS sg13g2_decap_8
X_12129_ _12198_/C _12061_/A _13189_/B _13668_/Q _12129_/B2 VDD VSS sg13g2_a22oi_1
Xclkbuf_leaf_70_clk_i clkload89/A clkbuf_leaf_71_clk_i/A VDD VSS sg13g2_buf_8
XFILLER_112_979 VDD VSS sg13g2_fill_1
XFILLER_81_1060 VDD VSS sg13g2_fill_1
XFILLER_78_860 VDD VSS sg13g2_fill_1
XFILLER_78_893 VDD VSS sg13g2_decap_8
XFILLER_38_724 VDD VSS sg13g2_fill_1
XFILLER_120_990 VDD VSS sg13g2_decap_8
XFILLER_38_735 VDD VSS sg13g2_decap_8
XFILLER_133_1194 VDD VSS sg13g2_decap_8
XFILLER_168_1202 VDD VSS sg13g2_decap_8
X_14246__1956 _14246_/RESET_B VDD VSS sg13g2_tiehi
X_07670_ _07670_/Y _10174_/B _13613_/B _13613_/C VDD VSS sg13g2_nand3_1
XFILLER_37_234 VDD VSS sg13g2_fill_2
X_16868_ _16868_/X _16868_/A VDD VSS sg13g2_buf_1
XFILLER_65_554 VDD VSS sg13g2_decap_8
XFILLER_53_716 VDD VSS sg13g2_decap_8
XFILLER_19_971 VDD VSS sg13g2_decap_8
Xclkbuf_leaf_85_clk_i clkload64/A clkbuf_leaf_90_clk_i/A VDD VSS sg13g2_buf_8
XFILLER_93_885 VDD VSS sg13g2_decap_8
XFILLER_77_1129 VDD VSS sg13g2_decap_4
XFILLER_37_289 VDD VSS sg13g2_decap_8
XFILLER_0_1436 VDD VSS sg13g2_decap_8
XFILLER_20_1375 VDD VSS sg13g2_decap_8
XFILLER_168_1279 VDD VSS sg13g2_decap_8
XFILLER_18_492 VDD VSS sg13g2_decap_8
X_09340_ _09606_/C _10105_/C _09905_/A VDD VSS sg13g2_nor2b_1
XFILLER_34_941 VDD VSS sg13g2_fill_2
XFILLER_94_1454 VDD VSS sg13g2_decap_8
XFILLER_55_1405 VDD VSS sg13g2_decap_8
XFILLER_178_401 VDD VSS sg13g2_decap_8
XFILLER_181_1435 VDD VSS sg13g2_decap_8
XFILLER_34_985 VDD VSS sg13g2_decap_8
X_09271_ _13880_/D _13880_/Q _10167_/A1 _09273_/S VDD VSS sg13g2_mux2_1
X_13701__2501 _13701_/RESET_B VDD VSS sg13g2_tiehi
XFILLER_179_979 VDD VSS sg13g2_decap_8
X_14461__1741 _14461_/RESET_B VDD VSS sg13g2_tiehi
XFILLER_20_112 VDD VSS sg13g2_decap_8
X_08222_ _08233_/C _08306_/A _08247_/B _08217_/X _08110_/D _08221_/Y VDD VSS sg13g2_a221oi_1
XFILLER_147_810 VDD VSS sg13g2_decap_8
XFILLER_147_821 VDD VSS sg13g2_fill_1
XFILLER_159_681 VDD VSS sg13g2_fill_2
XFILLER_14_1135 VDD VSS sg13g2_decap_8
X_08153_ _08484_/C _08363_/S1 _08151_/X _08152_/Y VDD VSS sg13g2_o21ai_1
XFILLER_53_1195 VDD VSS sg13g2_decap_8
XFILLER_119_556 VDD VSS sg13g2_decap_4
XFILLER_146_353 VDD VSS sg13g2_decap_8
XFILLER_174_662 VDD VSS sg13g2_decap_8
XFILLER_147_887 VDD VSS sg13g2_decap_8
Xclkbuf_leaf_23_clk_i _15139_/CLK clkbuf_leaf_9_clk_i/A VDD VSS sg13g2_buf_8
XFILLER_88_1236 VDD VSS sg13g2_decap_8
XFILLER_107_729 VDD VSS sg13g2_decap_8
X_08084_ _08085_/A _08922_/A1 _08925_/A1 _08928_/A1 _08931_/A1 _08046_/B _08084_/S1
+ VDD VSS sg13g2_mux4_1
XFILLER_101_1149 VDD VSS sg13g2_decap_8
XFILLER_173_161 VDD VSS sg13g2_decap_8
XFILLER_162_835 VDD VSS sg13g2_decap_8
XFILLER_179_1386 VDD VSS sg13g2_decap_8
X_13734__2468 _13734_/RESET_B VDD VSS sg13g2_tiehi
XFILLER_173_194 VDD VSS sg13g2_decap_8
XFILLER_115_751 VDD VSS sg13g2_fill_2
XFILLER_161_389 VDD VSS sg13g2_decap_8
XFILLER_88_613 VDD VSS sg13g2_decap_4
XFILLER_138_1061 VDD VSS sg13g2_decap_8
XFILLER_87_101 VDD VSS sg13g2_fill_2
XFILLER_142_581 VDD VSS sg13g2_fill_2
XFILLER_0_539 VDD VSS sg13g2_decap_8
XFILLER_103_946 VDD VSS sg13g2_decap_8
XFILLER_130_732 VDD VSS sg13g2_fill_2
XFILLER_138_1083 VDD VSS sg13g2_decap_4
Xclkbuf_leaf_38_clk_i _14514_/CLK clkbuf_leaf_38_clk_i/A VDD VSS sg13g2_buf_8
XFILLER_87_112 VDD VSS sg13g2_decap_8
XFILLER_114_294 VDD VSS sg13g2_decap_8
X_08986_ _08988_/B _10681_/A _10674_/A _12859_/A VDD VSS sg13g2_a21oi_1
XFILLER_88_668 VDD VSS sg13g2_decap_8
XFILLER_9_1472 VDD VSS sg13g2_decap_8
XFILLER_69_860 VDD VSS sg13g2_fill_2
X_14114__2088 _14114_/RESET_B VDD VSS sg13g2_tiehi
XFILLER_151_1250 VDD VSS sg13g2_fill_2
XFILLER_180_28 VDD VSS sg13g2_decap_8
X_07937_ _07937_/Y _08414_/C _07936_/Y _07793_/Y VDD VSS sg13g2_a21oi_1
XFILLER_60_1133 VDD VSS sg13g2_fill_1
XFILLER_87_189 VDD VSS sg13g2_decap_8
XFILLER_25_1264 VDD VSS sg13g2_decap_8
XFILLER_68_381 VDD VSS sg13g2_decap_8
XFILLER_56_521 VDD VSS sg13g2_fill_2
XFILLER_112_1234 VDD VSS sg13g2_decap_8
XFILLER_5_1358 VDD VSS sg13g2_decap_8
XFILLER_151_1294 VDD VSS sg13g2_decap_4
X_07868_ _08183_/B _07912_/B _08174_/A VDD VSS sg13g2_nor2_1
XFILLER_84_863 VDD VSS sg13g2_decap_8
XFILLER_29_768 VDD VSS sg13g2_fill_2
XFILLER_84_874 VDD VSS sg13g2_decap_8
XFILLER_28_267 VDD VSS sg13g2_decap_8
X_14998__2612 _14998_/RESET_B VDD VSS sg13g2_tiehi
X_09607_ _14203_/D _10071_/A0 _14203_/Q _09638_/S VDD VSS sg13g2_mux2_1
XFILLER_84_896 VDD VSS sg13g2_decap_8
XFILLER_147_1308 VDD VSS sg13g2_decap_8
XFILLER_186_1357 VDD VSS sg13g2_decap_8
XFILLER_44_738 VDD VSS sg13g2_decap_4
XFILLER_113_88 VDD VSS sg13g2_fill_1
X_07799_ _07799_/X _15006_/Q _07945_/B VDD VSS sg13g2_and2_1
XFILLER_73_48 VDD VSS sg13g2_decap_8
XFILLER_3_1082 VDD VSS sg13g2_decap_8
XFILLER_25_941 VDD VSS sg13g2_decap_8
X_09538_ _14137_/D _10101_/A0 _14137_/Q _09538_/S VDD VSS sg13g2_mux2_1
XFILLER_43_248 VDD VSS sg13g2_decap_8
XFILLER_58_1062 VDD VSS sg13g2_fill_2
XFILLER_71_579 VDD VSS sg13g2_decap_8
X_09469_ _14070_/D _10098_/A0 _14070_/Q _09473_/S VDD VSS sg13g2_mux2_1
XFILLER_24_495 VDD VSS sg13g2_decap_8
XFILLER_11_123 VDD VSS sg13g2_decap_8
XFILLER_185_916 VDD VSS sg13g2_decap_8
X_11500_ _11500_/Y _11499_/Y _11498_/Y _11485_/Y _11722_/B2 _11723_/A2 VDD VSS sg13g2_a221oi_1
XFILLER_157_618 VDD VSS sg13g2_decap_8
XFILLER_8_606 VDD VSS sg13g2_decap_8
XFILLER_12_668 VDD VSS sg13g2_decap_8
XFILLER_145_1087 VDD VSS sg13g2_fill_1
X_12480_ _12480_/X _14692_/Q _14724_/Q _13764_/Q _13796_/Q _12480_/S0 _12480_/S1 VDD
+ VSS sg13g2_mux4_1
XFILLER_184_415 VDD VSS sg13g2_decap_8
XFILLER_7_105 VDD VSS sg13g2_decap_8
XFILLER_138_843 VDD VSS sg13g2_decap_8
X_11431_ _11431_/Y _11837_/A1 _11430_/Y _11425_/Y _11426_/Y _11432_/A2 VDD VSS sg13g2_a221oi_1
XFILLER_32_1246 VDD VSS sg13g2_decap_8
XFILLER_123_1385 VDD VSS sg13g2_decap_4
X_14150_ _14150_/Q clkload50/A _14150_/D _14150_/RESET_B VDD VSS sg13g2_dfrbpq_1
X_11362_ _11362_/Y _11365_/A _14366_/Q VDD VSS sg13g2_nand2b_1
XFILLER_4_812 VDD VSS sg13g2_decap_8
XFILLER_137_386 VDD VSS sg13g2_decap_4
X_13101_ _13116_/A _14913_/Q _13674_/Q VDD VSS sg13g2_nand2_1
X_10313_ _10414_/B _14796_/Q _14797_/Q _14798_/Q _10327_/B VDD VSS sg13g2_and4_1
XFILLER_98_34 VDD VSS sg13g2_decap_4
X_14081_ _14081_/Q clkload6/A _14081_/D _14081_/RESET_B VDD VSS sg13g2_dfrbpq_1
X_14324__1878 _14324_/RESET_B VDD VSS sg13g2_tiehi
XFILLER_158_1459 VDD VSS sg13g2_decap_8
X_11293_ _11293_/Y _07684_/B _11292_/Y _11287_/Y _11289_/Y _11248_/B VDD VSS sg13g2_a221oi_1
XFILLER_98_56 VDD VSS sg13g2_decap_8
XFILLER_3_333 VDD VSS sg13g2_decap_8
XFILLER_153_879 VDD VSS sg13g2_decap_4
X_13032_ _13032_/Y _13600_/B _12997_/A input9/X VDD VSS sg13g2_a21oi_1
X_10244_ _10245_/A _14775_/Q _14776_/Q _10247_/D VDD VSS sg13g2_and3_1
XFILLER_4_889 VDD VSS sg13g2_decap_8
XFILLER_121_721 VDD VSS sg13g2_decap_8
XFILLER_78_101 VDD VSS sg13g2_decap_8
XFILLER_152_1003 VDD VSS sg13g2_fill_2
XFILLER_79_635 VDD VSS sg13g2_decap_8
Xfanout1101 _08046_/B _08009_/S VDD VSS sg13g2_buf_1
XFILLER_117_1145 VDD VSS sg13g2_fill_1
XFILLER_120_220 VDD VSS sg13g2_decap_8
XFILLER_156_1194 VDD VSS sg13g2_decap_8
Xfanout1112 _07850_/B _08012_/B VDD VSS sg13g2_buf_1
X_10175_ _10175_/Y _13293_/A _13613_/B _13613_/C VDD VSS sg13g2_nor3_1
Xfanout1123 _08928_/A1 _14981_/Q VDD VSS sg13g2_buf_1
XFILLER_78_145 VDD VSS sg13g2_decap_8
XFILLER_67_819 VDD VSS sg13g2_decap_8
XFILLER_121_776 VDD VSS sg13g2_decap_8
Xfanout1134 _07820_/B _08915_/A1 VDD VSS sg13g2_buf_1
XFILLER_117_1178 VDD VSS sg13g2_fill_2
X_13889__2313 _13889_/RESET_B VDD VSS sg13g2_tiehi
Xfanout1145 _08900_/A1 _14974_/Q VDD VSS sg13g2_buf_1
Xfanout1156 _07786_/A _08362_/A2 VDD VSS sg13g2_buf_1
XFILLER_130_1301 VDD VSS sg13g2_fill_1
Xfanout1167 _11526_/A _14966_/Q VDD VSS sg13g2_buf_1
XFILLER_66_329 VDD VSS sg13g2_fill_1
XFILLER_120_286 VDD VSS sg13g2_decap_4
X_14983_ _14983_/Q clkload48/A _14983_/D _14983_/RESET_B VDD VSS sg13g2_dfrbpq_1
Xfanout180 _10095_/A0 _09930_/A1 VDD VSS sg13g2_buf_1
XFILLER_94_649 VDD VSS sg13g2_decap_8
XFILLER_43_1364 VDD VSS sg13g2_decap_8
XFILLER_102_990 VDD VSS sg13g2_decap_4
Xfanout1178 _11454_/A _14962_/Q VDD VSS sg13g2_buf_1
Xfanout191 fanout191/X _09105_/Y VDD VSS sg13g2_buf_1
Xfanout1189 _08023_/B _08089_/B2 VDD VSS sg13g2_buf_1
X_13934_ _13934_/Q _14670_/CLK _13934_/D _13934_/RESET_B VDD VSS sg13g2_dfrbpq_1
XFILLER_93_159 VDD VSS sg13g2_decap_8
XFILLER_74_351 VDD VSS sg13g2_decap_8
XFILLER_75_885 VDD VSS sg13g2_fill_1
XFILLER_130_1378 VDD VSS sg13g2_decap_8
XFILLER_19_278 VDD VSS sg13g2_decap_8
X_14793__2943 _14793_/RESET_B VDD VSS sg13g2_tiehi
X_13865_ _13865_/Q _14729_/CLK _13865_/D _13865_/RESET_B VDD VSS sg13g2_dfrbpq_1
X_12816_ _12816_/Y _12914_/A _12814_/Y _12815_/Y VDD VSS sg13g2_o21ai_1
XFILLER_15_440 VDD VSS sg13g2_decap_8
XFILLER_16_963 VDD VSS sg13g2_decap_8
XFILLER_62_568 VDD VSS sg13g2_decap_4
XFILLER_16_974 VDD VSS sg13g2_fill_2
X_13796_ _13796_/Q _14724_/CLK _13796_/D _13796_/RESET_B VDD VSS sg13g2_dfrbpq_1
XFILLER_167_1290 VDD VSS sg13g2_decap_8
XFILLER_72_1015 VDD VSS sg13g2_decap_8
XFILLER_76_1184 VDD VSS sg13g2_decap_8
X_12747_ _12747_/X _12741_/X _12745_/X _12740_/X _12744_/X _12762_/S _12747_/S1 VDD
+ VSS sg13g2_mux4_1
XFILLER_37_1168 VDD VSS sg13g2_decap_8
XFILLER_179_81 VDD VSS sg13g2_decap_8
XFILLER_15_1411 VDD VSS sg13g2_decap_8
XFILLER_175_404 VDD VSS sg13g2_fill_1
X_12678_ _12678_/X _12676_/X _12677_/X _12762_/S VDD VSS sg13g2_mux2_1
XFILLER_8_32 VDD VSS sg13g2_decap_8
XFILLER_31_977 VDD VSS sg13g2_decap_8
XFILLER_30_454 VDD VSS sg13g2_decap_8
XFILLER_124_1149 VDD VSS sg13g2_decap_4
XFILLER_163_1198 VDD VSS sg13g2_decap_8
XFILLER_175_426 VDD VSS sg13g2_fill_2
XFILLER_176_949 VDD VSS sg13g2_decap_4
XFILLER_50_1302 VDD VSS sg13g2_decap_8
XFILLER_129_832 VDD VSS sg13g2_decap_8
XFILLER_102_1403 VDD VSS sg13g2_decap_8
XFILLER_141_1452 VDD VSS sg13g2_decap_8
X_14417_ _14417_/Q _14417_/CLK _14417_/D _14417_/RESET_B VDD VSS sg13g2_dfrbpq_1
X_11629_ _11629_/Y _14905_/Q _11433_/B _11625_/Y _11628_/Y VDD VSS sg13g2_a22oi_1
XFILLER_11_690 VDD VSS sg13g2_decap_8
XFILLER_128_342 VDD VSS sg13g2_decap_8
XFILLER_162_109 VDD VSS sg13g2_decap_8
XFILLER_184_982 VDD VSS sg13g2_decap_8
XFILLER_50_1379 VDD VSS sg13g2_decap_8
XFILLER_143_301 VDD VSS sg13g2_decap_8
X_14348_ _14348_/Q _14508_/CLK _14348_/D _14348_/RESET_B VDD VSS sg13g2_dfrbpq_1
XFILLER_7_672 VDD VSS sg13g2_decap_8
XFILLER_155_194 VDD VSS sg13g2_decap_8
XFILLER_116_559 VDD VSS sg13g2_decap_8
X_14279_ _14279_/Q clkload12/A _14279_/D _14279_/RESET_B VDD VSS sg13g2_dfrbpq_1
XFILLER_6_193 VDD VSS sg13g2_decap_8
XFILLER_100_1182 VDD VSS sg13g2_fill_2
XFILLER_135_1201 VDD VSS sg13g2_fill_2
XFILLER_124_592 VDD VSS sg13g2_decap_8
XFILLER_98_955 VDD VSS sg13g2_fill_1
X_08840_ _08840_/Y _15023_/Q _10669_/S _10805_/B VDD VSS sg13g2_a21oi_1
XFILLER_48_1286 VDD VSS sg13g2_decap_8
XFILLER_174_1294 VDD VSS sg13g2_decap_8
XFILLER_26_0 VDD VSS sg13g2_decap_8
XFILLER_112_787 VDD VSS sg13g2_decap_8
XFILLER_170_1158 VDD VSS sg13g2_decap_8
X_14479__1723 _14479_/RESET_B VDD VSS sg13g2_tiehi
X_08771_ _13675_/D _08728_/Y _08770_/Y _08769_/Y VDD VSS sg13g2_a21oi_1
XFILLER_61_1442 VDD VSS sg13g2_decap_8
XFILLER_111_275 VDD VSS sg13g2_decap_8
XFILLER_85_638 VDD VSS sg13g2_decap_8
XFILLER_22_1426 VDD VSS sg13g2_decap_8
X_07722_ _07726_/A _15109_/Q _15104_/Q _15103_/Q _15100_/Q VDD VSS sg13g2_nor4_1
XFILLER_66_863 VDD VSS sg13g2_fill_2
XFILLER_38_576 VDD VSS sg13g2_fill_2
X_07653_ _07653_/Y _10429_/D VDD VSS sg13g2_inv_1
XFILLER_26_749 VDD VSS sg13g2_decap_8
XFILLER_0_1233 VDD VSS sg13g2_decap_8
XFILLER_20_1172 VDD VSS sg13g2_decap_8
XFILLER_53_568 VDD VSS sg13g2_fill_1
XFILLER_81_888 VDD VSS sg13g2_decap_8
XFILLER_55_1202 VDD VSS sg13g2_decap_8
XFILLER_94_1262 VDD VSS sg13g2_fill_1
XFILLER_43_18 VDD VSS sg13g2_decap_8
XFILLER_146_1341 VDD VSS sg13g2_decap_8
XFILLER_185_1390 VDD VSS sg13g2_decap_8
X_09323_ _13930_/D _09622_/A0 _13930_/Q _09329_/S VDD VSS sg13g2_mux2_1
XFILLER_90_1104 VDD VSS sg13g2_decap_8
XFILLER_181_1232 VDD VSS sg13g2_decap_8
XFILLER_107_1303 VDD VSS sg13g2_decap_8
XFILLER_90_1137 VDD VSS sg13g2_decap_8
XFILLER_179_776 VDD VSS sg13g2_decap_8
XFILLER_107_1347 VDD VSS sg13g2_decap_8
X_09254_ _13863_/D _13863_/Q _09720_/A0 _09263_/S VDD VSS sg13g2_mux2_1
XFILLER_55_1279 VDD VSS sg13g2_decap_8
XFILLER_22_988 VDD VSS sg13g2_fill_1
XFILLER_166_437 VDD VSS sg13g2_decap_8
XFILLER_178_297 VDD VSS sg13g2_decap_8
X_08205_ _08211_/C _07888_/B _14995_/Q _08204_/Y VDD VSS sg13g2_o21ai_1
X_09185_ _13801_/D _13801_/Q _10152_/A1 _09189_/S VDD VSS sg13g2_mux2_1
XFILLER_147_640 VDD VSS sg13g2_decap_8
XFILLER_105_1071 VDD VSS sg13g2_decap_8
X_13967__2235 _13967_/RESET_B VDD VSS sg13g2_tiehi
XFILLER_5_609 VDD VSS sg13g2_decap_8
XFILLER_153_109 VDD VSS sg13g2_decap_8
X_08136_ _08145_/B _08402_/C _08133_/X _08135_/Y VDD VSS sg13g2_o21ai_1
XFILLER_181_429 VDD VSS sg13g2_decap_8
XFILLER_111_8 VDD VSS sg13g2_fill_1
XFILLER_175_39 VDD VSS sg13g2_decap_8
XFILLER_4_119 VDD VSS sg13g2_decap_8
XFILLER_134_334 VDD VSS sg13g2_decap_8
XFILLER_179_1183 VDD VSS sg13g2_decap_8
X_08067_ _08067_/Y _08402_/C _08064_/X _08397_/A VDD VSS sg13g2_o21ai_1
XFILLER_150_827 VDD VSS sg13g2_fill_2
XFILLER_175_1058 VDD VSS sg13g2_decap_8
XFILLER_89_911 VDD VSS sg13g2_decap_8
XFILLER_162_698 VDD VSS sg13g2_decap_8
XFILLER_1_826 VDD VSS sg13g2_decap_8
XFILLER_153_1312 VDD VSS sg13g2_decap_8
XFILLER_161_197 VDD VSS sg13g2_decap_8
XFILLER_66_1375 VDD VSS sg13g2_decap_8
XFILLER_0_336 VDD VSS sg13g2_decap_8
XFILLER_88_443 VDD VSS sg13g2_decap_8
XFILLER_27_1348 VDD VSS sg13g2_decap_8
XFILLER_76_627 VDD VSS sg13g2_fill_2
XFILLER_76_638 VDD VSS sg13g2_decap_4
XFILLER_29_510 VDD VSS sg13g2_fill_2
X_08969_ _08969_/X _08969_/A _09141_/A _08969_/C VDD VSS sg13g2_and3_1
XFILLER_25_1061 VDD VSS sg13g2_decap_8
X_11980_ _12006_/A _12126_/A _11983_/A VDD VSS sg13g2_nand2_1
XFILLER_75_159 VDD VSS sg13g2_fill_2
XFILLER_5_1155 VDD VSS sg13g2_decap_8
XFILLER_56_340 VDD VSS sg13g2_decap_8
XFILLER_1_1008 VDD VSS sg13g2_decap_8
XFILLER_72_800 VDD VSS sg13g2_decap_8
XFILLER_99_1173 VDD VSS sg13g2_decap_8
XFILLER_57_885 VDD VSS sg13g2_decap_8
X_10931_ _10932_/B _14757_/Q _10954_/B VDD VSS sg13g2_nand2b_1
XFILLER_72_822 VDD VSS sg13g2_decap_4
X_14947__2673 _14947_/RESET_B VDD VSS sg13g2_tiehi
XFILLER_186_1154 VDD VSS sg13g2_decap_8
XFILLER_56_395 VDD VSS sg13g2_decap_8
XFILLER_17_63 VDD VSS sg13g2_decap_8
XFILLER_83_192 VDD VSS sg13g2_decap_8
XFILLER_72_855 VDD VSS sg13g2_decap_8
X_13650_ _15116_/D _15185_/D _15116_/Q _13650_/S VDD VSS sg13g2_mux2_1
X_10862_ _10862_/Y _14932_/Q _10862_/B VDD VSS sg13g2_nand2_1
XFILLER_140_64 VDD VSS sg13g2_fill_2
XFILLER_77_1460 VDD VSS sg13g2_decap_8
XFILLER_13_900 VDD VSS sg13g2_decap_8
XFILLER_38_1433 VDD VSS sg13g2_decap_8
XFILLER_164_1441 VDD VSS sg13g2_decap_8
X_12601_ _12601_/X _14125_/Q _14157_/Q _14189_/Q _14221_/Q _12643_/S0 _12643_/S1 VDD
+ VSS sg13g2_mux4_1
XFILLER_71_387 VDD VSS sg13g2_decap_8
XFILLER_140_97 VDD VSS sg13g2_fill_1
X_13581_ _13581_/Y _15159_/Q _13593_/B VDD VSS sg13g2_nor2_1
X_10793_ _10793_/X _10793_/A _10793_/B _10793_/C VDD VSS sg13g2_and3_1
XFILLER_73_1346 VDD VSS sg13g2_decap_8
XFILLER_25_793 VDD VSS sg13g2_decap_8
XFILLER_169_253 VDD VSS sg13g2_decap_8
X_12532_ _12532_/X _14248_/Q _14280_/Q _14312_/Q _14344_/Q _12536_/S0 _12536_/S1 VDD
+ VSS sg13g2_mux4_1
XFILLER_24_292 VDD VSS sg13g2_decap_8
XFILLER_13_977 VDD VSS sg13g2_decap_8
XFILLER_185_724 VDD VSS sg13g2_decap_8
XFILLER_8_403 VDD VSS sg13g2_decap_8
XFILLER_184_212 VDD VSS sg13g2_decap_8
XFILLER_125_1469 VDD VSS sg13g2_fill_1
XFILLER_130_0 VDD VSS sg13g2_fill_2
XFILLER_149_51 VDD VSS sg13g2_fill_2
XFILLER_9_959 VDD VSS sg13g2_decap_8
X_12463_ _12463_/X _14563_/Q _14595_/Q _14627_/Q _14659_/Q _12466_/S0 _12466_/S1 VDD
+ VSS sg13g2_mux4_1
XFILLER_126_802 VDD VSS sg13g2_decap_4
XFILLER_144_109 VDD VSS sg13g2_decap_8
X_14202_ _14202_/Q _14682_/CLK _14202_/D _14202_/RESET_B VDD VSS sg13g2_dfrbpq_1
X_11414_ _11424_/C _11411_/Y _11413_/X _11830_/B1 VDD VSS sg13g2_o21ai_1
X_14557__1645 _14557_/RESET_B VDD VSS sg13g2_tiehi
X_15182_ _15182_/Q clkload63/A _15182_/D _15182_/RESET_B VDD VSS sg13g2_dfrbpq_1
XFILLER_184_289 VDD VSS sg13g2_decap_8
X_15125__2732 _15125_/RESET_B VDD VSS sg13g2_tiehi
X_12394_ _12394_/X _13950_/Q _13982_/Q _14014_/Q _14046_/Q _12590_/S0 _12590_/S1 VDD
+ VSS sg13g2_mux4_1
XFILLER_181_930 VDD VSS sg13g2_fill_2
XFILLER_125_323 VDD VSS sg13g2_decap_8
XFILLER_10_1330 VDD VSS sg13g2_decap_8
X_14133_ _14133_/Q clkload42/A _14133_/D _14133_/RESET_B VDD VSS sg13g2_dfrbpq_1
X_11345_ _11345_/Y _11368_/S0 _13918_/Q _11355_/B1 VDD VSS sg13g2_a21oi_1
XFILLER_152_131 VDD VSS sg13g2_decap_8
XFILLER_119_1207 VDD VSS sg13g2_decap_8
XFILLER_152_142 VDD VSS sg13g2_fill_1
XFILLER_158_1256 VDD VSS sg13g2_decap_8
XFILLER_99_719 VDD VSS sg13g2_decap_8
XFILLER_3_130 VDD VSS sg13g2_decap_8
XFILLER_141_838 VDD VSS sg13g2_decap_4
X_14064_ _14064_/Q clkload8/A _14064_/D _14064_/RESET_B VDD VSS sg13g2_dfrbpq_1
X_11276_ _11276_/Y _11275_/X _11283_/B _11274_/Y VDD VSS sg13g2_a21oi_1
XFILLER_98_229 VDD VSS sg13g2_decap_8
XFILLER_84_1442 VDD VSS sg13g2_decap_8
XFILLER_4_686 VDD VSS sg13g2_decap_8
XFILLER_140_337 VDD VSS sg13g2_decap_8
X_13015_ _13015_/Y _14780_/Q _13030_/A2 _13030_/B1 VDD VSS sg13g2_o21ai_1
XFILLER_79_432 VDD VSS sg13g2_decap_8
X_10227_ _14770_/D _10234_/D _10435_/A _10227_/C VDD VSS sg13g2_nor3_1
XFILLER_171_1434 VDD VSS sg13g2_decap_8
XFILLER_80_1328 VDD VSS sg13g2_decap_8
XFILLER_45_1459 VDD VSS sg13g2_decap_8
XFILLER_132_1418 VDD VSS sg13g2_decap_8
XFILLER_94_402 VDD VSS sg13g2_decap_8
X_10158_ _14735_/D _14735_/Q _10158_/A1 _10167_/S VDD VSS sg13g2_mux2_1
XFILLER_121_595 VDD VSS sg13g2_decap_8
XFILLER_67_649 VDD VSS sg13g2_decap_4
XFILLER_66_137 VDD VSS sg13g2_decap_8
XFILLER_43_1161 VDD VSS sg13g2_decap_8
XFILLER_130_1120 VDD VSS sg13g2_fill_2
XFILLER_48_852 VDD VSS sg13g2_decap_8
XFILLER_94_468 VDD VSS sg13g2_decap_8
X_14966_ _14966_/Q clkload58/A _14966_/D _14966_/RESET_B VDD VSS sg13g2_dfrbpq_1
X_10089_ _14669_/D _10089_/A0 _14669_/Q _10092_/S VDD VSS sg13g2_mux2_1
XFILLER_75_671 VDD VSS sg13g2_decap_4
XFILLER_35_502 VDD VSS sg13g2_decap_4
X_13917_ _13917_/Q clkload31/A _13917_/D _13917_/RESET_B VDD VSS sg13g2_dfrbpq_1
XFILLER_47_373 VDD VSS sg13g2_fill_2
XFILLER_63_833 VDD VSS sg13g2_fill_1
XFILLER_35_524 VDD VSS sg13g2_decap_4
XFILLER_21_1470 VDD VSS sg13g2_decap_4
X_14897_ _14897_/Q _14930_/CLK _14897_/D _14897_/RESET_B VDD VSS sg13g2_dfrbpq_1
XFILLER_90_630 VDD VSS sg13g2_fill_2
XFILLER_169_1385 VDD VSS sg13g2_decap_8
XFILLER_78_1268 VDD VSS sg13g2_decap_8
XFILLER_63_866 VDD VSS sg13g2_decap_8
XFILLER_74_80 VDD VSS sg13g2_decap_8
XFILLER_165_1238 VDD VSS sg13g2_decap_8
X_13848_ _13848_/Q clkload46/A _13848_/D _13848_/RESET_B VDD VSS sg13g2_dfrbpq_1
XFILLER_16_760 VDD VSS sg13g2_decap_8
XFILLER_23_719 VDD VSS sg13g2_decap_8
XFILLER_91_1402 VDD VSS sg13g2_decap_8
XFILLER_50_505 VDD VSS sg13g2_decap_8
XFILLER_50_516 VDD VSS sg13g2_fill_2
X_13779_ _13779_/Q clkload39/A _13779_/D _13779_/RESET_B VDD VSS sg13g2_dfrbpq_1
X_14757__2982 _14757_/RESET_B VDD VSS sg13g2_tiehi
XFILLER_91_1468 VDD VSS sg13g2_fill_2
XFILLER_176_724 VDD VSS sg13g2_decap_4
XFILLER_149_949 VDD VSS sg13g2_fill_2
XFILLER_31_796 VDD VSS sg13g2_decap_8
XFILLER_54_1290 VDD VSS sg13g2_decap_8
XFILLER_129_651 VDD VSS sg13g2_fill_2
XFILLER_106_1380 VDD VSS sg13g2_decap_8
XFILLER_8_970 VDD VSS sg13g2_decap_8
XFILLER_144_610 VDD VSS sg13g2_fill_2
XFILLER_15_1285 VDD VSS sg13g2_decap_8
XFILLER_50_1176 VDD VSS sg13g2_decap_8
XFILLER_11_1149 VDD VSS sg13g2_decap_8
XFILLER_172_941 VDD VSS sg13g2_decap_8
XFILLER_117_857 VDD VSS sg13g2_decap_8
XFILLER_143_120 VDD VSS sg13g2_decap_8
XFILLER_132_805 VDD VSS sg13g2_decap_8
XFILLER_176_1345 VDD VSS sg13g2_decap_8
XFILLER_89_1397 VDD VSS sg13g2_decap_8
XFILLER_85_1239 VDD VSS sg13g2_decap_8
XFILLER_89_207 VDD VSS sg13g2_decap_8
XFILLER_116_378 VDD VSS sg13g2_decap_8
XFILLER_144_687 VDD VSS sg13g2_decap_8
XFILLER_171_473 VDD VSS sg13g2_decap_8
X_09941_ _14525_/D _14525_/Q _10073_/A0 _09969_/S VDD VSS sg13g2_mux2_1
Xfanout905 _12756_/S0 _12768_/S0 VDD VSS sg13g2_buf_1
Xfanout916 _12983_/A1 _13020_/A1 VDD VSS sg13g2_buf_1
Xfanout927 _13134_/C _15207_/Q VDD VSS sg13g2_buf_1
X_09872_ _09872_/Y _09905_/A _10105_/C _10070_/A _10037_/B VDD VSS sg13g2_nand4_1
XFILLER_97_240 VDD VSS sg13g2_fill_2
XFILLER_112_551 VDD VSS sg13g2_decap_8
XFILLER_174_1091 VDD VSS sg13g2_decap_8
X_14602__1600 _14602_/RESET_B VDD VSS sg13g2_tiehi
Xfanout938 _13300_/B _13308_/B VDD VSS sg13g2_buf_1
XFILLER_48_1094 VDD VSS sg13g2_decap_8
XFILLER_140_871 VDD VSS sg13g2_decap_8
Xfanout949 _13563_/C _13558_/C VDD VSS sg13g2_buf_1
XFILLER_38_18 VDD VSS sg13g2_decap_8
X_08823_ _13691_/D _08821_/Y _08820_/Y _08822_/Y VDD VSS sg13g2_a21oi_1
XFILLER_86_947 VDD VSS sg13g2_fill_2
XFILLER_112_595 VDD VSS sg13g2_decap_8
XFILLER_135_1097 VDD VSS sg13g2_decap_8
XFILLER_85_446 VDD VSS sg13g2_decap_8
XFILLER_100_757 VDD VSS sg13g2_fill_2
XFILLER_6_1453 VDD VSS sg13g2_decap_8
XFILLER_22_1223 VDD VSS sg13g2_decap_8
X_08754_ _08754_/Y _13343_/B _11288_/A _15192_/Q VDD VSS sg13g2_o21ai_1
X_14031__2171 _14031_/RESET_B VDD VSS sg13g2_tiehi
XFILLER_39_885 VDD VSS sg13g2_fill_2
X_07705_ _15201_/D _07705_/A _13279_/D _07705_/C VDD VSS sg13g2_nand3_1
XFILLER_94_980 VDD VSS sg13g2_decap_8
XFILLER_72_118 VDD VSS sg13g2_decap_8
XFILLER_113_1395 VDD VSS sg13g2_decap_8
X_08685_ _15248_/D _08685_/A1 _08684_/X _08676_/Y VDD VSS sg13g2_o21ai_1
XFILLER_93_490 VDD VSS sg13g2_fill_2
XFILLER_96_1357 VDD VSS sg13g2_decap_8
XFILLER_0_1030 VDD VSS sg13g2_decap_8
XFILLER_148_1436 VDD VSS sg13g2_decap_8
XFILLER_183_1316 VDD VSS sg13g2_decap_8
X_07636_ _07636_/Y _15009_/Q VDD VSS sg13g2_inv_1
XFILLER_14_708 VDD VSS sg13g2_decap_8
X_14635__1567 _14635_/RESET_B VDD VSS sg13g2_tiehi
XFILLER_13_207 VDD VSS sg13g2_decap_8
XFILLER_81_696 VDD VSS sg13g2_decap_8
XFILLER_94_1081 VDD VSS sg13g2_fill_2
X_09306_ _13914_/D _13914_/Q _10169_/A1 _09306_/S VDD VSS sg13g2_mux2_1
XFILLER_10_903 VDD VSS sg13g2_decap_8
XFILLER_146_1193 VDD VSS sg13g2_fill_2
XFILLER_110_89 VDD VSS sg13g2_decap_8
XFILLER_107_1166 VDD VSS sg13g2_decap_8
X_09237_ _13848_/D _10167_/A1 _13848_/Q _09239_/S VDD VSS sg13g2_mux2_1
XFILLER_107_1177 VDD VSS sg13g2_fill_1
XFILLER_6_907 VDD VSS sg13g2_decap_8
XFILLER_186_49 VDD VSS sg13g2_decap_8
XFILLER_33_1352 VDD VSS sg13g2_decap_8
XFILLER_108_802 VDD VSS sg13g2_decap_8
XFILLER_148_971 VDD VSS sg13g2_decap_8
XFILLER_154_418 VDD VSS sg13g2_decap_8
XFILLER_5_406 VDD VSS sg13g2_decap_8
XFILLER_119_150 VDD VSS sg13g2_decap_8
XFILLER_120_1333 VDD VSS sg13g2_decap_8
XFILLER_148_993 VDD VSS sg13g2_fill_1
X_09168_ _10070_/B _09441_/A _10004_/B _09441_/C VDD VSS sg13g2_and3_1
XFILLER_163_941 VDD VSS sg13g2_fill_1
XFILLER_119_65 VDD VSS sg13g2_fill_2
XFILLER_135_643 VDD VSS sg13g2_fill_2
XFILLER_163_952 VDD VSS sg13g2_fill_1
X_08119_ _08119_/X _08471_/B _07820_/B _11936_/A _07812_/B _08337_/S0 _08337_/S1 VDD
+ VSS sg13g2_mux4_1
XFILLER_68_1426 VDD VSS sg13g2_decap_8
XFILLER_181_259 VDD VSS sg13g2_decap_8
XFILLER_79_25 VDD VSS sg13g2_decap_8
XFILLER_120_1388 VDD VSS sg13g2_decap_8
X_09099_ _13776_/D _13776_/Q _10159_/A1 _09127_/S VDD VSS sg13g2_mux2_1
XFILLER_162_462 VDD VSS sg13g2_decap_4
X_11130_ _11130_/Y _11129_/Y _11127_/Y _11114_/X _11117_/Y _11193_/A2 VDD VSS sg13g2_a221oi_1
XFILLER_79_58 VDD VSS sg13g2_decap_8
XFILLER_107_389 VDD VSS sg13g2_decap_8
XFILLER_150_624 VDD VSS sg13g2_decap_8
XFILLER_162_484 VDD VSS sg13g2_decap_4
XFILLER_1_623 VDD VSS sg13g2_decap_8
X_14241__1961 _14241_/RESET_B VDD VSS sg13g2_tiehi
XFILLER_135_42 VDD VSS sg13g2_decap_8
X_11061_ _11061_/Y _11068_/C _11086_/A _14760_/Q _11033_/B VDD VSS sg13g2_a22oi_1
XFILLER_66_1172 VDD VSS sg13g2_decap_8
XFILLER_0_133 VDD VSS sg13g2_decap_8
XFILLER_118_1251 VDD VSS sg13g2_fill_2
XFILLER_135_53 VDD VSS sg13g2_decap_8
XFILLER_27_1145 VDD VSS sg13g2_decap_8
XFILLER_131_871 VDD VSS sg13g2_decap_8
Xhold3050 _15172_/D _13485_/B VDD VSS sg13g2_dlygate4sd3_1
XFILLER_88_251 VDD VSS sg13g2_decap_8
Xhold3061 hold3061/X input10/X VDD VSS sg13g2_dlygate4sd3_1
X_10012_ _14594_/D _10045_/A0 _14594_/Q _10023_/S VDD VSS sg13g2_mux2_1
XFILLER_153_1164 VDD VSS sg13g2_decap_8
Xhold3072 input35/A mem_axi_rdata[9] VDD VSS sg13g2_dlygate4sd3_1
XFILLER_7_1239 VDD VSS sg13g2_decap_8
XFILLER_62_1047 VDD VSS sg13g2_fill_1
XFILLER_114_1126 VDD VSS sg13g2_decap_8
XFILLER_135_97 VDD VSS sg13g2_decap_8
XFILLER_153_1175 VDD VSS sg13g2_decap_8
XFILLER_23_1009 VDD VSS sg13g2_decap_4
Xhold3083 hold3083/X input9/X VDD VSS sg13g2_dlygate4sd3_1
XFILLER_77_947 VDD VSS sg13g2_decap_8
Xhold3094 input14/A mem_axi_rdata[19] VDD VSS sg13g2_dlygate4sd3_1
XFILLER_76_446 VDD VSS sg13g2_decap_4
XFILLER_40_1312 VDD VSS sg13g2_decap_8
X_14820_ _14820_/Q _14893_/CLK _14820_/D _14820_/RESET_B VDD VSS sg13g2_dfrbpq_1
X_15154__2672 _15154_/RESET_B VDD VSS sg13g2_tiehi
XFILLER_64_619 VDD VSS sg13g2_decap_8
XFILLER_29_351 VDD VSS sg13g2_decap_4
XFILLER_45_811 VDD VSS sg13g2_decap_8
XFILLER_178_0 VDD VSS sg13g2_decap_8
X_14751_ _14751_/Q _15196_/CLK _14751_/D _14751_/RESET_B VDD VSS sg13g2_dfrbpq_1
X_11963_ _11964_/A _14256_/Q _14288_/Q _14320_/Q _14352_/Q _11963_/S0 _11963_/S1 VDD
+ VSS sg13g2_mux4_1
XFILLER_57_693 VDD VSS sg13g2_decap_8
XFILLER_40_1389 VDD VSS sg13g2_decap_8
X_13702_ _16864_/A clkload58/A _13702_/D _13702_/RESET_B VDD VSS sg13g2_dfrbpq_1
X_10914_ _10914_/Y _10914_/A _10929_/B VDD VSS sg13g2_nand2_1
XFILLER_75_1419 VDD VSS sg13g2_decap_8
X_14682_ _14682_/Q _14682_/CLK _14682_/D _14682_/RESET_B VDD VSS sg13g2_dfrbpq_1
X_11894_ _11898_/A _11893_/X _11894_/B VDD VSS sg13g2_nand2b_1
XFILLER_72_674 VDD VSS sg13g2_decap_4
XFILLER_38_1230 VDD VSS sg13g2_decap_8
X_13633_ _13741_/D _13633_/A VDD VSS sg13g2_buf_1
X_10845_ _10845_/Y _10876_/D _10876_/A _10843_/C VDD VSS sg13g2_a21oi_1
X_13693__2509 _13693_/RESET_B VDD VSS sg13g2_tiehi
XFILLER_73_1143 VDD VSS sg13g2_decap_8
XFILLER_158_713 VDD VSS sg13g2_fill_1
X_13564_ _13564_/Y _07910_/A _13567_/A2 _13563_/Y VDD VSS sg13g2_a21oi_1
X_10776_ _10776_/X _10776_/A _10793_/B _10793_/A VDD VSS sg13g2_and3_1
XFILLER_8_200 VDD VSS sg13g2_decap_8
XFILLER_13_785 VDD VSS sg13g2_decap_8
XFILLER_185_532 VDD VSS sg13g2_decap_8
XFILLER_34_1138 VDD VSS sg13g2_decap_8
XFILLER_12_273 VDD VSS sg13g2_decap_8
XFILLER_160_1157 VDD VSS sg13g2_decap_8
X_12515_ _12515_/X _13831_/Q _13863_/Q _13895_/Q _13927_/Q _12520_/S0 _12520_/S1 VDD
+ VSS sg13g2_mux4_1
X_13495_ _13495_/Y _15129_/Q _15071_/Q _13507_/B VDD VSS sg13g2_o21ai_1
XFILLER_9_756 VDD VSS sg13g2_decap_8
XFILLER_51_1452 VDD VSS sg13g2_decap_8
XFILLER_12_1425 VDD VSS sg13g2_decap_8
X_15234_ _15234_/Q clkload54/A _15234_/D _15234_/RESET_B VDD VSS sg13g2_dfrbpq_1
X_12446_ _12446_/X _13730_/Q _14082_/Q _14434_/Q _14530_/Q _12450_/S0 _12450_/S1 VDD
+ VSS sg13g2_mux4_1
XFILLER_173_749 VDD VSS sg13g2_decap_8
XFILLER_8_277 VDD VSS sg13g2_decap_8
X_14073__2129 _14073_/RESET_B VDD VSS sg13g2_tiehi
XFILLER_138_492 VDD VSS sg13g2_decap_8
X_15165_ _15165_/Q _15165_/CLK _15165_/D _15165_/RESET_B VDD VSS sg13g2_dfrbpq_1
X_12377_ _12377_/X _13821_/Q _13853_/Q _13885_/Q _13917_/Q _12703_/S0 _12703_/S1 VDD
+ VSS sg13g2_mux4_1
XFILLER_114_805 VDD VSS sg13g2_fill_1
XFILLER_126_665 VDD VSS sg13g2_decap_4
XFILLER_154_974 VDD VSS sg13g2_fill_1
XFILLER_181_760 VDD VSS sg13g2_fill_2
XFILLER_126_687 VDD VSS sg13g2_decap_8
XFILLER_158_1053 VDD VSS sg13g2_decap_8
XFILLER_5_973 VDD VSS sg13g2_decap_8
X_14116_ _14116_/Q _14510_/CLK _14116_/D _14116_/RESET_B VDD VSS sg13g2_dfrbpq_1
X_11328_ _11328_/X _13949_/Q _13981_/Q _14013_/Q _14045_/Q _11328_/S0 _11328_/S1 VDD
+ VSS sg13g2_mux4_1
XFILLER_181_793 VDD VSS sg13g2_decap_4
X_15096_ _15096_/Q clkload70/A _15096_/D _15096_/RESET_B VDD VSS sg13g2_dfrbpq_1
XFILLER_113_326 VDD VSS sg13g2_fill_2
XFILLER_5_77 VDD VSS sg13g2_decap_8
XFILLER_4_483 VDD VSS sg13g2_decap_8
XFILLER_140_134 VDD VSS sg13g2_fill_2
XFILLER_84_1261 VDD VSS sg13g2_decap_8
XFILLER_113_359 VDD VSS sg13g2_fill_2
X_14047_ _14047_/Q _14655_/CLK _14047_/D _14047_/RESET_B VDD VSS sg13g2_dfrbpq_1
X_14713__1489 _14713_/RESET_B VDD VSS sg13g2_tiehi
X_11259_ _11259_/Y _12186_/A _13820_/Q VDD VSS sg13g2_nand2b_1
XFILLER_171_1231 VDD VSS sg13g2_decap_8
XFILLER_95_700 VDD VSS sg13g2_fill_1
XFILLER_45_1256 VDD VSS sg13g2_decap_8
XFILLER_68_936 VDD VSS sg13g2_fill_1
XFILLER_94_221 VDD VSS sg13g2_decap_4
XFILLER_39_126 VDD VSS sg13g2_fill_2
XFILLER_132_1248 VDD VSS sg13g2_fill_1
XFILLER_68_969 VDD VSS sg13g2_decap_8
XFILLER_83_917 VDD VSS sg13g2_decap_4
XFILLER_55_608 VDD VSS sg13g2_fill_1
XFILLER_54_129 VDD VSS sg13g2_decap_8
X_14949_ _14949_/Q _15240_/CLK _14949_/D _14949_/RESET_B VDD VSS sg13g2_dfrbpq_1
XFILLER_63_630 VDD VSS sg13g2_decap_8
XFILLER_35_321 VDD VSS sg13g2_decap_8
XFILLER_47_192 VDD VSS sg13g2_decap_8
X_08470_ _08475_/B _08541_/A _08470_/B _15008_/Q VDD VSS sg13g2_and3_1
XFILLER_91_961 VDD VSS sg13g2_fill_1
XFILLER_36_877 VDD VSS sg13g2_decap_8
XFILLER_169_1182 VDD VSS sg13g2_decap_8
XFILLER_62_140 VDD VSS sg13g2_decap_8
XFILLER_51_814 VDD VSS sg13g2_decap_8
XFILLER_1_1372 VDD VSS sg13g2_decap_8
XFILLER_78_1098 VDD VSS sg13g2_fill_2
XFILLER_126_1019 VDD VSS sg13g2_decap_8
XFILLER_91_1232 VDD VSS sg13g2_decap_8
XFILLER_51_869 VDD VSS sg13g2_decap_8
X_14283__1919 _14283_/RESET_B VDD VSS sg13g2_tiehi
XFILLER_93_0 VDD VSS sg13g2_decap_8
XFILLER_91_1254 VDD VSS sg13g2_fill_1
XFILLER_56_1374 VDD VSS sg13g2_decap_8
XFILLER_149_724 VDD VSS sg13g2_decap_8
XFILLER_17_1336 VDD VSS sg13g2_decap_8
XFILLER_91_1265 VDD VSS sg13g2_decap_8
XFILLER_176_521 VDD VSS sg13g2_decap_8
XFILLER_50_379 VDD VSS sg13g2_decap_8
XFILLER_143_1344 VDD VSS sg13g2_fill_1
XFILLER_148_234 VDD VSS sg13g2_decap_4
XFILLER_52_1249 VDD VSS sg13g2_decap_8
XFILLER_136_407 VDD VSS sg13g2_decap_8
X_09022_ _09024_/B _12957_/A _10702_/A _14902_/Q _09022_/D VDD VSS sg13g2_nand4_1
XFILLER_178_1418 VDD VSS sg13g2_decap_8
XFILLER_129_470 VDD VSS sg13g2_decap_4
XFILLER_15_1082 VDD VSS sg13g2_decap_8
X_14049__2153 _14049_/RESET_B VDD VSS sg13g2_tiehi
XFILLER_89_1172 VDD VSS sg13g2_decap_8
XFILLER_102_1074 VDD VSS sg13g2_decap_8
XFILLER_144_451 VDD VSS sg13g2_decap_8
XFILLER_176_1142 VDD VSS sg13g2_decap_8
XFILLER_85_1025 VDD VSS sg13g2_fill_1
XFILLER_116_164 VDD VSS sg13g2_fill_1
XFILLER_144_473 VDD VSS sg13g2_decap_4
XFILLER_104_315 VDD VSS sg13g2_decap_8
XFILLER_160_933 VDD VSS sg13g2_decap_4
XFILLER_171_270 VDD VSS sg13g2_decap_8
XFILLER_144_495 VDD VSS sg13g2_decap_8
XFILLER_132_646 VDD VSS sg13g2_fill_1
XFILLER_49_28 VDD VSS sg13g2_decap_8
XFILLER_172_18 VDD VSS sg13g2_decap_8
Xfanout702 _13479_/S _13336_/S VDD VSS sg13g2_buf_1
X_09924_ _14509_/D _14509_/Q _10156_/A1 _09927_/S VDD VSS sg13g2_mux2_1
Xfanout713 _12101_/B _11443_/A VDD VSS sg13g2_buf_1
XFILLER_63_1323 VDD VSS sg13g2_decap_8
XFILLER_160_999 VDD VSS sg13g2_decap_8
Xfanout724 _11359_/B fanout725/X VDD VSS sg13g2_buf_1
XFILLER_115_1413 VDD VSS sg13g2_decap_8
Xfanout735 _12088_/B _12112_/B1 VDD VSS sg13g2_buf_1
Xfanout746 _10886_/A2 _07653_/Y VDD VSS sg13g2_buf_1
XFILLER_59_947 VDD VSS sg13g2_decap_4
XFILLER_115_1435 VDD VSS sg13g2_fill_2
Xfanout757 _07753_/D _07649_/Y VDD VSS sg13g2_buf_1
X_09855_ _14442_/D _14442_/Q _10153_/A1 _09859_/S VDD VSS sg13g2_mux2_1
XFILLER_115_1446 VDD VSS sg13g2_fill_2
XFILLER_150_1326 VDD VSS sg13g2_decap_4
Xfanout768 _08234_/B _08426_/A VDD VSS sg13g2_buf_1
XFILLER_58_435 VDD VSS sg13g2_decap_8
Xfanout779 _13550_/A1 _07626_/Y VDD VSS sg13g2_buf_1
XFILLER_59_969 VDD VSS sg13g2_fill_2
XFILLER_115_1468 VDD VSS sg13g2_decap_8
X_08806_ _08808_/A _10843_/C _14752_/Q _08727_/X _15195_/Q _13392_/A2 VDD VSS sg13g2_a221oi_1
XFILLER_74_917 VDD VSS sg13g2_fill_1
XFILLER_6_1250 VDD VSS sg13g2_decap_8
X_09786_ _14375_/D _09918_/A1 _14375_/Q _09795_/S VDD VSS sg13g2_mux2_1
XFILLER_46_619 VDD VSS sg13g2_decap_8
XFILLER_73_416 VDD VSS sg13g2_decap_4
XFILLER_85_287 VDD VSS sg13g2_fill_1
XFILLER_171_7 VDD VSS sg13g2_decap_8
XFILLER_22_1064 VDD VSS sg13g2_decap_8
X_08737_ _08737_/Y _13664_/Q _08752_/B VDD VSS sg13g2_nor2_1
XFILLER_38_170 VDD VSS sg13g2_decap_8
XFILLER_148_1200 VDD VSS sg13g2_decap_8
XFILLER_96_1132 VDD VSS sg13g2_decap_8
XFILLER_22_1097 VDD VSS sg13g2_decap_8
XFILLER_96_1154 VDD VSS sg13g2_decap_8
XFILLER_2_1169 VDD VSS sg13g2_decap_8
XFILLER_183_1113 VDD VSS sg13g2_decap_8
X_08668_ _08668_/X _08668_/A _08668_/B VDD VSS sg13g2_or2_1
XFILLER_148_1233 VDD VSS sg13g2_decap_4
XFILLER_53_140 VDD VSS sg13g2_decap_8
XFILLER_42_825 VDD VSS sg13g2_decap_4
XFILLER_148_1255 VDD VSS sg13g2_decap_8
XFILLER_96_1187 VDD VSS sg13g2_fill_2
XFILLER_92_1018 VDD VSS sg13g2_decap_8
XFILLER_82_994 VDD VSS sg13g2_decap_8
XFILLER_121_66 VDD VSS sg13g2_decap_8
XFILLER_57_1149 VDD VSS sg13g2_decap_8
X_07619_ _09011_/C _14900_/Q VDD VSS sg13g2_inv_1
XFILLER_144_1119 VDD VSS sg13g2_decap_8
X_08599_ _08600_/D _08599_/A _08599_/B _08599_/C VDD VSS sg13g2_nor3_1
X_10630_ _14884_/D _10630_/A _10630_/B _10630_/C VDD VSS sg13g2_and3_1
XFILLER_161_1422 VDD VSS sg13g2_decap_8
XFILLER_186_329 VDD VSS sg13g2_decap_8
XFILLER_41_368 VDD VSS sg13g2_decap_8
XFILLER_14_42 VDD VSS sg13g2_decap_8
X_14259__1943 _14259_/RESET_B VDD VSS sg13g2_tiehi
XFILLER_35_1436 VDD VSS sg13g2_decap_8
XFILLER_10_700 VDD VSS sg13g2_decap_8
XFILLER_50_880 VDD VSS sg13g2_decap_8
XFILLER_50_891 VDD VSS sg13g2_fill_2
XFILLER_122_1417 VDD VSS sg13g2_decap_8
X_10561_ _10653_/A _10561_/A _10561_/B _10561_/C _10561_/D VDD VSS sg13g2_nor4_1
XFILLER_139_256 VDD VSS sg13g2_decap_8
XFILLER_139_267 VDD VSS sg13g2_fill_1
X_12300_ _12300_/Y _14988_/Q _13662_/Q VDD VSS sg13g2_xnor2_1
XFILLER_6_704 VDD VSS sg13g2_decap_8
XFILLER_127_418 VDD VSS sg13g2_decap_8
XFILLER_155_727 VDD VSS sg13g2_fill_1
XFILLER_10_777 VDD VSS sg13g2_decap_8
XFILLER_139_289 VDD VSS sg13g2_decap_8
XFILLER_155_738 VDD VSS sg13g2_fill_2
XFILLER_182_524 VDD VSS sg13g2_decap_8
X_13280_ _13281_/A _08832_/D _07752_/Y _13279_/Y VDD VSS sg13g2_a21oi_1
X_10492_ _10492_/Y _10513_/D _14850_/Q _10492_/C _10508_/C VDD VSS sg13g2_nand4_1
XFILLER_5_203 VDD VSS sg13g2_decap_8
X_12231_ _12231_/X _12231_/A _12231_/B VDD VSS sg13g2_xor2_1
XFILLER_170_719 VDD VSS sg13g2_fill_1
XFILLER_68_1223 VDD VSS sg13g2_decap_8
XFILLER_163_760 VDD VSS sg13g2_decap_8
XFILLER_107_153 VDD VSS sg13g2_decap_8
XFILLER_151_911 VDD VSS sg13g2_decap_8
XFILLER_30_63 VDD VSS sg13g2_fill_2
XFILLER_108_687 VDD VSS sg13g2_decap_8
XFILLER_123_624 VDD VSS sg13g2_fill_2
XFILLER_146_52 VDD VSS sg13g2_fill_2
X_12162_ _12163_/A _13974_/Q _14006_/Q _14038_/Q _14070_/Q _12168_/A _12169_/C VDD
+ VSS sg13g2_mux4_1
XFILLER_2_910 VDD VSS sg13g2_decap_8
XFILLER_146_63 VDD VSS sg13g2_fill_2
XFILLER_155_1215 VDD VSS sg13g2_fill_2
XFILLER_159_1395 VDD VSS sg13g2_decap_8
XFILLER_162_281 VDD VSS sg13g2_decap_8
XFILLER_123_657 VDD VSS sg13g2_fill_2
XFILLER_1_420 VDD VSS sg13g2_decap_8
X_11113_ _11113_/Y _14950_/Q _11133_/B VDD VSS sg13g2_nand2_1
XFILLER_151_977 VDD VSS sg13g2_decap_4
XFILLER_81_1412 VDD VSS sg13g2_decap_8
X_12093_ _12094_/A _13972_/Q _14004_/Q _14036_/Q _14068_/Q _12087_/S _12091_/C VDD
+ VSS sg13g2_mux4_1
XFILLER_96_519 VDD VSS sg13g2_decap_4
XFILLER_104_871 VDD VSS sg13g2_decap_8
XFILLER_122_167 VDD VSS sg13g2_decap_4
XFILLER_2_987 VDD VSS sg13g2_decap_8
X_11044_ _11046_/A _11044_/A _11044_/B _11044_/C VDD VSS sg13g2_nand3_1
XFILLER_39_50 VDD VSS sg13g2_decap_8
XFILLER_1_497 VDD VSS sg13g2_decap_8
XFILLER_7_1036 VDD VSS sg13g2_decap_8
XFILLER_39_61 VDD VSS sg13g2_fill_1
XFILLER_42_1429 VDD VSS sg13g2_decap_8
X_13747__2455 _13747_/RESET_B VDD VSS sg13g2_tiehi
XFILLER_64_405 VDD VSS sg13g2_fill_1
XFILLER_162_95 VDD VSS sg13g2_decap_8
XFILLER_92_725 VDD VSS sg13g2_decap_8
X_14803_ _14803_/Q clkload66/A _14803_/D _14803_/RESET_B VDD VSS sg13g2_dfrbpq_1
XFILLER_76_287 VDD VSS sg13g2_decap_8
XFILLER_131_1270 VDD VSS sg13g2_decap_4
XFILLER_131_1292 VDD VSS sg13g2_decap_8
X_12995_ _13005_/A _13010_/A _13079_/C _12995_/C VDD VSS sg13g2_nand3_1
XFILLER_40_1186 VDD VSS sg13g2_decap_8
XFILLER_166_1311 VDD VSS sg13g2_decap_8
X_14734_ _14734_/Q clkload19/A _14734_/D _14734_/RESET_B VDD VSS sg13g2_dfrbpq_1
XFILLER_79_1374 VDD VSS sg13g2_decap_8
XFILLER_55_60 VDD VSS sg13g2_decap_8
X_11946_ _11946_/X _11946_/A _11973_/B VDD VSS sg13g2_and2_1
XFILLER_75_1216 VDD VSS sg13g2_decap_8
XFILLER_44_162 VDD VSS sg13g2_decap_8
XFILLER_127_1306 VDD VSS sg13g2_fill_2
XFILLER_178_808 VDD VSS sg13g2_decap_8
X_13962__2240 _13962_/RESET_B VDD VSS sg13g2_tiehi
X_14127__2075 _14127_/RESET_B VDD VSS sg13g2_tiehi
XFILLER_44_173 VDD VSS sg13g2_fill_2
X_14665_ _14665_/Q _14665_/CLK _14665_/D _14665_/RESET_B VDD VSS sg13g2_dfrbpq_1
XFILLER_166_1388 VDD VSS sg13g2_decap_8
X_11877_ _11877_/Y _11882_/S0 _14574_/Q VDD VSS sg13g2_nand2b_1
X_13616_ _13724_/D _13616_/A VDD VSS sg13g2_buf_1
Xclkbuf_5_16__f_clk_i clkbuf_leaf_99_clk_i/A clkbuf_4_8_0_clk_i/X VDD VSS sg13g2_buf_16
X_10828_ _10831_/B _10851_/D _12347_/B VDD VSS sg13g2_nand2_1
X_14596_ _14596_/Q clkload49/A _14596_/D _14596_/RESET_B VDD VSS sg13g2_dfrbpq_1
XFILLER_13_571 VDD VSS sg13g2_decap_8
XFILLER_71_70 VDD VSS sg13g2_decap_8
X_13547_ _13547_/Y _13547_/A _13554_/S VDD VSS sg13g2_nor2_1
XFILLER_71_81 VDD VSS sg13g2_decap_4
X_10759_ _10759_/X _14948_/Q _10757_/A _10757_/Y VDD VSS sg13g2_a21o_1
XFILLER_9_553 VDD VSS sg13g2_decap_8
XFILLER_158_576 VDD VSS sg13g2_fill_2
XFILLER_186_896 VDD VSS sg13g2_decap_8
XFILLER_12_1222 VDD VSS sg13g2_decap_8
X_13478_ _15113_/D _15179_/D _15113_/Q _13480_/S VDD VSS sg13g2_mux2_1
XFILLER_65_4 VDD VSS sg13g2_decap_8
X_15217_ _15217_/Q clkload81/A _15217_/D _15217_/RESET_B VDD VSS sg13g2_dfrbpq_1
X_12429_ _12429_/Y _13688_/Q _12651_/A2 _12428_/X _12624_/B2 _12624_/C1 VDD VSS sg13g2_a221oi_1
XFILLER_114_602 VDD VSS sg13g2_decap_8
XFILLER_160_207 VDD VSS sg13g2_fill_1
XFILLER_160_218 VDD VSS sg13g2_decap_8
XFILLER_114_613 VDD VSS sg13g2_fill_2
XFILLER_12_1299 VDD VSS sg13g2_decap_8
XFILLER_86_1356 VDD VSS sg13g2_decap_8
XFILLER_5_770 VDD VSS sg13g2_decap_8
XFILLER_114_624 VDD VSS sg13g2_fill_1
X_15148_ _15148_/Q _15162_/CLK _15148_/D _15148_/RESET_B VDD VSS sg13g2_dfrbpq_1
XFILLER_99_324 VDD VSS sg13g2_decap_8
XFILLER_138_1435 VDD VSS sg13g2_fill_2
XFILLER_141_421 VDD VSS sg13g2_fill_1
XFILLER_99_335 VDD VSS sg13g2_fill_2
XFILLER_113_123 VDD VSS sg13g2_decap_8
XFILLER_173_1337 VDD VSS sg13g2_decap_8
XFILLER_4_280 VDD VSS sg13g2_decap_8
XFILLER_114_668 VDD VSS sg13g2_decap_4
X_07970_ _07976_/A _08697_/B _07834_/A _07981_/C VDD VSS sg13g2_o21ai_1
X_15079_ _15079_/Q _15203_/CLK _15079_/D _15079_/RESET_B VDD VSS sg13g2_dfrbpq_1
XFILLER_68_733 VDD VSS sg13g2_decap_4
XFILLER_45_1053 VDD VSS sg13g2_decap_8
XFILLER_110_830 VDD VSS sg13g2_decap_8
XFILLER_171_1094 VDD VSS sg13g2_fill_2
X_09640_ _09740_/B _10137_/A _09938_/B _09938_/A VDD VSS sg13g2_nand3b_1
X_14337__1865 _14337_/RESET_B VDD VSS sg13g2_tiehi
X_09571_ _14169_/D _09969_/A1 _14169_/Q _09571_/S VDD VSS sg13g2_mux2_1
XFILLER_83_747 VDD VSS sg13g2_decap_4
XFILLER_82_224 VDD VSS sg13g2_decap_8
XFILLER_67_298 VDD VSS sg13g2_decap_4
XFILLER_23_1395 VDD VSS sg13g2_decap_8
X_08522_ _08526_/B _08522_/A _08548_/B _08522_/C VDD VSS sg13g2_nand3_1
XFILLER_3_1467 VDD VSS sg13g2_decap_8
XFILLER_3_1478 VDD VSS sg13g2_fill_1
XFILLER_110_1365 VDD VSS sg13g2_decap_8
XFILLER_184_1422 VDD VSS sg13g2_decap_8
XFILLER_82_268 VDD VSS sg13g2_decap_8
XFILLER_36_663 VDD VSS sg13g2_decap_8
XFILLER_35_140 VDD VSS sg13g2_decap_8
XFILLER_93_1316 VDD VSS sg13g2_decap_8
XFILLER_70_419 VDD VSS sg13g2_decap_8
X_08453_ _08454_/C _13555_/A _08493_/B2 _07993_/Y VDD VSS sg13g2_a21oi_1
XFILLER_91_791 VDD VSS sg13g2_decap_8
XFILLER_58_1469 VDD VSS sg13g2_decap_8
XFILLER_51_633 VDD VSS sg13g2_decap_8
XFILLER_180_1308 VDD VSS sg13g2_decap_8
X_14552__1650 _14552_/RESET_B VDD VSS sg13g2_tiehi
XFILLER_50_121 VDD VSS sg13g2_decap_8
XFILLER_145_1439 VDD VSS sg13g2_decap_8
XFILLER_168_307 VDD VSS sg13g2_decap_8
XFILLER_11_508 VDD VSS sg13g2_decap_8
X_08384_ _08385_/C _08457_/A3 _08383_/B _08001_/A VDD VSS sg13g2_a21oi_1
XFILLER_56_1171 VDD VSS sg13g2_decap_8
XFILLER_17_1133 VDD VSS sg13g2_decap_8
XFILLER_91_1084 VDD VSS sg13g2_decap_8
XFILLER_177_863 VDD VSS sg13g2_decap_8
XFILLER_108_1283 VDD VSS sg13g2_fill_1
XFILLER_167_18 VDD VSS sg13g2_decap_8
XFILLER_176_351 VDD VSS sg13g2_decap_8
XFILLER_149_576 VDD VSS sg13g2_decap_8
XFILLER_13_1019 VDD VSS sg13g2_decap_8
XFILLER_30_1300 VDD VSS sg13g2_decap_8
XFILLER_137_738 VDD VSS sg13g2_fill_2
XFILLER_178_1215 VDD VSS sg13g2_decap_8
X_09005_ _09022_/D _09011_/B _09011_/C _09011_/D VDD VSS sg13g2_nor3_1
X_13825__2377 _13825_/RESET_B VDD VSS sg13g2_tiehi
XFILLER_164_568 VDD VSS sg13g2_decap_8
XFILLER_117_451 VDD VSS sg13g2_decap_8
XFILLER_3_718 VDD VSS sg13g2_decap_8
XFILLER_30_1377 VDD VSS sg13g2_decap_8
XFILLER_105_613 VDD VSS sg13g2_fill_2
XFILLER_133_933 VDD VSS sg13g2_decap_8
XFILLER_2_217 VDD VSS sg13g2_decap_8
XFILLER_104_112 VDD VSS sg13g2_decap_8
XFILLER_132_421 VDD VSS sg13g2_decap_4
XFILLER_172_590 VDD VSS sg13g2_decap_8
XFILLER_183_39 VDD VSS sg13g2_decap_8
XFILLER_132_465 VDD VSS sg13g2_decap_8
XFILLER_78_519 VDD VSS sg13g2_fill_2
Xfanout510 _13648_/S _10202_/S VDD VSS sg13g2_buf_1
XFILLER_120_627 VDD VSS sg13g2_fill_2
Xfanout521 _13535_/B _13515_/S VDD VSS sg13g2_buf_1
Xfanout532 _12777_/A2 _12791_/A2 VDD VSS sg13g2_buf_1
X_09907_ _14492_/D _14492_/Q _09907_/A1 _09937_/S VDD VSS sg13g2_mux2_1
XFILLER_8_1334 VDD VSS sg13g2_decap_8
XFILLER_63_1142 VDD VSS sg13g2_decap_8
XFILLER_115_1221 VDD VSS sg13g2_decap_8
Xfanout543 _10072_/A0 _10105_/A VDD VSS sg13g2_buf_1
XFILLER_28_1273 VDD VSS sg13g2_decap_8
Xfanout554 _09158_/A _09162_/A VDD VSS sg13g2_buf_1
Xfanout565 fanout565/X _08723_/Y VDD VSS sg13g2_buf_1
XFILLER_59_755 VDD VSS sg13g2_decap_8
XFILLER_24_1137 VDD VSS sg13g2_decap_8
Xfanout576 _13546_/B2 _12936_/Y VDD VSS sg13g2_buf_1
Xfanout587 _13272_/A2 _13264_/A2 VDD VSS sg13g2_buf_1
X_09838_ _14426_/D _09904_/A0 _14426_/Q _09838_/S VDD VSS sg13g2_mux2_1
XFILLER_63_1197 VDD VSS sg13g2_decap_8
Xfanout598 _10875_/B _10800_/B VDD VSS sg13g2_buf_1
XFILLER_100_373 VDD VSS sg13g2_decap_8
XFILLER_115_1298 VDD VSS sg13g2_decap_8
XFILLER_132_32 VDD VSS sg13g2_fill_1
XFILLER_185_1208 VDD VSS sg13g2_decap_8
X_09769_ _14359_/D _14359_/Q _10066_/A0 _09771_/S VDD VSS sg13g2_mux2_1
XFILLER_92_14 VDD VSS sg13g2_decap_8
X_11800_ _11800_/Y _12056_/A _11800_/B VDD VSS sg13g2_xnor2_1
XFILLER_61_408 VDD VSS sg13g2_fill_1
XFILLER_26_140 VDD VSS sg13g2_fill_2
X_12780_ _12780_/X _14138_/Q _14170_/Q _14202_/Q _14234_/Q _12787_/S0 _12787_/S1 VDD
+ VSS sg13g2_mux4_1
XFILLER_61_419 VDD VSS sg13g2_fill_2
XFILLER_42_622 VDD VSS sg13g2_decap_8
X_11731_ _11731_/Y _11759_/A _14154_/Q _11742_/C VDD VSS sg13g2_a21oi_1
XFILLER_109_1025 VDD VSS sg13g2_decap_8
XFILLER_14_346 VDD VSS sg13g2_decap_8
X_14450_ _14450_/Q _14546_/CLK _14450_/D _14450_/RESET_B VDD VSS sg13g2_dfrbpq_1
XFILLER_30_817 VDD VSS sg13g2_decap_8
XFILLER_186_126 VDD VSS sg13g2_decap_8
X_11662_ _11664_/B _11663_/A _11663_/B _11773_/B VDD VSS sg13g2_a21oi_1
XFILLER_74_1282 VDD VSS sg13g2_decap_8
XFILLER_35_1233 VDD VSS sg13g2_decap_8
X_13401_ _13433_/A _13438_/B _13401_/B _13401_/C VDD VSS sg13g2_nand3b_1
X_10613_ _10625_/D _10613_/A _10614_/B VDD VSS sg13g2_nor2_1
XFILLER_122_1214 VDD VSS sg13g2_decap_8
XFILLER_167_340 VDD VSS sg13g2_decap_8
X_14381_ _14381_/Q clkload24/A _14381_/D _14381_/RESET_B VDD VSS sg13g2_dfrbpq_1
X_11593_ _11593_/Y _11636_/C _11593_/B VDD VSS sg13g2_xnor2_1
XFILLER_31_1108 VDD VSS sg13g2_decap_4
XFILLER_155_502 VDD VSS sg13g2_decap_8
XFILLER_70_1168 VDD VSS sg13g2_decap_8
XFILLER_6_501 VDD VSS sg13g2_decap_8
XFILLER_127_215 VDD VSS sg13g2_decap_4
XFILLER_128_738 VDD VSS sg13g2_decap_8
XFILLER_161_1296 VDD VSS sg13g2_decap_8
XFILLER_167_384 VDD VSS sg13g2_decap_8
XFILLER_183_833 VDD VSS sg13g2_fill_1
X_13332_ _15175_/D hold3055/X _15175_/Q _13340_/S VDD VSS sg13g2_mux2_1
X_10544_ _14863_/D _10544_/A _10544_/B _10544_/C VDD VSS sg13g2_and3_1
XFILLER_10_574 VDD VSS sg13g2_decap_8
XFILLER_183_866 VDD VSS sg13g2_decap_8
XFILLER_182_354 VDD VSS sg13g2_decap_8
XFILLER_143_719 VDD VSS sg13g2_decap_4
X_13263_ _13263_/Y _13260_/Y _13261_/Y _13262_/Y VDD VSS sg13g2_a21oi_1
X_14415__1787 _14415_/RESET_B VDD VSS sg13g2_tiehi
X_10475_ _14846_/D _10504_/C _10492_/C _10474_/Y VDD VSS sg13g2_a21oi_1
XFILLER_136_760 VDD VSS sg13g2_fill_1
X_15052__2544 _15052_/RESET_B VDD VSS sg13g2_tiehi
XFILLER_6_578 VDD VSS sg13g2_decap_8
XFILLER_108_473 VDD VSS sg13g2_fill_1
XFILLER_124_922 VDD VSS sg13g2_fill_2
X_15002_ _15002_/Q _15230_/CLK _15002_/D _15002_/RESET_B VDD VSS sg13g2_dfrbpq_1
X_12214_ _12214_/Y _12213_/X _12219_/S VDD VSS sg13g2_nand2b_1
XFILLER_123_410 VDD VSS sg13g2_decap_8
XFILLER_136_793 VDD VSS sg13g2_decap_8
XFILLER_170_549 VDD VSS sg13g2_decap_8
X_13194_ _13196_/B _14856_/Q _13273_/B VDD VSS sg13g2_nand2_1
XFILLER_68_1053 VDD VSS sg13g2_fill_1
XFILLER_159_1192 VDD VSS sg13g2_decap_8
XFILLER_124_977 VDD VSS sg13g2_decap_8
X_12145_ _12145_/Y _11330_/S _12141_/X _12144_/Y VDD VSS sg13g2_o21ai_1
XFILLER_97_828 VDD VSS sg13g2_decap_8
XFILLER_111_616 VDD VSS sg13g2_decap_8
XFILLER_155_1067 VDD VSS sg13g2_decap_8
X_14594__1608 _14594_/RESET_B VDD VSS sg13g2_tiehi
XFILLER_46_1351 VDD VSS sg13g2_decap_8
XFILLER_123_498 VDD VSS sg13g2_decap_8
XFILLER_2_784 VDD VSS sg13g2_decap_8
X_12076_ _12076_/X _12073_/X _12072_/X _12069_/X _12068_/X _12219_/S _12142_/S1 VDD
+ VSS sg13g2_mux4_1
XFILLER_110_137 VDD VSS sg13g2_decap_4
X_14630__1572 _14630_/RESET_B VDD VSS sg13g2_tiehi
XFILLER_1_294 VDD VSS sg13g2_decap_8
XFILLER_42_1226 VDD VSS sg13g2_decap_8
X_11027_ _11027_/Y _11052_/D _11024_/B _07649_/A VDD VSS sg13g2_a21oi_1
XFILLER_81_1286 VDD VSS sg13g2_decap_8
XFILLER_38_917 VDD VSS sg13g2_decap_8
XFILLER_2_56 VDD VSS sg13g2_decap_8
X_16884_ _16884_/X _16884_/A VDD VSS sg13g2_buf_1
XFILLER_38_928 VDD VSS sg13g2_fill_2
XFILLER_133_1376 VDD VSS sg13g2_decap_8
XFILLER_66_70 VDD VSS sg13g2_decap_8
XFILLER_64_224 VDD VSS sg13g2_decap_8
XFILLER_37_438 VDD VSS sg13g2_fill_1
XFILLER_92_544 VDD VSS sg13g2_fill_1
XFILLER_17_140 VDD VSS sg13g2_decap_8
XFILLER_52_419 VDD VSS sg13g2_decap_8
X_12978_ _12978_/Y _14778_/Q _13030_/A2 _13030_/B1 VDD VSS sg13g2_o21ai_1
XFILLER_33_611 VDD VSS sg13g2_decap_4
X_13903__2299 _13903_/RESET_B VDD VSS sg13g2_tiehi
XFILLER_73_791 VDD VSS sg13g2_decap_8
XFILLER_61_931 VDD VSS sg13g2_decap_8
X_14717_ _14717_/Q clkload30/A _14717_/D _14717_/RESET_B VDD VSS sg13g2_dfrbpq_1
X_11929_ _11929_/Y _12223_/A _11929_/B VDD VSS sg13g2_nor2_1
XFILLER_75_1046 VDD VSS sg13g2_decap_8
XFILLER_166_1185 VDD VSS sg13g2_decap_8
XFILLER_18_1420 VDD VSS sg13g2_decap_8
XFILLER_61_986 VDD VSS sg13g2_fill_2
XFILLER_53_1300 VDD VSS sg13g2_decap_8
X_14648_ _14648_/Q clkload45/A _14648_/D _14648_/RESET_B VDD VSS sg13g2_dfrbpq_1
XFILLER_177_137 VDD VSS sg13g2_decap_8
XANTENNA_17 fanout335/X VDD VSS sg13g2_antennanp
XFILLER_105_1401 VDD VSS sg13g2_fill_2
XFILLER_14_1317 VDD VSS sg13g2_decap_8
X_14579_ _14579_/Q _15160_/CLK _14579_/D _14579_/RESET_B VDD VSS sg13g2_dfrbpq_1
XFILLER_53_1377 VDD VSS sg13g2_decap_8
XFILLER_9_350 VDD VSS sg13g2_decap_8
XFILLER_186_693 VDD VSS sg13g2_decap_8
XFILLER_88_1418 VDD VSS sg13g2_decap_8
XFILLER_174_855 VDD VSS sg13g2_decap_8
X_15080__2856 _15080_/RESET_B VDD VSS sg13g2_tiehi
XFILLER_161_516 VDD VSS sg13g2_decap_8
Xoutput102 mem_axi_bready _07661_/Y VDD VSS sg13g2_buf_1
Xoutput113 mem_axi_wdata[18] _15150_/Q VDD VSS sg13g2_buf_1
XFILLER_56_0 VDD VSS sg13g2_decap_8
XFILLER_127_793 VDD VSS sg13g2_decap_8
Xoutput124 mem_axi_wdata[28] _15160_/Q VDD VSS sg13g2_buf_1
XFILLER_12_1096 VDD VSS sg13g2_decap_8
Xoutput135 mem_axi_wdata[9] _15141_/Q VDD VSS sg13g2_buf_1
XFILLER_99_121 VDD VSS sg13g2_fill_2
XFILLER_173_1134 VDD VSS sg13g2_decap_8
XFILLER_47_1137 VDD VSS sg13g2_decap_8
XFILLER_115_988 VDD VSS sg13g2_decap_8
XFILLER_86_1197 VDD VSS sg13g2_decap_8
XFILLER_114_476 VDD VSS sg13g2_decap_8
XFILLER_134_1129 VDD VSS sg13g2_decap_8
XFILLER_87_338 VDD VSS sg13g2_decap_8
XFILLER_130_958 VDD VSS sg13g2_fill_1
X_07953_ _07954_/C _07818_/Y _07952_/Y _07951_/Y VDD VSS sg13g2_a21oi_1
XFILLER_60_1315 VDD VSS sg13g2_decap_8
XFILLER_25_1446 VDD VSS sg13g2_decap_8
XFILLER_112_1416 VDD VSS sg13g2_decap_8
X_07884_ _07884_/Y _07884_/A _08023_/B VDD VSS sg13g2_xnor2_1
XFILLER_151_1465 VDD VSS sg13g2_decap_8
XFILLER_95_371 VDD VSS sg13g2_fill_2
XFILLER_46_18 VDD VSS sg13g2_fill_2
XFILLER_83_522 VDD VSS sg13g2_decap_8
XFILLER_55_213 VDD VSS sg13g2_decap_4
X_09623_ _14219_/D _09922_/A1 _14219_/Q _09623_/S VDD VSS sg13g2_mux2_1
XFILLER_28_438 VDD VSS sg13g2_decap_4
XFILLER_95_393 VDD VSS sg13g2_decap_8
XFILLER_23_1192 VDD VSS sg13g2_decap_8
XFILLER_3_1264 VDD VSS sg13g2_decap_8
X_09554_ _14152_/D _09620_/A0 _14152_/Q _09556_/S VDD VSS sg13g2_mux2_1
XFILLER_55_268 VDD VSS sg13g2_decap_8
XFILLER_37_972 VDD VSS sg13g2_decap_8
XFILLER_71_728 VDD VSS sg13g2_decap_8
XFILLER_55_279 VDD VSS sg13g2_fill_2
XFILLER_24_600 VDD VSS sg13g2_decap_8
XFILLER_70_227 VDD VSS sg13g2_decap_8
X_08505_ _08505_/Y _07822_/A _08495_/Y _08504_/Y VDD VSS sg13g2_o21ai_1
XFILLER_36_482 VDD VSS sg13g2_decap_8
X_09485_ _14085_/D _10081_/A0 _14085_/Q _09493_/S VDD VSS sg13g2_mux2_1
XFILLER_58_1266 VDD VSS sg13g2_decap_8
XFILLER_180_1105 VDD VSS sg13g2_decap_8
XFILLER_52_964 VDD VSS sg13g2_decap_8
XFILLER_12_817 VDD VSS sg13g2_decap_8
XFILLER_184_1296 VDD VSS sg13g2_decap_8
X_08436_ _08436_/Y _08421_/Y _08436_/B VDD VSS sg13g2_nand2b_1
XFILLER_93_1179 VDD VSS sg13g2_decap_8
XFILLER_11_305 VDD VSS sg13g2_decap_8
XFILLER_145_1258 VDD VSS sg13g2_decap_8
XFILLER_168_126 VDD VSS sg13g2_decap_8
XFILLER_178_28 VDD VSS sg13g2_decap_8
XFILLER_71_1411 VDD VSS sg13g2_decap_8
XFILLER_145_1269 VDD VSS sg13g2_fill_2
XFILLER_51_485 VDD VSS sg13g2_decap_8
XFILLER_184_608 VDD VSS sg13g2_decap_8
X_08367_ _08367_/Y _08411_/A _08411_/C _08366_/X VDD VSS sg13g2_o21ai_1
XFILLER_32_1428 VDD VSS sg13g2_decap_8
XFILLER_137_535 VDD VSS sg13g2_decap_8
X_08298_ _08298_/Y _08318_/C _08297_/Y _08499_/B1 VDD VSS sg13g2_o21ai_1
XFILLER_109_248 VDD VSS sg13g2_decap_8
XFILLER_178_1023 VDD VSS sg13g2_decap_8
XFILLER_109_259 VDD VSS sg13g2_decap_8
XFILLER_137_568 VDD VSS sg13g2_decap_8
XFILLER_106_900 VDD VSS sg13g2_fill_2
XFILLER_11_32 VDD VSS sg13g2_decap_8
XFILLER_124_207 VDD VSS sg13g2_decap_8
XFILLER_152_516 VDD VSS sg13g2_decap_4
XFILLER_3_515 VDD VSS sg13g2_decap_8
XFILLER_30_1174 VDD VSS sg13g2_decap_8
XFILLER_105_410 VDD VSS sg13g2_decap_8
X_10260_ _14781_/D _10265_/A _10265_/D _10259_/Y VDD VSS sg13g2_a21oi_1
XFILLER_127_43 VDD VSS sg13g2_decap_4
XFILLER_178_1089 VDD VSS sg13g2_decap_8
XFILLER_106_955 VDD VSS sg13g2_fill_2
XFILLER_117_281 VDD VSS sg13g2_decap_8
XFILLER_133_752 VDD VSS sg13g2_decap_8
XFILLER_156_1343 VDD VSS sg13g2_decap_8
XFILLER_69_1395 VDD VSS sg13g2_decap_8
XFILLER_121_903 VDD VSS sg13g2_decap_8
XFILLER_87_25 VDD VSS sg13g2_decap_8
XFILLER_121_914 VDD VSS sg13g2_fill_2
X_10191_ _15196_/D input23/X _15196_/Q _10195_/S VDD VSS sg13g2_mux2_1
XFILLER_127_98 VDD VSS sg13g2_decap_8
XFILLER_132_262 VDD VSS sg13g2_fill_1
XFILLER_79_839 VDD VSS sg13g2_fill_1
XFILLER_121_936 VDD VSS sg13g2_decap_8
XFILLER_132_273 VDD VSS sg13g2_decap_8
Xpicorv32_macro_1445 mem_axi_awprot[2] VDD VSS sg13g2_tielo
Xfanout1305 _12135_/S1 _12139_/S1 VDD VSS sg13g2_buf_1
XFILLER_78_327 VDD VSS sg13g2_decap_8
XFILLER_120_424 VDD VSS sg13g2_decap_4
Xfanout1316 _12307_/C _12326_/B1 VDD VSS sg13g2_buf_1
Xfanout1327 _11963_/S0 _11756_/S VDD VSS sg13g2_buf_1
XFILLER_8_1131 VDD VSS sg13g2_decap_8
Xfanout340 _09772_/S _09760_/S VDD VSS sg13g2_buf_1
Xfanout1338 _12105_/A1 fanout1339/X VDD VSS sg13g2_buf_1
XFILLER_87_850 VDD VSS sg13g2_decap_8
XFILLER_143_31 VDD VSS sg13g2_decap_8
Xfanout351 _09704_/S _09706_/S VDD VSS sg13g2_buf_1
Xfanout1349 _11896_/A _11890_/S0 VDD VSS sg13g2_buf_1
Xfanout362 _09505_/S fanout364/X VDD VSS sg13g2_buf_1
XFILLER_115_1051 VDD VSS sg13g2_decap_4
X_13950_ _13950_/Q clkload53/A _13950_/D _13950_/RESET_B VDD VSS sg13g2_dfrbpq_1
Xfanout373 _09304_/S _09306_/S VDD VSS sg13g2_buf_1
Xfanout384 _09200_/S _09202_/S VDD VSS sg13g2_buf_1
Xfanout395 _09913_/A1 _09007_/X VDD VSS sg13g2_buf_1
X_12901_ _12902_/A input32/X _12841_/B _12803_/X input9/X VDD VSS sg13g2_a22oi_1
XFILLER_100_170 VDD VSS sg13g2_decap_4
XFILLER_101_693 VDD VSS sg13g2_decap_4
X_13881_ _13881_/Q _14745_/CLK _13881_/D _13881_/RESET_B VDD VSS sg13g2_dfrbpq_1
XFILLER_98_1046 VDD VSS sg13g2_decap_8
XFILLER_47_758 VDD VSS sg13g2_decap_8
XFILLER_100_192 VDD VSS sg13g2_decap_8
XFILLER_74_555 VDD VSS sg13g2_decap_4
XFILLER_185_1027 VDD VSS sg13g2_decap_8
X_12832_ _12832_/Y _12829_/Y _12830_/Y _12831_/Y VDD VSS sg13g2_a21oi_1
X_14872__2823 _14872_/RESET_B VDD VSS sg13g2_tiehi
XFILLER_41_1292 VDD VSS sg13g2_decap_8
XFILLER_74_588 VDD VSS sg13g2_decap_8
XFILLER_61_205 VDD VSS sg13g2_decap_8
XFILLER_46_279 VDD VSS sg13g2_decap_8
XFILLER_62_739 VDD VSS sg13g2_fill_1
XFILLER_15_611 VDD VSS sg13g2_fill_1
XFILLER_128_1401 VDD VSS sg13g2_decap_4
XFILLER_15_633 VDD VSS sg13g2_decap_8
XFILLER_163_1303 VDD VSS sg13g2_decap_8
X_12763_ _12764_/B _13664_/Q _12777_/A2 _12762_/X _12777_/B2 _12777_/C1 VDD VSS sg13g2_a221oi_1
XFILLER_76_1366 VDD VSS sg13g2_decap_8
XFILLER_70_750 VDD VSS sg13g2_decap_8
X_14502_ _14502_/Q _14655_/CLK _14502_/D _14502_/RESET_B VDD VSS sg13g2_dfrbpq_1
XFILLER_14_154 VDD VSS sg13g2_decap_8
X_11714_ _11714_/X _14377_/Q _14409_/Q _14473_/Q _14505_/Q _12100_/S0 _12100_/S1 VDD
+ VSS sg13g2_mux4_1
XFILLER_14_165 VDD VSS sg13g2_decap_4
X_12694_ _15013_/D _12694_/A _12694_/B VDD VSS sg13g2_nor2_1
XFILLER_14_187 VDD VSS sg13g2_decap_8
XFILLER_35_1030 VDD VSS sg13g2_decap_8
X_14433_ _14433_/Q clkload6/A _14433_/D _14433_/RESET_B VDD VSS sg13g2_dfrbpq_1
X_11645_ _11645_/X _13831_/Q _13863_/Q _13895_/Q _13927_/Q _11649_/S0 _11649_/S1 VDD
+ VSS sg13g2_mux4_1
XFILLER_30_658 VDD VSS sg13g2_decap_8
XFILLER_156_800 VDD VSS sg13g2_decap_8
XFILLER_168_660 VDD VSS sg13g2_decap_8
XFILLER_126_1191 VDD VSS sg13g2_decap_8
XFILLER_167_170 VDD VSS sg13g2_fill_1
X_14364_ _14364_/Q clkload74/A _14364_/D _14364_/RESET_B VDD VSS sg13g2_dfrbpq_1
X_14648__1554 _14648_/RESET_B VDD VSS sg13g2_tiehi
Xinput15 input15/X input15/A VDD VSS sg13g2_buf_1
Xinput26 input26/X input26/A VDD VSS sg13g2_buf_1
X_11576_ _11576_/X _14693_/Q _14725_/Q _13765_/Q _13797_/Q _11580_/S0 _11580_/S1 VDD
+ VSS sg13g2_mux4_1
XFILLER_10_371 VDD VSS sg13g2_decap_8
XFILLER_11_894 VDD VSS sg13g2_fill_1
XFILLER_167_192 VDD VSS sg13g2_decap_8
Xinput37 input37/X input37/A VDD VSS sg13g2_buf_1
XFILLER_122_1066 VDD VSS sg13g2_decap_4
XFILLER_7_854 VDD VSS sg13g2_decap_8
X_13315_ _15061_/D _15079_/Q _07694_/Y _13314_/X VDD VSS sg13g2_a21o_1
Xclkbuf_leaf_4_clk_i clkload14/A clkbuf_leaf_4_clk_i/A VDD VSS sg13g2_buf_8
X_10527_ _10529_/A _10564_/D _10531_/D _13218_/A VDD VSS sg13g2_a21o_1
XFILLER_100_1320 VDD VSS sg13g2_decap_8
XFILLER_182_151 VDD VSS sg13g2_decap_8
X_14295_ _14295_/Q clkload42/A _14295_/D _14295_/RESET_B VDD VSS sg13g2_dfrbpq_1
XFILLER_13_1383 VDD VSS sg13g2_decap_8
XFILLER_87_1440 VDD VSS sg13g2_decap_8
XFILLER_6_375 VDD VSS sg13g2_decap_8
XFILLER_143_538 VDD VSS sg13g2_decap_8
X_13246_ _13247_/C _14922_/Q _13665_/Q _13246_/C VDD VSS sg13g2_nand3_1
X_10458_ _10512_/A _14842_/Q _14841_/Q _14840_/Q _14839_/Q VDD VSS sg13g2_nand4_1
XFILLER_124_730 VDD VSS sg13g2_fill_1
XFILLER_171_869 VDD VSS sg13g2_fill_2
XFILLER_124_752 VDD VSS sg13g2_decap_8
XFILLER_83_1326 VDD VSS sg13g2_decap_8
XFILLER_123_251 VDD VSS sg13g2_decap_8
XFILLER_184_93 VDD VSS sg13g2_decap_8
X_13177_ _13177_/X _13225_/A _13188_/A VDD VSS sg13g2_xor2_1
X_10389_ _14820_/D _10378_/D _10387_/X _10388_/Y VDD VSS sg13g2_a21oi_1
XFILLER_97_614 VDD VSS sg13g2_decap_8
XFILLER_124_785 VDD VSS sg13g2_decap_8
XFILLER_48_1468 VDD VSS sg13g2_decap_8
XFILLER_112_958 VDD VSS sg13g2_decap_8
X_12128_ _12198_/B _12128_/A _13667_/Q VDD VSS sg13g2_xnor2_1
XFILLER_2_581 VDD VSS sg13g2_decap_8
X_15016__2594 _15016_/RESET_B VDD VSS sg13g2_tiehi
X_15065__2904 _15065_/RESET_B VDD VSS sg13g2_tiehi
XFILLER_85_809 VDD VSS sg13g2_fill_1
XFILLER_111_457 VDD VSS sg13g2_decap_8
XFILLER_42_1012 VDD VSS sg13g2_fill_2
XFILLER_28_4 VDD VSS sg13g2_decap_8
XFILLER_111_468 VDD VSS sg13g2_fill_2
XFILLER_96_157 VDD VSS sg13g2_decap_8
X_12059_ _12062_/B _12054_/Y _11986_/Y _11913_/A _12056_/C _12058_/Y VDD VSS sg13g2_a221oi_1
XFILLER_78_872 VDD VSS sg13g2_decap_8
XFILLER_77_382 VDD VSS sg13g2_decap_8
XFILLER_37_213 VDD VSS sg13g2_decap_8
X_16867_ _16867_/X _16867_/A VDD VSS sg13g2_buf_1
XFILLER_19_950 VDD VSS sg13g2_decap_8
XFILLER_93_864 VDD VSS sg13g2_decap_8
XFILLER_77_1108 VDD VSS sg13g2_decap_8
Xclkbuf_5_31__f_clk_i clkbuf_leaf_71_clk_i/A clkbuf_4_15_0_clk_i/X VDD VSS sg13g2_buf_16
XFILLER_0_1415 VDD VSS sg13g2_decap_8
XFILLER_92_363 VDD VSS sg13g2_fill_1
XFILLER_168_1258 VDD VSS sg13g2_decap_8
XFILLER_20_1354 VDD VSS sg13g2_decap_8
XFILLER_18_471 VDD VSS sg13g2_decap_8
XFILLER_92_385 VDD VSS sg13g2_decap_8
XFILLER_80_525 VDD VSS sg13g2_decap_8
XFILLER_94_1433 VDD VSS sg13g2_decap_8
XFILLER_34_931 VDD VSS sg13g2_decap_4
XFILLER_80_547 VDD VSS sg13g2_fill_1
XFILLER_181_1414 VDD VSS sg13g2_decap_8
XFILLER_34_964 VDD VSS sg13g2_decap_8
XFILLER_61_761 VDD VSS sg13g2_decap_8
X_09270_ _13879_/D _13879_/Q _10166_/A1 _09272_/S VDD VSS sg13g2_mux2_1
X_08221_ _08221_/Y _08220_/X _08325_/B _08319_/A VDD VSS sg13g2_a21oi_1
XFILLER_60_282 VDD VSS sg13g2_decap_8
XFILLER_178_479 VDD VSS sg13g2_decap_8
XFILLER_105_1231 VDD VSS sg13g2_fill_1
XFILLER_14_1114 VDD VSS sg13g2_decap_8
XFILLER_18_1294 VDD VSS sg13g2_decap_8
X_08152_ _08152_/Y _08402_/A _08402_/B _08363_/S1 VDD VSS sg13g2_o21ai_1
XFILLER_53_1174 VDD VSS sg13g2_decap_8
XFILLER_186_490 VDD VSS sg13g2_decap_8
XFILLER_105_1264 VDD VSS sg13g2_fill_2
XFILLER_140_1155 VDD VSS sg13g2_decap_4
XFILLER_101_1128 VDD VSS sg13g2_decap_8
XFILLER_173_140 VDD VSS sg13g2_decap_8
X_08083_ _08086_/B _08493_/B2 _08909_/A1 _08915_/A1 _08919_/A1 _08083_/S0 _08102_/S0
+ VDD VSS sg13g2_mux4_1
XFILLER_31_1461 VDD VSS sg13g2_decap_8
XFILLER_179_1365 VDD VSS sg13g2_decap_8
XFILLER_134_527 VDD VSS sg13g2_fill_2
XFILLER_115_730 VDD VSS sg13g2_decap_8
XFILLER_127_590 VDD VSS sg13g2_fill_1
XFILLER_134_549 VDD VSS sg13g2_decap_4
X_13742__2460 _13742_/RESET_B VDD VSS sg13g2_tiehi
XFILLER_138_1040 VDD VSS sg13g2_decap_8
XFILLER_130_700 VDD VSS sg13g2_decap_8
XFILLER_142_560 VDD VSS sg13g2_decap_8
XFILLER_0_518 VDD VSS sg13g2_decap_8
XFILLER_103_925 VDD VSS sg13g2_decap_8
XFILLER_130_711 VDD VSS sg13g2_fill_1
XFILLER_170_891 VDD VSS sg13g2_fill_1
XFILLER_88_647 VDD VSS sg13g2_decap_8
X_08985_ _08985_/X _15025_/Q _15222_/Q _09027_/S VDD VSS sg13g2_mux2_1
X_14086__2116 _14086_/RESET_B VDD VSS sg13g2_tiehi
XFILLER_9_1451 VDD VSS sg13g2_decap_8
XFILLER_64_1281 VDD VSS sg13g2_decap_8
XFILLER_87_168 VDD VSS sg13g2_decap_8
X_07936_ _07936_/Y _15003_/Q _11705_/A VDD VSS sg13g2_nor2b_1
XFILLER_25_1243 VDD VSS sg13g2_decap_8
X_14122__2080 _14122_/RESET_B VDD VSS sg13g2_tiehi
XFILLER_29_714 VDD VSS sg13g2_fill_1
XFILLER_112_1213 VDD VSS sg13g2_decap_8
XFILLER_116_1382 VDD VSS sg13g2_fill_2
XFILLER_5_1337 VDD VSS sg13g2_decap_8
XFILLER_56_533 VDD VSS sg13g2_fill_1
XFILLER_110_490 VDD VSS sg13g2_decap_8
X_07867_ _07905_/D _07969_/A _08678_/A _08650_/A _07867_/D VDD VSS sg13g2_or4_1
XFILLER_28_235 VDD VSS sg13g2_fill_1
XFILLER_60_1189 VDD VSS sg13g2_decap_8
X_09606_ _09606_/Y _10070_/A _10070_/B _09606_/C VDD VSS sg13g2_nand3_1
XFILLER_186_1336 VDD VSS sg13g2_decap_8
X_14726__1476 _14726_/RESET_B VDD VSS sg13g2_tiehi
XFILLER_3_1061 VDD VSS sg13g2_decap_8
X_07798_ _07798_/X _15006_/Q _07945_/B VDD VSS sg13g2_or2_1
XFILLER_83_385 VDD VSS sg13g2_decap_8
XFILLER_37_780 VDD VSS sg13g2_decap_8
XFILLER_43_227 VDD VSS sg13g2_decap_8
X_09537_ _14136_/D _09737_/A0 _14136_/Q _09538_/S VDD VSS sg13g2_mux2_1
XFILLER_58_1041 VDD VSS sg13g2_decap_8
XFILLER_97_1090 VDD VSS sg13g2_fill_2
XFILLER_52_750 VDD VSS sg13g2_fill_1
XFILLER_149_1191 VDD VSS sg13g2_decap_8
XFILLER_40_912 VDD VSS sg13g2_decap_4
X_09468_ _14069_/D _09767_/A1 _14069_/Q _09471_/S VDD VSS sg13g2_mux2_1
XFILLER_24_474 VDD VSS sg13g2_decap_8
XFILLER_184_1093 VDD VSS sg13g2_decap_8
XFILLER_58_1096 VDD VSS sg13g2_decap_8
XFILLER_11_102 VDD VSS sg13g2_decap_8
XFILLER_51_282 VDD VSS sg13g2_decap_8
XFILLER_12_647 VDD VSS sg13g2_decap_8
X_08419_ _08419_/Y _08419_/A VDD VSS sg13g2_inv_1
X_09399_ _14002_/D _09630_/A0 _14002_/Q _09405_/S VDD VSS sg13g2_mux2_1
XFILLER_40_978 VDD VSS sg13g2_decap_8
XFILLER_156_118 VDD VSS sg13g2_fill_2
XFILLER_40_989 VDD VSS sg13g2_fill_2
XFILLER_138_822 VDD VSS sg13g2_decap_8
XFILLER_36_1383 VDD VSS sg13g2_decap_8
X_11430_ _11430_/Y _11430_/A _11430_/B VDD VSS sg13g2_xnor2_1
XFILLER_32_1225 VDD VSS sg13g2_decap_8
XFILLER_11_179 VDD VSS sg13g2_decap_8
XFILLER_71_1285 VDD VSS sg13g2_decap_8
XFILLER_22_42 VDD VSS sg13g2_fill_1
XFILLER_149_192 VDD VSS sg13g2_decap_8
X_11361_ _11361_/Y _11832_/C _11361_/B VDD VSS sg13g2_nand2b_1
XFILLER_138_64 VDD VSS sg13g2_fill_2
X_13100_ _15039_/D _13093_/Y _13099_/Y _13127_/A VDD VSS sg13g2_a21oi_1
X_14296__1906 _14296_/RESET_B VDD VSS sg13g2_tiehi
X_10312_ _14797_/D _13328_/A _10312_/B _10342_/C VDD VSS sg13g2_nor3_1
XFILLER_158_1438 VDD VSS sg13g2_decap_8
XFILLER_3_312 VDD VSS sg13g2_decap_8
XFILLER_153_858 VDD VSS sg13g2_decap_8
XFILLER_180_644 VDD VSS sg13g2_decap_8
X_14080_ _14080_/Q _14528_/CLK _14080_/D _14080_/RESET_B VDD VSS sg13g2_dfrbpq_1
X_11292_ _11292_/Y _11292_/A _11292_/B VDD VSS sg13g2_xnor2_1
XFILLER_180_655 VDD VSS sg13g2_fill_2
X_14332__1870 _14332_/RESET_B VDD VSS sg13g2_tiehi
XFILLER_4_868 VDD VSS sg13g2_decap_8
X_13031_ _13031_/Y _13028_/Y _13029_/Y _13030_/Y VDD VSS sg13g2_a21oi_1
X_10243_ _10245_/C _14775_/Q _10247_/D _14776_/Q VDD VSS sg13g2_a21oi_1
XFILLER_69_1192 VDD VSS sg13g2_decap_8
XFILLER_133_560 VDD VSS sg13g2_fill_1
XFILLER_79_614 VDD VSS sg13g2_decap_8
XFILLER_106_785 VDD VSS sg13g2_decap_8
XFILLER_117_1124 VDD VSS sg13g2_decap_8
XFILLER_156_1173 VDD VSS sg13g2_decap_8
XFILLER_161_891 VDD VSS sg13g2_decap_8
XFILLER_3_389 VDD VSS sg13g2_decap_8
XFILLER_133_593 VDD VSS sg13g2_fill_1
Xfanout1102 _08009_/S fanout1103/X VDD VSS sg13g2_buf_1
X_10174_ _10174_/Y _15055_/Q _10174_/B _13613_/C VDD VSS sg13g2_nor3_1
Xfanout1113 _12152_/A _08012_/B VDD VSS sg13g2_buf_1
XFILLER_121_755 VDD VSS sg13g2_decap_8
Xfanout1124 _12009_/A _08591_/A2 VDD VSS sg13g2_buf_1
Xfanout1135 _08915_/A1 _14977_/Q VDD VSS sg13g2_buf_1
Xfanout1146 _07946_/B _08465_/A3 VDD VSS sg13g2_buf_1
XFILLER_43_1343 VDD VSS sg13g2_decap_8
X_14982_ _14982_/Q clkload38/A _14982_/D _14982_/RESET_B VDD VSS sg13g2_dfrbpq_1
Xfanout1157 _08362_/A2 _14969_/Q VDD VSS sg13g2_buf_1
XFILLER_94_628 VDD VSS sg13g2_fill_1
Xfanout170 _09767_/A1 _10064_/A0 VDD VSS sg13g2_buf_1
Xfanout1168 _07768_/A _07929_/B VDD VSS sg13g2_buf_1
Xfanout181 _09930_/A1 _09118_/Y VDD VSS sg13g2_buf_1
Xfanout1179 _07912_/B _08102_/A3 VDD VSS sg13g2_buf_1
Xfanout192 _09860_/A1 _10125_/A0 VDD VSS sg13g2_buf_1
X_13933_ _13933_/Q clkload26/A _13933_/D _13933_/RESET_B VDD VSS sg13g2_dfrbpq_1
XFILLER_93_138 VDD VSS sg13g2_decap_8
XFILLER_75_842 VDD VSS sg13g2_decap_8
XFILLER_19_235 VDD VSS sg13g2_decap_8
XFILLER_75_853 VDD VSS sg13g2_fill_1
XFILLER_130_1357 VDD VSS sg13g2_decap_8
XFILLER_19_257 VDD VSS sg13g2_decap_8
X_13864_ _13864_/Q clkload21/A _13864_/D _13864_/RESET_B VDD VSS sg13g2_dfrbpq_1
XFILLER_34_216 VDD VSS sg13g2_decap_4
XFILLER_170_95 VDD VSS sg13g2_decap_8
XFILLER_90_845 VDD VSS sg13g2_fill_1
X_12815_ _12815_/Y input15/X _12841_/B _12803_/X input35/X _12813_/X VDD VSS sg13g2_a221oi_1
XFILLER_34_249 VDD VSS sg13g2_decap_8
X_13784__2418 _13784_/RESET_B VDD VSS sg13g2_tiehi
X_13795_ _13795_/Q _14725_/CLK _13795_/D _13795_/RESET_B VDD VSS sg13g2_dfrbpq_1
XFILLER_163_1100 VDD VSS sg13g2_fill_2
XFILLER_76_1163 VDD VSS sg13g2_decap_8
XFILLER_43_772 VDD VSS sg13g2_decap_8
X_12746_ _12746_/X _12739_/X _12743_/X _12738_/X _12742_/X _12762_/S _12747_/S1 VDD
+ VSS sg13g2_mux4_1
X_13820__2382 _13820_/RESET_B VDD VSS sg13g2_tiehi
XFILLER_37_1147 VDD VSS sg13g2_decap_8
XFILLER_128_1264 VDD VSS sg13g2_decap_8
XFILLER_97_7 VDD VSS sg13g2_decap_4
XFILLER_179_60 VDD VSS sg13g2_decap_8
XFILLER_63_93 VDD VSS sg13g2_decap_8
XFILLER_30_433 VDD VSS sg13g2_decap_8
XFILLER_163_1177 VDD VSS sg13g2_decap_8
X_14836__2895 _14836_/RESET_B VDD VSS sg13g2_tiehi
XFILLER_8_11 VDD VSS sg13g2_decap_8
XFILLER_42_293 VDD VSS sg13g2_decap_8
X_12677_ _12677_/X _12675_/X _12674_/X _12668_/X _12669_/X _12747_/S1 _12748_/S VDD
+ VSS sg13g2_mux4_1
XFILLER_129_811 VDD VSS sg13g2_decap_8
XFILLER_54_1472 VDD VSS sg13g2_decap_8
X_14416_ _14416_/Q clkload14/A _14416_/D _14416_/RESET_B VDD VSS sg13g2_dfrbpq_1
X_11628_ _11628_/Y _11626_/Y _11627_/Y _11903_/C1 VDD VSS sg13g2_a21oi_1
XFILLER_15_1467 VDD VSS sg13g2_decap_8
X_14164__2038 _14164_/RESET_B VDD VSS sg13g2_tiehi
XFILLER_129_866 VDD VSS sg13g2_decap_8
XFILLER_15_1478 VDD VSS sg13g2_fill_1
XFILLER_184_961 VDD VSS sg13g2_decap_8
XFILLER_8_88 VDD VSS sg13g2_decap_8
XFILLER_50_1358 VDD VSS sg13g2_decap_8
XFILLER_129_877 VDD VSS sg13g2_fill_2
XFILLER_144_814 VDD VSS sg13g2_fill_1
X_14347_ _14347_/Q _15005_/CLK _14347_/D _14347_/RESET_B VDD VSS sg13g2_dfrbpq_1
XFILLER_7_651 VDD VSS sg13g2_decap_8
X_11559_ _11559_/Y _11557_/Y _11559_/B _11559_/C VDD VSS sg13g2_nand3b_1
XFILLER_102_1459 VDD VSS sg13g2_decap_8
XFILLER_128_387 VDD VSS sg13g2_decap_8
XFILLER_155_173 VDD VSS sg13g2_decap_8
XFILLER_116_538 VDD VSS sg13g2_decap_4
XFILLER_13_1180 VDD VSS sg13g2_decap_8
XFILLER_6_172 VDD VSS sg13g2_decap_8
X_14278_ _14278_/Q clkload52/A _14278_/D _14278_/RESET_B VDD VSS sg13g2_dfrbpq_1
XFILLER_131_508 VDD VSS sg13g2_decap_4
XFILLER_87_1281 VDD VSS sg13g2_fill_2
XFILLER_143_379 VDD VSS sg13g2_decap_8
XFILLER_171_688 VDD VSS sg13g2_decap_8
X_13229_ _13232_/A _13188_/A _13225_/X _13228_/Y VDD VSS sg13g2_a21oi_1
XFILLER_98_934 VDD VSS sg13g2_decap_8
XFILLER_83_1134 VDD VSS sg13g2_decap_8
XFILLER_139_1382 VDD VSS sg13g2_decap_4
XFILLER_69_102 VDD VSS sg13g2_decap_8
XFILLER_48_1265 VDD VSS sg13g2_decap_8
XFILLER_174_1273 VDD VSS sg13g2_decap_8
XFILLER_170_1115 VDD VSS sg13g2_fill_2
XFILLER_112_766 VDD VSS sg13g2_decap_8
XFILLER_69_146 VDD VSS sg13g2_decap_8
XFILLER_100_917 VDD VSS sg13g2_decap_4
XFILLER_61_1421 VDD VSS sg13g2_decap_8
X_08770_ _08770_/Y _07649_/A _15118_/Q _15187_/Q _07719_/X VDD VSS sg13g2_a22oi_1
XFILLER_22_1405 VDD VSS sg13g2_decap_8
XFILLER_78_691 VDD VSS sg13g2_fill_2
XFILLER_19_0 VDD VSS sg13g2_decap_8
X_07721_ _07735_/B _07721_/A _07721_/B _08201_/B VDD VSS sg13g2_nand3_1
X_14971__2639 _14971_/RESET_B VDD VSS sg13g2_tiehi
XFILLER_38_555 VDD VSS sg13g2_fill_2
X_07652_ _07652_/Y _11086_/A VDD VSS sg13g2_inv_1
XFILLER_81_823 VDD VSS sg13g2_decap_8
XFILLER_26_728 VDD VSS sg13g2_decap_8
XFILLER_0_1212 VDD VSS sg13g2_decap_8
XFILLER_20_1151 VDD VSS sg13g2_decap_8
XFILLER_81_834 VDD VSS sg13g2_fill_2
XFILLER_168_1077 VDD VSS sg13g2_decap_8
XFILLER_92_193 VDD VSS sg13g2_decap_4
XFILLER_25_249 VDD VSS sg13g2_decap_8
XFILLER_146_1320 VDD VSS sg13g2_decap_8
X_14374__1828 _14374_/RESET_B VDD VSS sg13g2_tiehi
Xclkbuf_leaf_105_clk_i _14668_/CLK clkbuf_leaf_96_clk_i/A VDD VSS sg13g2_buf_8
XFILLER_179_733 VDD VSS sg13g2_decap_8
XFILLER_181_1211 VDD VSS sg13g2_decap_8
X_09322_ _13929_/D _09920_/A1 _13929_/Q _09333_/S VDD VSS sg13g2_mux2_1
XFILLER_0_1289 VDD VSS sg13g2_decap_8
XFILLER_59_1394 VDD VSS sg13g2_decap_8
XFILLER_90_1116 VDD VSS sg13g2_decap_8
XFILLER_22_934 VDD VSS sg13g2_decap_8
X_14410__1792 _14410_/RESET_B VDD VSS sg13g2_tiehi
XFILLER_55_1258 VDD VSS sg13g2_decap_8
XFILLER_139_619 VDD VSS sg13g2_decap_8
X_09253_ _13862_/D _13862_/Q _10149_/A1 _09259_/S VDD VSS sg13g2_mux2_1
XFILLER_167_939 VDD VSS sg13g2_fill_2
XFILLER_166_416 VDD VSS sg13g2_decap_8
XFILLER_181_1288 VDD VSS sg13g2_decap_8
X_08204_ _08204_/Y _08432_/A2 _08247_/A _08325_/B VDD VSS sg13g2_o21ai_1
X_09184_ _13800_/D _13800_/Q _10151_/A1 _09190_/S VDD VSS sg13g2_mux2_1
XFILLER_119_321 VDD VSS sg13g2_fill_1
XFILLER_18_1091 VDD VSS sg13g2_decap_8
XFILLER_105_1050 VDD VSS sg13g2_decap_8
X_08135_ _08135_/Y _07629_/A _08131_/Y _08134_/Y VDD VSS sg13g2_a21oi_1
XFILLER_146_140 VDD VSS sg13g2_decap_8
XFILLER_107_505 VDD VSS sg13g2_decap_8
XFILLER_175_18 VDD VSS sg13g2_decap_8
XFILLER_88_1023 VDD VSS sg13g2_decap_4
XFILLER_147_696 VDD VSS sg13g2_decap_8
XFILLER_179_1162 VDD VSS sg13g2_decap_8
XFILLER_175_1004 VDD VSS sg13g2_fill_2
XFILLER_88_1056 VDD VSS sg13g2_fill_1
X_08066_ _08066_/Y _08066_/A VDD VSS sg13g2_inv_1
XFILLER_161_154 VDD VSS sg13g2_decap_8
XFILLER_1_805 VDD VSS sg13g2_decap_8
XFILLER_134_379 VDD VSS sg13g2_fill_2
XFILLER_161_165 VDD VSS sg13g2_fill_1
XFILLER_161_176 VDD VSS sg13g2_decap_8
XFILLER_115_571 VDD VSS sg13g2_fill_2
XFILLER_66_1354 VDD VSS sg13g2_decap_8
XFILLER_0_315 VDD VSS sg13g2_decap_8
XFILLER_88_422 VDD VSS sg13g2_fill_2
XFILLER_27_1327 VDD VSS sg13g2_decap_8
XFILLER_89_967 VDD VSS sg13g2_decap_8
XFILLER_62_1229 VDD VSS sg13g2_decap_8
XFILLER_130_541 VDD VSS sg13g2_fill_2
XFILLER_103_788 VDD VSS sg13g2_decap_8
XFILLER_153_1379 VDD VSS sg13g2_decap_8
X_08968_ _08969_/A _15021_/Q _15218_/Q _13305_/A VDD VSS sg13g2_mux2_1
XFILLER_124_55 VDD VSS sg13g2_decap_8
XFILLER_130_596 VDD VSS sg13g2_decap_8
XFILLER_5_1134 VDD VSS sg13g2_decap_8
X_07919_ _07919_/Y _08160_/B _08160_/C _07871_/X VDD VSS sg13g2_o21ai_1
XFILLER_99_1130 VDD VSS sg13g2_decap_8
XFILLER_99_1141 VDD VSS sg13g2_fill_1
X_08899_ _08899_/Y _08897_/Y _08898_/Y _08904_/S VDD VSS sg13g2_a21oi_1
XFILLER_57_864 VDD VSS sg13g2_decap_8
X_10930_ _10946_/B _10936_/B _14757_/Q VDD VSS sg13g2_nand2_1
XFILLER_186_1133 VDD VSS sg13g2_decap_8
XFILLER_56_374 VDD VSS sg13g2_decap_8
XFILLER_17_42 VDD VSS sg13g2_decap_8
XFILLER_72_834 VDD VSS sg13g2_decap_8
XFILLER_140_21 VDD VSS sg13g2_fill_2
XFILLER_16_227 VDD VSS sg13g2_fill_2
XFILLER_182_1008 VDD VSS sg13g2_fill_1
X_10861_ _14931_/D _10860_/Y _10859_/Y _10850_/Y VDD VSS sg13g2_o21ai_1
XFILLER_44_569 VDD VSS sg13g2_decap_8
XFILLER_38_1412 VDD VSS sg13g2_decap_8
XFILLER_164_1420 VDD VSS sg13g2_decap_8
X_12600_ _12600_/X _13741_/Q _14093_/Q _14445_/Q _14541_/Q _12643_/S0 _12643_/S1 VDD
+ VSS sg13g2_mux4_1
XFILLER_25_761 VDD VSS sg13g2_decap_8
X_13580_ _13580_/Y _15000_/Q _13592_/A2 _13569_/S _15016_/Q _13529_/X VDD VSS sg13g2_a221oi_1
XFILLER_73_1325 VDD VSS sg13g2_decap_8
X_10792_ _10792_/Y _14925_/Q _11196_/B VDD VSS sg13g2_nand2_1
XFILLER_158_906 VDD VSS sg13g2_fill_1
XFILLER_185_703 VDD VSS sg13g2_decap_8
X_12531_ _12531_/X _14376_/Q _14408_/Q _14472_/Q _14504_/Q _12536_/S0 _12536_/S1 VDD
+ VSS sg13g2_mux4_1
XFILLER_125_1448 VDD VSS sg13g2_fill_2
XFILLER_160_1339 VDD VSS sg13g2_decap_8
XFILLER_9_938 VDD VSS sg13g2_decap_8
X_15250_ _15250_/Q clkload80/A _15250_/D _15250_/RESET_B VDD VSS sg13g2_dfrbpq_1
XFILLER_36_1180 VDD VSS sg13g2_decap_8
X_12462_ _12462_/X _14243_/Q _14275_/Q _14307_/Q _14339_/Q _12466_/S0 _12466_/S1 VDD
+ VSS sg13g2_mux4_1
XFILLER_33_85 VDD VSS sg13g2_decap_4
X_14201_ _14201_/Q clkload45/A _14201_/D _14201_/RESET_B VDD VSS sg13g2_dfrbpq_1
XFILLER_8_459 VDD VSS sg13g2_decap_8
XFILLER_184_268 VDD VSS sg13g2_decap_8
X_11413_ _11413_/X _11413_/A _11422_/B VDD VSS sg13g2_and2_1
X_15181_ _15181_/Q clkload63/A _15181_/D _15181_/RESET_B VDD VSS sg13g2_dfrbpq_1
XFILLER_138_685 VDD VSS sg13g2_decap_8
X_12393_ _12393_/X _14110_/Q _14142_/Q _14174_/Q _14206_/Q _12590_/S0 _12590_/S1 VDD
+ VSS sg13g2_mux4_1
XFILLER_126_847 VDD VSS sg13g2_decap_4
X_14132_ _14132_/Q clkload11/A _14132_/D _14132_/RESET_B VDD VSS sg13g2_dfrbpq_1
XFILLER_32_1099 VDD VSS sg13g2_decap_8
XFILLER_125_335 VDD VSS sg13g2_decap_8
X_11344_ _11344_/Y _11368_/S0 _13886_/Q VDD VSS sg13g2_nand2b_1
XFILLER_158_1235 VDD VSS sg13g2_decap_8
Xclkbuf_leaf_84_clk_i clkload57/A clkbuf_leaf_84_clk_i/A VDD VSS sg13g2_buf_8
XFILLER_67_1129 VDD VSS sg13g2_decap_8
XFILLER_153_666 VDD VSS sg13g2_decap_4
XFILLER_84_1421 VDD VSS sg13g2_decap_8
XFILLER_4_665 VDD VSS sg13g2_decap_8
X_14063_ _14063_/Q clkload34/A _14063_/D _14063_/RESET_B VDD VSS sg13g2_dfrbpq_1
XFILLER_106_560 VDD VSS sg13g2_fill_1
XFILLER_10_1386 VDD VSS sg13g2_decap_8
XFILLER_153_699 VDD VSS sg13g2_fill_2
X_11275_ _11275_/X _14236_/Q _14268_/Q _14300_/Q _14332_/Q _11277_/S _11282_/S1 VDD
+ VSS sg13g2_mux4_1
XFILLER_165_95 VDD VSS sg13g2_decap_8
XFILLER_171_1413 VDD VSS sg13g2_decap_8
X_13014_ _13014_/Y _14812_/Q _13029_/A2 _12976_/B _14844_/Q _13069_/C1 VDD VSS sg13g2_a221oi_1
X_10226_ _10237_/C _14767_/Q _14768_/Q _14769_/Q _14770_/Q VDD VSS sg13g2_nand4_1
XFILLER_80_1307 VDD VSS sg13g2_fill_1
XFILLER_3_186 VDD VSS sg13g2_decap_8
XFILLER_45_1438 VDD VSS sg13g2_decap_8
X_13838__2364 _13838_/RESET_B VDD VSS sg13g2_tiehi
XFILLER_39_308 VDD VSS sg13g2_decap_4
Xclkbuf_leaf_99_clk_i _14724_/CLK clkbuf_leaf_99_clk_i/A VDD VSS sg13g2_buf_8
X_10157_ _14734_/D _14734_/Q _10157_/A1 _10157_/S VDD VSS sg13g2_mux2_1
XFILLER_95_937 VDD VSS sg13g2_fill_1
XFILLER_66_105 VDD VSS sg13g2_decap_8
XFILLER_43_1140 VDD VSS sg13g2_decap_8
XFILLER_12_7 VDD VSS sg13g2_decap_8
XFILLER_94_447 VDD VSS sg13g2_decap_8
X_14965_ _14965_/Q clkload55/A _14965_/D _14965_/RESET_B VDD VSS sg13g2_dfrbpq_1
X_10088_ _14668_/D _10088_/A0 _14668_/Q _10090_/S VDD VSS sg13g2_mux2_1
XFILLER_63_801 VDD VSS sg13g2_decap_8
XFILLER_47_352 VDD VSS sg13g2_decap_8
X_13916_ _13916_/Q clkload76/A _13916_/D _13916_/RESET_B VDD VSS sg13g2_dfrbpq_1
XFILLER_63_812 VDD VSS sg13g2_fill_2
XFILLER_130_1176 VDD VSS sg13g2_fill_1
X_14896_ _14896_/Q _14930_/CLK _14896_/D _14896_/RESET_B VDD VSS sg13g2_dfrbpq_1
Xclkbuf_leaf_22_clk_i _14417_/CLK clkbuf_leaf_9_clk_i/A VDD VSS sg13g2_buf_8
XFILLER_169_1364 VDD VSS sg13g2_decap_8
XFILLER_78_1247 VDD VSS sg13g2_decap_8
XFILLER_62_311 VDD VSS sg13g2_decap_8
XFILLER_63_845 VDD VSS sg13g2_decap_8
XFILLER_165_1217 VDD VSS sg13g2_decap_8
X_13847_ _13847_/Q _14743_/CLK _13847_/D _13847_/RESET_B VDD VSS sg13g2_dfrbpq_1
X_13778_ _13778_/Q _14743_/CLK _13778_/D _13778_/RESET_B VDD VSS sg13g2_dfrbpq_1
XFILLER_176_703 VDD VSS sg13g2_decap_8
XFILLER_91_1458 VDD VSS sg13g2_fill_1
X_12729_ _12729_/X _13750_/Q _14102_/Q _14454_/Q _14550_/Q _12731_/S0 _12731_/S1 VDD
+ VSS sg13g2_mux4_1
Xclkbuf_leaf_37_clk_i _14743_/CLK clkbuf_leaf_38_clk_i/A VDD VSS sg13g2_buf_8
XFILLER_31_753 VDD VSS sg13g2_decap_8
XFILLER_148_449 VDD VSS sg13g2_fill_1
XFILLER_102_1212 VDD VSS sg13g2_decap_8
XFILLER_117_803 VDD VSS sg13g2_decap_8
XFILLER_157_972 VDD VSS sg13g2_decap_8
XFILLER_15_1264 VDD VSS sg13g2_decap_8
XFILLER_102_1223 VDD VSS sg13g2_fill_1
XFILLER_175_279 VDD VSS sg13g2_decap_8
XFILLER_50_1155 VDD VSS sg13g2_decap_8
XFILLER_102_1245 VDD VSS sg13g2_fill_1
XFILLER_11_1128 VDD VSS sg13g2_decap_8
XFILLER_172_920 VDD VSS sg13g2_decap_8
XFILLER_184_791 VDD VSS sg13g2_decap_8
XFILLER_128_184 VDD VSS sg13g2_fill_2
XFILLER_176_1324 VDD VSS sg13g2_decap_8
XFILLER_89_1376 VDD VSS sg13g2_decap_8
XFILLER_85_1218 VDD VSS sg13g2_decap_8
XFILLER_102_1289 VDD VSS sg13g2_decap_8
XFILLER_116_357 VDD VSS sg13g2_decap_8
XFILLER_144_666 VDD VSS sg13g2_decap_8
XFILLER_171_452 VDD VSS sg13g2_fill_1
X_09940_ _14524_/D _14524_/Q _10072_/A0 _09970_/S VDD VSS sg13g2_mux2_1
XFILLER_143_176 VDD VSS sg13g2_fill_2
XFILLER_125_891 VDD VSS sg13g2_fill_2
XFILLER_131_327 VDD VSS sg13g2_decap_4
XFILLER_135_1010 VDD VSS sg13g2_decap_4
Xfanout906 _12773_/S0 _12768_/S0 VDD VSS sg13g2_buf_1
XFILLER_174_1070 VDD VSS sg13g2_fill_1
Xfanout917 _13004_/A2 _13020_/A1 VDD VSS sg13g2_buf_1
X_09871_ _14458_/D _14458_/Q _10102_/A0 _09871_/S VDD VSS sg13g2_mux2_1
XFILLER_140_850 VDD VSS sg13g2_decap_8
Xfanout928 _13307_/A _13308_/A VDD VSS sg13g2_buf_1
XFILLER_135_1043 VDD VSS sg13g2_fill_1
Xfanout939 _13308_/B _10647_/A VDD VSS sg13g2_buf_1
XFILLER_58_606 VDD VSS sg13g2_decap_8
XFILLER_97_252 VDD VSS sg13g2_fill_1
X_08822_ _08822_/Y _13691_/Q _13482_/B VDD VSS sg13g2_nor2_1
X_14428__1774 _14428_/RESET_B VDD VSS sg13g2_tiehi
XFILLER_135_1076 VDD VSS sg13g2_decap_8
XFILLER_6_1432 VDD VSS sg13g2_decap_8
XFILLER_22_1202 VDD VSS sg13g2_decap_8
XFILLER_57_127 VDD VSS sg13g2_decap_8
XFILLER_39_842 VDD VSS sg13g2_fill_1
XFILLER_26_1382 VDD VSS sg13g2_decap_8
X_08753_ _13669_/D _08753_/A1 _08751_/Y _08752_/Y VDD VSS sg13g2_a21oi_1
XFILLER_100_769 VDD VSS sg13g2_decap_8
X_13666__2563 _13666_/RESET_B VDD VSS sg13g2_tiehi
XFILLER_113_1363 VDD VSS sg13g2_decap_8
XFILLER_96_1303 VDD VSS sg13g2_decap_8
XFILLER_61_1295 VDD VSS sg13g2_decap_8
XFILLER_38_352 VDD VSS sg13g2_fill_2
X_07704_ _07705_/A _15080_/Q _07694_/Y _15201_/Q _07697_/A VDD VSS sg13g2_a22oi_1
XFILLER_96_1314 VDD VSS sg13g2_fill_2
XFILLER_39_897 VDD VSS sg13g2_decap_8
XFILLER_22_1279 VDD VSS sg13g2_decap_8
X_08684_ _08684_/X _08684_/A _08684_/B VDD VSS sg13g2_xor2_1
XFILLER_96_1336 VDD VSS sg13g2_decap_8
XFILLER_54_18 VDD VSS sg13g2_decap_8
XFILLER_53_333 VDD VSS sg13g2_decap_4
XFILLER_26_547 VDD VSS sg13g2_fill_1
X_07635_ _07910_/A _14994_/Q VDD VSS sg13g2_inv_1
XFILLER_65_193 VDD VSS sg13g2_fill_2
XFILLER_26_569 VDD VSS sg13g2_decap_4
X_14917__2733 _14917_/RESET_B VDD VSS sg13g2_tiehi
XFILLER_41_506 VDD VSS sg13g2_decap_4
XFILLER_80_163 VDD VSS sg13g2_decap_8
XFILLER_0_1086 VDD VSS sg13g2_decap_8
XFILLER_59_1191 VDD VSS sg13g2_decap_8
X_09305_ _13913_/D _13913_/Q _10168_/A1 _09306_/S VDD VSS sg13g2_mux2_1
XFILLER_55_1044 VDD VSS sg13g2_fill_2
XFILLER_110_57 VDD VSS sg13g2_decap_8
XFILLER_142_1003 VDD VSS sg13g2_decap_8
XFILLER_55_1066 VDD VSS sg13g2_fill_1
XFILLER_22_764 VDD VSS sg13g2_fill_2
XFILLER_181_1085 VDD VSS sg13g2_decap_8
XFILLER_70_39 VDD VSS sg13g2_decap_8
X_09236_ _13847_/D _10166_/A1 _13847_/Q _09238_/S VDD VSS sg13g2_mux2_1
XFILLER_103_1009 VDD VSS sg13g2_decap_8
XFILLER_186_28 VDD VSS sg13g2_decap_8
XFILLER_33_1331 VDD VSS sg13g2_decap_8
XFILLER_72_1391 VDD VSS sg13g2_decap_8
XFILLER_10_959 VDD VSS sg13g2_decap_8
X_13916__2286 _13916_/RESET_B VDD VSS sg13g2_tiehi
XFILLER_135_600 VDD VSS sg13g2_fill_1
X_09167_ _13786_/D _13786_/Q _10169_/A1 _09167_/S VDD VSS sg13g2_mux2_1
XFILLER_163_920 VDD VSS sg13g2_decap_8
XFILLER_181_238 VDD VSS sg13g2_decap_8
XFILLER_68_1405 VDD VSS sg13g2_decap_8
XFILLER_135_633 VDD VSS sg13g2_decap_4
X_08118_ _08145_/A _07904_/B _08116_/Y _08117_/Y VDD VSS sg13g2_o21ai_1
XFILLER_107_346 VDD VSS sg13g2_decap_8
XFILLER_120_1378 VDD VSS sg13g2_fill_1
X_09098_ _09098_/Y _09158_/A _10747_/B _09097_/X VDD VSS sg13g2_o21ai_1
XFILLER_119_99 VDD VSS sg13g2_decap_8
XFILLER_123_828 VDD VSS sg13g2_decap_8
XFILLER_150_603 VDD VSS sg13g2_decap_8
XFILLER_1_602 VDD VSS sg13g2_decap_8
X_08049_ _08397_/B _08049_/A _08048_/B VDD VSS sg13g2_nor2b_1
XFILLER_123_839 VDD VSS sg13g2_fill_2
XFILLER_122_327 VDD VSS sg13g2_decap_8
XFILLER_66_1151 VDD VSS sg13g2_decap_8
XFILLER_0_112 VDD VSS sg13g2_decap_8
XFILLER_153_1110 VDD VSS sg13g2_fill_1
X_11060_ _11060_/X _11064_/C _11064_/D VDD VSS sg13g2_and2_1
XFILLER_27_1113 VDD VSS sg13g2_fill_1
XFILLER_27_1124 VDD VSS sg13g2_decap_8
Xhold3040 input1/A mem_axi_arready VDD VSS sg13g2_dlygate4sd3_1
XFILLER_77_904 VDD VSS sg13g2_decap_8
Xhold3051 input15/A mem_axi_rdata[1] VDD VSS sg13g2_dlygate4sd3_1
X_10011_ _14593_/D _10077_/A0 _14593_/Q _10023_/S VDD VSS sg13g2_mux2_1
XFILLER_95_14 VDD VSS sg13g2_decap_8
XFILLER_7_1218 VDD VSS sg13g2_decap_8
XFILLER_1_679 VDD VSS sg13g2_decap_8
XFILLER_49_617 VDD VSS sg13g2_decap_8
Xhold3062 input30/A mem_axi_rdata[4] VDD VSS sg13g2_dlygate4sd3_1
XFILLER_77_937 VDD VSS sg13g2_decap_4
XFILLER_118_1285 VDD VSS sg13g2_decap_8
Xhold3073 hold3073/X input35/X VDD VSS sg13g2_dlygate4sd3_1
XFILLER_49_639 VDD VSS sg13g2_decap_8
Xhold3084 input8/A mem_axi_rdata[13] VDD VSS sg13g2_dlygate4sd3_1
XFILLER_95_47 VDD VSS sg13g2_decap_4
XFILLER_76_425 VDD VSS sg13g2_decap_8
XFILLER_0_189 VDD VSS sg13g2_decap_8
XFILLER_103_596 VDD VSS sg13g2_decap_8
X_15128__2726 _15128_/RESET_B VDD VSS sg13g2_tiehi
Xhold3095 hold3095/X input14/X VDD VSS sg13g2_dlygate4sd3_1
XFILLER_48_149 VDD VSS sg13g2_decap_4
XFILLER_57_650 VDD VSS sg13g2_fill_2
X_14750_ _14750_/Q _15214_/CLK _14750_/D _14750_/RESET_B VDD VSS sg13g2_dfrbpq_1
XFILLER_91_428 VDD VSS sg13g2_decap_8
XFILLER_151_53 VDD VSS sg13g2_decap_8
X_11962_ _11962_/Y _11958_/Y _11959_/Y _11961_/Y _11960_/Y _11964_/B VDD VSS sg13g2_a221oi_1
XFILLER_40_1368 VDD VSS sg13g2_decap_8
XFILLER_84_480 VDD VSS sg13g2_fill_2
X_13701_ _16863_/A clkload58/A _13701_/D _13701_/RESET_B VDD VSS sg13g2_dfrbpq_1
X_10913_ _14935_/D _10912_/Y _10911_/Y _10903_/Y VDD VSS sg13g2_o21ai_1
X_14681_ _14681_/Q clkload44/A _14681_/D _14681_/RESET_B VDD VSS sg13g2_dfrbpq_1
XFILLER_45_867 VDD VSS sg13g2_decap_8
X_11893_ _11893_/X _14126_/Q _14158_/Q _11896_/A VDD VSS sg13g2_mux2_1
XFILLER_32_517 VDD VSS sg13g2_fill_2
X_13632_ _13740_/D _13632_/A VDD VSS sg13g2_buf_1
X_10844_ _10897_/D _10844_/A _10844_/B _10851_/D _10851_/C VDD VSS sg13g2_nand4_1
XFILLER_129_1392 VDD VSS sg13g2_decap_8
X_13563_ _13563_/Y _15010_/Q _13566_/B _13563_/C VDD VSS sg13g2_nor3_1
XFILLER_44_95 VDD VSS sg13g2_decap_8
XFILLER_34_1106 VDD VSS sg13g2_fill_1
XFILLER_13_764 VDD VSS sg13g2_decap_8
XFILLER_160_1114 VDD VSS sg13g2_fill_1
XFILLER_185_511 VDD VSS sg13g2_decap_8
X_10775_ _14920_/D _11168_/B1 _11163_/A _10774_/Y VDD VSS sg13g2_o21ai_1
XFILLER_38_1286 VDD VSS sg13g2_decap_8
XFILLER_34_1117 VDD VSS sg13g2_decap_8
XFILLER_160_1125 VDD VSS sg13g2_fill_2
XFILLER_164_1294 VDD VSS sg13g2_decap_8
XFILLER_12_252 VDD VSS sg13g2_decap_8
XFILLER_160_1136 VDD VSS sg13g2_decap_8
XFILLER_125_1256 VDD VSS sg13g2_fill_2
X_12514_ _12527_/A _12570_/A1 _12570_/A2 _08351_/B VDD VSS sg13g2_a21oi_1
XFILLER_9_735 VDD VSS sg13g2_decap_8
XFILLER_73_1199 VDD VSS sg13g2_decap_8
X_13494_ _13494_/Y _15071_/Q _13494_/B VDD VSS sg13g2_nor2_1
XFILLER_51_1431 VDD VSS sg13g2_decap_8
XFILLER_12_1404 VDD VSS sg13g2_decap_8
XFILLER_157_268 VDD VSS sg13g2_decap_8
X_15233_ _15233_/Q clkload31/A _15233_/D _15233_/RESET_B VDD VSS sg13g2_dfrbpq_1
XFILLER_8_256 VDD VSS sg13g2_decap_8
XFILLER_139_983 VDD VSS sg13g2_decap_8
XFILLER_157_279 VDD VSS sg13g2_fill_2
XFILLER_185_588 VDD VSS sg13g2_decap_8
X_12445_ _12445_/X _14562_/Q _14594_/Q _14626_/Q _14658_/Q _12450_/S0 _12450_/S1 VDD
+ VSS sg13g2_mux4_1
X_14506__1696 _14506_/RESET_B VDD VSS sg13g2_tiehi
XFILLER_138_471 VDD VSS sg13g2_decap_8
XFILLER_166_791 VDD VSS sg13g2_decap_8
X_14081__2121 _14081_/RESET_B VDD VSS sg13g2_tiehi
X_15164_ _15164_/Q clkload86/A _15164_/D _15164_/RESET_B VDD VSS sg13g2_dfrbpq_1
X_12376_ _12376_/X _13725_/Q _14077_/Q _14429_/Q _14525_/Q _12380_/S0 _12380_/S1 VDD
+ VSS sg13g2_mux4_1
XFILLER_5_952 VDD VSS sg13g2_decap_8
XFILLER_125_154 VDD VSS sg13g2_decap_8
X_14115_ _14115_/Q clkload8/A _14115_/D _14115_/RESET_B VDD VSS sg13g2_dfrbpq_1
XFILLER_113_305 VDD VSS sg13g2_decap_8
X_11327_ _11327_/Y _11322_/Y _11323_/Y _12290_/S0 VDD VSS sg13g2_a21oi_1
X_15095_ _15095_/Q clkload70/A _15095_/D _15095_/RESET_B VDD VSS sg13g2_dfrbpq_1
XFILLER_5_56 VDD VSS sg13g2_decap_8
XFILLER_4_462 VDD VSS sg13g2_decap_8
XFILLER_10_1183 VDD VSS sg13g2_decap_8
XFILLER_119_1027 VDD VSS sg13g2_fill_1
X_14685__1517 _14685_/RESET_B VDD VSS sg13g2_tiehi
XFILLER_84_1240 VDD VSS sg13g2_decap_8
XFILLER_113_338 VDD VSS sg13g2_decap_8
XFILLER_141_647 VDD VSS sg13g2_decap_8
XFILLER_141_658 VDD VSS sg13g2_fill_1
XFILLER_171_1210 VDD VSS sg13g2_decap_8
X_14046_ _14046_/Q _14668_/CLK _14046_/D _14046_/RESET_B VDD VSS sg13g2_dfrbpq_1
X_11258_ _11258_/Y _11256_/Y _11255_/Y _12190_/B _11257_/X VDD VSS sg13g2_a22oi_1
X_14721__1481 _14721_/RESET_B VDD VSS sg13g2_tiehi
XFILLER_140_157 VDD VSS sg13g2_fill_2
XFILLER_45_1235 VDD VSS sg13g2_decap_8
X_10209_ _14762_/D _13127_/A _10209_/B _10209_/C VDD VSS sg13g2_nor3_1
XFILLER_94_200 VDD VSS sg13g2_decap_8
XFILLER_132_1227 VDD VSS sg13g2_fill_1
X_11189_ _11189_/Y _11190_/C _11190_/A _11199_/B VDD VSS sg13g2_o21ai_1
XFILLER_68_948 VDD VSS sg13g2_decap_8
XFILLER_171_1287 VDD VSS sg13g2_decap_8
XFILLER_121_393 VDD VSS sg13g2_decap_8
X_14948_ _14948_/Q _15240_/CLK _14948_/D _14948_/RESET_B VDD VSS sg13g2_dfrbpq_1
XFILLER_78_1011 VDD VSS sg13g2_decap_8
XFILLER_94_299 VDD VSS sg13g2_decap_8
XFILLER_82_439 VDD VSS sg13g2_fill_1
XFILLER_169_1161 VDD VSS sg13g2_decap_8
XFILLER_1_1351 VDD VSS sg13g2_decap_8
X_14879_ _14879_/Q clkload90/A _14879_/D _14879_/RESET_B VDD VSS sg13g2_dfrbpq_1
XFILLER_23_506 VDD VSS sg13g2_decap_8
XFILLER_90_450 VDD VSS sg13g2_decap_4
XFILLER_78_1077 VDD VSS sg13g2_decap_8
XFILLER_165_1036 VDD VSS sg13g2_decap_8
XFILLER_91_1211 VDD VSS sg13g2_decap_8
XFILLER_51_848 VDD VSS sg13g2_decap_8
XFILLER_62_185 VDD VSS sg13g2_decap_8
XFILLER_56_1353 VDD VSS sg13g2_decap_8
XFILLER_50_347 VDD VSS sg13g2_decap_8
XFILLER_17_1315 VDD VSS sg13g2_decap_8
X_14291__1911 _14291_/RESET_B VDD VSS sg13g2_tiehi
XFILLER_50_358 VDD VSS sg13g2_fill_2
XFILLER_182_1383 VDD VSS sg13g2_decap_8
XFILLER_148_213 VDD VSS sg13g2_decap_8
XFILLER_52_1228 VDD VSS sg13g2_decap_8
XFILLER_86_0 VDD VSS sg13g2_decap_8
XFILLER_164_706 VDD VSS sg13g2_decap_8
XFILLER_148_268 VDD VSS sg13g2_decap_8
XFILLER_164_717 VDD VSS sg13g2_fill_2
XFILLER_176_577 VDD VSS sg13g2_fill_1
X_09021_ _09021_/X _15031_/Q _15228_/Q _09027_/S VDD VSS sg13g2_mux2_1
XFILLER_15_1061 VDD VSS sg13g2_decap_8
XFILLER_117_600 VDD VSS sg13g2_fill_2
XFILLER_176_599 VDD VSS sg13g2_decap_8
XFILLER_129_493 VDD VSS sg13g2_decap_8
XFILLER_89_1162 VDD VSS sg13g2_decap_4
XFILLER_116_121 VDD VSS sg13g2_decap_8
XFILLER_144_430 VDD VSS sg13g2_decap_8
XFILLER_176_1121 VDD VSS sg13g2_decap_8
XFILLER_85_1037 VDD VSS sg13g2_fill_1
XFILLER_137_1116 VDD VSS sg13g2_decap_8
XFILLER_116_176 VDD VSS sg13g2_decap_8
XFILLER_117_699 VDD VSS sg13g2_decap_8
XFILLER_132_625 VDD VSS sg13g2_decap_8
XFILLER_172_794 VDD VSS sg13g2_decap_8
XFILLER_104_327 VDD VSS sg13g2_fill_2
XFILLER_131_113 VDD VSS sg13g2_decap_8
XFILLER_85_1059 VDD VSS sg13g2_decap_8
XFILLER_172_1018 VDD VSS sg13g2_decap_8
XFILLER_104_349 VDD VSS sg13g2_decap_8
XFILLER_132_658 VDD VSS sg13g2_decap_4
XFILLER_176_1198 VDD VSS sg13g2_decap_8
X_09923_ _14508_/D _14508_/Q _09923_/A1 _09925_/S VDD VSS sg13g2_mux2_1
XFILLER_63_1302 VDD VSS sg13g2_decap_8
Xfanout703 _13336_/S _07663_/Y VDD VSS sg13g2_buf_1
XFILLER_160_978 VDD VSS sg13g2_decap_8
Xfanout714 _11443_/A fanout725/X VDD VSS sg13g2_buf_1
Xfanout725 fanout725/X _07655_/Y VDD VSS sg13g2_buf_1
XFILLER_86_701 VDD VSS sg13g2_decap_8
XFILLER_28_1455 VDD VSS sg13g2_decap_8
Xfanout736 _11529_/B _11894_/B VDD VSS sg13g2_buf_1
XFILLER_98_572 VDD VSS sg13g2_fill_1
Xfanout747 _11193_/A2 _13419_/A2 VDD VSS sg13g2_buf_1
X_09854_ _14441_/D _14441_/Q _09953_/A1 _09858_/S VDD VSS sg13g2_mux2_1
XFILLER_140_680 VDD VSS sg13g2_fill_2
Xfanout758 _08428_/S _08301_/S VDD VSS sg13g2_buf_1
XFILLER_24_1319 VDD VSS sg13g2_decap_8
Xfanout769 _08256_/B _08426_/A VDD VSS sg13g2_buf_1
XFILLER_63_1379 VDD VSS sg13g2_decap_8
XFILLER_140_691 VDD VSS sg13g2_fill_1
X_08805_ _13686_/D _08805_/A _08805_/B VDD VSS sg13g2_nor2_1
X_14805__2931 _14805_/RESET_B VDD VSS sg13g2_tiehi
X_09785_ _14374_/D _09917_/A1 _14374_/Q _09789_/S VDD VSS sg13g2_mux2_1
XFILLER_86_789 VDD VSS sg13g2_decap_8
XFILLER_22_1043 VDD VSS sg13g2_decap_8
XFILLER_61_1092 VDD VSS sg13g2_fill_1
XFILLER_39_672 VDD VSS sg13g2_decap_8
XFILLER_100_588 VDD VSS sg13g2_decap_8
X_08736_ _08736_/Y _08751_/A1 _07720_/B _15198_/Q VDD VSS sg13g2_o21ai_1
XFILLER_96_1111 VDD VSS sg13g2_decap_8
XFILLER_22_1076 VDD VSS sg13g2_decap_8
XFILLER_38_182 VDD VSS sg13g2_decap_8
XFILLER_2_1148 VDD VSS sg13g2_decap_8
XFILLER_26_322 VDD VSS sg13g2_fill_1
XFILLER_38_193 VDD VSS sg13g2_fill_1
X_08667_ _15247_/D _08685_/A1 _08666_/X _08661_/X VDD VSS sg13g2_o21ai_1
XFILLER_54_653 VDD VSS sg13g2_decap_8
XFILLER_164_7 VDD VSS sg13g2_decap_8
X_15029__2581 _15029_/RESET_B VDD VSS sg13g2_tiehi
XFILLER_82_973 VDD VSS sg13g2_decap_8
XFILLER_42_804 VDD VSS sg13g2_fill_2
XFILLER_26_355 VDD VSS sg13g2_fill_2
XFILLER_96_1177 VDD VSS sg13g2_fill_1
XFILLER_57_1128 VDD VSS sg13g2_decap_8
X_15228__3019 _15228_/RESET_B VDD VSS sg13g2_tiehi
X_07618_ _09011_/B _14901_/Q VDD VSS sg13g2_inv_1
XFILLER_121_78 VDD VSS sg13g2_fill_1
XFILLER_109_1229 VDD VSS sg13g2_decap_4
X_08598_ _08599_/C _08934_/A1 _08931_/A1 _08928_/A1 _08925_/A1 _08054_/B _08669_/B1
+ VDD VSS sg13g2_mux4_1
XFILLER_183_1169 VDD VSS sg13g2_decap_8
XFILLER_161_1401 VDD VSS sg13g2_decap_8
XFILLER_186_308 VDD VSS sg13g2_decap_8
XFILLER_81_49 VDD VSS sg13g2_decap_8
XFILLER_41_347 VDD VSS sg13g2_decap_8
XFILLER_74_1464 VDD VSS sg13g2_decap_8
XFILLER_35_1415 VDD VSS sg13g2_decap_8
XFILLER_14_21 VDD VSS sg13g2_decap_8
XFILLER_22_550 VDD VSS sg13g2_fill_2
X_15157__2666 _15157_/RESET_B VDD VSS sg13g2_tiehi
XFILLER_139_235 VDD VSS sg13g2_decap_8
XFILLER_22_583 VDD VSS sg13g2_fill_1
X_10560_ _10561_/D _14868_/Q _14867_/Q _14866_/Q _14865_/Q VDD VSS sg13g2_nand4_1
XFILLER_22_594 VDD VSS sg13g2_decap_8
XFILLER_10_756 VDD VSS sg13g2_decap_8
XFILLER_14_98 VDD VSS sg13g2_decap_8
X_09219_ _13830_/D _10149_/A1 _13830_/Q _09225_/S VDD VSS sg13g2_mux2_1
X_10491_ _10493_/A _10513_/D _10498_/D _10499_/C VDD VSS sg13g2_o21ai_1
XFILLER_148_791 VDD VSS sg13g2_decap_8
X_12230_ _12231_/B _12272_/A _12204_/A _12274_/A VDD VSS sg13g2_o21ai_1
XFILLER_68_1202 VDD VSS sg13g2_decap_8
XFILLER_136_953 VDD VSS sg13g2_fill_1
XFILLER_182_569 VDD VSS sg13g2_fill_2
XFILLER_5_259 VDD VSS sg13g2_decap_8
XFILLER_159_1374 VDD VSS sg13g2_decap_8
X_12161_ _12161_/Y _12157_/Y _12158_/Y _12160_/Y _12159_/Y _12190_/B VDD VSS sg13g2_a221oi_1
XFILLER_163_794 VDD VSS sg13g2_fill_1
XFILLER_30_86 VDD VSS sg13g2_decap_8
XFILLER_29_1219 VDD VSS sg13g2_decap_8
XFILLER_162_271 VDD VSS sg13g2_decap_4
XFILLER_68_1279 VDD VSS sg13g2_decap_8
XFILLER_150_433 VDD VSS sg13g2_decap_4
X_11112_ _14949_/D _11111_/Y _11110_/Y _11102_/Y VDD VSS sg13g2_o21ai_1
XFILLER_155_1249 VDD VSS sg13g2_fill_2
XFILLER_104_850 VDD VSS sg13g2_decap_8
X_12092_ _12092_/Y _12092_/A _12092_/B _12092_/C VDD VSS sg13g2_nand3_1
XFILLER_2_966 VDD VSS sg13g2_decap_8
XFILLER_1_476 VDD VSS sg13g2_decap_8
X_11043_ _11044_/B _11043_/A _11043_/B _11078_/D VDD VSS sg13g2_nand3_1
XFILLER_7_1015 VDD VSS sg13g2_decap_8
XFILLER_89_583 VDD VSS sg13g2_fill_1
XFILLER_42_1408 VDD VSS sg13g2_decap_8
XFILLER_118_1082 VDD VSS sg13g2_decap_8
XFILLER_81_1468 VDD VSS sg13g2_decap_8
XFILLER_162_74 VDD VSS sg13g2_decap_8
XFILLER_92_704 VDD VSS sg13g2_fill_2
XFILLER_92_715 VDD VSS sg13g2_fill_1
XFILLER_76_266 VDD VSS sg13g2_decap_8
XFILLER_65_929 VDD VSS sg13g2_decap_8
X_14802_ _14802_/Q clkload66/A _14802_/D _14802_/RESET_B VDD VSS sg13g2_dfrbpq_1
XFILLER_36_108 VDD VSS sg13g2_fill_2
XFILLER_58_981 VDD VSS sg13g2_decap_8
X_12994_ _13010_/A _12994_/A _13058_/D VDD VSS sg13g2_nand2_1
XFILLER_45_620 VDD VSS sg13g2_fill_1
XFILLER_40_1165 VDD VSS sg13g2_decap_8
XFILLER_79_1353 VDD VSS sg13g2_decap_8
XFILLER_57_491 VDD VSS sg13g2_decap_8
X_14733_ _14733_/Q clkload18/A _14733_/D _14733_/RESET_B VDD VSS sg13g2_dfrbpq_1
XFILLER_29_193 VDD VSS sg13g2_decap_8
X_11945_ _11946_/A _13968_/Q _14000_/Q _14032_/Q _14064_/Q _11969_/A _11970_/C VDD
+ VSS sg13g2_mux4_1
XFILLER_45_653 VDD VSS sg13g2_fill_2
XFILLER_18_889 VDD VSS sg13g2_decap_8
X_14099__2103 _14099_/RESET_B VDD VSS sg13g2_tiehi
XFILLER_73_984 VDD VSS sg13g2_decap_8
XFILLER_45_675 VDD VSS sg13g2_decap_8
XFILLER_60_612 VDD VSS sg13g2_decap_8
X_14664_ _14664_/Q _14728_/CLK _14664_/D _14664_/RESET_B VDD VSS sg13g2_dfrbpq_1
XFILLER_166_1367 VDD VSS sg13g2_decap_8
X_11876_ _11876_/Y _11873_/Y _11875_/X _11901_/B1 VDD VSS sg13g2_o21ai_1
XFILLER_32_325 VDD VSS sg13g2_fill_1
X_13615_ _13723_/D _13615_/A VDD VSS sg13g2_buf_1
XFILLER_38_1050 VDD VSS sg13g2_decap_8
X_10827_ _10831_/A _12347_/B _10827_/B VDD VSS sg13g2_nand2b_1
X_14595_ _14595_/Q _14723_/CLK _14595_/D _14595_/RESET_B VDD VSS sg13g2_dfrbpq_1
XFILLER_38_1072 VDD VSS sg13g2_decap_8
XFILLER_13_550 VDD VSS sg13g2_decap_8
X_13546_ _13546_/Y _13545_/A _13545_/B _08383_/B _13546_/B2 VDD VSS sg13g2_a22oi_1
XFILLER_9_532 VDD VSS sg13g2_decap_8
X_14739__1463 _14739_/RESET_B VDD VSS sg13g2_tiehi
X_10758_ _11115_/A _14948_/Q _10757_/A _10757_/Y VDD VSS sg13g2_a21oi_1
XFILLER_186_875 VDD VSS sg13g2_decap_8
XFILLER_12_1201 VDD VSS sg13g2_decap_8
XFILLER_185_385 VDD VSS sg13g2_decap_8
X_13477_ _15179_/D hold3071/X _15179_/Q _13477_/S VDD VSS sg13g2_mux2_1
XFILLER_173_536 VDD VSS sg13g2_fill_1
X_10689_ _10689_/Y _14899_/Q _10875_/B VDD VSS sg13g2_nand2_1
XFILLER_127_931 VDD VSS sg13g2_fill_2
XFILLER_139_791 VDD VSS sg13g2_decap_8
X_14901__2765 _14901_/RESET_B VDD VSS sg13g2_tiehi
X_15216_ _15216_/Q clkload71/A _15216_/D _15216_/RESET_B VDD VSS sg13g2_dfrbpq_1
XFILLER_127_953 VDD VSS sg13g2_fill_2
X_12428_ _12428_/X _12426_/X _12427_/X _12706_/S VDD VSS sg13g2_mux2_1
XFILLER_12_1278 VDD VSS sg13g2_decap_8
XFILLER_126_463 VDD VSS sg13g2_decap_8
XFILLER_86_1335 VDD VSS sg13g2_decap_8
XFILLER_138_1414 VDD VSS sg13g2_decap_8
XFILLER_142_923 VDD VSS sg13g2_decap_4
X_15147_ _15147_/Q _15162_/CLK _15147_/D _15147_/RESET_B VDD VSS sg13g2_dfrbpq_1
XFILLER_99_303 VDD VSS sg13g2_decap_8
X_12359_ _12359_/Y _15119_/Q _12348_/A _12791_/A2 _15123_/Q _13282_/A1 VDD VSS sg13g2_a221oi_1
XFILLER_173_1316 VDD VSS sg13g2_decap_8
XFILLER_47_1319 VDD VSS sg13g2_decap_8
XFILLER_126_496 VDD VSS sg13g2_fill_1
XFILLER_142_945 VDD VSS sg13g2_decap_8
XFILLER_114_647 VDD VSS sg13g2_decap_8
X_15078_ _15078_/Q _15214_/CLK _15078_/D _15078_/RESET_B VDD VSS sg13g2_dfrbpq_1
XFILLER_142_989 VDD VSS sg13g2_decap_8
XFILLER_99_369 VDD VSS sg13g2_decap_8
X_14934__2699 _14934_/RESET_B VDD VSS sg13g2_tiehi
XFILLER_45_1032 VDD VSS sg13g2_decap_8
X_14029_ _14029_/Q clkload24/A _14029_/D _14029_/RESET_B VDD VSS sg13g2_dfrbpq_1
XFILLER_68_723 VDD VSS sg13g2_decap_4
XFILLER_136_1193 VDD VSS sg13g2_decap_8
XFILLER_132_1035 VDD VSS sg13g2_decap_8
XFILLER_132_1057 VDD VSS sg13g2_fill_2
XFILLER_56_929 VDD VSS sg13g2_fill_1
XFILLER_62_1390 VDD VSS sg13g2_decap_8
XFILLER_110_1300 VDD VSS sg13g2_fill_2
XFILLER_67_277 VDD VSS sg13g2_decap_8
X_09570_ _14168_/D _09737_/A0 _14168_/Q _09571_/S VDD VSS sg13g2_mux2_1
XFILLER_83_737 VDD VSS sg13g2_decap_4
XFILLER_23_1374 VDD VSS sg13g2_decap_8
XFILLER_3_1446 VDD VSS sg13g2_decap_8
XFILLER_97_1442 VDD VSS sg13g2_decap_8
XFILLER_184_1401 VDD VSS sg13g2_decap_8
X_08521_ _08521_/X _08279_/A _08362_/X _08457_/X _08597_/C _08597_/B _08452_/C VDD
+ VSS sg13g2_mux4_1
XFILLER_58_1448 VDD VSS sg13g2_decap_8
X_08452_ _08461_/A _08452_/A _08544_/B _08452_/C _08452_/D VDD VSS sg13g2_nand4_1
XFILLER_24_837 VDD VSS sg13g2_decap_8
XFILLER_145_1418 VDD VSS sg13g2_decap_8
XFILLER_50_100 VDD VSS sg13g2_decap_8
X_15112__2758 _15112_/RESET_B VDD VSS sg13g2_tiehi
XFILLER_149_500 VDD VSS sg13g2_decap_8
XFILLER_56_1150 VDD VSS sg13g2_decap_8
XFILLER_17_1112 VDD VSS sg13g2_decap_8
X_08383_ _08412_/B _08383_/A _08383_/B VDD VSS sg13g2_nor2_1
XFILLER_108_1240 VDD VSS sg13g2_fill_2
X_15092__2820 _15092_/RESET_B VDD VSS sg13g2_tiehi
XFILLER_177_842 VDD VSS sg13g2_decap_8
XFILLER_182_1180 VDD VSS sg13g2_decap_8
XFILLER_108_1262 VDD VSS sg13g2_decap_8
XFILLER_32_892 VDD VSS sg13g2_decap_8
XFILLER_52_1047 VDD VSS sg13g2_decap_8
XFILLER_31_391 VDD VSS sg13g2_decap_8
XFILLER_137_717 VDD VSS sg13g2_decap_8
XFILLER_177_897 VDD VSS sg13g2_fill_2
XFILLER_17_1189 VDD VSS sg13g2_decap_8
XFILLER_118_931 VDD VSS sg13g2_decap_8
X_13797__2405 _13797_/RESET_B VDD VSS sg13g2_tiehi
XFILLER_118_942 VDD VSS sg13g2_fill_2
X_09004_ _09006_/B _14900_/Q _08993_/X _14901_/Q VDD VSS sg13g2_a21oi_1
XFILLER_30_1356 VDD VSS sg13g2_decap_8
XFILLER_133_901 VDD VSS sg13g2_decap_8
XFILLER_105_603 VDD VSS sg13g2_fill_2
XFILLER_118_986 VDD VSS sg13g2_decap_8
XFILLER_118_997 VDD VSS sg13g2_decap_4
XFILLER_117_474 VDD VSS sg13g2_decap_8
XFILLER_183_18 VDD VSS sg13g2_decap_8
XFILLER_145_794 VDD VSS sg13g2_decap_8
XFILLER_104_135 VDD VSS sg13g2_fill_1
X_14177__2025 _14177_/RESET_B VDD VSS sg13g2_tiehi
Xfanout500 _08956_/S _08876_/S VDD VSS sg13g2_buf_1
Xfanout511 _13655_/S _10202_/S VDD VSS sg13g2_buf_1
XFILLER_8_1313 VDD VSS sg13g2_decap_8
XFILLER_67_1290 VDD VSS sg13g2_decap_8
XFILLER_115_1200 VDD VSS sg13g2_decap_8
Xfanout522 _13515_/S _13512_/S VDD VSS sg13g2_buf_1
X_09906_ _14491_/D _14491_/Q _09906_/A1 _09937_/S VDD VSS sg13g2_mux2_1
XFILLER_28_1252 VDD VSS sg13g2_decap_8
XFILLER_154_1260 VDD VSS sg13g2_decap_8
Xfanout533 _12596_/A2 _12791_/A2 VDD VSS sg13g2_buf_1
XFILLER_99_892 VDD VSS sg13g2_fill_1
XFILLER_113_680 VDD VSS sg13g2_decap_4
XFILLER_59_734 VDD VSS sg13g2_decap_8
Xfanout544 _10105_/A _08972_/X VDD VSS sg13g2_buf_1
XFILLER_115_1233 VDD VSS sg13g2_decap_8
Xfanout555 _09162_/A _08967_/Y VDD VSS sg13g2_buf_1
Xfanout566 _08544_/B _08400_/Y VDD VSS sg13g2_buf_1
XFILLER_76_49 VDD VSS sg13g2_decap_8
XFILLER_63_1176 VDD VSS sg13g2_decap_8
XFILLER_58_233 VDD VSS sg13g2_decap_8
Xfanout577 _12918_/B1 _13030_/B1 VDD VSS sg13g2_buf_1
X_09837_ _14425_/D _09936_/A1 _14425_/Q _09837_/S VDD VSS sg13g2_mux2_1
Xfanout588 _13264_/A2 _13561_/S VDD VSS sg13g2_buf_1
XFILLER_100_352 VDD VSS sg13g2_decap_8
XFILLER_132_11 VDD VSS sg13g2_fill_1
Xfanout599 _10862_/B _10800_/B VDD VSS sg13g2_buf_1
XFILLER_98_1217 VDD VSS sg13g2_fill_1
XFILLER_86_586 VDD VSS sg13g2_decap_8
XFILLER_73_203 VDD VSS sg13g2_decap_8
XFILLER_150_1179 VDD VSS sg13g2_decap_8
XFILLER_98_1239 VDD VSS sg13g2_decap_8
X_09768_ _14358_/D _14358_/Q _09933_/A1 _09772_/S VDD VSS sg13g2_mux2_1
XFILLER_46_439 VDD VSS sg13g2_decap_8
XFILLER_41_1474 VDD VSS sg13g2_decap_4
X_08719_ _15192_/D hold3069/X _15192_/Q _13477_/S VDD VSS sg13g2_mux2_1
X_09699_ _14291_/D _10095_/A0 _14291_/Q _09704_/S VDD VSS sg13g2_mux2_1
XFILLER_162_4 VDD VSS sg13g2_decap_8
X_11730_ _11730_/Y _11741_/A _14122_/Q VDD VSS sg13g2_nand2b_1
XFILLER_109_1004 VDD VSS sg13g2_fill_1
XFILLER_148_1064 VDD VSS sg13g2_decap_8
XFILLER_25_53 VDD VSS sg13g2_decap_8
XFILLER_159_308 VDD VSS sg13g2_decap_8
XFILLER_25_64 VDD VSS sg13g2_fill_1
XFILLER_186_105 VDD VSS sg13g2_decap_8
X_11661_ _11773_/B _14970_/Q _13680_/Q VDD VSS sg13g2_xnor2_1
X_14208__1994 _14208_/RESET_B VDD VSS sg13g2_tiehi
XFILLER_74_1261 VDD VSS sg13g2_decap_8
XFILLER_70_987 VDD VSS sg13g2_fill_1
XFILLER_35_1212 VDD VSS sg13g2_decap_8
XFILLER_39_1392 VDD VSS sg13g2_decap_8
X_13400_ _13400_/Y _13437_/A _13400_/B _15088_/Q VDD VSS sg13g2_nand3_1
X_14984__2626 _14984_/RESET_B VDD VSS sg13g2_tiehi
X_10612_ _10614_/B _14880_/Q _14879_/Q VDD VSS sg13g2_nand2_1
X_14380_ _14380_/Q _14508_/CLK _14380_/D _14380_/RESET_B VDD VSS sg13g2_dfrbpq_1
X_11592_ _11593_/B _11570_/A _13683_/Q _11571_/Y VDD VSS sg13g2_a21oi_1
XFILLER_161_1275 VDD VSS sg13g2_decap_8
XFILLER_183_812 VDD VSS sg13g2_decap_8
XFILLER_168_897 VDD VSS sg13g2_decap_8
X_13331_ _15173_/D _13502_/B VDD VSS sg13g2_inv_1
XFILLER_35_1289 VDD VSS sg13g2_decap_8
XFILLER_10_553 VDD VSS sg13g2_decap_8
X_10543_ _10544_/B _14863_/Q _13273_/A _10543_/C _10543_/D VDD VSS sg13g2_nand4_1
XFILLER_183_845 VDD VSS sg13g2_decap_8
X_14387__1815 _14387_/RESET_B VDD VSS sg13g2_tiehi
X_13262_ _13262_/Y _14797_/Q _13275_/A2 _13262_/B1 VDD VSS sg13g2_o21ai_1
X_10474_ _10474_/Y _10504_/C _10492_/C _10499_/C VDD VSS sg13g2_o21ai_1
XFILLER_6_557 VDD VSS sg13g2_decap_8
XFILLER_157_74 VDD VSS sg13g2_decap_4
XFILLER_183_889 VDD VSS sg13g2_fill_1
X_15001_ _15001_/Q clkload31/A _15001_/D _15001_/RESET_B VDD VSS sg13g2_dfrbpq_1
XFILLER_136_772 VDD VSS sg13g2_decap_8
X_12213_ _12213_/X _14135_/Q _14167_/Q _14199_/Q _14231_/Q _12215_/S0 _12241_/B1 VDD
+ VSS sg13g2_mux4_1
XFILLER_68_1032 VDD VSS sg13g2_decap_8
XFILLER_109_997 VDD VSS sg13g2_decap_8
XFILLER_170_528 VDD VSS sg13g2_decap_8
X_13193_ _13196_/A _14792_/Q _13248_/B VDD VSS sg13g2_nand2_1
XFILLER_155_1002 VDD VSS sg13g2_fill_2
XFILLER_159_1171 VDD VSS sg13g2_decap_8
XFILLER_163_580 VDD VSS sg13g2_decap_8
XFILLER_123_444 VDD VSS sg13g2_decap_8
X_12144_ _12144_/Y _12223_/A _12144_/B VDD VSS sg13g2_nor2_1
XFILLER_46_1330 VDD VSS sg13g2_decap_8
XFILLER_2_763 VDD VSS sg13g2_decap_8
XFILLER_123_477 VDD VSS sg13g2_decap_8
XFILLER_85_1390 VDD VSS sg13g2_decap_8
X_12075_ _12077_/B _12143_/A _12075_/B VDD VSS sg13g2_nor2_1
XFILLER_96_339 VDD VSS sg13g2_decap_8
XFILLER_104_680 VDD VSS sg13g2_decap_8
XFILLER_173_84 VDD VSS sg13g2_decap_8
XFILLER_1_273 VDD VSS sg13g2_decap_8
XFILLER_42_1205 VDD VSS sg13g2_decap_8
XFILLER_81_1265 VDD VSS sg13g2_decap_8
XFILLER_49_222 VDD VSS sg13g2_decap_8
XFILLER_172_1382 VDD VSS sg13g2_decap_8
XFILLER_2_35 VDD VSS sg13g2_decap_8
X_11026_ _11029_/A _11022_/Y _11064_/B _11025_/Y VDD VSS sg13g2_o21ai_1
XFILLER_133_1355 VDD VSS sg13g2_decap_8
X_16883_ _16883_/X _16883_/A VDD VSS sg13g2_buf_1
XFILLER_77_575 VDD VSS sg13g2_fill_1
XFILLER_77_586 VDD VSS sg13g2_decap_8
XFILLER_49_277 VDD VSS sg13g2_decap_8
XFILLER_18_642 VDD VSS sg13g2_decap_8
X_12977_ _12977_/Y _14810_/Q _13029_/A2 _12947_/B _14874_/Q _13069_/C1 VDD VSS sg13g2_a221oi_1
XFILLER_80_718 VDD VSS sg13g2_decap_8
XFILLER_166_1120 VDD VSS sg13g2_decap_4
X_13875__2327 _13875_/RESET_B VDD VSS sg13g2_tiehi
XFILLER_61_910 VDD VSS sg13g2_decap_8
XFILLER_46_984 VDD VSS sg13g2_decap_8
XFILLER_79_1183 VDD VSS sg13g2_decap_8
X_13911__2291 _13911_/RESET_B VDD VSS sg13g2_tiehi
X_14716_ _14716_/Q _15052_/CLK _14716_/D _14716_/RESET_B VDD VSS sg13g2_dfrbpq_1
X_11928_ _11928_/X _11920_/X _11921_/X _11923_/X _11922_/X _12290_/S0 _11999_/S1 VDD
+ VSS sg13g2_mux4_1
XFILLER_75_1025 VDD VSS sg13g2_decap_8
XFILLER_45_483 VDD VSS sg13g2_decap_8
XFILLER_166_1164 VDD VSS sg13g2_decap_8
XFILLER_178_628 VDD VSS sg13g2_decap_4
XFILLER_127_1137 VDD VSS sg13g2_decap_8
X_14647_ _14647_/Q clkload41/A _14647_/D _14647_/RESET_B VDD VSS sg13g2_dfrbpq_1
XFILLER_177_116 VDD VSS sg13g2_decap_8
X_11859_ _11859_/Y _11791_/S _11857_/X _11858_/Y VDD VSS sg13g2_o21ai_1
XANTENNA_18 _09727_/S VDD VSS sg13g2_antennanp
XFILLER_20_328 VDD VSS sg13g2_decap_8
XFILLER_159_864 VDD VSS sg13g2_decap_8
X_14578_ _14578_/Q clkload36/A _14578_/D _14578_/RESET_B VDD VSS sg13g2_dfrbpq_1
XFILLER_119_706 VDD VSS sg13g2_fill_2
XFILLER_53_1356 VDD VSS sg13g2_decap_8
XFILLER_186_672 VDD VSS sg13g2_decap_8
XFILLER_105_1457 VDD VSS sg13g2_decap_8
X_13529_ _13529_/X _13529_/A _13545_/B VDD VSS sg13g2_and2_1
XFILLER_173_311 VDD VSS sg13g2_decap_4
XFILLER_185_182 VDD VSS sg13g2_decap_8
XFILLER_173_333 VDD VSS sg13g2_decap_8
XFILLER_134_709 VDD VSS sg13g2_decap_8
XFILLER_12_1075 VDD VSS sg13g2_decap_8
XFILLER_173_388 VDD VSS sg13g2_fill_2
Xoutput103 mem_axi_rready _07658_/X VDD VSS sg13g2_buf_1
XFILLER_86_1132 VDD VSS sg13g2_decap_8
Xoutput114 mem_axi_wdata[19] _15151_/Q VDD VSS sg13g2_buf_1
XFILLER_99_100 VDD VSS sg13g2_decap_8
Xoutput125 mem_axi_wdata[29] _15161_/Q VDD VSS sg13g2_buf_1
Xoutput136 mem_axi_wstrb[0] _15164_/Q VDD VSS sg13g2_buf_1
XFILLER_142_742 VDD VSS sg13g2_decap_8
XFILLER_173_1113 VDD VSS sg13g2_decap_8
XFILLER_177_1282 VDD VSS sg13g2_decap_8
X_15141__2698 _15141_/RESET_B VDD VSS sg13g2_tiehi
XFILLER_86_1176 VDD VSS sg13g2_decap_8
XFILLER_49_0 VDD VSS sg13g2_decap_8
X_15227__3018 _15227_/RESET_B VDD VSS sg13g2_tiehi
XFILLER_82_1029 VDD VSS sg13g2_decap_8
XFILLER_102_606 VDD VSS sg13g2_decap_4
XFILLER_88_829 VDD VSS sg13g2_fill_1
XFILLER_134_1108 VDD VSS sg13g2_decap_8
XFILLER_138_1277 VDD VSS sg13g2_decap_8
X_07952_ _07952_/Y _15009_/Q _11914_/A VDD VSS sg13g2_nor2b_1
XFILLER_64_1463 VDD VSS sg13g2_decap_8
XFILLER_141_296 VDD VSS sg13g2_decap_8
XFILLER_151_1422 VDD VSS sg13g2_decap_8
XFILLER_25_1425 VDD VSS sg13g2_decap_8
XFILLER_151_1433 VDD VSS sg13g2_fill_1
XFILLER_151_1444 VDD VSS sg13g2_decap_8
X_07883_ _08073_/C _07883_/A _08023_/B VDD VSS sg13g2_nand2_1
XFILLER_95_350 VDD VSS sg13g2_fill_1
X_09622_ _14218_/D _09622_/A0 _14218_/Q _09622_/S VDD VSS sg13g2_mux2_1
XFILLER_96_895 VDD VSS sg13g2_decap_4
XFILLER_23_1171 VDD VSS sg13g2_decap_8
XFILLER_3_1243 VDD VSS sg13g2_decap_8
XFILLER_55_247 VDD VSS sg13g2_decap_8
X_09553_ _14151_/D _09654_/A0 _14151_/Q _09562_/S VDD VSS sg13g2_mux2_1
XFILLER_102_14 VDD VSS sg13g2_fill_2
XFILLER_83_578 VDD VSS sg13g2_decap_8
XFILLER_93_1103 VDD VSS sg13g2_fill_2
X_14465__1737 _14465_/RESET_B VDD VSS sg13g2_tiehi
X_08504_ _08504_/Y _15009_/Q _07820_/B _08497_/A VDD VSS sg13g2_a21oi_1
XFILLER_149_1351 VDD VSS sg13g2_decap_8
X_09484_ _14084_/D _10147_/A1 _14084_/Q _09500_/S VDD VSS sg13g2_mux2_1
XFILLER_58_1245 VDD VSS sg13g2_decap_8
XFILLER_52_943 VDD VSS sg13g2_decap_8
XFILLER_93_1136 VDD VSS sg13g2_decap_4
XFILLER_63_280 VDD VSS sg13g2_decap_4
XFILLER_62_18 VDD VSS sg13g2_decap_8
XFILLER_184_1275 VDD VSS sg13g2_decap_8
XFILLER_145_1237 VDD VSS sg13g2_decap_8
XFILLER_168_105 VDD VSS sg13g2_decap_8
X_08435_ _08435_/Y _08435_/A _08442_/B VDD VSS sg13g2_nand2_1
XFILLER_52_987 VDD VSS sg13g2_fill_1
XFILLER_52_998 VDD VSS sg13g2_decap_8
XFILLER_51_464 VDD VSS sg13g2_decap_8
XFILLER_24_689 VDD VSS sg13g2_decap_8
XFILLER_23_166 VDD VSS sg13g2_decap_4
XFILLER_23_188 VDD VSS sg13g2_decap_8
X_08366_ _08366_/X _08414_/D _08414_/A _08414_/B _08366_/D VDD VSS sg13g2_or4_1
XFILLER_32_1407 VDD VSS sg13g2_decap_8
XFILLER_71_1467 VDD VSS sg13g2_decap_8
X_14680__1522 _14680_/RESET_B VDD VSS sg13g2_tiehi
XFILLER_71_1478 VDD VSS sg13g2_fill_1
XFILLER_20_873 VDD VSS sg13g2_decap_4
X_08297_ _08297_/Y _08391_/A _08294_/Y _08296_/Y _08295_/Y VDD VSS sg13g2_a22oi_1
XFILLER_127_7 VDD VSS sg13g2_fill_2
XFILLER_178_1002 VDD VSS sg13g2_decap_8
XFILLER_11_11 VDD VSS sg13g2_decap_8
XFILLER_165_878 VDD VSS sg13g2_decap_8
XFILLER_164_366 VDD VSS sg13g2_decap_4
XFILLER_30_1153 VDD VSS sg13g2_decap_8
XFILLER_178_1068 VDD VSS sg13g2_decap_8
XFILLER_106_934 VDD VSS sg13g2_fill_2
XFILLER_156_1322 VDD VSS sg13g2_decap_8
XFILLER_69_1374 VDD VSS sg13g2_decap_8
XFILLER_11_88 VDD VSS sg13g2_decap_8
X_10190_ _14752_/D _15195_/D _14752_/Q _13651_/S VDD VSS sg13g2_mux2_1
XFILLER_132_241 VDD VSS sg13g2_decap_8
XFILLER_105_466 VDD VSS sg13g2_decap_4
XFILLER_106_989 VDD VSS sg13g2_decap_8
X_13953__2249 _13953_/RESET_B VDD VSS sg13g2_tiehi
XFILLER_65_1249 VDD VSS sg13g2_decap_8
XFILLER_152_1208 VDD VSS sg13g2_fill_1
Xfanout1306 _12026_/C _12139_/S1 VDD VSS sg13g2_buf_1
XFILLER_8_1110 VDD VSS sg13g2_decap_8
XFILLER_156_1399 VDD VSS sg13g2_decap_8
Xfanout1317 _11228_/S1 _12326_/B1 VDD VSS sg13g2_buf_1
Xfanout330 _09858_/S _09865_/S VDD VSS sg13g2_buf_1
Xfanout1328 _11756_/S fanout1329/X VDD VSS sg13g2_buf_1
XFILLER_28_1060 VDD VSS sg13g2_decap_8
Xfanout341 _09760_/S _09740_/Y VDD VSS sg13g2_buf_1
Xfanout1339 fanout1339/X fanout1394/X VDD VSS sg13g2_buf_1
XFILLER_115_1030 VDD VSS sg13g2_decap_8
Xfanout352 _09706_/S _09694_/S VDD VSS sg13g2_buf_1
Xfanout363 _09506_/S fanout364/X VDD VSS sg13g2_buf_1
Xfanout374 _09306_/S _09294_/S VDD VSS sg13g2_buf_1
Xfanout385 _09202_/S _09170_/Y VDD VSS sg13g2_buf_1
XFILLER_8_1187 VDD VSS sg13g2_decap_8
XFILLER_74_501 VDD VSS sg13g2_fill_1
XFILLER_101_672 VDD VSS sg13g2_decap_8
X_12900_ _12902_/B _12900_/A _12900_/B _12900_/C input18/X VDD VSS sg13g2_nand4_1
Xfanout396 _10010_/A0 _09612_/A0 VDD VSS sg13g2_buf_1
XFILLER_4_1029 VDD VSS sg13g2_decap_8
XFILLER_46_203 VDD VSS sg13g2_decap_8
XFILLER_59_597 VDD VSS sg13g2_fill_2
XFILLER_19_439 VDD VSS sg13g2_decap_8
X_13880_ _13880_/Q clkload68/A _13880_/D _13880_/RESET_B VDD VSS sg13g2_dfrbpq_1
XFILLER_74_534 VDD VSS sg13g2_decap_8
XFILLER_185_1006 VDD VSS sg13g2_decap_8
XFILLER_41_1271 VDD VSS sg13g2_decap_8
X_12831_ _12831_/Y _14769_/Q _12918_/A2 _12918_/B1 VDD VSS sg13g2_o21ai_1
XFILLER_46_258 VDD VSS sg13g2_decap_8
XFILLER_55_770 VDD VSS sg13g2_fill_2
XFILLER_28_995 VDD VSS sg13g2_decap_4
XFILLER_167_1451 VDD VSS sg13g2_decap_8
X_12762_ _12762_/X _12760_/X _12761_/X _12762_/S VDD VSS sg13g2_mux2_1
XFILLER_76_1345 VDD VSS sg13g2_decap_8
XFILLER_43_943 VDD VSS sg13g2_decap_8
X_14501_ _14501_/Q clkload20/A _14501_/D _14501_/RESET_B VDD VSS sg13g2_dfrbpq_1
XFILLER_14_133 VDD VSS sg13g2_decap_8
XFILLER_159_105 VDD VSS sg13g2_decap_8
X_11713_ _11713_/X _13961_/Q _13993_/Q _14025_/Q _14057_/Q _11715_/S0 _11715_/S1 VDD
+ VSS sg13g2_mux4_1
XFILLER_72_1209 VDD VSS sg13g2_decap_8
XFILLER_42_442 VDD VSS sg13g2_fill_2
XFILLER_37_1329 VDD VSS sg13g2_decap_8
X_12693_ _12694_/B _13189_/B _12749_/A2 _12692_/X _12749_/B2 _12749_/C1 VDD VSS sg13g2_a221oi_1
XFILLER_128_1468 VDD VSS sg13g2_fill_2
XFILLER_163_1359 VDD VSS sg13g2_decap_8
XFILLER_42_486 VDD VSS sg13g2_fill_2
XFILLER_30_626 VDD VSS sg13g2_decap_8
X_14432_ _14432_/Q _14528_/CLK _14432_/D _14432_/RESET_B VDD VSS sg13g2_dfrbpq_1
XFILLER_30_637 VDD VSS sg13g2_fill_2
X_11644_ _11644_/X _14695_/Q _14727_/Q _13767_/Q _13799_/Q _11649_/S0 _11649_/S1 VDD
+ VSS sg13g2_mux4_1
XFILLER_174_119 VDD VSS sg13g2_decap_8
X_14363_ _14363_/Q clkload79/A _14363_/D _14363_/RESET_B VDD VSS sg13g2_dfrbpq_1
XFILLER_10_350 VDD VSS sg13g2_decap_8
Xinput16 input16/X input16/A VDD VSS sg13g2_buf_1
X_11575_ _11575_/X _13829_/Q _13861_/Q _13893_/Q _13925_/Q _11580_/S0 _11580_/S1 VDD
+ VSS sg13g2_mux4_1
Xinput27 input27/X input27/A VDD VSS sg13g2_buf_1
XFILLER_7_833 VDD VSS sg13g2_decap_8
XFILLER_128_547 VDD VSS sg13g2_decap_8
XFILLER_168_84 VDD VSS sg13g2_decap_8
X_13314_ _13314_/X _15061_/Q _13600_/C _13316_/C VDD VSS sg13g2_and3_1
Xinput38 input38/X rst_ni VDD VSS sg13g2_buf_1
XFILLER_182_130 VDD VSS sg13g2_decap_8
X_10526_ _14857_/D _10564_/D _10531_/D _10525_/Y VDD VSS sg13g2_a21oi_1
XFILLER_171_804 VDD VSS sg13g2_fill_2
X_14294_ _14294_/Q _14742_/CLK _14294_/D _14294_/RESET_B VDD VSS sg13g2_dfrbpq_1
XFILLER_109_761 VDD VSS sg13g2_fill_2
XFILLER_13_1362 VDD VSS sg13g2_decap_8
XFILLER_143_506 VDD VSS sg13g2_decap_8
XFILLER_6_354 VDD VSS sg13g2_decap_8
XFILLER_108_260 VDD VSS sg13g2_fill_1
XFILLER_155_388 VDD VSS sg13g2_decap_8
XFILLER_183_697 VDD VSS sg13g2_fill_1
X_13245_ _13245_/X _13245_/A _13665_/Q _13246_/C VDD VSS sg13g2_and3_1
X_10457_ _10460_/C _14841_/Q _10462_/D _14842_/Q VDD VSS sg13g2_a21oi_1
XFILLER_83_1305 VDD VSS sg13g2_decap_8
XFILLER_123_230 VDD VSS sg13g2_decap_8
XFILLER_184_72 VDD VSS sg13g2_decap_8
X_13176_ _13188_/A _13176_/A _13176_/B _13176_/C VDD VSS sg13g2_nand3_1
XFILLER_48_1447 VDD VSS sg13g2_decap_8
XFILLER_42_7 VDD VSS sg13g2_decap_8
XFILLER_174_1455 VDD VSS sg13g2_decap_8
X_10388_ _10388_/Y _14820_/Q _10386_/C _10630_/C VDD VSS sg13g2_o21ai_1
XFILLER_112_926 VDD VSS sg13g2_decap_4
X_14543__1659 _14543_/RESET_B VDD VSS sg13g2_tiehi
XFILLER_2_560 VDD VSS sg13g2_decap_8
XFILLER_170_1319 VDD VSS sg13g2_decap_8
X_13929__2273 _13929_/RESET_B VDD VSS sg13g2_tiehi
X_12127_ _12155_/A _12128_/A _13667_/Q VDD VSS sg13g2_nand2_1
XFILLER_123_285 VDD VSS sg13g2_decap_8
XFILLER_81_1040 VDD VSS sg13g2_fill_1
XFILLER_111_447 VDD VSS sg13g2_decap_4
X_12058_ _12058_/Y _12012_/A _12008_/Y _12010_/B VDD VSS sg13g2_o21ai_1
XFILLER_81_1084 VDD VSS sg13g2_fill_1
X_14797__2939 _14797_/RESET_B VDD VSS sg13g2_tiehi
XFILLER_77_361 VDD VSS sg13g2_decap_8
XFILLER_38_715 VDD VSS sg13g2_decap_8
X_11009_ _11010_/C _11009_/A _11009_/B _11009_/C _11009_/D VDD VSS sg13g2_nand4_1
X_16866_ _16866_/X _16866_/A VDD VSS sg13g2_buf_1
XFILLER_93_843 VDD VSS sg13g2_decap_8
XFILLER_42_1079 VDD VSS sg13g2_decap_8
XFILLER_37_236 VDD VSS sg13g2_fill_1
XFILLER_92_342 VDD VSS sg13g2_decap_8
XFILLER_168_1237 VDD VSS sg13g2_decap_8
XFILLER_20_1333 VDD VSS sg13g2_decap_8
XFILLER_80_504 VDD VSS sg13g2_decap_8
XFILLER_52_217 VDD VSS sg13g2_fill_2
XFILLER_34_943 VDD VSS sg13g2_fill_1
XFILLER_179_926 VDD VSS sg13g2_decap_8
XFILLER_33_431 VDD VSS sg13g2_decap_4
X_08220_ _08220_/X _08219_/A _13545_/A _08432_/A2 VDD VSS sg13g2_a21o_1
XFILLER_178_458 VDD VSS sg13g2_decap_8
XFILLER_159_650 VDD VSS sg13g2_decap_8
XFILLER_105_1210 VDD VSS sg13g2_decap_8
XFILLER_21_659 VDD VSS sg13g2_decap_4
XFILLER_18_1273 VDD VSS sg13g2_decap_8
XFILLER_53_1153 VDD VSS sg13g2_decap_8
XFILLER_140_1112 VDD VSS sg13g2_decap_4
XFILLER_20_147 VDD VSS sg13g2_fill_2
XFILLER_119_514 VDD VSS sg13g2_decap_4
XFILLER_159_683 VDD VSS sg13g2_fill_1
X_08151_ _08151_/X _08215_/A3 _07630_/A _08142_/C _08023_/B _07884_/A _08151_/S1 VDD
+ VSS sg13g2_mux4_1
XFILLER_105_1243 VDD VSS sg13g2_decap_8
XFILLER_146_322 VDD VSS sg13g2_decap_8
XFILLER_101_1107 VDD VSS sg13g2_decap_8
XFILLER_147_856 VDD VSS sg13g2_fill_2
XFILLER_174_642 VDD VSS sg13g2_fill_1
XFILLER_31_1440 VDD VSS sg13g2_decap_8
XFILLER_179_1344 VDD VSS sg13g2_decap_8
X_08082_ _08082_/X _08081_/X _08079_/X _08599_/B VDD VSS sg13g2_mux2_1
XFILLER_161_336 VDD VSS sg13g2_decap_4
XFILLER_103_904 VDD VSS sg13g2_decap_8
XFILLER_102_414 VDD VSS sg13g2_fill_2
XFILLER_87_103 VDD VSS sg13g2_fill_1
XFILLER_130_734 VDD VSS sg13g2_fill_1
X_14519__1683 _14519_/RESET_B VDD VSS sg13g2_tiehi
X_08984_ _13758_/D _13758_/Q _10141_/A1 _09127_/S VDD VSS sg13g2_mux2_1
XFILLER_9_1430 VDD VSS sg13g2_decap_8
XFILLER_64_1260 VDD VSS sg13g2_decap_8
XFILLER_57_18 VDD VSS sg13g2_decap_8
XFILLER_29_1380 VDD VSS sg13g2_decap_8
XFILLER_87_147 VDD VSS sg13g2_decap_8
XFILLER_25_1222 VDD VSS sg13g2_decap_8
XFILLER_130_778 VDD VSS sg13g2_decap_8
X_07935_ _07935_/Y _08414_/D _07934_/Y _07933_/Y VDD VSS sg13g2_a21oi_1
XFILLER_69_884 VDD VSS sg13g2_decap_8
XFILLER_5_1316 VDD VSS sg13g2_decap_8
XFILLER_29_726 VDD VSS sg13g2_decap_4
XFILLER_96_681 VDD VSS sg13g2_decap_8
XFILLER_28_203 VDD VSS sg13g2_fill_2
X_07866_ _07866_/Y _07969_/A _08678_/A _08650_/A _07867_/D VDD VSS sg13g2_nor4_1
XFILLER_60_1168 VDD VSS sg13g2_decap_8
XFILLER_83_320 VDD VSS sg13g2_fill_1
XFILLER_25_1299 VDD VSS sg13g2_decap_8
XFILLER_95_191 VDD VSS sg13g2_decap_8
XFILLER_186_1315 VDD VSS sg13g2_decap_8
X_14698__1504 _14698_/RESET_B VDD VSS sg13g2_tiehi
X_09605_ _14202_/D _14202_/Q _09638_/A0 _09605_/S VDD VSS sg13g2_mux2_1
XFILLER_99_1378 VDD VSS sg13g2_fill_2
XFILLER_56_567 VDD VSS sg13g2_decap_8
XFILLER_3_1040 VDD VSS sg13g2_decap_8
XFILLER_83_364 VDD VSS sg13g2_fill_2
X_07797_ _07797_/X _07797_/A _07797_/B _07797_/C _07797_/D VDD VSS sg13g2_or4_1
XFILLER_43_206 VDD VSS sg13g2_decap_8
XFILLER_25_921 VDD VSS sg13g2_fill_1
X_09536_ _14135_/D _10066_/A0 _14135_/Q _09538_/S VDD VSS sg13g2_mux2_1
XFILLER_58_1020 VDD VSS sg13g2_decap_8
XFILLER_24_420 VDD VSS sg13g2_fill_1
XFILLER_145_1001 VDD VSS sg13g2_decap_8
XFILLER_149_1170 VDD VSS sg13g2_decap_8
XFILLER_24_453 VDD VSS sg13g2_decap_8
XFILLER_184_1072 VDD VSS sg13g2_decap_8
X_09467_ _14068_/D _10130_/A0 _14068_/Q _09467_/S VDD VSS sg13g2_mux2_1
XFILLER_169_436 VDD VSS sg13g2_decap_8
XFILLER_12_626 VDD VSS sg13g2_decap_8
X_08418_ _08419_/A _08418_/A _08418_/B VDD VSS sg13g2_and2_1
XFILLER_40_957 VDD VSS sg13g2_decap_8
X_09398_ _14001_/D _09961_/A1 _14001_/Q _09405_/S VDD VSS sg13g2_mux2_1
XFILLER_36_1362 VDD VSS sg13g2_decap_8
XFILLER_123_1321 VDD VSS sg13g2_decap_8
XFILLER_178_981 VDD VSS sg13g2_decap_8
XFILLER_32_1204 VDD VSS sg13g2_decap_8
XFILLER_11_158 VDD VSS sg13g2_decap_8
XFILLER_162_1381 VDD VSS sg13g2_decap_8
XFILLER_71_1264 VDD VSS sg13g2_decap_8
XFILLER_22_21 VDD VSS sg13g2_decap_8
X_08349_ _08353_/A _08414_/A _08366_/D _08348_/Y VDD VSS sg13g2_o21ai_1
XFILLER_165_631 VDD VSS sg13g2_decap_8
X_14875__2817 _14875_/RESET_B VDD VSS sg13g2_tiehi
XFILLER_137_344 VDD VSS sg13g2_decap_8
X_11360_ _11360_/Y _11357_/Y _11359_/Y _11834_/A2 VDD VSS sg13g2_a21oi_1
XFILLER_180_601 VDD VSS sg13g2_decap_8
XFILLER_125_517 VDD VSS sg13g2_fill_2
XFILLER_153_826 VDD VSS sg13g2_decap_4
XFILLER_158_1417 VDD VSS sg13g2_decap_8
X_10311_ _10342_/C _10311_/A _10311_/B _10311_/C _10327_/C VDD VSS sg13g2_and4_1
XFILLER_138_87 VDD VSS sg13g2_decap_4
X_11291_ _11292_/B _12911_/B _12836_/B VDD VSS sg13g2_xnor2_1
XFILLER_4_847 VDD VSS sg13g2_decap_8
X_13030_ _13030_/Y _14781_/Q _13030_/A2 _13030_/B1 VDD VSS sg13g2_o21ai_1
XFILLER_69_1171 VDD VSS sg13g2_decap_8
X_10242_ _14775_/D _14775_/Q _10247_/D _10241_/Y VDD VSS sg13g2_a21oi_1
XFILLER_106_775 VDD VSS sg13g2_decap_4
XFILLER_161_870 VDD VSS sg13g2_decap_8
XFILLER_3_368 VDD VSS sg13g2_decap_8
XFILLER_152_1005 VDD VSS sg13g2_fill_1
XFILLER_154_42 VDD VSS sg13g2_decap_8
XFILLER_105_285 VDD VSS sg13g2_decap_8
XFILLER_121_734 VDD VSS sg13g2_decap_8
XFILLER_160_380 VDD VSS sg13g2_decap_8
Xfanout1103 fanout1103/X _14989_/Q VDD VSS sg13g2_buf_1
X_10173_ _10173_/Y _10185_/B _10173_/B _10178_/A VDD VSS sg13g2_nand3_1
Xfanout1114 _08012_/B _14984_/Q VDD VSS sg13g2_buf_1
XFILLER_78_136 VDD VSS sg13g2_decap_4
Xfanout1125 _08591_/A2 _08925_/A1 VDD VSS sg13g2_buf_1
Xfanout1136 _08471_/B _08470_/B VDD VSS sg13g2_buf_1
XFILLER_43_1322 VDD VSS sg13g2_decap_8
XFILLER_154_97 VDD VSS sg13g2_decap_8
Xfanout1147 _08465_/A3 _11770_/A VDD VSS sg13g2_buf_1
X_14981_ _14981_/Q clkload38/A _14981_/D _14981_/RESET_B VDD VSS sg13g2_dfrbpq_1
Xfanout160 _10099_/A0 _09635_/A0 VDD VSS sg13g2_buf_1
Xfanout1158 _11635_/A _14969_/Q VDD VSS sg13g2_buf_1
XFILLER_82_1393 VDD VSS sg13g2_decap_8
Xfanout171 _10064_/A0 _09131_/X VDD VSS sg13g2_buf_1
Xfanout1169 _07929_/B _11502_/A VDD VSS sg13g2_buf_1
XFILLER_93_117 VDD VSS sg13g2_decap_8
Xfanout182 _09630_/A0 _09929_/A1 VDD VSS sg13g2_buf_1
XFILLER_59_383 VDD VSS sg13g2_decap_8
XFILLER_47_40 VDD VSS sg13g2_decap_8
X_13932_ _13932_/Q _14508_/CLK _13932_/D _13932_/RESET_B VDD VSS sg13g2_dfrbpq_1
Xfanout193 _10125_/A0 _09594_/A1 VDD VSS sg13g2_buf_1
XFILLER_130_1336 VDD VSS sg13g2_fill_2
XFILLER_43_1399 VDD VSS sg13g2_decap_8
XFILLER_75_876 VDD VSS sg13g2_decap_4
XFILLER_47_84 VDD VSS sg13g2_fill_2
X_13863_ _13863_/Q clkload5/A _13863_/D _13863_/RESET_B VDD VSS sg13g2_dfrbpq_1
XFILLER_78_1429 VDD VSS sg13g2_decap_8
XFILLER_170_74 VDD VSS sg13g2_decap_8
XFILLER_90_824 VDD VSS sg13g2_decap_8
XFILLER_62_526 VDD VSS sg13g2_decap_8
X_12814_ _12814_/Y _12900_/B input12/X _12866_/B VDD VSS sg13g2_nand3_1
XFILLER_34_228 VDD VSS sg13g2_decap_8
X_13794_ _13794_/Q _14722_/CLK _13794_/D _13794_/RESET_B VDD VSS sg13g2_dfrbpq_1
XFILLER_90_868 VDD VSS sg13g2_fill_2
XFILLER_76_1142 VDD VSS sg13g2_decap_8
XFILLER_37_1104 VDD VSS sg13g2_fill_1
X_13792__2410 _13792_/RESET_B VDD VSS sg13g2_tiehi
XFILLER_16_987 VDD VSS sg13g2_decap_8
X_12745_ _12745_/X _14263_/Q _14295_/Q _14327_/Q _14359_/Q _12756_/S0 _12756_/S1 VDD
+ VSS sg13g2_mux4_1
XFILLER_128_1243 VDD VSS sg13g2_decap_8
XFILLER_37_1126 VDD VSS sg13g2_decap_8
X_15226__3017 _15226_/RESET_B VDD VSS sg13g2_tiehi
XFILLER_30_401 VDD VSS sg13g2_decap_8
XFILLER_30_412 VDD VSS sg13g2_decap_8
XFILLER_31_946 VDD VSS sg13g2_decap_8
XFILLER_148_609 VDD VSS sg13g2_decap_8
XFILLER_15_497 VDD VSS sg13g2_decap_4
X_12676_ _12676_/X _12673_/X _12672_/X _12671_/X _12670_/X _12747_/S1 _12748_/S VDD
+ VSS sg13g2_mux4_1
XFILLER_128_1298 VDD VSS sg13g2_decap_8
XFILLER_54_1451 VDD VSS sg13g2_decap_8
XFILLER_175_428 VDD VSS sg13g2_fill_1
X_14415_ _14415_/Q clkload38/A _14415_/D _14415_/RESET_B VDD VSS sg13g2_dfrbpq_1
X_11627_ _11627_/Y _11622_/X _11830_/B1 _11625_/C VDD VSS sg13g2_a21oi_1
XFILLER_15_1446 VDD VSS sg13g2_decap_8
XFILLER_8_67 VDD VSS sg13g2_decap_8
XFILLER_50_1337 VDD VSS sg13g2_decap_8
X_14172__2030 _14172_/RESET_B VDD VSS sg13g2_tiehi
XFILLER_7_630 VDD VSS sg13g2_decap_8
X_14346_ _14346_/Q clkload20/A _14346_/D _14346_/RESET_B VDD VSS sg13g2_dfrbpq_1
XFILLER_102_1438 VDD VSS sg13g2_decap_8
X_11558_ _11559_/B _11547_/Y _11549_/X _11901_/B1 VDD VSS sg13g2_o21ai_1
XFILLER_129_889 VDD VSS sg13g2_decap_8
XFILLER_155_152 VDD VSS sg13g2_decap_8
XFILLER_6_151 VDD VSS sg13g2_decap_8
X_10509_ _10521_/D _10512_/A _10509_/B _10509_/C _10509_/D VDD VSS sg13g2_nor4_1
XFILLER_183_494 VDD VSS sg13g2_decap_8
X_14277_ _14277_/Q clkload16/A _14277_/D _14277_/RESET_B VDD VSS sg13g2_dfrbpq_1
XFILLER_144_859 VDD VSS sg13g2_decap_8
X_11489_ _11489_/X _14370_/Q _14402_/Q _14466_/Q _14498_/Q _11649_/S0 _11649_/S1 VDD
+ VSS sg13g2_mux4_1
XFILLER_171_667 VDD VSS sg13g2_decap_8
X_13228_ _13228_/Y _13228_/A _13228_/B _13228_/C VDD VSS sg13g2_nand3_1
XFILLER_98_902 VDD VSS sg13g2_decap_8
XFILLER_83_1113 VDD VSS sg13g2_decap_8
XFILLER_112_701 VDD VSS sg13g2_decap_4
XFILLER_48_1244 VDD VSS sg13g2_decap_8
XFILLER_40_4 VDD VSS sg13g2_decap_8
XFILLER_135_1203 VDD VSS sg13g2_fill_1
XFILLER_174_1252 VDD VSS sg13g2_decap_8
XFILLER_152_892 VDD VSS sg13g2_fill_2
XFILLER_97_423 VDD VSS sg13g2_decap_8
XFILLER_139_1394 VDD VSS sg13g2_decap_8
XFILLER_170_199 VDD VSS sg13g2_decap_8
X_13159_ _13159_/Y _13174_/A _13158_/B _13170_/D VDD VSS sg13g2_a21oi_1
XFILLER_88_80 VDD VSS sg13g2_decap_8
XFILLER_61_1400 VDD VSS sg13g2_decap_8
XFILLER_135_1258 VDD VSS sg13g2_fill_1
X_07720_ _15217_/D _13343_/B _07720_/B _07720_/C VDD VSS sg13g2_or3_1
XFILLER_38_523 VDD VSS sg13g2_decap_8
XFILLER_66_843 VDD VSS sg13g2_decap_8
XFILLER_61_1477 VDD VSS sg13g2_fill_2
XFILLER_65_331 VDD VSS sg13g2_fill_1
XFILLER_66_865 VDD VSS sg13g2_fill_1
XFILLER_26_707 VDD VSS sg13g2_decap_8
X_07651_ _11023_/A _15118_/Q VDD VSS sg13g2_inv_1
XFILLER_65_353 VDD VSS sg13g2_decap_8
XFILLER_20_1130 VDD VSS sg13g2_decap_8
XFILLER_93_684 VDD VSS sg13g2_decap_8
XFILLER_168_1056 VDD VSS sg13g2_decap_8
XFILLER_19_781 VDD VSS sg13g2_decap_8
XFILLER_92_172 VDD VSS sg13g2_decap_8
XFILLER_4_1393 VDD VSS sg13g2_decap_8
XFILLER_25_228 VDD VSS sg13g2_decap_8
XFILLER_94_1220 VDD VSS sg13g2_fill_2
XFILLER_65_397 VDD VSS sg13g2_decap_8
XFILLER_80_345 VDD VSS sg13g2_decap_4
XFILLER_0_1268 VDD VSS sg13g2_decap_8
X_09321_ _13928_/D _10151_/A1 _13928_/Q _09325_/S VDD VSS sg13g2_mux2_1
XFILLER_59_1373 VDD VSS sg13g2_decap_8
X_14382__1820 _14382_/RESET_B VDD VSS sg13g2_tiehi
XFILLER_94_1275 VDD VSS sg13g2_fill_2
XFILLER_94_1286 VDD VSS sg13g2_decap_4
XFILLER_55_1237 VDD VSS sg13g2_decap_8
XFILLER_94_1297 VDD VSS sg13g2_decap_8
X_09252_ _13861_/D _13861_/Q _10148_/A1 _09263_/S VDD VSS sg13g2_mux2_1
XFILLER_181_1267 VDD VSS sg13g2_decap_8
XFILLER_21_434 VDD VSS sg13g2_decap_8
X_08203_ _08247_/A _08203_/A _08203_/B VDD VSS sg13g2_nor2_1
XFILLER_138_119 VDD VSS sg13g2_decap_8
X_09183_ _13799_/D _13799_/Q _09720_/A0 _09189_/S VDD VSS sg13g2_mux2_1
XFILLER_159_491 VDD VSS sg13g2_fill_2
X_08134_ _08134_/Y _08030_/Y _08132_/X _08397_/A VDD VSS sg13g2_o21ai_1
XFILLER_88_1002 VDD VSS sg13g2_decap_8
XFILLER_119_355 VDD VSS sg13g2_fill_1
X_14002__2200 _14002_/RESET_B VDD VSS sg13g2_tiehi
XFILLER_147_675 VDD VSS sg13g2_decap_8
XFILLER_179_1141 VDD VSS sg13g2_decap_8
XFILLER_88_1035 VDD VSS sg13g2_decap_8
XFILLER_119_388 VDD VSS sg13g2_decap_8
XFILLER_134_314 VDD VSS sg13g2_decap_8
X_08065_ _08066_/A _07888_/B _07929_/B _07910_/B _08219_/A _08137_/S1 _08063_/A VDD
+ VSS sg13g2_mux4_1
XFILLER_108_35 VDD VSS sg13g2_fill_1
XFILLER_161_133 VDD VSS sg13g2_decap_4
XFILLER_122_509 VDD VSS sg13g2_decap_8
XFILLER_115_550 VDD VSS sg13g2_decap_8
XFILLER_66_1333 VDD VSS sg13g2_decap_8
XFILLER_27_1306 VDD VSS sg13g2_decap_8
XFILLER_103_723 VDD VSS sg13g2_decap_8
XFILLER_115_594 VDD VSS sg13g2_decap_4
XFILLER_88_434 VDD VSS sg13g2_decap_4
XFILLER_62_1208 VDD VSS sg13g2_decap_8
XFILLER_142_391 VDD VSS sg13g2_decap_8
X_14035__2167 _14035_/RESET_B VDD VSS sg13g2_tiehi
XFILLER_153_1358 VDD VSS sg13g2_decap_8
X_13870__2332 _13870_/RESET_B VDD VSS sg13g2_tiehi
X_08967_ _08967_/Y _09141_/A _08977_/C VDD VSS sg13g2_nand2_1
XFILLER_88_478 VDD VSS sg13g2_fill_1
XFILLER_124_34 VDD VSS sg13g2_decap_8
XFILLER_130_575 VDD VSS sg13g2_decap_8
XFILLER_76_629 VDD VSS sg13g2_fill_1
XFILLER_75_117 VDD VSS sg13g2_fill_1
XFILLER_5_1113 VDD VSS sg13g2_decap_8
Xpicorv32_macro mem_axi_araddr[0] VDD VSS sg13g2_tielo
XFILLER_29_512 VDD VSS sg13g2_fill_1
XFILLER_116_1180 VDD VSS sg13g2_fill_1
X_07918_ _07918_/Y _07893_/Y _07916_/Y _07917_/B VDD VSS sg13g2_a21oi_1
XFILLER_29_523 VDD VSS sg13g2_decap_4
XFILLER_84_16 VDD VSS sg13g2_fill_2
XFILLER_57_843 VDD VSS sg13g2_fill_1
X_08898_ _08898_/Y _10735_/A _14942_/Q VDD VSS sg13g2_nand2_1
XFILLER_112_1055 VDD VSS sg13g2_decap_8
XFILLER_17_21 VDD VSS sg13g2_decap_8
X_07849_ _07849_/X _15016_/Q _07850_/B VDD VSS sg13g2_and2_1
XFILLER_44_504 VDD VSS sg13g2_decap_4
Xclkbuf_leaf_3_clk_i _14704_/CLK clkbuf_leaf_4_clk_i/A VDD VSS sg13g2_buf_8
XFILLER_112_1088 VDD VSS sg13g2_decap_8
XFILLER_83_172 VDD VSS sg13g2_decap_8
XFILLER_147_1118 VDD VSS sg13g2_decap_8
X_10860_ _10860_/Y _10797_/C _10870_/A _10912_/B1 VDD VSS sg13g2_o21ai_1
XFILLER_71_345 VDD VSS sg13g2_decap_8
XFILLER_25_740 VDD VSS sg13g2_decap_8
XFILLER_186_1189 VDD VSS sg13g2_decap_8
XFILLER_17_98 VDD VSS sg13g2_decap_8
X_09519_ _14118_/D _09686_/A0 _14118_/Q _09523_/S VDD VSS sg13g2_mux2_1
XFILLER_73_1304 VDD VSS sg13g2_decap_8
X_10791_ _14924_/D _11207_/B1 _11199_/B _10790_/Y VDD VSS sg13g2_o21ai_1
XFILLER_13_935 VDD VSS sg13g2_decap_8
XFILLER_125_1416 VDD VSS sg13g2_decap_4
X_12530_ _12530_/X _13960_/Q _13992_/Q _14024_/Q _14056_/Q _12536_/S0 _12536_/S1 VDD
+ VSS sg13g2_mux4_1
XFILLER_38_1468 VDD VSS sg13g2_decap_8
XFILLER_12_434 VDD VSS sg13g2_decap_8
XFILLER_160_1318 VDD VSS sg13g2_decap_8
XFILLER_9_917 VDD VSS sg13g2_decap_8
XFILLER_33_53 VDD VSS sg13g2_decap_8
XFILLER_71_1050 VDD VSS sg13g2_decap_8
X_12461_ _12461_/X _14371_/Q _14403_/Q _14467_/Q _14499_/Q _12466_/S0 _12466_/S1 VDD
+ VSS sg13g2_mux4_1
XFILLER_149_53 VDD VSS sg13g2_fill_1
XFILLER_185_759 VDD VSS sg13g2_decap_8
XFILLER_8_438 VDD VSS sg13g2_decap_8
XFILLER_184_247 VDD VSS sg13g2_decap_8
X_14200_ _14200_/Q clkload47/A _14200_/D _14200_/RESET_B VDD VSS sg13g2_dfrbpq_1
X_11412_ _11413_/A _14239_/Q _14271_/Q _14303_/Q _14335_/Q _11418_/A _11419_/C VDD
+ VSS sg13g2_mux4_1
X_15180_ _15180_/Q clkload87/A _15180_/D _15180_/RESET_B VDD VSS sg13g2_dfrbpq_1
XFILLER_123_1173 VDD VSS sg13g2_decap_8
XFILLER_138_664 VDD VSS sg13g2_decap_8
XFILLER_166_973 VDD VSS sg13g2_decap_8
X_12392_ _12392_/X _13726_/Q _14078_/Q _14430_/Q _14526_/Q _12614_/S0 _12614_/S1 VDD
+ VSS sg13g2_mux4_1
XFILLER_123_1184 VDD VSS sg13g2_decap_8
XFILLER_165_461 VDD VSS sg13g2_fill_2
XFILLER_32_1078 VDD VSS sg13g2_decap_8
XFILLER_181_932 VDD VSS sg13g2_fill_1
X_14131_ _14131_/Q clkload37/A _14131_/D _14131_/RESET_B VDD VSS sg13g2_dfrbpq_1
X_14245__1957 _14245_/RESET_B VDD VSS sg13g2_tiehi
XFILLER_158_1214 VDD VSS sg13g2_decap_8
X_11343_ _11343_/Y _11368_/S0 _13854_/Q _11366_/C VDD VSS sg13g2_a21oi_1
XFILLER_126_859 VDD VSS sg13g2_decap_4
XFILLER_153_645 VDD VSS sg13g2_decap_8
XFILLER_180_431 VDD VSS sg13g2_fill_2
XFILLER_101_1460 VDD VSS sg13g2_decap_8
XFILLER_84_1400 VDD VSS sg13g2_decap_8
XFILLER_4_644 VDD VSS sg13g2_decap_8
XFILLER_10_1365 VDD VSS sg13g2_decap_8
X_14062_ _14062_/Q clkload58/A _14062_/D _14062_/RESET_B VDD VSS sg13g2_dfrbpq_1
X_11274_ _11274_/Y _11270_/Y _11271_/Y _11273_/Y _11272_/Y _11283_/B VDD VSS sg13g2_a221oi_1
XFILLER_165_74 VDD VSS sg13g2_decap_8
X_14839__2889 _14839_/RESET_B VDD VSS sg13g2_tiehi
X_13013_ _13013_/Y _14876_/Q _13028_/B VDD VSS sg13g2_nand2_1
XFILLER_3_165 VDD VSS sg13g2_decap_8
XFILLER_106_583 VDD VSS sg13g2_decap_8
X_10225_ _10234_/D _14767_/Q _14768_/Q _14769_/Q _14770_/Q VDD VSS sg13g2_and4_1
XFILLER_45_1417 VDD VSS sg13g2_decap_8
XFILLER_121_553 VDD VSS sg13g2_decap_8
X_13700__2502 _13700_/RESET_B VDD VSS sg13g2_tiehi
XFILLER_171_1469 VDD VSS sg13g2_decap_4
X_14460__1742 _14460_/RESET_B VDD VSS sg13g2_tiehi
X_10156_ _14733_/D _14733_/Q _10156_/A1 _10156_/S VDD VSS sg13g2_mux2_1
XFILLER_79_489 VDD VSS sg13g2_decap_8
XFILLER_48_810 VDD VSS sg13g2_fill_1
XFILLER_0_883 VDD VSS sg13g2_decap_8
XFILLER_94_437 VDD VSS sg13g2_decap_8
XFILLER_130_1122 VDD VSS sg13g2_fill_1
X_14964_ _14964_/Q clkload55/A _14964_/D _14964_/RESET_B VDD VSS sg13g2_dfrbpq_1
X_10087_ _14667_/D _10087_/A0 _14667_/Q _10096_/S VDD VSS sg13g2_mux2_1
XFILLER_181_84 VDD VSS sg13g2_decap_8
XFILLER_43_1196 VDD VSS sg13g2_decap_8
X_13915_ _13915_/Q _14491_/CLK _13915_/D _13915_/RESET_B VDD VSS sg13g2_dfrbpq_1
XFILLER_78_1226 VDD VSS sg13g2_decap_8
XFILLER_169_1343 VDD VSS sg13g2_decap_8
X_14895_ _14895_/Q _14930_/CLK _14895_/D _14895_/RESET_B VDD VSS sg13g2_dfrbpq_1
XFILLER_63_824 VDD VSS sg13g2_fill_1
XFILLER_47_375 VDD VSS sg13g2_fill_1
XFILLER_47_386 VDD VSS sg13g2_decap_8
XFILLER_90_632 VDD VSS sg13g2_fill_1
X_13846_ _13846_/Q clkload68/A _13846_/D _13846_/RESET_B VDD VSS sg13g2_dfrbpq_1
X_13733__2469 _13733_/RESET_B VDD VSS sg13g2_tiehi
X_13777_ _13777_/Q _15139_/CLK _13777_/D _13777_/RESET_B VDD VSS sg13g2_dfrbpq_1
X_10989_ _10989_/Y _10995_/B _15116_/Q VDD VSS sg13g2_nand2b_1
XFILLER_50_529 VDD VSS sg13g2_decap_8
XFILLER_91_1437 VDD VSS sg13g2_fill_2
XFILLER_43_581 VDD VSS sg13g2_decap_4
XFILLER_128_1073 VDD VSS sg13g2_decap_4
XFILLER_15_294 VDD VSS sg13g2_decap_8
X_12728_ _12728_/X _14582_/Q _14614_/Q _14646_/Q _14678_/Q _12731_/S0 _12731_/S1 VDD
+ VSS sg13g2_mux4_1
XFILLER_148_428 VDD VSS sg13g2_decap_8
X_12659_ _12659_/X _14705_/Q _14737_/Q _13777_/Q _13809_/Q _12661_/S0 _12661_/S1 VDD
+ VSS sg13g2_mux4_1
XFILLER_30_275 VDD VSS sg13g2_decap_8
XFILLER_141_1240 VDD VSS sg13g2_decap_8
XFILLER_157_951 VDD VSS sg13g2_decap_8
XFILLER_15_1243 VDD VSS sg13g2_decap_8
XFILLER_175_247 VDD VSS sg13g2_decap_8
X_14113__2089 _14113_/RESET_B VDD VSS sg13g2_tiehi
XFILLER_141_1251 VDD VSS sg13g2_fill_2
XFILLER_30_297 VDD VSS sg13g2_fill_2
XFILLER_11_1107 VDD VSS sg13g2_decap_8
XFILLER_129_664 VDD VSS sg13g2_decap_8
XFILLER_141_1273 VDD VSS sg13g2_decap_4
XFILLER_184_770 VDD VSS sg13g2_decap_8
XFILLER_141_1284 VDD VSS sg13g2_decap_8
XFILLER_141_1295 VDD VSS sg13g2_fill_2
XFILLER_176_1303 VDD VSS sg13g2_decap_8
XFILLER_89_1355 VDD VSS sg13g2_decap_8
XFILLER_144_623 VDD VSS sg13g2_decap_8
XFILLER_102_1268 VDD VSS sg13g2_decap_8
X_14329_ _14329_/Q _14745_/CLK _14329_/D _14329_/RESET_B VDD VSS sg13g2_dfrbpq_1
XFILLER_116_336 VDD VSS sg13g2_decap_8
XFILLER_144_645 VDD VSS sg13g2_decap_8
XFILLER_171_431 VDD VSS sg13g2_decap_8
XFILLER_183_291 VDD VSS sg13g2_decap_8
X_14997__2613 _14997_/RESET_B VDD VSS sg13g2_tiehi
XFILLER_143_155 VDD VSS sg13g2_decap_4
XFILLER_172_987 VDD VSS sg13g2_decap_8
XFILLER_98_721 VDD VSS sg13g2_decap_4
Xfanout907 _12768_/S0 _12717_/S0 VDD VSS sg13g2_buf_1
X_09870_ _14457_/D _14457_/Q _10101_/A0 _09870_/S VDD VSS sg13g2_mux2_1
Xfanout918 _13020_/A1 _15209_/Q VDD VSS sg13g2_buf_1
XFILLER_139_1191 VDD VSS sg13g2_decap_8
XFILLER_31_0 VDD VSS sg13g2_decap_8
Xclkbuf_5_7__f_clk_i clkbuf_5_7__f_clk_i/X clkbuf_4_3_0_clk_i/X VDD VSS sg13g2_buf_16
Xfanout929 _13308_/A _13160_/B VDD VSS sg13g2_buf_1
X_08821_ _08821_/Y _07720_/C _15121_/Q _08727_/D _15178_/Q _13390_/A2 VDD VSS sg13g2_a221oi_1
XFILLER_98_787 VDD VSS sg13g2_fill_2
XFILLER_98_798 VDD VSS sg13g2_decap_8
XFILLER_6_1411 VDD VSS sg13g2_decap_8
XFILLER_39_821 VDD VSS sg13g2_decap_8
XFILLER_100_737 VDD VSS sg13g2_decap_4
XFILLER_85_437 VDD VSS sg13g2_decap_4
XFILLER_26_1361 VDD VSS sg13g2_decap_8
XFILLER_100_748 VDD VSS sg13g2_fill_1
X_08752_ _08752_/Y _13189_/B _08752_/B VDD VSS sg13g2_nor2_1
XFILLER_100_759 VDD VSS sg13g2_fill_1
XFILLER_113_1342 VDD VSS sg13g2_decap_8
XFILLER_61_1274 VDD VSS sg13g2_decap_8
XFILLER_38_331 VDD VSS sg13g2_decap_8
X_07703_ _07703_/Y _13300_/B _13356_/B VDD VSS sg13g2_nand2_1
XFILLER_22_1258 VDD VSS sg13g2_decap_8
X_08683_ _08684_/B _08649_/S _08697_/A _08682_/Y VDD VSS sg13g2_o21ai_1
XFILLER_93_470 VDD VSS sg13g2_fill_1
X_07634_ _07909_/B _11454_/A VDD VSS sg13g2_inv_1
XFILLER_4_1190 VDD VSS sg13g2_decap_8
X_14323__1879 _14323_/RESET_B VDD VSS sg13g2_tiehi
X_13709__2493 _13709_/RESET_B VDD VSS sg13g2_tiehi
XFILLER_0_1065 VDD VSS sg13g2_decap_8
XFILLER_59_1170 VDD VSS sg13g2_decap_8
XFILLER_41_529 VDD VSS sg13g2_decap_8
XFILLER_110_36 VDD VSS sg13g2_decap_8
X_14943__2681 _14943_/RESET_B VDD VSS sg13g2_tiehi
X_09304_ _13912_/D _13912_/Q _10167_/A1 _09304_/S VDD VSS sg13g2_mux2_1
XFILLER_94_1083 VDD VSS sg13g2_fill_1
XFILLER_167_704 VDD VSS sg13g2_decap_8
XFILLER_107_1124 VDD VSS sg13g2_decap_8
XFILLER_70_18 VDD VSS sg13g2_decap_8
XFILLER_146_1195 VDD VSS sg13g2_fill_1
XFILLER_16_1029 VDD VSS sg13g2_decap_8
X_09235_ _13846_/D _09933_/A1 _13846_/Q _09239_/S VDD VSS sg13g2_mux2_1
XFILLER_33_1310 VDD VSS sg13g2_decap_8
XFILLER_72_1370 VDD VSS sg13g2_decap_8
XFILLER_10_938 VDD VSS sg13g2_decap_8
XFILLER_167_759 VDD VSS sg13g2_decap_8
X_13888__2314 _13888_/RESET_B VDD VSS sg13g2_tiehi
X_09166_ _09166_/Y _09162_/A _09165_/Y _09162_/Y VDD VSS sg13g2_a21oi_1
XFILLER_148_984 VDD VSS sg13g2_decap_8
XFILLER_182_729 VDD VSS sg13g2_decap_8
XFILLER_107_303 VDD VSS sg13g2_decap_8
XFILLER_181_217 VDD VSS sg13g2_decap_8
XFILLER_33_1387 VDD VSS sg13g2_decap_8
XFILLER_175_792 VDD VSS sg13g2_fill_1
X_08117_ _08117_/Y _07904_/B _08116_/Y _08395_/A VDD VSS sg13g2_a21oi_1
XFILLER_119_185 VDD VSS sg13g2_fill_1
XFILLER_119_67 VDD VSS sg13g2_fill_1
XFILLER_134_111 VDD VSS sg13g2_decap_8
X_09097_ _09097_/X _09137_/A _09097_/B _09136_/B VDD VSS sg13g2_or3_1
XFILLER_119_196 VDD VSS sg13g2_decap_8
X_14792__2944 _14792_/RESET_B VDD VSS sg13g2_tiehi
XFILLER_135_678 VDD VSS sg13g2_fill_2
X_08048_ _08048_/Y _08048_/A _08048_/B VDD VSS sg13g2_nand2_1
XFILLER_122_306 VDD VSS sg13g2_decap_8
XFILLER_134_188 VDD VSS sg13g2_fill_1
X_15121__2740 _15121_/RESET_B VDD VSS sg13g2_tiehi
XFILLER_89_732 VDD VSS sg13g2_fill_2
XFILLER_157_1280 VDD VSS sg13g2_decap_8
XFILLER_153_1122 VDD VSS sg13g2_decap_4
XFILLER_103_542 VDD VSS sg13g2_fill_2
XFILLER_1_658 VDD VSS sg13g2_decap_8
X_15225__3016 _15225_/RESET_B VDD VSS sg13g2_tiehi
Xhold3041 _10210_/C input1/X VDD VSS sg13g2_dlygate4sd3_1
X_10010_ _14592_/D _10010_/A0 _14592_/Q _10023_/S VDD VSS sg13g2_mux2_1
XFILLER_118_1264 VDD VSS sg13g2_decap_8
Xhold3052 hold3052/X input15/X VDD VSS sg13g2_dlygate4sd3_1
XFILLER_89_776 VDD VSS sg13g2_decap_8
Xhold3063 hold3063/X input30/X VDD VSS sg13g2_dlygate4sd3_1
XFILLER_76_404 VDD VSS sg13g2_decap_4
XFILLER_0_168 VDD VSS sg13g2_decap_8
XFILLER_103_575 VDD VSS sg13g2_decap_8
XFILLER_131_884 VDD VSS sg13g2_decap_8
Xhold3074 input11/A hold3103/X VDD VSS sg13g2_dlygate4sd3_1
X_09999_ _14582_/D _10098_/A0 _14582_/Q _10003_/S VDD VSS sg13g2_mux2_1
XFILLER_48_106 VDD VSS sg13g2_decap_4
XFILLER_130_372 VDD VSS sg13g2_decap_4
Xhold3085 hold3085/X input8/X VDD VSS sg13g2_dlygate4sd3_1
Xhold3096 input36/A mem_axi_rvalid VDD VSS sg13g2_dlygate4sd3_1
XFILLER_88_297 VDD VSS sg13g2_decap_8
XFILLER_130_394 VDD VSS sg13g2_fill_1
XFILLER_92_919 VDD VSS sg13g2_fill_2
XFILLER_131_1453 VDD VSS sg13g2_decap_8
XFILLER_85_960 VDD VSS sg13g2_decap_4
XFILLER_91_407 VDD VSS sg13g2_decap_8
XFILLER_40_1347 VDD VSS sg13g2_decap_8
X_11961_ _11961_/Y _11756_/S _14512_/Q _11967_/B VDD VSS sg13g2_a21oi_1
XFILLER_17_515 VDD VSS sg13g2_decap_8
XFILLER_17_526 VDD VSS sg13g2_fill_2
XFILLER_28_97 VDD VSS sg13g2_fill_1
X_13700_ _16862_/A clkload58/A _13700_/D _13700_/RESET_B VDD VSS sg13g2_dfrbpq_1
X_10912_ _10912_/Y _07751_/B _10936_/D _10912_/B1 VDD VSS sg13g2_o21ai_1
XFILLER_45_846 VDD VSS sg13g2_decap_8
XFILLER_151_87 VDD VSS sg13g2_decap_8
X_14680_ _14680_/Q _14742_/CLK _14680_/D _14680_/RESET_B VDD VSS sg13g2_dfrbpq_1
XFILLER_72_643 VDD VSS sg13g2_fill_1
XFILLER_151_98 VDD VSS sg13g2_fill_1
X_11892_ _11892_/Y _11889_/Y _11891_/X _11901_/B1 VDD VSS sg13g2_o21ai_1
XFILLER_44_345 VDD VSS sg13g2_fill_1
XFILLER_71_142 VDD VSS sg13g2_decap_8
X_13631_ _13739_/D _13631_/A VDD VSS sg13g2_buf_1
X_10843_ _10843_/Y _10841_/Y _10843_/B _10843_/C VDD VSS sg13g2_nand3b_1
XFILLER_71_175 VDD VSS sg13g2_fill_2
XFILLER_13_721 VDD VSS sg13g2_decap_8
XFILLER_77_1292 VDD VSS sg13g2_decap_8
XFILLER_129_1371 VDD VSS sg13g2_decap_4
XFILLER_44_74 VDD VSS sg13g2_decap_8
XFILLER_13_743 VDD VSS sg13g2_decap_8
X_13562_ _15152_/D _15152_/Q _13561_/X _13587_/B VDD VSS sg13g2_mux2_1
XFILLER_38_1265 VDD VSS sg13g2_decap_8
X_10774_ _10774_/Y _13199_/A _11133_/B VDD VSS sg13g2_nand2_1
XFILLER_12_231 VDD VSS sg13g2_decap_8
XFILLER_164_1273 VDD VSS sg13g2_decap_8
XFILLER_9_714 VDD VSS sg13g2_decap_8
X_12513_ _15000_/D _12513_/A _12513_/B VDD VSS sg13g2_nor2_1
XFILLER_73_1178 VDD VSS sg13g2_decap_8
XFILLER_157_225 VDD VSS sg13g2_decap_8
XFILLER_158_748 VDD VSS sg13g2_decap_4
XFILLER_51_1410 VDD VSS sg13g2_decap_8
X_13493_ _13493_/Y _13412_/B _13412_/C _15126_/Q VDD VSS sg13g2_o21ai_1
XFILLER_157_236 VDD VSS sg13g2_fill_1
XFILLER_157_247 VDD VSS sg13g2_decap_8
XFILLER_8_235 VDD VSS sg13g2_decap_8
XFILLER_139_962 VDD VSS sg13g2_decap_8
XFILLER_185_567 VDD VSS sg13g2_decap_8
X_14478__1724 _14478_/RESET_B VDD VSS sg13g2_tiehi
XFILLER_145_409 VDD VSS sg13g2_decap_8
X_15232_ _15232_/Q clkload54/A _15232_/D _15232_/RESET_B VDD VSS sg13g2_dfrbpq_1
X_12444_ _12457_/A _12570_/A1 _12570_/A2 _13545_/A VDD VSS sg13g2_a21oi_1
XFILLER_138_450 VDD VSS sg13g2_fill_2
XFILLER_172_239 VDD VSS sg13g2_fill_1
X_15163_ _15163_/Q clkload37/A _15163_/D _15163_/RESET_B VDD VSS sg13g2_dfrbpq_1
XFILLER_154_943 VDD VSS sg13g2_decap_4
X_12375_ _12375_/X _14557_/Q _14589_/Q _14621_/Q _14653_/Q _12380_/S0 _12380_/S1 VDD
+ VSS sg13g2_mux4_1
XFILLER_5_931 VDD VSS sg13g2_decap_8
XFILLER_165_291 VDD VSS sg13g2_decap_8
XFILLER_181_740 VDD VSS sg13g2_decap_8
XFILLER_125_133 VDD VSS sg13g2_decap_8
XFILLER_176_84 VDD VSS sg13g2_decap_8
XFILLER_181_751 VDD VSS sg13g2_fill_1
XFILLER_158_1033 VDD VSS sg13g2_decap_4
X_14114_ _14114_/Q _14722_/CLK _14114_/D _14114_/RESET_B VDD VSS sg13g2_dfrbpq_1
X_11326_ _11326_/Y _11326_/A _11326_/B VDD VSS sg13g2_nand2_1
XFILLER_5_35 VDD VSS sg13g2_decap_8
XFILLER_4_441 VDD VSS sg13g2_decap_8
X_15094_ _15094_/Q clkload70/A _15094_/D _15094_/RESET_B VDD VSS sg13g2_dfrbpq_1
XFILLER_107_870 VDD VSS sg13g2_fill_2
XFILLER_10_1162 VDD VSS sg13g2_decap_8
XFILLER_141_626 VDD VSS sg13g2_decap_8
X_14045_ _14045_/Q clkload29/A _14045_/D _14045_/RESET_B VDD VSS sg13g2_dfrbpq_1
XFILLER_125_199 VDD VSS sg13g2_decap_8
XFILLER_180_294 VDD VSS sg13g2_decap_8
Xclkbuf_leaf_104_clk_i clkload53/A clkload3/A VDD VSS sg13g2_buf_8
X_11257_ _11257_/X _13724_/Q _14076_/Q _14428_/Q _14524_/Q _11282_/S0 _11282_/S1 VDD
+ VSS sg13g2_mux4_1
XFILLER_140_136 VDD VSS sg13g2_fill_1
XFILLER_45_1214 VDD VSS sg13g2_decap_8
XFILLER_140_147 VDD VSS sg13g2_fill_2
XFILLER_175_1391 VDD VSS sg13g2_decap_8
XFILLER_49_1394 VDD VSS sg13g2_decap_8
X_10208_ _10209_/B _14765_/Q _14749_/Q VDD VSS sg13g2_nand2b_1
XFILLER_95_713 VDD VSS sg13g2_fill_2
XFILLER_84_1296 VDD VSS sg13g2_decap_8
XFILLER_68_927 VDD VSS sg13g2_decap_8
XFILLER_136_1375 VDD VSS sg13g2_fill_2
X_11188_ _11188_/Y _11186_/B _11187_/Y _11186_/Y _11197_/B _11151_/A VDD VSS sg13g2_a221oi_1
XFILLER_171_1266 VDD VSS sg13g2_decap_8
XFILLER_121_372 VDD VSS sg13g2_fill_2
XFILLER_95_735 VDD VSS sg13g2_fill_1
XFILLER_132_1239 VDD VSS sg13g2_decap_8
X_15069__2890 _15069_/RESET_B VDD VSS sg13g2_tiehi
XFILLER_39_128 VDD VSS sg13g2_fill_1
X_10139_ _14716_/D _14716_/Q _10105_/A _10169_/S VDD VSS sg13g2_mux2_1
XFILLER_67_448 VDD VSS sg13g2_decap_8
Xclkbuf_leaf_119_clk_i clkload20/A clkload1/A VDD VSS sg13g2_buf_8
XFILLER_94_278 VDD VSS sg13g2_decap_8
XFILLER_36_813 VDD VSS sg13g2_decap_8
X_14947_ _14947_/Q _15240_/CLK _14947_/D _14947_/RESET_B VDD VSS sg13g2_dfrbpq_1
XFILLER_85_81 VDD VSS sg13g2_decap_8
X_13966__2236 _13966_/RESET_B VDD VSS sg13g2_tiehi
XFILLER_35_301 VDD VSS sg13g2_decap_8
XFILLER_36_835 VDD VSS sg13g2_fill_2
XFILLER_1_1330 VDD VSS sg13g2_decap_8
X_14878_ _14878_/Q clkload83/A _14878_/D _14878_/RESET_B VDD VSS sg13g2_dfrbpq_1
XFILLER_165_1015 VDD VSS sg13g2_decap_8
XFILLER_39_1018 VDD VSS sg13g2_decap_4
XFILLER_35_356 VDD VSS sg13g2_decap_8
X_13829_ _13829_/Q clkload16/A _13829_/D _13829_/RESET_B VDD VSS sg13g2_dfrbpq_1
XFILLER_95_1370 VDD VSS sg13g2_decap_8
XFILLER_90_473 VDD VSS sg13g2_decap_8
XFILLER_56_1332 VDD VSS sg13g2_decap_8
XFILLER_50_326 VDD VSS sg13g2_decap_8
XFILLER_108_1422 VDD VSS sg13g2_fill_1
XFILLER_182_1362 VDD VSS sg13g2_decap_8
XFILLER_52_1207 VDD VSS sg13g2_decap_8
XFILLER_176_512 VDD VSS sg13g2_fill_1
XFILLER_143_1335 VDD VSS sg13g2_decap_8
X_13669__2557 _13669_/RESET_B VDD VSS sg13g2_tiehi
XFILLER_149_748 VDD VSS sg13g2_decap_8
XFILLER_108_1477 VDD VSS sg13g2_fill_2
XFILLER_31_573 VDD VSS sg13g2_decap_8
XFILLER_15_1040 VDD VSS sg13g2_decap_8
X_09020_ _13764_/D _13764_/Q _10080_/A0 _09127_/S VDD VSS sg13g2_mux2_1
XFILLER_106_1190 VDD VSS sg13g2_fill_1
XFILLER_102_1032 VDD VSS sg13g2_decap_4
XFILLER_116_100 VDD VSS sg13g2_decap_8
XFILLER_176_1100 VDD VSS sg13g2_decap_8
XFILLER_117_678 VDD VSS sg13g2_decap_8
XFILLER_172_773 VDD VSS sg13g2_decap_8
XFILLER_176_1177 VDD VSS sg13g2_decap_8
XFILLER_160_957 VDD VSS sg13g2_decap_8
X_09922_ _14507_/D _14507_/Q _09922_/A1 _09931_/S VDD VSS sg13g2_mux2_1
XFILLER_67_1472 VDD VSS sg13g2_fill_2
Xfanout704 _11975_/A _11791_/S VDD VSS sg13g2_buf_1
XFILLER_28_1434 VDD VSS sg13g2_decap_8
Xfanout715 _11696_/B fanout719/X VDD VSS sg13g2_buf_1
XFILLER_98_551 VDD VSS sg13g2_decap_8
Xfanout726 _12253_/B _12290_/S0 VDD VSS sg13g2_buf_1
XFILLER_131_169 VDD VSS sg13g2_decap_8
Xfanout737 _11802_/B _11894_/B VDD VSS sg13g2_buf_1
X_09853_ _14440_/D _14440_/Q _10084_/A0 _09859_/S VDD VSS sg13g2_mux2_1
XFILLER_154_1464 VDD VSS sg13g2_decap_8
Xfanout748 _13419_/A2 _13307_/B VDD VSS sg13g2_buf_1
XFILLER_63_1358 VDD VSS sg13g2_decap_8
XFILLER_115_1437 VDD VSS sg13g2_fill_1
Xfanout759 _08301_/S fanout767/X VDD VSS sg13g2_buf_1
XFILLER_98_595 VDD VSS sg13g2_decap_8
XFILLER_105_36 VDD VSS sg13g2_decap_8
XFILLER_115_1448 VDD VSS sg13g2_fill_1
X_08804_ _08805_/B _13686_/Q _08810_/B VDD VSS sg13g2_nor2_1
XFILLER_22_1000 VDD VSS sg13g2_decap_8
X_09784_ _14373_/D _09916_/A1 _14373_/Q _09795_/S VDD VSS sg13g2_mux2_1
XFILLER_65_18 VDD VSS sg13g2_decap_8
XFILLER_100_567 VDD VSS sg13g2_decap_8
XFILLER_22_1022 VDD VSS sg13g2_decap_8
XFILLER_65_29 VDD VSS sg13g2_fill_1
XFILLER_39_651 VDD VSS sg13g2_decap_8
X_08735_ _13663_/D _08765_/A1 _08733_/Y _08734_/Y VDD VSS sg13g2_a21oi_1
XFILLER_67_982 VDD VSS sg13g2_decap_8
XFILLER_6_1285 VDD VSS sg13g2_decap_8
XFILLER_2_1127 VDD VSS sg13g2_decap_8
X_14556__1646 _14556_/RESET_B VDD VSS sg13g2_tiehi
XFILLER_54_632 VDD VSS sg13g2_decap_8
X_08666_ _08666_/X _08678_/A _08666_/B VDD VSS sg13g2_xor2_1
XFILLER_26_334 VDD VSS sg13g2_decap_8
XFILLER_57_1107 VDD VSS sg13g2_decap_8
X_15150__2680 _15150_/RESET_B VDD VSS sg13g2_tiehi
Xclkbuf_leaf_83_clk_i _15188_/CLK clkbuf_leaf_84_clk_i/A VDD VSS sg13g2_buf_8
X_07617_ _09011_/A _14902_/Q VDD VSS sg13g2_inv_1
XFILLER_109_1208 VDD VSS sg13g2_decap_8
XFILLER_96_1189 VDD VSS sg13g2_fill_1
XFILLER_183_1148 VDD VSS sg13g2_decap_8
X_08597_ _08600_/C _08599_/A _08597_/B _08597_/C VDD VSS sg13g2_nor3_1
XFILLER_81_484 VDD VSS sg13g2_decap_8
XFILLER_81_28 VDD VSS sg13g2_decap_8
XFILLER_74_1443 VDD VSS sg13g2_decap_8
XFILLER_70_1329 VDD VSS sg13g2_decap_8
XFILLER_167_534 VDD VSS sg13g2_decap_8
XFILLER_161_1457 VDD VSS sg13g2_decap_8
XFILLER_14_77 VDD VSS sg13g2_decap_8
XFILLER_10_735 VDD VSS sg13g2_decap_8
Xclkbuf_leaf_98_clk_i clkload52/A clkload3/A VDD VSS sg13g2_buf_8
X_09218_ _13829_/D _10148_/A1 _13829_/Q _09229_/S VDD VSS sg13g2_mux2_1
XFILLER_155_718 VDD VSS sg13g2_decap_8
XFILLER_182_504 VDD VSS sg13g2_fill_2
XFILLER_167_589 VDD VSS sg13g2_fill_1
X_10490_ _14850_/D _10490_/A _10490_/B _10498_/D VDD VSS sg13g2_nor3_1
XFILLER_154_217 VDD VSS sg13g2_fill_2
XFILLER_6_739 VDD VSS sg13g2_decap_8
XFILLER_33_1184 VDD VSS sg13g2_decap_8
XFILLER_182_548 VDD VSS sg13g2_decap_8
X_09149_ _09151_/B _09157_/C _09157_/D _14923_/Q VDD VSS sg13g2_a21o_1
XFILLER_108_645 VDD VSS sg13g2_decap_4
XFILLER_30_32 VDD VSS sg13g2_decap_8
XFILLER_5_238 VDD VSS sg13g2_decap_8
XFILLER_30_43 VDD VSS sg13g2_fill_1
XFILLER_120_1176 VDD VSS sg13g2_decap_4
XFILLER_159_1353 VDD VSS sg13g2_decap_8
Xclkbuf_leaf_21_clk_i clkload29/A clkbuf_leaf_9_clk_i/A VDD VSS sg13g2_buf_8
XFILLER_108_678 VDD VSS sg13g2_decap_4
X_12160_ _12160_/Y _12168_/A _14230_/Q _12184_/B VDD VSS sg13g2_a21oi_1
XFILLER_11_1471 VDD VSS sg13g2_decap_4
XFILLER_162_250 VDD VSS sg13g2_decap_8
XFILLER_135_475 VDD VSS sg13g2_decap_8
XFILLER_68_1258 VDD VSS sg13g2_decap_8
XFILLER_155_1217 VDD VSS sg13g2_fill_1
XFILLER_107_188 VDD VSS sg13g2_fill_1
XFILLER_122_114 VDD VSS sg13g2_fill_1
XFILLER_151_946 VDD VSS sg13g2_decap_8
X_11111_ _11111_/Y _11109_/B _10764_/X _11154_/B1 VDD VSS sg13g2_o21ai_1
XFILLER_2_945 VDD VSS sg13g2_decap_8
X_12091_ _12092_/B _12091_/A _12091_/B _12091_/C VDD VSS sg13g2_nand3_1
XFILLER_118_1050 VDD VSS sg13g2_decap_8
XFILLER_150_478 VDD VSS sg13g2_fill_1
XFILLER_1_455 VDD VSS sg13g2_decap_8
X_11042_ _11078_/D _11042_/A _11042_/B _11042_/C _11042_/D VDD VSS sg13g2_nand4_1
XFILLER_89_562 VDD VSS sg13g2_decap_8
X_14756__2983 _14756_/RESET_B VDD VSS sg13g2_tiehi
XFILLER_81_1447 VDD VSS sg13g2_decap_8
XFILLER_49_404 VDD VSS sg13g2_decap_4
XFILLER_150_489 VDD VSS sg13g2_decap_8
Xclkbuf_leaf_36_clk_i clkload42/A clkbuf_leaf_38_clk_i/A VDD VSS sg13g2_buf_8
XFILLER_162_53 VDD VSS sg13g2_decap_8
XFILLER_77_757 VDD VSS sg13g2_decap_4
XFILLER_76_245 VDD VSS sg13g2_decap_8
XFILLER_77_779 VDD VSS sg13g2_decap_8
X_14801_ _14801_/Q clkload65/A _14801_/D _14801_/RESET_B VDD VSS sg13g2_dfrbpq_1
XFILLER_44_1291 VDD VSS sg13g2_decap_8
XFILLER_131_1250 VDD VSS sg13g2_fill_1
XFILLER_18_824 VDD VSS sg13g2_decap_8
XFILLER_40_1144 VDD VSS sg13g2_decap_8
X_12993_ _12995_/C _13058_/D _12993_/B _12993_/C VDD VSS sg13g2_nand3b_1
XFILLER_57_470 VDD VSS sg13g2_decap_8
XFILLER_91_226 VDD VSS sg13g2_fill_1
XFILLER_79_1332 VDD VSS sg13g2_decap_8
XFILLER_29_172 VDD VSS sg13g2_decap_8
X_14732_ _14732_/Q clkload53/A _14732_/D _14732_/RESET_B VDD VSS sg13g2_dfrbpq_1
XFILLER_18_868 VDD VSS sg13g2_decap_8
X_11944_ _11944_/Y _11940_/Y _11941_/Y _11943_/Y _11942_/Y _11973_/B VDD VSS sg13g2_a221oi_1
XFILLER_44_120 VDD VSS sg13g2_fill_1
XFILLER_73_963 VDD VSS sg13g2_decap_8
XFILLER_44_131 VDD VSS sg13g2_decap_8
XFILLER_166_1346 VDD VSS sg13g2_decap_8
X_14663_ _14663_/Q _14727_/CLK _14663_/D _14663_/RESET_B VDD VSS sg13g2_dfrbpq_1
X_11875_ _11875_/X _11875_/A _11875_/B VDD VSS sg13g2_and2_1
XFILLER_55_95 VDD VSS sg13g2_decap_4
XFILLER_33_838 VDD VSS sg13g2_decap_4
XFILLER_72_484 VDD VSS sg13g2_decap_8
X_13614_ _15168_/D _08842_/S _16854_/A _13613_/Y VDD VSS sg13g2_a21o_1
X_10826_ _10841_/A _12347_/B _10851_/D VDD VSS sg13g2_nor2_1
X_14594_ _14594_/Q clkload7/A _14594_/D _14594_/RESET_B VDD VSS sg13g2_dfrbpq_1
XFILLER_129_1190 VDD VSS sg13g2_decap_8
XFILLER_158_534 VDD VSS sg13g2_decap_8
XFILLER_9_511 VDD VSS sg13g2_decap_8
X_13545_ _13545_/X _13545_/A _13545_/B VDD VSS sg13g2_and2_1
X_14601__1601 _14601_/RESET_B VDD VSS sg13g2_tiehi
X_10757_ _10757_/Y _10757_/A _10757_/B VDD VSS sg13g2_nor2_1
XFILLER_186_854 VDD VSS sg13g2_decap_8
XFILLER_125_1065 VDD VSS sg13g2_decap_8
XFILLER_158_578 VDD VSS sg13g2_fill_1
XFILLER_185_364 VDD VSS sg13g2_decap_8
X_13476_ _15112_/D _15178_/D _15112_/Q _13653_/S VDD VSS sg13g2_mux2_1
X_10688_ _10851_/C _08992_/B _08852_/A _08852_/Y VDD VSS sg13g2_a21o_1
XFILLER_9_588 VDD VSS sg13g2_decap_8
XFILLER_16_1393 VDD VSS sg13g2_decap_8
X_14030__2172 _14030_/RESET_B VDD VSS sg13g2_tiehi
X_15215_ _15215_/Q clkload71/A _15215_/D _15215_/RESET_B VDD VSS sg13g2_dfrbpq_1
X_12427_ _12427_/X _12425_/X _12424_/X _12421_/X _12420_/X _12427_/S0 _12609_/S VDD
+ VSS sg13g2_mux4_1
XFILLER_51_1284 VDD VSS sg13g2_decap_8
XFILLER_12_1257 VDD VSS sg13g2_decap_8
XFILLER_138_291 VDD VSS sg13g2_decap_8
XFILLER_154_762 VDD VSS sg13g2_decap_4
X_15146_ _15146_/Q _15162_/CLK _15146_/D _15146_/RESET_B VDD VSS sg13g2_dfrbpq_1
X_12358_ _12358_/Y _15217_/Q _12358_/B VDD VSS sg13g2_nand2b_1
XFILLER_127_998 VDD VSS sg13g2_decap_8
XFILLER_177_1464 VDD VSS sg13g2_decap_4
XFILLER_181_570 VDD VSS sg13g2_fill_1
XFILLER_153_272 VDD VSS sg13g2_decap_8
XFILLER_181_581 VDD VSS sg13g2_decap_8
X_14634__1568 _14634_/RESET_B VDD VSS sg13g2_tiehi
X_11309_ _11309_/Y _11310_/A1 _14429_/Q VDD VSS sg13g2_nand2b_1
XFILLER_141_434 VDD VSS sg13g2_fill_1
X_15077_ _15077_/Q clkload71/A _15077_/D _15077_/RESET_B VDD VSS sg13g2_dfrbpq_1
XFILLER_99_348 VDD VSS sg13g2_decap_8
Xclkbuf_5_25__f_clk_i clkload4/A clkbuf_4_12_0_clk_i/X VDD VSS sg13g2_buf_16
X_12289_ _12289_/X _12283_/X _12284_/X _12287_/X _12288_/X _12253_/B _12263_/C VDD
+ VSS sg13g2_mux4_1
XFILLER_113_147 VDD VSS sg13g2_decap_8
XFILLER_45_1011 VDD VSS sg13g2_decap_8
X_14028_ _14028_/Q clkload50/A _14028_/D _14028_/RESET_B VDD VSS sg13g2_dfrbpq_1
XFILLER_68_702 VDD VSS sg13g2_decap_8
XFILLER_49_1191 VDD VSS sg13g2_decap_8
XFILLER_84_1093 VDD VSS sg13g2_decap_8
XFILLER_95_510 VDD VSS sg13g2_decap_8
XFILLER_171_1085 VDD VSS sg13g2_fill_1
XFILLER_56_908 VDD VSS sg13g2_fill_1
XFILLER_110_865 VDD VSS sg13g2_decap_8
XFILLER_95_565 VDD VSS sg13g2_decap_4
XFILLER_110_876 VDD VSS sg13g2_fill_1
XFILLER_23_1353 VDD VSS sg13g2_decap_8
XFILLER_3_1425 VDD VSS sg13g2_decap_8
XFILLER_97_1421 VDD VSS sg13g2_decap_8
XFILLER_36_610 VDD VSS sg13g2_decap_8
X_08520_ _08520_/X _08457_/X _08597_/C _08597_/B VDD VSS sg13g2_mux2_1
XFILLER_97_1465 VDD VSS sg13g2_decap_8
XFILLER_64_963 VDD VSS sg13g2_decap_8
XFILLER_58_1427 VDD VSS sg13g2_decap_8
XFILLER_24_805 VDD VSS sg13g2_decap_8
XFILLER_110_1378 VDD VSS sg13g2_fill_1
XFILLER_24_816 VDD VSS sg13g2_fill_2
X_08451_ _08462_/B _08483_/A1 _08087_/X _08688_/C VDD VSS sg13g2_o21ai_1
XFILLER_184_1457 VDD VSS sg13g2_decap_8
XFILLER_63_484 VDD VSS sg13g2_decap_8
XFILLER_36_698 VDD VSS sg13g2_decap_8
XFILLER_184_1468 VDD VSS sg13g2_fill_2
X_14240__1962 _14240_/RESET_B VDD VSS sg13g2_tiehi
X_08382_ _08382_/X _08383_/A _08383_/B VDD VSS sg13g2_and2_1
XFILLER_51_668 VDD VSS sg13g2_fill_1
XFILLER_50_156 VDD VSS sg13g2_fill_1
X_15224__3015 _15224_/RESET_B VDD VSS sg13g2_tiehi
XFILLER_52_1026 VDD VSS sg13g2_decap_8
XFILLER_143_1154 VDD VSS sg13g2_decap_4
XFILLER_31_370 VDD VSS sg13g2_decap_8
XFILLER_177_876 VDD VSS sg13g2_decap_8
XFILLER_17_1168 VDD VSS sg13g2_decap_8
XFILLER_52_1059 VDD VSS sg13g2_decap_4
XFILLER_34_1460 VDD VSS sg13g2_decap_8
XFILLER_136_217 VDD VSS sg13g2_decap_8
XFILLER_176_386 VDD VSS sg13g2_decap_8
XFILLER_121_1430 VDD VSS sg13g2_decap_8
X_09003_ _09003_/X _15028_/Q _15225_/Q _09027_/S VDD VSS sg13g2_mux2_1
XFILLER_121_1441 VDD VSS sg13g2_fill_1
XFILLER_176_397 VDD VSS sg13g2_fill_1
XFILLER_30_1335 VDD VSS sg13g2_decap_8
XFILLER_132_401 VDD VSS sg13g2_fill_2
XFILLER_105_637 VDD VSS sg13g2_decap_8
XFILLER_132_434 VDD VSS sg13g2_fill_2
XFILLER_133_979 VDD VSS sg13g2_decap_4
Xfanout501 _08876_/S _08861_/S VDD VSS sg13g2_buf_1
XFILLER_28_1231 VDD VSS sg13g2_decap_8
Xfanout512 _10202_/S _13480_/S VDD VSS sg13g2_buf_1
X_09905_ _09905_/X _09905_/A _10105_/C _10037_/A _10070_/B VDD VSS sg13g2_and4_1
XFILLER_116_57 VDD VSS sg13g2_decap_8
Xfanout523 _13512_/S _13508_/X VDD VSS sg13g2_buf_1
XFILLER_59_713 VDD VSS sg13g2_decap_8
XFILLER_113_670 VDD VSS sg13g2_fill_2
XFILLER_116_68 VDD VSS sg13g2_fill_1
Xfanout534 _12791_/A2 _12358_/Y VDD VSS sg13g2_buf_1
Xfanout545 _10138_/A1 _09741_/A1 VDD VSS sg13g2_buf_1
XFILLER_76_28 VDD VSS sg13g2_decap_8
XFILLER_58_212 VDD VSS sg13g2_decap_8
Xfanout556 _08835_/A _08833_/Y VDD VSS sg13g2_buf_1
XFILLER_98_392 VDD VSS sg13g2_fill_1
XFILLER_100_320 VDD VSS sg13g2_decap_4
XFILLER_112_180 VDD VSS sg13g2_fill_1
Xfanout567 _08652_/B1 _08688_/C VDD VSS sg13g2_buf_1
X_09836_ _14424_/D _09935_/A1 _14424_/Q _09837_/S VDD VSS sg13g2_mux2_1
XFILLER_8_1369 VDD VSS sg13g2_decap_8
Xfanout578 _13030_/B1 _13297_/A0 VDD VSS sg13g2_buf_1
Xfanout589 _13561_/S _12793_/Y VDD VSS sg13g2_buf_1
XFILLER_86_565 VDD VSS sg13g2_decap_8
XFILLER_150_1158 VDD VSS sg13g2_decap_4
XFILLER_74_716 VDD VSS sg13g2_decap_4
XFILLER_101_887 VDD VSS sg13g2_decap_4
XFILLER_18_109 VDD VSS sg13g2_decap_8
XFILLER_46_418 VDD VSS sg13g2_decap_4
XFILLER_132_23 VDD VSS sg13g2_decap_8
XFILLER_41_1453 VDD VSS sg13g2_decap_8
X_09767_ _14357_/D _14357_/Q _09767_/A1 _09771_/S VDD VSS sg13g2_mux2_1
XFILLER_6_1082 VDD VSS sg13g2_decap_8
XFILLER_27_621 VDD VSS sg13g2_fill_1
XFILLER_39_481 VDD VSS sg13g2_decap_8
XFILLER_132_67 VDD VSS sg13g2_fill_1
X_08718_ _15212_/D _15191_/D _15121_/Q _13655_/S VDD VSS sg13g2_mux2_1
X_09698_ _14290_/D _09929_/A1 _14290_/Q _09704_/S VDD VSS sg13g2_mux2_1
XFILLER_55_974 VDD VSS sg13g2_decap_4
XFILLER_26_142 VDD VSS sg13g2_fill_1
X_08649_ _08650_/B _08662_/B _08647_/Y _08649_/S VDD VSS sg13g2_mux2_1
XFILLER_82_793 VDD VSS sg13g2_fill_2
XFILLER_25_32 VDD VSS sg13g2_decap_8
XFILLER_155_4 VDD VSS sg13g2_decap_8
X_11660_ _11771_/A _14970_/Q _13680_/Q VDD VSS sg13g2_nor2_1
XFILLER_74_1240 VDD VSS sg13g2_decap_8
XFILLER_70_966 VDD VSS sg13g2_decap_8
XFILLER_70_977 VDD VSS sg13g2_fill_2
XFILLER_42_668 VDD VSS sg13g2_fill_2
XFILLER_39_1371 VDD VSS sg13g2_decap_8
X_10611_ _14879_/D _10611_/A _10626_/B _10611_/C VDD VSS sg13g2_and3_1
XFILLER_167_320 VDD VSS sg13g2_fill_2
XFILLER_126_1363 VDD VSS sg13g2_decap_4
X_11591_ _11636_/C _11591_/A _13682_/Q VDD VSS sg13g2_xor2_1
XFILLER_161_1254 VDD VSS sg13g2_decap_8
XFILLER_22_381 VDD VSS sg13g2_fill_2
XFILLER_10_532 VDD VSS sg13g2_decap_8
XFILLER_126_1385 VDD VSS sg13g2_decap_8
X_13330_ _13502_/B hold3063/X _13340_/S _13329_/Y VDD VSS sg13g2_o21ai_1
XFILLER_35_1268 VDD VSS sg13g2_decap_8
X_10542_ _10544_/A _13273_/A _10547_/D _14863_/Q VDD VSS sg13g2_a21o_1
XFILLER_41_42 VDD VSS sg13g2_decap_8
XFILLER_182_312 VDD VSS sg13g2_decap_8
XFILLER_127_239 VDD VSS sg13g2_decap_8
XFILLER_155_548 VDD VSS sg13g2_decap_8
X_13261_ _13261_/Y _14829_/Q _13206_/B _07728_/C _14893_/Q _13248_/B VDD VSS sg13g2_a221oi_1
XFILLER_6_536 VDD VSS sg13g2_decap_8
X_10473_ _10484_/D _10504_/C _14845_/Q _10500_/A _10473_/D VDD VSS sg13g2_and4_1
XFILLER_157_53 VDD VSS sg13g2_decap_8
XFILLER_68_1011 VDD VSS sg13g2_decap_8
XFILLER_109_976 VDD VSS sg13g2_fill_2
XFILLER_170_507 VDD VSS sg13g2_decap_8
X_15000_ _15000_/Q clkload22/A _15000_/D _15000_/RESET_B VDD VSS sg13g2_dfrbpq_1
X_12212_ _12212_/X _13751_/Q _14103_/Q _14455_/Q _14551_/Q _12215_/S0 _12241_/B1 VDD
+ VSS sg13g2_mux4_1
XFILLER_159_1150 VDD VSS sg13g2_decap_8
XFILLER_182_389 VDD VSS sg13g2_decap_8
X_13192_ _13192_/X input21/X _13272_/A2 _13264_/B1 VDD VSS sg13g2_a21o_1
XFILLER_123_401 VDD VSS sg13g2_decap_4
XFILLER_108_486 VDD VSS sg13g2_decap_8
XFILLER_29_1006 VDD VSS sg13g2_decap_4
X_12143_ _12144_/B _12143_/A _12143_/B VDD VSS sg13g2_nor2_1
XFILLER_155_1025 VDD VSS sg13g2_decap_4
XFILLER_9_0 VDD VSS sg13g2_decap_8
XFILLER_2_742 VDD VSS sg13g2_decap_8
XFILLER_68_1099 VDD VSS sg13g2_decap_4
XFILLER_1_252 VDD VSS sg13g2_decap_8
X_12074_ _12075_/B _12071_/X _12070_/X _12067_/X _12066_/X _12219_/S _12142_/S1 VDD
+ VSS sg13g2_mux4_1
XFILLER_173_63 VDD VSS sg13g2_decap_8
XFILLER_172_1361 VDD VSS sg13g2_decap_8
XFILLER_81_1244 VDD VSS sg13g2_decap_8
XFILLER_150_297 VDD VSS sg13g2_decap_8
XFILLER_2_14 VDD VSS sg13g2_decap_8
XFILLER_133_1334 VDD VSS sg13g2_decap_8
X_11025_ _11025_/Y _11022_/Y _11064_/B _11014_/A VDD VSS sg13g2_a21oi_1
XFILLER_89_392 VDD VSS sg13g2_decap_8
XFILLER_46_1386 VDD VSS sg13g2_decap_8
X_14904__2759 _14904_/RESET_B VDD VSS sg13g2_tiehi
X_16882_ _16882_/X _16882_/A VDD VSS sg13g2_buf_1
XFILLER_65_716 VDD VSS sg13g2_decap_8
XFILLER_92_524 VDD VSS sg13g2_fill_2
XFILLER_168_1419 VDD VSS sg13g2_decap_8
X_12976_ _12976_/Y _14842_/Q _12976_/B VDD VSS sg13g2_nand2_1
X_14048__2154 _14048_/RESET_B VDD VSS sg13g2_tiehi
XFILLER_79_1162 VDD VSS sg13g2_decap_8
XFILLER_18_676 VDD VSS sg13g2_decap_8
XFILLER_75_1004 VDD VSS sg13g2_decap_8
X_14715_ _14715_/Q clkload80/A _14715_/D _14715_/RESET_B VDD VSS sg13g2_dfrbpq_1
X_11927_ _11929_/B _12291_/A _11927_/B VDD VSS sg13g2_nor2_1
XFILLER_17_175 VDD VSS sg13g2_fill_2
XFILLER_60_410 VDD VSS sg13g2_decap_8
XFILLER_32_112 VDD VSS sg13g2_decap_8
XFILLER_72_292 VDD VSS sg13g2_decap_8
XFILLER_127_1127 VDD VSS sg13g2_decap_4
XFILLER_162_1007 VDD VSS sg13g2_fill_2
X_14646_ _14646_/Q clkload75/A _14646_/D _14646_/RESET_B VDD VSS sg13g2_dfrbpq_1
X_11858_ _11858_/Y _11858_/A _11858_/B VDD VSS sg13g2_nor2_1
XFILLER_57_1471 VDD VSS sg13g2_fill_1
XFILLER_20_307 VDD VSS sg13g2_decap_8
XANTENNA_19 fanout364/X VDD VSS sg13g2_antennanp
XFILLER_105_1403 VDD VSS sg13g2_fill_1
XFILLER_158_320 VDD VSS sg13g2_fill_2
XFILLER_18_1455 VDD VSS sg13g2_decap_8
X_10809_ _10809_/Y _11043_/A _10809_/B VDD VSS sg13g2_nor2_1
XFILLER_53_1335 VDD VSS sg13g2_decap_8
X_14577_ _14577_/Q _15139_/CLK _14577_/D _14577_/RESET_B VDD VSS sg13g2_dfrbpq_1
X_11789_ _11789_/X _11781_/X _11782_/X _11785_/X _11786_/X _12092_/C _12118_/C VDD
+ VSS sg13g2_mux4_1
XFILLER_92_1395 VDD VSS sg13g2_decap_8
XFILLER_144_1474 VDD VSS sg13g2_fill_1
XFILLER_186_651 VDD VSS sg13g2_decap_8
XFILLER_105_1436 VDD VSS sg13g2_decap_8
X_13528_ _15142_/D _13565_/S _13526_/Y _13527_/Y VDD VSS sg13g2_a21oi_1
XFILLER_185_161 VDD VSS sg13g2_decap_8
XFILLER_140_1349 VDD VSS sg13g2_fill_2
XFILLER_16_1190 VDD VSS sg13g2_decap_8
XFILLER_9_385 VDD VSS sg13g2_decap_8
X_13459_ _13459_/Y _15196_/Q _13459_/B _13459_/C _13459_/D VDD VSS sg13g2_nand4_1
XFILLER_51_1092 VDD VSS sg13g2_decap_8
XFILLER_127_762 VDD VSS sg13g2_decap_4
XFILLER_12_1054 VDD VSS sg13g2_decap_8
Xoutput104 mem_axi_wdata[0] _15132_/Q VDD VSS sg13g2_buf_1
Xoutput115 mem_axi_wdata[1] _15133_/Q VDD VSS sg13g2_buf_1
XFILLER_115_935 VDD VSS sg13g2_decap_8
XFILLER_177_1261 VDD VSS sg13g2_decap_8
XFILLER_182_890 VDD VSS sg13g2_decap_8
Xoutput126 mem_axi_wdata[2] _15134_/Q VDD VSS sg13g2_buf_1
XFILLER_86_1155 VDD VSS sg13g2_decap_8
XFILLER_138_1234 VDD VSS sg13g2_decap_4
X_15095__2814 _15095_/RESET_B VDD VSS sg13g2_tiehi
Xoutput137 mem_axi_wstrb[1] _15165_/Q VDD VSS sg13g2_buf_1
XFILLER_99_123 VDD VSS sg13g2_fill_1
X_15129_ _15129_/Q _15214_/CLK _15129_/D _15129_/RESET_B VDD VSS sg13g2_dfrbpq_1
XFILLER_82_1008 VDD VSS sg13g2_decap_8
XFILLER_88_808 VDD VSS sg13g2_decap_8
XFILLER_114_467 VDD VSS sg13g2_fill_1
XFILLER_142_776 VDD VSS sg13g2_fill_2
XFILLER_99_156 VDD VSS sg13g2_decap_8
XFILLER_99_167 VDD VSS sg13g2_fill_2
XFILLER_141_264 VDD VSS sg13g2_decap_8
XFILLER_173_1169 VDD VSS sg13g2_decap_8
X_07951_ _07951_/Y _15010_/Q _07818_/B VDD VSS sg13g2_nor2b_1
XFILLER_64_1442 VDD VSS sg13g2_decap_8
XFILLER_151_1401 VDD VSS sg13g2_decap_8
XFILLER_25_1404 VDD VSS sg13g2_decap_8
XFILLER_101_117 VDD VSS sg13g2_decap_8
XFILLER_130_949 VDD VSS sg13g2_decap_8
X_14258__1944 _14258_/RESET_B VDD VSS sg13g2_tiehi
X_07882_ _07882_/Y _08079_/S _13609_/A VDD VSS sg13g2_nor2_1
XFILLER_110_651 VDD VSS sg13g2_decap_8
XFILLER_112_1407 VDD VSS sg13g2_fill_1
XFILLER_110_662 VDD VSS sg13g2_fill_1
X_09621_ _14217_/D _09755_/A1 _14217_/Q _09623_/S VDD VSS sg13g2_mux2_1
XFILLER_95_373 VDD VSS sg13g2_fill_1
XFILLER_110_695 VDD VSS sg13g2_decap_8
XFILLER_23_1150 VDD VSS sg13g2_decap_8
XFILLER_49_790 VDD VSS sg13g2_decap_4
XFILLER_3_1222 VDD VSS sg13g2_decap_8
X_09552_ _14150_/D _09686_/A0 _14150_/Q _09556_/S VDD VSS sg13g2_mux2_1
XFILLER_83_557 VDD VSS sg13g2_decap_8
XFILLER_71_708 VDD VSS sg13g2_fill_2
XFILLER_110_1142 VDD VSS sg13g2_decap_4
XFILLER_97_1251 VDD VSS sg13g2_decap_8
XFILLER_71_719 VDD VSS sg13g2_decap_4
X_08503_ _08503_/Y _07820_/B _07636_/Y _08497_/A VDD VSS sg13g2_o21ai_1
XFILLER_64_771 VDD VSS sg13g2_fill_1
XFILLER_58_1224 VDD VSS sg13g2_decap_8
X_09483_ _14083_/D _10113_/A0 _14083_/Q _09493_/S VDD VSS sg13g2_mux2_1
XFILLER_3_1299 VDD VSS sg13g2_decap_8
XFILLER_102_48 VDD VSS sg13g2_decap_4
XFILLER_97_1295 VDD VSS sg13g2_decap_8
XFILLER_110_1197 VDD VSS sg13g2_decap_8
XFILLER_184_1254 VDD VSS sg13g2_decap_8
XFILLER_24_635 VDD VSS sg13g2_decap_8
XFILLER_19_1219 VDD VSS sg13g2_decap_8
X_08434_ _08442_/B _08574_/B _08434_/B VDD VSS sg13g2_nand2b_1
XFILLER_169_629 VDD VSS sg13g2_decap_8
XFILLER_24_668 VDD VSS sg13g2_decap_8
X_08365_ _08411_/C _07782_/A _15002_/Q _07786_/A _08351_/B VDD VSS sg13g2_a22oi_1
XFILLER_149_342 VDD VSS sg13g2_decap_4
XFILLER_71_1446 VDD VSS sg13g2_decap_8
XFILLER_183_109 VDD VSS sg13g2_decap_8
XFILLER_149_364 VDD VSS sg13g2_decap_4
XFILLER_149_375 VDD VSS sg13g2_fill_2
XFILLER_176_161 VDD VSS sg13g2_decap_8
XFILLER_177_684 VDD VSS sg13g2_decap_8
X_08296_ _08296_/Y _07778_/A _08276_/B _08391_/A VDD VSS sg13g2_a21oi_1
XFILLER_109_217 VDD VSS sg13g2_decap_8
X_13746__2456 _13746_/RESET_B VDD VSS sg13g2_tiehi
XFILLER_106_913 VDD VSS sg13g2_decap_8
XFILLER_117_250 VDD VSS sg13g2_fill_1
XFILLER_11_67 VDD VSS sg13g2_decap_8
XFILLER_156_1301 VDD VSS sg13g2_decap_8
XFILLER_69_1353 VDD VSS sg13g2_decap_8
XFILLER_133_721 VDD VSS sg13g2_fill_2
XFILLER_105_445 VDD VSS sg13g2_decap_8
XFILLER_106_968 VDD VSS sg13g2_decap_8
XFILLER_65_1228 VDD VSS sg13g2_decap_8
XFILLER_160_540 VDD VSS sg13g2_fill_2
XFILLER_2_7 VDD VSS sg13g2_decap_8
X_13961__2241 _13961_/RESET_B VDD VSS sg13g2_tiehi
X_14126__2076 _14126_/RESET_B VDD VSS sg13g2_tiehi
XFILLER_120_404 VDD VSS sg13g2_decap_8
XFILLER_156_1378 VDD VSS sg13g2_decap_8
Xfanout1307 _12139_/S1 _12140_/S1 VDD VSS sg13g2_buf_1
Xfanout320 _09958_/S fanout323/X VDD VSS sg13g2_buf_1
XFILLER_114_990 VDD VSS sg13g2_decap_8
Xfanout1318 _12326_/B1 fanout1319/X VDD VSS sg13g2_buf_1
Xfanout331 _09865_/S fanout335/X VDD VSS sg13g2_buf_1
Xfanout1329 fanout1329/X fanout1394/X VDD VSS sg13g2_buf_1
Xfanout342 _09729_/S _09725_/S VDD VSS sg13g2_buf_1
Xfanout353 _09632_/S _09622_/S VDD VSS sg13g2_buf_1
Xfanout364 fanout364/X _09474_/X VDD VSS sg13g2_buf_1
Xfanout375 _09263_/S _09259_/S VDD VSS sg13g2_buf_1
XFILLER_8_1166 VDD VSS sg13g2_decap_8
XFILLER_87_885 VDD VSS sg13g2_decap_4
XFILLER_4_1008 VDD VSS sg13g2_decap_8
XFILLER_19_418 VDD VSS sg13g2_decap_8
Xfanout386 _10113_/A0 fanout390/X VDD VSS sg13g2_buf_1
XFILLER_98_1004 VDD VSS sg13g2_decap_8
XFILLER_143_77 VDD VSS sg13g2_fill_1
Xfanout397 _09612_/A0 _10110_/A0 VDD VSS sg13g2_buf_1
X_09819_ _14407_/D _09918_/A1 _14407_/Q _09828_/S VDD VSS sg13g2_mux2_1
XFILLER_74_513 VDD VSS sg13g2_decap_8
XFILLER_47_738 VDD VSS sg13g2_decap_8
XFILLER_143_99 VDD VSS sg13g2_decap_8
XFILLER_41_1250 VDD VSS sg13g2_decap_8
X_12830_ _12830_/Y _14801_/Q _12851_/B _12879_/B _14833_/Q _12930_/C1 VDD VSS sg13g2_a221oi_1
XFILLER_167_1430 VDD VSS sg13g2_decap_8
XFILLER_76_1324 VDD VSS sg13g2_decap_8
X_12761_ _12761_/X _12759_/X _12758_/X _12755_/X _12754_/X _12775_/S1 _12748_/S VDD
+ VSS sg13g2_mux4_1
XFILLER_61_229 VDD VSS sg13g2_decap_8
XFILLER_54_270 VDD VSS sg13g2_decap_8
XFILLER_14_112 VDD VSS sg13g2_decap_8
XFILLER_37_1308 VDD VSS sg13g2_decap_8
X_14500_ _14500_/Q _14510_/CLK _14500_/D _14500_/RESET_B VDD VSS sg13g2_dfrbpq_1
X_11712_ _11712_/X _14121_/Q _14153_/Q _14185_/Q _14217_/Q _11715_/S0 _11715_/S1 VDD
+ VSS sg13g2_mux4_1
X_12692_ _12692_/X _12691_/X _12690_/X _12762_/S VDD VSS sg13g2_mux2_1
XFILLER_163_1338 VDD VSS sg13g2_decap_8
XFILLER_43_988 VDD VSS sg13g2_decap_8
XFILLER_30_605 VDD VSS sg13g2_decap_8
XFILLER_159_128 VDD VSS sg13g2_decap_8
XFILLER_42_465 VDD VSS sg13g2_decap_8
XFILLER_146_0 VDD VSS sg13g2_decap_8
X_14431_ _14431_/Q clkload61/A _14431_/D _14431_/RESET_B VDD VSS sg13g2_dfrbpq_1
X_11643_ _11643_/Y _11643_/A _11643_/B VDD VSS sg13g2_xnor2_1
XFILLER_52_85 VDD VSS sg13g2_fill_1
XFILLER_161_1073 VDD VSS sg13g2_decap_8
X_14362_ _14362_/Q _14682_/CLK _14362_/D _14362_/RESET_B VDD VSS sg13g2_dfrbpq_1
X_11574_ _11574_/X _13733_/Q _14085_/Q _14437_/Q _14533_/Q _11580_/S0 _11580_/S1 VDD
+ VSS sg13g2_mux4_1
XFILLER_128_526 VDD VSS sg13g2_decap_8
XFILLER_155_301 VDD VSS sg13g2_decap_8
XFILLER_156_835 VDD VSS sg13g2_decap_8
XFILLER_168_63 VDD VSS sg13g2_decap_8
XFILLER_7_812 VDD VSS sg13g2_decap_8
XFILLER_52_96 VDD VSS sg13g2_decap_8
XFILLER_11_874 VDD VSS sg13g2_decap_8
XFILLER_168_695 VDD VSS sg13g2_decap_8
Xinput17 input17/X input17/A VDD VSS sg13g2_buf_1
XFILLER_183_632 VDD VSS sg13g2_decap_4
Xinput28 input28/X input28/A VDD VSS sg13g2_buf_1
X_13313_ _13316_/C _07691_/Y _07677_/B _13312_/Y VDD VSS sg13g2_a21oi_1
X_14336__1866 _14336_/RESET_B VDD VSS sg13g2_tiehi
X_10525_ _10525_/Y _10564_/D _10531_/D _10626_/B VDD VSS sg13g2_o21ai_1
XFILLER_13_1341 VDD VSS sg13g2_decap_8
XFILLER_155_345 VDD VSS sg13g2_decap_4
X_14293_ _14293_/Q _14677_/CLK _14293_/D _14293_/RESET_B VDD VSS sg13g2_dfrbpq_1
XFILLER_6_333 VDD VSS sg13g2_decap_8
XFILLER_183_665 VDD VSS sg13g2_decap_8
XFILLER_155_367 VDD VSS sg13g2_decap_8
XFILLER_115_209 VDD VSS sg13g2_decap_8
XFILLER_157_1109 VDD VSS sg13g2_decap_8
X_13244_ _13247_/B _13232_/A _13244_/B _13246_/C VDD VSS sg13g2_nand3b_1
XFILLER_7_889 VDD VSS sg13g2_decap_8
X_10456_ _14841_/D _14841_/Q _10453_/X _10455_/Y VDD VSS sg13g2_a21oi_1
XFILLER_171_849 VDD VSS sg13g2_decap_8
XFILLER_100_1355 VDD VSS sg13g2_fill_1
XFILLER_182_186 VDD VSS sg13g2_decap_8
XFILLER_170_337 VDD VSS sg13g2_decap_8
XFILLER_184_51 VDD VSS sg13g2_decap_8
XFILLER_48_1426 VDD VSS sg13g2_decap_8
XFILLER_108_294 VDD VSS sg13g2_decap_8
XFILLER_174_1434 VDD VSS sg13g2_decap_8
X_13175_ _13176_/C _13157_/A _13670_/Q _13145_/A _13169_/Y _13174_/Y VDD VSS sg13g2_a221oi_1
X_10387_ _10387_/X _14818_/Q _14819_/Q _14820_/Q _10396_/C VDD VSS sg13g2_and4_1
X_12126_ _12149_/A _12126_/A _12128_/A VDD VSS sg13g2_nand2_1
XFILLER_123_264 VDD VSS sg13g2_decap_8
XFILLER_135_1429 VDD VSS sg13g2_decap_4
X_14551__1651 _14551_/RESET_B VDD VSS sg13g2_tiehi
XFILLER_96_104 VDD VSS sg13g2_fill_2
X_12057_ _12062_/A _11778_/A _11778_/B _12056_/X VDD VSS sg13g2_o21ai_1
X_15223__3014 _15223_/RESET_B VDD VSS sg13g2_tiehi
XFILLER_46_1183 VDD VSS sg13g2_decap_8
XFILLER_42_1014 VDD VSS sg13g2_fill_1
XFILLER_77_340 VDD VSS sg13g2_decap_8
XFILLER_133_1153 VDD VSS sg13g2_decap_8
X_11008_ _11010_/B _10974_/Y _10989_/Y _10988_/Y VDD VSS sg13g2_a21o_1
XFILLER_81_1096 VDD VSS sg13g2_decap_8
XFILLER_93_822 VDD VSS sg13g2_decap_8
X_16865_ _16865_/X _16865_/A VDD VSS sg13g2_buf_1
XFILLER_38_749 VDD VSS sg13g2_decap_8
XFILLER_20_1312 VDD VSS sg13g2_decap_8
XFILLER_168_1216 VDD VSS sg13g2_decap_8
XFILLER_65_568 VDD VSS sg13g2_fill_2
X_13824__2378 _13824_/RESET_B VDD VSS sg13g2_tiehi
XFILLER_93_899 VDD VSS sg13g2_decap_8
XFILLER_92_398 VDD VSS sg13g2_decap_8
XFILLER_20_1389 VDD VSS sg13g2_decap_8
X_12959_ _12959_/X _14903_/Q _13684_/Q _12945_/Y VDD VSS sg13g2_a21o_1
XFILLER_46_793 VDD VSS sg13g2_fill_2
X_14848__2871 _14848_/RESET_B VDD VSS sg13g2_tiehi
XFILLER_94_1468 VDD VSS sg13g2_decap_8
XFILLER_55_1419 VDD VSS sg13g2_decap_8
XFILLER_178_415 VDD VSS sg13g2_fill_1
XFILLER_60_251 VDD VSS sg13g2_fill_2
XFILLER_178_437 VDD VSS sg13g2_decap_8
XFILLER_181_1449 VDD VSS sg13g2_decap_8
XFILLER_34_999 VDD VSS sg13g2_decap_8
XFILLER_53_1110 VDD VSS sg13g2_fill_1
X_14629_ _14629_/Q _14725_/CLK _14629_/D _14629_/RESET_B VDD VSS sg13g2_dfrbpq_1
XFILLER_18_1252 VDD VSS sg13g2_decap_8
XFILLER_53_1132 VDD VSS sg13g2_decap_8
XFILLER_20_126 VDD VSS sg13g2_decap_8
XFILLER_165_109 VDD VSS sg13g2_decap_8
X_08150_ _08150_/X _08013_/X _08146_/A _08397_/B _08011_/X _08452_/D _08244_/B VDD
+ VSS sg13g2_mux4_1
XFILLER_20_159 VDD VSS sg13g2_decap_8
XFILLER_147_835 VDD VSS sg13g2_fill_2
XFILLER_174_621 VDD VSS sg13g2_decap_8
XFILLER_14_1149 VDD VSS sg13g2_decap_8
XFILLER_179_1323 VDD VSS sg13g2_decap_8
X_08081_ _08081_/X _08934_/A1 _08012_/B _12203_/A _12229_/A _08046_/B _08084_/S1 VDD
+ VSS sg13g2_mux4_1
XFILLER_9_182 VDD VSS sg13g2_decap_8
XFILLER_146_345 VDD VSS sg13g2_fill_2
XFILLER_146_367 VDD VSS sg13g2_decap_8
XFILLER_61_0 VDD VSS sg13g2_decap_8
XFILLER_175_1209 VDD VSS sg13g2_decap_8
XFILLER_173_175 VDD VSS sg13g2_decap_8
XFILLER_162_849 VDD VSS sg13g2_decap_8
XFILLER_161_359 VDD VSS sg13g2_decap_8
XFILLER_114_253 VDD VSS sg13g2_decap_8
XFILLER_115_787 VDD VSS sg13g2_decap_8
X_08983_ _08983_/X _09031_/A _08980_/X _08982_/Y VDD VSS sg13g2_a21o_1
XFILLER_102_437 VDD VSS sg13g2_decap_4
XFILLER_87_126 VDD VSS sg13g2_decap_8
XFILLER_25_1201 VDD VSS sg13g2_decap_8
X_07934_ _07934_/Y _08351_/B _08362_/A2 VDD VSS sg13g2_nor2b_1
XFILLER_60_1114 VDD VSS sg13g2_fill_1
XFILLER_84_822 VDD VSS sg13g2_decap_8
X_07865_ _07867_/D _08641_/A _08641_/B _08641_/C _08641_/D VDD VSS sg13g2_nand4_1
XFILLER_25_1278 VDD VSS sg13g2_decap_8
XFILLER_99_1335 VDD VSS sg13g2_decap_8
XFILLER_84_844 VDD VSS sg13g2_fill_2
XFILLER_28_226 VDD VSS sg13g2_decap_8
XFILLER_112_1248 VDD VSS sg13g2_decap_8
XFILLER_56_546 VDD VSS sg13g2_decap_8
X_09604_ _14201_/D _14201_/Q _09969_/A1 _09604_/S VDD VSS sg13g2_mux2_1
X_07796_ _07796_/Y _07796_/A _07796_/B _07797_/D VDD VSS sg13g2_nor3_1
XFILLER_84_888 VDD VSS sg13g2_fill_1
X_14414__1788 _14414_/RESET_B VDD VSS sg13g2_tiehi
X_09535_ _14134_/D _09966_/A1 _14134_/Q _09539_/S VDD VSS sg13g2_mux2_1
XFILLER_71_549 VDD VSS sg13g2_decap_8
XFILLER_3_1096 VDD VSS sg13g2_decap_8
XFILLER_25_955 VDD VSS sg13g2_decap_8
XFILLER_52_741 VDD VSS sg13g2_decap_8
XFILLER_24_432 VDD VSS sg13g2_decap_8
X_09466_ _14067_/D _10162_/A1 _14067_/Q _09471_/S VDD VSS sg13g2_mux2_1
XFILLER_58_1076 VDD VSS sg13g2_fill_2
XFILLER_12_605 VDD VSS sg13g2_decap_8
XFILLER_52_785 VDD VSS sg13g2_decap_4
XFILLER_40_936 VDD VSS sg13g2_decap_8
X_08417_ _08417_/Y _08418_/B _08417_/B VDD VSS sg13g2_nand2_1
X_09397_ _14000_/D _09463_/A0 _14000_/Q _09397_/S VDD VSS sg13g2_mux2_1
XFILLER_36_1341 VDD VSS sg13g2_decap_8
X_14593__1609 _14593_/RESET_B VDD VSS sg13g2_tiehi
XFILLER_11_137 VDD VSS sg13g2_decap_8
X_13979__2223 _13979_/RESET_B VDD VSS sg13g2_tiehi
XFILLER_71_1243 VDD VSS sg13g2_decap_8
XFILLER_162_1360 VDD VSS sg13g2_decap_8
XFILLER_149_150 VDD VSS sg13g2_decap_8
X_08348_ _08348_/Y _07786_/A _08351_/B _08369_/B VDD VSS sg13g2_a21oi_1
XFILLER_165_610 VDD VSS sg13g2_decap_8
XFILLER_184_429 VDD VSS sg13g2_decap_8
XFILLER_7_119 VDD VSS sg13g2_decap_8
X_08279_ _08279_/X _08279_/A _08511_/S VDD VSS sg13g2_and2_1
XFILLER_165_665 VDD VSS sg13g2_decap_8
XFILLER_118_4 VDD VSS sg13g2_decap_8
X_10310_ _10327_/C _14796_/Q _14797_/Q VDD VSS sg13g2_and2_1
XFILLER_22_99 VDD VSS sg13g2_decap_8
XFILLER_165_698 VDD VSS sg13g2_decap_8
X_11290_ _11338_/A _11290_/A _12836_/B VDD VSS sg13g2_nor2_1
XFILLER_4_826 VDD VSS sg13g2_decap_8
XFILLER_164_186 VDD VSS sg13g2_fill_2
XFILLER_69_1150 VDD VSS sg13g2_decap_8
XFILLER_118_592 VDD VSS sg13g2_fill_2
XFILLER_152_337 VDD VSS sg13g2_fill_2
XFILLER_106_743 VDD VSS sg13g2_decap_8
X_10241_ _10241_/Y _14775_/Q _10247_/D _10343_/C VDD VSS sg13g2_o21ai_1
XFILLER_65_1003 VDD VSS sg13g2_decap_8
XFILLER_156_1120 VDD VSS sg13g2_decap_8
XFILLER_180_668 VDD VSS sg13g2_decap_8
XFILLER_3_347 VDD VSS sg13g2_decap_8
XFILLER_180_679 VDD VSS sg13g2_fill_2
XFILLER_133_551 VDD VSS sg13g2_decap_8
XFILLER_154_21 VDD VSS sg13g2_decap_8
XFILLER_105_264 VDD VSS sg13g2_decap_8
XFILLER_133_584 VDD VSS sg13g2_decap_8
X_10172_ _10185_/B _13328_/A _14766_/Q _10172_/C _13600_/A VDD VSS sg13g2_or4_1
XFILLER_26_1009 VDD VSS sg13g2_decap_4
XFILLER_78_115 VDD VSS sg13g2_decap_8
Xfanout1104 _08048_/B _12298_/A VDD VSS sg13g2_buf_1
XFILLER_79_649 VDD VSS sg13g2_decap_8
XFILLER_65_1069 VDD VSS sg13g2_decap_8
XFILLER_152_1028 VDD VSS sg13g2_decap_8
Xfanout1115 _07853_/B _08934_/A1 VDD VSS sg13g2_buf_1
XFILLER_43_1301 VDD VSS sg13g2_decap_8
XFILLER_120_234 VDD VSS sg13g2_decap_8
Xfanout1126 _08925_/A1 _14980_/Q VDD VSS sg13g2_buf_1
XFILLER_82_1372 VDD VSS sg13g2_decap_8
X_14980_ _14980_/Q clkload32/A _14980_/D _14980_/RESET_B VDD VSS sg13g2_dfrbpq_1
Xfanout1137 _08470_/B _08909_/A1 VDD VSS sg13g2_buf_1
XFILLER_78_159 VDD VSS sg13g2_decap_8
Xfanout150 _09969_/A1 _09936_/A1 VDD VSS sg13g2_buf_1
Xfanout1148 _11770_/A _14973_/Q VDD VSS sg13g2_buf_1
Xfanout161 _09635_/A0 _09145_/Y VDD VSS sg13g2_buf_1
Xfanout1159 _08306_/C _08362_/A3 VDD VSS sg13g2_buf_1
Xfanout172 _10163_/A1 _09931_/A1 VDD VSS sg13g2_buf_1
XFILLER_59_362 VDD VSS sg13g2_decap_8
X_13931_ _13931_/Q clkload11/A _13931_/D _13931_/RESET_B VDD VSS sg13g2_dfrbpq_1
Xfanout183 _09929_/A1 _09830_/A0 VDD VSS sg13g2_buf_1
Xfanout194 _09827_/A0 _09594_/A1 VDD VSS sg13g2_buf_1
XFILLER_43_1378 VDD VSS sg13g2_decap_8
XFILLER_78_1408 VDD VSS sg13g2_decap_8
XFILLER_170_53 VDD VSS sg13g2_decap_8
X_15199__2764 _15199_/RESET_B VDD VSS sg13g2_tiehi
X_13862_ _13862_/Q clkload51/A _13862_/D _13862_/RESET_B VDD VSS sg13g2_dfrbpq_1
XFILLER_90_803 VDD VSS sg13g2_decap_8
X_12813_ _12813_/X _12866_/A _12866_/B _12899_/C input21/X VDD VSS sg13g2_and4_1
XFILLER_74_387 VDD VSS sg13g2_fill_2
XFILLER_76_1121 VDD VSS sg13g2_decap_8
X_13793_ _13793_/Q clkload10/A _13793_/D _13793_/RESET_B VDD VSS sg13g2_dfrbpq_1
XFILLER_27_292 VDD VSS sg13g2_fill_1
X_12744_ _12744_/X _14391_/Q _14423_/Q _14487_/Q _14519_/Q _12756_/S0 _12756_/S1 VDD
+ VSS sg13g2_mux4_1
XFILLER_31_925 VDD VSS sg13g2_decap_8
XFILLER_72_1029 VDD VSS sg13g2_fill_2
XFILLER_76_1198 VDD VSS sg13g2_decap_8
XFILLER_54_1430 VDD VSS sg13g2_decap_8
XFILLER_128_1288 VDD VSS sg13g2_fill_1
X_12675_ _12675_/X _13970_/Q _14002_/Q _14034_/Q _14066_/Q _12675_/S0 _12675_/S1 VDD
+ VSS sg13g2_mux4_1
XFILLER_179_95 VDD VSS sg13g2_decap_8
X_14414_ _14414_/Q clkload50/A _14414_/D _14414_/RESET_B VDD VSS sg13g2_dfrbpq_1
X_14569__1633 _14569_/RESET_B VDD VSS sg13g2_tiehi
XFILLER_15_1425 VDD VSS sg13g2_decap_8
X_11626_ _11626_/Y _11606_/Y _11608_/X _11765_/A VDD VSS sg13g2_o21ai_1
XFILLER_8_46 VDD VSS sg13g2_decap_8
XFILLER_30_468 VDD VSS sg13g2_decap_4
XFILLER_50_1316 VDD VSS sg13g2_decap_8
XFILLER_128_323 VDD VSS sg13g2_fill_2
XFILLER_102_1417 VDD VSS sg13g2_decap_8
XFILLER_141_1466 VDD VSS sg13g2_decap_4
X_14345_ _14345_/Q clkload28/A _14345_/D _14345_/RESET_B VDD VSS sg13g2_dfrbpq_1
XFILLER_144_805 VDD VSS sg13g2_decap_8
X_11557_ _11557_/Y _11533_/Y _11535_/Y _11901_/B1 VDD VSS sg13g2_a21oi_1
XFILLER_6_130 VDD VSS sg13g2_decap_8
XFILLER_116_507 VDD VSS sg13g2_decap_8
XFILLER_183_473 VDD VSS sg13g2_decap_8
XFILLER_184_996 VDD VSS sg13g2_decap_8
XFILLER_143_315 VDD VSS sg13g2_decap_8
XFILLER_144_838 VDD VSS sg13g2_decap_8
X_10508_ _10509_/D _14851_/Q _14850_/Q _10508_/C VDD VSS sg13g2_nand3_1
X_14276_ _14276_/Q clkload49/A _14276_/D _14276_/RESET_B VDD VSS sg13g2_dfrbpq_1
X_11488_ _11488_/X _14242_/Q _14274_/Q _14306_/Q _14338_/Q _11649_/S0 _11649_/S1 VDD
+ VSS sg13g2_mux4_1
XFILLER_7_686 VDD VSS sg13g2_decap_8
XFILLER_170_123 VDD VSS sg13g2_decap_8
X_13227_ _13228_/C _14921_/Q _13666_/Q _13199_/X VDD VSS sg13g2_o21ai_1
X_10439_ _10459_/B _14836_/Q _14835_/Q _14834_/Q _14833_/Q VDD VSS sg13g2_nand4_1
XFILLER_48_1223 VDD VSS sg13g2_decap_8
XFILLER_124_551 VDD VSS sg13g2_decap_4
XFILLER_170_156 VDD VSS sg13g2_decap_4
XFILLER_174_1231 VDD VSS sg13g2_decap_8
XFILLER_87_1294 VDD VSS sg13g2_decap_8
X_13158_ _13160_/C _13174_/A _13158_/B _13170_/D VDD VSS sg13g2_nand3_1
XFILLER_83_1158 VDD VSS sg13g2_decap_8
XFILLER_111_223 VDD VSS sg13g2_fill_2
XFILLER_33_4 VDD VSS sg13g2_decap_8
X_12109_ _12109_/Y _12090_/A _13844_/Q VDD VSS sg13g2_nand2b_1
X_13089_ _13112_/A _14912_/Q _13675_/Q VDD VSS sg13g2_xnor2_1
XFILLER_97_479 VDD VSS sg13g2_decap_8
XFILLER_66_822 VDD VSS sg13g2_fill_2
XFILLER_61_1456 VDD VSS sg13g2_decap_8
XFILLER_84_129 VDD VSS sg13g2_decap_8
XFILLER_78_693 VDD VSS sg13g2_fill_1
X_07650_ _10818_/A _15122_/Q VDD VSS sg13g2_inv_1
XFILLER_38_557 VDD VSS sg13g2_fill_1
XFILLER_65_376 VDD VSS sg13g2_decap_8
XFILLER_4_1372 VDD VSS sg13g2_decap_8
XFILLER_80_313 VDD VSS sg13g2_decap_8
XFILLER_111_1281 VDD VSS sg13g2_decap_8
XFILLER_0_1247 VDD VSS sg13g2_decap_8
XFILLER_111_1292 VDD VSS sg13g2_fill_2
XFILLER_59_1352 VDD VSS sg13g2_decap_8
XFILLER_20_1186 VDD VSS sg13g2_decap_8
X_09320_ _13927_/D _09720_/A0 _13927_/Q _09329_/S VDD VSS sg13g2_mux2_1
XFILLER_22_903 VDD VSS sg13g2_fill_1
XFILLER_80_368 VDD VSS sg13g2_decap_8
XFILLER_55_1216 VDD VSS sg13g2_decap_8
XFILLER_61_560 VDD VSS sg13g2_fill_1
XFILLER_146_1355 VDD VSS sg13g2_fill_1
XFILLER_181_1246 VDD VSS sg13g2_decap_8
X_09251_ _13860_/D _13860_/Q _10080_/A0 _09259_/S VDD VSS sg13g2_mux2_1
XFILLER_61_593 VDD VSS sg13g2_decap_8
X_08202_ _08211_/D _08256_/B _08198_/X _08201_/Y VDD VSS sg13g2_o21ai_1
X_09182_ _13798_/D _13798_/Q _10149_/A1 _09196_/S VDD VSS sg13g2_mux2_1
X_08133_ _08133_/X _08142_/C _07910_/B _07912_/B _07888_/B _07884_/A _08023_/A VDD
+ VSS sg13g2_mux4_1
XFILLER_147_654 VDD VSS sg13g2_decap_8
XFILLER_179_1120 VDD VSS sg13g2_decap_8
XFILLER_105_1085 VDD VSS sg13g2_decap_8
X_15054__2538 _15054_/RESET_B VDD VSS sg13g2_tiehi
XFILLER_134_304 VDD VSS sg13g2_fill_2
XFILLER_175_996 VDD VSS sg13g2_decap_4
XFILLER_107_529 VDD VSS sg13g2_decap_8
X_08064_ _08064_/X _08023_/B _08142_/C _07630_/A _07912_/B _08137_/S1 _08151_/S1 VDD
+ VSS sg13g2_mux4_1
XFILLER_161_112 VDD VSS sg13g2_decap_8
XFILLER_175_1006 VDD VSS sg13g2_fill_1
XFILLER_134_348 VDD VSS sg13g2_decap_8
XFILLER_179_1197 VDD VSS sg13g2_decap_8
XFILLER_31_1293 VDD VSS sg13g2_decap_8
XFILLER_66_1312 VDD VSS sg13g2_decap_8
XFILLER_157_1462 VDD VSS sg13g2_decap_8
XFILLER_68_18 VDD VSS sg13g2_fill_2
XFILLER_88_413 VDD VSS sg13g2_fill_1
XFILLER_118_1435 VDD VSS sg13g2_decap_4
XFILLER_130_510 VDD VSS sg13g2_decap_4
XFILLER_142_370 VDD VSS sg13g2_decap_8
XFILLER_130_532 VDD VSS sg13g2_decap_4
XFILLER_153_1337 VDD VSS sg13g2_decap_8
XFILLER_66_1389 VDD VSS sg13g2_decap_8
XFILLER_88_457 VDD VSS sg13g2_decap_8
XFILLER_130_554 VDD VSS sg13g2_decap_8
X_08966_ _08966_/Y _15060_/Q _08969_/C VDD VSS sg13g2_nor2b_1
XFILLER_9_1283 VDD VSS sg13g2_decap_8
XFILLER_57_822 VDD VSS sg13g2_decap_8
X_07917_ _08160_/C _07917_/A _07917_/B _07917_/C VDD VSS sg13g2_nor3_1
XFILLER_69_693 VDD VSS sg13g2_decap_8
X_08897_ _08897_/Y _10697_/C _08977_/C _15038_/Q VDD VSS sg13g2_nand3_1
X_14647__1555 _14647_/RESET_B VDD VSS sg13g2_tiehi
XFILLER_84_652 VDD VSS sg13g2_decap_8
XFILLER_5_1169 VDD VSS sg13g2_decap_8
XFILLER_186_1113 VDD VSS sg13g2_fill_2
X_07848_ _08643_/C _15016_/Q _07850_/B VDD VSS sg13g2_or2_1
XFILLER_56_354 VDD VSS sg13g2_fill_2
XFILLER_29_579 VDD VSS sg13g2_decap_8
XFILLER_99_1187 VDD VSS sg13g2_decap_8
XFILLER_71_302 VDD VSS sg13g2_fill_1
XFILLER_57_899 VDD VSS sg13g2_decap_4
XFILLER_71_324 VDD VSS sg13g2_decap_8
XFILLER_186_1168 VDD VSS sg13g2_decap_8
X_07779_ _07779_/Y _08318_/C _08318_/D VDD VSS sg13g2_nor2_1
XFILLER_17_77 VDD VSS sg13g2_decap_8
XFILLER_72_869 VDD VSS sg13g2_decap_8
X_09518_ _14117_/D _09617_/A0 _14117_/Q _09533_/S VDD VSS sg13g2_mux2_1
X_10790_ _10790_/Y _14924_/Q _11196_/B VDD VSS sg13g2_nand2_1
XFILLER_77_1474 VDD VSS sg13g2_fill_1
XFILLER_13_914 VDD VSS sg13g2_decap_8
XFILLER_24_251 VDD VSS sg13g2_decap_8
XFILLER_38_1447 VDD VSS sg13g2_decap_8
XFILLER_125_1406 VDD VSS sg13g2_decap_4
XFILLER_164_1455 VDD VSS sg13g2_decap_8
XFILLER_24_262 VDD VSS sg13g2_fill_2
XFILLER_12_413 VDD VSS sg13g2_decap_8
X_09449_ _14050_/D _09614_/A0 _14050_/Q _09463_/S VDD VSS sg13g2_mux2_1
XFILLER_33_32 VDD VSS sg13g2_decap_8
X_15015__2595 _15015_/RESET_B VDD VSS sg13g2_tiehi
XFILLER_185_738 VDD VSS sg13g2_decap_8
X_12460_ _12460_/X _14691_/Q _14723_/Q _13763_/Q _13795_/Q _12466_/S0 _12466_/S1 VDD
+ VSS sg13g2_mux4_1
XFILLER_8_417 VDD VSS sg13g2_decap_8
XFILLER_12_479 VDD VSS sg13g2_decap_8
XFILLER_184_226 VDD VSS sg13g2_decap_8
XFILLER_32_1013 VDD VSS sg13g2_decap_8
X_15222__3013 _15222_/RESET_B VDD VSS sg13g2_tiehi
XFILLER_138_643 VDD VSS sg13g2_decap_8
X_11411_ _11411_/Y _11407_/Y _11408_/Y _11410_/Y _11409_/Y _11422_/B VDD VSS sg13g2_a221oi_1
X_12391_ _12391_/X _14558_/Q _14590_/Q _14622_/Q _14654_/Q _12614_/S0 _12614_/S1 VDD
+ VSS sg13g2_mux4_1
XFILLER_125_304 VDD VSS sg13g2_fill_1
X_14130_ _14130_/Q clkload40/A _14130_/D _14130_/RESET_B VDD VSS sg13g2_dfrbpq_1
X_11342_ _11342_/Y _11368_/S0 _13822_/Q VDD VSS sg13g2_nand2b_1
XFILLER_152_101 VDD VSS sg13g2_decap_8
XFILLER_165_484 VDD VSS sg13g2_decap_8
X_15097__2806 _15097_/RESET_B VDD VSS sg13g2_tiehi
XFILLER_4_623 VDD VSS sg13g2_decap_8
XFILLER_10_1344 VDD VSS sg13g2_decap_8
X_14061_ _14061_/Q clkload24/A _14061_/D _14061_/RESET_B VDD VSS sg13g2_dfrbpq_1
X_11273_ _11273_/Y _11273_/A1 _14492_/Q _12184_/B VDD VSS sg13g2_a21oi_1
XFILLER_165_53 VDD VSS sg13g2_decap_8
XFILLER_106_551 VDD VSS sg13g2_decap_8
XFILLER_181_999 VDD VSS sg13g2_fill_1
XFILLER_3_144 VDD VSS sg13g2_decap_8
X_13012_ _13012_/Y _13012_/A _13026_/C VDD VSS sg13g2_nor2_1
X_10224_ _10227_/C _14769_/Q _10219_/X _14770_/Q VDD VSS sg13g2_a21oi_1
XFILLER_84_1456 VDD VSS sg13g2_decap_8
XFILLER_121_521 VDD VSS sg13g2_decap_4
XFILLER_79_446 VDD VSS sg13g2_decap_8
XFILLER_79_457 VDD VSS sg13g2_fill_2
XFILLER_171_1448 VDD VSS sg13g2_decap_8
X_10155_ _14732_/D _14732_/Q _10155_/A1 _10157_/S VDD VSS sg13g2_mux2_1
XFILLER_79_468 VDD VSS sg13g2_decap_8
XFILLER_0_862 VDD VSS sg13g2_decap_8
XFILLER_94_416 VDD VSS sg13g2_fill_2
XFILLER_181_63 VDD VSS sg13g2_decap_8
X_14963_ _14963_/Q clkload56/A _14963_/D _14963_/RESET_B VDD VSS sg13g2_dfrbpq_1
X_10086_ _14666_/D _10086_/A0 _14666_/Q _10090_/S VDD VSS sg13g2_mux2_1
XFILLER_59_181 VDD VSS sg13g2_fill_1
XFILLER_43_1175 VDD VSS sg13g2_decap_8
X_13914_ _13914_/Q _15052_/CLK _13914_/D _13914_/RESET_B VDD VSS sg13g2_dfrbpq_1
XFILLER_169_1322 VDD VSS sg13g2_decap_8
XFILLER_78_1205 VDD VSS sg13g2_decap_8
X_14894_ _14894_/Q clkload86/A _14894_/D _14894_/RESET_B VDD VSS sg13g2_dfrbpq_1
XFILLER_130_1189 VDD VSS sg13g2_decap_8
X_13845_ _13845_/Q clkload36/A _13845_/D _13845_/RESET_B VDD VSS sg13g2_dfrbpq_1
XFILLER_169_1399 VDD VSS sg13g2_decap_8
X_13741__2461 _13741_/RESET_B VDD VSS sg13g2_tiehi
XFILLER_74_94 VDD VSS sg13g2_fill_2
XFILLER_90_677 VDD VSS sg13g2_decap_8
XFILLER_16_774 VDD VSS sg13g2_decap_8
X_13776_ _13776_/Q _14704_/CLK _13776_/D _13776_/RESET_B VDD VSS sg13g2_dfrbpq_1
XFILLER_91_1416 VDD VSS sg13g2_decap_8
X_10988_ _10988_/Y _15116_/Q _10995_/B VDD VSS sg13g2_nor2b_1
XFILLER_43_560 VDD VSS sg13g2_decap_8
XFILLER_71_891 VDD VSS sg13g2_fill_1
X_12727_ _12727_/X _13974_/Q _14006_/Q _14038_/Q _14070_/Q _12731_/S0 _12731_/S1 VDD
+ VSS sg13g2_mux4_1
XFILLER_31_733 VDD VSS sg13g2_decap_4
XFILLER_148_407 VDD VSS sg13g2_decap_8
XFILLER_30_232 VDD VSS sg13g2_decap_8
XFILLER_176_738 VDD VSS sg13g2_fill_1
XFILLER_19_1380 VDD VSS sg13g2_decap_8
XFILLER_15_1222 VDD VSS sg13g2_decap_8
XFILLER_175_226 VDD VSS sg13g2_decap_8
X_12658_ _12658_/X _13841_/Q _13873_/Q _13905_/Q _13937_/Q _12661_/S0 _12661_/S1 VDD
+ VSS sg13g2_mux4_1
X_14085__2117 _14085_/RESET_B VDD VSS sg13g2_tiehi
XFILLER_157_930 VDD VSS sg13g2_decap_8
XFILLER_106_1361 VDD VSS sg13g2_decap_8
XFILLER_12_991 VDD VSS sg13g2_decap_8
X_14121__2081 _14121_/RESET_B VDD VSS sg13g2_tiehi
X_11609_ _11609_/Y _11621_/S0 _14374_/Q VDD VSS sg13g2_nand2b_1
XFILLER_106_1394 VDD VSS sg13g2_decap_8
X_12589_ _12589_/X _14572_/Q _14604_/Q _14636_/Q _14668_/Q _12589_/S0 _12589_/S1 VDD
+ VSS sg13g2_mux4_1
XFILLER_102_1236 VDD VSS sg13g2_decap_8
XFILLER_117_827 VDD VSS sg13g2_decap_8
XFILLER_156_473 VDD VSS sg13g2_decap_8
XFILLER_8_984 VDD VSS sg13g2_decap_8
XFILLER_15_1299 VDD VSS sg13g2_decap_8
X_14328_ _14328_/Q _14745_/CLK _14328_/D _14328_/RESET_B VDD VSS sg13g2_dfrbpq_1
XFILLER_171_410 VDD VSS sg13g2_decap_8
XFILLER_183_270 VDD VSS sg13g2_decap_8
XFILLER_7_483 VDD VSS sg13g2_decap_8
XFILLER_172_955 VDD VSS sg13g2_fill_2
XFILLER_143_134 VDD VSS sg13g2_decap_8
X_14725__1477 _14725_/RESET_B VDD VSS sg13g2_tiehi
XFILLER_132_819 VDD VSS sg13g2_decap_8
XFILLER_176_1359 VDD VSS sg13g2_decap_8
X_14259_ _14259_/Q clkload36/A _14259_/D _14259_/RESET_B VDD VSS sg13g2_dfrbpq_1
XFILLER_131_318 VDD VSS sg13g2_fill_1
XFILLER_171_487 VDD VSS sg13g2_decap_8
XFILLER_97_210 VDD VSS sg13g2_decap_4
XFILLER_124_381 VDD VSS sg13g2_fill_2
Xfanout908 _12717_/S0 fanout915/X VDD VSS sg13g2_buf_1
XFILLER_140_841 VDD VSS sg13g2_decap_4
Xfanout919 _11243_/B _13312_/A VDD VSS sg13g2_buf_1
X_08820_ _08820_/Y _13482_/A _15191_/Q VDD VSS sg13g2_nand2_1
XFILLER_98_766 VDD VSS sg13g2_decap_8
XFILLER_100_716 VDD VSS sg13g2_decap_8
XFILLER_140_885 VDD VSS sg13g2_decap_8
XFILLER_26_1340 VDD VSS sg13g2_decap_8
XFILLER_140_896 VDD VSS sg13g2_fill_1
XFILLER_79_980 VDD VSS sg13g2_decap_8
XFILLER_24_0 VDD VSS sg13g2_decap_8
XFILLER_113_1321 VDD VSS sg13g2_decap_8
XFILLER_152_1370 VDD VSS sg13g2_fill_2
X_08751_ _08751_/Y _08751_/A1 _11288_/A _15193_/Q VDD VSS sg13g2_o21ai_1
XFILLER_61_1253 VDD VSS sg13g2_decap_8
XFILLER_6_1467 VDD VSS sg13g2_fill_2
XFILLER_22_1237 VDD VSS sg13g2_decap_8
X_07702_ _07702_/X _13300_/B _13356_/B VDD VSS sg13g2_and2_1
XFILLER_2_1309 VDD VSS sg13g2_decap_8
X_08682_ _08682_/Y _08678_/Y _08647_/Y _08681_/Y VDD VSS sg13g2_o21ai_1
XFILLER_53_313 VDD VSS sg13g2_fill_2
XFILLER_38_387 VDD VSS sg13g2_decap_8
X_07633_ _08203_/B _14995_/Q VDD VSS sg13g2_inv_1
X_14295__1907 _14295_/RESET_B VDD VSS sg13g2_tiehi
XFILLER_65_195 VDD VSS sg13g2_fill_1
XFILLER_0_1044 VDD VSS sg13g2_decap_8
XFILLER_0_91 VDD VSS sg13g2_decap_8
XFILLER_81_677 VDD VSS sg13g2_fill_1
X_14331__1871 _14331_/RESET_B VDD VSS sg13g2_tiehi
X_09303_ _13911_/D _13911_/Q _10166_/A1 _09304_/S VDD VSS sg13g2_mux2_1
XFILLER_107_1103 VDD VSS sg13g2_decap_8
XFILLER_16_1008 VDD VSS sg13g2_decap_8
XFILLER_10_917 VDD VSS sg13g2_decap_8
XFILLER_139_429 VDD VSS sg13g2_decap_8
XFILLER_142_1027 VDD VSS sg13g2_decap_8
XFILLER_21_243 VDD VSS sg13g2_decap_8
X_09234_ _13845_/D _09899_/A0 _13845_/Q _09238_/S VDD VSS sg13g2_mux2_1
XFILLER_21_254 VDD VSS sg13g2_fill_2
XFILLER_22_799 VDD VSS sg13g2_fill_2
XFILLER_21_287 VDD VSS sg13g2_decap_8
XFILLER_119_120 VDD VSS sg13g2_decap_4
XFILLER_182_708 VDD VSS sg13g2_decap_8
X_09165_ _09165_/Y _09157_/C _09164_/X _14925_/Q _09158_/C VDD VSS sg13g2_a22oi_1
XFILLER_33_1366 VDD VSS sg13g2_decap_8
XFILLER_108_816 VDD VSS sg13g2_decap_8
XFILLER_147_462 VDD VSS sg13g2_decap_8
X_08116_ _08116_/Y _08190_/A _07916_/Y _08115_/Y VDD VSS sg13g2_a21oi_1
XFILLER_119_164 VDD VSS sg13g2_decap_8
XFILLER_147_473 VDD VSS sg13g2_fill_2
X_09096_ _09136_/B _14915_/Q _09103_/C _09103_/D VDD VSS sg13g2_and3_1
XFILLER_174_281 VDD VSS sg13g2_decap_8
XFILLER_135_657 VDD VSS sg13g2_decap_8
X_08047_ _08047_/Y _08046_/B _12229_/A _08046_/Y VDD VSS sg13g2_o21ai_1
XFILLER_79_39 VDD VSS sg13g2_decap_8
XFILLER_102_7 VDD VSS sg13g2_decap_8
XFILLER_163_988 VDD VSS sg13g2_decap_8
XFILLER_134_167 VDD VSS sg13g2_decap_8
XFILLER_89_711 VDD VSS sg13g2_decap_4
XFILLER_66_1131 VDD VSS sg13g2_decap_4
XFILLER_116_893 VDD VSS sg13g2_decap_8
XFILLER_162_498 VDD VSS sg13g2_decap_8
X_13783__2419 _13783_/RESET_B VDD VSS sg13g2_tiehi
XFILLER_27_1104 VDD VSS sg13g2_decap_8
XFILLER_1_637 VDD VSS sg13g2_decap_8
X_14809__2927 _14809_/RESET_B VDD VSS sg13g2_tiehi
XFILLER_89_755 VDD VSS sg13g2_decap_8
XFILLER_131_852 VDD VSS sg13g2_decap_8
Xhold3042 hold3042/X _10211_/Y VDD VSS sg13g2_dlygate4sd3_1
XFILLER_66_1186 VDD VSS sg13g2_decap_8
XFILLER_0_147 VDD VSS sg13g2_decap_8
XFILLER_135_67 VDD VSS sg13g2_decap_8
XFILLER_62_1028 VDD VSS sg13g2_decap_8
XFILLER_114_1107 VDD VSS sg13g2_decap_8
Xhold3053 _15170_/D _13486_/B VDD VSS sg13g2_dlygate4sd3_1
XFILLER_27_1159 VDD VSS sg13g2_decap_8
Xhold3064 input34/A mem_axi_rdata[8] VDD VSS sg13g2_dlygate4sd3_1
X_09998_ _14581_/D _10097_/A0 _14581_/Q _10002_/S VDD VSS sg13g2_mux2_1
XFILLER_88_265 VDD VSS sg13g2_decap_8
Xhold3075 hold3075/X input11/X VDD VSS sg13g2_dlygate4sd3_1
XFILLER_88_276 VDD VSS sg13g2_decap_8
XFILLER_76_416 VDD VSS sg13g2_fill_1
Xhold3086 input7/A mem_axi_rdata[12] VDD VSS sg13g2_dlygate4sd3_1
XFILLER_153_1189 VDD VSS sg13g2_decap_8
Xhold3097 input18/A mem_axi_rdata[22] VDD VSS sg13g2_dlygate4sd3_1
X_08949_ _08949_/Y _08954_/S _14955_/Q VDD VSS sg13g2_nand2_1
XFILLER_44_1473 VDD VSS sg13g2_decap_4
XFILLER_29_321 VDD VSS sg13g2_fill_2
XFILLER_40_1326 VDD VSS sg13g2_decap_8
XFILLER_151_33 VDD VSS sg13g2_decap_4
X_14163__2039 _14163_/RESET_B VDD VSS sg13g2_tiehi
X_11960_ _11960_/Y _11756_/S _14480_/Q VDD VSS sg13g2_nand2b_1
XFILLER_28_65 VDD VSS sg13g2_fill_1
XFILLER_72_600 VDD VSS sg13g2_decap_8
XFILLER_45_825 VDD VSS sg13g2_decap_8
XFILLER_44_302 VDD VSS sg13g2_decap_8
XFILLER_29_387 VDD VSS sg13g2_decap_8
X_10911_ _10911_/Y _10910_/Y _10908_/Y _10907_/Y _07649_/A _11045_/A2 VDD VSS sg13g2_a221oi_1
XFILLER_84_493 VDD VSS sg13g2_decap_8
X_11891_ _11891_/X _11891_/A _11900_/B VDD VSS sg13g2_and2_1
XFILLER_44_357 VDD VSS sg13g2_decap_8
X_13630_ _13738_/D _13630_/A VDD VSS sg13g2_buf_1
X_10842_ _10843_/B _10841_/A _10841_/C _10841_/B VDD VSS sg13g2_o21ai_1
XFILLER_13_700 VDD VSS sg13g2_decap_8
XFILLER_77_1271 VDD VSS sg13g2_decap_8
XFILLER_73_1102 VDD VSS sg13g2_fill_1
XFILLER_72_688 VDD VSS sg13g2_fill_2
XFILLER_32_519 VDD VSS sg13g2_fill_1
XFILLER_73_1113 VDD VSS sg13g2_fill_1
XFILLER_38_1244 VDD VSS sg13g2_decap_8
XFILLER_12_210 VDD VSS sg13g2_decap_8
XFILLER_164_1252 VDD VSS sg13g2_decap_8
X_13561_ _13561_/X _13533_/A _15009_/Q _13561_/S VDD VSS sg13g2_mux2_1
XFILLER_71_198 VDD VSS sg13g2_fill_2
X_10773_ _11164_/A _14951_/Q _08936_/S _10772_/X VDD VSS sg13g2_a21oi_1
XFILLER_73_1157 VDD VSS sg13g2_decap_8
XFILLER_160_1127 VDD VSS sg13g2_fill_1
X_12512_ _12513_/B _13682_/Q _12596_/A2 _12511_/X _12415_/A _12596_/C1 VDD VSS sg13g2_a221oi_1
XFILLER_125_1258 VDD VSS sg13g2_fill_1
X_13492_ _15125_/D _13492_/A VDD VSS sg13g2_inv_1
XFILLER_8_214 VDD VSS sg13g2_decap_8
XFILLER_100_70 VDD VSS sg13g2_decap_8
XFILLER_13_799 VDD VSS sg13g2_fill_2
XFILLER_185_546 VDD VSS sg13g2_decap_8
XFILLER_12_287 VDD VSS sg13g2_decap_8
XFILLER_139_952 VDD VSS sg13g2_fill_2
X_15231_ _15231_/Q clkload22/A _15231_/D _15231_/RESET_B VDD VSS sg13g2_dfrbpq_1
X_12443_ _14995_/D _08203_/B _12651_/C1 _12442_/Y VDD VSS sg13g2_a21oi_1
XFILLER_60_52 VDD VSS sg13g2_decap_8
XFILLER_51_1466 VDD VSS sg13g2_decap_8
XFILLER_51_1477 VDD VSS sg13g2_fill_2
XFILLER_12_1439 VDD VSS sg13g2_decap_8
XFILLER_5_910 VDD VSS sg13g2_decap_8
XFILLER_126_624 VDD VSS sg13g2_decap_8
X_15162_ _15162_/Q _15162_/CLK _15162_/D _15162_/RESET_B VDD VSS sg13g2_dfrbpq_1
XFILLER_60_85 VDD VSS sg13g2_decap_8
XFILLER_126_635 VDD VSS sg13g2_fill_1
XFILLER_176_63 VDD VSS sg13g2_decap_8
X_12374_ _14990_/D _13553_/A1 _13282_/A1 _12373_/Y _12372_/Y VDD VSS sg13g2_a22oi_1
XFILLER_158_1012 VDD VSS sg13g2_decap_8
XFILLER_5_14 VDD VSS sg13g2_decap_8
XFILLER_4_420 VDD VSS sg13g2_decap_8
XFILLER_153_443 VDD VSS sg13g2_decap_8
X_14113_ _14113_/Q clkload6/A _14113_/D _14113_/RESET_B VDD VSS sg13g2_dfrbpq_1
XFILLER_10_1141 VDD VSS sg13g2_decap_8
XFILLER_153_454 VDD VSS sg13g2_decap_4
X_11325_ _11326_/A _11328_/S0 _14205_/Q _12257_/B1 VDD VSS sg13g2_a21oi_1
X_15093_ _15093_/Q clkload70/A _15093_/D _15093_/RESET_B VDD VSS sg13g2_dfrbpq_1
XFILLER_99_519 VDD VSS sg13g2_decap_8
XFILLER_154_999 VDD VSS sg13g2_decap_4
XFILLER_158_1067 VDD VSS sg13g2_fill_2
XFILLER_5_987 VDD VSS sg13g2_decap_8
XFILLER_180_273 VDD VSS sg13g2_decap_8
XFILLER_136_1310 VDD VSS sg13g2_decap_8
X_14044_ _14044_/Q clkload77/A _14044_/D _14044_/RESET_B VDD VSS sg13g2_dfrbpq_1
X_11256_ _11256_/Y _11251_/Y _11252_/Y _12190_/B VDD VSS sg13g2_a21oi_1
XFILLER_175_1370 VDD VSS sg13g2_decap_8
XFILLER_49_1373 VDD VSS sg13g2_decap_8
X_14373__1829 _14373_/RESET_B VDD VSS sg13g2_tiehi
XFILLER_4_497 VDD VSS sg13g2_decap_8
X_13759__2443 _13759_/RESET_B VDD VSS sg13g2_tiehi
XFILLER_84_1275 VDD VSS sg13g2_decap_8
XFILLER_68_906 VDD VSS sg13g2_decap_8
X_10207_ _10207_/Y hold3044/X _07661_/Y _14762_/Q VDD VSS sg13g2_a21oi_1
XFILLER_171_1245 VDD VSS sg13g2_decap_8
X_11187_ _11187_/Y _11171_/B _11181_/A _11197_/B VDD VSS sg13g2_a21oi_1
XFILLER_79_254 VDD VSS sg13g2_decap_8
XFILLER_121_351 VDD VSS sg13g2_decap_4
XFILLER_122_885 VDD VSS sg13g2_decap_4
X_10138_ _14715_/D _14715_/Q _10138_/A1 _10169_/S VDD VSS sg13g2_mux2_1
XFILLER_95_747 VDD VSS sg13g2_decap_8
XFILLER_48_630 VDD VSS sg13g2_decap_8
X_14946_ _14946_/Q clkload69/A _14946_/D _14946_/RESET_B VDD VSS sg13g2_dfrbpq_1
X_10069_ _14650_/D _10102_/A0 _14650_/Q _10069_/S VDD VSS sg13g2_mux2_1
XFILLER_47_140 VDD VSS sg13g2_fill_1
XFILLER_48_685 VDD VSS sg13g2_decap_8
X_14139__2063 _14139_/RESET_B VDD VSS sg13g2_tiehi
XFILLER_75_493 VDD VSS sg13g2_decap_4
X_14877_ _14877_/Q clkload83/A _14877_/D _14877_/RESET_B VDD VSS sg13g2_dfrbpq_1
XFILLER_78_1046 VDD VSS sg13g2_decap_8
XFILLER_35_335 VDD VSS sg13g2_decap_8
XFILLER_78_1057 VDD VSS sg13g2_fill_2
XFILLER_21_1281 VDD VSS sg13g2_decap_8
X_13662__2571 _13662_/RESET_B VDD VSS sg13g2_tiehi
XFILLER_169_1196 VDD VSS sg13g2_decap_8
X_13828_ _13828_/Q clkload49/A _13828_/D _13828_/RESET_B VDD VSS sg13g2_dfrbpq_1
XFILLER_62_154 VDD VSS sg13g2_fill_2
XFILLER_91_997 VDD VSS sg13g2_decap_4
XFILLER_56_1311 VDD VSS sg13g2_decap_8
XFILLER_51_828 VDD VSS sg13g2_decap_8
XFILLER_1_1386 VDD VSS sg13g2_decap_8
XFILLER_182_1341 VDD VSS sg13g2_decap_8
XFILLER_147_1461 VDD VSS sg13g2_decap_8
X_13759_ _13759_/Q clkload51/A _13759_/D _13759_/RESET_B VDD VSS sg13g2_dfrbpq_1
XFILLER_108_1434 VDD VSS sg13g2_decap_8
XFILLER_91_1246 VDD VSS sg13g2_fill_2
XFILLER_31_541 VDD VSS sg13g2_decap_8
XFILLER_56_1388 VDD VSS sg13g2_decap_8
XFILLER_31_552 VDD VSS sg13g2_decap_8
XFILLER_91_1279 VDD VSS sg13g2_decap_8
XFILLER_176_535 VDD VSS sg13g2_decap_4
X_14913__2741 _14913_/RESET_B VDD VSS sg13g2_tiehi
XFILLER_143_1369 VDD VSS sg13g2_decap_8
XFILLER_176_568 VDD VSS sg13g2_decap_8
XFILLER_157_760 VDD VSS sg13g2_decap_8
XFILLER_157_771 VDD VSS sg13g2_fill_1
XFILLER_89_1120 VDD VSS sg13g2_decap_8
XFILLER_102_1022 VDD VSS sg13g2_fill_1
XFILLER_141_1071 VDD VSS sg13g2_decap_8
XFILLER_117_635 VDD VSS sg13g2_decap_8
XFILLER_145_944 VDD VSS sg13g2_fill_2
XFILLER_15_1096 VDD VSS sg13g2_decap_8
XFILLER_8_781 VDD VSS sg13g2_decap_8
XFILLER_117_657 VDD VSS sg13g2_decap_8
XFILLER_172_752 VDD VSS sg13g2_decap_8
XFILLER_7_280 VDD VSS sg13g2_decap_8
Xclkbuf_leaf_2_clk_i clkload5/A clkbuf_leaf_2_clk_i/A VDD VSS sg13g2_buf_8
XFILLER_89_1186 VDD VSS sg13g2_fill_1
XFILLER_102_1088 VDD VSS sg13g2_decap_4
X_14946__2675 _14946_/RESET_B VDD VSS sg13g2_tiehi
XFILLER_144_465 VDD VSS sg13g2_decap_4
XFILLER_176_1156 VDD VSS sg13g2_decap_8
X_09921_ _14506_/D _14506_/Q _09921_/A1 _09921_/S VDD VSS sg13g2_mux2_1
XFILLER_67_1451 VDD VSS sg13g2_decap_8
XFILLER_171_284 VDD VSS sg13g2_decap_8
XFILLER_28_1413 VDD VSS sg13g2_decap_8
XFILLER_125_690 VDD VSS sg13g2_decap_8
Xfanout705 _11791_/S _11765_/A VDD VSS sg13g2_buf_1
XFILLER_98_530 VDD VSS sg13g2_decap_8
XFILLER_131_148 VDD VSS sg13g2_decap_8
XFILLER_154_1443 VDD VSS sg13g2_decap_8
X_14349__1853 _14349_/RESET_B VDD VSS sg13g2_tiehi
Xfanout716 _11549_/B fanout719/X VDD VSS sg13g2_buf_1
Xfanout727 _12036_/B _12290_/S0 VDD VSS sg13g2_buf_1
X_09852_ _14439_/D _14439_/Q _10083_/A0 _09858_/S VDD VSS sg13g2_mux2_1
XFILLER_63_1337 VDD VSS sg13g2_decap_8
Xfanout738 _11894_/B _11355_/B1 VDD VSS sg13g2_buf_1
Xfanout749 _08723_/B _13412_/C VDD VSS sg13g2_buf_1
XFILLER_59_939 VDD VSS sg13g2_decap_4
X_08803_ _08805_/A _10898_/B1 _14753_/Q _08727_/X _15196_/Q _13392_/A2 VDD VSS sg13g2_a221oi_1
XFILLER_112_384 VDD VSS sg13g2_decap_4
X_09783_ _14372_/D _09882_/A0 _14372_/Q _09789_/S VDD VSS sg13g2_mux2_1
XFILLER_85_235 VDD VSS sg13g2_decap_4
XFILLER_58_449 VDD VSS sg13g2_decap_8
X_15221__3012 _15221_/RESET_B VDD VSS sg13g2_tiehi
X_08734_ _08734_/Y _13663_/Q _13507_/B VDD VSS sg13g2_nor2_1
XFILLER_6_1264 VDD VSS sg13g2_decap_8
XFILLER_61_1083 VDD VSS sg13g2_decap_8
XFILLER_2_1106 VDD VSS sg13g2_decap_8
XFILLER_113_1173 VDD VSS sg13g2_decap_8
XFILLER_94_780 VDD VSS sg13g2_decap_8
XFILLER_26_313 VDD VSS sg13g2_decap_8
X_15124__2734 _15124_/RESET_B VDD VSS sg13g2_tiehi
X_08665_ _08666_/B _08663_/X _08662_/Y _08678_/B _08664_/Y VDD VSS sg13g2_a22oi_1
XFILLER_82_953 VDD VSS sg13g2_decap_4
XFILLER_121_36 VDD VSS sg13g2_decap_8
XFILLER_42_806 VDD VSS sg13g2_fill_1
XFILLER_26_357 VDD VSS sg13g2_fill_1
XFILLER_121_47 VDD VSS sg13g2_fill_1
XFILLER_183_1127 VDD VSS sg13g2_decap_8
X_07616_ _07616_/Y _14944_/Q VDD VSS sg13g2_inv_1
XFILLER_81_463 VDD VSS sg13g2_decap_8
XFILLER_26_379 VDD VSS sg13g2_decap_8
X_08596_ _15243_/D _08596_/A _08596_/B _08596_/C _08596_/D VDD VSS sg13g2_nand4_1
XFILLER_148_1269 VDD VSS sg13g2_decap_8
XFILLER_74_1422 VDD VSS sg13g2_decap_8
XFILLER_54_699 VDD VSS sg13g2_decap_8
XFILLER_70_1308 VDD VSS sg13g2_decap_8
XFILLER_161_1436 VDD VSS sg13g2_decap_8
XFILLER_10_714 VDD VSS sg13g2_decap_8
XFILLER_14_56 VDD VSS sg13g2_decap_8
X_13837__2365 _13837_/RESET_B VDD VSS sg13g2_tiehi
XFILLER_155_708 VDD VSS sg13g2_decap_4
X_09217_ _13828_/D _10080_/A0 _13828_/Q _09225_/S VDD VSS sg13g2_mux2_1
XFILLER_6_718 VDD VSS sg13g2_decap_8
XFILLER_33_1163 VDD VSS sg13g2_decap_8
XFILLER_107_101 VDD VSS sg13g2_decap_8
XFILLER_108_624 VDD VSS sg13g2_decap_8
XFILLER_135_410 VDD VSS sg13g2_decap_8
X_09148_ _09148_/Y _09161_/S _15050_/Q _09147_/Y VDD VSS sg13g2_o21ai_1
XFILLER_5_217 VDD VSS sg13g2_decap_8
XFILLER_30_11 VDD VSS sg13g2_decap_8
XFILLER_136_966 VDD VSS sg13g2_decap_8
XFILLER_159_1332 VDD VSS sg13g2_decap_8
XFILLER_11_1450 VDD VSS sg13g2_decap_8
XFILLER_146_22 VDD VSS sg13g2_decap_8
X_09079_ _09079_/Y _09078_/B _15040_/Q _09078_/Y VDD VSS sg13g2_o21ai_1
XFILLER_68_1237 VDD VSS sg13g2_decap_8
XFILLER_123_605 VDD VSS sg13g2_fill_2
XFILLER_163_774 VDD VSS sg13g2_fill_2
XFILLER_107_167 VDD VSS sg13g2_decap_8
XFILLER_120_1199 VDD VSS sg13g2_decap_8
XFILLER_151_925 VDD VSS sg13g2_decap_8
X_11110_ _11110_/Y _11106_/Y _11104_/Y _11109_/Y VDD VSS sg13g2_a21oi_1
XFILLER_2_924 VDD VSS sg13g2_decap_8
X_12090_ _12091_/B _12090_/A _14228_/Q VDD VSS sg13g2_nand2_1
XFILLER_162_295 VDD VSS sg13g2_decap_8
XFILLER_146_88 VDD VSS sg13g2_decap_8
XFILLER_1_434 VDD VSS sg13g2_decap_8
XFILLER_89_541 VDD VSS sg13g2_decap_8
X_11041_ _11068_/A _11052_/A _11052_/B _11052_/D VDD VSS sg13g2_nor3_1
XFILLER_81_1426 VDD VSS sg13g2_decap_8
XFILLER_104_885 VDD VSS sg13g2_decap_8
XFILLER_77_725 VDD VSS sg13g2_fill_1
XFILLER_162_32 VDD VSS sg13g2_decap_8
XFILLER_77_736 VDD VSS sg13g2_decap_8
XFILLER_76_224 VDD VSS sg13g2_decap_8
XFILLER_65_909 VDD VSS sg13g2_decap_8
XFILLER_44_1270 VDD VSS sg13g2_decap_8
X_14800_ _14800_/Q clkload65/A _14800_/D _14800_/RESET_B VDD VSS sg13g2_dfrbpq_1
XFILLER_18_803 VDD VSS sg13g2_decap_8
X_12992_ _12994_/A _12993_/B _12993_/C VDD VSS sg13g2_nand2_1
XFILLER_92_739 VDD VSS sg13g2_decap_8
XFILLER_45_611 VDD VSS sg13g2_decap_8
XFILLER_176_0 VDD VSS sg13g2_decap_8
X_14731_ _14731_/Q clkload12/A _14731_/D _14731_/RESET_B VDD VSS sg13g2_dfrbpq_1
X_11943_ _11943_/Y _11969_/A _14224_/Q _11967_/B VDD VSS sg13g2_a21oi_1
XFILLER_45_655 VDD VSS sg13g2_fill_1
XFILLER_166_1325 VDD VSS sg13g2_decap_8
XFILLER_17_357 VDD VSS sg13g2_fill_2
XFILLER_79_1388 VDD VSS sg13g2_decap_8
XFILLER_55_74 VDD VSS sg13g2_decap_8
X_14662_ _14662_/Q clkload51/A _14662_/D _14662_/RESET_B VDD VSS sg13g2_dfrbpq_1
X_11874_ _11875_/A _14702_/Q _14734_/Q _13774_/Q _13806_/Q _11890_/S0 _11742_/C VDD
+ VSS sg13g2_mux4_1
XFILLER_32_316 VDD VSS sg13g2_decap_8
X_13613_ _13613_/Y _13613_/A _13613_/B _13613_/C _13613_/D VDD VSS sg13g2_nor4_1
X_10825_ _14928_/D hold3175/X _10862_/B _10824_/Y VDD VSS sg13g2_a21o_1
XFILLER_44_198 VDD VSS sg13g2_decap_8
XFILLER_125_1000 VDD VSS sg13g2_fill_1
X_14593_ _14593_/Q clkload10/A _14593_/D _14593_/RESET_B VDD VSS sg13g2_dfrbpq_1
XFILLER_125_1033 VDD VSS sg13g2_decap_8
XFILLER_186_833 VDD VSS sg13g2_decap_8
X_13544_ _15146_/D _13554_/S _13542_/Y _13543_/Y VDD VSS sg13g2_a21oi_1
X_10756_ _14916_/D _10756_/A VDD VSS sg13g2_inv_1
XFILLER_13_585 VDD VSS sg13g2_decap_8
XFILLER_185_343 VDD VSS sg13g2_decap_8
X_14427__1775 _14427_/RESET_B VDD VSS sg13g2_tiehi
XFILLER_40_382 VDD VSS sg13g2_fill_2
XFILLER_71_95 VDD VSS sg13g2_decap_8
X_13475_ _15178_/D hold3073/X _15178_/Q _13477_/S VDD VSS sg13g2_mux2_1
XFILLER_9_567 VDD VSS sg13g2_decap_8
XFILLER_16_1372 VDD VSS sg13g2_decap_8
X_10687_ _10876_/A _08992_/B _08852_/A _08852_/Y VDD VSS sg13g2_a21oi_1
XFILLER_173_527 VDD VSS sg13g2_decap_8
XFILLER_51_1263 VDD VSS sg13g2_decap_8
X_15214_ _15214_/Q _15214_/CLK _15214_/D _15214_/RESET_B VDD VSS sg13g2_dfrbpq_1
XFILLER_103_1342 VDD VSS sg13g2_decap_8
XFILLER_127_933 VDD VSS sg13g2_fill_1
XFILLER_145_229 VDD VSS sg13g2_decap_8
X_12426_ _12426_/X _12423_/X _12422_/X _12419_/X _12418_/X _12705_/S0 _12609_/S VDD
+ VSS sg13g2_mux4_1
XFILLER_12_1236 VDD VSS sg13g2_decap_8
XFILLER_127_955 VDD VSS sg13g2_fill_1
XFILLER_126_432 VDD VSS sg13g2_fill_2
XFILLER_177_1443 VDD VSS sg13g2_decap_8
X_15145_ _15145_/Q clkload34/A _15145_/D _15145_/RESET_B VDD VSS sg13g2_dfrbpq_1
XFILLER_138_1405 VDD VSS sg13g2_fill_2
X_12357_ _12358_/B _12348_/A _15126_/Q VDD VSS sg13g2_nand2b_1
XFILLER_5_784 VDD VSS sg13g2_decap_8
X_11308_ _11308_/Y _11310_/A1 _14077_/Q _11328_/S1 VDD VSS sg13g2_a21oi_1
X_14642__1560 _14642_/RESET_B VDD VSS sg13g2_tiehi
X_15076_ _15076_/Q clkload71/A _15076_/D _15076_/RESET_B VDD VSS sg13g2_dfrbpq_1
X_12288_ _12288_/X _14265_/Q _14297_/Q _14329_/Q _14361_/Q _12288_/S0 _12288_/S1 VDD
+ VSS sg13g2_mux4_1
XFILLER_113_137 VDD VSS sg13g2_decap_4
XFILLER_4_294 VDD VSS sg13g2_decap_8
XFILLER_49_1170 VDD VSS sg13g2_decap_8
X_14027_ _14027_/Q _14665_/CLK _14027_/D _14027_/RESET_B VDD VSS sg13g2_dfrbpq_1
XFILLER_84_1072 VDD VSS sg13g2_decap_8
X_11239_ _11239_/Y _12799_/A _15123_/Q _07684_/B VDD VSS sg13g2_o21ai_1
XFILLER_95_500 VDD VSS sg13g2_fill_2
XFILLER_171_1042 VDD VSS sg13g2_fill_2
XFILLER_67_202 VDD VSS sg13g2_decap_8
XFILLER_150_991 VDD VSS sg13g2_decap_4
XFILLER_171_1064 VDD VSS sg13g2_decap_8
XFILLER_45_1067 VDD VSS sg13g2_decap_8
XFILLER_110_844 VDD VSS sg13g2_decap_8
XFILLER_45_1078 VDD VSS sg13g2_fill_1
XFILLER_95_544 VDD VSS sg13g2_decap_8
XFILLER_132_1059 VDD VSS sg13g2_fill_1
XFILLER_23_1332 VDD VSS sg13g2_decap_8
XFILLER_3_1404 VDD VSS sg13g2_decap_8
XFILLER_55_408 VDD VSS sg13g2_decap_8
XFILLER_110_899 VDD VSS sg13g2_decap_8
X_13915__2287 _13915_/RESET_B VDD VSS sg13g2_tiehi
XFILLER_110_1324 VDD VSS sg13g2_fill_2
XFILLER_76_791 VDD VSS sg13g2_fill_1
X_14929_ _14929_/Q _14930_/CLK _14929_/D _14929_/RESET_B VDD VSS sg13g2_dfrbpq_1
XFILLER_82_238 VDD VSS sg13g2_decap_4
XFILLER_58_1406 VDD VSS sg13g2_decap_8
XFILLER_184_1436 VDD VSS sg13g2_decap_8
X_08450_ _08462_/A _07948_/A _08448_/Y _08449_/Y VDD VSS sg13g2_o21ai_1
XFILLER_63_463 VDD VSS sg13g2_decap_8
XFILLER_36_677 VDD VSS sg13g2_decap_4
XFILLER_35_154 VDD VSS sg13g2_fill_1
XFILLER_1_1183 VDD VSS sg13g2_decap_8
X_08381_ _08381_/Y _08381_/A _08688_/D _08688_/A _08688_/B VDD VSS sg13g2_nand4_1
XFILLER_51_647 VDD VSS sg13g2_decap_8
XFILLER_50_135 VDD VSS sg13g2_decap_8
XFILLER_91_1032 VDD VSS sg13g2_fill_2
XFILLER_177_811 VDD VSS sg13g2_decap_8
XFILLER_147_1280 VDD VSS sg13g2_decap_8
XFILLER_177_822 VDD VSS sg13g2_fill_2
XFILLER_52_1005 VDD VSS sg13g2_decap_8
XFILLER_143_1133 VDD VSS sg13g2_decap_8
XFILLER_56_1185 VDD VSS sg13g2_decap_8
XFILLER_149_546 VDD VSS sg13g2_decap_8
XFILLER_17_1147 VDD VSS sg13g2_decap_8
XFILLER_91_1098 VDD VSS sg13g2_decap_4
XFILLER_176_365 VDD VSS sg13g2_decap_8
X_09002_ _13761_/D _13761_/Q _09978_/A0 _09077_/S VDD VSS sg13g2_mux2_1
XFILLER_30_1314 VDD VSS sg13g2_decap_8
XFILLER_164_549 VDD VSS sg13g2_decap_8
XFILLER_178_1229 VDD VSS sg13g2_decap_8
X_15153__2674 _15153_/RESET_B VDD VSS sg13g2_tiehi
XFILLER_157_590 VDD VSS sg13g2_decap_8
XFILLER_145_741 VDD VSS sg13g2_decap_8
XFILLER_144_240 VDD VSS sg13g2_decap_8
XFILLER_117_498 VDD VSS sg13g2_decap_8
XFILLER_133_947 VDD VSS sg13g2_decap_4
XFILLER_160_733 VDD VSS sg13g2_decap_8
XFILLER_160_744 VDD VSS sg13g2_fill_2
XFILLER_28_1210 VDD VSS sg13g2_decap_8
XFILLER_116_36 VDD VSS sg13g2_decap_8
XFILLER_160_777 VDD VSS sg13g2_decap_4
Xfanout502 _08861_/S _08834_/X VDD VSS sg13g2_buf_1
X_09904_ _14490_/D _09904_/A0 _14490_/Q _09904_/S VDD VSS sg13g2_mux2_1
Xfanout513 _13651_/S _13650_/S VDD VSS sg13g2_buf_1
XFILLER_132_479 VDD VSS sg13g2_decap_8
Xfanout524 _13554_/S fanout528/X VDD VSS sg13g2_buf_1
Xfanout535 _11858_/A _11235_/X VDD VSS sg13g2_buf_1
XFILLER_98_371 VDD VSS sg13g2_decap_4
Xfanout546 _09906_/A1 _09741_/A1 VDD VSS sg13g2_buf_1
XFILLER_8_1348 VDD VSS sg13g2_decap_8
XFILLER_63_1156 VDD VSS sg13g2_fill_1
Xfanout557 _13600_/A _08833_/Y VDD VSS sg13g2_buf_1
X_09835_ _14423_/D _09934_/A1 _14423_/Q _09837_/S VDD VSS sg13g2_mux2_1
XFILLER_28_1287 VDD VSS sg13g2_decap_8
Xfanout568 _08688_/C _08398_/Y VDD VSS sg13g2_buf_1
XFILLER_86_544 VDD VSS sg13g2_decap_4
Xfanout579 _13262_/B1 _13275_/B1 VDD VSS sg13g2_buf_1
XFILLER_59_769 VDD VSS sg13g2_decap_8
XFILLER_101_866 VDD VSS sg13g2_decap_8
XFILLER_41_1432 VDD VSS sg13g2_decap_8
X_09766_ _14356_/D _14356_/Q _10096_/A0 _09766_/S VDD VSS sg13g2_mux2_1
XFILLER_6_1061 VDD VSS sg13g2_decap_8
X_14505__1697 _14505_/RESET_B VDD VSS sg13g2_tiehi
X_08717_ _15191_/D input18/X _15191_/Q _10203_/S VDD VSS sg13g2_mux2_1
XFILLER_73_249 VDD VSS sg13g2_fill_2
X_09697_ _14289_/D _09895_/A0 _14289_/Q _09704_/S VDD VSS sg13g2_mux2_1
X_14080__2122 _14080_/RESET_B VDD VSS sg13g2_tiehi
XFILLER_92_28 VDD VSS sg13g2_decap_8
XFILLER_15_817 VDD VSS sg13g2_fill_1
X_08648_ _08662_/B _07867_/D _07960_/Y _07969_/D VDD VSS sg13g2_o21ai_1
XFILLER_25_11 VDD VSS sg13g2_decap_8
XFILLER_14_305 VDD VSS sg13g2_decap_8
XFILLER_54_474 VDD VSS sg13g2_decap_8
XFILLER_81_271 VDD VSS sg13g2_fill_2
XFILLER_81_293 VDD VSS sg13g2_decap_8
XFILLER_39_1350 VDD VSS sg13g2_decap_8
XFILLER_109_1039 VDD VSS sg13g2_decap_8
X_14684__1518 _14684_/RESET_B VDD VSS sg13g2_tiehi
X_08579_ _08579_/Y _08641_/D _08578_/Y _08039_/A VDD VSS sg13g2_a21oi_1
Xclkbuf_leaf_103_clk_i clkload50/A clkbuf_leaf_99_clk_i/A VDD VSS sg13g2_buf_8
XFILLER_148_4 VDD VSS sg13g2_decap_4
X_10610_ _10611_/A _14879_/Q _14878_/Q _14877_/Q _10610_/D VDD VSS sg13g2_nand4_1
XFILLER_41_168 VDD VSS sg13g2_decap_8
XFILLER_25_99 VDD VSS sg13g2_decap_8
X_14720__1482 _14720_/RESET_B VDD VSS sg13g2_tiehi
XFILLER_161_1233 VDD VSS sg13g2_decap_8
XFILLER_168_844 VDD VSS sg13g2_decap_8
XFILLER_23_883 VDD VSS sg13g2_decap_8
X_11590_ _11590_/Y _11591_/A _13682_/Q VDD VSS sg13g2_nor2_1
XFILLER_10_511 VDD VSS sg13g2_decap_8
XFILLER_74_1296 VDD VSS sg13g2_decap_8
XFILLER_35_1247 VDD VSS sg13g2_decap_8
XFILLER_50_691 VDD VSS sg13g2_decap_8
XFILLER_122_1228 VDD VSS sg13g2_fill_2
XFILLER_128_719 VDD VSS sg13g2_fill_1
XFILLER_167_354 VDD VSS sg13g2_fill_2
X_10541_ _14862_/D _13273_/A _10547_/D _10540_/Y VDD VSS sg13g2_a21oi_1
XFILLER_41_21 VDD VSS sg13g2_decap_8
XFILLER_122_1239 VDD VSS sg13g2_decap_8
XFILLER_155_516 VDD VSS sg13g2_decap_8
XFILLER_6_515 VDD VSS sg13g2_decap_8
XFILLER_167_398 VDD VSS sg13g2_fill_2
XFILLER_157_32 VDD VSS sg13g2_decap_8
X_13260_ _13260_/Y _14861_/Q _13273_/B VDD VSS sg13g2_nand2_1
XFILLER_10_588 VDD VSS sg13g2_decap_8
X_10472_ _14845_/D _10492_/C _10487_/A _10472_/C VDD VSS sg13g2_nor3_1
XFILLER_109_955 VDD VSS sg13g2_decap_8
Xclkbuf_leaf_118_clk_i clkload19/A clkload1/A VDD VSS sg13g2_buf_8
XFILLER_41_87 VDD VSS sg13g2_decap_4
X_12211_ _12211_/X _14583_/Q _14615_/Q _14647_/Q _14679_/Q _12215_/S0 _12241_/B1 VDD
+ VSS sg13g2_mux4_1
XFILLER_108_454 VDD VSS sg13g2_decap_8
XFILLER_182_368 VDD VSS sg13g2_decap_8
XFILLER_109_988 VDD VSS sg13g2_fill_2
X_13191_ _13191_/Y _13191_/A _13202_/A _13191_/C _13308_/A VDD VSS sg13g2_nand4_1
XFILLER_124_947 VDD VSS sg13g2_decap_8
XFILLER_155_1004 VDD VSS sg13g2_fill_1
XFILLER_123_424 VDD VSS sg13g2_fill_2
XFILLER_151_733 VDD VSS sg13g2_decap_8
X_12142_ _12143_/B _12133_/X _12134_/X _12139_/X _12140_/X _12036_/B _12142_/S1 VDD
+ VSS sg13g2_mux4_1
XFILLER_2_721 VDD VSS sg13g2_decap_8
XFILLER_151_744 VDD VSS sg13g2_fill_1
XFILLER_68_1078 VDD VSS sg13g2_decap_4
XFILLER_29_1029 VDD VSS sg13g2_decap_8
XFILLER_1_231 VDD VSS sg13g2_decap_8
XFILLER_173_42 VDD VSS sg13g2_decap_8
XFILLER_137_1460 VDD VSS sg13g2_decap_4
XFILLER_172_1340 VDD VSS sg13g2_decap_8
X_12073_ _12073_/X _14707_/Q _14739_/Q _13779_/Q _13811_/Q _12135_/S0 _12135_/S1 VDD
+ VSS sg13g2_mux4_1
XFILLER_81_1223 VDD VSS sg13g2_decap_8
XFILLER_133_1302 VDD VSS sg13g2_decap_4
XFILLER_150_276 VDD VSS sg13g2_decap_8
XFILLER_151_799 VDD VSS sg13g2_decap_8
XFILLER_110_118 VDD VSS sg13g2_fill_1
XFILLER_132_980 VDD VSS sg13g2_fill_1
XFILLER_46_1365 VDD VSS sg13g2_decap_8
X_14290__1912 _14290_/RESET_B VDD VSS sg13g2_tiehi
XFILLER_2_798 VDD VSS sg13g2_decap_8
X_11024_ _11064_/B _15118_/Q _11024_/B VDD VSS sg13g2_xnor2_1
X_16881_ _16881_/X _16881_/A VDD VSS sg13g2_buf_1
XFILLER_103_181 VDD VSS sg13g2_decap_8
XFILLER_77_555 VDD VSS sg13g2_decap_8
XFILLER_37_408 VDD VSS sg13g2_fill_1
XFILLER_18_611 VDD VSS sg13g2_decap_4
XFILLER_66_84 VDD VSS sg13g2_decap_8
X_12975_ _12975_/X _12988_/D _12975_/B VDD VSS sg13g2_xor2_1
XFILLER_92_569 VDD VSS sg13g2_decap_8
XFILLER_166_1111 VDD VSS sg13g2_decap_4
X_14714_ _14714_/Q clkload76/A _14714_/D _14714_/RESET_B VDD VSS sg13g2_dfrbpq_1
X_11926_ _11927_/B _11918_/X _11919_/X _11924_/X _11925_/X _12290_/S0 _11999_/S1 VDD
+ VSS sg13g2_mux4_1
XFILLER_2_1470 VDD VSS sg13g2_decap_8
XFILLER_166_1144 VDD VSS sg13g2_fill_2
XFILLER_61_945 VDD VSS sg13g2_decap_8
XFILLER_17_198 VDD VSS sg13g2_decap_8
X_14645_ _14645_/Q _14677_/CLK _14645_/D _14645_/RESET_B VDD VSS sg13g2_dfrbpq_1
X_11857_ _11857_/X _11849_/X _11850_/X _11853_/X _11854_/X _11964_/B _11974_/B1 VDD
+ VSS sg13g2_mux4_1
XFILLER_57_1450 VDD VSS sg13g2_decap_8
XFILLER_33_658 VDD VSS sg13g2_decap_8
XFILLER_159_811 VDD VSS sg13g2_decap_4
XFILLER_92_1341 VDD VSS sg13g2_decap_8
XFILLER_166_1199 VDD VSS sg13g2_decap_8
XFILLER_18_1434 VDD VSS sg13g2_decap_8
XFILLER_53_1314 VDD VSS sg13g2_decap_8
X_10808_ _10809_/B _12346_/A _10807_/B _10807_/C VDD VSS sg13g2_a21oi_1
XFILLER_186_630 VDD VSS sg13g2_decap_8
X_14576_ _14576_/Q clkload14/A _14576_/D _14576_/RESET_B VDD VSS sg13g2_dfrbpq_1
XFILLER_32_179 VDD VSS sg13g2_decap_4
XFILLER_144_1453 VDD VSS sg13g2_decap_8
X_11788_ _11788_/X _13963_/Q _13995_/Q _14027_/Q _14059_/Q _11788_/S0 _12091_/C VDD
+ VSS sg13g2_mux4_1
XFILLER_13_382 VDD VSS sg13g2_decap_8
XFILLER_158_354 VDD VSS sg13g2_fill_2
XFILLER_185_140 VDD VSS sg13g2_decap_8
X_13527_ _13527_/Y _13527_/A _13565_/S VDD VSS sg13g2_nor2_1
XFILLER_119_719 VDD VSS sg13g2_decap_8
XFILLER_140_1328 VDD VSS sg13g2_decap_8
X_10739_ _11052_/B _07616_/Y _09079_/Y _10788_/S VDD VSS sg13g2_mux2_1
XFILLER_118_207 VDD VSS sg13g2_decap_8
XFILLER_9_364 VDD VSS sg13g2_decap_8
X_14804__2932 _14804_/RESET_B VDD VSS sg13g2_tiehi
X_15220__3011 _15220_/RESET_B VDD VSS sg13g2_tiehi
XFILLER_146_549 VDD VSS sg13g2_decap_8
X_13458_ _13458_/Y _08723_/A _08723_/B _13051_/B VDD VSS sg13g2_o21ai_1
XFILLER_12_1033 VDD VSS sg13g2_decap_8
XFILLER_51_1082 VDD VSS sg13g2_decap_4
XFILLER_127_741 VDD VSS sg13g2_decap_8
X_12409_ _12409_/X _13727_/Q _14079_/Q _14431_/Q _14527_/Q _12411_/S0 _12411_/S1 VDD
+ VSS sg13g2_mux4_1
XFILLER_103_1183 VDD VSS sg13g2_fill_1
XFILLER_177_1240 VDD VSS sg13g2_decap_8
X_13389_ _13389_/Y _13389_/A _13389_/B _13429_/A _13391_/C VDD VSS sg13g2_nor4_1
Xoutput105 mem_axi_wdata[10] _15142_/Q VDD VSS sg13g2_buf_1
Xoutput116 mem_axi_wdata[20] _15152_/Q VDD VSS sg13g2_buf_1
XFILLER_138_1213 VDD VSS sg13g2_decap_8
Xoutput127 mem_axi_wdata[30] _15162_/Q VDD VSS sg13g2_buf_1
XFILLER_126_284 VDD VSS sg13g2_decap_8
X_15128_ _15128_/Q _15212_/CLK _15128_/D _15128_/RESET_B VDD VSS sg13g2_dfrbpq_1
Xoutput138 mem_axi_wstrb[2] _15166_/Q VDD VSS sg13g2_buf_1
XFILLER_47_1107 VDD VSS sg13g2_decap_8
X_15028__2582 _15028_/RESET_B VDD VSS sg13g2_tiehi
XFILLER_5_581 VDD VSS sg13g2_decap_8
XFILLER_126_295 VDD VSS sg13g2_fill_2
Xclkbuf_leaf_82_clk_i clkload63/A clkbuf_leaf_90_clk_i/A VDD VSS sg13g2_buf_8
XFILLER_99_135 VDD VSS sg13g2_decap_8
XFILLER_114_446 VDD VSS sg13g2_decap_8
XFILLER_64_1421 VDD VSS sg13g2_decap_8
XFILLER_173_1148 VDD VSS sg13g2_decap_8
XFILLER_87_308 VDD VSS sg13g2_decap_8
XFILLER_130_928 VDD VSS sg13g2_fill_2
X_15059_ _15059_/Q clkload73/A _15059_/D _15059_/RESET_B VDD VSS sg13g2_dfrbpq_1
X_07950_ _07950_/Y _07950_/A _07950_/B _07950_/C VDD VSS sg13g2_nand3_1
XFILLER_130_939 VDD VSS sg13g2_fill_2
XFILLER_123_991 VDD VSS sg13g2_decap_8
XFILLER_68_533 VDD VSS sg13g2_fill_1
XFILLER_110_630 VDD VSS sg13g2_decap_4
X_07881_ _08073_/A _08079_/S _13609_/A VDD VSS sg13g2_nand2_1
XFILLER_60_1329 VDD VSS sg13g2_decap_8
X_09620_ _14216_/D _09620_/A0 _14216_/Q _09622_/S VDD VSS sg13g2_mux2_1
Xclkbuf_leaf_97_clk_i clkload51/A clkload3/A VDD VSS sg13g2_buf_8
XFILLER_110_674 VDD VSS sg13g2_decap_8
XFILLER_3_1201 VDD VSS sg13g2_decap_8
XFILLER_83_536 VDD VSS sg13g2_decap_8
X_09551_ _14149_/D _09617_/A0 _14149_/Q _09562_/S VDD VSS sg13g2_mux2_1
XFILLER_64_750 VDD VSS sg13g2_decap_8
XFILLER_58_1203 VDD VSS sg13g2_decap_8
XFILLER_102_16 VDD VSS sg13g2_fill_1
X_08502_ _08502_/Y _07636_/Y _11914_/A _08434_/B _07829_/B _07950_/Y VDD VSS sg13g2_a221oi_1
XFILLER_3_1278 VDD VSS sg13g2_decap_8
XFILLER_102_27 VDD VSS sg13g2_decap_8
XFILLER_97_1274 VDD VSS sg13g2_decap_8
XFILLER_110_1176 VDD VSS sg13g2_decap_8
X_09482_ _14082_/D _10045_/A0 _14082_/Q _09493_/S VDD VSS sg13g2_mux2_1
XFILLER_24_614 VDD VSS sg13g2_decap_8
XFILLER_184_1233 VDD VSS sg13g2_decap_8
Xclkbuf_leaf_20_clk_i clkload32/A clkload2/A VDD VSS sg13g2_buf_8
XFILLER_36_496 VDD VSS sg13g2_decap_8
XFILLER_169_608 VDD VSS sg13g2_decap_8
X_08433_ _08441_/A _07799_/X _08306_/A _08432_/Y _07798_/X _08431_/X VDD VSS sg13g2_a221oi_1
XFILLER_180_1119 VDD VSS sg13g2_decap_8
XFILLER_52_978 VDD VSS sg13g2_decap_8
XFILLER_23_146 VDD VSS sg13g2_fill_2
XFILLER_11_319 VDD VSS sg13g2_decap_8
X_08364_ _08373_/B _08110_/D _08363_/X _08361_/Y VDD VSS sg13g2_a21oi_1
XFILLER_71_1425 VDD VSS sg13g2_decap_8
XFILLER_108_1050 VDD VSS sg13g2_fill_1
XFILLER_149_321 VDD VSS sg13g2_decap_8
XFILLER_51_499 VDD VSS sg13g2_decap_8
XFILLER_176_140 VDD VSS sg13g2_decap_8
Xclkbuf_leaf_35_clk_i clkload41/A clkbuf_leaf_38_clk_i/A VDD VSS sg13g2_buf_8
X_08295_ _08295_/Y _07778_/A _08276_/B _08289_/Y VDD VSS sg13g2_o21ai_1
XFILLER_149_387 VDD VSS sg13g2_decap_8
XFILLER_165_836 VDD VSS sg13g2_decap_8
XFILLER_118_730 VDD VSS sg13g2_decap_4
XFILLER_118_752 VDD VSS sg13g2_decap_8
XFILLER_178_1037 VDD VSS sg13g2_decap_8
XFILLER_118_763 VDD VSS sg13g2_fill_1
XFILLER_11_46 VDD VSS sg13g2_decap_8
XFILLER_69_1332 VDD VSS sg13g2_decap_8
XFILLER_133_700 VDD VSS sg13g2_decap_8
XFILLER_145_560 VDD VSS sg13g2_fill_1
XFILLER_173_880 VDD VSS sg13g2_decap_8
XFILLER_106_936 VDD VSS sg13g2_fill_1
XFILLER_3_529 VDD VSS sg13g2_decap_8
XFILLER_30_1188 VDD VSS sg13g2_decap_8
XFILLER_105_424 VDD VSS sg13g2_decap_8
XFILLER_65_1207 VDD VSS sg13g2_decap_8
XFILLER_117_295 VDD VSS sg13g2_decap_4
X_14098__2104 _14098_/RESET_B VDD VSS sg13g2_tiehi
XFILLER_133_766 VDD VSS sg13g2_fill_1
XFILLER_156_1357 VDD VSS sg13g2_decap_8
XFILLER_87_39 VDD VSS sg13g2_decap_8
Xfanout310 _10167_/S _10169_/S VDD VSS sg13g2_buf_1
Xfanout1308 _12236_/C _12283_/S1 VDD VSS sg13g2_buf_1
XFILLER_132_287 VDD VSS sg13g2_decap_8
Xfanout321 _09969_/S fanout323/X VDD VSS sg13g2_buf_1
Xfanout1319 fanout1319/X _13658_/Q VDD VSS sg13g2_buf_1
Xfanout332 _09859_/S fanout335/X VDD VSS sg13g2_buf_1
Xfanout343 _09733_/S _09725_/S VDD VSS sg13g2_buf_1
XFILLER_8_1145 VDD VSS sg13g2_decap_8
XFILLER_101_641 VDD VSS sg13g2_decap_8
XFILLER_154_1081 VDD VSS sg13g2_decap_8
Xfanout354 _09623_/S _09622_/S VDD VSS sg13g2_buf_1
XFILLER_143_45 VDD VSS sg13g2_fill_1
Xfanout365 _09329_/S _09325_/S VDD VSS sg13g2_buf_1
XFILLER_87_864 VDD VSS sg13g2_decap_8
X_14738__1464 _14738_/RESET_B VDD VSS sg13g2_tiehi
Xfanout376 _09267_/S _09259_/S VDD VSS sg13g2_buf_1
XFILLER_47_706 VDD VSS sg13g2_decap_4
Xfanout387 _10146_/A1 fanout390/X VDD VSS sg13g2_buf_1
X_09818_ _14406_/D _09917_/A1 _14406_/Q _09822_/S VDD VSS sg13g2_mux2_1
XFILLER_86_363 VDD VSS sg13g2_fill_2
Xfanout398 _10143_/A1 _10110_/A0 VDD VSS sg13g2_buf_1
XFILLER_59_588 VDD VSS sg13g2_fill_1
XFILLER_115_1087 VDD VSS sg13g2_decap_8
XFILLER_98_1027 VDD VSS sg13g2_decap_8
XFILLER_86_385 VDD VSS sg13g2_decap_8
XFILLER_132_1390 VDD VSS sg13g2_decap_8
X_09749_ _14339_/D _14339_/Q _09749_/A1 _09762_/S VDD VSS sg13g2_mux2_1
XFILLER_36_21 VDD VSS sg13g2_decap_8
XFILLER_27_430 VDD VSS sg13g2_decap_4
XFILLER_76_1303 VDD VSS sg13g2_decap_8
X_12760_ _12760_/X _12757_/X _12756_/X _12753_/X _12752_/X _12775_/S1 _12748_/S VDD
+ VSS sg13g2_mux4_1
XFILLER_61_219 VDD VSS sg13g2_decap_4
XFILLER_42_400 VDD VSS sg13g2_decap_8
XFILLER_82_580 VDD VSS sg13g2_fill_1
X_11711_ _11711_/X _14697_/Q _14729_/Q _13769_/Q _13801_/Q _11715_/S0 _11715_/S1 VDD
+ VSS sg13g2_mux4_1
XFILLER_163_1317 VDD VSS sg13g2_decap_8
X_12691_ _12691_/X _12683_/X _12687_/X _12682_/X _12686_/X _12748_/S _12747_/S1 VDD
+ VSS sg13g2_mux4_1
XFILLER_70_764 VDD VSS sg13g2_decap_8
X_14430_ _14430_/Q clkload60/A _14430_/D _14430_/RESET_B VDD VSS sg13g2_dfrbpq_1
X_11642_ _11663_/B _11643_/B _11643_/A VDD VSS sg13g2_nand2_1
XFILLER_74_1071 VDD VSS sg13g2_decap_8
XFILLER_70_797 VDD VSS sg13g2_decap_8
XFILLER_126_1150 VDD VSS sg13g2_decap_8
XFILLER_161_1030 VDD VSS sg13g2_decap_8
XFILLER_74_1082 VDD VSS sg13g2_fill_1
XFILLER_35_1044 VDD VSS sg13g2_decap_8
XFILLER_139_0 VDD VSS sg13g2_decap_8
XFILLER_168_42 VDD VSS sg13g2_decap_8
X_14361_ _14361_/Q clkload44/A _14361_/D _14361_/RESET_B VDD VSS sg13g2_dfrbpq_1
XFILLER_11_853 VDD VSS sg13g2_decap_8
XFILLER_156_814 VDD VSS sg13g2_decap_8
XFILLER_167_151 VDD VSS sg13g2_decap_8
X_11573_ _11573_/X _14565_/Q _14597_/Q _14629_/Q _14661_/Q _11580_/S0 _11580_/S1 VDD
+ VSS sg13g2_mux4_1
XFILLER_35_1066 VDD VSS sg13g2_fill_2
Xinput18 input18/X input18/A VDD VSS sg13g2_buf_1
XFILLER_35_1088 VDD VSS sg13g2_decap_8
XFILLER_13_1320 VDD VSS sg13g2_decap_8
X_13312_ _13312_/Y _13312_/A _13308_/B VDD VSS sg13g2_nor2b_1
Xinput29 input29/X input29/A VDD VSS sg13g2_buf_1
X_10524_ _10543_/C _10538_/A _10538_/B _10567_/A VDD VSS sg13g2_nor3_1
XFILLER_6_312 VDD VSS sg13g2_decap_8
X_14292_ _14292_/Q _15005_/CLK _14292_/D _14292_/RESET_B VDD VSS sg13g2_dfrbpq_1
XFILLER_10_385 VDD VSS sg13g2_decap_8
XFILLER_171_806 VDD VSS sg13g2_fill_1
XFILLER_7_868 VDD VSS sg13g2_decap_8
XFILLER_171_828 VDD VSS sg13g2_decap_8
X_13243_ _13243_/Y _13244_/B _13246_/C VDD VSS sg13g2_nand2_1
XFILLER_170_305 VDD VSS sg13g2_decap_8
XFILLER_182_165 VDD VSS sg13g2_decap_8
X_10455_ _10455_/Y _14841_/Q _10462_/D _10557_/C VDD VSS sg13g2_o21ai_1
XFILLER_100_1334 VDD VSS sg13g2_decap_8
XFILLER_13_1397 VDD VSS sg13g2_decap_8
XFILLER_184_30 VDD VSS sg13g2_decap_8
XFILLER_87_1454 VDD VSS sg13g2_decap_8
XFILLER_48_1405 VDD VSS sg13g2_decap_8
XFILLER_108_273 VDD VSS sg13g2_decap_8
XFILLER_136_582 VDD VSS sg13g2_decap_8
XFILLER_174_1413 VDD VSS sg13g2_decap_8
XFILLER_6_389 VDD VSS sg13g2_decap_8
X_13174_ _13174_/Y _13174_/A _13174_/B VDD VSS sg13g2_nor2_1
X_10386_ _14819_/D _10623_/A _10386_/B _10386_/C VDD VSS sg13g2_nor3_1
XFILLER_124_766 VDD VSS sg13g2_fill_1
X_12125_ _14982_/D _12125_/A _12125_/B VDD VSS sg13g2_nor2_1
XFILLER_111_405 VDD VSS sg13g2_decap_8
XFILLER_151_596 VDD VSS sg13g2_decap_8
XFILLER_111_438 VDD VSS sg13g2_fill_1
XFILLER_96_138 VDD VSS sg13g2_fill_1
XFILLER_78_842 VDD VSS sg13g2_decap_8
XFILLER_46_1162 VDD VSS sg13g2_decap_8
XFILLER_2_595 VDD VSS sg13g2_decap_8
X_12056_ _12056_/X _12056_/A _12056_/B _12056_/C VDD VSS sg13g2_and3_1
XFILLER_81_1053 VDD VSS sg13g2_decap_8
XFILLER_133_1132 VDD VSS sg13g2_decap_8
XFILLER_77_72 VDD VSS sg13g2_fill_1
X_11007_ _11010_/A _11007_/A _11007_/B VDD VSS sg13g2_or2_1
XFILLER_78_886 VDD VSS sg13g2_decap_8
XFILLER_120_983 VDD VSS sg13g2_decap_8
XFILLER_133_1176 VDD VSS sg13g2_fill_2
X_16864_ _16864_/X _16864_/A VDD VSS sg13g2_buf_1
XFILLER_65_525 VDD VSS sg13g2_fill_1
XFILLER_77_396 VDD VSS sg13g2_decap_4
XFILLER_37_227 VDD VSS sg13g2_decap_8
XFILLER_65_547 VDD VSS sg13g2_decap_8
X_13796__2406 _13796_/RESET_B VDD VSS sg13g2_tiehi
XFILLER_18_441 VDD VSS sg13g2_decap_8
XFILLER_19_964 VDD VSS sg13g2_decap_8
XFILLER_93_878 VDD VSS sg13g2_decap_8
XFILLER_18_452 VDD VSS sg13g2_fill_2
X_13832__2370 _13832_/RESET_B VDD VSS sg13g2_tiehi
XFILLER_0_1429 VDD VSS sg13g2_decap_8
XFILLER_46_772 VDD VSS sg13g2_decap_8
XFILLER_20_1368 VDD VSS sg13g2_decap_8
X_12958_ _12961_/C _14903_/Q _12942_/B _12945_/Y VDD VSS sg13g2_a21oi_1
XFILLER_18_485 VDD VSS sg13g2_decap_8
XFILLER_94_1447 VDD VSS sg13g2_decap_8
XFILLER_45_282 VDD VSS sg13g2_decap_8
X_11909_ _11913_/A _11864_/Y _11908_/Y _11907_/X VDD VSS sg13g2_o21ai_1
XFILLER_181_1428 VDD VSS sg13g2_decap_8
X_12889_ _12889_/Y _12874_/A _12877_/C _12872_/X VDD VSS sg13g2_a21oi_1
XFILLER_34_978 VDD VSS sg13g2_decap_8
XFILLER_61_775 VDD VSS sg13g2_decap_4
X_14628_ _14628_/Q clkload49/A _14628_/D _14628_/RESET_B VDD VSS sg13g2_dfrbpq_1
XFILLER_18_1231 VDD VSS sg13g2_decap_8
XFILLER_20_105 VDD VSS sg13g2_decap_8
X_14176__2026 _14176_/RESET_B VDD VSS sg13g2_tiehi
XFILLER_60_274 VDD VSS sg13g2_fill_2
XFILLER_60_296 VDD VSS sg13g2_decap_4
XFILLER_147_803 VDD VSS sg13g2_decap_8
XFILLER_144_1272 VDD VSS sg13g2_decap_8
X_14559_ _14559_/Q clkload61/A _14559_/D _14559_/RESET_B VDD VSS sg13g2_dfrbpq_1
XFILLER_144_1294 VDD VSS sg13g2_fill_2
XFILLER_14_1128 VDD VSS sg13g2_decap_8
XFILLER_179_1302 VDD VSS sg13g2_decap_8
XFILLER_9_161 VDD VSS sg13g2_decap_8
XFILLER_53_1188 VDD VSS sg13g2_decap_8
XFILLER_119_538 VDD VSS sg13g2_decap_4
X_08080_ _08080_/Y _08048_/A _07845_/B _13553_/A1 VDD VSS sg13g2_a21oi_1
XFILLER_119_549 VDD VSS sg13g2_decap_8
XFILLER_147_858 VDD VSS sg13g2_fill_1
XFILLER_174_655 VDD VSS sg13g2_decap_8
XFILLER_88_1229 VDD VSS sg13g2_decap_8
XFILLER_173_154 VDD VSS sg13g2_decap_8
XFILLER_162_828 VDD VSS sg13g2_decap_8
XFILLER_31_1475 VDD VSS sg13g2_decap_4
XFILLER_179_1379 VDD VSS sg13g2_decap_8
XFILLER_155_880 VDD VSS sg13g2_decap_8
XFILLER_54_0 VDD VSS sg13g2_decap_8
XFILLER_115_744 VDD VSS sg13g2_fill_2
XFILLER_154_390 VDD VSS sg13g2_fill_2
XFILLER_88_606 VDD VSS sg13g2_decap_8
XFILLER_138_1054 VDD VSS sg13g2_decap_8
XFILLER_88_617 VDD VSS sg13g2_fill_2
XFILLER_142_574 VDD VSS sg13g2_decap_8
XFILLER_103_939 VDD VSS sg13g2_decap_8
XFILLER_130_725 VDD VSS sg13g2_decap_8
X_08982_ _08982_/Y _10681_/A _10674_/A _08981_/Y VDD VSS sg13g2_a21oi_1
XFILLER_114_287 VDD VSS sg13g2_decap_8
XFILLER_138_1087 VDD VSS sg13g2_fill_2
XFILLER_116_1330 VDD VSS sg13g2_fill_1
X_14207__1995 _14207_/RESET_B VDD VSS sg13g2_tiehi
X_07933_ _07933_/Y _15002_/Q _11659_/A VDD VSS sg13g2_nor2b_1
XFILLER_130_769 VDD VSS sg13g2_decap_4
XFILLER_69_853 VDD VSS sg13g2_fill_2
XFILLER_151_1232 VDD VSS sg13g2_decap_8
X_14983__2627 _14983_/RESET_B VDD VSS sg13g2_tiehi
XFILLER_9_1465 VDD VSS sg13g2_decap_8
XFILLER_64_1295 VDD VSS sg13g2_decap_8
XFILLER_25_1257 VDD VSS sg13g2_decap_8
X_07864_ _07864_/Y _08608_/A _08608_/B _08641_/C VDD VSS sg13g2_o21ai_1
XFILLER_56_514 VDD VSS sg13g2_decap_8
XFILLER_112_1227 VDD VSS sg13g2_decap_8
X_09603_ _14200_/D _14200_/Q _09737_/A0 _09604_/S VDD VSS sg13g2_mux2_1
XFILLER_95_182 VDD VSS sg13g2_decap_4
XFILLER_113_37 VDD VSS sg13g2_fill_2
XFILLER_84_856 VDD VSS sg13g2_decap_8
X_07795_ _07797_/D _07795_/A _08414_/C VDD VSS sg13g2_nand2_1
X_14386__1816 _14386_/RESET_B VDD VSS sg13g2_tiehi
XFILLER_83_366 VDD VSS sg13g2_fill_1
X_09534_ _14133_/D _10164_/A1 _14133_/Q _09538_/S VDD VSS sg13g2_mux2_1
XFILLER_71_517 VDD VSS sg13g2_decap_4
X_14422__1780 _14422_/RESET_B VDD VSS sg13g2_tiehi
XFILLER_3_1075 VDD VSS sg13g2_decap_8
XFILLER_83_399 VDD VSS sg13g2_decap_8
XFILLER_25_934 VDD VSS sg13g2_decap_8
X_15051__2546 _15051_/RESET_B VDD VSS sg13g2_tiehi
XFILLER_52_720 VDD VSS sg13g2_decap_8
XFILLER_37_794 VDD VSS sg13g2_decap_8
XFILLER_24_411 VDD VSS sg13g2_decap_8
X_09465_ _14066_/D _09630_/A0 _14066_/Q _09471_/S VDD VSS sg13g2_mux2_1
XFILLER_58_1055 VDD VSS sg13g2_decap_8
X_08416_ _08575_/A _08418_/B _08417_/B VDD VSS sg13g2_and2_1
XFILLER_36_1320 VDD VSS sg13g2_decap_8
XFILLER_24_488 VDD VSS sg13g2_decap_8
XFILLER_185_909 VDD VSS sg13g2_decap_8
X_09396_ _13999_/D _09860_/A1 _13999_/Q _09405_/S VDD VSS sg13g2_mux2_1
XFILLER_11_116 VDD VSS sg13g2_decap_8
XFILLER_75_1391 VDD VSS sg13g2_decap_8
XFILLER_71_1222 VDD VSS sg13g2_decap_8
XFILLER_123_1301 VDD VSS sg13g2_decap_8
XFILLER_51_296 VDD VSS sg13g2_decap_4
XFILLER_184_408 VDD VSS sg13g2_decap_8
X_08347_ _08347_/Y _08359_/B2 _08336_/Y _08341_/Y _08110_/D _08346_/Y VDD VSS sg13g2_a221oi_1
XFILLER_132_7 VDD VSS sg13g2_decap_4
XFILLER_138_836 VDD VSS sg13g2_decap_8
XFILLER_36_1397 VDD VSS sg13g2_decap_8
XFILLER_32_1239 VDD VSS sg13g2_decap_8
XFILLER_71_1299 VDD VSS sg13g2_decap_8
X_08278_ _08279_/A _08276_/A _08258_/C _07768_/A _08278_/A3 _08023_/A _07884_/A VDD
+ VSS sg13g2_mux4_1
XFILLER_138_34 VDD VSS sg13g2_decap_8
XFILLER_20_694 VDD VSS sg13g2_decap_8
XFILLER_123_1389 VDD VSS sg13g2_fill_2
XFILLER_4_805 VDD VSS sg13g2_decap_8
XFILLER_125_519 VDD VSS sg13g2_fill_1
XFILLER_137_379 VDD VSS sg13g2_decap_8
XFILLER_106_722 VDD VSS sg13g2_decap_8
XFILLER_98_49 VDD VSS sg13g2_decap_8
X_10240_ _10250_/D _14775_/Q _10247_/D VDD VSS sg13g2_and2_1
XFILLER_3_326 VDD VSS sg13g2_decap_8
X_13874__2328 _13874_/RESET_B VDD VSS sg13g2_tiehi
XFILLER_105_232 VDD VSS sg13g2_decap_8
XFILLER_106_755 VDD VSS sg13g2_fill_1
X_13910__2292 _13910_/RESET_B VDD VSS sg13g2_tiehi
X_10171_ _10178_/A _10174_/B _13324_/A _14766_/Q _10171_/D VDD VSS sg13g2_or4_1
XFILLER_121_714 VDD VSS sg13g2_decap_8
XFILLER_79_628 VDD VSS sg13g2_decap_8
XFILLER_117_1138 VDD VSS sg13g2_decap_8
XFILLER_120_213 VDD VSS sg13g2_decap_8
XFILLER_156_1187 VDD VSS sg13g2_decap_8
Xfanout1105 _12298_/A _14988_/Q VDD VSS sg13g2_buf_1
XFILLER_82_1351 VDD VSS sg13g2_decap_8
Xfanout1116 _12128_/A _08934_/A1 VDD VSS sg13g2_buf_1
Xfanout1127 _11983_/A _08922_/A1 VDD VSS sg13g2_buf_1
XFILLER_121_769 VDD VSS sg13g2_decap_8
Xfanout1138 _08909_/A1 _11865_/A VDD VSS sg13g2_buf_1
Xfanout151 _09936_/A1 _09159_/Y VDD VSS sg13g2_buf_1
Xfanout1149 _08383_/A _08457_/A3 VDD VSS sg13g2_buf_1
Xfanout162 _09933_/A1 _10165_/A1 VDD VSS sg13g2_buf_1
X_13930_ _13930_/Q clkload27/A _13930_/D _13930_/RESET_B VDD VSS sg13g2_dfrbpq_1
X_14959__2651 _14959_/RESET_B VDD VSS sg13g2_tiehi
XFILLER_43_1357 VDD VSS sg13g2_decap_8
XFILLER_120_279 VDD VSS sg13g2_decap_8
Xfanout173 _10130_/A0 _09931_/A1 VDD VSS sg13g2_buf_1
XFILLER_102_994 VDD VSS sg13g2_fill_2
Xfanout184 _10094_/A0 _10161_/A1 VDD VSS sg13g2_buf_1
Xfanout195 _10158_/A1 _09594_/A1 VDD VSS sg13g2_buf_1
XFILLER_130_1338 VDD VSS sg13g2_fill_1
XFILLER_170_32 VDD VSS sg13g2_decap_8
X_13861_ _13861_/Q clkload16/A _13861_/D _13861_/RESET_B VDD VSS sg13g2_dfrbpq_1
XFILLER_86_193 VDD VSS sg13g2_fill_2
XFILLER_16_912 VDD VSS sg13g2_decap_8
X_12812_ _15021_/D _12812_/A _12812_/B VDD VSS sg13g2_nor2_1
X_13792_ _13792_/Q clkload23/A _13792_/D _13792_/RESET_B VDD VSS sg13g2_dfrbpq_1
XFILLER_43_731 VDD VSS sg13g2_decap_8
XFILLER_15_433 VDD VSS sg13g2_decap_8
X_12743_ _12743_/X _13975_/Q _14007_/Q _14039_/Q _14071_/Q _12756_/S0 _12756_/S1 VDD
+ VSS sg13g2_mux4_1
XFILLER_167_1283 VDD VSS sg13g2_decap_8
XFILLER_76_1177 VDD VSS sg13g2_decap_8
XFILLER_72_1008 VDD VSS sg13g2_decap_8
XFILLER_43_786 VDD VSS sg13g2_fill_2
X_12674_ _12674_/X _14130_/Q _14162_/Q _14194_/Q _14226_/Q _12674_/S0 _12674_/S1 VDD
+ VSS sg13g2_mux4_1
XFILLER_128_1278 VDD VSS sg13g2_decap_4
XFILLER_70_594 VDD VSS sg13g2_decap_8
XFILLER_179_74 VDD VSS sg13g2_decap_8
XFILLER_15_1404 VDD VSS sg13g2_decap_8
XFILLER_169_972 VDD VSS sg13g2_decap_8
X_14413_ _14413_/Q clkload23/A _14413_/D _14413_/RESET_B VDD VSS sg13g2_dfrbpq_1
XFILLER_30_447 VDD VSS sg13g2_decap_8
XFILLER_141_1412 VDD VSS sg13g2_decap_8
X_11625_ _11625_/Y _11623_/Y _11625_/B _11625_/C VDD VSS sg13g2_nand3b_1
XFILLER_8_25 VDD VSS sg13g2_decap_8
XFILLER_141_1423 VDD VSS sg13g2_fill_2
XFILLER_129_825 VDD VSS sg13g2_decap_8
XFILLER_184_920 VDD VSS sg13g2_decap_8
XFILLER_141_1445 VDD VSS sg13g2_decap_8
X_14344_ _14344_/Q clkload21/A _14344_/D _14344_/RESET_B VDD VSS sg13g2_dfrbpq_1
XFILLER_11_683 VDD VSS sg13g2_decap_8
XFILLER_128_335 VDD VSS sg13g2_decap_8
X_11556_ _11556_/X _11549_/B _11555_/X _11554_/Y VDD VSS sg13g2_a21o_1
XFILLER_184_975 VDD VSS sg13g2_decap_8
XFILLER_10_182 VDD VSS sg13g2_decap_8
XFILLER_183_452 VDD VSS sg13g2_decap_8
X_10507_ _10509_/C _14852_/Q _14845_/Q _10514_/A _10507_/D VDD VSS sg13g2_nand4_1
XFILLER_7_665 VDD VSS sg13g2_decap_8
XFILLER_109_560 VDD VSS sg13g2_fill_2
X_14275_ _14275_/Q clkload17/A _14275_/D _14275_/RESET_B VDD VSS sg13g2_dfrbpq_1
XFILLER_156_699 VDD VSS sg13g2_decap_8
XFILLER_170_102 VDD VSS sg13g2_decap_8
XFILLER_171_625 VDD VSS sg13g2_decap_4
X_11487_ _11487_/X _14690_/Q _14722_/Q _13762_/Q _13794_/Q _11493_/S0 _07654_/A VDD
+ VSS sg13g2_mux4_1
XFILLER_155_187 VDD VSS sg13g2_decap_8
XFILLER_100_1142 VDD VSS sg13g2_decap_4
XFILLER_13_1194 VDD VSS sg13g2_decap_8
X_13226_ _13228_/B _13202_/B _13226_/B VDD VSS sg13g2_nand2b_1
XFILLER_6_186 VDD VSS sg13g2_decap_8
XFILLER_48_1202 VDD VSS sg13g2_decap_8
XFILLER_124_530 VDD VSS sg13g2_decap_8
XFILLER_174_1210 VDD VSS sg13g2_decap_8
X_10438_ _10441_/A _14835_/Q _10443_/D _14836_/Q VDD VSS sg13g2_a21o_1
XFILLER_87_1262 VDD VSS sg13g2_decap_8
XFILLER_178_1390 VDD VSS sg13g2_decap_8
XFILLER_100_1175 VDD VSS sg13g2_decap_8
X_14464__1738 _14464_/RESET_B VDD VSS sg13g2_tiehi
XFILLER_124_563 VDD VSS sg13g2_fill_1
XFILLER_97_403 VDD VSS sg13g2_fill_1
X_13157_ _13170_/D _13157_/A _13670_/Q VDD VSS sg13g2_xnor2_1
XFILLER_124_585 VDD VSS sg13g2_decap_8
XFILLER_152_894 VDD VSS sg13g2_fill_1
X_10369_ _10369_/Y _10400_/A _10400_/B _10400_/C VDD VSS sg13g2_nor3_1
XFILLER_98_948 VDD VSS sg13g2_decap_8
XFILLER_48_1279 VDD VSS sg13g2_decap_8
XFILLER_174_1287 VDD VSS sg13g2_decap_8
XFILLER_3_893 VDD VSS sg13g2_decap_8
X_12108_ _12108_/X _12108_/A _12108_/B VDD VSS sg13g2_and2_1
X_13088_ _13088_/X _13088_/A _13675_/Q VDD VSS sg13g2_and2_1
XFILLER_2_392 VDD VSS sg13g2_decap_8
XFILLER_61_1435 VDD VSS sg13g2_decap_8
X_12039_ _12039_/Y _12040_/A1 _14194_/Q VDD VSS sg13g2_nand2b_1
XFILLER_22_1419 VDD VSS sg13g2_decap_8
XFILLER_93_620 VDD VSS sg13g2_decap_8
XFILLER_66_856 VDD VSS sg13g2_decap_8
XFILLER_92_141 VDD VSS sg13g2_fill_1
XFILLER_4_1351 VDD VSS sg13g2_decap_8
XFILLER_38_569 VDD VSS sg13g2_decap_8
XFILLER_53_506 VDD VSS sg13g2_fill_2
XFILLER_80_303 VDD VSS sg13g2_fill_2
XFILLER_0_1226 VDD VSS sg13g2_decap_8
XFILLER_20_1165 VDD VSS sg13g2_decap_8
XFILLER_59_1331 VDD VSS sg13g2_decap_8
XFILLER_46_580 VDD VSS sg13g2_fill_1
XFILLER_146_1312 VDD VSS sg13g2_decap_4
XFILLER_18_293 VDD VSS sg13g2_fill_2
XFILLER_146_1334 VDD VSS sg13g2_decap_8
XFILLER_185_1383 VDD VSS sg13g2_decap_8
XFILLER_179_747 VDD VSS sg13g2_decap_4
XFILLER_181_1225 VDD VSS sg13g2_decap_8
XFILLER_94_1277 VDD VSS sg13g2_fill_1
X_09250_ _13859_/D _13859_/Q _10146_/A1 _09263_/S VDD VSS sg13g2_mux2_1
XFILLER_33_263 VDD VSS sg13g2_decap_4
XFILLER_179_769 VDD VSS sg13g2_decap_8
XFILLER_22_948 VDD VSS sg13g2_fill_2
X_08201_ _08201_/Y _08201_/A _08201_/B _08201_/C _08201_/D VDD VSS sg13g2_nor4_1
XFILLER_18_1061 VDD VSS sg13g2_fill_2
X_09181_ _13797_/D _13797_/Q _10148_/A1 _09189_/S VDD VSS sg13g2_mux2_1
XFILLER_147_622 VDD VSS sg13g2_decap_4
XFILLER_159_493 VDD VSS sg13g2_fill_1
X_08132_ _08132_/X _08219_/A _08258_/C _07768_/A _08276_/A _08337_/S1 _08337_/S0 VDD
+ VSS sg13g2_mux4_1
XFILLER_105_1064 VDD VSS sg13g2_decap_8
XFILLER_146_154 VDD VSS sg13g2_decap_8
XFILLER_107_519 VDD VSS sg13g2_decap_4
X_08063_ _08063_/Y _08063_/A _13602_/A VDD VSS sg13g2_nand2_1
XFILLER_179_1176 VDD VSS sg13g2_decap_8
XFILLER_31_1272 VDD VSS sg13g2_decap_8
XFILLER_134_327 VDD VSS sg13g2_decap_8
X_14871__2825 _14871_/RESET_B VDD VSS sg13g2_tiehi
XFILLER_127_390 VDD VSS sg13g2_decap_8
XFILLER_157_1441 VDD VSS sg13g2_decap_8
XFILLER_89_904 VDD VSS sg13g2_decap_8
XFILLER_1_819 VDD VSS sg13g2_decap_8
XFILLER_89_926 VDD VSS sg13g2_fill_2
XFILLER_153_1305 VDD VSS sg13g2_fill_2
XFILLER_66_1368 VDD VSS sg13g2_decap_8
XFILLER_0_329 VDD VSS sg13g2_decap_8
XFILLER_103_736 VDD VSS sg13g2_fill_1
XFILLER_170_691 VDD VSS sg13g2_decap_8
XFILLER_118_1469 VDD VSS sg13g2_fill_1
X_08965_ _08965_/Y _09938_/C _09806_/B _10137_/B _09707_/C VDD VSS sg13g2_nor4_1
XFILLER_124_14 VDD VSS sg13g2_fill_2
XFILLER_124_25 VDD VSS sg13g2_fill_1
XFILLER_9_1262 VDD VSS sg13g2_decap_8
XFILLER_64_1081 VDD VSS sg13g2_fill_2
X_07916_ _07916_/Y _07914_/Y _07904_/C _07878_/Y VDD VSS sg13g2_o21ai_1
XFILLER_69_672 VDD VSS sg13g2_decap_8
XFILLER_29_503 VDD VSS sg13g2_decap_8
XFILLER_116_1171 VDD VSS sg13g2_decap_8
XFILLER_151_1051 VDD VSS sg13g2_decap_8
XFILLER_25_1054 VDD VSS sg13g2_decap_8
XFILLER_151_1062 VDD VSS sg13g2_fill_2
X_08896_ _13707_/D _16869_/A _08895_/X _08932_/S VDD VSS sg13g2_mux2_1
XFILLER_84_18 VDD VSS sg13g2_fill_1
XFILLER_84_631 VDD VSS sg13g2_decap_8
XFILLER_5_1148 VDD VSS sg13g2_decap_8
XFILLER_151_1084 VDD VSS sg13g2_fill_2
XFILLER_56_333 VDD VSS sg13g2_decap_8
XFILLER_151_1095 VDD VSS sg13g2_decap_8
X_07847_ _07847_/Y _08678_/B _08678_/C _08678_/A VDD VSS sg13g2_a21oi_1
XFILLER_57_878 VDD VSS sg13g2_decap_8
XFILLER_186_1147 VDD VSS sg13g2_decap_8
XFILLER_71_314 VDD VSS sg13g2_decap_8
XFILLER_56_388 VDD VSS sg13g2_decap_8
XFILLER_17_56 VDD VSS sg13g2_decap_8
X_07778_ _08318_/D _07778_/A _08276_/B VDD VSS sg13g2_xor2_1
XFILLER_72_848 VDD VSS sg13g2_decap_8
XFILLER_140_57 VDD VSS sg13g2_decap_8
X_09517_ _14116_/D _09583_/A1 _14116_/Q _09523_/S VDD VSS sg13g2_mux2_1
XFILLER_77_1453 VDD VSS sg13g2_decap_8
XFILLER_38_1426 VDD VSS sg13g2_decap_8
XFILLER_164_1434 VDD VSS sg13g2_decap_8
XFILLER_169_202 VDD VSS sg13g2_decap_8
XFILLER_80_870 VDD VSS sg13g2_decap_8
XFILLER_25_786 VDD VSS sg13g2_decap_8
X_09448_ _14049_/D _09978_/A0 _14049_/Q _09463_/S VDD VSS sg13g2_mux2_1
XFILLER_73_1339 VDD VSS sg13g2_decap_8
XFILLER_33_11 VDD VSS sg13g2_decap_8
XFILLER_24_285 VDD VSS sg13g2_decap_8
X_13928__2274 _13928_/RESET_B VDD VSS sg13g2_tiehi
XFILLER_185_717 VDD VSS sg13g2_decap_8
XFILLER_184_205 VDD VSS sg13g2_decap_8
X_09379_ _13982_/D _09942_/A1 _13982_/Q _09401_/S VDD VSS sg13g2_mux2_1
XFILLER_149_44 VDD VSS sg13g2_decap_8
XFILLER_178_780 VDD VSS sg13g2_decap_8
XFILLER_166_942 VDD VSS sg13g2_fill_2
X_11410_ _11410_/Y _11821_/S0 _14495_/Q _11802_/B VDD VSS sg13g2_a21oi_1
XFILLER_36_1194 VDD VSS sg13g2_decap_8
XFILLER_137_110 VDD VSS sg13g2_decap_8
XFILLER_166_953 VDD VSS sg13g2_fill_2
X_12390_ _12390_/X _13822_/Q _13854_/Q _13886_/Q _13918_/Q _12614_/S0 _12614_/S1 VDD
+ VSS sg13g2_mux4_1
XFILLER_126_806 VDD VSS sg13g2_fill_2
X_11341_ _14959_/D _11335_/A _11432_/A2 _11340_/Y VDD VSS sg13g2_a21o_1
XFILLER_138_699 VDD VSS sg13g2_decap_8
XFILLER_4_602 VDD VSS sg13g2_decap_8
XFILLER_10_1323 VDD VSS sg13g2_decap_8
XFILLER_125_316 VDD VSS sg13g2_decap_8
XFILLER_152_124 VDD VSS sg13g2_decap_8
XFILLER_125_349 VDD VSS sg13g2_decap_8
XFILLER_165_32 VDD VSS sg13g2_decap_8
XFILLER_181_967 VDD VSS sg13g2_decap_4
X_14060_ _14060_/Q clkload53/A _14060_/D _14060_/RESET_B VDD VSS sg13g2_dfrbpq_1
XFILLER_158_1249 VDD VSS sg13g2_decap_8
X_11272_ _11272_/Y _11273_/A1 _14460_/Q VDD VSS sg13g2_nand2b_1
XFILLER_3_123 VDD VSS sg13g2_decap_8
X_13011_ _13012_/A _13009_/A _13010_/B _13079_/C VDD VSS sg13g2_o21ai_1
XFILLER_84_1435 VDD VSS sg13g2_decap_8
XFILLER_4_679 VDD VSS sg13g2_decap_8
X_10223_ _14769_/D _14769_/Q _10219_/X _10222_/Y VDD VSS sg13g2_a21oi_1
XFILLER_121_500 VDD VSS sg13g2_decap_8
XFILLER_171_1427 VDD VSS sg13g2_decap_8
XFILLER_0_841 VDD VSS sg13g2_decap_8
X_10154_ _14731_/D _14731_/Q _10154_/A1 _10163_/S VDD VSS sg13g2_mux2_1
XFILLER_181_42 VDD VSS sg13g2_decap_8
XFILLER_88_981 VDD VSS sg13g2_decap_8
XFILLER_43_1132 VDD VSS sg13g2_decap_4
XFILLER_121_588 VDD VSS sg13g2_decap_8
X_14962_ _14962_/Q clkload25/A _14962_/D _14962_/RESET_B VDD VSS sg13g2_dfrbpq_1
X_10085_ _14665_/D _10152_/A1 _14665_/Q _10096_/S VDD VSS sg13g2_mux2_1
XFILLER_43_1154 VDD VSS sg13g2_decap_8
XFILLER_169_1301 VDD VSS sg13g2_decap_8
X_13913_ _13913_/Q _14745_/CLK _13913_/D _13913_/RESET_B VDD VSS sg13g2_dfrbpq_1
X_14893_ _14893_/Q _14893_/CLK _14893_/D _14893_/RESET_B VDD VSS sg13g2_dfrbpq_1
XFILLER_75_664 VDD VSS sg13g2_decap_8
XFILLER_75_675 VDD VSS sg13g2_fill_2
XFILLER_47_366 VDD VSS sg13g2_decap_8
XFILLER_35_506 VDD VSS sg13g2_fill_1
XFILLER_35_517 VDD VSS sg13g2_decap_8
X_13844_ _13844_/Q clkload15/A _13844_/D _13844_/RESET_B VDD VSS sg13g2_dfrbpq_1
XFILLER_75_697 VDD VSS sg13g2_decap_8
XFILLER_35_528 VDD VSS sg13g2_fill_1
XFILLER_21_1463 VDD VSS sg13g2_decap_8
XFILLER_169_1378 VDD VSS sg13g2_decap_8
XFILLER_21_1474 VDD VSS sg13g2_fill_1
XFILLER_62_325 VDD VSS sg13g2_decap_4
XFILLER_63_859 VDD VSS sg13g2_decap_8
XFILLER_62_358 VDD VSS sg13g2_fill_2
X_13775_ _13775_/Q clkload35/A _13775_/D _13775_/RESET_B VDD VSS sg13g2_dfrbpq_1
X_10987_ _10987_/Y _10987_/A _11001_/B VDD VSS sg13g2_nand2_1
XFILLER_31_712 VDD VSS sg13g2_decap_8
X_12726_ _12726_/X _14134_/Q _14166_/Q _14198_/Q _14230_/Q _12731_/S0 _12731_/S1 VDD
+ VSS sg13g2_mux4_1
XFILLER_95_7 VDD VSS sg13g2_decap_8
XFILLER_128_1086 VDD VSS sg13g2_fill_2
XFILLER_176_717 VDD VSS sg13g2_decap_8
XFILLER_70_391 VDD VSS sg13g2_decap_8
XFILLER_15_1201 VDD VSS sg13g2_decap_8
XFILLER_176_728 VDD VSS sg13g2_fill_2
X_14518__1684 _14518_/RESET_B VDD VSS sg13g2_tiehi
X_12657_ _12657_/X _13969_/Q _14001_/Q _14033_/Q _14065_/Q _12661_/S0 _12661_/S1 VDD
+ VSS sg13g2_mux4_1
XFILLER_31_767 VDD VSS sg13g2_decap_4
Xclkbuf_5_19__f_clk_i clkbuf_leaf_84_clk_i/A clkbuf_4_9_0_clk_i/X VDD VSS sg13g2_buf_16
XFILLER_12_970 VDD VSS sg13g2_decap_8
XFILLER_180_1280 VDD VSS sg13g2_decap_8
XFILLER_54_1283 VDD VSS sg13g2_decap_8
X_11608_ _11608_/X _11608_/A _11615_/B VDD VSS sg13g2_and2_1
XFILLER_89_1302 VDD VSS sg13g2_fill_2
XFILLER_106_1373 VDD VSS sg13g2_decap_8
X_12588_ _12588_/X _14252_/Q _14284_/Q _14316_/Q _14348_/Q _12592_/S0 _12592_/S1 VDD
+ VSS sg13g2_mux4_1
XFILLER_11_480 VDD VSS sg13g2_decap_8
XFILLER_156_452 VDD VSS sg13g2_decap_8
XFILLER_117_817 VDD VSS sg13g2_fill_1
XFILLER_15_1278 VDD VSS sg13g2_decap_8
XFILLER_8_963 VDD VSS sg13g2_decap_8
X_14327_ _14327_/Q clkload42/A _14327_/D _14327_/RESET_B VDD VSS sg13g2_dfrbpq_1
XFILLER_50_1169 VDD VSS sg13g2_decap_8
X_11539_ _11539_/Y _11551_/A1 _14660_/Q _11529_/B VDD VSS sg13g2_a21oi_1
XFILLER_7_462 VDD VSS sg13g2_decap_8
XFILLER_172_934 VDD VSS sg13g2_decap_8
X_14697__1505 _14697_/RESET_B VDD VSS sg13g2_tiehi
XFILLER_143_113 VDD VSS sg13g2_decap_8
XFILLER_176_1338 VDD VSS sg13g2_decap_8
XFILLER_172_967 VDD VSS sg13g2_fill_2
X_14258_ _14258_/Q _14546_/CLK _14258_/D _14258_/RESET_B VDD VSS sg13g2_dfrbpq_1
XFILLER_171_466 VDD VSS sg13g2_decap_8
X_13209_ _13209_/Y _13206_/Y _13207_/Y _13208_/Y VDD VSS sg13g2_a21oi_1
XFILLER_87_1081 VDD VSS sg13g2_decap_4
X_14189_ _14189_/Q _14637_/CLK _14189_/D _14189_/RESET_B VDD VSS sg13g2_dfrbpq_1
XFILLER_98_734 VDD VSS sg13g2_fill_2
Xfanout909 _12731_/S0 _12752_/S0 VDD VSS sg13g2_buf_1
XFILLER_112_544 VDD VSS sg13g2_decap_8
XFILLER_48_1087 VDD VSS sg13g2_decap_8
XFILLER_3_690 VDD VSS sg13g2_decap_8
XFILLER_140_864 VDD VSS sg13g2_decap_8
XFILLER_97_266 VDD VSS sg13g2_fill_1
XFILLER_61_1232 VDD VSS sg13g2_decap_8
XFILLER_57_108 VDD VSS sg13g2_fill_2
XFILLER_112_588 VDD VSS sg13g2_decap_8
X_08750_ _13668_/D _08753_/A1 _08748_/Y _08749_/Y VDD VSS sg13g2_a21oi_1
XFILLER_79_992 VDD VSS sg13g2_decap_8
XFILLER_6_1446 VDD VSS sg13g2_decap_8
XFILLER_66_620 VDD VSS sg13g2_decap_8
XFILLER_38_311 VDD VSS sg13g2_fill_2
XFILLER_152_1382 VDD VSS sg13g2_decap_8
XFILLER_22_1216 VDD VSS sg13g2_decap_8
XFILLER_17_0 VDD VSS sg13g2_decap_8
X_07701_ _07705_/C _15085_/Q _07701_/B VDD VSS sg13g2_nand2_1
XFILLER_26_1396 VDD VSS sg13g2_decap_8
X_08681_ _08681_/Y _08698_/B _08681_/B VDD VSS sg13g2_nor2_1
XFILLER_94_973 VDD VSS sg13g2_decap_8
XFILLER_65_141 VDD VSS sg13g2_decap_4
XFILLER_54_804 VDD VSS sg13g2_fill_1
XFILLER_113_1377 VDD VSS sg13g2_decap_4
XFILLER_66_675 VDD VSS sg13g2_fill_1
XFILLER_113_1388 VDD VSS sg13g2_decap_8
XFILLER_66_686 VDD VSS sg13g2_fill_1
X_07632_ _08203_/A _07888_/B VDD VSS sg13g2_inv_1
XFILLER_53_303 VDD VSS sg13g2_fill_2
XFILLER_0_1023 VDD VSS sg13g2_decap_8
XFILLER_183_1309 VDD VSS sg13g2_decap_8
XFILLER_0_70 VDD VSS sg13g2_decap_8
XFILLER_80_122 VDD VSS sg13g2_decap_4
XFILLER_81_689 VDD VSS sg13g2_decap_8
XFILLER_185_1180 VDD VSS sg13g2_decap_8
X_09302_ _13910_/D _13910_/Q _09933_/A1 _09306_/S VDD VSS sg13g2_mux2_1
XFILLER_94_1063 VDD VSS sg13g2_fill_2
XFILLER_80_177 VDD VSS sg13g2_decap_8
XFILLER_62_881 VDD VSS sg13g2_decap_8
XFILLER_142_1017 VDD VSS sg13g2_fill_1
XFILLER_179_577 VDD VSS sg13g2_fill_1
X_09233_ _13844_/D _10163_/A1 _13844_/Q _09233_/S VDD VSS sg13g2_mux2_1
XFILLER_179_599 VDD VSS sg13g2_decap_8
XFILLER_107_1159 VDD VSS sg13g2_decap_8
XFILLER_181_1099 VDD VSS sg13g2_decap_8
X_09164_ _09164_/X _14923_/Q _13245_/A _09164_/C _09164_/D VDD VSS sg13g2_and4_1
XFILLER_33_1345 VDD VSS sg13g2_decap_8
XFILLER_124_1473 VDD VSS sg13g2_fill_2
XFILLER_119_143 VDD VSS sg13g2_decap_8
X_08115_ _08115_/Y _08190_/A _08115_/B VDD VSS sg13g2_nor2_1
XFILLER_147_485 VDD VSS sg13g2_fill_2
XFILLER_174_260 VDD VSS sg13g2_decap_8
X_09095_ _09097_/B _09103_/C _09103_/D _14915_/Q VDD VSS sg13g2_a21oi_1
XFILLER_162_422 VDD VSS sg13g2_decap_8
XFILLER_79_18 VDD VSS sg13g2_decap_8
XFILLER_68_1419 VDD VSS sg13g2_decap_8
XFILLER_162_433 VDD VSS sg13g2_fill_2
X_08046_ _08046_/Y _08673_/B _08046_/B VDD VSS sg13g2_nand2b_1
XFILLER_162_455 VDD VSS sg13g2_decap_8
XFILLER_162_466 VDD VSS sg13g2_fill_1
XFILLER_150_617 VDD VSS sg13g2_decap_8
XFILLER_162_477 VDD VSS sg13g2_decap_8
XFILLER_1_616 VDD VSS sg13g2_decap_8
XFILLER_115_360 VDD VSS sg13g2_decap_8
X_13791__2411 _13791_/RESET_B VDD VSS sg13g2_tiehi
XFILLER_131_831 VDD VSS sg13g2_fill_2
XFILLER_135_35 VDD VSS sg13g2_decap_8
XFILLER_143_691 VDD VSS sg13g2_decap_8
XFILLER_66_1165 VDD VSS sg13g2_decap_8
XFILLER_0_126 VDD VSS sg13g2_decap_8
XFILLER_115_393 VDD VSS sg13g2_fill_2
XFILLER_88_222 VDD VSS sg13g2_decap_8
XFILLER_130_330 VDD VSS sg13g2_fill_1
Xhold3043 input2/A mem_axi_awready VDD VSS sg13g2_dlygate4sd3_1
XFILLER_88_244 VDD VSS sg13g2_decap_8
XFILLER_27_1138 VDD VSS sg13g2_decap_8
Xhold3054 input32/A mem_axi_rdata[6] VDD VSS sg13g2_dlygate4sd3_1
X_09997_ _14580_/D _10063_/A0 _14580_/Q _09997_/S VDD VSS sg13g2_mux2_1
XFILLER_77_918 VDD VSS sg13g2_decap_8
XFILLER_103_566 VDD VSS sg13g2_fill_1
XFILLER_153_1157 VDD VSS sg13g2_decap_8
Xhold3065 hold3065/X input34/X VDD VSS sg13g2_dlygate4sd3_1
XFILLER_95_28 VDD VSS sg13g2_decap_4
Xhold3076 input13/A mem_axi_rdata[18] VDD VSS sg13g2_dlygate4sd3_1
XFILLER_44_1452 VDD VSS sg13g2_decap_8
XFILLER_118_1299 VDD VSS sg13g2_decap_4
X_14835__2897 _14835_/RESET_B VDD VSS sg13g2_tiehi
Xhold3087 hold3087/X input7/X VDD VSS sg13g2_dlygate4sd3_1
X_08948_ _08948_/Y _10793_/A _10793_/B _15051_/Q VDD VSS sg13g2_nand3_1
XFILLER_28_11 VDD VSS sg13g2_decap_8
Xhold3098 input20/A mem_axi_rdata[24] VDD VSS sg13g2_dlygate4sd3_1
XFILLER_76_439 VDD VSS sg13g2_decap_8
XFILLER_131_1422 VDD VSS sg13g2_decap_8
XFILLER_9_1092 VDD VSS sg13g2_decap_8
XFILLER_40_1305 VDD VSS sg13g2_decap_8
XFILLER_29_344 VDD VSS sg13g2_decap_8
X_08879_ _08879_/X _08878_/X _11635_/A _08904_/S VDD VSS sg13g2_mux2_1
XFILLER_45_804 VDD VSS sg13g2_decap_8
X_14171__2031 _14171_/RESET_B VDD VSS sg13g2_tiehi
XFILLER_84_450 VDD VSS sg13g2_fill_2
X_10910_ _10910_/Y _10936_/A _10936_/D _11017_/A1 VDD VSS sg13g2_a21oi_1
XFILLER_151_67 VDD VSS sg13g2_fill_2
X_11890_ _11891_/A _14254_/Q _14286_/Q _14318_/Q _14350_/Q _11890_/S0 _11897_/C VDD
+ VSS sg13g2_mux4_1
XFILLER_71_122 VDD VSS sg13g2_fill_2
X_10841_ _10841_/Y _10841_/A _10841_/B _10841_/C VDD VSS sg13g2_nor3_1
XFILLER_77_1250 VDD VSS sg13g2_decap_8
XFILLER_72_667 VDD VSS sg13g2_decap_8
XFILLER_44_21 VDD VSS sg13g2_decap_8
XFILLER_72_678 VDD VSS sg13g2_fill_2
XFILLER_129_1340 VDD VSS sg13g2_decap_8
XFILLER_38_1223 VDD VSS sg13g2_decap_8
XFILLER_164_1231 VDD VSS sg13g2_decap_8
X_13560_ _15151_/D _15151_/Q _13559_/Y _13587_/B VDD VSS sg13g2_mux2_1
X_10772_ _10772_/X _10772_/A _10793_/B _10793_/A VDD VSS sg13g2_and3_1
XFILLER_73_1136 VDD VSS sg13g2_decap_8
XFILLER_158_706 VDD VSS sg13g2_decap_8
X_12511_ _12511_/X _12510_/X _12509_/X _12511_/S VDD VSS sg13g2_mux2_1
XFILLER_13_778 VDD VSS sg13g2_decap_8
XFILLER_185_525 VDD VSS sg13g2_decap_8
X_13491_ _13492_/A _15125_/Q _13490_/B _13414_/Y _15129_/Q _13490_/Y VDD VSS sg13g2_a221oi_1
XFILLER_12_266 VDD VSS sg13g2_decap_8
XFILLER_139_931 VDD VSS sg13g2_decap_8
XFILLER_90_1472 VDD VSS sg13g2_fill_2
X_15230_ _15230_/Q _15230_/CLK _15230_/D _15230_/RESET_B VDD VSS sg13g2_dfrbpq_1
XFILLER_9_749 VDD VSS sg13g2_decap_8
X_12442_ _12442_/Y _13687_/Q _12651_/A2 _12441_/X _12386_/A _12651_/C1 VDD VSS sg13g2_a221oi_1
XFILLER_51_1445 VDD VSS sg13g2_decap_8
XFILLER_166_750 VDD VSS sg13g2_decap_8
XFILLER_12_1418 VDD VSS sg13g2_decap_8
XFILLER_139_997 VDD VSS sg13g2_decap_8
XFILLER_176_42 VDD VSS sg13g2_decap_8
X_15161_ _15161_/Q _15162_/CLK _15161_/D _15161_/RESET_B VDD VSS sg13g2_dfrbpq_1
X_12373_ _12373_/Y _15120_/Q _12348_/A _12791_/A2 _12836_/B _13282_/A1 VDD VSS sg13g2_a221oi_1
XFILLER_125_102 VDD VSS sg13g2_decap_8
XFILLER_138_485 VDD VSS sg13g2_decap_8
XFILLER_125_113 VDD VSS sg13g2_fill_2
XFILLER_153_422 VDD VSS sg13g2_decap_8
XFILLER_10_1120 VDD VSS sg13g2_decap_8
X_14112_ _14112_/Q _14528_/CLK _14112_/D _14112_/RESET_B VDD VSS sg13g2_dfrbpq_1
X_11324_ _11326_/B _11328_/S0 _14173_/Q VDD VSS sg13g2_nand2b_1
X_15092_ _15092_/Q clkload72/A _15092_/D _15092_/RESET_B VDD VSS sg13g2_dfrbpq_1
XFILLER_5_966 VDD VSS sg13g2_decap_8
XFILLER_101_1270 VDD VSS sg13g2_fill_2
XFILLER_180_252 VDD VSS sg13g2_decap_8
XFILLER_125_168 VDD VSS sg13g2_decap_8
XFILLER_141_617 VDD VSS sg13g2_decap_4
XFILLER_88_1390 VDD VSS sg13g2_decap_8
XFILLER_181_797 VDD VSS sg13g2_fill_1
X_14043_ _14043_/Q clkload79/A _14043_/D _14043_/RESET_B VDD VSS sg13g2_dfrbpq_1
X_11255_ _11255_/Y _11255_/A _11255_/B VDD VSS sg13g2_nand2_1
XFILLER_4_476 VDD VSS sg13g2_decap_8
XFILLER_49_1352 VDD VSS sg13g2_decap_8
XFILLER_122_820 VDD VSS sg13g2_decap_8
XFILLER_10_1197 VDD VSS sg13g2_decap_8
XFILLER_140_127 VDD VSS sg13g2_decap_8
XFILLER_84_1254 VDD VSS sg13g2_decap_8
XFILLER_106_393 VDD VSS sg13g2_decap_8
XFILLER_136_1344 VDD VSS sg13g2_decap_4
XFILLER_171_1224 VDD VSS sg13g2_decap_8
X_14381__1821 _14381_/RESET_B VDD VSS sg13g2_tiehi
X_10206_ _14761_/D _15200_/D _10206_/A1 _13653_/S VDD VSS sg13g2_mux2_1
XFILLER_121_330 VDD VSS sg13g2_decap_8
X_11186_ _11186_/Y _11186_/A _11186_/B VDD VSS sg13g2_nand2_1
XFILLER_122_875 VDD VSS sg13g2_fill_1
XFILLER_45_1249 VDD VSS sg13g2_decap_8
XFILLER_95_715 VDD VSS sg13g2_fill_1
X_10137_ _10137_/Y _10137_/A _10137_/B _10137_/C VDD VSS sg13g2_nor3_1
XFILLER_94_214 VDD VSS sg13g2_decap_8
XFILLER_39_119 VDD VSS sg13g2_decap_8
XFILLER_0_693 VDD VSS sg13g2_decap_8
XFILLER_10_7 VDD VSS sg13g2_decap_8
XFILLER_134_1090 VDD VSS sg13g2_decap_8
X_14945_ _14945_/Q clkload69/A _14945_/D _14945_/RESET_B VDD VSS sg13g2_dfrbpq_1
X_10068_ _14649_/D _10101_/A0 _14649_/Q _10068_/S VDD VSS sg13g2_mux2_1
XFILLER_82_409 VDD VSS sg13g2_fill_2
X_14001__2201 _14001_/RESET_B VDD VSS sg13g2_tiehi
XFILLER_75_472 VDD VSS sg13g2_decap_4
XFILLER_63_623 VDD VSS sg13g2_decap_8
XFILLER_35_314 VDD VSS sg13g2_decap_8
XFILLER_21_1260 VDD VSS sg13g2_decap_8
X_14876_ _14876_/Q clkload83/A _14876_/D _14876_/RESET_B VDD VSS sg13g2_dfrbpq_1
XFILLER_47_185 VDD VSS sg13g2_decap_8
XFILLER_169_1175 VDD VSS sg13g2_decap_8
XFILLER_62_133 VDD VSS sg13g2_decap_8
XFILLER_51_807 VDD VSS sg13g2_decap_8
XFILLER_1_1365 VDD VSS sg13g2_decap_8
X_13827_ _13827_/Q clkload17/A _13827_/D _13827_/RESET_B VDD VSS sg13g2_dfrbpq_1
XFILLER_147_1440 VDD VSS sg13g2_decap_8
XFILLER_182_1320 VDD VSS sg13g2_decap_8
XFILLER_16_583 VDD VSS sg13g2_decap_4
X_13758_ _13758_/Q clkload60/A _13758_/D _13758_/RESET_B VDD VSS sg13g2_dfrbpq_1
XFILLER_91_1225 VDD VSS sg13g2_decap_8
XFILLER_62_199 VDD VSS sg13g2_decap_8
XFILLER_31_520 VDD VSS sg13g2_decap_8
XFILLER_56_1367 VDD VSS sg13g2_decap_8
XFILLER_149_717 VDD VSS sg13g2_decap_8
XFILLER_91_1258 VDD VSS sg13g2_decap_8
XFILLER_17_1329 VDD VSS sg13g2_decap_8
X_12709_ _12722_/A _07737_/A _07737_/B _15015_/Q VDD VSS sg13g2_a21oi_1
XFILLER_182_1397 VDD VSS sg13g2_decap_8
X_13689_ _13689_/Q _15212_/CLK _13689_/D _13689_/RESET_B VDD VSS sg13g2_dfrbpq_1
X_14034__2168 _14034_/RESET_B VDD VSS sg13g2_tiehi
XFILLER_148_227 VDD VSS sg13g2_decap_8
XFILLER_148_238 VDD VSS sg13g2_fill_1
XFILLER_129_463 VDD VSS sg13g2_decap_8
XFILLER_15_1075 VDD VSS sg13g2_decap_8
XFILLER_8_760 VDD VSS sg13g2_decap_8
XFILLER_156_260 VDD VSS sg13g2_decap_8
XFILLER_184_580 VDD VSS sg13g2_decap_8
XFILLER_172_731 VDD VSS sg13g2_decap_8
XFILLER_116_135 VDD VSS sg13g2_fill_1
XFILLER_144_444 VDD VSS sg13g2_decap_8
XFILLER_176_1135 VDD VSS sg13g2_decap_8
XFILLER_116_157 VDD VSS sg13g2_decap_8
XFILLER_171_241 VDD VSS sg13g2_fill_2
XFILLER_104_308 VDD VSS sg13g2_decap_8
XFILLER_67_1430 VDD VSS sg13g2_decap_8
X_09920_ _14505_/D _14505_/Q _09920_/A1 _09931_/S VDD VSS sg13g2_mux2_1
XFILLER_144_488 VDD VSS sg13g2_decap_8
XFILLER_160_937 VDD VSS sg13g2_fill_2
XFILLER_132_639 VDD VSS sg13g2_fill_2
XFILLER_154_1422 VDD VSS sg13g2_decap_8
XFILLER_67_1474 VDD VSS sg13g2_fill_1
Xfanout706 _11765_/A _07656_/Y VDD VSS sg13g2_buf_1
XFILLER_63_1316 VDD VSS sg13g2_decap_8
XFILLER_113_853 VDD VSS sg13g2_fill_1
X_15194__2792 _15194_/RESET_B VDD VSS sg13g2_tiehi
Xfanout717 _11875_/B fanout719/X VDD VSS sg13g2_buf_1
X_09851_ _14438_/D _14438_/Q _10082_/A0 _09865_/S VDD VSS sg13g2_mux2_1
XFILLER_115_1406 VDD VSS sg13g2_decap_8
Xfanout728 _12290_/S0 _07655_/Y VDD VSS sg13g2_buf_1
XFILLER_112_341 VDD VSS sg13g2_decap_8
XFILLER_140_650 VDD VSS sg13g2_fill_1
Xfanout739 _11355_/B1 _12112_/B1 VDD VSS sg13g2_buf_1
XFILLER_28_1469 VDD VSS sg13g2_decap_4
XFILLER_115_1428 VDD VSS sg13g2_decap_8
XFILLER_140_672 VDD VSS sg13g2_decap_4
X_08802_ _13685_/D _08802_/A _08802_/B VDD VSS sg13g2_nor2_1
XFILLER_150_1319 VDD VSS sg13g2_decap_8
XFILLER_58_428 VDD VSS sg13g2_decap_8
X_09782_ _14371_/D _09914_/A1 _14371_/Q _09795_/S VDD VSS sg13g2_mux2_1
XFILLER_100_536 VDD VSS sg13g2_decap_4
XFILLER_6_1243 VDD VSS sg13g2_decap_8
X_08733_ _08733_/Y _08751_/A1 _07720_/B _15199_/Q VDD VSS sg13g2_o21ai_1
XFILLER_61_1062 VDD VSS sg13g2_fill_2
XFILLER_26_1193 VDD VSS sg13g2_decap_8
XFILLER_113_1152 VDD VSS sg13g2_decap_8
XFILLER_22_1057 VDD VSS sg13g2_decap_8
XFILLER_66_461 VDD VSS sg13g2_fill_2
XFILLER_38_163 VDD VSS sg13g2_decap_8
X_08664_ _08664_/Y _08647_/Y _08678_/C _08698_/B VDD VSS sg13g2_a21oi_1
XFILLER_96_1125 VDD VSS sg13g2_decap_8
XFILLER_82_932 VDD VSS sg13g2_decap_8
X_14244__1958 _14244_/RESET_B VDD VSS sg13g2_tiehi
XFILLER_183_1106 VDD VSS sg13g2_decap_8
X_07615_ _07615_/Y _14945_/Q VDD VSS sg13g2_inv_1
XFILLER_81_442 VDD VSS sg13g2_decap_8
XFILLER_148_1237 VDD VSS sg13g2_fill_1
X_08595_ _08596_/D _08036_/B _08592_/X _08590_/Y VDD VSS sg13g2_a21oi_1
XFILLER_82_987 VDD VSS sg13g2_decap_8
XFILLER_74_1401 VDD VSS sg13g2_decap_8
XFILLER_121_59 VDD VSS sg13g2_decap_8
XFILLER_53_199 VDD VSS sg13g2_fill_1
X_15139__2702 _15139_/RESET_B VDD VSS sg13g2_tiehi
XFILLER_161_1415 VDD VSS sg13g2_decap_8
XFILLER_35_1429 VDD VSS sg13g2_decap_8
XFILLER_14_35 VDD VSS sg13g2_decap_8
XFILLER_50_873 VDD VSS sg13g2_decap_8
X_09216_ _13827_/D _10146_/A1 _13827_/Q _09229_/S VDD VSS sg13g2_mux2_1
XFILLER_139_249 VDD VSS sg13g2_decap_8
XFILLER_33_1142 VDD VSS sg13g2_decap_8
XFILLER_182_506 VDD VSS sg13g2_fill_1
XFILLER_120_1112 VDD VSS sg13g2_fill_1
X_09147_ _09147_/Y _15247_/Q _09147_/B VDD VSS sg13g2_nand2b_1
XFILLER_147_260 VDD VSS sg13g2_decap_8
XFILLER_159_1311 VDD VSS sg13g2_decap_8
XFILLER_68_1216 VDD VSS sg13g2_decap_8
XFILLER_163_753 VDD VSS sg13g2_decap_8
XFILLER_107_146 VDD VSS sg13g2_decap_8
XFILLER_151_904 VDD VSS sg13g2_decap_8
X_09078_ _09078_/Y _15237_/Q _09078_/B VDD VSS sg13g2_nand2b_1
XFILLER_136_989 VDD VSS sg13g2_fill_2
X_14189__2013 _14189_/RESET_B VDD VSS sg13g2_tiehi
XFILLER_146_45 VDD VSS sg13g2_decap_8
XFILLER_2_903 VDD VSS sg13g2_decap_8
XFILLER_123_617 VDD VSS sg13g2_decap_8
XFILLER_155_1208 VDD VSS sg13g2_decap_8
XFILLER_159_1388 VDD VSS sg13g2_decap_8
X_08029_ _08029_/Y _08212_/A _08597_/B VDD VSS sg13g2_nor2_1
XFILLER_146_78 VDD VSS sg13g2_decap_4
XFILLER_1_413 VDD VSS sg13g2_decap_8
XFILLER_89_520 VDD VSS sg13g2_decap_8
XFILLER_81_1405 VDD VSS sg13g2_decap_8
X_11040_ _11042_/C _11052_/A _11052_/B VDD VSS sg13g2_nor2_1
XFILLER_104_864 VDD VSS sg13g2_fill_1
XFILLER_131_661 VDD VSS sg13g2_decap_8
XFILLER_39_32 VDD VSS sg13g2_decap_8
XFILLER_103_363 VDD VSS sg13g2_decap_8
XFILLER_162_11 VDD VSS sg13g2_decap_8
XFILLER_7_1029 VDD VSS sg13g2_decap_8
XFILLER_118_1096 VDD VSS sg13g2_fill_1
XFILLER_162_88 VDD VSS sg13g2_decap_8
X_12991_ _12993_/C _14905_/Q _13682_/Q _12959_/X _12987_/Y _12990_/X VDD VSS sg13g2_a221oi_1
XFILLER_58_973 VDD VSS sg13g2_decap_4
XFILLER_29_141 VDD VSS sg13g2_fill_2
XFILLER_131_1274 VDD VSS sg13g2_fill_1
XFILLER_73_921 VDD VSS sg13g2_decap_8
XFILLER_58_995 VDD VSS sg13g2_decap_4
X_14730_ _14730_/Q clkload27/A _14730_/D _14730_/RESET_B VDD VSS sg13g2_dfrbpq_1
X_11942_ _11942_/Y _11969_/A _14192_/Q VDD VSS sg13g2_nand2b_1
XFILLER_131_1285 VDD VSS sg13g2_decap_8
XFILLER_18_848 VDD VSS sg13g2_fill_2
XFILLER_166_1304 VDD VSS sg13g2_decap_8
XFILLER_40_1179 VDD VSS sg13g2_decap_8
XFILLER_79_1367 VDD VSS sg13g2_decap_8
XFILLER_55_53 VDD VSS sg13g2_decap_8
XFILLER_75_1209 VDD VSS sg13g2_decap_8
X_14661_ _14661_/Q clkload16/A _14661_/D _14661_/RESET_B VDD VSS sg13g2_dfrbpq_1
XFILLER_169_0 VDD VSS sg13g2_decap_8
X_11873_ _11873_/Y _11869_/Y _11870_/Y _11872_/Y _11871_/Y _11875_/B VDD VSS sg13g2_a221oi_1
X_14996__2614 _14996_/RESET_B VDD VSS sg13g2_tiehi
XFILLER_73_998 VDD VSS sg13g2_fill_2
XFILLER_45_689 VDD VSS sg13g2_decap_4
X_13612_ _13613_/D _13283_/A _15053_/Q _10173_/B VDD VSS sg13g2_o21ai_1
XFILLER_60_626 VDD VSS sg13g2_fill_1
X_10824_ _10824_/Y _10818_/B _10801_/Y _10823_/Y _10815_/Y _10824_/C1 VDD VSS sg13g2_a221oi_1
X_14592_ _14592_/Q clkload24/A _14592_/D _14592_/RESET_B VDD VSS sg13g2_dfrbpq_1
XFILLER_125_1012 VDD VSS sg13g2_decap_8
XFILLER_186_812 VDD VSS sg13g2_decap_8
XFILLER_164_1072 VDD VSS sg13g2_decap_8
X_13543_ _13543_/Y _13543_/A _13554_/S VDD VSS sg13g2_nor2_1
XFILLER_41_862 VDD VSS sg13g2_decap_8
X_10755_ _10756_/A _13142_/A _11102_/B _11154_/B1 _10754_/X VDD VSS sg13g2_a22oi_1
XFILLER_13_564 VDD VSS sg13g2_decap_8
XFILLER_164_1083 VDD VSS sg13g2_fill_1
XFILLER_40_350 VDD VSS sg13g2_decap_8
XFILLER_185_322 VDD VSS sg13g2_decap_8
X_14399__1803 _14399_/RESET_B VDD VSS sg13g2_tiehi
XFILLER_71_63 VDD VSS sg13g2_decap_8
XFILLER_9_546 VDD VSS sg13g2_decap_8
XFILLER_71_85 VDD VSS sg13g2_fill_2
XFILLER_158_569 VDD VSS sg13g2_decap_8
XFILLER_16_1351 VDD VSS sg13g2_decap_8
X_13474_ _15111_/D _15177_/D _15111_/Q _13653_/S VDD VSS sg13g2_mux2_1
XFILLER_90_1280 VDD VSS sg13g2_decap_8
XFILLER_186_889 VDD VSS sg13g2_decap_8
X_10686_ _14898_/D _10886_/B1 _10827_/B _10685_/Y VDD VSS sg13g2_o21ai_1
XFILLER_51_1242 VDD VSS sg13g2_decap_8
X_15213_ _15213_/Q clkload82/A _15213_/D _15213_/RESET_B VDD VSS sg13g2_dfrbpq_1
XFILLER_12_1215 VDD VSS sg13g2_decap_8
X_12425_ _12425_/X _14688_/Q _14720_/Q _13760_/Q _13792_/Q _12425_/S0 _12425_/S1 VDD
+ VSS sg13g2_mux4_1
XFILLER_185_399 VDD VSS sg13g2_decap_8
XFILLER_126_411 VDD VSS sg13g2_decap_8
X_13665__2565 _13665_/RESET_B VDD VSS sg13g2_tiehi
XFILLER_177_1422 VDD VSS sg13g2_decap_8
X_15144_ _15144_/Q clkload34/A _15144_/D _15144_/RESET_B VDD VSS sg13g2_dfrbpq_1
X_12356_ _12356_/Y _12415_/A _12356_/B VDD VSS sg13g2_nand2_1
XFILLER_103_1398 VDD VSS sg13g2_decap_8
XFILLER_142_904 VDD VSS sg13g2_fill_1
XFILLER_5_763 VDD VSS sg13g2_decap_8
XFILLER_58_7 VDD VSS sg13g2_decap_8
XFILLER_141_403 VDD VSS sg13g2_fill_2
XFILLER_86_1349 VDD VSS sg13g2_decap_8
XFILLER_138_1428 VDD VSS sg13g2_decap_8
X_11307_ _11307_/Y _11310_/A1 _13725_/Q VDD VSS sg13g2_nand2b_1
XFILLER_99_317 VDD VSS sg13g2_decap_8
X_15075_ _15075_/Q clkload72/A _15075_/D _15075_/RESET_B VDD VSS sg13g2_dfrbpq_1
XFILLER_113_116 VDD VSS sg13g2_decap_8
X_12287_ _12287_/X _14393_/Q _14425_/Q _14489_/Q _14521_/Q _12288_/S0 _12288_/S1 VDD
+ VSS sg13g2_mux4_1
XFILLER_4_273 VDD VSS sg13g2_decap_8
XFILLER_142_959 VDD VSS sg13g2_decap_8
X_13708__2494 _13708_/RESET_B VDD VSS sg13g2_tiehi
X_14916__2735 _14916_/RESET_B VDD VSS sg13g2_tiehi
X_14026_ _14026_/Q clkload26/A _14026_/D _14026_/RESET_B VDD VSS sg13g2_dfrbpq_1
X_11238_ _11292_/A _12799_/A _15123_/Q VDD VSS sg13g2_nand2_1
XFILLER_171_1021 VDD VSS sg13g2_decap_8
XFILLER_45_1046 VDD VSS sg13g2_decap_8
XFILLER_110_823 VDD VSS sg13g2_decap_8
XFILLER_1_980 VDD VSS sg13g2_decap_8
XFILLER_68_737 VDD VSS sg13g2_fill_1
X_11169_ _14953_/D _11168_/X _11167_/Y _11156_/Y VDD VSS sg13g2_o21ai_1
XFILLER_23_1311 VDD VSS sg13g2_decap_8
XFILLER_0_490 VDD VSS sg13g2_decap_8
XFILLER_49_962 VDD VSS sg13g2_decap_8
X_13887__2315 _13887_/RESET_B VDD VSS sg13g2_tiehi
XFILLER_114_1472 VDD VSS sg13g2_decap_8
X_14949__2669 _14949_/RESET_B VDD VSS sg13g2_tiehi
XFILLER_82_217 VDD VSS sg13g2_decap_8
XFILLER_48_472 VDD VSS sg13g2_decap_4
XFILLER_64_932 VDD VSS sg13g2_fill_1
XFILLER_23_1388 VDD VSS sg13g2_decap_8
X_14928_ _14928_/Q _14930_/CLK _14928_/D _14928_/RESET_B VDD VSS sg13g2_dfrbpq_1
XFILLER_97_1456 VDD VSS sg13g2_decap_4
XFILLER_184_1415 VDD VSS sg13g2_decap_8
XFILLER_36_656 VDD VSS sg13g2_decap_8
XFILLER_93_1309 VDD VSS sg13g2_decap_8
X_14859_ _14859_/Q clkload90/A _14859_/D _14859_/RESET_B VDD VSS sg13g2_dfrbpq_1
XFILLER_1_1162 VDD VSS sg13g2_decap_8
X_14791__2945 _14791_/RESET_B VDD VSS sg13g2_tiehi
XFILLER_91_784 VDD VSS sg13g2_decap_8
XFILLER_35_166 VDD VSS sg13g2_fill_1
XFILLER_51_626 VDD VSS sg13g2_decap_8
X_08380_ _08380_/Y _08484_/B _08378_/Y _08379_/Y VDD VSS sg13g2_o21ai_1
XFILLER_50_114 VDD VSS sg13g2_decap_8
XFILLER_108_1221 VDD VSS sg13g2_decap_8
XFILLER_149_514 VDD VSS sg13g2_decap_4
XFILLER_56_1164 VDD VSS sg13g2_decap_8
XFILLER_17_1126 VDD VSS sg13g2_decap_8
XFILLER_177_856 VDD VSS sg13g2_decap_8
XFILLER_182_1194 VDD VSS sg13g2_decap_8
XFILLER_108_1276 VDD VSS sg13g2_decap_8
XFILLER_176_344 VDD VSS sg13g2_decap_8
XFILLER_149_569 VDD VSS sg13g2_decap_8
XFILLER_118_912 VDD VSS sg13g2_fill_1
X_15127__2728 _15127_/RESET_B VDD VSS sg13g2_tiehi
X_09001_ _09001_/X _09031_/A _08998_/X _09000_/Y VDD VSS sg13g2_a21o_1
XFILLER_178_1208 VDD VSS sg13g2_decap_8
XFILLER_117_422 VDD VSS sg13g2_decap_8
XFILLER_129_293 VDD VSS sg13g2_decap_4
Xclkbuf_4_13_0_clk_i clkbuf_4_13_0_clk_i/X clkbuf_0_clk_i/X VDD VSS sg13g2_buf_8
XFILLER_133_926 VDD VSS sg13g2_decap_8
XFILLER_172_561 VDD VSS sg13g2_decap_8
XFILLER_132_403 VDD VSS sg13g2_fill_1
XFILLER_160_712 VDD VSS sg13g2_decap_4
XFILLER_104_105 VDD VSS sg13g2_decap_8
XFILLER_132_414 VDD VSS sg13g2_fill_2
XFILLER_172_583 VDD VSS sg13g2_decap_8
XFILLER_132_447 VDD VSS sg13g2_fill_2
XFILLER_63_1102 VDD VSS sg13g2_decap_4
X_09903_ _14489_/D _09903_/A0 _14489_/Q _09903_/S VDD VSS sg13g2_mux2_1
XFILLER_119_1350 VDD VSS sg13g2_decap_8
Xfanout503 _08765_/A1 _08729_/Y VDD VSS sg13g2_buf_1
Xfanout514 _13652_/S _13656_/S VDD VSS sg13g2_buf_1
Xfanout525 _13590_/B fanout528/X VDD VSS sg13g2_buf_1
XFILLER_8_1327 VDD VSS sg13g2_decap_8
XFILLER_86_501 VDD VSS sg13g2_decap_8
XFILLER_63_1135 VDD VSS sg13g2_decap_8
XFILLER_115_1214 VDD VSS sg13g2_decap_8
Xfanout536 _11903_/C1 _11235_/X VDD VSS sg13g2_buf_1
XFILLER_28_1266 VDD VSS sg13g2_decap_8
Xfanout547 _10005_/A0 _10071_/A0 VDD VSS sg13g2_buf_1
X_09834_ _14422_/D _09834_/A0 _14422_/Q _09838_/S VDD VSS sg13g2_mux2_1
XFILLER_113_694 VDD VSS sg13g2_decap_8
XFILLER_59_748 VDD VSS sg13g2_decap_8
Xfanout558 _08810_/B fanout565/X VDD VSS sg13g2_buf_1
XFILLER_86_534 VDD VSS sg13g2_decap_4
XFILLER_115_1247 VDD VSS sg13g2_decap_4
Xfanout569 _08539_/B1 _08035_/X VDD VSS sg13g2_buf_1
XFILLER_58_247 VDD VSS sg13g2_fill_2
XFILLER_41_1411 VDD VSS sg13g2_decap_8
X_09765_ _14355_/D _14355_/Q _10095_/A0 _09771_/S VDD VSS sg13g2_mux2_1
XFILLER_6_1040 VDD VSS sg13g2_decap_8
XFILLER_100_366 VDD VSS sg13g2_decap_8
X_14477__1725 _14477_/RESET_B VDD VSS sg13g2_tiehi
XFILLER_55_921 VDD VSS sg13g2_decap_8
XFILLER_100_388 VDD VSS sg13g2_decap_8
X_08716_ _15211_/D _15190_/D _12346_/A _13655_/S VDD VSS sg13g2_mux2_1
XFILLER_55_932 VDD VSS sg13g2_fill_1
X_09696_ _14288_/D _09762_/A1 _14288_/Q _09696_/S VDD VSS sg13g2_mux2_1
XFILLER_148_1012 VDD VSS sg13g2_decap_8
XFILLER_26_133 VDD VSS sg13g2_decap_8
X_08647_ _08647_/Y _08576_/Y _08641_/Y _08646_/Y VDD VSS sg13g2_a21oi_1
XFILLER_81_250 VDD VSS sg13g2_decap_8
XFILLER_42_615 VDD VSS sg13g2_decap_8
XFILLER_27_689 VDD VSS sg13g2_decap_4
XFILLER_109_1018 VDD VSS sg13g2_decap_8
XFILLER_70_946 VDD VSS sg13g2_fill_2
XFILLER_148_1078 VDD VSS sg13g2_fill_2
XFILLER_14_339 VDD VSS sg13g2_decap_8
X_08578_ _08578_/Y _08612_/S _08576_/Y _08577_/Y VDD VSS sg13g2_a21oi_1
X_14692__1510 _14692_/RESET_B VDD VSS sg13g2_tiehi
XFILLER_161_1212 VDD VSS sg13g2_decap_8
XFILLER_186_119 VDD VSS sg13g2_decap_8
XFILLER_23_862 VDD VSS sg13g2_decap_8
XFILLER_165_1392 VDD VSS sg13g2_decap_8
XFILLER_74_1275 VDD VSS sg13g2_decap_8
XFILLER_35_1226 VDD VSS sg13g2_decap_8
XFILLER_167_333 VDD VSS sg13g2_decap_8
XFILLER_179_193 VDD VSS sg13g2_decap_8
XFILLER_122_1207 VDD VSS sg13g2_decap_8
X_10540_ _10540_/Y _13273_/A _10547_/D _10343_/C VDD VSS sg13g2_o21ai_1
XFILLER_161_1289 VDD VSS sg13g2_decap_8
XFILLER_183_826 VDD VSS sg13g2_decap_8
XFILLER_157_11 VDD VSS sg13g2_decap_8
XFILLER_167_377 VDD VSS sg13g2_decap_8
XFILLER_10_567 VDD VSS sg13g2_decap_8
XFILLER_127_219 VDD VSS sg13g2_fill_2
X_10471_ _10492_/C _14845_/Q _10500_/A _10471_/C _10471_/D VDD VSS sg13g2_and4_1
XFILLER_183_859 VDD VSS sg13g2_decap_8
XFILLER_136_742 VDD VSS sg13g2_decap_8
XFILLER_182_347 VDD VSS sg13g2_decap_8
X_12210_ _12217_/B _12219_/S _12210_/B VDD VSS sg13g2_nor2_1
X_13190_ _13191_/C _14918_/Q _13669_/Q _13225_/B VDD VSS sg13g2_nand3_1
X_13965__2237 _13965_/RESET_B VDD VSS sg13g2_tiehi
XFILLER_136_786 VDD VSS sg13g2_decap_8
XFILLER_151_712 VDD VSS sg13g2_decap_8
XFILLER_68_1046 VDD VSS sg13g2_decap_8
XFILLER_2_700 VDD VSS sg13g2_decap_8
X_12141_ _12141_/X _12135_/X _12136_/X _12138_/X _12137_/X _12036_/B _12142_/S1 VDD
+ VSS sg13g2_mux4_1
XFILLER_159_1185 VDD VSS sg13g2_decap_8
XFILLER_163_594 VDD VSS sg13g2_decap_8
XFILLER_1_210 VDD VSS sg13g2_decap_8
XFILLER_151_756 VDD VSS sg13g2_fill_1
XFILLER_173_21 VDD VSS sg13g2_decap_8
XFILLER_123_458 VDD VSS sg13g2_fill_1
X_12072_ _12072_/X _13843_/Q _13875_/Q _13907_/Q _13939_/Q _12072_/S0 _12072_/S1 VDD
+ VSS sg13g2_mux4_1
XFILLER_46_1344 VDD VSS sg13g2_decap_8
XFILLER_2_777 VDD VSS sg13g2_decap_8
XFILLER_89_361 VDD VSS sg13g2_fill_1
X_11023_ _11023_/Y _11023_/A _11024_/B VDD VSS sg13g2_nor2_1
XFILLER_132_992 VDD VSS sg13g2_fill_2
XFILLER_131_480 VDD VSS sg13g2_decap_8
XFILLER_173_98 VDD VSS sg13g2_decap_8
XFILLER_1_287 VDD VSS sg13g2_decap_8
X_16880_ _16880_/X _16880_/A VDD VSS sg13g2_buf_1
XFILLER_42_1219 VDD VSS sg13g2_decap_8
XFILLER_49_236 VDD VSS sg13g2_fill_2
XFILLER_172_1396 VDD VSS sg13g2_decap_8
XFILLER_81_1279 VDD VSS sg13g2_decap_8
XFILLER_2_49 VDD VSS sg13g2_decap_8
XFILLER_133_1369 VDD VSS sg13g2_decap_8
XFILLER_106_92 VDD VSS sg13g2_decap_8
XFILLER_44_1090 VDD VSS sg13g2_fill_2
XFILLER_66_63 VDD VSS sg13g2_decap_8
XFILLER_92_526 VDD VSS sg13g2_fill_1
XFILLER_46_932 VDD VSS sg13g2_decap_8
X_12974_ _12975_/B _12957_/A _13683_/Q _12960_/Y VDD VSS sg13g2_a21oi_1
XFILLER_46_943 VDD VSS sg13g2_fill_2
XFILLER_57_291 VDD VSS sg13g2_decap_4
XFILLER_166_1101 VDD VSS sg13g2_fill_2
XFILLER_17_133 VDD VSS sg13g2_decap_8
XFILLER_18_656 VDD VSS sg13g2_fill_2
X_14713_ _14713_/Q clkload43/A _14713_/D _14713_/RESET_B VDD VSS sg13g2_dfrbpq_1
X_11925_ _11925_/X _13967_/Q _13999_/Q _14031_/Q _14063_/Q _12072_/S0 _12072_/S1 VDD
+ VSS sg13g2_mux4_1
XFILLER_33_604 VDD VSS sg13g2_decap_8
Xclkbuf_leaf_1_clk_i _14727_/CLK clkbuf_leaf_2_clk_i/A VDD VSS sg13g2_buf_8
XFILLER_61_924 VDD VSS sg13g2_decap_8
XFILLER_46_998 VDD VSS sg13g2_decap_8
XFILLER_33_615 VDD VSS sg13g2_fill_2
XFILLER_79_1197 VDD VSS sg13g2_decap_8
XFILLER_72_272 VDD VSS sg13g2_fill_1
XFILLER_75_1039 VDD VSS sg13g2_decap_8
XFILLER_45_497 VDD VSS sg13g2_decap_8
X_14644_ _14644_/Q _15005_/CLK _14644_/D _14644_/RESET_B VDD VSS sg13g2_dfrbpq_1
X_11856_ _11858_/B _11957_/A _11856_/B VDD VSS sg13g2_nor2_1
XFILLER_92_1320 VDD VSS sg13g2_decap_8
XFILLER_166_1178 VDD VSS sg13g2_decap_8
XFILLER_18_1413 VDD VSS sg13g2_decap_8
XFILLER_14_851 VDD VSS sg13g2_decap_8
XFILLER_183_1470 VDD VSS sg13g2_decap_4
X_10807_ _10807_/Y _12346_/A _10807_/B _10807_/C VDD VSS sg13g2_nand3_1
XFILLER_60_467 VDD VSS sg13g2_decap_4
X_14575_ _14575_/Q clkload34/A _14575_/D _14575_/RESET_B VDD VSS sg13g2_dfrbpq_1
X_11787_ _11787_/X _14123_/Q _14155_/Q _14187_/Q _14219_/Q _11788_/S0 _12091_/C VDD
+ VSS sg13g2_mux4_1
XFILLER_92_1375 VDD VSS sg13g2_decap_4
XFILLER_13_361 VDD VSS sg13g2_decap_8
XFILLER_158_322 VDD VSS sg13g2_fill_1
XFILLER_159_845 VDD VSS sg13g2_fill_2
XFILLER_140_1307 VDD VSS sg13g2_decap_4
XFILLER_159_878 VDD VSS sg13g2_fill_2
X_13526_ _13526_/Y _13525_/A _13563_/C _14999_/Q _13546_/B2 VDD VSS sg13g2_a22oi_1
X_10738_ _14912_/D _11045_/B1 _11024_/B _10737_/Y VDD VSS sg13g2_o21ai_1
XFILLER_9_343 VDD VSS sg13g2_decap_8
XFILLER_186_686 VDD VSS sg13g2_decap_8
XFILLER_12_1012 VDD VSS sg13g2_decap_8
X_13457_ _15105_/D _13449_/X _13456_/X _13446_/Y VDD VSS sg13g2_o21ai_1
XFILLER_51_1061 VDD VSS sg13g2_decap_8
X_10669_ _10807_/B _14926_/Q _08971_/X _10669_/S VDD VSS sg13g2_mux2_1
XFILLER_185_196 VDD VSS sg13g2_decap_8
X_12408_ _12408_/X _14559_/Q _14591_/Q _14623_/Q _14655_/Q _12411_/S0 _12411_/S1 VDD
+ VSS sg13g2_mux4_1
XFILLER_161_509 VDD VSS sg13g2_decap_8
X_13388_ _13391_/C _15127_/Q _13388_/B VDD VSS sg13g2_nand2_1
XFILLER_154_561 VDD VSS sg13g2_fill_2
X_14555__1647 _14555_/RESET_B VDD VSS sg13g2_tiehi
Xoutput106 mem_axi_wdata[11] _15143_/Q VDD VSS sg13g2_buf_1
XFILLER_103_1195 VDD VSS sg13g2_decap_8
XFILLER_127_786 VDD VSS sg13g2_decap_8
XFILLER_142_712 VDD VSS sg13g2_fill_1
XFILLER_114_414 VDD VSS sg13g2_decap_4
XFILLER_12_1089 VDD VSS sg13g2_decap_8
Xoutput117 mem_axi_wdata[21] _15153_/Q VDD VSS sg13g2_buf_1
XFILLER_86_1146 VDD VSS sg13g2_fill_1
XFILLER_5_560 VDD VSS sg13g2_decap_8
X_15127_ _15127_/Q _15212_/CLK _15127_/D _15127_/RESET_B VDD VSS sg13g2_dfrbpq_1
Xoutput128 mem_axi_wdata[31] _15163_/Q VDD VSS sg13g2_buf_1
X_12339_ _12340_/A _07684_/B _12338_/Y _11724_/B VDD VSS sg13g2_o21ai_1
XFILLER_99_114 VDD VSS sg13g2_decap_8
Xoutput139 mem_axi_wstrb[3] _15167_/Q VDD VSS sg13g2_buf_1
XFILLER_142_756 VDD VSS sg13g2_decap_4
XFILLER_173_1127 VDD VSS sg13g2_decap_8
XFILLER_177_1296 VDD VSS sg13g2_decap_8
XFILLER_64_1400 VDD VSS sg13g2_decap_8
X_15058_ _15058_/Q clkload73/A _15058_/D _15058_/RESET_B VDD VSS sg13g2_dfrbpq_1
XFILLER_123_970 VDD VSS sg13g2_decap_8
X_14009_ _14009_/Q clkload45/A _14009_/D _14009_/RESET_B VDD VSS sg13g2_dfrbpq_1
XFILLER_96_821 VDD VSS sg13g2_decap_8
X_07880_ _08090_/B _07883_/A _08023_/B VDD VSS sg13g2_nor2_1
XFILLER_64_1477 VDD VSS sg13g2_fill_2
XFILLER_60_1308 VDD VSS sg13g2_decap_8
XFILLER_25_1439 VDD VSS sg13g2_decap_8
X_15156__2668 _15156_/RESET_B VDD VSS sg13g2_tiehi
XFILLER_96_865 VDD VSS sg13g2_fill_2
XFILLER_151_1458 VDD VSS sg13g2_decap_8
XFILLER_83_515 VDD VSS sg13g2_decap_8
XFILLER_110_1100 VDD VSS sg13g2_fill_2
XFILLER_95_386 VDD VSS sg13g2_decap_8
XFILLER_55_217 VDD VSS sg13g2_fill_1
X_09550_ _14148_/D _09583_/A1 _14148_/Q _09556_/S VDD VSS sg13g2_mux2_1
XFILLER_7_1393 VDD VSS sg13g2_decap_8
XFILLER_114_1291 VDD VSS sg13g2_fill_1
XFILLER_48_280 VDD VSS sg13g2_decap_8
XFILLER_23_1185 VDD VSS sg13g2_decap_8
XFILLER_3_1257 VDD VSS sg13g2_decap_8
XFILLER_36_431 VDD VSS sg13g2_decap_8
X_08501_ _15238_/D _08501_/A _08501_/B _08501_/C _08501_/D VDD VSS sg13g2_nand4_1
XFILLER_37_965 VDD VSS sg13g2_decap_8
XFILLER_184_1212 VDD VSS sg13g2_decap_8
X_09481_ _14081_/D _10077_/A0 _14081_/Q _09493_/S VDD VSS sg13g2_mux2_1
XFILLER_149_1343 VDD VSS sg13g2_decap_4
XFILLER_36_475 VDD VSS sg13g2_decap_8
X_08432_ _08432_/Y _07799_/X _08432_/A2 _08325_/B VDD VSS sg13g2_o21ai_1
XFILLER_58_1259 VDD VSS sg13g2_decap_8
XFILLER_52_957 VDD VSS sg13g2_decap_8
XFILLER_149_1387 VDD VSS sg13g2_fill_2
XFILLER_51_434 VDD VSS sg13g2_fill_2
XFILLER_184_1289 VDD VSS sg13g2_decap_8
XFILLER_168_119 VDD VSS sg13g2_decap_8
XFILLER_71_1404 VDD VSS sg13g2_decap_8
XFILLER_149_300 VDD VSS sg13g2_decap_8
X_08363_ _08363_/X _08207_/X _08362_/X _08452_/A _08279_/A _08431_/C _08363_/S1 VDD
+ VSS sg13g2_mux4_1
XFILLER_51_478 VDD VSS sg13g2_fill_2
X_14755__2984 _14755_/RESET_B VDD VSS sg13g2_tiehi
XFILLER_32_692 VDD VSS sg13g2_fill_1
XFILLER_20_843 VDD VSS sg13g2_fill_1
X_08294_ _08294_/Y _08318_/D _08286_/Y _07777_/Y VDD VSS sg13g2_o21ai_1
XFILLER_137_528 VDD VSS sg13g2_decap_8
XFILLER_164_336 VDD VSS sg13g2_fill_2
XFILLER_178_1016 VDD VSS sg13g2_decap_8
XFILLER_34_1292 VDD VSS sg13g2_decap_8
XFILLER_69_1311 VDD VSS sg13g2_decap_8
XFILLER_11_25 VDD VSS sg13g2_decap_8
XFILLER_3_508 VDD VSS sg13g2_decap_8
XFILLER_30_1167 VDD VSS sg13g2_decap_8
XFILLER_105_403 VDD VSS sg13g2_decap_8
XFILLER_121_1295 VDD VSS sg13g2_decap_4
XFILLER_117_274 VDD VSS sg13g2_decap_8
XFILLER_127_36 VDD VSS sg13g2_decap_8
XFILLER_133_723 VDD VSS sg13g2_fill_1
XFILLER_106_948 VDD VSS sg13g2_decap_8
XFILLER_156_1336 VDD VSS sg13g2_decap_8
XFILLER_172_391 VDD VSS sg13g2_decap_8
XFILLER_87_18 VDD VSS sg13g2_decap_8
XFILLER_69_1388 VDD VSS sg13g2_decap_8
XFILLER_132_255 VDD VSS sg13g2_decap_8
XFILLER_121_929 VDD VSS sg13g2_decap_8
Xfanout300 _10074_/A0 _09909_/A1 VDD VSS sg13g2_buf_1
XFILLER_120_417 VDD VSS sg13g2_decap_8
Xpicorv32_macro_1438 mem_axi_araddr[1] VDD VSS sg13g2_tielo
Xfanout311 _10169_/S _10137_/Y VDD VSS sg13g2_buf_1
XFILLER_99_670 VDD VSS sg13g2_fill_1
XFILLER_59_501 VDD VSS sg13g2_fill_1
Xfanout1309 _12241_/B1 _12283_/S1 VDD VSS sg13g2_buf_1
XFILLER_120_428 VDD VSS sg13g2_fill_2
Xfanout322 _09970_/S fanout323/X VDD VSS sg13g2_buf_1
XFILLER_8_1124 VDD VSS sg13g2_decap_8
Xfanout333 _09870_/S fanout335/X VDD VSS sg13g2_buf_1
XFILLER_143_24 VDD VSS sg13g2_decap_8
Xfanout344 _09725_/S _09727_/S VDD VSS sg13g2_buf_1
Xfanout355 _09622_/S _09626_/S VDD VSS sg13g2_buf_1
XFILLER_115_1044 VDD VSS sg13g2_decap_8
Xfanout366 _09333_/S _09325_/S VDD VSS sg13g2_buf_1
X_14600__1602 _14600_/RESET_B VDD VSS sg13g2_tiehi
Xfanout377 _09259_/S _09261_/S VDD VSS sg13g2_buf_1
X_09817_ _14405_/D _09916_/A1 _14405_/Q _09828_/S VDD VSS sg13g2_mux2_1
Xfanout388 _09914_/A1 fanout390/X VDD VSS sg13g2_buf_1
Xfanout399 _09911_/A1 _10110_/A0 VDD VSS sg13g2_buf_1
XFILLER_86_375 VDD VSS sg13g2_fill_1
XFILLER_100_163 VDD VSS sg13g2_decap_8
XFILLER_101_686 VDD VSS sg13g2_decap_8
XFILLER_100_185 VDD VSS sg13g2_decap_8
X_09748_ _14338_/D _14338_/Q _09814_/A0 _09762_/S VDD VSS sg13g2_mux2_1
XFILLER_74_548 VDD VSS sg13g2_decap_8
XFILLER_39_280 VDD VSS sg13g2_decap_8
XFILLER_74_559 VDD VSS sg13g2_fill_1
XFILLER_55_740 VDD VSS sg13g2_fill_2
XFILLER_41_1285 VDD VSS sg13g2_decap_8
X_14900__2767 _14900_/RESET_B VDD VSS sg13g2_tiehi
XFILLER_43_902 VDD VSS sg13g2_fill_1
X_09679_ _14271_/D _09745_/A1 _14271_/Q _09692_/S VDD VSS sg13g2_mux2_1
XFILLER_160_4 VDD VSS sg13g2_decap_8
XFILLER_167_1465 VDD VSS sg13g2_decap_4
X_11710_ _11710_/X _13833_/Q _13865_/Q _13897_/Q _13929_/Q _11715_/S0 _11715_/S1 VDD
+ VSS sg13g2_mux4_1
XFILLER_36_88 VDD VSS sg13g2_fill_2
XFILLER_76_1359 VDD VSS sg13g2_decap_8
XFILLER_128_1427 VDD VSS sg13g2_fill_2
X_12690_ _12690_/X _12685_/X _12689_/X _12684_/X _12688_/X _12748_/S _12747_/S1 VDD
+ VSS sg13g2_mux4_1
XFILLER_70_743 VDD VSS sg13g2_decap_8
XFILLER_43_957 VDD VSS sg13g2_decap_4
X_14633__1569 _14633_/RESET_B VDD VSS sg13g2_tiehi
XFILLER_14_147 VDD VSS sg13g2_decap_8
X_11641_ _11643_/B _11506_/B _11776_/A _11774_/A VDD VSS sg13g2_a21o_1
XFILLER_14_169 VDD VSS sg13g2_fill_2
XFILLER_168_620 VDD VSS sg13g2_decap_8
XFILLER_23_670 VDD VSS sg13g2_fill_2
XFILLER_168_21 VDD VSS sg13g2_decap_8
XFILLER_11_832 VDD VSS sg13g2_decap_8
XFILLER_167_130 VDD VSS sg13g2_decap_8
XFILLER_168_653 VDD VSS sg13g2_decap_8
X_14360_ _14360_/Q _14745_/CLK _14360_/D _14360_/RESET_B VDD VSS sg13g2_dfrbpq_1
X_11572_ _11572_/X _11572_/A _11638_/C VDD VSS sg13g2_xor2_1
XFILLER_128_506 VDD VSS sg13g2_decap_8
XFILLER_126_1184 VDD VSS sg13g2_decap_8
X_13311_ _15060_/D _07613_/Y _13308_/Y _07987_/Y _13310_/Y _13507_/A VDD VSS sg13g2_a221oi_1
Xinput19 input19/X input19/A VDD VSS sg13g2_buf_1
X_10523_ _10567_/A _10564_/D _14856_/Q _14855_/Q VDD VSS sg13g2_nand3_1
XFILLER_109_720 VDD VSS sg13g2_decap_8
XFILLER_11_887 VDD VSS sg13g2_decap_8
X_14291_ _14291_/Q clkload36/A _14291_/D _14291_/RESET_B VDD VSS sg13g2_dfrbpq_1
XFILLER_10_364 VDD VSS sg13g2_decap_8
XFILLER_122_1059 VDD VSS sg13g2_decap_8
XFILLER_7_847 VDD VSS sg13g2_decap_8
XFILLER_168_98 VDD VSS sg13g2_decap_8
XFILLER_182_144 VDD VSS sg13g2_decap_8
X_13242_ _13247_/A _13242_/A _13242_/B VDD VSS sg13g2_nand2_1
XFILLER_100_1313 VDD VSS sg13g2_fill_2
XFILLER_171_818 VDD VSS sg13g2_decap_4
X_10454_ _14840_/D _14840_/Q _10450_/C _10452_/Y VDD VSS sg13g2_a21oi_1
XFILLER_13_1376 VDD VSS sg13g2_decap_8
XFILLER_87_1433 VDD VSS sg13g2_decap_8
XFILLER_124_701 VDD VSS sg13g2_decap_8
XFILLER_6_368 VDD VSS sg13g2_decap_8
X_13173_ _13176_/B _13066_/A _13066_/C _13172_/X VDD VSS sg13g2_o21ai_1
X_10385_ _10386_/C _14818_/Q _14819_/Q _10391_/C _10396_/C VDD VSS sg13g2_and4_1
XFILLER_100_1379 VDD VSS sg13g2_decap_4
XFILLER_124_745 VDD VSS sg13g2_decap_8
X_15196__2784 _15196_/RESET_B VDD VSS sg13g2_tiehi
XFILLER_83_1319 VDD VSS sg13g2_decap_8
XFILLER_151_542 VDD VSS sg13g2_decap_8
XFILLER_112_907 VDD VSS sg13g2_fill_2
XFILLER_123_244 VDD VSS sg13g2_decap_8
XFILLER_184_86 VDD VSS sg13g2_decap_8
X_12124_ _12125_/B _12086_/X _12156_/A _12123_/Y VDD VSS sg13g2_a21oi_1
XFILLER_97_607 VDD VSS sg13g2_decap_8
XFILLER_112_918 VDD VSS sg13g2_decap_4
XFILLER_124_778 VDD VSS sg13g2_decap_8
XFILLER_174_1469 VDD VSS sg13g2_decap_4
XFILLER_97_629 VDD VSS sg13g2_decap_4
XFILLER_96_106 VDD VSS sg13g2_fill_1
XFILLER_81_1010 VDD VSS sg13g2_fill_1
XFILLER_85_1190 VDD VSS sg13g2_decap_8
XFILLER_46_1141 VDD VSS sg13g2_decap_8
XFILLER_2_574 VDD VSS sg13g2_decap_8
XFILLER_78_821 VDD VSS sg13g2_decap_8
X_12055_ _12056_/C _12055_/A _12055_/B _12055_/C _12055_/D VDD VSS sg13g2_nor4_1
XFILLER_42_1005 VDD VSS sg13g2_decap_8
XFILLER_81_1065 VDD VSS sg13g2_fill_2
XFILLER_78_865 VDD VSS sg13g2_decap_8
XFILLER_172_1193 VDD VSS sg13g2_decap_8
X_11006_ _11012_/C _10893_/A _10893_/B _11005_/X VDD VSS sg13g2_a21oi_1
X_16863_ _16863_/X _16863_/A VDD VSS sg13g2_buf_1
XFILLER_37_206 VDD VSS sg13g2_decap_8
XFILLER_77_375 VDD VSS sg13g2_decap_8
XFILLER_19_943 VDD VSS sg13g2_decap_8
XFILLER_93_857 VDD VSS sg13g2_decap_8
XFILLER_18_420 VDD VSS sg13g2_decap_8
XFILLER_0_1408 VDD VSS sg13g2_decap_8
XFILLER_92_356 VDD VSS sg13g2_decap_8
XFILLER_20_1347 VDD VSS sg13g2_decap_8
XFILLER_18_464 VDD VSS sg13g2_decap_8
XFILLER_92_378 VDD VSS sg13g2_decap_8
XFILLER_80_518 VDD VSS sg13g2_decap_8
X_12957_ _12988_/C _12957_/A _13683_/Q VDD VSS sg13g2_xnor2_1
XFILLER_34_924 VDD VSS sg13g2_decap_8
XFILLER_94_1426 VDD VSS sg13g2_decap_8
XFILLER_45_261 VDD VSS sg13g2_decap_8
XFILLER_46_795 VDD VSS sg13g2_fill_1
XFILLER_34_935 VDD VSS sg13g2_fill_1
XFILLER_181_1407 VDD VSS sg13g2_decap_8
X_11908_ _11908_/Y _11843_/A _13675_/Q _13674_/Q _11865_/A VDD VSS sg13g2_a22oi_1
XFILLER_34_957 VDD VSS sg13g2_decap_8
X_12888_ _15026_/D _12878_/Y _12887_/Y _12984_/A VDD VSS sg13g2_a21oi_1
XFILLER_18_1210 VDD VSS sg13g2_decap_8
X_14609__1593 _14609_/RESET_B VDD VSS sg13g2_tiehi
X_14627_ _14627_/Q _14723_/CLK _14627_/D _14627_/RESET_B VDD VSS sg13g2_dfrbpq_1
X_11839_ _14974_/D _11839_/A _11839_/B VDD VSS sg13g2_nor2_1
XFILLER_159_664 VDD VSS sg13g2_decap_4
XFILLER_105_1224 VDD VSS sg13g2_decap_8
XFILLER_119_506 VDD VSS sg13g2_decap_4
XFILLER_14_1107 VDD VSS sg13g2_decap_8
X_14558_ _14558_/Q clkload62/A _14558_/D _14558_/RESET_B VDD VSS sg13g2_dfrbpq_1
XFILLER_18_1287 VDD VSS sg13g2_decap_8
XFILLER_53_1167 VDD VSS sg13g2_decap_8
XFILLER_9_140 VDD VSS sg13g2_decap_8
XFILLER_105_1257 VDD VSS sg13g2_decap_8
XFILLER_186_483 VDD VSS sg13g2_decap_8
X_13509_ _15132_/D _15132_/Q _13509_/A1 _13512_/S VDD VSS sg13g2_mux2_1
XFILLER_140_1148 VDD VSS sg13g2_decap_8
XFILLER_140_1159 VDD VSS sg13g2_fill_1
X_14489_ _14489_/Q clkload45/A _14489_/D _14489_/RESET_B VDD VSS sg13g2_dfrbpq_1
XFILLER_146_347 VDD VSS sg13g2_fill_1
XFILLER_173_133 VDD VSS sg13g2_decap_8
XFILLER_31_1454 VDD VSS sg13g2_decap_8
XFILLER_179_1358 VDD VSS sg13g2_decap_8
XFILLER_161_306 VDD VSS sg13g2_decap_4
XFILLER_115_723 VDD VSS sg13g2_decap_8
XFILLER_138_1033 VDD VSS sg13g2_decap_8
XFILLER_177_1093 VDD VSS sg13g2_decap_8
XFILLER_103_918 VDD VSS sg13g2_decap_8
X_15190__2808 _15190_/RESET_B VDD VSS sg13g2_tiehi
X_08981_ _08981_/Y _10681_/A _10674_/A _09024_/A VDD VSS sg13g2_o21ai_1
X_07932_ _07932_/Y _08286_/A _08286_/B VDD VSS sg13g2_nor2_1
Xclkbuf_leaf_102_clk_i _14670_/CLK clkbuf_leaf_99_clk_i/A VDD VSS sg13g2_buf_8
XFILLER_9_1444 VDD VSS sg13g2_decap_8
XFILLER_111_940 VDD VSS sg13g2_fill_1
XFILLER_64_1274 VDD VSS sg13g2_decap_8
XFILLER_29_1394 VDD VSS sg13g2_decap_8
XFILLER_68_342 VDD VSS sg13g2_decap_8
XFILLER_25_1236 VDD VSS sg13g2_decap_8
XFILLER_84_802 VDD VSS sg13g2_fill_1
XFILLER_111_973 VDD VSS sg13g2_decap_4
XFILLER_112_1206 VDD VSS sg13g2_decap_8
X_07863_ _08641_/D _08608_/A _08608_/B VDD VSS sg13g2_or2_1
XFILLER_3_81 VDD VSS sg13g2_decap_8
XFILLER_95_161 VDD VSS sg13g2_decap_8
XFILLER_116_1397 VDD VSS sg13g2_decap_8
XFILLER_151_1277 VDD VSS sg13g2_decap_4
XFILLER_96_695 VDD VSS sg13g2_decap_8
XFILLER_110_483 VDD VSS sg13g2_decap_8
X_09602_ _14199_/D _14199_/Q _09635_/A0 _09604_/S VDD VSS sg13g2_mux2_1
XFILLER_84_846 VDD VSS sg13g2_fill_1
X_07794_ _08414_/C _08383_/A _08383_/B VDD VSS sg13g2_xnor2_1
XFILLER_7_1190 VDD VSS sg13g2_decap_8
XFILLER_186_1329 VDD VSS sg13g2_decap_8
Xclkbuf_leaf_117_clk_i clkload27/A clkbuf_5_7__f_clk_i/X VDD VSS sg13g2_buf_8
X_09533_ _14132_/D _10163_/A1 _14132_/Q _09533_/S VDD VSS sg13g2_mux2_1
XFILLER_3_1054 VDD VSS sg13g2_decap_8
XFILLER_83_378 VDD VSS sg13g2_decap_8
XFILLER_58_1012 VDD VSS sg13g2_decap_4
XFILLER_37_773 VDD VSS sg13g2_decap_8
XFILLER_58_1034 VDD VSS sg13g2_decap_8
X_09464_ _14065_/D _09961_/A1 _14065_/Q _09471_/S VDD VSS sg13g2_mux2_1
XFILLER_51_220 VDD VSS sg13g2_decap_8
XFILLER_149_1184 VDD VSS sg13g2_decap_8
XFILLER_40_905 VDD VSS sg13g2_decap_8
X_08415_ _08417_/B _08415_/A _08415_/B VDD VSS sg13g2_nand2_1
XFILLER_40_916 VDD VSS sg13g2_fill_2
XFILLER_24_467 VDD VSS sg13g2_decap_8
XFILLER_184_1086 VDD VSS sg13g2_decap_8
XFILLER_58_1089 VDD VSS sg13g2_decap_8
XFILLER_145_1048 VDD VSS sg13g2_decap_4
X_09395_ _13998_/D _10057_/A0 _13998_/Q _09395_/S VDD VSS sg13g2_mux2_1
XFILLER_75_1370 VDD VSS sg13g2_decap_8
XFILLER_71_1201 VDD VSS sg13g2_decap_8
XFILLER_52_798 VDD VSS sg13g2_decap_8
XFILLER_51_275 VDD VSS sg13g2_decap_8
XFILLER_178_962 VDD VSS sg13g2_fill_1
X_08346_ _08346_/Y _08346_/A _08346_/B _08346_/C VDD VSS sg13g2_nand3_1
XFILLER_36_1376 VDD VSS sg13g2_decap_8
XFILLER_137_303 VDD VSS sg13g2_fill_1
XFILLER_178_995 VDD VSS sg13g2_decap_8
XFILLER_32_1218 VDD VSS sg13g2_decap_8
XFILLER_162_1395 VDD VSS sg13g2_decap_8
XFILLER_71_1278 VDD VSS sg13g2_decap_8
XFILLER_177_483 VDD VSS sg13g2_decap_8
XFILLER_22_35 VDD VSS sg13g2_decap_8
XFILLER_149_185 VDD VSS sg13g2_decap_8
XFILLER_177_494 VDD VSS sg13g2_decap_8
X_08277_ _08277_/Y _08318_/D _08359_/A2 _08523_/B1 _08276_/X _08275_/Y VDD VSS sg13g2_a221oi_1
XFILLER_123_1368 VDD VSS sg13g2_decap_8
XFILLER_118_550 VDD VSS sg13g2_decap_8
XFILLER_138_57 VDD VSS sg13g2_decap_8
XFILLER_180_615 VDD VSS sg13g2_decap_4
XFILLER_69_1130 VDD VSS sg13g2_fill_2
XFILLER_3_305 VDD VSS sg13g2_decap_8
XFILLER_121_1092 VDD VSS sg13g2_decap_8
XFILLER_180_637 VDD VSS sg13g2_decap_8
XFILLER_105_211 VDD VSS sg13g2_decap_8
XFILLER_118_594 VDD VSS sg13g2_fill_1
X_14047__2155 _14047_/RESET_B VDD VSS sg13g2_tiehi
X_13882__2320 _13882_/RESET_B VDD VSS sg13g2_tiehi
XFILLER_161_851 VDD VSS sg13g2_fill_1
XFILLER_69_1185 VDD VSS sg13g2_decap_8
XFILLER_79_607 VDD VSS sg13g2_decap_8
XFILLER_121_704 VDD VSS sg13g2_decap_4
X_10170_ _10185_/A _10179_/B _14748_/Q _10173_/B VDD VSS sg13g2_nand3_1
XFILLER_161_884 VDD VSS sg13g2_decap_8
XFILLER_117_1117 VDD VSS sg13g2_decap_8
XFILLER_156_1166 VDD VSS sg13g2_decap_8
XFILLER_82_1330 VDD VSS sg13g2_decap_8
XFILLER_154_56 VDD VSS sg13g2_decap_8
Xfanout1106 _08673_/B _14987_/Q VDD VSS sg13g2_buf_1
XFILLER_105_299 VDD VSS sg13g2_fill_2
XFILLER_121_748 VDD VSS sg13g2_decap_8
XFILLER_160_394 VDD VSS sg13g2_decap_8
Xfanout1117 _08934_/A1 _14983_/Q VDD VSS sg13g2_buf_1
Xfanout1128 _07812_/B _08922_/A1 VDD VSS sg13g2_buf_1
XFILLER_59_331 VDD VSS sg13g2_decap_4
Xfanout1139 _11865_/A _14976_/Q VDD VSS sg13g2_buf_1
Xfanout152 _09737_/A0 _09770_/A1 VDD VSS sg13g2_buf_1
XFILLER_43_1336 VDD VSS sg13g2_decap_8
XFILLER_134_1464 VDD VSS sg13g2_decap_4
Xfanout163 _10165_/A1 _09834_/A0 VDD VSS sg13g2_buf_1
Xfanout174 _09931_/A1 _09126_/Y VDD VSS sg13g2_buf_1
XFILLER_75_813 VDD VSS sg13g2_fill_2
Xfanout185 _10161_/A1 _09830_/A0 VDD VSS sg13g2_buf_1
XFILLER_170_11 VDD VSS sg13g2_decap_8
XFILLER_19_228 VDD VSS sg13g2_decap_8
Xfanout196 _09594_/A1 _09091_/Y VDD VSS sg13g2_buf_1
XFILLER_86_172 VDD VSS sg13g2_decap_8
XFILLER_47_54 VDD VSS sg13g2_fill_2
X_13860_ _13860_/Q _14724_/CLK _13860_/D _13860_/RESET_B VDD VSS sg13g2_dfrbpq_1
X_12811_ _12812_/B _13303_/A _15123_/Q _12805_/Y _13048_/B _12810_/Y VDD VSS sg13g2_a221oi_1
XFILLER_170_88 VDD VSS sg13g2_decap_8
XFILLER_34_209 VDD VSS sg13g2_decap_8
X_13791_ _13791_/Q clkload51/A _13791_/D _13791_/RESET_B VDD VSS sg13g2_dfrbpq_1
XFILLER_90_838 VDD VSS sg13g2_decap_8
XFILLER_43_710 VDD VSS sg13g2_decap_8
XFILLER_16_935 VDD VSS sg13g2_fill_2
XFILLER_15_412 VDD VSS sg13g2_decap_8
XFILLER_63_20 VDD VSS sg13g2_fill_1
XFILLER_55_592 VDD VSS sg13g2_decap_8
XFILLER_167_1262 VDD VSS sg13g2_decap_8
X_12742_ _12742_/X _14135_/Q _14167_/Q _14199_/Q _14231_/Q _12756_/S0 _12756_/S1 VDD
+ VSS sg13g2_mux4_1
XFILLER_76_1156 VDD VSS sg13g2_decap_8
XFILLER_70_540 VDD VSS sg13g2_decap_8
XFILLER_43_765 VDD VSS sg13g2_decap_8
XFILLER_151_0 VDD VSS sg13g2_decap_4
Xclkbuf_leaf_81_clk_i _15212_/CLK clkbuf_leaf_90_clk_i/A VDD VSS sg13g2_buf_8
XFILLER_128_1257 VDD VSS sg13g2_decap_8
X_12673_ _12673_/X _13746_/Q _14098_/Q _14450_/Q _14546_/Q _12675_/S0 _12675_/S1 VDD
+ VSS sg13g2_mux4_1
XFILLER_169_940 VDD VSS sg13g2_fill_1
XFILLER_179_53 VDD VSS sg13g2_decap_8
XFILLER_63_86 VDD VSS sg13g2_decap_8
XFILLER_42_286 VDD VSS sg13g2_decap_8
XFILLER_30_426 VDD VSS sg13g2_decap_8
XFILLER_24_990 VDD VSS sg13g2_decap_8
X_14412_ _14412_/Q _14495_/CLK _14412_/D _14412_/RESET_B VDD VSS sg13g2_dfrbpq_1
X_11624_ _11625_/B _11613_/Y _11615_/X _11830_/B1 VDD VSS sg13g2_o21ai_1
XFILLER_180_1462 VDD VSS sg13g2_decap_8
XFILLER_54_1465 VDD VSS sg13g2_decap_8
X_14257__1945 _14257_/RESET_B VDD VSS sg13g2_tiehi
XFILLER_11_662 VDD VSS sg13g2_decap_8
XFILLER_155_100 VDD VSS sg13g2_decap_8
XFILLER_128_325 VDD VSS sg13g2_fill_1
X_14343_ _14343_/Q clkload12/A _14343_/D _14343_/RESET_B VDD VSS sg13g2_dfrbpq_1
X_11555_ _11555_/X _14692_/Q _14724_/Q _13764_/Q _13796_/Q _11555_/S0 _11532_/C VDD
+ VSS sg13g2_mux4_1
XFILLER_129_859 VDD VSS sg13g2_decap_8
XFILLER_10_161 VDD VSS sg13g2_decap_8
XFILLER_183_431 VDD VSS sg13g2_decap_8
Xclkbuf_leaf_96_clk_i clkload61/A clkbuf_leaf_96_clk_i/A VDD VSS sg13g2_buf_8
XFILLER_7_644 VDD VSS sg13g2_decap_8
X_10506_ _10575_/C _10538_/A _10654_/A VDD VSS sg13g2_nor2_1
XFILLER_128_369 VDD VSS sg13g2_decap_4
X_14274_ _14274_/Q _14722_/CLK _14274_/D _14274_/RESET_B VDD VSS sg13g2_dfrbpq_1
X_11486_ _11486_/X _13826_/Q _13858_/Q _13890_/Q _13922_/Q _11493_/S0 _07654_/A VDD
+ VSS sg13g2_mux4_1
XFILLER_100_1121 VDD VSS sg13g2_decap_8
XFILLER_13_1173 VDD VSS sg13g2_decap_8
XFILLER_155_166 VDD VSS sg13g2_decap_8
XFILLER_137_881 VDD VSS sg13g2_decap_4
XFILLER_6_165 VDD VSS sg13g2_decap_8
X_13225_ _13225_/X _13225_/A _13225_/B _13226_/B VDD VSS sg13g2_and3_1
XFILLER_87_1241 VDD VSS sg13g2_decap_8
XFILLER_109_594 VDD VSS sg13g2_decap_8
X_10437_ _14835_/D _14835_/Q _10443_/D _10436_/Y VDD VSS sg13g2_a21oi_1
X_14472__1730 _14472_/RESET_B VDD VSS sg13g2_tiehi
XFILLER_139_1364 VDD VSS sg13g2_fill_2
X_13156_ _13174_/B _13156_/A _13670_/Q VDD VSS sg13g2_nor2_1
XFILLER_83_1127 VDD VSS sg13g2_decap_8
XFILLER_139_1375 VDD VSS sg13g2_decap_8
XFILLER_152_873 VDD VSS sg13g2_decap_4
X_10368_ _10391_/C _10400_/A _10397_/B _10395_/A _10400_/C VDD VSS sg13g2_nor4_1
XFILLER_48_1258 VDD VSS sg13g2_decap_8
XFILLER_83_1149 VDD VSS sg13g2_fill_1
XFILLER_3_872 VDD VSS sg13g2_decap_8
XFILLER_139_1386 VDD VSS sg13g2_fill_2
XFILLER_174_1266 VDD VSS sg13g2_decap_8
X_12107_ _12108_/A _14260_/Q _14292_/Q _14324_/Q _14356_/Q _12087_/S _12091_/C VDD
+ VSS sg13g2_mux4_1
XFILLER_97_437 VDD VSS sg13g2_fill_1
XFILLER_88_94 VDD VSS sg13g2_decap_8
XFILLER_2_371 VDD VSS sg13g2_decap_8
XFILLER_112_759 VDD VSS sg13g2_decap_8
X_13087_ _15038_/D _13087_/A _13087_/B VDD VSS sg13g2_nor2_1
X_10299_ _10299_/Y _10299_/A _10299_/B _10299_/C VDD VSS sg13g2_nor3_1
XFILLER_97_459 VDD VSS sg13g2_decap_4
XFILLER_61_1414 VDD VSS sg13g2_decap_8
XFILLER_78_651 VDD VSS sg13g2_decap_8
X_12038_ _12038_/Y _12040_/A1 _14162_/Q _12038_/B1 VDD VSS sg13g2_a21oi_1
XFILLER_78_684 VDD VSS sg13g2_decap_8
Xclkbuf_leaf_34_clk_i _14677_/CLK clkbuf_leaf_34_clk_i/A VDD VSS sg13g2_buf_8
XFILLER_65_301 VDD VSS sg13g2_decap_8
XFILLER_77_194 VDD VSS sg13g2_fill_1
XFILLER_4_1330 VDD VSS sg13g2_decap_8
XFILLER_38_548 VDD VSS sg13g2_decap_8
X_13745__2457 _13745_/RESET_B VDD VSS sg13g2_tiehi
XFILLER_93_665 VDD VSS sg13g2_decap_4
XFILLER_24_1291 VDD VSS sg13g2_decap_8
XFILLER_65_367 VDD VSS sg13g2_decap_4
XFILLER_0_1205 VDD VSS sg13g2_decap_8
XFILLER_20_1144 VDD VSS sg13g2_decap_8
XFILLER_59_1310 VDD VSS sg13g2_decap_8
XFILLER_93_698 VDD VSS sg13g2_fill_1
X_13989_ _13989_/Q clkload17/A _13989_/D _13989_/RESET_B VDD VSS sg13g2_dfrbpq_1
XFILLER_19_795 VDD VSS sg13g2_decap_8
XFILLER_92_186 VDD VSS sg13g2_decap_8
XFILLER_92_197 VDD VSS sg13g2_fill_1
XFILLER_185_1362 VDD VSS sg13g2_decap_8
XFILLER_181_1204 VDD VSS sg13g2_decap_8
Xclkbuf_leaf_49_clk_i _15240_/CLK clkbuf_leaf_52_clk_i/A VDD VSS sg13g2_buf_8
XFILLER_61_540 VDD VSS sg13g2_fill_2
XFILLER_179_726 VDD VSS sg13g2_decap_8
XFILLER_59_1387 VDD VSS sg13g2_decap_8
XFILLER_33_242 VDD VSS sg13g2_decap_8
X_14125__2077 _14125_/RESET_B VDD VSS sg13g2_tiehi
X_13960__2242 _13960_/RESET_B VDD VSS sg13g2_tiehi
X_08200_ _08201_/D _08200_/A _08200_/B _08200_/C VDD VSS sg13g2_nor3_1
X_09180_ _13796_/D _13796_/Q _10080_/A0 _09196_/S VDD VSS sg13g2_mux2_1
XFILLER_105_1010 VDD VSS sg13g2_decap_4
XFILLER_159_450 VDD VSS sg13g2_decap_8
XFILLER_119_303 VDD VSS sg13g2_decap_4
X_08131_ _08131_/Y _08428_/S _08128_/X _08130_/Y VDD VSS sg13g2_o21ai_1
XFILLER_105_1043 VDD VSS sg13g2_decap_8
XFILLER_186_280 VDD VSS sg13g2_decap_8
XFILLER_30_982 VDD VSS sg13g2_decap_8
XFILLER_175_954 VDD VSS sg13g2_fill_1
XFILLER_174_442 VDD VSS sg13g2_decap_8
XFILLER_88_1016 VDD VSS sg13g2_decap_8
X_08062_ _08256_/A _08177_/S _08059_/X _08061_/Y VDD VSS sg13g2_o21ai_1
XFILLER_135_829 VDD VSS sg13g2_decap_4
XFILLER_31_1251 VDD VSS sg13g2_decap_8
XFILLER_179_1155 VDD VSS sg13g2_decap_8
XFILLER_88_1049 VDD VSS sg13g2_decap_8
XFILLER_157_1420 VDD VSS sg13g2_decap_8
XFILLER_161_147 VDD VSS sg13g2_decap_8
XFILLER_143_862 VDD VSS sg13g2_decap_4
X_14302__1900 _14302_/RESET_B VDD VSS sg13g2_tiehi
XFILLER_115_564 VDD VSS sg13g2_decap_8
XFILLER_66_1347 VDD VSS sg13g2_decap_8
XFILLER_0_308 VDD VSS sg13g2_decap_8
X_08964_ _09839_/D _10004_/B _09441_/C _09441_/A VDD VSS sg13g2_nand3b_1
XFILLER_9_1241 VDD VSS sg13g2_decap_8
XFILLER_25_1000 VDD VSS sg13g2_decap_4
XFILLER_29_1191 VDD VSS sg13g2_decap_8
XFILLER_151_1030 VDD VSS sg13g2_decap_8
XFILLER_102_269 VDD VSS sg13g2_fill_2
X_07915_ _07917_/C _07884_/Y _07900_/Y _07914_/Y VDD VSS sg13g2_a21oi_1
XFILLER_124_48 VDD VSS sg13g2_decap_8
XFILLER_130_589 VDD VSS sg13g2_decap_8
X_08895_ _08895_/X _08894_/X _11770_/A _08904_/S VDD VSS sg13g2_mux2_1
XFILLER_99_1101 VDD VSS sg13g2_fill_2
XFILLER_68_161 VDD VSS sg13g2_decap_8
XFILLER_5_1127 VDD VSS sg13g2_decap_8
XFILLER_99_1123 VDD VSS sg13g2_decap_8
X_07846_ _08650_/A _08678_/B _08678_/C VDD VSS sg13g2_and2_1
XFILLER_57_857 VDD VSS sg13g2_decap_8
X_14335__1867 _14335_/RESET_B VDD VSS sg13g2_tiehi
XFILLER_56_356 VDD VSS sg13g2_fill_1
XFILLER_42_1380 VDD VSS sg13g2_decap_8
XFILLER_186_1126 VDD VSS sg13g2_decap_8
XFILLER_56_367 VDD VSS sg13g2_decap_8
XFILLER_17_35 VDD VSS sg13g2_decap_8
X_07777_ _07777_/Y _08276_/B _07778_/A VDD VSS sg13g2_nand2b_1
XFILLER_44_529 VDD VSS sg13g2_decap_4
XFILLER_83_186 VDD VSS sg13g2_fill_2
XFILLER_77_1432 VDD VSS sg13g2_decap_8
X_09516_ _14115_/D _09749_/A1 _14115_/Q _09533_/S VDD VSS sg13g2_mux2_1
XFILLER_38_1405 VDD VSS sg13g2_decap_8
XFILLER_164_1413 VDD VSS sg13g2_decap_8
XFILLER_52_540 VDD VSS sg13g2_fill_1
XFILLER_25_754 VDD VSS sg13g2_decap_8
XFILLER_24_231 VDD VSS sg13g2_fill_2
XFILLER_73_1318 VDD VSS sg13g2_decap_8
X_09447_ _14048_/D _09612_/A0 _14048_/Q _09463_/S VDD VSS sg13g2_mux2_1
X_15177__2882 _15177_/RESET_B VDD VSS sg13g2_tiehi
XFILLER_40_713 VDD VSS sg13g2_fill_2
X_14550__1652 _14550_/RESET_B VDD VSS sg13g2_tiehi
XFILLER_12_448 VDD VSS sg13g2_decap_4
X_09378_ _13981_/D _10040_/A0 _13981_/Q _09405_/S VDD VSS sg13g2_mux2_1
XFILLER_166_921 VDD VSS sg13g2_decap_8
XFILLER_36_1173 VDD VSS sg13g2_decap_8
XFILLER_33_78 VDD VSS sg13g2_decap_8
X_08329_ _08329_/Y _08329_/A _08544_/C VDD VSS sg13g2_nand2_1
XFILLER_33_89 VDD VSS sg13g2_fill_1
XFILLER_162_1192 VDD VSS sg13g2_decap_8
XFILLER_123_4 VDD VSS sg13g2_decap_8
X_11340_ _11340_/Y _11837_/A1 _11339_/Y _11332_/Y _11333_/Y _11432_/A2 VDD VSS sg13g2_a221oi_1
XFILLER_138_678 VDD VSS sg13g2_decap_8
XFILLER_166_987 VDD VSS sg13g2_decap_4
XFILLER_10_1302 VDD VSS sg13g2_decap_8
XFILLER_123_1198 VDD VSS sg13g2_decap_8
XFILLER_14_1471 VDD VSS sg13g2_decap_8
XFILLER_165_11 VDD VSS sg13g2_decap_8
XFILLER_158_1228 VDD VSS sg13g2_decap_8
XFILLER_3_102 VDD VSS sg13g2_decap_8
X_11271_ _11271_/Y _11273_/A1 _14396_/Q _12187_/C VDD VSS sg13g2_a21oi_1
XFILLER_153_659 VDD VSS sg13g2_decap_8
X_13823__2379 _13823_/RESET_B VDD VSS sg13g2_tiehi
XFILLER_84_1414 VDD VSS sg13g2_decap_8
X_13010_ _13026_/C _13010_/A _13010_/B VDD VSS sg13g2_nor2_1
XFILLER_4_658 VDD VSS sg13g2_decap_8
XFILLER_10_1379 VDD VSS sg13g2_decap_8
X_10222_ _10222_/Y _14769_/Q _10219_/X _10441_/C VDD VSS sg13g2_o21ai_1
XFILLER_140_309 VDD VSS sg13g2_decap_4
XFILLER_165_88 VDD VSS sg13g2_decap_8
XFILLER_171_1406 VDD VSS sg13g2_decap_8
XFILLER_134_895 VDD VSS sg13g2_decap_8
XFILLER_3_179 VDD VSS sg13g2_decap_8
XFILLER_0_820 VDD VSS sg13g2_decap_8
XFILLER_106_597 VDD VSS sg13g2_decap_4
X_10153_ _14730_/D _14730_/Q _10153_/A1 _10157_/S VDD VSS sg13g2_mux2_1
XFILLER_181_21 VDD VSS sg13g2_decap_8
XFILLER_88_960 VDD VSS sg13g2_decap_8
XFILLER_82_1160 VDD VSS sg13g2_decap_8
XFILLER_43_1111 VDD VSS sg13g2_decap_8
XFILLER_121_567 VDD VSS sg13g2_decap_4
XFILLER_47_1291 VDD VSS sg13g2_decap_8
X_14961_ _14961_/Q clkload62/A _14961_/D _14961_/RESET_B VDD VSS sg13g2_dfrbpq_1
X_10084_ _14664_/D _10084_/A0 _14664_/Q _10090_/S VDD VSS sg13g2_mux2_1
XFILLER_0_897 VDD VSS sg13g2_decap_8
XFILLER_58_97 VDD VSS sg13g2_decap_4
X_13912_ _13912_/Q _14742_/CLK _13912_/D _13912_/RESET_B VDD VSS sg13g2_dfrbpq_1
XFILLER_75_643 VDD VSS sg13g2_decap_4
XFILLER_181_98 VDD VSS sg13g2_decap_8
X_14892_ _14892_/Q clkload86/A _14892_/D _14892_/RESET_B VDD VSS sg13g2_dfrbpq_1
XFILLER_74_131 VDD VSS sg13g2_fill_2
XFILLER_130_1169 VDD VSS sg13g2_decap_8
XFILLER_21_1442 VDD VSS sg13g2_decap_8
X_13843_ _13843_/Q clkload39/A _13843_/D _13843_/RESET_B VDD VSS sg13g2_dfrbpq_1
XFILLER_90_613 VDD VSS sg13g2_decap_4
XFILLER_74_164 VDD VSS sg13g2_decap_4
XFILLER_62_304 VDD VSS sg13g2_decap_8
XFILLER_169_1357 VDD VSS sg13g2_decap_8
XFILLER_63_838 VDD VSS sg13g2_decap_8
XFILLER_16_732 VDD VSS sg13g2_fill_1
X_13774_ _13774_/Q clkload19/A _13774_/D _13774_/RESET_B VDD VSS sg13g2_dfrbpq_1
X_10986_ _14940_/D _10985_/X _10984_/Y _10973_/Y VDD VSS sg13g2_o21ai_1
XFILLER_74_96 VDD VSS sg13g2_fill_1
XFILLER_71_860 VDD VSS sg13g2_fill_2
X_12725_ _12725_/X _14390_/Q _14422_/Q _14486_/Q _14518_/Q _12725_/S0 _12725_/S1 VDD
+ VSS sg13g2_mux4_1
XFILLER_71_882 VDD VSS sg13g2_decap_8
XFILLER_70_370 VDD VSS sg13g2_decap_8
X_12656_ _12656_/X _14129_/Q _14161_/Q _14193_/Q _14225_/Q _12661_/S0 _12661_/S1 VDD
+ VSS sg13g2_mux4_1
XFILLER_88_7 VDD VSS sg13g2_decap_8
XFILLER_54_1262 VDD VSS sg13g2_decap_8
XFILLER_12_960 VDD VSS sg13g2_decap_4
XFILLER_129_634 VDD VSS sg13g2_decap_4
X_11607_ _11608_/A _13734_/Q _14086_/Q _14438_/Q _14534_/Q _11617_/A1 _11391_/B VDD
+ VSS sg13g2_mux4_1
X_12587_ _12587_/X _14380_/Q _14412_/Q _14476_/Q _14508_/Q _12592_/S0 _12592_/S1 VDD
+ VSS sg13g2_mux4_1
XFILLER_102_1205 VDD VSS sg13g2_decap_8
XFILLER_15_1257 VDD VSS sg13g2_decap_8
XFILLER_8_942 VDD VSS sg13g2_decap_8
XFILLER_141_1265 VDD VSS sg13g2_fill_2
XFILLER_157_965 VDD VSS sg13g2_decap_8
XFILLER_50_1148 VDD VSS sg13g2_decap_8
XFILLER_128_144 VDD VSS sg13g2_decap_4
XFILLER_172_913 VDD VSS sg13g2_decap_8
X_14326_ _14326_/Q _14742_/CLK _14326_/D _14326_/RESET_B VDD VSS sg13g2_dfrbpq_1
XFILLER_7_441 VDD VSS sg13g2_decap_8
X_11538_ _11538_/Y _11551_/A1 _14628_/Q VDD VSS sg13g2_nand2b_1
XFILLER_184_784 VDD VSS sg13g2_decap_8
XFILLER_128_177 VDD VSS sg13g2_fill_2
XFILLER_176_1317 VDD VSS sg13g2_decap_8
XFILLER_89_1369 VDD VSS sg13g2_decap_8
XFILLER_144_659 VDD VSS sg13g2_decap_8
X_14257_ _14257_/Q _14417_/CLK _14257_/D _14257_/RESET_B VDD VSS sg13g2_dfrbpq_1
X_11469_ _11469_/X _14369_/Q _14401_/Q _14465_/Q _14497_/Q _11473_/S0 _11473_/S1 VDD
+ VSS sg13g2_mux4_1
XFILLER_171_445 VDD VSS sg13g2_decap_8
XFILLER_125_851 VDD VSS sg13g2_decap_8
X_14413__1789 _14413_/RESET_B VDD VSS sg13g2_tiehi
XFILLER_87_1060 VDD VSS sg13g2_decap_4
XFILLER_99_93 VDD VSS sg13g2_decap_8
XFILLER_143_169 VDD VSS sg13g2_decap_8
X_13208_ _13208_/Y _14793_/Q _13275_/A2 _13262_/B1 VDD VSS sg13g2_o21ai_1
XFILLER_139_1150 VDD VSS sg13g2_fill_2
X_14188_ _14188_/Q clkload53/A _14188_/D _14188_/RESET_B VDD VSS sg13g2_dfrbpq_1
XFILLER_124_372 VDD VSS sg13g2_decap_4
XFILLER_135_1003 VDD VSS sg13g2_decap_8
XFILLER_152_681 VDD VSS sg13g2_decap_8
XFILLER_112_523 VDD VSS sg13g2_decap_4
XFILLER_135_1014 VDD VSS sg13g2_fill_1
XFILLER_140_832 VDD VSS sg13g2_decap_4
XFILLER_135_1025 VDD VSS sg13g2_decap_4
X_13139_ _13139_/Y _13139_/A _13139_/B VDD VSS sg13g2_nand2_1
XFILLER_86_908 VDD VSS sg13g2_decap_4
XFILLER_86_919 VDD VSS sg13g2_decap_8
XFILLER_61_1211 VDD VSS sg13g2_decap_8
XFILLER_135_1069 VDD VSS sg13g2_decap_8
XFILLER_97_278 VDD VSS sg13g2_fill_2
X_13978__2224 _13978_/RESET_B VDD VSS sg13g2_tiehi
XFILLER_6_1425 VDD VSS sg13g2_decap_8
XFILLER_39_835 VDD VSS sg13g2_decap_8
XFILLER_152_1372 VDD VSS sg13g2_fill_1
X_07700_ _15202_/D _07700_/A _07700_/B _07700_/C VDD VSS sg13g2_nand3_1
XFILLER_26_1375 VDD VSS sg13g2_decap_8
X_08680_ _08681_/B _08678_/C _08654_/A _07841_/Y VDD VSS sg13g2_o21ai_1
XFILLER_94_952 VDD VSS sg13g2_decap_8
XFILLER_6_1469 VDD VSS sg13g2_fill_1
XFILLER_113_1356 VDD VSS sg13g2_decap_8
X_14874__2819 _14874_/RESET_B VDD VSS sg13g2_tiehi
XFILLER_65_120 VDD VSS sg13g2_decap_8
XFILLER_61_1288 VDD VSS sg13g2_decap_8
XFILLER_38_345 VDD VSS sg13g2_decap_8
X_07631_ _07631_/Y _08377_/B VDD VSS sg13g2_inv_1
XFILLER_96_1329 VDD VSS sg13g2_decap_8
XFILLER_81_613 VDD VSS sg13g2_fill_1
XFILLER_0_1002 VDD VSS sg13g2_decap_8
XFILLER_53_348 VDD VSS sg13g2_decap_4
XFILLER_111_1091 VDD VSS sg13g2_decap_8
XFILLER_94_1031 VDD VSS sg13g2_decap_4
XFILLER_146_1110 VDD VSS sg13g2_decap_8
X_09301_ _13909_/D _13909_/Q _09899_/A0 _09304_/S VDD VSS sg13g2_mux2_1
XFILLER_62_860 VDD VSS sg13g2_decap_8
XFILLER_0_1079 VDD VSS sg13g2_decap_8
XFILLER_59_1184 VDD VSS sg13g2_decap_8
XFILLER_94_1075 VDD VSS sg13g2_fill_2
X_09232_ _13843_/D _09963_/A1 _13843_/Q _09238_/S VDD VSS sg13g2_mux2_1
XFILLER_167_718 VDD VSS sg13g2_decap_4
XFILLER_181_1078 VDD VSS sg13g2_decap_8
XFILLER_124_1430 VDD VSS sg13g2_fill_2
XFILLER_33_1324 VDD VSS sg13g2_decap_8
X_09163_ _09164_/D _14925_/Q _14924_/Q VDD VSS sg13g2_nor2b_1
XFILLER_72_1384 VDD VSS sg13g2_decap_8
XFILLER_124_1452 VDD VSS sg13g2_decap_8
XFILLER_9_91 VDD VSS sg13g2_decap_8
X_08114_ _08115_/B _07630_/A _08363_/S1 _08113_/Y VDD VSS sg13g2_a21oi_1
XFILLER_108_829 VDD VSS sg13g2_decap_8
XFILLER_148_998 VDD VSS sg13g2_decap_8
X_09094_ _10747_/B _09107_/B _15042_/Q _09093_/Y VDD VSS sg13g2_o21ai_1
XFILLER_162_401 VDD VSS sg13g2_decap_8
XFILLER_135_626 VDD VSS sg13g2_decap_8
XFILLER_135_637 VDD VSS sg13g2_fill_1
XFILLER_107_339 VDD VSS sg13g2_decap_8
X_15198__2776 _15198_/RESET_B VDD VSS sg13g2_tiehi
X_08045_ _08045_/Y _08177_/S _08044_/X _08043_/Y VDD VSS sg13g2_o21ai_1
XFILLER_66_1144 VDD VSS sg13g2_decap_8
XFILLER_88_201 VDD VSS sg13g2_decap_8
XFILLER_0_105 VDD VSS sg13g2_decap_8
XFILLER_118_1223 VDD VSS sg13g2_decap_8
XFILLER_153_1103 VDD VSS sg13g2_decap_8
XFILLER_171_990 VDD VSS sg13g2_fill_2
XFILLER_157_1294 VDD VSS sg13g2_decap_8
Xhold3044 hold3044/X input2/X VDD VSS sg13g2_dlygate4sd3_1
X_09996_ _14579_/D _10062_/A0 _14579_/Q _10002_/S VDD VSS sg13g2_mux2_1
Xhold3055 hold3055/X input32/X VDD VSS sg13g2_dlygate4sd3_1
XFILLER_118_1278 VDD VSS sg13g2_decap_8
Xhold3066 input6/A mem_axi_rdata[11] VDD VSS sg13g2_dlygate4sd3_1
XFILLER_44_1431 VDD VSS sg13g2_decap_8
Xhold3077 hold3077/X input13/X VDD VSS sg13g2_dlygate4sd3_1
XFILLER_103_589 VDD VSS sg13g2_decap_8
XFILLER_131_1401 VDD VSS sg13g2_decap_8
XFILLER_131_898 VDD VSS sg13g2_decap_4
Xhold3088 input31/A mem_axi_rdata[5] VDD VSS sg13g2_dlygate4sd3_1
X_08947_ _13720_/D _08956_/S _08945_/Y _08946_/Y VDD VSS sg13g2_a21oi_1
XFILLER_9_1071 VDD VSS sg13g2_decap_8
X_14568__1634 _14568_/RESET_B VDD VSS sg13g2_tiehi
Xhold3099 input25/A mem_axi_rdata[29] VDD VSS sg13g2_dlygate4sd3_1
XFILLER_57_643 VDD VSS sg13g2_decap_8
X_08878_ _08878_/X _15033_/Q _08877_/A _08877_/Y VDD VSS sg13g2_a21o_1
XFILLER_131_1467 VDD VSS sg13g2_fill_2
XFILLER_151_46 VDD VSS sg13g2_decap_8
XFILLER_84_462 VDD VSS sg13g2_decap_8
X_07829_ _07906_/B _07829_/A _07829_/B VDD VSS sg13g2_and2_1
X_10840_ _10841_/C _10851_/D _12347_/B _10821_/C _10821_/A _10818_/Y VDD VSS sg13g2_a221oi_1
XFILLER_38_1202 VDD VSS sg13g2_decap_8
XFILLER_164_1210 VDD VSS sg13g2_decap_8
XFILLER_53_860 VDD VSS sg13g2_decap_8
X_10771_ _14919_/D _11168_/B1 _11147_/A _10770_/Y VDD VSS sg13g2_o21ai_1
XFILLER_25_573 VDD VSS sg13g2_decap_8
XFILLER_125_1205 VDD VSS sg13g2_fill_2
XFILLER_13_735 VDD VSS sg13g2_decap_4
XFILLER_80_690 VDD VSS sg13g2_decap_8
XFILLER_44_88 VDD VSS sg13g2_decap_8
X_12510_ _12510_/X _12506_/X _12505_/X _12504_/X _12503_/X _12594_/S0 _12623_/S VDD
+ VSS sg13g2_mux4_1
XFILLER_38_1279 VDD VSS sg13g2_decap_8
XFILLER_13_757 VDD VSS sg13g2_decap_8
XFILLER_185_504 VDD VSS sg13g2_decap_8
X_13490_ _13490_/Y _15198_/Q _13490_/B _13490_/C _13490_/D VDD VSS sg13g2_nor4_1
XFILLER_12_245 VDD VSS sg13g2_decap_8
XFILLER_139_910 VDD VSS sg13g2_decap_8
XFILLER_164_1287 VDD VSS sg13g2_decap_8
XFILLER_9_728 VDD VSS sg13g2_decap_8
X_12441_ _12441_/X _12439_/X _12440_/X _12455_/S VDD VSS sg13g2_mux2_1
XFILLER_51_1424 VDD VSS sg13g2_decap_8
XFILLER_60_32 VDD VSS sg13g2_fill_2
XFILLER_8_249 VDD VSS sg13g2_decap_8
XFILLER_139_976 VDD VSS sg13g2_decap_8
XFILLER_176_21 VDD VSS sg13g2_decap_8
XFILLER_138_464 VDD VSS sg13g2_decap_8
X_15160_ _15160_/Q _15160_/CLK _15160_/D _15160_/RESET_B VDD VSS sg13g2_dfrbpq_1
X_12372_ _12372_/Y _12372_/A _12372_/B VDD VSS sg13g2_nand2_1
XFILLER_166_784 VDD VSS sg13g2_decap_8
XFILLER_181_710 VDD VSS sg13g2_fill_1
XFILLER_181_721 VDD VSS sg13g2_fill_1
XFILLER_114_0 VDD VSS sg13g2_decap_8
X_14111_ _14111_/Q clkload61/A _14111_/D _14111_/RESET_B VDD VSS sg13g2_dfrbpq_1
X_11323_ _11323_/Y _11328_/S0 _14141_/Q _11328_/S1 VDD VSS sg13g2_a21oi_1
X_15091_ _15091_/Q clkload70/A _15091_/D _15091_/RESET_B VDD VSS sg13g2_dfrbpq_1
XFILLER_5_945 VDD VSS sg13g2_decap_8
XFILLER_125_147 VDD VSS sg13g2_decap_8
XFILLER_176_98 VDD VSS sg13g2_decap_8
XFILLER_180_231 VDD VSS sg13g2_decap_8
XFILLER_153_467 VDD VSS sg13g2_decap_4
XFILLER_5_49 VDD VSS sg13g2_decap_8
XFILLER_4_455 VDD VSS sg13g2_decap_8
XFILLER_49_1331 VDD VSS sg13g2_decap_8
XFILLER_101_1282 VDD VSS sg13g2_decap_8
XFILLER_106_350 VDD VSS sg13g2_decap_8
X_14042_ _14042_/Q clkload78/A _14042_/D _14042_/RESET_B VDD VSS sg13g2_dfrbpq_1
X_11254_ _11255_/A _11282_/S0 _14652_/Q _12184_/B VDD VSS sg13g2_a21oi_1
XFILLER_69_30 VDD VSS sg13g2_fill_2
XFILLER_10_1176 VDD VSS sg13g2_decap_8
XFILLER_84_1233 VDD VSS sg13g2_decap_8
XFILLER_134_670 VDD VSS sg13g2_decap_8
XFILLER_171_1203 VDD VSS sg13g2_decap_8
XFILLER_79_212 VDD VSS sg13g2_fill_1
X_10205_ _15200_/D hold3079/X _15200_/Q _13477_/S VDD VSS sg13g2_mux2_1
X_11185_ _11197_/B _11185_/A _11185_/B VDD VSS sg13g2_xnor2_1
XFILLER_45_1228 VDD VSS sg13g2_decap_8
X_10136_ _14714_/D _10169_/A1 _14714_/Q _10136_/S VDD VSS sg13g2_mux2_1
XFILLER_0_672 VDD VSS sg13g2_decap_8
XFILLER_121_386 VDD VSS sg13g2_decap_8
XFILLER_88_790 VDD VSS sg13g2_fill_2
X_14944_ _14944_/Q clkload69/A _14944_/D _14944_/RESET_B VDD VSS sg13g2_dfrbpq_1
X_10067_ _14648_/D _10100_/A0 _14648_/Q _10069_/S VDD VSS sg13g2_mux2_1
XFILLER_85_51 VDD VSS sg13g2_decap_4
XFILLER_48_654 VDD VSS sg13g2_fill_2
XFILLER_78_1004 VDD VSS sg13g2_decap_8
XFILLER_169_1132 VDD VSS sg13g2_fill_2
XFILLER_85_95 VDD VSS sg13g2_decap_4
X_14875_ _14875_/Q clkload83/A _14875_/D _14875_/RESET_B VDD VSS sg13g2_dfrbpq_1
XFILLER_91_944 VDD VSS sg13g2_fill_2
XFILLER_90_421 VDD VSS sg13g2_decap_8
XFILLER_62_112 VDD VSS sg13g2_decap_8
XFILLER_1_1344 VDD VSS sg13g2_decap_8
X_13826_ _13826_/Q _14722_/CLK _13826_/D _13826_/RESET_B VDD VSS sg13g2_dfrbpq_1
XFILLER_165_1029 VDD VSS sg13g2_decap_8
XFILLER_95_1362 VDD VSS sg13g2_fill_2
XFILLER_91_1204 VDD VSS sg13g2_decap_8
XFILLER_44_871 VDD VSS sg13g2_decap_4
XFILLER_95_1384 VDD VSS sg13g2_decap_4
X_13757_ _13757_/Q clkload30/A _13757_/D _13757_/RESET_B VDD VSS sg13g2_dfrbpq_1
XFILLER_90_498 VDD VSS sg13g2_decap_8
X_10969_ _10969_/Y _10969_/A _10969_/B VDD VSS sg13g2_nand2_1
XFILLER_95_1395 VDD VSS sg13g2_fill_2
XFILLER_56_1346 VDD VSS sg13g2_decap_8
XFILLER_17_1308 VDD VSS sg13g2_decap_8
XFILLER_91_1248 VDD VSS sg13g2_fill_1
XFILLER_143_1327 VDD VSS sg13g2_fill_2
XFILLER_182_1376 VDD VSS sg13g2_decap_8
X_12708_ _15014_/D _12708_/A _12708_/B VDD VSS sg13g2_nor2_1
XFILLER_148_206 VDD VSS sg13g2_decap_8
X_13688_ _13688_/Q _14930_/CLK _13688_/D _13688_/RESET_B VDD VSS sg13g2_dfrbpq_1
X_14042__2160 _14042_/RESET_B VDD VSS sg13g2_tiehi
X_12639_ _12652_/A _12639_/A1 _12639_/A2 _15010_/Q VDD VSS sg13g2_a21oi_1
XFILLER_129_442 VDD VSS sg13g2_decap_8
XFILLER_15_1054 VDD VSS sg13g2_decap_8
XFILLER_163_209 VDD VSS sg13g2_decap_4
XFILLER_156_250 VDD VSS sg13g2_fill_1
XFILLER_129_486 VDD VSS sg13g2_decap_8
X_14646__1556 _14646_/RESET_B VDD VSS sg13g2_tiehi
XFILLER_116_114 VDD VSS sg13g2_fill_2
XFILLER_144_423 VDD VSS sg13g2_decap_8
XFILLER_145_946 VDD VSS sg13g2_fill_1
XFILLER_89_1155 VDD VSS sg13g2_decap_8
XFILLER_176_1114 VDD VSS sg13g2_decap_8
X_14309_ _14309_/Q clkload16/A _14309_/D _14309_/RESET_B VDD VSS sg13g2_dfrbpq_1
XFILLER_89_1166 VDD VSS sg13g2_fill_1
XFILLER_145_968 VDD VSS sg13g2_decap_4
XFILLER_160_905 VDD VSS sg13g2_fill_1
XFILLER_116_169 VDD VSS sg13g2_decap_8
XFILLER_137_1109 VDD VSS sg13g2_decap_8
XFILLER_172_787 VDD VSS sg13g2_decap_8
XFILLER_131_106 VDD VSS sg13g2_decap_8
XFILLER_154_1401 VDD VSS sg13g2_decap_8
XFILLER_112_320 VDD VSS sg13g2_fill_2
Xfanout707 _11330_/S _12192_/A VDD VSS sg13g2_buf_1
X_09850_ _14437_/D _14437_/Q _10081_/A0 _09858_/S VDD VSS sg13g2_mux2_1
Xfanout718 _11900_/B fanout719/X VDD VSS sg13g2_buf_1
XFILLER_28_1448 VDD VSS sg13g2_decap_8
Xfanout729 _12190_/B _12258_/C1 VDD VSS sg13g2_buf_1
XFILLER_98_565 VDD VSS sg13g2_decap_8
X_08801_ _08802_/B _13685_/Q _08810_/B VDD VSS sg13g2_nor2_1
X_09781_ _14370_/D _09814_/A0 _14370_/Q _09795_/S VDD VSS sg13g2_mux2_1
XFILLER_6_1222 VDD VSS sg13g2_decap_8
X_15014__2596 _15014_/RESET_B VDD VSS sg13g2_tiehi
XFILLER_26_1172 VDD VSS sg13g2_decap_8
XFILLER_113_1131 VDD VSS sg13g2_decap_8
XFILLER_22_1014 VDD VSS sg13g2_decap_4
X_08732_ _13662_/D _08765_/A1 _08730_/Y _08731_/Y VDD VSS sg13g2_a21oi_1
XFILLER_85_259 VDD VSS sg13g2_decap_8
XFILLER_38_120 VDD VSS sg13g2_decap_8
XFILLER_22_1036 VDD VSS sg13g2_decap_8
XFILLER_39_665 VDD VSS sg13g2_decap_8
X_08663_ _08663_/X _08663_/A _08698_/B VDD VSS sg13g2_and2_1
XFILLER_67_996 VDD VSS sg13g2_fill_2
XFILLER_6_1299 VDD VSS sg13g2_decap_8
XFILLER_81_421 VDD VSS sg13g2_decap_8
XFILLER_54_646 VDD VSS sg13g2_decap_8
X_14252__1950 _14252_/RESET_B VDD VSS sg13g2_tiehi
X_07614_ _07614_/Y _14955_/Q VDD VSS sg13g2_inv_1
XFILLER_82_966 VDD VSS sg13g2_decap_8
XFILLER_26_348 VDD VSS sg13g2_decap_8
X_08594_ _08596_/C _08541_/A _07858_/X _07857_/X _08593_/Y VDD VSS sg13g2_a22oi_1
XFILLER_22_521 VDD VSS sg13g2_fill_2
XFILLER_14_14 VDD VSS sg13g2_decap_8
XFILLER_74_1457 VDD VSS sg13g2_decap_8
XFILLER_35_1408 VDD VSS sg13g2_decap_8
XFILLER_139_228 VDD VSS sg13g2_decap_8
XFILLER_179_397 VDD VSS sg13g2_decap_4
XFILLER_167_548 VDD VSS sg13g2_decap_4
X_09215_ _13826_/D _09814_/A0 _13826_/Q _09229_/S VDD VSS sg13g2_mux2_1
XFILLER_33_1121 VDD VSS sg13g2_decap_8
XFILLER_72_1181 VDD VSS sg13g2_decap_8
XFILLER_10_749 VDD VSS sg13g2_decap_8
XFILLER_182_518 VDD VSS sg13g2_fill_2
X_09146_ _13783_/D _13783_/Q _10166_/A1 _09153_/S VDD VSS sg13g2_mux2_1
XFILLER_120_1146 VDD VSS sg13g2_decap_4
XFILLER_33_1198 VDD VSS sg13g2_decap_8
X_09077_ _13773_/D _13773_/Q _10156_/A1 _09077_/S VDD VSS sg13g2_mux2_1
XFILLER_159_1367 VDD VSS sg13g2_decap_8
XFILLER_163_787 VDD VSS sg13g2_decap_8
X_08028_ _08031_/C _08102_/A3 _07910_/B _08253_/A1 _08278_/A3 _07900_/B _07883_/A
+ VDD VSS sg13g2_mux4_1
XFILLER_150_404 VDD VSS sg13g2_fill_1
XFILLER_162_264 VDD VSS sg13g2_decap_8
XFILLER_135_489 VDD VSS sg13g2_decap_4
XFILLER_162_275 VDD VSS sg13g2_fill_2
XFILLER_150_426 VDD VSS sg13g2_decap_8
XFILLER_150_437 VDD VSS sg13g2_fill_1
X_13740__2462 _13740_/RESET_B VDD VSS sg13g2_tiehi
XFILLER_104_843 VDD VSS sg13g2_decap_8
XFILLER_2_959 VDD VSS sg13g2_decap_8
XFILLER_103_342 VDD VSS sg13g2_decap_8
XFILLER_7_1008 VDD VSS sg13g2_decap_8
XFILLER_77_705 VDD VSS sg13g2_decap_8
XFILLER_118_1064 VDD VSS sg13g2_fill_2
XFILLER_1_469 VDD VSS sg13g2_decap_8
XFILLER_89_576 VDD VSS sg13g2_decap_8
XFILLER_118_1075 VDD VSS sg13g2_decap_8
XFILLER_131_695 VDD VSS sg13g2_decap_4
X_09979_ _14562_/D _10045_/A0 _14562_/Q _09990_/S VDD VSS sg13g2_mux2_1
XFILLER_130_172 VDD VSS sg13g2_fill_2
XFILLER_162_67 VDD VSS sg13g2_decap_8
X_14084__2118 _14084_/RESET_B VDD VSS sg13g2_tiehi
XFILLER_40_1103 VDD VSS sg13g2_decap_4
XFILLER_76_259 VDD VSS sg13g2_decap_8
XFILLER_170_1291 VDD VSS sg13g2_decap_8
X_12990_ _12990_/X _12990_/A _13683_/Q _14904_/Q VDD VSS sg13g2_and3_1
X_14120__2082 _14120_/RESET_B VDD VSS sg13g2_tiehi
XFILLER_79_1302 VDD VSS sg13g2_decap_4
XFILLER_73_900 VDD VSS sg13g2_decap_8
XFILLER_18_838 VDD VSS sg13g2_decap_4
X_11941_ _11941_/Y _11969_/A _14160_/Q _11970_/C VDD VSS sg13g2_a21oi_1
XFILLER_40_1158 VDD VSS sg13g2_decap_8
XFILLER_85_793 VDD VSS sg13g2_decap_8
XFILLER_84_270 VDD VSS sg13g2_fill_2
XFILLER_57_484 VDD VSS sg13g2_decap_8
XFILLER_55_32 VDD VSS sg13g2_decap_8
XFILLER_79_1346 VDD VSS sg13g2_decap_8
XFILLER_29_186 VDD VSS sg13g2_decap_8
X_14660_ _14660_/Q clkload49/A _14660_/D _14660_/RESET_B VDD VSS sg13g2_dfrbpq_1
XFILLER_17_359 VDD VSS sg13g2_fill_1
X_11872_ _11872_/Y _11896_/A _13934_/Q _11529_/B VDD VSS sg13g2_a21oi_1
XFILLER_73_977 VDD VSS sg13g2_decap_8
XFILLER_45_668 VDD VSS sg13g2_decap_8
XFILLER_44_145 VDD VSS sg13g2_decap_8
X_14724__1478 _14724_/RESET_B VDD VSS sg13g2_tiehi
XFILLER_60_605 VDD VSS sg13g2_decap_8
X_13611_ _15167_/D _13610_/Y _13508_/C _13608_/Y VDD VSS sg13g2_a21oi_1
X_10823_ _10823_/Y _10823_/A _10843_/C _10823_/C VDD VSS sg13g2_nand3_1
X_14591_ _14591_/Q clkload61/A _14591_/D _14591_/RESET_B VDD VSS sg13g2_dfrbpq_1
XFILLER_60_638 VDD VSS sg13g2_fill_2
XFILLER_26_893 VDD VSS sg13g2_fill_1
XFILLER_38_1043 VDD VSS sg13g2_decap_8
XFILLER_111_71 VDD VSS sg13g2_decap_8
XFILLER_164_1051 VDD VSS sg13g2_fill_2
XFILLER_41_841 VDD VSS sg13g2_decap_8
XFILLER_25_392 VDD VSS sg13g2_decap_8
XFILLER_13_543 VDD VSS sg13g2_decap_8
X_13542_ _13542_/Y _14995_/Q _13545_/B _15003_/Q _13546_/B2 VDD VSS sg13g2_a22oi_1
XFILLER_38_1065 VDD VSS sg13g2_decap_8
XFILLER_185_301 VDD VSS sg13g2_decap_8
X_10754_ _10754_/X _14947_/Q _10752_/A _10752_/Y VDD VSS sg13g2_a21o_1
XFILLER_71_42 VDD VSS sg13g2_decap_8
XFILLER_38_1098 VDD VSS sg13g2_fill_2
XFILLER_16_1330 VDD VSS sg13g2_decap_8
XFILLER_9_525 VDD VSS sg13g2_decap_8
XFILLER_186_868 VDD VSS sg13g2_decap_8
X_13473_ _15177_/D hold3065/X _15177_/Q _13477_/S VDD VSS sg13g2_mux2_1
X_10685_ _10685_/Y _12859_/A _10875_/B VDD VSS sg13g2_nand2_1
XFILLER_51_1221 VDD VSS sg13g2_decap_8
XFILLER_40_384 VDD VSS sg13g2_fill_1
XFILLER_103_1300 VDD VSS sg13g2_decap_8
XFILLER_103_1311 VDD VSS sg13g2_fill_2
XFILLER_40_395 VDD VSS sg13g2_decap_8
X_15212_ _15212_/Q _15212_/CLK _15212_/D _15212_/RESET_B VDD VSS sg13g2_dfrbpq_1
XFILLER_185_378 VDD VSS sg13g2_decap_8
X_12424_ _12424_/X _13824_/Q _13856_/Q _13888_/Q _13920_/Q _12698_/S0 _12698_/S1 VDD
+ VSS sg13g2_mux4_1
XFILLER_127_924 VDD VSS sg13g2_decap_8
XFILLER_139_784 VDD VSS sg13g2_decap_8
XFILLER_142_1382 VDD VSS sg13g2_fill_1
XFILLER_177_1401 VDD VSS sg13g2_decap_8
XFILLER_127_946 VDD VSS sg13g2_decap_8
XFILLER_51_1298 VDD VSS sg13g2_decap_8
XFILLER_126_434 VDD VSS sg13g2_fill_1
X_15143_ _15143_/Q clkload34/A _15143_/D _15143_/RESET_B VDD VSS sg13g2_dfrbpq_1
X_12355_ _12356_/B _12353_/X _12354_/X _12355_/S VDD VSS sg13g2_mux2_1
XFILLER_126_456 VDD VSS sg13g2_decap_8
XFILLER_5_742 VDD VSS sg13g2_decap_8
XFILLER_138_1407 VDD VSS sg13g2_fill_1
XFILLER_142_916 VDD VSS sg13g2_decap_8
XFILLER_153_242 VDD VSS sg13g2_decap_8
XFILLER_173_1309 VDD VSS sg13g2_decap_8
X_11306_ _11306_/Y _11302_/Y _11303_/Y _11305_/Y _11304_/Y _12290_/S0 VDD VSS sg13g2_a221oi_1
XFILLER_142_938 VDD VSS sg13g2_decap_8
X_14294__1908 _14294_/RESET_B VDD VSS sg13g2_tiehi
X_15074_ _15074_/Q clkload72/A _15074_/D _15074_/RESET_B VDD VSS sg13g2_dfrbpq_1
X_12286_ _12286_/X _13977_/Q _14009_/Q _14041_/Q _14073_/Q _12286_/S0 _12288_/S1 VDD
+ VSS sg13g2_mux4_1
XFILLER_4_252 VDD VSS sg13g2_decap_8
XFILLER_181_595 VDD VSS sg13g2_decap_8
XFILLER_136_1120 VDD VSS sg13g2_fill_2
X_14025_ _14025_/Q _14665_/CLK _14025_/D _14025_/RESET_B VDD VSS sg13g2_dfrbpq_1
X_14330__1872 _14330_/RESET_B VDD VSS sg13g2_tiehi
X_11237_ _11237_/Y _12192_/A _11231_/X _11236_/Y VDD VSS sg13g2_o21ai_1
XFILLER_45_1025 VDD VSS sg13g2_decap_8
X_14942__2683 _14942_/RESET_B VDD VSS sg13g2_tiehi
XFILLER_110_802 VDD VSS sg13g2_decap_8
XFILLER_68_716 VDD VSS sg13g2_decap_8
XFILLER_68_727 VDD VSS sg13g2_fill_2
XFILLER_171_1055 VDD VSS sg13g2_fill_1
X_11168_ _11168_/X _11164_/C _11193_/A2 _11168_/B1 VDD VSS sg13g2_a21o_1
XFILLER_136_1186 VDD VSS sg13g2_decap_8
XFILLER_121_172 VDD VSS sg13g2_fill_2
XFILLER_132_1028 VDD VSS sg13g2_decap_8
X_10119_ _14697_/D _10152_/A1 _14697_/Q _10123_/S VDD VSS sg13g2_mux2_1
XFILLER_67_248 VDD VSS sg13g2_fill_1
X_11099_ _11099_/Y _11098_/Y _11096_/Y _11095_/Y _11139_/B1 _13419_/A2 VDD VSS sg13g2_a221oi_1
XFILLER_62_1383 VDD VSS sg13g2_decap_8
XFILLER_23_1367 VDD VSS sg13g2_decap_8
X_14927_ _14927_/Q _14930_/CLK _14927_/D _14927_/RESET_B VDD VSS sg13g2_dfrbpq_1
XFILLER_3_1439 VDD VSS sg13g2_decap_8
XFILLER_97_1435 VDD VSS sg13g2_decap_8
XFILLER_36_624 VDD VSS sg13g2_decap_4
XFILLER_91_730 VDD VSS sg13g2_fill_2
XFILLER_1_1141 VDD VSS sg13g2_decap_8
X_14858_ _14858_/Q clkload90/A _14858_/D _14858_/RESET_B VDD VSS sg13g2_dfrbpq_1
X_15179__2874 _15179_/RESET_B VDD VSS sg13g2_tiehi
X_13809_ _13809_/Q _14417_/CLK _13809_/D _13809_/RESET_B VDD VSS sg13g2_dfrbpq_1
XFILLER_17_893 VDD VSS sg13g2_fill_1
XFILLER_63_498 VDD VSS sg13g2_decap_8
X_14789_ _14789_/Q clkload89/A _14789_/D _14789_/RESET_B VDD VSS sg13g2_dfrbpq_1
XFILLER_16_381 VDD VSS sg13g2_decap_8
X_15120__2742 _15120_/RESET_B VDD VSS sg13g2_tiehi
XFILLER_56_1143 VDD VSS sg13g2_decap_8
XFILLER_177_802 VDD VSS sg13g2_decap_4
XFILLER_17_1105 VDD VSS sg13g2_decap_8
XFILLER_91_1034 VDD VSS sg13g2_fill_1
XFILLER_177_835 VDD VSS sg13g2_decap_8
XFILLER_182_1173 VDD VSS sg13g2_decap_8
X_14808__2928 _14808_/RESET_B VDD VSS sg13g2_tiehi
XFILLER_108_1255 VDD VSS sg13g2_decap_8
XFILLER_143_1168 VDD VSS sg13g2_decap_8
XFILLER_31_384 VDD VSS sg13g2_decap_8
X_09000_ _09000_/Y _14900_/Q _08993_/X _08999_/Y VDD VSS sg13g2_a21oi_1
XFILLER_34_1474 VDD VSS sg13g2_decap_4
XFILLER_117_401 VDD VSS sg13g2_fill_1
XFILLER_30_1349 VDD VSS sg13g2_decap_8
XFILLER_144_220 VDD VSS sg13g2_decap_8
XFILLER_117_467 VDD VSS sg13g2_fill_2
XFILLER_6_81 VDD VSS sg13g2_decap_8
XFILLER_144_275 VDD VSS sg13g2_fill_2
X_09902_ _14488_/D _09935_/A1 _14488_/Q _09903_/S VDD VSS sg13g2_mux2_1
Xfanout504 _08753_/A1 _08729_/Y VDD VSS sg13g2_buf_1
XFILLER_67_1283 VDD VSS sg13g2_decap_8
XFILLER_141_960 VDD VSS sg13g2_fill_2
Xfanout515 _13656_/S _13650_/S VDD VSS sg13g2_buf_1
XFILLER_99_874 VDD VSS sg13g2_decap_4
XFILLER_8_1306 VDD VSS sg13g2_decap_8
XFILLER_28_1245 VDD VSS sg13g2_decap_8
Xfanout526 _13587_/B fanout528/X VDD VSS sg13g2_buf_1
Xfanout537 _12223_/A _12292_/A VDD VSS sg13g2_buf_1
X_09833_ _14421_/D _10164_/A1 _14421_/Q _09837_/S VDD VSS sg13g2_mux2_1
XFILLER_59_727 VDD VSS sg13g2_decap_8
XFILLER_113_684 VDD VSS sg13g2_fill_1
XFILLER_141_993 VDD VSS sg13g2_decap_8
Xfanout548 _10071_/A0 _09741_/A1 VDD VSS sg13g2_buf_1
XFILLER_112_172 VDD VSS sg13g2_decap_4
Xfanout559 _08787_/B fanout565/X VDD VSS sg13g2_buf_1
XFILLER_63_1169 VDD VSS sg13g2_decap_8
XFILLER_80_1461 VDD VSS sg13g2_decap_8
XFILLER_100_345 VDD VSS sg13g2_decap_8
X_09764_ _14354_/D _14354_/Q _09830_/A0 _09771_/S VDD VSS sg13g2_mux2_1
XFILLER_86_579 VDD VSS sg13g2_decap_8
XFILLER_67_760 VDD VSS sg13g2_decap_8
XFILLER_55_900 VDD VSS sg13g2_decap_8
X_08715_ _15190_/D hold3091/X _15190_/Q _10203_/S VDD VSS sg13g2_mux2_1
XFILLER_41_1467 VDD VSS sg13g2_decap_8
X_09695_ _14287_/D _10158_/A1 _14287_/Q _09704_/S VDD VSS sg13g2_mux2_1
XFILLER_6_1096 VDD VSS sg13g2_decap_8
XFILLER_41_1478 VDD VSS sg13g2_fill_1
XFILLER_39_495 VDD VSS sg13g2_decap_4
XFILLER_26_112 VDD VSS sg13g2_decap_8
XFILLER_66_292 VDD VSS sg13g2_decap_8
XFILLER_54_432 VDD VSS sg13g2_decap_8
X_08646_ _08646_/Y _08646_/A _08646_/B _08646_/C VDD VSS sg13g2_nand3_1
XFILLER_81_273 VDD VSS sg13g2_fill_1
X_08577_ _08577_/Y _08612_/S _08577_/B VDD VSS sg13g2_nor2_1
XFILLER_25_46 VDD VSS sg13g2_decap_8
XFILLER_35_690 VDD VSS sg13g2_decap_4
XFILLER_23_841 VDD VSS sg13g2_decap_8
XFILLER_165_1371 VDD VSS sg13g2_decap_8
XFILLER_74_1254 VDD VSS sg13g2_decap_8
XFILLER_35_1205 VDD VSS sg13g2_decap_8
Xclkbuf_5_0__f_clk_i clkbuf_leaf_2_clk_i/A clkbuf_4_0_0_clk_i/X VDD VSS sg13g2_buf_16
X_13758__2444 _13758_/RESET_B VDD VSS sg13g2_tiehi
XFILLER_39_1385 VDD VSS sg13g2_decap_8
XFILLER_179_172 VDD VSS sg13g2_decap_8
XFILLER_161_1268 VDD VSS sg13g2_decap_8
XFILLER_183_805 VDD VSS sg13g2_decap_8
XFILLER_10_546 VDD VSS sg13g2_decap_8
XFILLER_126_1399 VDD VSS sg13g2_decap_8
X_15068__2892 _15068_/RESET_B VDD VSS sg13g2_tiehi
XFILLER_183_838 VDD VSS sg13g2_decap_8
X_10470_ _10477_/C _14845_/Q _10500_/A _10511_/D _10471_/D VDD VSS sg13g2_and4_1
XFILLER_108_401 VDD VSS sg13g2_fill_1
XFILLER_136_710 VDD VSS sg13g2_fill_2
XFILLER_41_56 VDD VSS sg13g2_decap_8
XFILLER_182_326 VDD VSS sg13g2_decap_4
XFILLER_109_946 VDD VSS sg13g2_decap_4
XFILLER_108_434 VDD VSS sg13g2_fill_2
X_09129_ _09129_/Y _13199_/A _09157_/C _09151_/A VDD VSS sg13g2_o21ai_1
XFILLER_157_67 VDD VSS sg13g2_decap_8
XFILLER_136_765 VDD VSS sg13g2_decap_8
XFILLER_157_78 VDD VSS sg13g2_fill_2
X_14138__2064 _14138_/RESET_B VDD VSS sg13g2_tiehi
XFILLER_68_1025 VDD VSS sg13g2_decap_8
X_12140_ _12140_/X _13973_/Q _14005_/Q _14037_/Q _14069_/Q _12140_/S0 _12140_/S1 VDD
+ VSS sg13g2_mux4_1
XFILLER_159_1164 VDD VSS sg13g2_decap_8
XFILLER_163_573 VDD VSS sg13g2_decap_8
XFILLER_11_1282 VDD VSS sg13g2_decap_8
X_12071_ _12071_/X _13747_/Q _14099_/Q _14451_/Q _14547_/Q _12135_/S0 _12135_/S1 VDD
+ VSS sg13g2_mux4_1
XFILLER_46_1323 VDD VSS sg13g2_decap_8
XFILLER_2_756 VDD VSS sg13g2_decap_8
XFILLER_151_779 VDD VSS sg13g2_decap_4
XFILLER_85_1383 VDD VSS sg13g2_decap_8
XFILLER_132_971 VDD VSS sg13g2_decap_8
X_11022_ _11022_/Y _11022_/A _11022_/B VDD VSS sg13g2_nand2_1
XFILLER_104_673 VDD VSS sg13g2_decap_8
XFILLER_1_266 VDD VSS sg13g2_decap_8
XFILLER_77_513 VDD VSS sg13g2_decap_4
XFILLER_173_77 VDD VSS sg13g2_decap_8
XFILLER_172_1375 VDD VSS sg13g2_decap_8
XFILLER_81_1258 VDD VSS sg13g2_decap_8
XFILLER_49_215 VDD VSS sg13g2_decap_8
XFILLER_2_28 VDD VSS sg13g2_decap_8
XFILLER_133_1348 VDD VSS sg13g2_decap_8
X_13668__2559 _13668_/RESET_B VDD VSS sg13g2_tiehi
XFILLER_49_248 VDD VSS sg13g2_fill_2
XFILLER_66_42 VDD VSS sg13g2_decap_8
XFILLER_181_0 VDD VSS sg13g2_decap_8
X_12973_ _12988_/D _14905_/Q _13682_/Q VDD VSS sg13g2_xnor2_1
XFILLER_17_112 VDD VSS sg13g2_decap_8
XFILLER_18_635 VDD VSS sg13g2_decap_8
XFILLER_45_432 VDD VSS sg13g2_fill_2
X_14712_ _14712_/Q clkload46/A _14712_/D _14712_/RESET_B VDD VSS sg13g2_dfrbpq_1
X_14919__2729 _14919_/RESET_B VDD VSS sg13g2_tiehi
X_11924_ _11924_/X _14127_/Q _14159_/Q _14191_/Q _14223_/Q _12072_/S0 _12072_/S1 VDD
+ VSS sg13g2_mux4_1
XFILLER_46_977 VDD VSS sg13g2_decap_8
XFILLER_61_903 VDD VSS sg13g2_decap_8
XFILLER_79_1176 VDD VSS sg13g2_decap_8
XFILLER_122_70 VDD VSS sg13g2_decap_8
XFILLER_75_1018 VDD VSS sg13g2_decap_8
XFILLER_45_476 VDD VSS sg13g2_decap_8
XFILLER_122_81 VDD VSS sg13g2_fill_2
XFILLER_166_1157 VDD VSS sg13g2_decap_8
X_14643_ _14643_/Q clkload37/A _14643_/D _14643_/RESET_B VDD VSS sg13g2_dfrbpq_1
X_11855_ _11856_/B _11847_/X _11848_/X _11851_/X _11852_/X _11964_/B _11974_/B1 VDD
+ VSS sg13g2_mux4_1
XFILLER_60_424 VDD VSS sg13g2_decap_4
XFILLER_32_126 VDD VSS sg13g2_decap_4
XFILLER_177_109 VDD VSS sg13g2_decap_8
XFILLER_144_1422 VDD VSS sg13g2_decap_8
X_10806_ _10807_/C _15121_/Q _10813_/A VDD VSS sg13g2_xnor2_1
XFILLER_13_340 VDD VSS sg13g2_decap_8
XFILLER_144_1433 VDD VSS sg13g2_fill_2
X_14574_ _14574_/Q clkload19/A _14574_/D _14574_/RESET_B VDD VSS sg13g2_dfrbpq_1
X_11786_ _11786_/X _14379_/Q _14411_/Q _14475_/Q _14507_/Q _11786_/S0 _11786_/S1 VDD
+ VSS sg13g2_mux4_1
X_14348__1854 _14348_/RESET_B VDD VSS sg13g2_tiehi
XFILLER_159_857 VDD VSS sg13g2_decap_8
XFILLER_41_671 VDD VSS sg13g2_fill_1
XFILLER_18_1469 VDD VSS sg13g2_decap_4
X_13525_ _13525_/X _13525_/A _13545_/B VDD VSS sg13g2_and2_1
XFILLER_9_322 VDD VSS sg13g2_decap_8
XFILLER_53_1349 VDD VSS sg13g2_decap_8
X_10737_ _10737_/Y _13088_/A _11001_/B VDD VSS sg13g2_nand2_1
XFILLER_41_693 VDD VSS sg13g2_decap_8
XFILLER_186_665 VDD VSS sg13g2_decap_8
XFILLER_173_304 VDD VSS sg13g2_decap_8
XFILLER_173_315 VDD VSS sg13g2_fill_1
XFILLER_185_175 VDD VSS sg13g2_decap_8
X_13456_ _13456_/X _15190_/Q _15191_/Q _15192_/Q _13463_/D VDD VSS sg13g2_or4_1
XFILLER_70_7 VDD VSS sg13g2_decap_8
XFILLER_173_326 VDD VSS sg13g2_decap_8
X_10668_ _10802_/A _10697_/C _10697_/B _14926_/Q VDD VSS sg13g2_a21oi_1
XFILLER_103_1141 VDD VSS sg13g2_fill_1
XFILLER_9_399 VDD VSS sg13g2_decap_8
X_12407_ _12407_/X _14239_/Q _14271_/Q _14303_/Q _14335_/Q _12411_/S0 _12411_/S1 VDD
+ VSS sg13g2_mux4_1
X_13387_ _15082_/D _13367_/Y _13378_/C _13386_/Y VDD VSS sg13g2_o21ai_1
X_10599_ _14876_/D _10599_/A _10599_/B _10610_/D VDD VSS sg13g2_nor3_1
XFILLER_12_1068 VDD VSS sg13g2_decap_8
XFILLER_86_1125 VDD VSS sg13g2_decap_8
Xoutput107 mem_axi_wdata[12] _15144_/Q VDD VSS sg13g2_buf_1
X_15126_ _15126_/Q clkload81/A _15126_/D _15126_/RESET_B VDD VSS sg13g2_dfrbpq_1
Xoutput118 mem_axi_wdata[22] _15154_/Q VDD VSS sg13g2_buf_1
Xoutput129 mem_axi_wdata[3] _15135_/Q VDD VSS sg13g2_buf_1
X_12338_ _12338_/Y _14925_/Q _12338_/A2 _12334_/Y _12337_/Y VDD VSS sg13g2_a22oi_1
XFILLER_142_735 VDD VSS sg13g2_decap_8
XFILLER_173_1106 VDD VSS sg13g2_decap_8
XFILLER_177_1275 VDD VSS sg13g2_decap_8
XFILLER_86_1169 VDD VSS sg13g2_decap_8
X_15057_ _15057_/Q _15165_/CLK _15057_/D _15057_/RESET_B VDD VSS sg13g2_dfrbpq_1
X_12269_ _12270_/B _12231_/X _12294_/B1 _12268_/Y VDD VSS sg13g2_a21oi_1
X_14008_ _14008_/Q _14514_/CLK _14008_/D _14008_/RESET_B VDD VSS sg13g2_dfrbpq_1
XFILLER_64_1456 VDD VSS sg13g2_decap_8
XFILLER_25_1418 VDD VSS sg13g2_decap_8
XFILLER_151_1415 VDD VSS sg13g2_decap_8
XFILLER_151_1437 VDD VSS sg13g2_decap_8
XFILLER_95_332 VDD VSS sg13g2_decap_8
X_13836__2366 _13836_/RESET_B VDD VSS sg13g2_tiehi
XFILLER_96_899 VDD VSS sg13g2_fill_2
XFILLER_7_1372 VDD VSS sg13g2_decap_8
XFILLER_62_1180 VDD VSS sg13g2_decap_8
XFILLER_23_1164 VDD VSS sg13g2_decap_8
XFILLER_36_410 VDD VSS sg13g2_decap_8
XFILLER_3_1236 VDD VSS sg13g2_decap_8
X_08500_ _08501_/B _08527_/B _08498_/Y _08499_/Y VDD VSS sg13g2_a21o_1
XFILLER_149_1322 VDD VSS sg13g2_decap_8
X_09480_ _14080_/D _10010_/A0 _14080_/Q _09493_/S VDD VSS sg13g2_mux2_1
XFILLER_97_1265 VDD VSS sg13g2_decap_4
XFILLER_58_1238 VDD VSS sg13g2_decap_8
X_08431_ _08431_/X _08431_/A _08544_/B _08431_/C _08511_/S VDD VSS sg13g2_and4_1
XFILLER_93_1129 VDD VSS sg13g2_decap_8
XFILLER_63_273 VDD VSS sg13g2_decap_8
XFILLER_91_593 VDD VSS sg13g2_decap_8
XFILLER_63_284 VDD VSS sg13g2_fill_1
XFILLER_184_1268 VDD VSS sg13g2_decap_8
XFILLER_24_649 VDD VSS sg13g2_decap_8
XFILLER_23_148 VDD VSS sg13g2_fill_1
X_08362_ _08362_/X _11705_/A _11659_/A _08362_/A2 _08362_/A3 _08023_/A _07884_/A VDD
+ VSS sg13g2_mux4_1
XFILLER_51_457 VDD VSS sg13g2_decap_8
XFILLER_23_159 VDD VSS sg13g2_decap_8
XFILLER_177_621 VDD VSS sg13g2_decap_4
XFILLER_147_1090 VDD VSS sg13g2_decap_8
X_08293_ _15228_/D _08293_/A _08293_/B VDD VSS sg13g2_nand2_1
XFILLER_108_1085 VDD VSS sg13g2_decap_4
XFILLER_20_866 VDD VSS sg13g2_decap_8
XFILLER_20_877 VDD VSS sg13g2_fill_2
XFILLER_34_1271 VDD VSS sg13g2_decap_8
XFILLER_160_1290 VDD VSS sg13g2_decap_8
XFILLER_117_220 VDD VSS sg13g2_fill_1
XFILLER_164_359 VDD VSS sg13g2_decap_8
XFILLER_30_1146 VDD VSS sg13g2_decap_8
XFILLER_106_927 VDD VSS sg13g2_decap_8
XFILLER_145_573 VDD VSS sg13g2_fill_1
XFILLER_118_798 VDD VSS sg13g2_decap_8
XFILLER_156_1315 VDD VSS sg13g2_decap_8
XFILLER_172_370 VDD VSS sg13g2_decap_8
XFILLER_69_1367 VDD VSS sg13g2_decap_8
XFILLER_133_735 VDD VSS sg13g2_decap_8
XFILLER_105_459 VDD VSS sg13g2_decap_8
Xpicorv32_macro_1439 mem_axi_arprot[0] VDD VSS sg13g2_tielo
Xfanout301 _09744_/A1 _10141_/A1 VDD VSS sg13g2_buf_1
XFILLER_8_1103 VDD VSS sg13g2_decap_8
Xfanout312 _10092_/S _10096_/S VDD VSS sg13g2_buf_1
Xfanout323 fanout323/X _09938_/Y VDD VSS sg13g2_buf_1
XFILLER_28_1053 VDD VSS sg13g2_decap_8
Xfanout334 _09871_/S fanout335/X VDD VSS sg13g2_buf_1
XFILLER_87_833 VDD VSS sg13g2_fill_1
XFILLER_115_1023 VDD VSS sg13g2_decap_8
Xfanout345 _09738_/S _09727_/S VDD VSS sg13g2_buf_1
XFILLER_86_321 VDD VSS sg13g2_fill_1
Xfanout356 _09637_/S _09626_/S VDD VSS sg13g2_buf_1
XFILLER_100_120 VDD VSS sg13g2_decap_8
Xfanout367 _09325_/S _09327_/S VDD VSS sg13g2_buf_1
X_09816_ _14404_/D _09882_/A0 _14404_/Q _09822_/S VDD VSS sg13g2_mux2_1
Xfanout378 _09272_/S _09261_/S VDD VSS sg13g2_buf_1
XFILLER_101_665 VDD VSS sg13g2_decap_8
Xfanout389 _09749_/A1 fanout390/X VDD VSS sg13g2_buf_1
X_14426__1776 _14426_/RESET_B VDD VSS sg13g2_tiehi
XFILLER_87_899 VDD VSS sg13g2_decap_8
XFILLER_86_365 VDD VSS sg13g2_fill_1
XFILLER_80_1291 VDD VSS sg13g2_decap_8
XFILLER_74_527 VDD VSS sg13g2_decap_8
X_09747_ _14337_/D _14337_/Q _09912_/A1 _09762_/S VDD VSS sg13g2_mux2_1
XFILLER_41_1264 VDD VSS sg13g2_decap_8
XFILLER_55_763 VDD VSS sg13g2_decap_8
X_09678_ _14270_/D _09744_/A1 _14270_/Q _09692_/S VDD VSS sg13g2_mux2_1
XFILLER_167_1444 VDD VSS sg13g2_decap_8
XFILLER_28_999 VDD VSS sg13g2_fill_1
XFILLER_76_1338 VDD VSS sg13g2_decap_8
XFILLER_43_936 VDD VSS sg13g2_decap_8
X_08629_ _08629_/Y _08641_/B _08611_/Y _07966_/Y VDD VSS sg13g2_a21oi_1
XFILLER_14_126 VDD VSS sg13g2_decap_8
XFILLER_42_435 VDD VSS sg13g2_decap_8
XFILLER_153_4 VDD VSS sg13g2_decap_8
X_14641__1561 _14641_/RESET_B VDD VSS sg13g2_tiehi
X_11640_ _11774_/A _11638_/X _11639_/Y _11590_/Y VDD VSS sg13g2_a21oi_1
XFILLER_52_11 VDD VSS sg13g2_fill_2
XFILLER_35_1002 VDD VSS sg13g2_decap_4
XFILLER_30_619 VDD VSS sg13g2_decap_8
XFILLER_126_1130 VDD VSS sg13g2_fill_1
XFILLER_161_1010 VDD VSS sg13g2_decap_8
XFILLER_42_479 VDD VSS sg13g2_decap_8
XFILLER_39_1182 VDD VSS sg13g2_decap_8
XFILLER_11_811 VDD VSS sg13g2_decap_8
XFILLER_51_991 VDD VSS sg13g2_decap_8
X_11571_ _11571_/Y _11638_/A _11638_/C _11571_/C VDD VSS sg13g2_nor3_1
XFILLER_183_602 VDD VSS sg13g2_decap_8
X_13310_ _13310_/Y _15071_/Q _13305_/B _13307_/Y _13279_/B _13308_/Y VDD VSS sg13g2_a221oi_1
XFILLER_10_343 VDD VSS sg13g2_decap_8
XFILLER_161_1087 VDD VSS sg13g2_decap_4
X_10522_ _14856_/D _10595_/B _10522_/B _10531_/D VDD VSS sg13g2_nor3_1
XFILLER_155_315 VDD VSS sg13g2_decap_4
XFILLER_168_77 VDD VSS sg13g2_decap_8
X_14290_ _14290_/Q _14546_/CLK _14290_/D _14290_/RESET_B VDD VSS sg13g2_dfrbpq_1
XFILLER_7_826 VDD VSS sg13g2_decap_8
XFILLER_182_123 VDD VSS sg13g2_decap_8
XFILLER_52_1382 VDD VSS sg13g2_decap_8
XFILLER_13_1355 VDD VSS sg13g2_decap_8
X_13241_ _13242_/B _13245_/A _13665_/Q _13246_/C VDD VSS sg13g2_a21oi_1
X_10453_ _10453_/X _14840_/Q _14839_/Q _10453_/C _10514_/A VDD VSS sg13g2_and4_1
XFILLER_87_1412 VDD VSS sg13g2_decap_8
XFILLER_136_540 VDD VSS sg13g2_fill_1
X_13914__2288 _13914_/RESET_B VDD VSS sg13g2_tiehi
XFILLER_6_347 VDD VSS sg13g2_decap_8
XFILLER_136_551 VDD VSS sg13g2_fill_1
XFILLER_183_679 VDD VSS sg13g2_decap_8
XFILLER_164_882 VDD VSS sg13g2_fill_2
X_13172_ _13172_/X _13172_/A _13172_/B _13172_/C _13172_/D VDD VSS sg13g2_and4_1
X_10384_ _10398_/D _14818_/Q _14819_/Q _10396_/C VDD VSS sg13g2_and3_1
XFILLER_163_381 VDD VSS sg13g2_decap_4
XFILLER_184_65 VDD VSS sg13g2_decap_8
XFILLER_174_1448 VDD VSS sg13g2_decap_8
X_12123_ _12123_/Y _12156_/A _12122_/Y _12298_/B VDD VSS sg13g2_o21ai_1
XFILLER_7_0 VDD VSS sg13g2_decap_8
XFILLER_2_553 VDD VSS sg13g2_decap_8
XFILLER_105_982 VDD VSS sg13g2_decap_8
XFILLER_123_278 VDD VSS sg13g2_decap_8
X_12054_ _12054_/Y _12055_/C _12055_/D VDD VSS sg13g2_nor2_1
XFILLER_81_1033 VDD VSS sg13g2_fill_2
XFILLER_172_1172 VDD VSS sg13g2_decap_8
XFILLER_120_941 VDD VSS sg13g2_fill_1
XFILLER_137_1292 VDD VSS sg13g2_decap_8
X_15170__2510 _15170_/RESET_B VDD VSS sg13g2_tiehi
X_11005_ _11005_/X _11005_/A _11007_/A VDD VSS sg13g2_or2_1
X_16862_ _16862_/X _16862_/A VDD VSS sg13g2_buf_1
XFILLER_46_1197 VDD VSS sg13g2_decap_8
XFILLER_38_708 VDD VSS sg13g2_decap_8
XFILLER_77_354 VDD VSS sg13g2_decap_8
XFILLER_19_922 VDD VSS sg13g2_decap_8
Xfanout890 _12506_/S0 fanout894/X VDD VSS sg13g2_buf_1
XFILLER_93_836 VDD VSS sg13g2_decap_8
XFILLER_24_1473 VDD VSS sg13g2_decap_4
XFILLER_20_1326 VDD VSS sg13g2_decap_8
X_12956_ _15030_/D _12956_/A _13499_/B VDD VSS sg13g2_and2_1
XFILLER_45_240 VDD VSS sg13g2_decap_8
X_11907_ _11907_/X _11907_/A _11907_/B _11910_/B _11910_/C VDD VSS sg13g2_or4_1
XFILLER_179_919 VDD VSS sg13g2_decap_8
XFILLER_33_424 VDD VSS sg13g2_decap_8
X_12887_ _12887_/Y _12886_/Y _12983_/A1 _12882_/Y VDD VSS sg13g2_a21oi_1
XFILLER_33_435 VDD VSS sg13g2_fill_1
XFILLER_21_608 VDD VSS sg13g2_fill_2
X_14626_ _14626_/Q clkload7/A _14626_/D _14626_/RESET_B VDD VSS sg13g2_dfrbpq_1
X_11838_ _11839_/B _11800_/Y _11868_/A _11837_/Y VDD VSS sg13g2_a21oi_1
XFILLER_92_1162 VDD VSS sg13g2_decap_8
XFILLER_57_1282 VDD VSS sg13g2_decap_8
XFILLER_144_1241 VDD VSS sg13g2_decap_8
XFILLER_60_276 VDD VSS sg13g2_fill_1
XFILLER_105_1203 VDD VSS sg13g2_decap_8
XFILLER_144_1252 VDD VSS sg13g2_fill_1
XFILLER_159_643 VDD VSS sg13g2_decap_8
XFILLER_42_991 VDD VSS sg13g2_decap_4
X_14557_ _14557_/Q clkload32/A _14557_/D _14557_/RESET_B VDD VSS sg13g2_dfrbpq_1
XFILLER_53_1146 VDD VSS sg13g2_decap_8
XFILLER_18_1266 VDD VSS sg13g2_decap_8
X_11769_ _14972_/D _11729_/Y _11768_/Y _11724_/Y VDD VSS sg13g2_a21oi_1
XFILLER_140_1105 VDD VSS sg13g2_decap_8
XFILLER_186_462 VDD VSS sg13g2_decap_8
XFILLER_144_1296 VDD VSS sg13g2_fill_1
X_13508_ _13508_/X _13613_/A _13508_/B _13508_/C VDD VSS sg13g2_and3_1
XFILLER_146_315 VDD VSS sg13g2_fill_2
XFILLER_147_849 VDD VSS sg13g2_decap_8
XFILLER_174_635 VDD VSS sg13g2_decap_8
X_14488_ _14488_/Q clkload47/A _14488_/D _14488_/RESET_B VDD VSS sg13g2_dfrbpq_1
XFILLER_173_112 VDD VSS sg13g2_decap_8
XFILLER_179_1337 VDD VSS sg13g2_decap_8
XFILLER_31_1433 VDD VSS sg13g2_decap_8
XFILLER_9_196 VDD VSS sg13g2_decap_8
XFILLER_162_808 VDD VSS sg13g2_fill_2
X_13439_ _15101_/D _13444_/B _13438_/Y _13437_/Y VDD VSS sg13g2_o21ai_1
X_14504__1698 _14504_/RESET_B VDD VSS sg13g2_tiehi
XFILLER_161_329 VDD VSS sg13g2_decap_8
XFILLER_177_1061 VDD VSS sg13g2_decap_8
XFILLER_114_212 VDD VSS sg13g2_decap_8
XFILLER_115_746 VDD VSS sg13g2_fill_1
XFILLER_182_690 VDD VSS sg13g2_decap_8
XFILLER_142_532 VDD VSS sg13g2_decap_8
X_15109_ _15109_/Q clkload69/A _15109_/D _15109_/RESET_B VDD VSS sg13g2_dfrbpq_1
X_08980_ _08980_/X _15024_/Q _15221_/Q _09027_/S VDD VSS sg13g2_mux2_1
XFILLER_102_407 VDD VSS sg13g2_decap_8
XFILLER_170_896 VDD VSS sg13g2_decap_4
XFILLER_9_1423 VDD VSS sg13g2_decap_8
X_14683__1519 _14683_/RESET_B VDD VSS sg13g2_tiehi
X_07931_ _08286_/B _14998_/Q _07771_/A VDD VSS sg13g2_nor2b_1
XFILLER_69_822 VDD VSS sg13g2_decap_8
XFILLER_69_833 VDD VSS sg13g2_fill_1
XFILLER_68_310 VDD VSS sg13g2_fill_1
XFILLER_64_1253 VDD VSS sg13g2_decap_8
XFILLER_29_1373 VDD VSS sg13g2_decap_8
XFILLER_25_1215 VDD VSS sg13g2_decap_8
XFILLER_111_952 VDD VSS sg13g2_decap_8
XFILLER_96_641 VDD VSS sg13g2_fill_1
XFILLER_3_60 VDD VSS sg13g2_decap_8
XFILLER_5_1309 VDD VSS sg13g2_decap_8
XFILLER_116_1365 VDD VSS sg13g2_decap_4
X_07862_ _07862_/Y _08608_/A _08608_/B VDD VSS sg13g2_nor2_1
XFILLER_69_877 VDD VSS sg13g2_decap_8
XFILLER_151_1256 VDD VSS sg13g2_fill_2
XFILLER_96_674 VDD VSS sg13g2_fill_2
XFILLER_29_719 VDD VSS sg13g2_decap_8
X_09601_ _14198_/D _14198_/Q _09966_/A1 _09605_/S VDD VSS sg13g2_mux2_1
XFILLER_83_313 VDD VSS sg13g2_decap_8
XFILLER_56_538 VDD VSS sg13g2_decap_4
XFILLER_186_1308 VDD VSS sg13g2_decap_8
X_07793_ _07793_/Y _08383_/B _08383_/A VDD VSS sg13g2_nor2b_1
XFILLER_3_1033 VDD VSS sg13g2_decap_8
X_09532_ _14131_/D _10062_/A0 _14131_/Q _09538_/S VDD VSS sg13g2_mux2_1
XFILLER_83_357 VDD VSS sg13g2_decap_8
XFILLER_37_752 VDD VSS sg13g2_decap_8
XFILLER_184_1010 VDD VSS sg13g2_decap_8
XFILLER_52_711 VDD VSS sg13g2_decap_4
XFILLER_92_891 VDD VSS sg13g2_decap_8
X_09463_ _14064_/D _09463_/A0 _14064_/Q _09463_/S VDD VSS sg13g2_mux2_1
XFILLER_149_1163 VDD VSS sg13g2_decap_8
XFILLER_19_1008 VDD VSS sg13g2_fill_2
XFILLER_184_1065 VDD VSS sg13g2_decap_8
XFILLER_24_446 VDD VSS sg13g2_decap_8
X_08414_ _08415_/B _08414_/A _08414_/B _08414_/C _08414_/D VDD VSS sg13g2_nor4_1
XFILLER_12_619 VDD VSS sg13g2_decap_8
X_09394_ _13997_/D _10089_/A0 _13997_/Q _09397_/S VDD VSS sg13g2_mux2_1
XFILLER_40_928 VDD VSS sg13g2_decap_4
XFILLER_178_941 VDD VSS sg13g2_decap_8
X_08345_ _08346_/B _08340_/A _08177_/X _08344_/Y VDD VSS sg13g2_o21ai_1
XFILLER_36_1355 VDD VSS sg13g2_decap_8
XFILLER_123_1314 VDD VSS sg13g2_decap_8
XFILLER_178_974 VDD VSS sg13g2_decap_8
XFILLER_71_1257 VDD VSS sg13g2_decap_8
XFILLER_162_1374 VDD VSS sg13g2_decap_8
XFILLER_177_462 VDD VSS sg13g2_fill_2
XFILLER_22_14 VDD VSS sg13g2_decap_8
XFILLER_165_624 VDD VSS sg13g2_decap_8
X_08276_ _08276_/X _08276_/A _08276_/B VDD VSS sg13g2_or2_1
XFILLER_20_663 VDD VSS sg13g2_decap_4
X_14883__2801 _14883_/RESET_B VDD VSS sg13g2_tiehi
XFILLER_164_112 VDD VSS sg13g2_decap_8
XFILLER_164_123 VDD VSS sg13g2_fill_2
XFILLER_165_679 VDD VSS sg13g2_decap_4
XFILLER_164_156 VDD VSS sg13g2_decap_4
XFILLER_146_893 VDD VSS sg13g2_decap_8
XFILLER_173_690 VDD VSS sg13g2_fill_1
XFILLER_69_1164 VDD VSS sg13g2_decap_8
XFILLER_65_1017 VDD VSS sg13g2_fill_1
XFILLER_106_768 VDD VSS sg13g2_decap_8
Xclkbuf_leaf_0_clk_i _14722_/CLK clkbuf_leaf_2_clk_i/A VDD VSS sg13g2_buf_8
XFILLER_0_7 VDD VSS sg13g2_decap_8
XFILLER_106_779 VDD VSS sg13g2_fill_2
XFILLER_160_340 VDD VSS sg13g2_decap_8
XFILLER_161_863 VDD VSS sg13g2_decap_8
XFILLER_65_1028 VDD VSS sg13g2_fill_2
XFILLER_154_35 VDD VSS sg13g2_decap_8
XFILLER_105_278 VDD VSS sg13g2_decap_8
Xfanout1107 _12278_/A _14987_/Q VDD VSS sg13g2_buf_1
XFILLER_173_1470 VDD VSS sg13g2_decap_8
Xfanout1118 _12084_/A _12129_/B2 VDD VSS sg13g2_buf_1
XFILLER_47_1473 VDD VSS sg13g2_fill_2
X_14659__1543 _14659_/RESET_B VDD VSS sg13g2_tiehi
Xfanout1129 _08922_/A1 _14979_/Q VDD VSS sg13g2_buf_1
XFILLER_43_1315 VDD VSS sg13g2_decap_8
XFILLER_120_248 VDD VSS sg13g2_decap_4
Xfanout142 _10169_/A1 _09904_/A0 VDD VSS sg13g2_buf_1
Xfanout153 _09935_/A1 _09770_/A1 VDD VSS sg13g2_buf_1
XFILLER_82_1386 VDD VSS sg13g2_decap_8
XFILLER_47_11 VDD VSS sg13g2_decap_8
Xfanout164 _10098_/A0 _09834_/A0 VDD VSS sg13g2_buf_1
Xfanout175 _10063_/A0 _10096_/A0 VDD VSS sg13g2_buf_1
Xfanout186 _09830_/A0 _09111_/Y VDD VSS sg13g2_buf_1
XFILLER_87_685 VDD VSS sg13g2_decap_8
XFILLER_59_376 VDD VSS sg13g2_decap_8
XFILLER_130_1329 VDD VSS sg13g2_decap_8
Xfanout197 _10378_/D _10369_/Y VDD VSS sg13g2_buf_1
XFILLER_101_495 VDD VSS sg13g2_decap_8
XFILLER_41_1050 VDD VSS sg13g2_fill_2
XFILLER_47_77 VDD VSS sg13g2_decap_8
X_14803__2933 _14803_/RESET_B VDD VSS sg13g2_tiehi
X_12810_ _12810_/Y _12806_/Y _12807_/Y _12809_/Y VDD VSS sg13g2_a21oi_1
XFILLER_170_67 VDD VSS sg13g2_decap_8
XFILLER_90_817 VDD VSS sg13g2_decap_8
X_13790_ _13790_/Q clkload60/A _13790_/D _13790_/RESET_B VDD VSS sg13g2_dfrbpq_1
XFILLER_76_1113 VDD VSS sg13g2_decap_4
XFILLER_167_1241 VDD VSS sg13g2_decap_8
XFILLER_28_796 VDD VSS sg13g2_decap_8
X_12741_ _12741_/X _14711_/Q _14743_/Q _13783_/Q _13815_/Q _12756_/S0 _12756_/S1 VDD
+ VSS sg13g2_mux4_1
XFILLER_76_1135 VDD VSS sg13g2_decap_8
XFILLER_103_83 VDD VSS sg13g2_fill_1
XFILLER_70_530 VDD VSS sg13g2_fill_1
X_15027__2583 _15027_/RESET_B VDD VSS sg13g2_tiehi
XFILLER_128_1236 VDD VSS sg13g2_decap_8
X_15094__2816 _15094_/RESET_B VDD VSS sg13g2_tiehi
XFILLER_179_32 VDD VSS sg13g2_decap_8
X_12672_ _12672_/X _14578_/Q _14610_/Q _14642_/Q _14674_/Q _12675_/S0 _12675_/S1 VDD
+ VSS sg13g2_mux4_1
XFILLER_31_939 VDD VSS sg13g2_decap_8
XFILLER_144_0 VDD VSS sg13g2_fill_2
X_14411_ _14411_/Q clkload11/A _14411_/D _14411_/RESET_B VDD VSS sg13g2_dfrbpq_1
XFILLER_180_1441 VDD VSS sg13g2_decap_8
X_11623_ _11623_/Y _11599_/Y _11601_/Y _11830_/B1 VDD VSS sg13g2_a21oi_1
XFILLER_54_1444 VDD VSS sg13g2_decap_8
XFILLER_11_641 VDD VSS sg13g2_decap_8
XFILLER_15_1439 VDD VSS sg13g2_decap_8
X_14342_ _14342_/Q clkload52/A _14342_/D _14342_/RESET_B VDD VSS sg13g2_dfrbpq_1
XFILLER_10_140 VDD VSS sg13g2_decap_8
XFILLER_183_410 VDD VSS sg13g2_decap_8
X_11554_ _11554_/Y _11550_/Y _11551_/Y _11553_/Y _11552_/Y _11549_/B VDD VSS sg13g2_a221oi_1
XFILLER_7_623 VDD VSS sg13g2_decap_8
X_10505_ _10654_/A _10514_/A _10505_/B _10505_/C _10505_/D VDD VSS sg13g2_nand4_1
XFILLER_144_819 VDD VSS sg13g2_fill_2
XFILLER_155_145 VDD VSS sg13g2_decap_8
X_14273_ _14273_/Q clkload9/A _14273_/D _14273_/RESET_B VDD VSS sg13g2_dfrbpq_1
XFILLER_13_1152 VDD VSS sg13g2_decap_8
X_11485_ _11485_/Y _11485_/A _11485_/B VDD VSS sg13g2_xnor2_1
XFILLER_6_144 VDD VSS sg13g2_decap_8
XFILLER_109_562 VDD VSS sg13g2_fill_1
XFILLER_87_1220 VDD VSS sg13g2_decap_8
XFILLER_183_487 VDD VSS sg13g2_decap_8
X_13224_ _13226_/B _13224_/A _13215_/A VDD VSS sg13g2_nor2b_1
X_10436_ _10436_/Y _14835_/Q _10443_/D _10441_/C VDD VSS sg13g2_o21ai_1
XFILLER_12_91 VDD VSS sg13g2_decap_8
XFILLER_139_1332 VDD VSS sg13g2_fill_1
XFILLER_170_137 VDD VSS sg13g2_fill_1
XFILLER_83_1106 VDD VSS sg13g2_decap_8
XFILLER_152_852 VDD VSS sg13g2_decap_8
XFILLER_48_1237 VDD VSS sg13g2_decap_8
X_13155_ _15043_/D _13155_/A _13155_/B VDD VSS sg13g2_nor2_1
XFILLER_3_851 VDD VSS sg13g2_decap_8
XFILLER_112_705 VDD VSS sg13g2_fill_2
XFILLER_174_1245 VDD VSS sg13g2_decap_8
X_10367_ _10400_/C _14812_/Q _14813_/Q _14814_/Q VDD VSS sg13g2_nand3_1
XFILLER_100_1199 VDD VSS sg13g2_decap_8
XFILLER_151_351 VDD VSS sg13g2_decap_4
XFILLER_152_885 VDD VSS sg13g2_decap_8
XFILLER_97_416 VDD VSS sg13g2_fill_2
XFILLER_2_350 VDD VSS sg13g2_decap_8
X_12106_ _12106_/Y _12102_/Y _12103_/Y _12105_/Y _12104_/Y _11443_/A VDD VSS sg13g2_a221oi_1
X_13086_ _13087_/B _13154_/A1 _13081_/X _13085_/Y _13297_/A0 _13080_/Y VDD VSS sg13g2_a221oi_1
X_10298_ _10299_/C _14791_/Q _14792_/Q _14793_/Q _10298_/D VDD VSS sg13g2_nand4_1
X_12037_ _12037_/Y _12040_/A1 _14130_/Q VDD VSS sg13g2_nand2b_1
XFILLER_66_803 VDD VSS sg13g2_fill_1
XFILLER_92_110 VDD VSS sg13g2_decap_8
XFILLER_92_121 VDD VSS sg13g2_fill_2
XFILLER_24_1270 VDD VSS sg13g2_decap_8
XFILLER_65_346 VDD VSS sg13g2_decap_8
XFILLER_19_752 VDD VSS sg13g2_decap_8
XFILLER_20_1123 VDD VSS sg13g2_decap_8
X_13988_ _13988_/Q clkload49/A _13988_/D _13988_/RESET_B VDD VSS sg13g2_dfrbpq_1
XFILLER_92_165 VDD VSS sg13g2_decap_8
XFILLER_4_1386 VDD VSS sg13g2_decap_8
XFILLER_98_1382 VDD VSS sg13g2_decap_4
XFILLER_80_327 VDD VSS sg13g2_fill_2
XFILLER_185_1341 VDD VSS sg13g2_decap_8
X_12939_ _12939_/Y _12934_/Y _12938_/Y _12933_/Y VDD VSS sg13g2_o21ai_1
XFILLER_80_338 VDD VSS sg13g2_decap_8
XFILLER_18_295 VDD VSS sg13g2_fill_1
XFILLER_80_349 VDD VSS sg13g2_fill_2
XFILLER_59_1366 VDD VSS sg13g2_decap_8
XFILLER_22_917 VDD VSS sg13g2_fill_2
X_14097__2105 _14097_/RESET_B VDD VSS sg13g2_tiehi
XFILLER_94_1268 VDD VSS sg13g2_decap_8
XFILLER_61_552 VDD VSS sg13g2_fill_2
XFILLER_18_1030 VDD VSS sg13g2_decap_4
X_14609_ _14609_/Q _15139_/CLK _14609_/D _14609_/RESET_B VDD VSS sg13g2_dfrbpq_1
XFILLER_175_911 VDD VSS sg13g2_fill_1
XFILLER_18_1063 VDD VSS sg13g2_fill_1
X_08130_ _08130_/Y _08129_/X _08301_/S VDD VSS sg13g2_nand2b_1
XFILLER_30_961 VDD VSS sg13g2_decap_8
XFILLER_119_315 VDD VSS sg13g2_fill_1
X_14737__1465 _14737_/RESET_B VDD VSS sg13g2_tiehi
X_08061_ _08061_/Y _08060_/X _08177_/S VDD VSS sg13g2_nand2b_1
XFILLER_31_1230 VDD VSS sg13g2_decap_8
XFILLER_147_668 VDD VSS sg13g2_fill_2
XFILLER_179_1134 VDD VSS sg13g2_decap_8
XFILLER_162_605 VDD VSS sg13g2_decap_4
XFILLER_105_1099 VDD VSS sg13g2_fill_1
XFILLER_128_893 VDD VSS sg13g2_decap_8
XFILLER_161_126 VDD VSS sg13g2_decap_8
XFILLER_143_841 VDD VSS sg13g2_decap_8
XFILLER_115_543 VDD VSS sg13g2_fill_2
XFILLER_66_1326 VDD VSS sg13g2_decap_8
XFILLER_153_1307 VDD VSS sg13g2_fill_1
XFILLER_115_598 VDD VSS sg13g2_fill_1
XFILLER_142_384 VDD VSS sg13g2_decap_8
XFILLER_153_1329 VDD VSS sg13g2_decap_4
X_08963_ _10037_/B _10004_/B _09707_/C VDD VSS sg13g2_nor2_1
XFILLER_9_1220 VDD VSS sg13g2_decap_8
XFILLER_29_1170 VDD VSS sg13g2_decap_8
XFILLER_69_641 VDD VSS sg13g2_decap_8
XFILLER_130_568 VDD VSS sg13g2_decap_8
X_07914_ _07914_/Y _08105_/A _08200_/B _07913_/Y VDD VSS sg13g2_o21ai_1
XFILLER_68_140 VDD VSS sg13g2_decap_8
XFILLER_5_1106 VDD VSS sg13g2_decap_8
X_08894_ _08894_/X _15037_/Q _08893_/A _08893_/Y VDD VSS sg13g2_a21o_1
XFILLER_9_1297 VDD VSS sg13g2_decap_8
XFILLER_57_836 VDD VSS sg13g2_decap_8
XFILLER_29_527 VDD VSS sg13g2_fill_1
XFILLER_111_793 VDD VSS sg13g2_decap_8
X_07845_ _08678_/C _15017_/Q _07845_/B VDD VSS sg13g2_nand2_1
XFILLER_29_549 VDD VSS sg13g2_fill_2
XFILLER_25_1089 VDD VSS sg13g2_decap_4
XFILLER_112_1048 VDD VSS sg13g2_decap_8
XFILLER_17_14 VDD VSS sg13g2_decap_8
X_07776_ _07776_/Y _08276_/B _08276_/A VDD VSS sg13g2_nor2b_1
XFILLER_77_1411 VDD VSS sg13g2_decap_8
X_09515_ _14114_/D _09614_/A0 _14114_/Q _09533_/S VDD VSS sg13g2_mux2_1
XFILLER_71_338 VDD VSS sg13g2_decap_8
XFILLER_25_733 VDD VSS sg13g2_decap_8
XFILLER_24_210 VDD VSS sg13g2_decap_8
XFILLER_52_552 VDD VSS sg13g2_decap_8
X_09446_ _14047_/D _10075_/A0 _14047_/Q _09467_/S VDD VSS sg13g2_mux2_1
XFILLER_13_928 VDD VSS sg13g2_decap_8
XFILLER_164_1469 VDD VSS sg13g2_decap_4
XFILLER_12_427 VDD VSS sg13g2_decap_8
XFILLER_52_596 VDD VSS sg13g2_decap_4
X_09377_ _13980_/D _09841_/A1 _13980_/Q _09407_/S VDD VSS sg13g2_mux2_1
XFILLER_33_46 VDD VSS sg13g2_decap_8
XFILLER_36_1152 VDD VSS sg13g2_decap_8
XFILLER_123_1111 VDD VSS sg13g2_decap_8
XFILLER_162_1171 VDD VSS sg13g2_decap_8
XFILLER_138_624 VDD VSS sg13g2_decap_4
X_08328_ _08329_/A _08235_/X _08327_/X _08428_/S VDD VSS sg13g2_mux2_1
XFILLER_166_944 VDD VSS sg13g2_fill_1
XFILLER_32_1027 VDD VSS sg13g2_decap_4
XFILLER_165_421 VDD VSS sg13g2_decap_4
XFILLER_123_1166 VDD VSS sg13g2_decap_8
XFILLER_138_657 VDD VSS sg13g2_decap_8
XFILLER_166_966 VDD VSS sg13g2_decap_8
XFILLER_71_1098 VDD VSS sg13g2_decap_8
XFILLER_137_145 VDD VSS sg13g2_fill_2
XFILLER_14_1450 VDD VSS sg13g2_decap_8
XFILLER_126_819 VDD VSS sg13g2_decap_8
X_08259_ _08259_/Y _08315_/A _08325_/B _08258_/Y VDD VSS sg13g2_o21ai_1
XFILLER_119_860 VDD VSS sg13g2_decap_8
XFILLER_158_1207 VDD VSS sg13g2_decap_8
X_13795__2407 _13795_/RESET_B VDD VSS sg13g2_tiehi
XFILLER_153_638 VDD VSS sg13g2_decap_8
XFILLER_165_498 VDD VSS sg13g2_fill_1
XFILLER_101_1453 VDD VSS sg13g2_decap_8
X_11270_ _11270_/Y _11273_/A1 _14364_/Q VDD VSS sg13g2_nand2b_1
XFILLER_134_830 VDD VSS sg13g2_decap_8
XFILLER_4_637 VDD VSS sg13g2_decap_8
XFILLER_10_1358 VDD VSS sg13g2_decap_8
X_13831__2371 _13831_/RESET_B VDD VSS sg13g2_tiehi
X_10221_ _14768_/D _14767_/Q _14768_/Q _10220_/Y VDD VSS sg13g2_a21oi_1
XFILLER_165_67 VDD VSS sg13g2_decap_8
X_14847__2873 _14847_/RESET_B VDD VSS sg13g2_tiehi
XFILLER_3_158 VDD VSS sg13g2_decap_8
XFILLER_106_576 VDD VSS sg13g2_decap_8
XFILLER_133_373 VDD VSS sg13g2_decap_4
X_10152_ _14729_/D _14729_/Q _10152_/A1 _10156_/S VDD VSS sg13g2_mux2_1
XFILLER_161_693 VDD VSS sg13g2_decap_8
XFILLER_121_546 VDD VSS sg13g2_decap_8
XFILLER_82_1150 VDD VSS sg13g2_fill_2
XFILLER_47_1270 VDD VSS sg13g2_decap_8
X_14175__2027 _14175_/RESET_B VDD VSS sg13g2_tiehi
X_14960_ _14960_/Q clkload64/A _14960_/D _14960_/RESET_B VDD VSS sg13g2_dfrbpq_1
X_10083_ _14663_/D _10083_/A0 _14663_/Q _10092_/S VDD VSS sg13g2_mux2_1
XFILLER_0_876 VDD VSS sg13g2_decap_8
XFILLER_87_460 VDD VSS sg13g2_decap_8
XFILLER_134_1273 VDD VSS sg13g2_decap_8
X_13911_ _13911_/Q _14743_/CLK _13911_/D _13911_/RESET_B VDD VSS sg13g2_dfrbpq_1
XFILLER_75_622 VDD VSS sg13g2_decap_8
XFILLER_181_77 VDD VSS sg13g2_decap_8
X_14891_ _14891_/Q _14893_/CLK _14891_/D _14891_/RESET_B VDD VSS sg13g2_dfrbpq_1
XFILLER_43_1189 VDD VSS sg13g2_decap_8
XFILLER_21_1421 VDD VSS sg13g2_decap_8
XFILLER_169_1336 VDD VSS sg13g2_decap_8
X_13842_ _13842_/Q _14743_/CLK _13842_/D _13842_/RESET_B VDD VSS sg13g2_dfrbpq_1
XFILLER_78_1219 VDD VSS sg13g2_decap_8
XFILLER_56_880 VDD VSS sg13g2_decap_8
XFILLER_28_582 VDD VSS sg13g2_decap_8
XFILLER_15_210 VDD VSS sg13g2_decap_8
X_13773_ _13773_/Q clkload26/A _13773_/D _13773_/RESET_B VDD VSS sg13g2_dfrbpq_1
X_10985_ _10985_/X _10995_/A _11045_/A2 _10985_/B1 VDD VSS sg13g2_a21o_1
XFILLER_167_1060 VDD VSS sg13g2_decap_8
XFILLER_71_850 VDD VSS sg13g2_decap_4
X_12724_ _12724_/X _14262_/Q _14294_/Q _14326_/Q _14358_/Q _12731_/S0 _12731_/S1 VDD
+ VSS sg13g2_mux4_1
XFILLER_16_788 VDD VSS sg13g2_fill_2
XFILLER_43_574 VDD VSS sg13g2_decap_8
XFILLER_43_585 VDD VSS sg13g2_fill_2
XFILLER_128_1066 VDD VSS sg13g2_decap_8
XFILLER_130_81 VDD VSS sg13g2_decap_8
XFILLER_15_287 VDD VSS sg13g2_decap_8
X_12655_ _12655_/X _13745_/Q _14097_/Q _14449_/Q _14545_/Q _12661_/S0 _12661_/S1 VDD
+ VSS sg13g2_mux4_1
XFILLER_54_1241 VDD VSS sg13g2_decap_8
Xclkbuf_leaf_101_clk_i _14510_/CLK clkbuf_leaf_99_clk_i/A VDD VSS sg13g2_buf_8
XFILLER_30_246 VDD VSS sg13g2_decap_4
X_14206__1996 _14206_/RESET_B VDD VSS sg13g2_tiehi
XFILLER_19_1394 VDD VSS sg13g2_decap_8
X_11606_ _11606_/Y _11602_/Y _11603_/Y _11605_/Y _11604_/Y _11615_/B VDD VSS sg13g2_a221oi_1
XFILLER_141_1233 VDD VSS sg13g2_decap_8
XFILLER_15_1236 VDD VSS sg13g2_decap_8
X_14982__2628 _14982_/RESET_B VDD VSS sg13g2_tiehi
XFILLER_8_921 VDD VSS sg13g2_decap_8
XFILLER_30_268 VDD VSS sg13g2_decap_8
XFILLER_157_944 VDD VSS sg13g2_decap_8
X_12586_ _12586_/X _13964_/Q _13996_/Q _14028_/Q _14060_/Q _12590_/S0 _12590_/S1 VDD
+ VSS sg13g2_mux4_1
XFILLER_129_657 VDD VSS sg13g2_decap_8
XFILLER_7_420 VDD VSS sg13g2_decap_8
X_14325_ _14325_/Q _14677_/CLK _14325_/D _14325_/RESET_B VDD VSS sg13g2_dfrbpq_1
XFILLER_141_1277 VDD VSS sg13g2_fill_2
XFILLER_184_763 VDD VSS sg13g2_decap_8
X_11537_ _11537_/Y _11551_/A1 _14596_/Q _11532_/C VDD VSS sg13g2_a21oi_1
XFILLER_144_616 VDD VSS sg13g2_decap_8
XFILLER_89_1348 VDD VSS sg13g2_decap_8
XFILLER_156_487 VDD VSS sg13g2_decap_4
XFILLER_8_998 VDD VSS sg13g2_decap_8
XFILLER_116_329 VDD VSS sg13g2_decap_8
XFILLER_171_424 VDD VSS sg13g2_decap_8
XFILLER_183_284 VDD VSS sg13g2_decap_8
X_14256_ _14256_/Q _14637_/CLK _14256_/D _14256_/RESET_B VDD VSS sg13g2_dfrbpq_1
X_14385__1817 _14385_/RESET_B VDD VSS sg13g2_tiehi
XFILLER_109_381 VDD VSS sg13g2_decap_8
XFILLER_125_830 VDD VSS sg13g2_decap_8
Xclkbuf_leaf_116_clk_i clkload26/A clkbuf_5_7__f_clk_i/X VDD VSS sg13g2_buf_8
X_11468_ _11468_/X _14241_/Q _14273_/Q _14305_/Q _14337_/Q _11473_/S0 _11473_/S1 VDD
+ VSS sg13g2_mux4_1
XFILLER_7_497 VDD VSS sg13g2_decap_8
XFILLER_172_969 VDD VSS sg13g2_fill_1
XFILLER_99_72 VDD VSS sg13g2_decap_8
XFILLER_143_148 VDD VSS sg13g2_decap_8
XFILLER_171_457 VDD VSS sg13g2_decap_4
X_13207_ _13207_/Y _14857_/Q _13234_/B _13219_/B1 _14889_/Q _13219_/C1 VDD VSS sg13g2_a221oi_1
X_14421__1781 _14421_/RESET_B VDD VSS sg13g2_tiehi
X_10419_ _10421_/B _14828_/Q _14829_/Q _10422_/D VDD VSS sg13g2_nand3_1
X_14187_ _14187_/Q _14729_/CLK _14187_/D _14187_/RESET_B VDD VSS sg13g2_dfrbpq_1
XFILLER_112_502 VDD VSS sg13g2_decap_8
X_11399_ _11401_/A _11418_/A _14623_/Q VDD VSS sg13g2_nand2b_1
XFILLER_152_671 VDD VSS sg13g2_decap_4
XFILLER_98_736 VDD VSS sg13g2_fill_1
X_13138_ _13139_/B _14852_/Q _13150_/B _13138_/B1 _14788_/Q VDD VSS sg13g2_a22oi_1
Xclkbuf_5_28__f_clk_i clkbuf_leaf_80_clk_i/A clkbuf_4_14_0_clk_i/X VDD VSS sg13g2_buf_16
XFILLER_6_1404 VDD VSS sg13g2_decap_8
XFILLER_39_803 VDD VSS sg13g2_decap_4
X_13069_ _13069_/Y _14847_/Q _13150_/B _12947_/B _14879_/Q _13069_/C1 VDD VSS sg13g2_a221oi_1
XFILLER_26_1354 VDD VSS sg13g2_decap_8
XFILLER_94_931 VDD VSS sg13g2_decap_8
XFILLER_38_313 VDD VSS sg13g2_fill_1
XFILLER_113_1335 VDD VSS sg13g2_decap_8
XFILLER_61_1267 VDD VSS sg13g2_decap_8
XFILLER_39_847 VDD VSS sg13g2_fill_2
XFILLER_38_324 VDD VSS sg13g2_decap_8
X_07630_ _08105_/A _07630_/A VDD VSS sg13g2_inv_1
XFILLER_26_508 VDD VSS sg13g2_fill_1
XFILLER_19_571 VDD VSS sg13g2_decap_8
XFILLER_4_1183 VDD VSS sg13g2_decap_8
XFILLER_19_593 VDD VSS sg13g2_decap_8
XFILLER_0_1058 VDD VSS sg13g2_decap_8
X_13873__2329 _13873_/RESET_B VDD VSS sg13g2_tiehi
X_09300_ _13908_/D _13908_/Q _10163_/A1 _09300_/S VDD VSS sg13g2_mux2_1
XFILLER_59_1163 VDD VSS sg13g2_decap_8
XFILLER_94_1065 VDD VSS sg13g2_fill_1
XFILLER_55_1016 VDD VSS sg13g2_fill_1
XFILLER_110_29 VDD VSS sg13g2_decap_8
XFILLER_61_360 VDD VSS sg13g2_decap_8
XFILLER_34_585 VDD VSS sg13g2_fill_2
XFILLER_179_557 VDD VSS sg13g2_decap_4
XFILLER_22_736 VDD VSS sg13g2_fill_1
XFILLER_107_1117 VDD VSS sg13g2_decap_8
X_09231_ _13842_/D _10161_/A1 _13842_/Q _09238_/S VDD VSS sg13g2_mux2_1
XFILLER_33_1303 VDD VSS sg13g2_decap_8
XFILLER_72_1363 VDD VSS sg13g2_decap_8
X_09162_ _09162_/Y _09162_/A _10793_/C VDD VSS sg13g2_nor2_1
XFILLER_9_70 VDD VSS sg13g2_decap_8
X_14958__2652 _14958_/RESET_B VDD VSS sg13g2_tiehi
XFILLER_175_752 VDD VSS sg13g2_decap_8
X_08113_ _08113_/Y _08079_/S _13609_/A _08105_/A _08199_/B _08090_/C VDD VSS sg13g2_a221oi_1
XFILLER_135_605 VDD VSS sg13g2_decap_4
X_09093_ _09093_/Y _15239_/Q _09107_/B VDD VSS sg13g2_nand2b_1
XFILLER_119_178 VDD VSS sg13g2_decap_8
XFILLER_147_487 VDD VSS sg13g2_fill_1
X_08044_ _08044_/X _08919_/A1 _08922_/A1 _08925_/A1 _08928_/A1 _08046_/B _07627_/A
+ VDD VSS sg13g2_mux4_1
XFILLER_174_295 VDD VSS sg13g2_decap_4
XFILLER_118_1202 VDD VSS sg13g2_decap_8
XFILLER_143_660 VDD VSS sg13g2_fill_1
XFILLER_157_1273 VDD VSS sg13g2_decap_8
XFILLER_153_1115 VDD VSS sg13g2_decap_8
XFILLER_103_535 VDD VSS sg13g2_decap_8
XFILLER_118_1235 VDD VSS sg13g2_decap_4
Xclkbuf_leaf_80_clk_i _15214_/CLK clkbuf_leaf_80_clk_i/A VDD VSS sg13g2_buf_8
X_09995_ _14578_/D _10094_/A0 _14578_/Q _10002_/S VDD VSS sg13g2_mux2_1
XFILLER_118_1257 VDD VSS sg13g2_decap_8
XFILLER_142_192 VDD VSS sg13g2_decap_8
Xhold3045 _10209_/C _10207_/Y VDD VSS sg13g2_dlygate4sd3_1
XFILLER_89_769 VDD VSS sg13g2_decap_8
XFILLER_44_1410 VDD VSS sg13g2_decap_8
Xhold3056 input33/A mem_axi_rdata[7] VDD VSS sg13g2_dlygate4sd3_1
Xhold3067 hold3067/X input6/X VDD VSS sg13g2_dlygate4sd3_1
X_08946_ _08946_/Y _08835_/A _08835_/B _16882_/A VDD VSS sg13g2_a21oi_1
XFILLER_9_1050 VDD VSS sg13g2_decap_8
XFILLER_130_365 VDD VSS sg13g2_decap_8
Xhold3078 input28/A mem_axi_rdata[31] VDD VSS sg13g2_dlygate4sd3_1
XFILLER_130_376 VDD VSS sg13g2_fill_1
Xhold3089 hold3089/X input31/X VDD VSS sg13g2_dlygate4sd3_1
XFILLER_130_387 VDD VSS sg13g2_decap_8
XFILLER_97_780 VDD VSS sg13g2_decap_8
XFILLER_69_482 VDD VSS sg13g2_decap_8
X_08877_ _08877_/Y _08877_/A _14937_/Q VDD VSS sg13g2_nor2b_1
XFILLER_85_953 VDD VSS sg13g2_decap_8
XFILLER_185_7 VDD VSS sg13g2_decap_8
XFILLER_84_452 VDD VSS sg13g2_fill_1
XFILLER_17_508 VDD VSS sg13g2_decap_8
Xclkbuf_leaf_95_clk_i _14655_/CLK clkload3/A VDD VSS sg13g2_buf_8
X_07828_ _07829_/B _08574_/A _08574_/B _07828_/C VDD VSS sg13g2_nor3_1
XFILLER_85_997 VDD VSS sg13g2_fill_1
XFILLER_45_839 VDD VSS sg13g2_decap_8
XFILLER_44_316 VDD VSS sg13g2_decap_4
XFILLER_71_102 VDD VSS sg13g2_decap_8
XFILLER_56_176 VDD VSS sg13g2_decap_8
X_07759_ _07759_/Y _13281_/C _07755_/Y _07758_/Y VDD VSS sg13g2_a21oi_1
XFILLER_71_135 VDD VSS sg13g2_decap_8
XFILLER_37_390 VDD VSS sg13g2_decap_8
XFILLER_168_1391 VDD VSS sg13g2_decap_8
XFILLER_44_45 VDD VSS sg13g2_fill_2
XFILLER_13_714 VDD VSS sg13g2_decap_8
X_14463__1739 _14463_/RESET_B VDD VSS sg13g2_tiehi
X_10770_ _10770_/Y _14919_/Q _11133_/B VDD VSS sg13g2_nand2_1
XFILLER_77_1285 VDD VSS sg13g2_decap_8
X_13849__2353 _13849_/RESET_B VDD VSS sg13g2_tiehi
XFILLER_40_522 VDD VSS sg13g2_decap_8
XFILLER_38_1258 VDD VSS sg13g2_decap_8
XFILLER_12_224 VDD VSS sg13g2_decap_8
XFILLER_164_1266 VDD VSS sg13g2_decap_8
X_09429_ _14031_/D _09860_/A1 _14031_/Q _09438_/S VDD VSS sg13g2_mux2_1
XFILLER_139_900 VDD VSS sg13g2_fill_1
XFILLER_9_707 VDD VSS sg13g2_decap_8
XFILLER_125_1239 VDD VSS sg13g2_fill_2
XFILLER_90_1452 VDD VSS sg13g2_decap_8
XFILLER_51_1403 VDD VSS sg13g2_decap_8
XFILLER_157_218 VDD VSS sg13g2_decap_8
X_12440_ _12440_/X _12434_/X _12438_/X _12433_/X _12437_/X _12650_/S _12649_/S0 VDD
+ VSS sg13g2_mux4_1
XFILLER_60_11 VDD VSS sg13g2_decap_8
XFILLER_90_1474 VDD VSS sg13g2_fill_1
XFILLER_8_228 VDD VSS sg13g2_decap_8
XFILLER_138_443 VDD VSS sg13g2_decap_8
Xclkbuf_leaf_33_clk_i clkload37/A clkbuf_leaf_34_clk_i/A VDD VSS sg13g2_buf_8
X_12371_ _12372_/B _12370_/X _12369_/X _12790_/S VDD VSS sg13g2_mux2_1
X_14110_ _14110_/Q _14668_/CLK _14110_/D _14110_/RESET_B VDD VSS sg13g2_dfrbpq_1
XFILLER_5_924 VDD VSS sg13g2_decap_8
XFILLER_181_733 VDD VSS sg13g2_decap_8
X_11322_ _11322_/Y _11328_/S0 _14109_/Q VDD VSS sg13g2_nand2b_1
XFILLER_60_99 VDD VSS sg13g2_decap_4
XFILLER_176_77 VDD VSS sg13g2_decap_8
XFILLER_180_210 VDD VSS sg13g2_decap_8
X_15090_ _15090_/Q clkload71/A _15090_/D _15090_/RESET_B VDD VSS sg13g2_dfrbpq_1
XFILLER_125_126 VDD VSS sg13g2_decap_8
XFILLER_158_1026 VDD VSS sg13g2_decap_8
XFILLER_158_1037 VDD VSS sg13g2_fill_2
XFILLER_5_28 VDD VSS sg13g2_decap_8
XFILLER_4_434 VDD VSS sg13g2_decap_8
XFILLER_49_1310 VDD VSS sg13g2_decap_8
XFILLER_109_60 VDD VSS sg13g2_decap_8
XFILLER_107_0 VDD VSS sg13g2_decap_8
XFILLER_107_863 VDD VSS sg13g2_decap_8
XFILLER_109_71 VDD VSS sg13g2_fill_1
XFILLER_10_1155 VDD VSS sg13g2_decap_8
X_14041_ _14041_/Q clkload45/A _14041_/D _14041_/RESET_B VDD VSS sg13g2_dfrbpq_1
XFILLER_84_1212 VDD VSS sg13g2_decap_8
X_11253_ _11255_/B _11282_/S0 _14620_/Q VDD VSS sg13g2_nand2b_1
XFILLER_107_885 VDD VSS sg13g2_decap_8
XFILLER_180_287 VDD VSS sg13g2_decap_8
XFILLER_136_1324 VDD VSS sg13g2_fill_2
Xclkbuf_leaf_48_clk_i clkload48/A clkbuf_leaf_48_clk_i/A VDD VSS sg13g2_buf_8
X_10204_ _14759_/D _15183_/D _14759_/Q _13648_/S VDD VSS sg13g2_mux2_1
XFILLER_45_1207 VDD VSS sg13g2_decap_8
XFILLER_49_1387 VDD VSS sg13g2_decap_8
XFILLER_175_1384 VDD VSS sg13g2_decap_8
X_11184_ _14954_/D _11183_/Y _11182_/Y _11170_/Y VDD VSS sg13g2_o21ai_1
XFILLER_84_1289 VDD VSS sg13g2_decap_8
XFILLER_95_706 VDD VSS sg13g2_decap_8
XFILLER_0_651 VDD VSS sg13g2_decap_8
XFILLER_171_1259 VDD VSS sg13g2_decap_8
X_10135_ _14713_/D _10168_/A1 _14713_/Q _10136_/S VDD VSS sg13g2_mux2_1
XFILLER_121_365 VDD VSS sg13g2_decap_8
X_14943_ _14943_/Q clkload69/A _14943_/D _14943_/RESET_B VDD VSS sg13g2_dfrbpq_1
X_10066_ _14647_/D _10066_/A0 _14647_/Q _10068_/S VDD VSS sg13g2_mux2_1
XFILLER_48_644 VDD VSS sg13g2_fill_2
XFILLER_76_964 VDD VSS sg13g2_decap_4
XFILLER_36_806 VDD VSS sg13g2_decap_8
X_14874_ _14874_/Q clkload83/A _14874_/D _14874_/RESET_B VDD VSS sg13g2_dfrbpq_1
XFILLER_5_1470 VDD VSS sg13g2_decap_4
XFILLER_48_699 VDD VSS sg13g2_decap_8
XFILLER_90_411 VDD VSS sg13g2_decap_4
XFILLER_62_102 VDD VSS sg13g2_decap_4
XFILLER_1_1323 VDD VSS sg13g2_decap_8
XFILLER_29_891 VDD VSS sg13g2_fill_2
X_13825_ _13825_/Q clkload10/A _13825_/D _13825_/RESET_B VDD VSS sg13g2_dfrbpq_1
XFILLER_165_1008 VDD VSS sg13g2_decap_8
XFILLER_95_1330 VDD VSS sg13g2_decap_8
XFILLER_35_349 VDD VSS sg13g2_decap_8
XFILLER_28_390 VDD VSS sg13g2_decap_4
XFILLER_21_1295 VDD VSS sg13g2_decap_8
XFILLER_95_1352 VDD VSS sg13g2_fill_1
XFILLER_44_850 VDD VSS sg13g2_decap_8
XFILLER_90_466 VDD VSS sg13g2_decap_8
X_13756_ _13756_/Q _15052_/CLK _13756_/D _13756_/RESET_B VDD VSS sg13g2_dfrbpq_1
XFILLER_56_1325 VDD VSS sg13g2_decap_8
XFILLER_50_319 VDD VSS sg13g2_decap_8
X_10968_ _10969_/A _11015_/C _11015_/A _10966_/Y VDD VSS sg13g2_o21ai_1
XFILLER_71_680 VDD VSS sg13g2_decap_4
XFILLER_182_1355 VDD VSS sg13g2_decap_8
X_14439__1763 _14439_/RESET_B VDD VSS sg13g2_tiehi
X_12707_ _12708_/B _13668_/Q _12749_/A2 _12706_/X _12749_/B2 _12749_/C1 VDD VSS sg13g2_a221oi_1
XFILLER_108_1448 VDD VSS sg13g2_fill_2
XFILLER_176_505 VDD VSS sg13g2_decap_8
X_13687_ _13687_/Q _14930_/CLK _13687_/D _13687_/RESET_B VDD VSS sg13g2_dfrbpq_1
X_13677__2541 _13677_/RESET_B VDD VSS sg13g2_tiehi
X_10899_ _10899_/Y _10936_/A _10898_/X _07751_/B VDD VSS sg13g2_o21ai_1
XFILLER_31_566 VDD VSS sg13g2_decap_8
X_12638_ _15009_/D _07636_/Y _12749_/C1 _12637_/Y VDD VSS sg13g2_a21oi_1
XFILLER_19_1191 VDD VSS sg13g2_decap_8
XFILLER_15_1033 VDD VSS sg13g2_decap_8
XFILLER_54_1093 VDD VSS sg13g2_decap_8
XFILLER_106_1172 VDD VSS sg13g2_decap_8
XFILLER_79_4 VDD VSS sg13g2_decap_8
XFILLER_117_605 VDD VSS sg13g2_decap_4
X_12569_ _15004_/D _12569_/A _12569_/B VDD VSS sg13g2_nor2_1
XFILLER_89_1134 VDD VSS sg13g2_fill_2
XFILLER_102_1036 VDD VSS sg13g2_fill_1
XFILLER_117_627 VDD VSS sg13g2_fill_2
XFILLER_141_1085 VDD VSS sg13g2_decap_4
X_14308_ _14308_/Q clkload52/A _14308_/D _14308_/RESET_B VDD VSS sg13g2_dfrbpq_1
X_14928__2711 _14928_/RESET_B VDD VSS sg13g2_tiehi
XFILLER_8_795 VDD VSS sg13g2_decap_8
XFILLER_172_766 VDD VSS sg13g2_decap_8
XFILLER_7_294 VDD VSS sg13g2_decap_8
X_14239_ _14239_/Q clkload61/A _14239_/D _14239_/RESET_B VDD VSS sg13g2_dfrbpq_1
XFILLER_113_800 VDD VSS sg13g2_fill_1
XFILLER_67_1465 VDD VSS sg13g2_decap_8
XFILLER_124_170 VDD VSS sg13g2_decap_8
XFILLER_171_298 VDD VSS sg13g2_decap_8
XFILLER_28_1427 VDD VSS sg13g2_decap_8
Xfanout708 _12217_/A _12192_/A VDD VSS sg13g2_buf_1
XFILLER_124_181 VDD VSS sg13g2_fill_1
Xfanout719 fanout719/X _11359_/B VDD VSS sg13g2_buf_1
XFILLER_98_544 VDD VSS sg13g2_decap_8
XFILLER_154_1457 VDD VSS sg13g2_decap_8
X_08800_ _08802_/A _10898_/B1 _14754_/Q _08727_/X _15197_/Q _13392_/A2 VDD VSS sg13g2_a221oi_1
X_09780_ _14369_/D _09912_/A1 _14369_/Q _09795_/S VDD VSS sg13g2_mux2_1
XFILLER_6_1201 VDD VSS sg13g2_decap_8
X_13927__2275 _13927_/RESET_B VDD VSS sg13g2_tiehi
XFILLER_22_0 VDD VSS sg13g2_decap_8
XFILLER_26_1151 VDD VSS sg13g2_decap_8
X_08731_ _08731_/Y _13662_/Q _13507_/B VDD VSS sg13g2_nor2_1
XFILLER_79_791 VDD VSS sg13g2_decap_8
XFILLER_78_290 VDD VSS sg13g2_decap_8
XFILLER_61_1064 VDD VSS sg13g2_fill_1
Xfanout1290 _11532_/C fanout1293/X VDD VSS sg13g2_buf_1
XFILLER_6_1278 VDD VSS sg13g2_decap_8
XFILLER_61_1097 VDD VSS sg13g2_decap_8
X_08662_ _08662_/Y _08650_/A _08662_/B VDD VSS sg13g2_nand2b_1
XFILLER_81_400 VDD VSS sg13g2_decap_8
XFILLER_54_625 VDD VSS sg13g2_decap_8
XFILLER_26_327 VDD VSS sg13g2_decap_8
X_07613_ _07613_/Y _10793_/A VDD VSS sg13g2_inv_1
XFILLER_93_293 VDD VSS sg13g2_fill_2
XFILLER_19_390 VDD VSS sg13g2_decap_8
X_08593_ _08593_/Y _07858_/X _08001_/A _08001_/C VDD VSS sg13g2_o21ai_1
XFILLER_81_477 VDD VSS sg13g2_decap_8
XFILLER_35_872 VDD VSS sg13g2_decap_8
XFILLER_179_321 VDD VSS sg13g2_decap_4
XFILLER_74_1436 VDD VSS sg13g2_decap_8
XFILLER_179_354 VDD VSS sg13g2_decap_4
XFILLER_167_505 VDD VSS sg13g2_fill_2
XFILLER_139_207 VDD VSS sg13g2_decap_8
XFILLER_167_527 VDD VSS sg13g2_decap_8
X_09214_ _13825_/D _09978_/A0 _13825_/Q _09229_/S VDD VSS sg13g2_mux2_1
XFILLER_72_1160 VDD VSS sg13g2_decap_8
XFILLER_37_1280 VDD VSS sg13g2_decap_8
XFILLER_10_728 VDD VSS sg13g2_decap_8
XFILLER_50_897 VDD VSS sg13g2_decap_8
XFILLER_148_752 VDD VSS sg13g2_decap_8
X_09145_ _09145_/Y _09145_/A _09145_/B VDD VSS sg13g2_nand2_1
XFILLER_108_605 VDD VSS sg13g2_decap_4
XFILLER_33_1177 VDD VSS sg13g2_decap_8
XFILLER_108_638 VDD VSS sg13g2_decap_8
XFILLER_135_424 VDD VSS sg13g2_decap_8
XFILLER_162_210 VDD VSS sg13g2_decap_4
XFILLER_175_593 VDD VSS sg13g2_decap_8
XFILLER_30_25 VDD VSS sg13g2_decap_8
XFILLER_108_649 VDD VSS sg13g2_fill_2
X_09076_ _09076_/Y _09090_/A _10735_/B _09075_/X VDD VSS sg13g2_o21ai_1
XFILLER_120_1169 VDD VSS sg13g2_decap_8
XFILLER_159_1346 VDD VSS sg13g2_decap_8
XFILLER_162_243 VDD VSS sg13g2_decap_8
XFILLER_11_1464 VDD VSS sg13g2_decap_8
XFILLER_135_468 VDD VSS sg13g2_fill_2
XFILLER_146_36 VDD VSS sg13g2_decap_4
X_08027_ _08027_/Y _08483_/A1 _08027_/B VDD VSS sg13g2_nand2b_1
XFILLER_100_7 VDD VSS sg13g2_decap_8
XFILLER_104_800 VDD VSS sg13g2_decap_8
XFILLER_151_939 VDD VSS sg13g2_fill_2
XFILLER_2_938 VDD VSS sg13g2_decap_8
XFILLER_118_1043 VDD VSS sg13g2_decap_8
XFILLER_1_448 VDD VSS sg13g2_decap_8
XFILLER_89_555 VDD VSS sg13g2_decap_8
XFILLER_49_408 VDD VSS sg13g2_fill_1
XFILLER_104_899 VDD VSS sg13g2_fill_2
XFILLER_130_151 VDD VSS sg13g2_decap_8
X_09978_ _14561_/D _09978_/A0 _14561_/Q _09990_/S VDD VSS sg13g2_mux2_1
XFILLER_49_419 VDD VSS sg13g2_decap_4
XFILLER_131_685 VDD VSS sg13g2_decap_4
X_14517__1685 _14517_/RESET_B VDD VSS sg13g2_tiehi
XFILLER_103_398 VDD VSS sg13g2_decap_8
XFILLER_162_46 VDD VSS sg13g2_decap_8
X_08929_ _13715_/D _16877_/A _08928_/X _08932_/S VDD VSS sg13g2_mux2_1
XFILLER_76_238 VDD VSS sg13g2_decap_8
XFILLER_39_89 VDD VSS sg13g2_fill_2
XFILLER_170_1270 VDD VSS sg13g2_decap_8
X_14092__2110 _14092_/RESET_B VDD VSS sg13g2_tiehi
XFILLER_44_1284 VDD VSS sg13g2_decap_8
XFILLER_183_4 VDD VSS sg13g2_decap_8
XFILLER_18_817 VDD VSS sg13g2_decap_8
XFILLER_29_143 VDD VSS sg13g2_fill_1
X_11940_ _11940_/Y _11969_/A _14128_/Q VDD VSS sg13g2_nand2b_1
XFILLER_55_11 VDD VSS sg13g2_decap_8
XFILLER_79_1325 VDD VSS sg13g2_decap_8
XFILLER_29_165 VDD VSS sg13g2_decap_8
XFILLER_44_102 VDD VSS sg13g2_decap_8
XFILLER_73_956 VDD VSS sg13g2_decap_8
X_14696__1506 _14696_/RESET_B VDD VSS sg13g2_tiehi
X_11871_ _11871_/Y _11882_/S0 _13902_/Q VDD VSS sg13g2_nand2b_1
XFILLER_166_1339 VDD VSS sg13g2_decap_8
X_13610_ _13610_/Y _13609_/Y _13600_/Y _08830_/X VDD VSS sg13g2_o21ai_1
X_14732__1470 _14732_/RESET_B VDD VSS sg13g2_tiehi
XFILLER_55_88 VDD VSS sg13g2_decap_8
X_10822_ _10823_/A _10821_/A _10821_/B _10821_/C VDD VSS sg13g2_a21o_1
XFILLER_72_477 VDD VSS sg13g2_decap_8
X_14590_ _14590_/Q clkload62/A _14590_/D _14590_/RESET_B VDD VSS sg13g2_dfrbpq_1
XFILLER_25_360 VDD VSS sg13g2_fill_1
XFILLER_111_50 VDD VSS sg13g2_decap_8
XFILLER_41_820 VDD VSS sg13g2_decap_8
XFILLER_25_371 VDD VSS sg13g2_decap_8
XFILLER_13_522 VDD VSS sg13g2_decap_8
X_13541_ _13541_/X _14995_/Q _13545_/B VDD VSS sg13g2_and2_1
XFILLER_71_21 VDD VSS sg13g2_decap_8
X_10753_ _11097_/A _14947_/Q _10752_/A _10752_/Y VDD VSS sg13g2_a21oi_1
XFILLER_129_1183 VDD VSS sg13g2_decap_8
XFILLER_9_504 VDD VSS sg13g2_decap_8
XFILLER_125_1047 VDD VSS sg13g2_decap_4
XFILLER_186_847 VDD VSS sg13g2_decap_8
XFILLER_51_1200 VDD VSS sg13g2_decap_8
X_13472_ _15110_/D _15176_/D _15110_/Q _13653_/S VDD VSS sg13g2_mux2_1
XFILLER_41_897 VDD VSS sg13g2_decap_8
X_10684_ _10851_/D _08985_/X _08852_/A _08848_/Y VDD VSS sg13g2_a21o_1
XFILLER_55_1391 VDD VSS sg13g2_decap_8
XFILLER_185_357 VDD VSS sg13g2_decap_8
X_15211_ _15211_/Q clkload63/A _15211_/D _15211_/RESET_B VDD VSS sg13g2_dfrbpq_1
XFILLER_142_1361 VDD VSS sg13g2_decap_8
X_12423_ _12423_/X _13728_/Q _14080_/Q _14432_/Q _14528_/Q _12698_/S0 _12698_/S1 VDD
+ VSS sg13g2_mux4_1
XFILLER_16_1386 VDD VSS sg13g2_decap_8
XFILLER_138_262 VDD VSS sg13g2_decap_8
XFILLER_51_1277 VDD VSS sg13g2_decap_8
XFILLER_103_1356 VDD VSS sg13g2_fill_2
X_15142_ _15142_/Q clkload33/A _15142_/D _15142_/RESET_B VDD VSS sg13g2_dfrbpq_1
XFILLER_138_284 VDD VSS sg13g2_decap_8
X_12354_ _12354_/X _12342_/X _12343_/X _12352_/X _12351_/X _12788_/S0 _12790_/S VDD
+ VSS sg13g2_mux4_1
XFILLER_5_721 VDD VSS sg13g2_decap_8
XFILLER_153_221 VDD VSS sg13g2_fill_2
XFILLER_154_766 VDD VSS sg13g2_fill_2
XFILLER_181_552 VDD VSS sg13g2_decap_8
XFILLER_177_1457 VDD VSS sg13g2_decap_8
X_11305_ _11305_/Y _11310_/A1 _14653_/Q _12257_/B1 VDD VSS sg13g2_a21oi_1
XFILLER_4_231 VDD VSS sg13g2_decap_8
XFILLER_177_1468 VDD VSS sg13g2_fill_2
X_15073_ _15073_/Q clkload81/A _15073_/D _15073_/RESET_B VDD VSS sg13g2_dfrbpq_1
XFILLER_107_660 VDD VSS sg13g2_decap_8
XFILLER_141_405 VDD VSS sg13g2_fill_1
XFILLER_153_265 VDD VSS sg13g2_decap_8
X_12285_ _12285_/X _14137_/Q _14169_/Q _14201_/Q _14233_/Q _12286_/S0 _12288_/S1 VDD
+ VSS sg13g2_mux4_1
XFILLER_154_799 VDD VSS sg13g2_decap_8
XFILLER_84_1020 VDD VSS sg13g2_fill_2
XFILLER_5_798 VDD VSS sg13g2_decap_8
X_14024_ _14024_/Q clkload16/A _14024_/D _14024_/RESET_B VDD VSS sg13g2_dfrbpq_1
X_11236_ _11236_/Y _11243_/B _13289_/C _12292_/A _11236_/D VDD VSS sg13g2_nor4_1
XFILLER_20_91 VDD VSS sg13g2_decap_8
XFILLER_45_1004 VDD VSS sg13g2_decap_8
XFILLER_175_1181 VDD VSS sg13g2_decap_8
XFILLER_49_1184 VDD VSS sg13g2_decap_8
XFILLER_84_1086 VDD VSS sg13g2_decap_8
XFILLER_150_972 VDD VSS sg13g2_decap_4
XFILLER_136_1165 VDD VSS sg13g2_decap_4
X_11167_ _11167_/Y _11161_/X _11158_/Y _11166_/Y VDD VSS sg13g2_a21oi_1
XFILLER_67_216 VDD VSS sg13g2_fill_1
XFILLER_27_1460 VDD VSS sg13g2_decap_8
XFILLER_171_1078 VDD VSS sg13g2_decap_8
X_10118_ _14696_/D _10151_/A1 _14696_/Q _10124_/S VDD VSS sg13g2_mux2_1
XFILLER_62_1362 VDD VSS sg13g2_decap_8
XFILLER_110_858 VDD VSS sg13g2_decap_8
XFILLER_95_558 VDD VSS sg13g2_decap_8
X_11098_ _11098_/Y _11138_/B _10759_/X _11139_/B1 VDD VSS sg13g2_a21oi_1
XFILLER_83_709 VDD VSS sg13g2_fill_1
XFILLER_23_1346 VDD VSS sg13g2_decap_8
XFILLER_3_1418 VDD VSS sg13g2_decap_8
XFILLER_97_1414 VDD VSS sg13g2_decap_8
XFILLER_110_1316 VDD VSS sg13g2_fill_1
X_14926_ _14926_/Q clkload63/A _14926_/D _14926_/RESET_B VDD VSS sg13g2_dfrbpq_1
X_10049_ _14630_/D _10082_/A0 _14630_/Q _10063_/S VDD VSS sg13g2_mux2_1
XFILLER_1_1120 VDD VSS sg13g2_decap_8
XFILLER_91_742 VDD VSS sg13g2_decap_8
X_14857_ _14857_/Q clkload90/A _14857_/D _14857_/RESET_B VDD VSS sg13g2_dfrbpq_1
XFILLER_63_444 VDD VSS sg13g2_fill_1
XFILLER_63_477 VDD VSS sg13g2_decap_8
X_13808_ _13808_/Q clkload14/A _13808_/D _13808_/RESET_B VDD VSS sg13g2_dfrbpq_1
X_14788_ _14788_/Q clkload87/A _14788_/D _14788_/RESET_B VDD VSS sg13g2_dfrbpq_1
XFILLER_95_1171 VDD VSS sg13g2_fill_1
XFILLER_1_1197 VDD VSS sg13g2_decap_8
XFILLER_95_1193 VDD VSS sg13g2_fill_1
XFILLER_182_1152 VDD VSS sg13g2_decap_8
X_13739_ _13739_/Q clkload13/A _13739_/D _13739_/RESET_B VDD VSS sg13g2_dfrbpq_1
X_13790__2412 _13790_/RESET_B VDD VSS sg13g2_tiehi
XFILLER_50_149 VDD VSS sg13g2_decap_8
XFILLER_147_1294 VDD VSS sg13g2_decap_8
X_14816__2920 _14816_/RESET_B VDD VSS sg13g2_tiehi
XFILLER_52_1019 VDD VSS sg13g2_decap_8
XFILLER_143_1147 VDD VSS sg13g2_decap_8
XFILLER_56_1199 VDD VSS sg13g2_decap_8
XFILLER_31_363 VDD VSS sg13g2_decap_8
XFILLER_143_1158 VDD VSS sg13g2_fill_1
XFILLER_34_1453 VDD VSS sg13g2_decap_8
X_15135__2710 _15135_/RESET_B VDD VSS sg13g2_tiehi
XFILLER_121_1423 VDD VSS sg13g2_decap_8
XFILLER_145_700 VDD VSS sg13g2_decap_8
XFILLER_176_379 VDD VSS sg13g2_fill_2
XFILLER_118_925 VDD VSS sg13g2_fill_1
XFILLER_145_722 VDD VSS sg13g2_decap_4
XFILLER_30_1328 VDD VSS sg13g2_decap_8
X_14170__2032 _14170_/RESET_B VDD VSS sg13g2_tiehi
XFILLER_8_592 VDD VSS sg13g2_decap_8
XFILLER_145_766 VDD VSS sg13g2_fill_2
XFILLER_144_254 VDD VSS sg13g2_decap_4
XFILLER_6_60 VDD VSS sg13g2_decap_8
XFILLER_126_991 VDD VSS sg13g2_decap_8
X_09901_ _14487_/D _09934_/A1 _14487_/Q _09903_/S VDD VSS sg13g2_mux2_1
XFILLER_67_1262 VDD VSS sg13g2_decap_8
XFILLER_132_449 VDD VSS sg13g2_fill_1
XFILLER_28_1224 VDD VSS sg13g2_decap_8
Xfanout505 _08395_/A _08424_/A1 VDD VSS sg13g2_buf_1
XFILLER_113_652 VDD VSS sg13g2_decap_8
Xfanout516 _13650_/S _13480_/S VDD VSS sg13g2_buf_1
XFILLER_59_706 VDD VSS sg13g2_decap_8
Xfanout527 _13593_/B fanout528/X VDD VSS sg13g2_buf_1
X_09832_ _14420_/D _10096_/A0 _14420_/Q _09832_/S VDD VSS sg13g2_mux2_1
Xfanout538 _12292_/A _11235_/X VDD VSS sg13g2_buf_1
Xfanout549 _09741_/A1 _08969_/X VDD VSS sg13g2_buf_1
XFILLER_100_313 VDD VSS sg13g2_decap_8
XFILLER_80_1440 VDD VSS sg13g2_decap_8
XFILLER_101_847 VDD VSS sg13g2_decap_4
XFILLER_101_858 VDD VSS sg13g2_decap_4
X_09763_ _14353_/D _14353_/Q _09895_/A0 _09771_/S VDD VSS sg13g2_mux2_1
XFILLER_86_558 VDD VSS sg13g2_decap_8
XFILLER_74_709 VDD VSS sg13g2_decap_8
XFILLER_132_16 VDD VSS sg13g2_decap_8
X_08714_ _15210_/D _15189_/D _15119_/Q _13653_/S VDD VSS sg13g2_mux2_1
XFILLER_41_1446 VDD VSS sg13g2_decap_8
XFILLER_6_1075 VDD VSS sg13g2_decap_8
X_09694_ _14286_/D _10124_/A0 _14286_/Q _09694_/S VDD VSS sg13g2_mux2_1
XFILLER_39_474 VDD VSS sg13g2_decap_8
XFILLER_54_411 VDD VSS sg13g2_decap_8
XFILLER_66_271 VDD VSS sg13g2_decap_8
X_08645_ _08645_/X _08646_/A _08646_/B _08646_/C VDD VSS sg13g2_and3_1
XFILLER_55_978 VDD VSS sg13g2_fill_1
XFILLER_26_157 VDD VSS sg13g2_fill_2
XFILLER_25_25 VDD VSS sg13g2_decap_8
XFILLER_109_1009 VDD VSS sg13g2_fill_1
XFILLER_14_319 VDD VSS sg13g2_fill_2
X_08576_ _08576_/Y _08421_/Y _08575_/B _08573_/Y VDD VSS sg13g2_o21ai_1
XFILLER_78_1380 VDD VSS sg13g2_decap_8
XFILLER_23_820 VDD VSS sg13g2_decap_8
XFILLER_74_1233 VDD VSS sg13g2_decap_8
XFILLER_165_1350 VDD VSS sg13g2_decap_8
XFILLER_39_1364 VDD VSS sg13g2_decap_8
XFILLER_168_814 VDD VSS sg13g2_fill_2
XFILLER_179_151 VDD VSS sg13g2_decap_8
X_14380__1822 _14380_/RESET_B VDD VSS sg13g2_tiehi
XFILLER_70_1108 VDD VSS sg13g2_fill_1
XFILLER_167_313 VDD VSS sg13g2_decap_8
XFILLER_126_1356 VDD VSS sg13g2_decap_8
XFILLER_126_1367 VDD VSS sg13g2_fill_2
XFILLER_161_1247 VDD VSS sg13g2_decap_8
XFILLER_22_374 VDD VSS sg13g2_decap_8
Xclkbuf_4_7_0_clk_i clkbuf_4_7_0_clk_i/X clkbuf_0_clk_i/X VDD VSS sg13g2_buf_8
XFILLER_23_897 VDD VSS sg13g2_decap_8
XFILLER_10_525 VDD VSS sg13g2_decap_8
XFILLER_126_1378 VDD VSS sg13g2_decap_8
XFILLER_41_35 VDD VSS sg13g2_fill_2
XFILLER_182_305 VDD VSS sg13g2_decap_8
XFILLER_148_582 VDD VSS sg13g2_decap_8
XFILLER_6_529 VDD VSS sg13g2_decap_8
XFILLER_157_46 VDD VSS sg13g2_decap_8
X_09128_ _10772_/A _15047_/Q _15244_/Q _09147_/B VDD VSS sg13g2_mux2_1
XFILLER_109_969 VDD VSS sg13g2_decap_8
X_14000__2202 _14000_/RESET_B VDD VSS sg13g2_tiehi
XFILLER_68_1004 VDD VSS sg13g2_decap_8
XFILLER_135_243 VDD VSS sg13g2_fill_2
XFILLER_163_563 VDD VSS sg13g2_decap_4
XFILLER_108_479 VDD VSS sg13g2_decap_8
XFILLER_11_1261 VDD VSS sg13g2_decap_8
X_09059_ _13770_/D _13770_/Q _10153_/A1 _09084_/S VDD VSS sg13g2_mux2_1
XFILLER_155_1018 VDD VSS sg13g2_decap_8
XFILLER_135_298 VDD VSS sg13g2_decap_8
XFILLER_155_1029 VDD VSS sg13g2_fill_1
XFILLER_46_1302 VDD VSS sg13g2_decap_8
XFILLER_2_735 VDD VSS sg13g2_decap_8
XFILLER_137_1430 VDD VSS sg13g2_decap_4
X_12070_ _12070_/X _14579_/Q _14611_/Q _14643_/Q _14675_/Q _12135_/S0 _12135_/S1 VDD
+ VSS sg13g2_mux4_1
XFILLER_85_1362 VDD VSS sg13g2_decap_8
XFILLER_116_490 VDD VSS sg13g2_fill_1
XFILLER_1_245 VDD VSS sg13g2_decap_8
XFILLER_173_56 VDD VSS sg13g2_decap_8
X_11021_ _11021_/X _14943_/Q _11048_/B VDD VSS sg13g2_and2_1
XFILLER_89_352 VDD VSS sg13g2_decap_8
XFILLER_172_1354 VDD VSS sg13g2_decap_8
XFILLER_81_1237 VDD VSS sg13g2_decap_8
XFILLER_131_471 VDD VSS sg13g2_decap_4
XFILLER_89_385 VDD VSS sg13g2_fill_2
XFILLER_133_1327 VDD VSS sg13g2_decap_8
XFILLER_46_1379 VDD VSS sg13g2_decap_8
X_14033__2169 _14033_/RESET_B VDD VSS sg13g2_tiehi
X_14912__2743 _14912_/RESET_B VDD VSS sg13g2_tiehi
XFILLER_103_195 VDD VSS sg13g2_decap_4
XFILLER_66_21 VDD VSS sg13g2_decap_8
XFILLER_65_709 VDD VSS sg13g2_decap_8
XFILLER_92_506 VDD VSS sg13g2_decap_4
XFILLER_58_750 VDD VSS sg13g2_fill_1
XFILLER_92_517 VDD VSS sg13g2_decap_8
XFILLER_79_1100 VDD VSS sg13g2_fill_1
X_12972_ _12990_/A _14905_/Q _13682_/Q VDD VSS sg13g2_or2_1
XFILLER_85_591 VDD VSS sg13g2_decap_8
XFILLER_66_98 VDD VSS sg13g2_decap_8
XFILLER_174_0 VDD VSS sg13g2_decap_8
X_14711_ _14711_/Q clkload42/A _14711_/D _14711_/RESET_B VDD VSS sg13g2_dfrbpq_1
X_11923_ _11923_/X _14383_/Q _14415_/Q _14479_/Q _14511_/Q _12040_/A1 _12038_/B1 VDD
+ VSS sg13g2_mux4_1
XFILLER_73_742 VDD VSS sg13g2_fill_1
XFILLER_79_1155 VDD VSS sg13g2_decap_8
XFILLER_18_669 VDD VSS sg13g2_decap_8
XFILLER_17_168 VDD VSS sg13g2_decap_8
X_14642_ _14642_/Q _14743_/CLK _14642_/D _14642_/RESET_B VDD VSS sg13g2_dfrbpq_1
X_14945__2677 _14945_/RESET_B VDD VSS sg13g2_tiehi
XFILLER_60_403 VDD VSS sg13g2_decap_8
X_11854_ _11854_/X _14253_/Q _14285_/Q _14317_/Q _14349_/Q _11963_/S0 _11963_/S1 VDD
+ VSS sg13g2_mux4_1
XFILLER_32_105 VDD VSS sg13g2_decap_8
XFILLER_82_53 VDD VSS sg13g2_decap_8
XFILLER_72_285 VDD VSS sg13g2_decap_8
X_10805_ _10805_/Y _15121_/Q _10805_/B _10805_/C VDD VSS sg13g2_nor3_1
X_14573_ _14573_/Q _14637_/CLK _14573_/D _14573_/RESET_B VDD VSS sg13g2_dfrbpq_1
XFILLER_57_1464 VDD VSS sg13g2_decap_8
X_11785_ _11785_/X _14251_/Q _14283_/Q _14315_/Q _14347_/Q _11786_/S0 _11786_/S1 VDD
+ VSS sg13g2_mux4_1
XFILLER_82_97 VDD VSS sg13g2_decap_4
XFILLER_18_1448 VDD VSS sg13g2_decap_8
XFILLER_9_301 VDD VSS sg13g2_decap_8
XFILLER_53_1328 VDD VSS sg13g2_decap_8
X_13524_ _15141_/D _13565_/S _13522_/Y _13523_/Y VDD VSS sg13g2_a21oi_1
XFILLER_92_1388 VDD VSS sg13g2_decap_8
XFILLER_14_897 VDD VSS sg13g2_fill_1
XFILLER_186_644 VDD VSS sg13g2_decap_8
X_10736_ _10736_/Y _14943_/Q _10735_/A _10735_/Y VDD VSS sg13g2_a21oi_1
XFILLER_144_1467 VDD VSS sg13g2_decap_8
XFILLER_15_91 VDD VSS sg13g2_decap_8
XFILLER_105_1429 VDD VSS sg13g2_decap_8
XFILLER_40_171 VDD VSS sg13g2_decap_8
XFILLER_13_396 VDD VSS sg13g2_decap_8
XFILLER_40_182 VDD VSS sg13g2_fill_1
XFILLER_185_154 VDD VSS sg13g2_decap_8
X_13455_ _13463_/D _13455_/A _13455_/B _13455_/C _13455_/D VDD VSS sg13g2_or4_1
XFILLER_90_1090 VDD VSS sg13g2_decap_8
X_10667_ _14894_/D _12812_/A _10667_/B _10667_/C VDD VSS sg13g2_nor3_1
XFILLER_139_571 VDD VSS sg13g2_decap_4
XFILLER_9_378 VDD VSS sg13g2_decap_8
XFILLER_167_891 VDD VSS sg13g2_decap_8
XFILLER_16_1183 VDD VSS sg13g2_decap_8
X_12406_ _12406_/X _14367_/Q _14399_/Q _14463_/Q _14495_/Q _12592_/S0 _12592_/S1 VDD
+ VSS sg13g2_mux4_1
XFILLER_12_1047 VDD VSS sg13g2_decap_8
X_13386_ _13386_/Y _08723_/A _08723_/B _15082_/Q VDD VSS sg13g2_o21ai_1
XFILLER_63_7 VDD VSS sg13g2_fill_2
XFILLER_127_755 VDD VSS sg13g2_decap_8
X_10598_ _10607_/D _14876_/Q _14875_/Q VDD VSS sg13g2_and2_1
XFILLER_126_254 VDD VSS sg13g2_fill_2
XFILLER_154_563 VDD VSS sg13g2_fill_1
X_15125_ _15125_/Q clkload81/A _15125_/D _15125_/RESET_B VDD VSS sg13g2_dfrbpq_1
XFILLER_115_928 VDD VSS sg13g2_decap_8
XFILLER_177_1254 VDD VSS sg13g2_decap_8
X_15123__2736 _15123_/RESET_B VDD VSS sg13g2_tiehi
Xoutput108 mem_axi_wdata[13] _15145_/Q VDD VSS sg13g2_buf_1
X_12337_ _12337_/Y _12335_/Y _12336_/Y _12292_/A VDD VSS sg13g2_a21oi_1
X_14243__1959 _14243_/RESET_B VDD VSS sg13g2_tiehi
Xoutput119 mem_axi_wdata[23] _15155_/Q VDD VSS sg13g2_buf_1
XFILLER_154_585 VDD VSS sg13g2_fill_2
XFILLER_138_1227 VDD VSS sg13g2_decap_8
XFILLER_138_1238 VDD VSS sg13g2_fill_1
XFILLER_147_90 VDD VSS sg13g2_decap_8
XFILLER_181_382 VDD VSS sg13g2_decap_8
XFILLER_181_393 VDD VSS sg13g2_fill_1
X_15056_ _15056_/Q _15165_/CLK _15056_/D _15056_/RESET_B VDD VSS sg13g2_dfrbpq_1
XFILLER_5_595 VDD VSS sg13g2_decap_8
X_12268_ _12268_/Y _12294_/B1 _12267_/Y _12298_/B VDD VSS sg13g2_o21ai_1
XFILLER_99_149 VDD VSS sg13g2_decap_8
XFILLER_123_950 VDD VSS sg13g2_decap_8
XFILLER_123_961 VDD VSS sg13g2_fill_1
XFILLER_64_1435 VDD VSS sg13g2_decap_8
X_14007_ _14007_/Q clkload43/A _14007_/D _14007_/RESET_B VDD VSS sg13g2_dfrbpq_1
X_11219_ _11219_/X _11218_/X _11228_/S1 _11266_/B VDD VSS sg13g2_a21o_1
X_12199_ _12200_/A _12155_/A _12151_/Y _12153_/B VDD VSS sg13g2_o21ai_1
XFILLER_68_525 VDD VSS sg13g2_decap_4
Xoutput90 mem_axi_awaddr[29] _16882_/X VDD VSS sg13g2_buf_1
XFILLER_122_482 VDD VSS sg13g2_decap_8
XFILLER_96_867 VDD VSS sg13g2_fill_1
XFILLER_7_1351 VDD VSS sg13g2_decap_8
X_14009__2193 _14009_/RESET_B VDD VSS sg13g2_tiehi
XFILLER_23_1143 VDD VSS sg13g2_decap_8
XFILLER_37_912 VDD VSS sg13g2_decap_8
XFILLER_110_688 VDD VSS sg13g2_decap_8
XFILLER_3_1215 VDD VSS sg13g2_decap_8
XFILLER_110_1102 VDD VSS sg13g2_fill_1
XFILLER_49_783 VDD VSS sg13g2_decap_8
XFILLER_114_1282 VDD VSS sg13g2_fill_2
XFILLER_49_794 VDD VSS sg13g2_fill_1
XFILLER_110_1135 VDD VSS sg13g2_decap_8
XFILLER_149_1301 VDD VSS sg13g2_decap_8
XFILLER_110_1146 VDD VSS sg13g2_fill_1
X_14909_ _14909_/Q clkload59/A _14909_/D _14909_/RESET_B VDD VSS sg13g2_dfrbpq_1
XFILLER_97_1244 VDD VSS sg13g2_decap_8
XFILLER_64_764 VDD VSS sg13g2_decap_8
XFILLER_58_1217 VDD VSS sg13g2_decap_8
X_08430_ _08441_/D _07629_/A _08428_/X _08429_/Y VDD VSS sg13g2_o21ai_1
XFILLER_97_1288 VDD VSS sg13g2_decap_8
X_14188__2014 _14188_/RESET_B VDD VSS sg13g2_tiehi
XFILLER_24_628 VDD VSS sg13g2_decap_8
XFILLER_184_1247 VDD VSS sg13g2_decap_8
XFILLER_149_1389 VDD VSS sg13g2_fill_1
X_08361_ _08361_/Y _08200_/A _08195_/Y _08360_/Y VDD VSS sg13g2_a21oi_1
XFILLER_71_1439 VDD VSS sg13g2_decap_8
XFILLER_149_335 VDD VSS sg13g2_decap_8
X_08292_ _08293_/A _08318_/D _08290_/X _08291_/Y VDD VSS sg13g2_o21ai_1
XFILLER_149_357 VDD VSS sg13g2_decap_8
XFILLER_177_677 VDD VSS sg13g2_decap_8
XFILLER_176_154 VDD VSS sg13g2_decap_8
XFILLER_34_1250 VDD VSS sg13g2_decap_8
XFILLER_30_1114 VDD VSS sg13g2_decap_4
XFILLER_121_1253 VDD VSS sg13g2_fill_1
XFILLER_106_906 VDD VSS sg13g2_decap_8
XFILLER_69_1346 VDD VSS sg13g2_decap_8
XFILLER_133_714 VDD VSS sg13g2_decap_8
XFILLER_173_894 VDD VSS sg13g2_decap_8
XFILLER_105_438 VDD VSS sg13g2_decap_8
X_14219__1983 _14219_/RESET_B VDD VSS sg13g2_tiehi
XFILLER_160_533 VDD VSS sg13g2_decap_8
X_14995__2615 _14995_/RESET_B VDD VSS sg13g2_tiehi
Xfanout302 _10141_/A1 _09909_/A1 VDD VSS sg13g2_buf_1
XFILLER_87_801 VDD VSS sg13g2_fill_2
XFILLER_28_1032 VDD VSS sg13g2_decap_8
XFILLER_119_1160 VDD VSS sg13g2_fill_1
Xfanout313 _10096_/S fanout317/X VDD VSS sg13g2_buf_1
XFILLER_115_1002 VDD VSS sg13g2_decap_8
Xfanout324 _09927_/S _09921_/S VDD VSS sg13g2_buf_1
XFILLER_101_611 VDD VSS sg13g2_decap_8
XFILLER_113_471 VDD VSS sg13g2_fill_1
Xfanout335 fanout335/X _09839_/Y VDD VSS sg13g2_buf_1
XFILLER_86_311 VDD VSS sg13g2_fill_1
XFILLER_113_482 VDD VSS sg13g2_decap_8
XFILLER_154_1073 VDD VSS sg13g2_decap_4
Xfanout346 _09739_/S _09727_/S VDD VSS sg13g2_buf_1
Xfanout357 _09638_/S _09626_/S VDD VSS sg13g2_buf_1
X_09815_ _14403_/D _09914_/A1 _14403_/Q _09828_/S VDD VSS sg13g2_mux2_1
XFILLER_8_1159 VDD VSS sg13g2_decap_8
X_14398__1804 _14398_/RESET_B VDD VSS sg13g2_tiehi
Xfanout368 _09337_/S _09339_/S VDD VSS sg13g2_buf_1
Xfanout379 _09273_/S _09261_/S VDD VSS sg13g2_buf_1
XFILLER_87_878 VDD VSS sg13g2_decap_8
XFILLER_59_569 VDD VSS sg13g2_decap_8
XFILLER_80_1270 VDD VSS sg13g2_decap_8
XFILLER_74_506 VDD VSS sg13g2_decap_8
XFILLER_28_912 VDD VSS sg13g2_decap_8
X_09746_ _14336_/D _14336_/Q _09911_/A1 _09766_/S VDD VSS sg13g2_mux2_1
XFILLER_41_1243 VDD VSS sg13g2_decap_8
XFILLER_132_1371 VDD VSS sg13g2_decap_8
XFILLER_86_399 VDD VSS sg13g2_decap_4
X_09677_ _14269_/D _09743_/A1 _14269_/Q _09704_/S VDD VSS sg13g2_mux2_1
XFILLER_167_1423 VDD VSS sg13g2_decap_8
XFILLER_82_550 VDD VSS sg13g2_decap_8
XFILLER_76_1317 VDD VSS sg13g2_decap_8
X_08628_ _08628_/Y _07855_/A _08610_/Y _08627_/Y VDD VSS sg13g2_o21ai_1
XFILLER_54_263 VDD VSS sg13g2_decap_8
XFILLER_14_105 VDD VSS sg13g2_decap_8
XFILLER_55_797 VDD VSS sg13g2_decap_8
XFILLER_128_1429 VDD VSS sg13g2_fill_1
X_08559_ _08560_/C _07861_/B _08591_/A2 _07812_/B _07818_/B _13517_/A _13521_/A VDD
+ VSS sg13g2_mux4_1
XFILLER_39_1161 VDD VSS sg13g2_decap_8
X_13707__2495 _13707_/RESET_B VDD VSS sg13g2_tiehi
XFILLER_70_778 VDD VSS sg13g2_fill_2
XFILLER_51_970 VDD VSS sg13g2_decap_8
XFILLER_23_672 VDD VSS sg13g2_fill_1
X_11570_ _11638_/C _11570_/A _13683_/Q VDD VSS sg13g2_xnor2_1
XFILLER_126_1164 VDD VSS sg13g2_fill_1
XFILLER_22_171 VDD VSS sg13g2_decap_8
XFILLER_35_1058 VDD VSS sg13g2_fill_2
XFILLER_10_322 VDD VSS sg13g2_decap_8
XFILLER_50_491 VDD VSS sg13g2_decap_8
XFILLER_168_56 VDD VSS sg13g2_decap_8
XFILLER_22_193 VDD VSS sg13g2_fill_2
X_10521_ _10531_/D _14856_/Q _14855_/Q _10521_/C _10521_/D VDD VSS sg13g2_and4_1
XFILLER_7_805 VDD VSS sg13g2_decap_8
XFILLER_11_867 VDD VSS sg13g2_decap_8
XFILLER_156_828 VDD VSS sg13g2_fill_2
XFILLER_183_625 VDD VSS sg13g2_decap_8
XFILLER_52_1361 VDD VSS sg13g2_decap_8
XFILLER_182_102 VDD VSS sg13g2_decap_8
XFILLER_183_636 VDD VSS sg13g2_fill_2
XFILLER_13_1334 VDD VSS sg13g2_decap_8
X_13240_ _13246_/C _14923_/Q _13664_/Q VDD VSS sg13g2_xor2_1
X_13886__2316 _13886_/RESET_B VDD VSS sg13g2_tiehi
XFILLER_6_326 VDD VSS sg13g2_decap_8
XFILLER_104_1462 VDD VSS sg13g2_decap_8
X_10452_ _10452_/Y _14840_/Q _10450_/C _10557_/C VDD VSS sg13g2_o21ai_1
XFILLER_10_399 VDD VSS sg13g2_decap_8
X_13922__2280 _13922_/RESET_B VDD VSS sg13g2_tiehi
XFILLER_182_179 VDD VSS sg13g2_decap_8
X_13171_ _13176_/A _13171_/A _13172_/D VDD VSS sg13g2_nand2_1
XFILLER_100_1348 VDD VSS sg13g2_decap_8
X_10383_ _10386_/B _10378_/D _10380_/X _14819_/Q VDD VSS sg13g2_a21oi_1
XFILLER_184_44 VDD VSS sg13g2_decap_8
XFILLER_87_1468 VDD VSS sg13g2_decap_8
XFILLER_48_1419 VDD VSS sg13g2_decap_8
XFILLER_108_287 VDD VSS sg13g2_decap_8
XFILLER_136_596 VDD VSS sg13g2_decap_8
XFILLER_174_1427 VDD VSS sg13g2_decap_8
X_12122_ _12122_/Y _14919_/Q _12294_/A2 _12118_/Y _12121_/Y VDD VSS sg13g2_a22oi_1
X_14790__2946 _14790_/RESET_B VDD VSS sg13g2_tiehi
XFILLER_112_909 VDD VSS sg13g2_fill_1
XFILLER_2_532 VDD VSS sg13g2_decap_8
XFILLER_81_1001 VDD VSS sg13g2_decap_8
XFILLER_78_801 VDD VSS sg13g2_fill_1
XFILLER_111_419 VDD VSS sg13g2_decap_4
X_12053_ _14980_/D _12053_/A _12053_/B VDD VSS sg13g2_nor2_1
XFILLER_104_460 VDD VSS sg13g2_decap_8
XFILLER_172_1151 VDD VSS sg13g2_decap_8
XFILLER_132_791 VDD VSS sg13g2_decap_8
X_15091__2824 _15091_/RESET_B VDD VSS sg13g2_tiehi
X_11004_ _11007_/A _11004_/A _11004_/B _11009_/D _11009_/C VDD VSS sg13g2_nand4_1
XFILLER_78_856 VDD VSS sg13g2_decap_4
XFILLER_46_1176 VDD VSS sg13g2_decap_8
XFILLER_77_333 VDD VSS sg13g2_decap_8
XFILLER_133_1146 VDD VSS sg13g2_decap_8
X_16861_ _16861_/X _16861_/A VDD VSS sg13g2_buf_1
XFILLER_93_815 VDD VSS sg13g2_decap_8
XFILLER_81_1089 VDD VSS sg13g2_decap_8
XFILLER_19_901 VDD VSS sg13g2_decap_8
Xfanout880 _12550_/S0 _12701_/S0 VDD VSS sg13g2_buf_1
XFILLER_120_997 VDD VSS sg13g2_decap_8
Xfanout891 _12411_/S0 fanout894/X VDD VSS sg13g2_buf_1
XFILLER_24_1452 VDD VSS sg13g2_decap_8
XFILLER_20_1305 VDD VSS sg13g2_decap_8
XFILLER_168_1209 VDD VSS sg13g2_decap_8
XFILLER_111_1444 VDD VSS sg13g2_fill_1
X_12955_ _12956_/A _12945_/Y _12946_/Y _12954_/Y VDD VSS sg13g2_o21ai_1
X_15152__2676 _15152_/RESET_B VDD VSS sg13g2_tiehi
XFILLER_19_978 VDD VSS sg13g2_fill_2
XFILLER_111_1477 VDD VSS sg13g2_fill_2
XFILLER_93_63 VDD VSS sg13g2_decap_4
X_11906_ _14976_/D _11868_/Y _11905_/Y _11863_/Y VDD VSS sg13g2_a21oi_1
XFILLER_46_786 VDD VSS sg13g2_decap_8
X_15238__3029 _15238_/RESET_B VDD VSS sg13g2_tiehi
XFILLER_18_499 VDD VSS sg13g2_decap_8
X_12886_ _12886_/Y _12914_/A _12884_/Y _12885_/Y VDD VSS sg13g2_o21ai_1
XFILLER_93_96 VDD VSS sg13g2_decap_8
XFILLER_2_1281 VDD VSS sg13g2_decap_8
XFILLER_60_211 VDD VSS sg13g2_decap_4
XFILLER_178_408 VDD VSS sg13g2_decap_8
X_14625_ _14625_/Q clkload6/A _14625_/D _14625_/RESET_B VDD VSS sg13g2_dfrbpq_1
X_11837_ _11837_/Y _11837_/A1 _11836_/Y _11724_/B VDD VSS sg13g2_o21ai_1
XFILLER_92_1141 VDD VSS sg13g2_decap_4
XFILLER_57_1261 VDD VSS sg13g2_decap_8
XFILLER_42_970 VDD VSS sg13g2_decap_8
XFILLER_14_672 VDD VSS sg13g2_fill_1
XFILLER_18_1245 VDD VSS sg13g2_decap_8
XFILLER_20_119 VDD VSS sg13g2_decap_8
X_14556_ _14556_/Q _14588_/CLK _14556_/D _14556_/RESET_B VDD VSS sg13g2_dfrbpq_1
XFILLER_53_1125 VDD VSS sg13g2_decap_8
X_11768_ _11768_/Y _11767_/X _07682_/Y _11768_/B1 VDD VSS sg13g2_a21oi_1
XFILLER_14_694 VDD VSS sg13g2_decap_8
XFILLER_158_132 VDD VSS sg13g2_decap_8
XFILLER_186_441 VDD VSS sg13g2_decap_8
XFILLER_147_817 VDD VSS sg13g2_decap_4
XFILLER_13_193 VDD VSS sg13g2_decap_8
XFILLER_146_305 VDD VSS sg13g2_fill_2
XFILLER_174_614 VDD VSS sg13g2_decap_8
X_13507_ _15131_/D _13507_/A _13507_/B _13507_/C VDD VSS sg13g2_nor3_1
X_10719_ _14907_/D _10985_/B1 _10954_/C _10718_/Y VDD VSS sg13g2_o21ai_1
X_14487_ _14487_/Q clkload43/A _14487_/D _14487_/RESET_B VDD VSS sg13g2_dfrbpq_1
XFILLER_179_1316 VDD VSS sg13g2_decap_8
X_11699_ _11699_/Y _11698_/Y _11688_/Y _11680_/Y _11672_/Y _11903_/C1 VDD VSS sg13g2_a221oi_1
XFILLER_31_1412 VDD VSS sg13g2_decap_8
XFILLER_9_175 VDD VSS sg13g2_decap_8
XFILLER_146_338 VDD VSS sg13g2_fill_2
X_13438_ _13438_/Y _13469_/A _13438_/B _15130_/Q _13438_/D VDD VSS sg13g2_nand4_1
XFILLER_174_669 VDD VSS sg13g2_fill_2
X_14476__1726 _14476_/RESET_B VDD VSS sg13g2_tiehi
XFILLER_127_552 VDD VSS sg13g2_decap_8
XFILLER_173_168 VDD VSS sg13g2_decap_8
X_14512__1690 _14512_/RESET_B VDD VSS sg13g2_tiehi
XFILLER_177_1040 VDD VSS sg13g2_decap_8
X_13369_ _13369_/Y _13437_/A _13400_/B _15076_/Q VDD VSS sg13g2_nand3_1
XFILLER_155_894 VDD VSS sg13g2_decap_8
XFILLER_138_1013 VDD VSS sg13g2_decap_4
XFILLER_6_893 VDD VSS sg13g2_decap_8
X_15108_ _15108_/Q _15203_/CLK _15108_/D _15108_/RESET_B VDD VSS sg13g2_dfrbpq_1
XFILLER_5_392 VDD VSS sg13g2_decap_8
XFILLER_9_1402 VDD VSS sg13g2_decap_8
XFILLER_114_268 VDD VSS sg13g2_decap_4
XFILLER_130_717 VDD VSS sg13g2_decap_4
XFILLER_138_1068 VDD VSS sg13g2_fill_2
X_14766__2970 _14766_/RESET_B VDD VSS sg13g2_tiehi
XFILLER_69_801 VDD VSS sg13g2_decap_8
X_15039_ _15039_/Q _15188_/CLK _15039_/D _15039_/RESET_B VDD VSS sg13g2_dfrbpq_1
X_07930_ _08286_/A _07930_/A _08318_/B VDD VSS sg13g2_nor2_1
XFILLER_64_1232 VDD VSS sg13g2_decap_8
XFILLER_29_1352 VDD VSS sg13g2_decap_8
XFILLER_87_119 VDD VSS sg13g2_decap_8
X_14691__1511 _14691_/RESET_B VDD VSS sg13g2_tiehi
XFILLER_96_620 VDD VSS sg13g2_decap_8
XFILLER_155_1382 VDD VSS sg13g2_decap_8
X_07861_ _08608_/B _15013_/Q _07861_/B VDD VSS sg13g2_and2_1
XFILLER_151_1246 VDD VSS sg13g2_decap_4
X_09600_ _14197_/D _14197_/Q _10097_/A0 _09604_/S VDD VSS sg13g2_mux2_1
XFILLER_84_815 VDD VSS sg13g2_decap_8
XFILLER_68_388 VDD VSS sg13g2_fill_1
X_07792_ _07795_/A _08391_/B _08412_/A VDD VSS sg13g2_nand2b_1
XFILLER_3_1012 VDD VSS sg13g2_decap_8
XFILLER_37_731 VDD VSS sg13g2_decap_8
X_09531_ _14130_/D _09630_/A0 _14130_/Q _09538_/S VDD VSS sg13g2_mux2_1
XFILLER_97_1052 VDD VSS sg13g2_decap_8
X_13964__2238 _13964_/RESET_B VDD VSS sg13g2_tiehi
X_09462_ _14063_/D _09860_/A1 _14063_/Q _09471_/S VDD VSS sg13g2_mux2_1
XFILLER_64_572 VDD VSS sg13g2_decap_4
XFILLER_3_1089 VDD VSS sg13g2_decap_8
XFILLER_25_948 VDD VSS sg13g2_decap_8
XFILLER_52_734 VDD VSS sg13g2_decap_8
XFILLER_24_425 VDD VSS sg13g2_decap_8
X_08413_ _08418_/B _08383_/A _08383_/B _08415_/A _08411_/Y _08412_/Y VDD VSS sg13g2_a221oi_1
X_09393_ _13996_/D _09989_/A0 _13996_/Q _09395_/S VDD VSS sg13g2_mux2_1
XFILLER_178_920 VDD VSS sg13g2_decap_8
XFILLER_52_778 VDD VSS sg13g2_decap_8
XFILLER_52_789 VDD VSS sg13g2_fill_1
X_14749__1451 _14749_/RESET_B VDD VSS sg13g2_tiehi
XFILLER_36_1334 VDD VSS sg13g2_decap_8
X_08344_ _08344_/Y _08168_/Y _08270_/B _08027_/Y VDD VSS sg13g2_a21oi_1
XFILLER_162_1353 VDD VSS sg13g2_decap_8
XFILLER_177_441 VDD VSS sg13g2_decap_8
XFILLER_71_1236 VDD VSS sg13g2_decap_8
XFILLER_149_143 VDD VSS sg13g2_decap_8
XFILLER_165_603 VDD VSS sg13g2_decap_8
XFILLER_20_642 VDD VSS sg13g2_decap_8
X_08275_ _08275_/Y _08275_/A _08275_/B VDD VSS sg13g2_nor2_1
XFILLER_123_1359 VDD VSS sg13g2_fill_2
XFILLER_165_658 VDD VSS sg13g2_decap_8
XFILLER_20_686 VDD VSS sg13g2_fill_2
XFILLER_121_1050 VDD VSS sg13g2_fill_1
XFILLER_4_819 VDD VSS sg13g2_decap_8
XFILLER_146_872 VDD VSS sg13g2_decap_8
XFILLER_69_1143 VDD VSS sg13g2_decap_8
XFILLER_106_736 VDD VSS sg13g2_decap_8
XFILLER_145_371 VDD VSS sg13g2_decap_8
XFILLER_156_1113 VDD VSS sg13g2_decap_8
XFILLER_161_842 VDD VSS sg13g2_decap_8
XFILLER_133_544 VDD VSS sg13g2_decap_8
XFILLER_154_14 VDD VSS sg13g2_decap_8
XFILLER_78_108 VDD VSS sg13g2_decap_8
XFILLER_121_728 VDD VSS sg13g2_fill_2
XFILLER_134_1400 VDD VSS sg13g2_decap_8
XFILLER_47_1452 VDD VSS sg13g2_decap_8
Xfanout1108 _08653_/B _12229_/A VDD VSS sg13g2_buf_1
XFILLER_120_227 VDD VSS sg13g2_decap_8
Xfanout1119 _12129_/B2 _08931_/A1 VDD VSS sg13g2_buf_1
XFILLER_82_1365 VDD VSS sg13g2_decap_8
XFILLER_102_953 VDD VSS sg13g2_decap_4
Xfanout143 _09904_/A0 _09937_/A1 VDD VSS sg13g2_buf_1
Xfanout154 _09770_/A1 _09152_/Y VDD VSS sg13g2_buf_1
Xfanout165 _09966_/A1 _09834_/A0 VDD VSS sg13g2_buf_1
Xfanout176 _10096_/A0 _09126_/Y VDD VSS sg13g2_buf_1
XFILLER_47_23 VDD VSS sg13g2_fill_2
Xfanout187 _10160_/A1 fanout191/X VDD VSS sg13g2_buf_1
Xfanout198 _09463_/A0 _09762_/A1 VDD VSS sg13g2_buf_1
XFILLER_170_46 VDD VSS sg13g2_decap_8
X_09729_ _14320_/D _09762_/A1 _14320_/Q _09729_/S VDD VSS sg13g2_mux2_1
XFILLER_74_358 VDD VSS sg13g2_fill_1
XFILLER_103_40 VDD VSS sg13g2_decap_8
XFILLER_167_1220 VDD VSS sg13g2_decap_8
XFILLER_16_937 VDD VSS sg13g2_fill_1
X_12740_ _12740_/X _13847_/Q _13879_/Q _13911_/Q _13943_/Q _12759_/S0 _12759_/S1 VDD
+ VSS sg13g2_mux4_1
X_14554__1648 _14554_/RESET_B VDD VSS sg13g2_tiehi
XFILLER_42_211 VDD VSS sg13g2_decap_8
XFILLER_43_745 VDD VSS sg13g2_fill_2
XFILLER_179_11 VDD VSS sg13g2_decap_8
XFILLER_15_447 VDD VSS sg13g2_fill_2
X_12671_ _12671_/X _14706_/Q _14738_/Q _13778_/Q _13810_/Q _12675_/S0 _12675_/S1 VDD
+ VSS sg13g2_mux4_1
XFILLER_167_1297 VDD VSS sg13g2_decap_8
XFILLER_70_564 VDD VSS sg13g2_fill_1
XFILLER_169_931 VDD VSS sg13g2_decap_4
XFILLER_93_1461 VDD VSS sg13g2_decap_8
XFILLER_180_1420 VDD VSS sg13g2_decap_8
X_14410_ _14410_/Q clkload19/A _14410_/D _14410_/RESET_B VDD VSS sg13g2_dfrbpq_1
XFILLER_54_1423 VDD VSS sg13g2_decap_8
X_11622_ _11622_/X _11615_/B _11621_/X _11620_/Y VDD VSS sg13g2_a21o_1
XFILLER_11_620 VDD VSS sg13g2_decap_8
XFILLER_179_88 VDD VSS sg13g2_decap_8
XFILLER_15_1418 VDD VSS sg13g2_decap_8
XFILLER_137_0 VDD VSS sg13g2_decap_8
X_14341_ _14341_/Q clkload16/A _14341_/D _14341_/RESET_B VDD VSS sg13g2_dfrbpq_1
XFILLER_8_39 VDD VSS sg13g2_decap_8
XFILLER_50_1309 VDD VSS sg13g2_decap_8
XFILLER_128_305 VDD VSS sg13g2_fill_2
XFILLER_141_1437 VDD VSS sg13g2_fill_2
X_11553_ _11553_/Y _11555_/S0 _13924_/Q _11529_/B VDD VSS sg13g2_a21oi_1
XFILLER_7_602 VDD VSS sg13g2_decap_8
XFILLER_128_316 VDD VSS sg13g2_decap_8
XFILLER_129_839 VDD VSS sg13g2_decap_8
XFILLER_141_1459 VDD VSS sg13g2_decap_8
X_10504_ _10505_/D _14854_/Q _14853_/Q _10504_/C _14845_/Q VDD VSS sg13g2_and4_1
XFILLER_11_697 VDD VSS sg13g2_decap_8
XFILLER_128_349 VDD VSS sg13g2_fill_2
XFILLER_13_1131 VDD VSS sg13g2_decap_8
X_14272_ _14272_/Q clkload25/A _14272_/D _14272_/RESET_B VDD VSS sg13g2_dfrbpq_1
X_11484_ _11485_/B _11461_/A _13687_/Q _11463_/Y VDD VSS sg13g2_a21oi_1
XFILLER_6_123 VDD VSS sg13g2_decap_8
XFILLER_184_989 VDD VSS sg13g2_decap_8
XFILLER_10_196 VDD VSS sg13g2_decap_8
XFILLER_183_466 VDD VSS sg13g2_decap_8
XFILLER_143_308 VDD VSS sg13g2_decap_8
X_13223_ _15048_/D _13216_/Y _13222_/Y _13266_/A VDD VSS sg13g2_a21oi_1
XFILLER_7_679 VDD VSS sg13g2_decap_8
XFILLER_12_70 VDD VSS sg13g2_decap_8
X_10435_ _14834_/D _10435_/A _10435_/B _10443_/D VDD VSS sg13g2_nor3_1
XFILLER_170_116 VDD VSS sg13g2_decap_8
XFILLER_100_1156 VDD VSS sg13g2_fill_2
XFILLER_136_393 VDD VSS sg13g2_decap_8
XFILLER_48_1216 VDD VSS sg13g2_decap_8
XFILLER_124_544 VDD VSS sg13g2_decap_8
XFILLER_139_1344 VDD VSS sg13g2_decap_8
XFILLER_174_1224 VDD VSS sg13g2_decap_8
X_13154_ _13155_/B _13154_/A1 _13149_/X _13148_/Y _13160_/B _13153_/Y VDD VSS sg13g2_a221oi_1
XFILLER_3_830 VDD VSS sg13g2_decap_8
X_10366_ _10370_/C _14814_/Q _10365_/B VDD VSS sg13g2_nor2b_1
XFILLER_87_1287 VDD VSS sg13g2_decap_8
XFILLER_139_1366 VDD VSS sg13g2_fill_1
XFILLER_88_63 VDD VSS sg13g2_decap_8
X_12105_ _12105_/Y _12105_/A1 _14516_/Q _12088_/B VDD VSS sg13g2_a21oi_1
X_13085_ _13085_/Y _13085_/A _13085_/B _13085_/C VDD VSS sg13g2_nand3_1
XFILLER_111_216 VDD VSS sg13g2_decap_8
X_10297_ _10311_/B _10297_/A _10297_/B _10297_/C VDD VSS sg13g2_nor3_1
X_12036_ _12036_/X _12036_/A _12036_/B VDD VSS sg13g2_and2_1
XFILLER_26_7 VDD VSS sg13g2_decap_8
X_14754__2985 _14754_/RESET_B VDD VSS sg13g2_tiehi
XFILLER_61_1449 VDD VSS sg13g2_decap_8
XFILLER_120_794 VDD VSS sg13g2_decap_4
XFILLER_19_731 VDD VSS sg13g2_decap_8
XFILLER_20_1102 VDD VSS sg13g2_decap_8
XFILLER_18_230 VDD VSS sg13g2_fill_2
XFILLER_4_1365 VDD VSS sg13g2_decap_8
X_13987_ _13987_/Q _14723_/CLK _13987_/D _13987_/RESET_B VDD VSS sg13g2_dfrbpq_1
XFILLER_185_1320 VDD VSS sg13g2_decap_8
XFILLER_20_1179 VDD VSS sg13g2_decap_8
X_12938_ _12938_/Y input20/X _12795_/Y _12937_/Y VDD VSS sg13g2_o21ai_1
XFILLER_59_1345 VDD VSS sg13g2_decap_8
XFILLER_55_1209 VDD VSS sg13g2_decap_8
XFILLER_146_1348 VDD VSS sg13g2_decap_8
XFILLER_185_1397 VDD VSS sg13g2_decap_8
X_12869_ _12869_/Y _12914_/A _12867_/Y _12868_/Y VDD VSS sg13g2_o21ai_1
XFILLER_181_1239 VDD VSS sg13g2_decap_8
XFILLER_61_586 VDD VSS sg13g2_decap_8
X_14608_ _14608_/Q clkload11/A _14608_/D _14608_/RESET_B VDD VSS sg13g2_dfrbpq_1
XFILLER_33_288 VDD VSS sg13g2_decap_8
XFILLER_109_1170 VDD VSS sg13g2_decap_8
XFILLER_30_940 VDD VSS sg13g2_decap_8
X_14539_ _14539_/Q _14729_/CLK _14539_/D _14539_/RESET_B VDD VSS sg13g2_dfrbpq_1
XFILLER_146_102 VDD VSS sg13g2_fill_1
XFILLER_147_647 VDD VSS sg13g2_decap_8
XFILLER_179_1113 VDD VSS sg13g2_decap_8
X_08060_ _08060_/X _07771_/A _07778_/A _08362_/A3 _11635_/A _08023_/A _07884_/A VDD
+ VSS sg13g2_mux4_1
XFILLER_105_1078 VDD VSS sg13g2_decap_8
XFILLER_70_1280 VDD VSS sg13g2_decap_8
XFILLER_128_872 VDD VSS sg13g2_decap_8
XFILLER_161_105 VDD VSS sg13g2_decap_8
XFILLER_115_511 VDD VSS sg13g2_fill_2
XFILLER_127_371 VDD VSS sg13g2_fill_2
XFILLER_143_820 VDD VSS sg13g2_decap_8
XFILLER_31_1286 VDD VSS sg13g2_decap_8
XFILLER_66_1305 VDD VSS sg13g2_decap_8
XFILLER_6_690 VDD VSS sg13g2_decap_8
XFILLER_157_1455 VDD VSS sg13g2_decap_8
XFILLER_170_661 VDD VSS sg13g2_decap_8
XFILLER_130_503 VDD VSS sg13g2_decap_8
XFILLER_142_363 VDD VSS sg13g2_decap_8
XFILLER_118_1439 VDD VSS sg13g2_fill_1
XFILLER_153_1319 VDD VSS sg13g2_fill_1
X_08962_ _09707_/C _09441_/A _09441_/C VDD VSS sg13g2_nand2_1
XFILLER_130_525 VDD VSS sg13g2_decap_8
XFILLER_130_547 VDD VSS sg13g2_decap_8
X_07913_ _07913_/Y _08079_/S _08023_/B VDD VSS sg13g2_nand2_1
XFILLER_97_951 VDD VSS sg13g2_decap_8
X_08893_ _08893_/Y _08893_/A _14941_/Q VDD VSS sg13g2_nor2b_1
XFILLER_9_1276 VDD VSS sg13g2_decap_8
XFILLER_96_461 VDD VSS sg13g2_decap_4
XFILLER_57_815 VDD VSS sg13g2_decap_8
XFILLER_111_772 VDD VSS sg13g2_decap_8
XFILLER_112_1005 VDD VSS sg13g2_fill_2
XFILLER_69_686 VDD VSS sg13g2_decap_8
X_07844_ _07844_/X _15017_/Q _07845_/B VDD VSS sg13g2_and2_1
XFILLER_57_848 VDD VSS sg13g2_fill_1
XFILLER_110_271 VDD VSS sg13g2_decap_8
XFILLER_84_645 VDD VSS sg13g2_decap_8
XFILLER_186_1106 VDD VSS sg13g2_decap_8
XFILLER_83_133 VDD VSS sg13g2_decap_4
XFILLER_56_347 VDD VSS sg13g2_decap_8
XFILLER_72_807 VDD VSS sg13g2_fill_2
X_07775_ _08318_/C _08306_/C _08306_/B VDD VSS sg13g2_xor2_1
X_09514_ _14113_/D _09714_/A0 _14113_/Q _09533_/S VDD VSS sg13g2_mux2_1
XFILLER_37_572 VDD VSS sg13g2_fill_1
XFILLER_83_199 VDD VSS sg13g2_decap_4
XFILLER_77_1467 VDD VSS sg13g2_decap_8
XFILLER_13_907 VDD VSS sg13g2_decap_8
X_09445_ _14046_/D _09942_/A1 _14046_/Q _09467_/S VDD VSS sg13g2_mux2_1
XFILLER_164_1448 VDD VSS sg13g2_decap_8
XFILLER_12_406 VDD VSS sg13g2_decap_8
XFILLER_80_884 VDD VSS sg13g2_decap_4
XFILLER_33_25 VDD VSS sg13g2_decap_8
X_09376_ _13979_/D _10005_/A0 _13979_/Q _09407_/S VDD VSS sg13g2_mux2_1
XFILLER_71_1011 VDD VSS sg13g2_fill_2
XFILLER_24_299 VDD VSS sg13g2_decap_4
XFILLER_162_1150 VDD VSS sg13g2_decap_8
XFILLER_166_901 VDD VSS sg13g2_fill_1
XFILLER_127_1270 VDD VSS sg13g2_decap_8
XFILLER_184_219 VDD VSS sg13g2_decap_8
X_08327_ _08327_/X _07786_/A _08362_/A3 _08276_/A _08258_/C _08337_/S0 _08337_/S1
+ VDD VSS sg13g2_mux4_1
XFILLER_165_400 VDD VSS sg13g2_decap_8
XFILLER_178_794 VDD VSS sg13g2_decap_8
XFILLER_138_636 VDD VSS sg13g2_fill_1
X_08258_ _08258_/Y _08306_/A _14998_/Q _08258_/C VDD VSS sg13g2_nand3_1
XFILLER_137_157 VDD VSS sg13g2_decap_8
XFILLER_101_1432 VDD VSS sg13g2_decap_8
XFILLER_4_616 VDD VSS sg13g2_decap_8
X_08189_ _08190_/B _07909_/B _07910_/A _08188_/Y VDD VSS sg13g2_a21oi_1
XFILLER_10_1337 VDD VSS sg13g2_decap_8
XFILLER_152_138 VDD VSS sg13g2_decap_4
XFILLER_106_533 VDD VSS sg13g2_decap_4
XFILLER_109_4 VDD VSS sg13g2_decap_8
XFILLER_165_46 VDD VSS sg13g2_decap_8
X_10220_ _10220_/Y _14767_/Q _14768_/Q _10441_/C VDD VSS sg13g2_o21ai_1
XFILLER_106_544 VDD VSS sg13g2_decap_8
XFILLER_3_137 VDD VSS sg13g2_decap_8
X_15237__3028 _15237_/RESET_B VDD VSS sg13g2_tiehi
XFILLER_133_352 VDD VSS sg13g2_decap_8
XFILLER_84_1449 VDD VSS sg13g2_decap_8
XFILLER_161_672 VDD VSS sg13g2_decap_8
XFILLER_121_514 VDD VSS sg13g2_decap_8
X_10151_ _14728_/D _14728_/Q _10151_/A1 _10157_/S VDD VSS sg13g2_mux2_1
XFILLER_79_439 VDD VSS sg13g2_decap_8
X_14608__1594 _14608_/RESET_B VDD VSS sg13g2_tiehi
XFILLER_160_193 VDD VSS sg13g2_decap_8
XFILLER_0_855 VDD VSS sg13g2_decap_8
XFILLER_134_1230 VDD VSS sg13g2_decap_8
X_10082_ _14662_/D _10082_/A0 _14662_/Q _10096_/S VDD VSS sg13g2_mux2_1
XFILLER_94_409 VDD VSS sg13g2_decap_8
XFILLER_134_1252 VDD VSS sg13g2_decap_8
XFILLER_75_601 VDD VSS sg13g2_decap_8
XFILLER_181_56 VDD VSS sg13g2_decap_8
XFILLER_88_995 VDD VSS sg13g2_decap_8
X_13910_ _13910_/Q clkload68/A _13910_/D _13910_/RESET_B VDD VSS sg13g2_dfrbpq_1
XFILLER_47_314 VDD VSS sg13g2_fill_2
XFILLER_43_1168 VDD VSS sg13g2_decap_8
XFILLER_134_1296 VDD VSS sg13g2_decap_4
XFILLER_21_1400 VDD VSS sg13g2_decap_8
X_14890_ _14890_/Q _14893_/CLK _14890_/D _14890_/RESET_B VDD VSS sg13g2_dfrbpq_1
XFILLER_48_859 VDD VSS sg13g2_fill_2
XFILLER_169_1315 VDD VSS sg13g2_decap_8
X_13841_ _13841_/Q _14417_/CLK _13841_/D _13841_/RESET_B VDD VSS sg13g2_dfrbpq_1
XFILLER_63_829 VDD VSS sg13g2_decap_4
XFILLER_28_561 VDD VSS sg13g2_decap_8
X_13772_ _13772_/Q clkload53/A _13772_/D _13772_/RESET_B VDD VSS sg13g2_dfrbpq_1
X_10984_ _10984_/Y _10984_/A _10981_/Y VDD VSS sg13g2_nor2b_1
XFILLER_74_87 VDD VSS sg13g2_decap_8
XFILLER_55_380 VDD VSS sg13g2_decap_8
XFILLER_16_767 VDD VSS sg13g2_decap_8
X_12723_ _12736_/A _07737_/A _07737_/B _15016_/Q VDD VSS sg13g2_a21oi_1
XFILLER_91_1409 VDD VSS sg13g2_decap_8
XFILLER_43_553 VDD VSS sg13g2_decap_8
XFILLER_130_60 VDD VSS sg13g2_decap_8
XFILLER_15_266 VDD VSS sg13g2_decap_4
XFILLER_31_726 VDD VSS sg13g2_decap_8
XFILLER_54_1220 VDD VSS sg13g2_decap_8
X_12654_ _12654_/X _14577_/Q _14609_/Q _14641_/Q _14673_/Q _12661_/S0 _12661_/S1 VDD
+ VSS sg13g2_mux4_1
XFILLER_31_737 VDD VSS sg13g2_fill_2
XFILLER_30_225 VDD VSS sg13g2_decap_8
XFILLER_106_1321 VDD VSS sg13g2_fill_1
XFILLER_19_1373 VDD VSS sg13g2_decap_8
XFILLER_15_1215 VDD VSS sg13g2_decap_8
X_11605_ _11605_/Y _11617_/A1 _14662_/Q _11802_/B VDD VSS sg13g2_a21oi_1
XFILLER_8_900 VDD VSS sg13g2_decap_8
XFILLER_157_923 VDD VSS sg13g2_decap_8
XFILLER_175_219 VDD VSS sg13g2_decap_8
XFILLER_145_1392 VDD VSS sg13g2_fill_2
X_12585_ _12585_/X _14124_/Q _14156_/Q _14188_/Q _14220_/Q _12590_/S0 _12590_/S1 VDD
+ VSS sg13g2_mux4_1
XFILLER_106_1354 VDD VSS sg13g2_decap_8
X_14990__2620 _14990_/RESET_B VDD VSS sg13g2_tiehi
XFILLER_12_984 VDD VSS sg13g2_decap_8
XFILLER_180_1294 VDD VSS sg13g2_decap_8
XFILLER_54_1297 VDD VSS sg13g2_decap_8
XFILLER_184_742 VDD VSS sg13g2_decap_8
XFILLER_141_1267 VDD VSS sg13g2_fill_1
X_14324_ _14324_/Q _15005_/CLK _14324_/D _14324_/RESET_B VDD VSS sg13g2_dfrbpq_1
X_11536_ _11536_/Y _11551_/A1 _14564_/Q VDD VSS sg13g2_nand2b_1
XFILLER_106_1387 VDD VSS sg13g2_decap_8
XFILLER_11_494 VDD VSS sg13g2_decap_8
XFILLER_144_606 VDD VSS sg13g2_decap_4
XFILLER_156_466 VDD VSS sg13g2_decap_8
XFILLER_8_977 VDD VSS sg13g2_decap_8
XFILLER_171_403 VDD VSS sg13g2_decap_8
XFILLER_183_263 VDD VSS sg13g2_decap_8
XFILLER_128_179 VDD VSS sg13g2_fill_1
X_14255_ _14255_/Q clkload35/A _14255_/D _14255_/RESET_B VDD VSS sg13g2_dfrbpq_1
XFILLER_7_476 VDD VSS sg13g2_decap_8
XFILLER_109_360 VDD VSS sg13g2_decap_4
XFILLER_172_948 VDD VSS sg13g2_decap_8
X_11467_ _11467_/X _13953_/Q _13985_/Q _14017_/Q _14049_/Q _11493_/S0 _07654_/A VDD
+ VSS sg13g2_mux4_1
XFILLER_99_51 VDD VSS sg13g2_decap_8
XFILLER_143_127 VDD VSS sg13g2_decap_8
X_13206_ _13206_/Y _14825_/Q _13206_/B VDD VSS sg13g2_nand2_1
X_10418_ _10420_/A _14828_/Q _10422_/D _14829_/Q VDD VSS sg13g2_a21o_1
XFILLER_124_330 VDD VSS sg13g2_decap_8
X_14186_ _14186_/Q clkload27/A _14186_/D _14186_/RESET_B VDD VSS sg13g2_dfrbpq_1
XFILLER_152_650 VDD VSS sg13g2_decap_8
X_15050__2548 _15050_/RESET_B VDD VSS sg13g2_tiehi
X_11398_ _11398_/Y _11403_/S0 _14591_/Q _11419_/C VDD VSS sg13g2_a21oi_1
XFILLER_180_981 VDD VSS sg13g2_decap_8
X_13137_ _13139_/A _14820_/Q _13068_/B _13219_/B1 _14884_/Q VDD VSS sg13g2_a22oi_1
X_10349_ _10350_/B _14809_/Q _10352_/C VDD VSS sg13g2_nand2_1
XFILLER_97_214 VDD VSS sg13g2_fill_2
XFILLER_112_558 VDD VSS sg13g2_decap_4
XFILLER_174_1098 VDD VSS sg13g2_decap_8
XFILLER_79_951 VDD VSS sg13g2_fill_2
XFILLER_100_709 VDD VSS sg13g2_decap_8
XFILLER_140_878 VDD VSS sg13g2_decap_8
X_13068_ _13068_/Y _14815_/Q _13068_/B VDD VSS sg13g2_nand2_1
XFILLER_65_1382 VDD VSS sg13g2_decap_8
XFILLER_26_1333 VDD VSS sg13g2_decap_8
XFILLER_61_1246 VDD VSS sg13g2_decap_8
XFILLER_113_1314 VDD VSS sg13g2_decap_8
XFILLER_152_1363 VDD VSS sg13g2_fill_2
X_12019_ _12019_/Y _12019_/A _12019_/B _12219_/S VDD VSS sg13g2_nand3_1
XFILLER_66_634 VDD VSS sg13g2_decap_4
XFILLER_152_1396 VDD VSS sg13g2_decap_8
XFILLER_93_453 VDD VSS sg13g2_fill_2
XFILLER_38_358 VDD VSS sg13g2_fill_2
XFILLER_94_987 VDD VSS sg13g2_decap_4
XFILLER_19_550 VDD VSS sg13g2_decap_8
XFILLER_4_1162 VDD VSS sg13g2_decap_8
XFILLER_93_486 VDD VSS sg13g2_decap_4
XFILLER_0_1037 VDD VSS sg13g2_decap_8
XFILLER_0_84 VDD VSS sg13g2_decap_8
X_14046__2156 _14046_/RESET_B VDD VSS sg13g2_tiehi
X_13881__2321 _13881_/RESET_B VDD VSS sg13g2_tiehi
XFILLER_185_1194 VDD VSS sg13g2_decap_8
X_09230_ _13841_/D _09895_/A0 _13841_/Q _09238_/S VDD VSS sg13g2_mux2_1
XFILLER_62_895 VDD VSS sg13g2_decap_8
XFILLER_21_236 VDD VSS sg13g2_decap_8
XFILLER_72_1342 VDD VSS sg13g2_decap_8
XFILLER_37_1462 VDD VSS sg13g2_decap_8
XFILLER_124_1432 VDD VSS sg13g2_fill_1
X_09161_ _10793_/C _15052_/Q _15249_/Q _09161_/S VDD VSS sg13g2_mux2_1
XFILLER_119_113 VDD VSS sg13g2_decap_8
XFILLER_119_124 VDD VSS sg13g2_fill_1
X_08112_ _15220_/D _08112_/A _08112_/B _08112_/C _08112_/D VDD VSS sg13g2_nand4_1
XFILLER_33_1359 VDD VSS sg13g2_decap_8
XFILLER_108_809 VDD VSS sg13g2_decap_8
XFILLER_148_978 VDD VSS sg13g2_fill_2
X_09092_ _13775_/D _13775_/Q _09827_/A0 _09153_/S VDD VSS sg13g2_mux2_1
XFILLER_119_157 VDD VSS sg13g2_decap_8
X_08043_ _08043_/Y _08042_/X _08177_/S VDD VSS sg13g2_nand2b_1
XFILLER_174_274 VDD VSS sg13g2_decap_8
XFILLER_31_1072 VDD VSS sg13g2_fill_2
XFILLER_66_1102 VDD VSS sg13g2_decap_4
XFILLER_31_1094 VDD VSS sg13g2_decap_8
XFILLER_116_864 VDD VSS sg13g2_fill_2
XFILLER_89_704 VDD VSS sg13g2_decap_8
XFILLER_89_715 VDD VSS sg13g2_fill_1
XFILLER_66_1135 VDD VSS sg13g2_fill_1
XFILLER_157_1252 VDD VSS sg13g2_decap_8
XFILLER_115_374 VDD VSS sg13g2_decap_4
XFILLER_142_171 VDD VSS sg13g2_decap_8
X_09994_ _14577_/D _10160_/A1 _14577_/Q _10002_/S VDD VSS sg13g2_mux2_1
XFILLER_89_748 VDD VSS sg13g2_decap_8
XFILLER_118_1247 VDD VSS sg13g2_decap_4
XFILLER_131_845 VDD VSS sg13g2_decap_8
XFILLER_66_1179 VDD VSS sg13g2_decap_8
Xhold3046 input26/A mem_axi_rdata[2] VDD VSS sg13g2_dlygate4sd3_1
Xhold3057 hold3057/X input33/X VDD VSS sg13g2_dlygate4sd3_1
XFILLER_88_258 VDD VSS sg13g2_decap_8
XFILLER_131_878 VDD VSS sg13g2_fill_2
Xhold3068 input19/A mem_axi_rdata[23] VDD VSS sg13g2_dlygate4sd3_1
X_08945_ _08945_/Y _12229_/A _08955_/S _08944_/Y VDD VSS sg13g2_a21oi_1
Xhold3079 hold3079/X input28/X VDD VSS sg13g2_dlygate4sd3_1
XFILLER_170_1452 VDD VSS sg13g2_decap_8
XFILLER_69_461 VDD VSS sg13g2_decap_8
XFILLER_44_1466 VDD VSS sg13g2_decap_8
XFILLER_29_314 VDD VSS sg13g2_decap_8
XFILLER_28_25 VDD VSS sg13g2_decap_4
X_08876_ _13702_/D _16864_/A _08875_/X _08876_/S VDD VSS sg13g2_mux2_1
XFILLER_44_1477 VDD VSS sg13g2_fill_2
XFILLER_131_1436 VDD VSS sg13g2_decap_8
X_14256__1946 _14256_/RESET_B VDD VSS sg13g2_tiehi
XFILLER_40_1319 VDD VSS sg13g2_decap_8
XFILLER_56_133 VDD VSS sg13g2_decap_4
X_07827_ _08574_/B _15005_/Q _07946_/B VDD VSS sg13g2_xor2_1
XFILLER_131_1469 VDD VSS sg13g2_fill_1
XFILLER_45_818 VDD VSS sg13g2_decap_8
XFILLER_178_7 VDD VSS sg13g2_decap_8
XFILLER_84_486 VDD VSS sg13g2_decap_8
X_07758_ _07758_/Y _07742_/B _13282_/A1 _07757_/Y VDD VSS sg13g2_o21ai_1
XFILLER_129_1321 VDD VSS sg13g2_decap_8
XFILLER_168_1370 VDD VSS sg13g2_decap_8
XFILLER_77_1264 VDD VSS sg13g2_decap_8
X_07689_ _07690_/A _13356_/B _13281_/C VDD VSS sg13g2_nand2_1
XFILLER_129_1354 VDD VSS sg13g2_decap_4
X_14471__1731 _14471_/RESET_B VDD VSS sg13g2_tiehi
XFILLER_40_501 VDD VSS sg13g2_decap_8
XFILLER_38_1237 VDD VSS sg13g2_decap_8
XFILLER_12_203 VDD VSS sg13g2_decap_8
XFILLER_164_1245 VDD VSS sg13g2_decap_8
X_09428_ _14030_/D _09626_/A0 _14030_/Q _09428_/S VDD VSS sg13g2_mux2_1
XFILLER_185_539 VDD VSS sg13g2_decap_8
X_09359_ _13963_/D _10154_/A1 _13963_/Q _09368_/S VDD VSS sg13g2_mux2_1
XFILLER_8_207 VDD VSS sg13g2_decap_8
XFILLER_100_63 VDD VSS sg13g2_decap_8
XFILLER_138_422 VDD VSS sg13g2_decap_8
XFILLER_139_945 VDD VSS sg13g2_decap_8
XFILLER_60_45 VDD VSS sg13g2_decap_8
X_12370_ _12370_/X _12366_/X _12365_/X _12364_/X _12363_/X _12788_/S0 _12355_/S VDD
+ VSS sg13g2_mux4_1
XFILLER_51_1459 VDD VSS sg13g2_decap_8
XFILLER_166_764 VDD VSS sg13g2_decap_4
XFILLER_5_903 VDD VSS sg13g2_decap_8
XFILLER_165_252 VDD VSS sg13g2_decap_4
XFILLER_60_78 VDD VSS sg13g2_decap_8
XFILLER_176_56 VDD VSS sg13g2_decap_8
X_11321_ _11321_/Y _11319_/Y _11318_/Y _12101_/B _11320_/X VDD VSS sg13g2_a22oi_1
X_13744__2458 _13744_/RESET_B VDD VSS sg13g2_tiehi
XFILLER_138_499 VDD VSS sg13g2_decap_8
XFILLER_4_413 VDD VSS sg13g2_decap_8
XFILLER_153_436 VDD VSS sg13g2_decap_8
XFILLER_10_1134 VDD VSS sg13g2_decap_8
XFILLER_181_756 VDD VSS sg13g2_decap_4
XFILLER_107_842 VDD VSS sg13g2_decap_8
X_14040_ _14040_/Q _14514_/CLK _14040_/D _14040_/RESET_B VDD VSS sg13g2_dfrbpq_1
X_11252_ _11252_/Y _11277_/S _14588_/Q _12169_/C VDD VSS sg13g2_a21oi_1
XFILLER_180_266 VDD VSS sg13g2_decap_8
XFILLER_69_32 VDD VSS sg13g2_fill_1
XFILLER_136_1303 VDD VSS sg13g2_decap_8
X_10203_ _15183_/D hold3083/X _13391_/A _10203_/S VDD VSS sg13g2_mux2_1
XFILLER_175_1363 VDD VSS sg13g2_decap_8
XFILLER_49_1366 VDD VSS sg13g2_decap_8
XFILLER_122_834 VDD VSS sg13g2_fill_2
X_11183_ _11183_/Y _11206_/B1 _11181_/A _07753_/B VDD VSS sg13g2_o21ai_1
XFILLER_161_480 VDD VSS sg13g2_decap_8
XFILLER_84_1268 VDD VSS sg13g2_decap_8
XFILLER_0_630 VDD VSS sg13g2_decap_8
XFILLER_171_1238 VDD VSS sg13g2_decap_8
XFILLER_121_344 VDD VSS sg13g2_decap_8
X_14124__2078 _14124_/RESET_B VDD VSS sg13g2_tiehi
X_10134_ _14712_/D _10167_/A1 _14712_/Q _10134_/S VDD VSS sg13g2_mux2_1
XFILLER_122_889 VDD VSS sg13g2_fill_1
XFILLER_76_910 VDD VSS sg13g2_decap_8
X_14942_ _14942_/Q clkload57/A _14942_/D _14942_/RESET_B VDD VSS sg13g2_dfrbpq_1
X_10065_ _14646_/D _10098_/A0 _14646_/Q _10069_/S VDD VSS sg13g2_mux2_1
XFILLER_88_792 VDD VSS sg13g2_fill_1
XFILLER_48_623 VDD VSS sg13g2_decap_8
XFILLER_87_280 VDD VSS sg13g2_decap_8
XFILLER_48_656 VDD VSS sg13g2_fill_1
XFILLER_75_442 VDD VSS sg13g2_decap_8
XFILLER_75_453 VDD VSS sg13g2_fill_1
X_14873_ _14873_/Q clkload83/A _14873_/D _14873_/RESET_B VDD VSS sg13g2_dfrbpq_1
XFILLER_1_1302 VDD VSS sg13g2_decap_8
XFILLER_29_870 VDD VSS sg13g2_decap_8
XFILLER_78_1039 VDD VSS sg13g2_decap_4
XFILLER_75_486 VDD VSS sg13g2_decap_8
X_13824_ _13824_/Q clkload23/A _13824_/D _13824_/RESET_B VDD VSS sg13g2_dfrbpq_1
XFILLER_63_637 VDD VSS sg13g2_decap_8
XFILLER_35_328 VDD VSS sg13g2_decap_8
XFILLER_21_1274 VDD VSS sg13g2_decap_8
XFILLER_47_199 VDD VSS sg13g2_fill_2
XFILLER_169_1189 VDD VSS sg13g2_decap_8
X_14870__2827 _14870_/RESET_B VDD VSS sg13g2_tiehi
XFILLER_62_147 VDD VSS sg13g2_decap_8
XFILLER_56_1304 VDD VSS sg13g2_decap_8
XFILLER_1_1379 VDD VSS sg13g2_decap_8
X_13755_ _13755_/Q clkload80/A _13755_/D _13755_/RESET_B VDD VSS sg13g2_dfrbpq_1
X_10967_ _10995_/C _10967_/A _11015_/C VDD VSS sg13g2_nand2_1
XFILLER_147_1454 VDD VSS sg13g2_decap_8
XFILLER_182_1334 VDD VSS sg13g2_decap_8
X_14301__1901 _14301_/RESET_B VDD VSS sg13g2_tiehi
XFILLER_71_670 VDD VSS sg13g2_fill_2
X_12706_ _12706_/X _12705_/X _12704_/X _12706_/S VDD VSS sg13g2_mux2_1
XFILLER_91_1239 VDD VSS sg13g2_decap_8
XFILLER_93_7 VDD VSS sg13g2_decap_8
XFILLER_31_534 VDD VSS sg13g2_decap_8
XFILLER_143_1329 VDD VSS sg13g2_fill_1
X_13686_ _13686_/Q clkload60/A _13686_/D _13686_/RESET_B VDD VSS sg13g2_dfrbpq_1
X_10898_ _10898_/X _10923_/D _10923_/A _10898_/B1 VDD VSS sg13g2_a21o_1
XFILLER_176_528 VDD VSS sg13g2_decap_8
XFILLER_19_1170 VDD VSS sg13g2_decap_8
XFILLER_129_411 VDD VSS sg13g2_fill_2
XFILLER_15_1012 VDD VSS sg13g2_decap_8
XFILLER_176_539 VDD VSS sg13g2_fill_1
X_12637_ _12637_/Y _13673_/Q _12749_/A2 _12636_/X _12749_/B2 _12749_/C1 VDD VSS sg13g2_a221oi_1
XFILLER_54_1061 VDD VSS sg13g2_decap_8
XFILLER_169_591 VDD VSS sg13g2_fill_2
XFILLER_157_753 VDD VSS sg13g2_decap_8
XFILLER_180_1091 VDD VSS sg13g2_decap_8
X_12568_ _12569_/B _13678_/Q _12596_/A2 _12567_/X _12415_/A _12624_/C1 VDD VSS sg13g2_a221oi_1
XFILLER_89_1113 VDD VSS sg13g2_decap_8
XFILLER_141_1064 VDD VSS sg13g2_decap_8
XFILLER_11_291 VDD VSS sg13g2_decap_8
XFILLER_15_1089 VDD VSS sg13g2_decap_8
XFILLER_172_712 VDD VSS sg13g2_decap_4
XFILLER_8_774 VDD VSS sg13g2_decap_8
XFILLER_145_937 VDD VSS sg13g2_decap_8
XFILLER_156_274 VDD VSS sg13g2_fill_2
XFILLER_157_797 VDD VSS sg13g2_decap_8
X_14307_ _14307_/Q clkload18/A _14307_/D _14307_/RESET_B VDD VSS sg13g2_dfrbpq_1
X_11519_ _11519_/Y _11974_/B1 _11517_/X _11518_/Y VDD VSS sg13g2_o21ai_1
XFILLER_116_116 VDD VSS sg13g2_fill_1
XFILLER_184_594 VDD VSS sg13g2_decap_8
X_14334__1868 _14334_/RESET_B VDD VSS sg13g2_tiehi
X_12499_ _14999_/D _12499_/A _12499_/B VDD VSS sg13g2_nor2_1
XFILLER_7_273 VDD VSS sg13g2_decap_8
XFILLER_172_745 VDD VSS sg13g2_decap_8
XFILLER_89_1179 VDD VSS sg13g2_decap_8
XFILLER_144_458 VDD VSS sg13g2_decap_8
XFILLER_176_1149 VDD VSS sg13g2_decap_8
X_14238_ _14238_/Q _14526_/CLK _14238_/D _14238_/RESET_B VDD VSS sg13g2_dfrbpq_1
XFILLER_67_1444 VDD VSS sg13g2_decap_8
XFILLER_171_277 VDD VSS sg13g2_decap_8
XFILLER_28_1406 VDD VSS sg13g2_decap_8
XFILLER_125_683 VDD VSS sg13g2_decap_8
XFILLER_153_992 VDD VSS sg13g2_decap_8
X_14169_ _14169_/Q clkload44/A _14169_/D _14169_/RESET_B VDD VSS sg13g2_dfrbpq_1
XFILLER_98_523 VDD VSS sg13g2_decap_8
XFILLER_4_980 VDD VSS sg13g2_decap_8
XFILLER_154_1436 VDD VSS sg13g2_decap_8
Xfanout709 _12192_/A _07656_/Y VDD VSS sg13g2_buf_1
XFILLER_124_193 VDD VSS sg13g2_decap_8
X_13899__2303 _13899_/RESET_B VDD VSS sg13g2_tiehi
XFILLER_112_355 VDD VSS sg13g2_decap_4
X_15176__2894 _15176_/RESET_B VDD VSS sg13g2_tiehi
XFILLER_100_506 VDD VSS sg13g2_decap_4
XFILLER_26_1130 VDD VSS sg13g2_decap_8
XFILLER_79_770 VDD VSS sg13g2_decap_8
XFILLER_67_910 VDD VSS sg13g2_decap_8
XFILLER_112_388 VDD VSS sg13g2_fill_2
XFILLER_140_697 VDD VSS sg13g2_decap_8
X_08730_ _08730_/Y _08751_/A1 _07720_/B _13459_/B VDD VSS sg13g2_o21ai_1
XFILLER_61_1032 VDD VSS sg13g2_fill_1
XFILLER_152_1160 VDD VSS sg13g2_fill_2
XFILLER_85_228 VDD VSS sg13g2_decap_8
XFILLER_85_239 VDD VSS sg13g2_fill_2
XFILLER_15_0 VDD VSS sg13g2_decap_8
XFILLER_6_1257 VDD VSS sg13g2_decap_8
XFILLER_66_431 VDD VSS sg13g2_decap_8
XFILLER_152_1193 VDD VSS sg13g2_decap_8
Xfanout1280 fanout1280/X fanout1281/X VDD VSS sg13g2_buf_1
XFILLER_61_1076 VDD VSS sg13g2_decap_8
Xfanout1291 _11742_/C fanout1293/X VDD VSS sg13g2_buf_1
X_08661_ _08661_/X _08661_/A _08661_/B _08661_/C _08661_/D VDD VSS sg13g2_and4_1
XFILLER_113_1166 VDD VSS sg13g2_decap_8
XFILLER_94_773 VDD VSS sg13g2_decap_8
XFILLER_82_913 VDD VSS sg13g2_fill_1
XFILLER_26_306 VDD VSS sg13g2_decap_8
XFILLER_93_261 VDD VSS sg13g2_fill_1
X_07612_ _07612_/Y _08497_/A VDD VSS sg13g2_inv_1
XFILLER_94_795 VDD VSS sg13g2_fill_1
XFILLER_148_1207 VDD VSS sg13g2_decap_4
XFILLER_96_1139 VDD VSS sg13g2_fill_1
XFILLER_93_283 VDD VSS sg13g2_fill_2
XFILLER_82_946 VDD VSS sg13g2_decap_8
XFILLER_53_114 VDD VSS sg13g2_fill_1
X_08592_ _08592_/X _08337_/X _08427_/X _08510_/X _08591_/X _08511_/S _08431_/C VDD
+ VSS sg13g2_mux4_1
XFILLER_81_456 VDD VSS sg13g2_decap_8
XFILLER_53_147 VDD VSS sg13g2_decap_4
XFILLER_179_300 VDD VSS sg13g2_decap_8
XFILLER_74_1415 VDD VSS sg13g2_decap_8
X_15236__3027 _15236_/RESET_B VDD VSS sg13g2_tiehi
XFILLER_34_394 VDD VSS sg13g2_decap_8
XFILLER_161_1429 VDD VSS sg13g2_decap_8
XFILLER_61_191 VDD VSS sg13g2_decap_8
X_09213_ _13824_/D _09612_/A0 _13824_/Q _09233_/S VDD VSS sg13g2_mux2_1
XFILLER_10_707 VDD VSS sg13g2_decap_8
XFILLER_14_49 VDD VSS sg13g2_decap_8
XFILLER_50_887 VDD VSS sg13g2_decap_4
XFILLER_124_1251 VDD VSS sg13g2_fill_1
X_09144_ _09145_/B _13245_/A _09137_/C _09143_/Y VDD VSS sg13g2_o21ai_1
XFILLER_33_1156 VDD VSS sg13g2_decap_8
XFILLER_135_403 VDD VSS sg13g2_decap_8
XFILLER_163_712 VDD VSS sg13g2_fill_2
XFILLER_175_572 VDD VSS sg13g2_decap_8
X_09075_ _09075_/X _13088_/A _09103_/C _09074_/Y VDD VSS sg13g2_a21o_1
XFILLER_50_1470 VDD VSS sg13g2_fill_2
XFILLER_159_1325 VDD VSS sg13g2_decap_8
XFILLER_11_1443 VDD VSS sg13g2_decap_8
XFILLER_30_48 VDD VSS sg13g2_fill_1
XFILLER_163_767 VDD VSS sg13g2_decap_8
X_08026_ _08397_/A _08201_/A _08201_/B VDD VSS sg13g2_nor2_1
XFILLER_151_918 VDD VSS sg13g2_decap_8
XFILLER_144_970 VDD VSS sg13g2_fill_2
XFILLER_2_917 VDD VSS sg13g2_decap_8
XFILLER_144_992 VDD VSS sg13g2_decap_8
XFILLER_162_288 VDD VSS sg13g2_decap_8
XFILLER_1_427 VDD VSS sg13g2_decap_8
XFILLER_89_534 VDD VSS sg13g2_decap_8
XFILLER_131_631 VDD VSS sg13g2_decap_8
XFILLER_81_1419 VDD VSS sg13g2_decap_8
XFILLER_103_333 VDD VSS sg13g2_fill_1
XFILLER_130_130 VDD VSS sg13g2_decap_8
XFILLER_104_878 VDD VSS sg13g2_fill_1
XFILLER_118_1066 VDD VSS sg13g2_fill_1
X_14489__1713 _14489_/RESET_B VDD VSS sg13g2_tiehi
XFILLER_131_675 VDD VSS sg13g2_fill_1
X_09977_ _14560_/D _10010_/A0 _14560_/Q _09990_/S VDD VSS sg13g2_mux2_1
XFILLER_162_25 VDD VSS sg13g2_decap_8
Xclkbuf_4_3_0_clk_i clkbuf_4_3_0_clk_i/X clkbuf_0_clk_i/X VDD VSS sg13g2_buf_8
XFILLER_39_57 VDD VSS sg13g2_decap_4
XFILLER_76_217 VDD VSS sg13g2_decap_8
Xclkbuf_leaf_100_clk_i clkload49/A clkbuf_leaf_99_clk_i/A VDD VSS sg13g2_buf_8
X_08928_ _08928_/X _08927_/X _08928_/A1 _08928_/S VDD VSS sg13g2_mux2_1
XFILLER_44_1263 VDD VSS sg13g2_decap_8
XFILLER_131_1222 VDD VSS sg13g2_fill_1
XFILLER_57_442 VDD VSS sg13g2_fill_2
XFILLER_131_1255 VDD VSS sg13g2_fill_1
XFILLER_45_604 VDD VSS sg13g2_decap_8
X_08859_ _08859_/X _15028_/Q _14932_/Q _10675_/A VDD VSS sg13g2_mux2_1
XFILLER_73_935 VDD VSS sg13g2_fill_2
XFILLER_72_412 VDD VSS sg13g2_fill_2
XFILLER_131_1299 VDD VSS sg13g2_decap_8
X_11870_ _11870_/Y _11882_/S0 _13870_/Q _11742_/C VDD VSS sg13g2_a21oi_1
XFILLER_166_1318 VDD VSS sg13g2_decap_8
XFILLER_55_67 VDD VSS sg13g2_decap_8
Xclkbuf_leaf_115_clk_i clkload24/A clkbuf_5_6__f_clk_i/X VDD VSS sg13g2_buf_8
X_10821_ _10823_/C _10821_/A _10821_/B _10821_/C VDD VSS sg13g2_nand3_1
XFILLER_44_169 VDD VSS sg13g2_decap_4
XFILLER_13_501 VDD VSS sg13g2_decap_8
XFILLER_164_1042 VDD VSS sg13g2_fill_1
X_13540_ _15145_/D _13554_/S _13538_/Y _13539_/Y VDD VSS sg13g2_a21oi_1
X_10752_ _10752_/Y _10752_/A _10752_/B VDD VSS sg13g2_nor2_1
XFILLER_164_1053 VDD VSS sg13g2_fill_1
XFILLER_125_1026 VDD VSS sg13g2_decap_8
XFILLER_186_826 VDD VSS sg13g2_decap_8
X_13471_ _15176_/D hold3057/X _15176_/Q _13477_/S VDD VSS sg13g2_mux2_1
XFILLER_41_876 VDD VSS sg13g2_decap_4
XFILLER_13_578 VDD VSS sg13g2_decap_8
X_10683_ _10827_/B _08985_/X _08852_/A _08848_/Y VDD VSS sg13g2_a21oi_1
XFILLER_55_1370 VDD VSS sg13g2_decap_8
XFILLER_185_336 VDD VSS sg13g2_decap_8
XFILLER_142_1340 VDD VSS sg13g2_decap_8
X_13977__2225 _13977_/RESET_B VDD VSS sg13g2_tiehi
X_15210_ _15210_/Q _15214_/CLK _15210_/D _15210_/RESET_B VDD VSS sg13g2_dfrbpq_1
X_12422_ _12422_/X _14560_/Q _14592_/Q _14624_/Q _14656_/Q _12698_/S0 _12698_/S1 VDD
+ VSS sg13g2_mux4_1
XFILLER_16_1365 VDD VSS sg13g2_decap_8
XFILLER_90_1294 VDD VSS sg13g2_decap_4
XFILLER_138_241 VDD VSS sg13g2_decap_8
XFILLER_51_1256 VDD VSS sg13g2_decap_8
XFILLER_154_701 VDD VSS sg13g2_decap_8
XFILLER_103_1335 VDD VSS sg13g2_decap_8
XFILLER_12_1229 VDD VSS sg13g2_decap_8
XFILLER_5_700 VDD VSS sg13g2_decap_8
X_15141_ _15141_/Q clkload33/A _15141_/D _15141_/RESET_B VDD VSS sg13g2_dfrbpq_1
X_12353_ _12353_/X _12345_/X _12350_/X _12344_/X _12349_/X _12790_/S _12788_/S0 VDD
+ VSS sg13g2_mux4_1
XFILLER_126_425 VDD VSS sg13g2_decap_8
XFILLER_177_1436 VDD VSS sg13g2_decap_8
XFILLER_4_210 VDD VSS sg13g2_decap_8
X_11304_ _11304_/Y _11328_/S0 _14621_/Q VDD VSS sg13g2_nand2b_1
X_15072_ _15072_/Q clkload81/A _15072_/D _15072_/RESET_B VDD VSS sg13g2_dfrbpq_1
XFILLER_114_609 VDD VSS sg13g2_decap_4
X_12284_ _12284_/X _14713_/Q _14745_/Q _13785_/Q _13817_/Q _12288_/S0 _12288_/S1 VDD
+ VSS sg13g2_mux4_1
XFILLER_5_777 VDD VSS sg13g2_decap_8
X_14023_ _14023_/Q clkload12/A _14023_/D _14023_/RESET_B VDD VSS sg13g2_dfrbpq_1
XFILLER_20_70 VDD VSS sg13g2_decap_8
X_11235_ _11235_/X _11232_/Y _11233_/Y _15217_/Q VDD VSS sg13g2_a21o_1
XFILLER_175_1160 VDD VSS sg13g2_decap_8
XFILLER_4_287 VDD VSS sg13g2_decap_8
XFILLER_49_1163 VDD VSS sg13g2_decap_8
XFILLER_134_480 VDD VSS sg13g2_decap_8
XFILLER_136_1122 VDD VSS sg13g2_fill_1
XFILLER_106_182 VDD VSS sg13g2_decap_4
XFILLER_84_1065 VDD VSS sg13g2_decap_8
XFILLER_122_642 VDD VSS sg13g2_decap_8
XFILLER_171_1035 VDD VSS sg13g2_decap_8
X_11166_ _11166_/Y _11162_/Y _11165_/X _11206_/B1 VDD VSS sg13g2_o21ai_1
XFILLER_121_152 VDD VSS sg13g2_fill_2
XFILLER_62_1341 VDD VSS sg13g2_decap_8
XFILLER_110_837 VDD VSS sg13g2_decap_8
XFILLER_1_994 VDD VSS sg13g2_decap_8
X_10117_ _14695_/D _10150_/A1 _14695_/Q _10123_/S VDD VSS sg13g2_mux2_1
X_11097_ _11097_/Y _11097_/A _11115_/A _11097_/C VDD VSS sg13g2_nor3_1
XFILLER_49_943 VDD VSS sg13g2_decap_4
XFILLER_23_1325 VDD VSS sg13g2_decap_8
XFILLER_76_740 VDD VSS sg13g2_decap_8
XFILLER_49_976 VDD VSS sg13g2_fill_2
X_14925_ _14925_/Q _15052_/CLK _14925_/D _14925_/RESET_B VDD VSS sg13g2_dfrbpq_1
X_10048_ _14629_/D _10081_/A0 _14629_/Q _10059_/S VDD VSS sg13g2_mux2_1
XFILLER_63_401 VDD VSS sg13g2_decap_4
XFILLER_152_80 VDD VSS sg13g2_decap_8
XFILLER_75_261 VDD VSS sg13g2_fill_1
XFILLER_64_946 VDD VSS sg13g2_decap_8
XFILLER_75_283 VDD VSS sg13g2_decap_4
X_14856_ _14856_/Q clkload83/A _14856_/D _14856_/RESET_B VDD VSS sg13g2_dfrbpq_1
XFILLER_90_220 VDD VSS sg13g2_fill_1
XFILLER_64_957 VDD VSS sg13g2_fill_2
XFILLER_63_434 VDD VSS sg13g2_fill_2
XFILLER_184_1429 VDD VSS sg13g2_decap_8
XFILLER_63_456 VDD VSS sg13g2_decap_8
XFILLER_35_147 VDD VSS sg13g2_decap_8
XFILLER_21_1082 VDD VSS sg13g2_fill_1
XFILLER_17_862 VDD VSS sg13g2_decap_8
X_13807_ _13807_/Q clkload35/A _13807_/D _13807_/RESET_B VDD VSS sg13g2_dfrbpq_1
XFILLER_17_873 VDD VSS sg13g2_fill_2
XFILLER_1_1176 VDD VSS sg13g2_decap_8
X_14787_ _14787_/Q clkload87/A _14787_/D _14787_/RESET_B VDD VSS sg13g2_dfrbpq_1
XFILLER_91_798 VDD VSS sg13g2_fill_2
X_11999_ _12000_/B _11997_/X _11996_/X _11991_/X _11990_/X _12237_/C _11999_/S1 VDD
+ VSS sg13g2_mux4_1
XFILLER_32_810 VDD VSS sg13g2_fill_2
XFILLER_182_1131 VDD VSS sg13g2_decap_8
XFILLER_72_990 VDD VSS sg13g2_fill_2
XFILLER_50_128 VDD VSS sg13g2_decap_8
XFILLER_44_692 VDD VSS sg13g2_decap_8
X_13738_ _13738_/Q clkload25/A _13738_/D _13738_/RESET_B VDD VSS sg13g2_dfrbpq_1
XFILLER_147_1273 VDD VSS sg13g2_decap_8
XFILLER_108_1235 VDD VSS sg13g2_fill_1
XFILLER_91_4 VDD VSS sg13g2_decap_8
XFILLER_143_1126 VDD VSS sg13g2_decap_8
XFILLER_56_1178 VDD VSS sg13g2_decap_8
XFILLER_31_342 VDD VSS sg13g2_decap_8
X_13669_ _13669_/Q clkload72/A _13669_/D _13669_/RESET_B VDD VSS sg13g2_dfrbpq_1
XFILLER_34_1432 VDD VSS sg13g2_decap_8
XFILLER_121_1402 VDD VSS sg13g2_decap_8
XFILLER_160_1451 VDD VSS sg13g2_decap_8
XFILLER_176_358 VDD VSS sg13g2_decap_8
X_14834__2899 _14834_/RESET_B VDD VSS sg13g2_tiehi
X_14567__1635 _14567_/RESET_B VDD VSS sg13g2_tiehi
XFILLER_30_1307 VDD VSS sg13g2_decap_8
XFILLER_157_583 VDD VSS sg13g2_decap_8
XFILLER_145_734 VDD VSS sg13g2_decap_8
XFILLER_8_571 VDD VSS sg13g2_decap_8
XFILLER_117_436 VDD VSS sg13g2_fill_1
XFILLER_184_380 VDD VSS sg13g2_decap_8
Xclkbuf_leaf_94_clk_i _14508_/CLK clkbuf_leaf_94_clk_i/A VDD VSS sg13g2_buf_8
XFILLER_145_756 VDD VSS sg13g2_fill_2
XFILLER_117_458 VDD VSS sg13g2_decap_4
XFILLER_144_277 VDD VSS sg13g2_fill_1
XFILLER_160_726 VDD VSS sg13g2_decap_8
XFILLER_104_119 VDD VSS sg13g2_fill_2
XFILLER_172_597 VDD VSS sg13g2_fill_2
X_09900_ _14486_/D _10165_/A1 _14486_/Q _09904_/S VDD VSS sg13g2_mux2_1
XFILLER_67_1241 VDD VSS sg13g2_decap_8
XFILLER_28_1203 VDD VSS sg13g2_decap_8
XFILLER_154_1211 VDD VSS sg13g2_decap_8
Xfanout506 _08039_/A _08424_/A1 VDD VSS sg13g2_buf_1
XFILLER_98_342 VDD VSS sg13g2_decap_8
Xfanout517 _13653_/S _13480_/S VDD VSS sg13g2_buf_1
X_09831_ _14419_/D _09963_/A1 _14419_/Q _09837_/S VDD VSS sg13g2_mux2_1
Xfanout528 fanout528/X _13508_/X VDD VSS sg13g2_buf_1
XFILLER_98_364 VDD VSS sg13g2_decap_8
Xfanout539 _10870_/A _10691_/X VDD VSS sg13g2_buf_1
XFILLER_98_375 VDD VSS sg13g2_fill_2
XFILLER_86_515 VDD VSS sg13g2_fill_2
XFILLER_63_1149 VDD VSS sg13g2_decap_8
XFILLER_115_1228 VDD VSS sg13g2_fill_1
Xclkbuf_5_12__f_clk_i clkbuf_leaf_30_clk_i/A clkbuf_4_6_0_clk_i/X VDD VSS sg13g2_buf_16
X_09762_ _14352_/D _14352_/Q _09762_/A1 _09762_/S VDD VSS sg13g2_mux2_1
XFILLER_41_1425 VDD VSS sg13g2_decap_8
XFILLER_39_431 VDD VSS sg13g2_fill_2
XFILLER_39_442 VDD VSS sg13g2_fill_2
X_08713_ _15189_/D hold3093/X _15189_/Q _13479_/S VDD VSS sg13g2_mux2_1
XFILLER_6_1054 VDD VSS sg13g2_decap_8
X_09693_ _14285_/D _09726_/A0 _14285_/Q _09696_/S VDD VSS sg13g2_mux2_1
X_13658__1449 _13658_/RESET_B VDD VSS sg13g2_tiehi
Xclkbuf_leaf_32_clk_i _15160_/CLK clkbuf_leaf_34_clk_i/A VDD VSS sg13g2_buf_8
X_08644_ _08646_/C _15016_/Q _07850_/B _07855_/B VDD VSS sg13g2_o21ai_1
X_08575_ _08575_/Y _08575_/A _08575_/B _08575_/C VDD VSS sg13g2_nor3_1
XFILLER_81_264 VDD VSS sg13g2_decap_8
XFILLER_74_1212 VDD VSS sg13g2_decap_8
XFILLER_81_286 VDD VSS sg13g2_decap_8
XFILLER_39_1343 VDD VSS sg13g2_decap_8
XFILLER_179_130 VDD VSS sg13g2_decap_8
Xclkbuf_leaf_47_clk_i clkload47/A clkbuf_leaf_48_clk_i/A VDD VSS sg13g2_buf_8
XFILLER_34_191 VDD VSS sg13g2_fill_1
XFILLER_148_8 VDD VSS sg13g2_fill_1
XFILLER_161_1226 VDD VSS sg13g2_decap_8
XFILLER_168_837 VDD VSS sg13g2_decap_8
XFILLER_23_876 VDD VSS sg13g2_decap_8
XFILLER_74_1289 VDD VSS sg13g2_decap_8
XFILLER_50_662 VDD VSS sg13g2_decap_8
XFILLER_10_504 VDD VSS sg13g2_decap_8
XFILLER_50_684 VDD VSS sg13g2_decap_8
XFILLER_167_347 VDD VSS sg13g2_decap_8
XFILLER_41_14 VDD VSS sg13g2_decap_8
XFILLER_109_904 VDD VSS sg13g2_fill_1
XFILLER_155_509 VDD VSS sg13g2_decap_8
XFILLER_6_508 VDD VSS sg13g2_decap_8
XFILLER_157_25 VDD VSS sg13g2_decap_8
XFILLER_136_723 VDD VSS sg13g2_fill_1
X_09127_ _13780_/D _13780_/Q _10163_/A1 _09127_/S VDD VSS sg13g2_mux2_1
XFILLER_108_436 VDD VSS sg13g2_fill_1
XFILLER_108_447 VDD VSS sg13g2_decap_8
XFILLER_136_756 VDD VSS sg13g2_decap_4
XFILLER_11_1240 VDD VSS sg13g2_decap_8
XFILLER_108_469 VDD VSS sg13g2_decap_4
XFILLER_124_918 VDD VSS sg13g2_decap_4
X_09058_ _09058_/Y _09074_/B1 _10725_/B _09057_/X VDD VSS sg13g2_o21ai_1
XFILLER_123_417 VDD VSS sg13g2_decap_8
XFILLER_150_203 VDD VSS sg13g2_fill_2
XFILLER_151_726 VDD VSS sg13g2_decap_8
XFILLER_2_714 VDD VSS sg13g2_decap_8
X_08009_ _08009_/X _08673_/B _08048_/B _08009_/S VDD VSS sg13g2_mux2_1
XFILLER_85_1341 VDD VSS sg13g2_decap_8
XFILLER_159_1199 VDD VSS sg13g2_decap_8
XFILLER_1_224 VDD VSS sg13g2_decap_8
XFILLER_89_320 VDD VSS sg13g2_fill_1
XFILLER_104_642 VDD VSS sg13g2_fill_2
XFILLER_173_35 VDD VSS sg13g2_decap_8
XFILLER_137_1453 VDD VSS sg13g2_decap_8
XFILLER_172_1333 VDD VSS sg13g2_decap_8
X_11020_ _14942_/D _11019_/Y _11018_/Y _11001_/Y VDD VSS sg13g2_o21ai_1
XFILLER_81_1216 VDD VSS sg13g2_decap_8
XFILLER_137_1464 VDD VSS sg13g2_fill_2
XFILLER_133_1306 VDD VSS sg13g2_fill_2
XFILLER_46_1358 VDD VSS sg13g2_decap_8
XFILLER_131_494 VDD VSS sg13g2_decap_8
XFILLER_77_548 VDD VSS sg13g2_decap_8
X_14041__2161 _14041_/RESET_B VDD VSS sg13g2_tiehi
XFILLER_58_762 VDD VSS sg13g2_decap_8
XFILLER_18_604 VDD VSS sg13g2_decap_8
X_12971_ _15031_/D _12962_/Y _12970_/Y _13127_/A VDD VSS sg13g2_a21oi_1
XFILLER_85_570 VDD VSS sg13g2_decap_8
XFILLER_66_77 VDD VSS sg13g2_decap_8
XFILLER_73_721 VDD VSS sg13g2_decap_4
X_14710_ _14710_/Q _14742_/CLK _14710_/D _14710_/RESET_B VDD VSS sg13g2_dfrbpq_1
X_11922_ _11922_/X _14255_/Q _14287_/Q _14319_/Q _14351_/Q _12072_/S0 _12072_/S1 VDD
+ VSS sg13g2_mux4_1
XFILLER_79_1145 VDD VSS sg13g2_decap_4
X_14645__1557 _14645_/RESET_B VDD VSS sg13g2_tiehi
XFILLER_166_1115 VDD VSS sg13g2_fill_1
XFILLER_17_147 VDD VSS sg13g2_fill_2
XFILLER_22_1391 VDD VSS sg13g2_decap_8
XFILLER_2_1463 VDD VSS sg13g2_decap_8
X_14641_ _14641_/Q _15139_/CLK _14641_/D _14641_/RESET_B VDD VSS sg13g2_dfrbpq_1
X_11853_ _11853_/X _14381_/Q _14413_/Q _14477_/Q _14509_/Q _11756_/S _11760_/C VDD
+ VSS sg13g2_mux4_1
XFILLER_82_32 VDD VSS sg13g2_decap_8
XFILLER_73_798 VDD VSS sg13g2_decap_8
XFILLER_61_938 VDD VSS sg13g2_decap_8
XFILLER_57_1443 VDD VSS sg13g2_decap_8
X_10804_ _10804_/Y _10805_/B _10805_/C _15121_/Q VDD VSS sg13g2_o21ai_1
XFILLER_92_1334 VDD VSS sg13g2_decap_8
XFILLER_159_804 VDD VSS sg13g2_decap_8
X_14572_ _14572_/Q _14668_/CLK _14572_/D _14572_/RESET_B VDD VSS sg13g2_dfrbpq_1
X_11784_ _11784_/X _13739_/Q _14091_/Q _14443_/Q _14539_/Q _11786_/S0 _11786_/S1 VDD
+ VSS sg13g2_mux4_1
XFILLER_159_815 VDD VSS sg13g2_fill_2
XFILLER_18_1427 VDD VSS sg13g2_decap_8
XFILLER_53_1307 VDD VSS sg13g2_decap_8
XFILLER_14_865 VDD VSS sg13g2_decap_4
XFILLER_144_1446 VDD VSS sg13g2_decap_8
XFILLER_15_70 VDD VSS sg13g2_decap_8
XFILLER_186_623 VDD VSS sg13g2_decap_8
X_13523_ _13523_/Y _13523_/A _13565_/S VDD VSS sg13g2_nor2_1
X_10735_ _10735_/Y _10735_/A _10735_/B VDD VSS sg13g2_nor2_1
XFILLER_40_150 VDD VSS sg13g2_decap_8
XFILLER_13_375 VDD VSS sg13g2_decap_8
XFILLER_185_133 VDD VSS sg13g2_decap_8
XFILLER_139_550 VDD VSS sg13g2_decap_8
X_13454_ _13455_/D _15169_/Q _15170_/Q _13454_/C _13454_/D VDD VSS sg13g2_nand4_1
X_10666_ _10667_/C _14894_/Q _14893_/Q _14892_/Q _10666_/D VDD VSS sg13g2_and4_1
XFILLER_9_357 VDD VSS sg13g2_decap_8
XFILLER_167_870 VDD VSS sg13g2_decap_8
XFILLER_16_1162 VDD VSS sg13g2_decap_8
X_15013__2597 _15013_/RESET_B VDD VSS sg13g2_tiehi
XFILLER_103_1132 VDD VSS sg13g2_decap_8
XFILLER_12_1026 VDD VSS sg13g2_decap_8
X_12405_ _12405_/X _13951_/Q _13983_/Q _14015_/Q _14047_/Q _12590_/S0 _12590_/S1 VDD
+ VSS sg13g2_mux4_1
XFILLER_51_1075 VDD VSS sg13g2_decap_8
XFILLER_127_734 VDD VSS sg13g2_decap_8
XFILLER_154_520 VDD VSS sg13g2_fill_2
X_13385_ _15081_/D _13435_/A _13378_/C _13384_/Y VDD VSS sg13g2_o21ai_1
X_10597_ _10610_/D _14876_/Q _14875_/Q _14874_/Q _10597_/D VDD VSS sg13g2_and4_1
XFILLER_51_1086 VDD VSS sg13g2_fill_2
XFILLER_103_1176 VDD VSS sg13g2_decap_8
XFILLER_177_1233 VDD VSS sg13g2_decap_8
XFILLER_182_851 VDD VSS sg13g2_decap_8
X_15124_ _15124_/Q _15212_/CLK _15124_/D _15124_/RESET_B VDD VSS sg13g2_dfrbpq_1
Xoutput109 mem_axi_wdata[14] _15146_/Q VDD VSS sg13g2_buf_1
X_12336_ _12336_/Y _12331_/X _12336_/A2 _12334_/C VDD VSS sg13g2_a21oi_1
XFILLER_31_91 VDD VSS sg13g2_decap_8
XFILLER_138_1206 VDD VSS sg13g2_decap_8
XFILLER_56_7 VDD VSS sg13g2_decap_8
XFILLER_181_361 VDD VSS sg13g2_decap_8
XFILLER_108_981 VDD VSS sg13g2_fill_1
XFILLER_126_277 VDD VSS sg13g2_decap_8
X_14251__1951 _14251_/RESET_B VDD VSS sg13g2_tiehi
XFILLER_5_574 VDD VSS sg13g2_decap_8
XFILLER_141_214 VDD VSS sg13g2_fill_1
XFILLER_99_128 VDD VSS sg13g2_decap_8
XFILLER_114_439 VDD VSS sg13g2_decap_8
XFILLER_141_225 VDD VSS sg13g2_fill_2
X_15055_ _15055_/Q clkload86/A _15055_/D _15055_/RESET_B VDD VSS sg13g2_dfrbpq_1
X_12267_ _12267_/Y _14923_/Q _12294_/A2 _12263_/Y _12266_/Y VDD VSS sg13g2_a22oi_1
XFILLER_107_480 VDD VSS sg13g2_decap_8
XFILLER_64_1414 VDD VSS sg13g2_decap_8
X_14006_ _14006_/Q clkload75/A _14006_/D _14006_/RESET_B VDD VSS sg13g2_dfrbpq_1
X_15235__3026 _15235_/RESET_B VDD VSS sg13g2_tiehi
X_11218_ _11218_/X _14619_/Q _14651_/Q _11218_/S VDD VSS sg13g2_mux2_1
XFILLER_123_984 VDD VSS sg13g2_decap_8
X_12198_ _12200_/B _12198_/A _12198_/B _12198_/C _12198_/D VDD VSS sg13g2_nor4_1
XFILLER_122_461 VDD VSS sg13g2_decap_8
X_15138__2704 _15138_/RESET_B VDD VSS sg13g2_tiehi
Xoutput80 mem_axi_awaddr[19] _16872_/X VDD VSS sg13g2_buf_1
Xoutput91 mem_axi_awaddr[2] _16855_/X VDD VSS sg13g2_buf_1
XFILLER_110_623 VDD VSS sg13g2_decap_8
XFILLER_110_634 VDD VSS sg13g2_fill_1
X_11149_ _11151_/B _11150_/B _11150_/A VDD VSS sg13g2_nor2_1
XFILLER_1_791 VDD VSS sg13g2_decap_8
XFILLER_7_1330 VDD VSS sg13g2_decap_8
XFILLER_110_667 VDD VSS sg13g2_decap_8
XFILLER_114_1261 VDD VSS sg13g2_decap_8
XFILLER_83_529 VDD VSS sg13g2_decap_8
X_14908_ _14908_/Q _15228_/CLK _14908_/D _14908_/RESET_B VDD VSS sg13g2_dfrbpq_1
XFILLER_64_743 VDD VSS sg13g2_decap_8
XFILLER_23_1199 VDD VSS sg13g2_decap_8
XFILLER_36_445 VDD VSS sg13g2_decap_4
XFILLER_37_979 VDD VSS sg13g2_fill_2
XFILLER_24_607 VDD VSS sg13g2_decap_8
XFILLER_184_1226 VDD VSS sg13g2_decap_8
X_14839_ _14839_/Q _14848_/CLK _14839_/D _14839_/RESET_B VDD VSS sg13g2_dfrbpq_1
XFILLER_36_489 VDD VSS sg13g2_decap_8
X_08360_ _08360_/Y _08360_/A1 _08198_/X _08397_/A VDD VSS sg13g2_o21ai_1
XFILLER_23_139 VDD VSS sg13g2_decap_8
XFILLER_71_1418 VDD VSS sg13g2_decap_8
XFILLER_149_314 VDD VSS sg13g2_decap_8
XFILLER_108_1043 VDD VSS sg13g2_decap_8
X_08291_ _08291_/Y _08290_/X _08318_/D _08395_/A VDD VSS sg13g2_a21oi_1
XFILLER_60_982 VDD VSS sg13g2_decap_8
XFILLER_176_133 VDD VSS sg13g2_decap_8
XFILLER_31_172 VDD VSS sg13g2_decap_8
XFILLER_165_829 VDD VSS sg13g2_decap_8
XFILLER_121_1210 VDD VSS sg13g2_fill_2
X_14083__2119 _14083_/RESET_B VDD VSS sg13g2_tiehi
XFILLER_69_1325 VDD VSS sg13g2_decap_8
XFILLER_11_39 VDD VSS sg13g2_decap_8
XFILLER_173_873 VDD VSS sg13g2_decap_8
XFILLER_105_417 VDD VSS sg13g2_decap_8
XFILLER_117_288 VDD VSS sg13g2_decap_8
XFILLER_133_759 VDD VSS sg13g2_decap_8
X_14723__1479 _14723_/RESET_B VDD VSS sg13g2_tiehi
XFILLER_160_556 VDD VSS sg13g2_fill_2
Xfanout303 _09909_/A1 _08983_/X VDD VSS sg13g2_buf_1
XFILLER_67_1082 VDD VSS sg13g2_decap_8
Xfanout314 _10090_/S fanout317/X VDD VSS sg13g2_buf_1
Xfanout325 _09931_/S _09921_/S VDD VSS sg13g2_buf_1
XFILLER_119_1172 VDD VSS sg13g2_decap_8
XFILLER_141_781 VDD VSS sg13g2_decap_8
Xfanout336 _09762_/S _09758_/S VDD VSS sg13g2_buf_1
XFILLER_8_1138 VDD VSS sg13g2_decap_8
XFILLER_141_792 VDD VSS sg13g2_fill_1
Xfanout347 _09727_/S _09707_/X VDD VSS sg13g2_buf_1
X_09814_ _14402_/D _09814_/A0 _14402_/Q _09828_/S VDD VSS sg13g2_mux2_1
XFILLER_101_634 VDD VSS sg13g2_decap_8
XFILLER_143_38 VDD VSS sg13g2_decap_8
Xfanout358 _09626_/S _09606_/Y VDD VSS sg13g2_buf_1
XFILLER_87_857 VDD VSS sg13g2_decap_8
Xfanout369 _09339_/S _09327_/S VDD VSS sg13g2_buf_1
XFILLER_86_356 VDD VSS sg13g2_decap_8
XFILLER_41_1222 VDD VSS sg13g2_decap_8
X_09745_ _14335_/D _14335_/Q _09745_/A1 _09758_/S VDD VSS sg13g2_mux2_1
XFILLER_132_1361 VDD VSS sg13g2_decap_4
XFILLER_36_14 VDD VSS sg13g2_decap_8
XFILLER_100_199 VDD VSS sg13g2_decap_8
XFILLER_167_1402 VDD VSS sg13g2_decap_8
X_13664__2567 _13664_/RESET_B VDD VSS sg13g2_tiehi
XFILLER_39_294 VDD VSS sg13g2_decap_8
XFILLER_28_957 VDD VSS sg13g2_decap_8
XFILLER_27_434 VDD VSS sg13g2_fill_2
X_09676_ _14268_/D _09907_/A1 _14268_/Q _09706_/S VDD VSS sg13g2_mux2_1
XFILLER_41_1299 VDD VSS sg13g2_decap_8
XFILLER_43_916 VDD VSS sg13g2_fill_2
X_08627_ _08627_/Y _15015_/Q _12128_/A _08698_/B VDD VSS sg13g2_a21oi_1
XFILLER_36_990 VDD VSS sg13g2_fill_2
X_14293__1909 _14293_/RESET_B VDD VSS sg13g2_tiehi
XFILLER_70_757 VDD VSS sg13g2_decap_8
X_08558_ _08581_/C _08668_/A _08243_/Y _08557_/Y VDD VSS sg13g2_o21ai_1
XFILLER_168_601 VDD VSS sg13g2_fill_1
X_14915__2737 _14915_/RESET_B VDD VSS sg13g2_tiehi
XFILLER_74_1042 VDD VSS sg13g2_decap_8
XFILLER_52_13 VDD VSS sg13g2_fill_1
XFILLER_74_1064 VDD VSS sg13g2_decap_8
XFILLER_126_1143 VDD VSS sg13g2_decap_8
X_08489_ _08489_/Y _08621_/B _08406_/A _08484_/B VDD VSS sg13g2_a21oi_1
XFILLER_10_301 VDD VSS sg13g2_decap_8
XFILLER_35_1037 VDD VSS sg13g2_decap_8
XFILLER_168_35 VDD VSS sg13g2_decap_8
XFILLER_11_846 VDD VSS sg13g2_decap_8
XFILLER_156_807 VDD VSS sg13g2_decap_8
XFILLER_167_144 VDD VSS sg13g2_decap_8
XFILLER_168_667 VDD VSS sg13g2_fill_1
X_10520_ _10522_/B _14855_/Q _10579_/B _14856_/Q VDD VSS sg13g2_a21oi_1
XFILLER_52_1340 VDD VSS sg13g2_decap_8
XFILLER_122_1029 VDD VSS sg13g2_decap_4
XFILLER_126_1198 VDD VSS sg13g2_decap_8
XFILLER_13_1313 VDD VSS sg13g2_decap_8
XFILLER_6_305 VDD VSS sg13g2_decap_8
XFILLER_104_1441 VDD VSS sg13g2_decap_8
XFILLER_109_734 VDD VSS sg13g2_decap_8
XFILLER_167_199 VDD VSS sg13g2_fill_2
X_10451_ _10462_/D _14840_/Q _14839_/Q _10453_/C _10514_/A VDD VSS sg13g2_and4_1
XFILLER_10_378 VDD VSS sg13g2_decap_8
X_14059__2143 _14059_/RESET_B VDD VSS sg13g2_tiehi
XFILLER_182_158 VDD VSS sg13g2_decap_8
XFILLER_100_1327 VDD VSS sg13g2_decap_8
X_13170_ _13172_/D _13170_/A _13170_/B _13170_/C _13170_/D VDD VSS sg13g2_nor4_1
XFILLER_184_23 VDD VSS sg13g2_decap_8
X_10382_ _14818_/D _10378_/D _10380_/X _10381_/Y VDD VSS sg13g2_a21oi_1
XFILLER_87_1447 VDD VSS sg13g2_decap_8
XFILLER_124_715 VDD VSS sg13g2_decap_8
XFILLER_136_575 VDD VSS sg13g2_decap_8
XFILLER_164_884 VDD VSS sg13g2_fill_1
XFILLER_174_1406 VDD VSS sg13g2_decap_8
XFILLER_163_372 VDD VSS sg13g2_fill_1
X_12121_ _12121_/Y _12119_/Y _12120_/Y _11858_/A VDD VSS sg13g2_a21oi_1
XFILLER_2_511 VDD VSS sg13g2_decap_8
XFILLER_124_759 VDD VSS sg13g2_decap_8
XFILLER_151_556 VDD VSS sg13g2_decap_8
XFILLER_123_258 VDD VSS sg13g2_fill_2
X_12052_ _12053_/B _12011_/X _12013_/Y _12051_/Y VDD VSS sg13g2_a21oi_1
XFILLER_172_1130 VDD VSS sg13g2_decap_8
XFILLER_77_32 VDD VSS sg13g2_decap_8
XFILLER_46_1155 VDD VSS sg13g2_decap_8
XFILLER_2_588 VDD VSS sg13g2_decap_8
X_11003_ _11064_/A _15117_/Q _11042_/D VDD VSS sg13g2_xor2_1
XFILLER_81_1046 VDD VSS sg13g2_decap_8
XFILLER_78_835 VDD VSS sg13g2_decap_8
XFILLER_120_932 VDD VSS sg13g2_decap_8
XFILLER_133_1125 VDD VSS sg13g2_fill_2
X_14807__2929 _14807_/RESET_B VDD VSS sg13g2_tiehi
X_16860_ _16860_/X _16860_/A VDD VSS sg13g2_buf_1
XFILLER_77_65 VDD VSS sg13g2_decap_8
Xfanout870 _12520_/S0 _12647_/S0 VDD VSS sg13g2_buf_1
XFILLER_78_879 VDD VSS sg13g2_decap_8
XFILLER_24_1431 VDD VSS sg13g2_decap_8
Xfanout881 _12703_/S0 _12701_/S0 VDD VSS sg13g2_buf_1
Xfanout892 _12590_/S0 fanout894/X VDD VSS sg13g2_buf_1
XFILLER_92_304 VDD VSS sg13g2_fill_1
XFILLER_150_1461 VDD VSS sg13g2_decap_8
XFILLER_77_389 VDD VSS sg13g2_decap_8
XFILLER_111_1423 VDD VSS sg13g2_decap_8
XFILLER_86_890 VDD VSS sg13g2_decap_4
XFILLER_19_957 VDD VSS sg13g2_decap_8
XFILLER_18_434 VDD VSS sg13g2_decap_8
X_12954_ _12954_/Y _12953_/Y _13004_/A2 _12950_/Y VDD VSS sg13g2_a21oi_1
X_15039__2570 _15039_/RESET_B VDD VSS sg13g2_tiehi
XFILLER_93_42 VDD VSS sg13g2_decap_8
XFILLER_46_765 VDD VSS sg13g2_decap_8
XFILLER_34_905 VDD VSS sg13g2_decap_4
XFILLER_18_478 VDD VSS sg13g2_decap_8
X_11905_ _11905_/Y _11904_/X _11458_/A _11978_/B1 VDD VSS sg13g2_a21oi_1
XFILLER_2_1260 VDD VSS sg13g2_decap_8
X_12885_ _12885_/Y input31/X _12841_/B _12803_/X input8/X _12883_/X VDD VSS sg13g2_a221oi_1
XFILLER_45_275 VDD VSS sg13g2_decap_8
X_14624_ _14624_/Q clkload23/A _14624_/D _14624_/RESET_B VDD VSS sg13g2_dfrbpq_1
XFILLER_57_1240 VDD VSS sg13g2_decap_8
X_11836_ _11836_/Y _14911_/Q _11433_/B _11832_/Y _11835_/Y VDD VSS sg13g2_a22oi_1
X_14269__1933 _14269_/RESET_B VDD VSS sg13g2_tiehi
XFILLER_61_768 VDD VSS sg13g2_decap_8
XFILLER_26_91 VDD VSS sg13g2_decap_8
XFILLER_61_779 VDD VSS sg13g2_fill_2
XFILLER_14_651 VDD VSS sg13g2_decap_8
XFILLER_18_1224 VDD VSS sg13g2_decap_8
XFILLER_109_1352 VDD VSS sg13g2_decap_8
XFILLER_158_100 VDD VSS sg13g2_decap_8
XFILLER_183_1281 VDD VSS sg13g2_decap_8
XFILLER_186_420 VDD VSS sg13g2_decap_8
X_14555_ _14555_/Q _14682_/CLK _14555_/D _14555_/RESET_B VDD VSS sg13g2_dfrbpq_1
X_11767_ _11767_/X _14909_/Q _11792_/B _11766_/Y VDD VSS sg13g2_a21o_1
XFILLER_60_289 VDD VSS sg13g2_decap_8
XFILLER_13_172 VDD VSS sg13g2_decap_8
XFILLER_144_1265 VDD VSS sg13g2_decap_8
XFILLER_41_481 VDD VSS sg13g2_decap_8
X_13506_ _13507_/C _13506_/A _07721_/B VDD VSS sg13g2_nor2b_1
XFILLER_144_1287 VDD VSS sg13g2_decap_8
X_10718_ _10718_/Y _14907_/Q _10973_/B VDD VSS sg13g2_nand2_1
X_14486_ _14486_/Q _14742_/CLK _14486_/D _14486_/RESET_B VDD VSS sg13g2_dfrbpq_1
X_11698_ _11698_/Y _11698_/A _11559_/C VDD VSS sg13g2_nor2b_1
XFILLER_9_154 VDD VSS sg13g2_decap_8
XFILLER_70_1462 VDD VSS sg13g2_decap_8
XFILLER_186_497 VDD VSS sg13g2_decap_8
XFILLER_174_648 VDD VSS sg13g2_decap_8
X_13437_ _13437_/Y _13437_/A _13469_/A _13437_/C VDD VSS sg13g2_nand3_1
X_10649_ _10652_/B _14874_/Q _12963_/A _14872_/Q _14871_/Q VDD VSS sg13g2_nand4_1
XFILLER_173_147 VDD VSS sg13g2_decap_8
X_13657__1448 _13657_/RESET_B VDD VSS sg13g2_tiehi
XFILLER_31_1468 VDD VSS sg13g2_decap_8
XFILLER_155_862 VDD VSS sg13g2_fill_1
XFILLER_127_564 VDD VSS sg13g2_fill_2
X_13368_ _15075_/D _13361_/C _13367_/Y _13366_/Y VDD VSS sg13g2_o21ai_1
XFILLER_6_872 VDD VSS sg13g2_decap_8
XFILLER_115_737 VDD VSS sg13g2_decap_8
XFILLER_154_372 VDD VSS sg13g2_decap_8
X_15107_ _15107_/Q clkload87/A _15107_/D _15107_/RESET_B VDD VSS sg13g2_dfrbpq_1
XFILLER_5_371 VDD VSS sg13g2_decap_8
X_12319_ _12319_/Y _12330_/S0 _14426_/Q _12307_/C VDD VSS sg13g2_a21oi_1
XFILLER_170_854 VDD VSS sg13g2_decap_4
XFILLER_138_1047 VDD VSS sg13g2_decap_8
X_13299_ _13299_/Y _07988_/D _13298_/X _13297_/X VDD VSS sg13g2_a21oi_1
XFILLER_64_1211 VDD VSS sg13g2_decap_8
XFILLER_29_1331 VDD VSS sg13g2_decap_8
XFILLER_130_707 VDD VSS sg13g2_decap_4
XFILLER_142_567 VDD VSS sg13g2_decap_8
XFILLER_170_887 VDD VSS sg13g2_decap_4
X_15038_ _15038_/Q clkload63/A _15038_/D _15038_/RESET_B VDD VSS sg13g2_dfrbpq_1
XFILLER_68_1391 VDD VSS sg13g2_decap_8
XFILLER_155_1361 VDD VSS sg13g2_decap_8
XFILLER_96_610 VDD VSS sg13g2_decap_4
XFILLER_69_846 VDD VSS sg13g2_decap_8
XFILLER_151_1225 VDD VSS sg13g2_decap_8
X_13757__2445 _13757_/RESET_B VDD VSS sg13g2_tiehi
X_07860_ _08608_/A _15013_/Q _07861_/B VDD VSS sg13g2_nor2_1
XFILLER_9_1458 VDD VSS sg13g2_decap_8
XFILLER_110_420 VDD VSS sg13g2_fill_1
XFILLER_64_1288 VDD VSS sg13g2_decap_8
XFILLER_110_442 VDD VSS sg13g2_decap_8
XFILLER_68_356 VDD VSS sg13g2_decap_8
XFILLER_110_453 VDD VSS sg13g2_fill_1
XFILLER_3_95 VDD VSS sg13g2_decap_8
X_07791_ _08415_/A _08391_/B _08412_/A VDD VSS sg13g2_nor2b_1
XFILLER_95_175 VDD VSS sg13g2_fill_2
XFILLER_37_710 VDD VSS sg13g2_decap_8
XFILLER_95_186 VDD VSS sg13g2_fill_1
XFILLER_110_497 VDD VSS sg13g2_decap_8
XFILLER_77_890 VDD VSS sg13g2_decap_8
X_09530_ _14129_/D _09961_/A1 _14129_/Q _09538_/S VDD VSS sg13g2_mux2_1
XFILLER_97_1031 VDD VSS sg13g2_decap_8
XFILLER_97_1042 VDD VSS sg13g2_fill_1
XFILLER_64_551 VDD VSS sg13g2_decap_8
XFILLER_3_1068 VDD VSS sg13g2_decap_8
X_09461_ _14062_/D _09626_/A0 _14062_/Q _09461_/S VDD VSS sg13g2_mux2_1
X_13972__2230 _13972_/RESET_B VDD VSS sg13g2_tiehi
X_14137__2065 _14137_/RESET_B VDD VSS sg13g2_tiehi
XFILLER_37_787 VDD VSS sg13g2_decap_8
XFILLER_25_927 VDD VSS sg13g2_decap_8
XFILLER_24_404 VDD VSS sg13g2_decap_8
XFILLER_97_1086 VDD VSS sg13g2_decap_4
XFILLER_58_1048 VDD VSS sg13g2_decap_8
X_08412_ _08412_/Y _08412_/A _08412_/B VDD VSS sg13g2_nor2_1
XFILLER_36_297 VDD VSS sg13g2_decap_8
X_09392_ _13995_/D _10154_/A1 _13995_/Q _09401_/S VDD VSS sg13g2_mux2_1
XFILLER_51_234 VDD VSS sg13g2_decap_8
XFILLER_149_1198 VDD VSS sg13g2_decap_8
XFILLER_36_1313 VDD VSS sg13g2_decap_8
X_08343_ _08346_/C _08306_/A _07784_/B _08359_/A2 _07796_/A VDD VSS sg13g2_a22oi_1
XFILLER_33_971 VDD VSS sg13g2_decap_8
XFILLER_11_109 VDD VSS sg13g2_decap_8
XFILLER_162_1332 VDD VSS sg13g2_decap_8
XFILLER_177_420 VDD VSS sg13g2_decap_8
XFILLER_75_1384 VDD VSS sg13g2_decap_8
XFILLER_71_1215 VDD VSS sg13g2_decap_8
XFILLER_51_289 VDD VSS sg13g2_decap_8
XFILLER_177_464 VDD VSS sg13g2_fill_1
X_08274_ _08275_/A _08276_/A _08276_/B VDD VSS sg13g2_nand2_1
XFILLER_138_829 VDD VSS sg13g2_decap_8
XFILLER_118_520 VDD VSS sg13g2_decap_8
XFILLER_149_199 VDD VSS sg13g2_decap_8
XFILLER_146_851 VDD VSS sg13g2_decap_8
XFILLER_69_1111 VDD VSS sg13g2_decap_4
XFILLER_118_564 VDD VSS sg13g2_fill_2
XFILLER_106_715 VDD VSS sg13g2_decap_8
XFILLER_145_350 VDD VSS sg13g2_fill_1
XFILLER_133_501 VDD VSS sg13g2_fill_2
XFILLER_3_319 VDD VSS sg13g2_decap_8
XFILLER_105_225 VDD VSS sg13g2_decap_8
XFILLER_12_1390 VDD VSS sg13g2_decap_8
XFILLER_145_394 VDD VSS sg13g2_decap_8
XFILLER_69_1199 VDD VSS sg13g2_decap_8
XFILLER_133_567 VDD VSS sg13g2_fill_2
XFILLER_47_1431 VDD VSS sg13g2_decap_8
XFILLER_161_898 VDD VSS sg13g2_decap_8
XFILLER_114_781 VDD VSS sg13g2_decap_4
Xfanout1109 _12229_/A _14986_/Q VDD VSS sg13g2_buf_1
XFILLER_82_1344 VDD VSS sg13g2_decap_8
Xfanout144 _10102_/A0 _09937_/A1 VDD VSS sg13g2_buf_1
X_14347__1855 _14347_/RESET_B VDD VSS sg13g2_tiehi
XFILLER_87_654 VDD VSS sg13g2_decap_4
Xfanout155 _10167_/A1 _09152_/Y VDD VSS sg13g2_buf_1
Xfanout166 _09834_/A0 _09138_/X VDD VSS sg13g2_buf_1
Xfanout177 _10162_/A1 _09963_/A1 VDD VSS sg13g2_buf_1
XFILLER_101_464 VDD VSS sg13g2_fill_2
Xfanout188 _09961_/A1 fanout191/X VDD VSS sg13g2_buf_1
Xfanout199 _09762_/A1 _09098_/Y VDD VSS sg13g2_buf_1
XFILLER_170_25 VDD VSS sg13g2_decap_8
X_07989_ _07989_/Y _10172_/C _13600_/C _10174_/B VDD VSS sg13g2_nand3_1
XFILLER_80_1090 VDD VSS sg13g2_decap_8
XFILLER_75_849 VDD VSS sg13g2_decap_4
XFILLER_86_186 VDD VSS sg13g2_decap_8
X_09728_ _14319_/D _10158_/A1 _14319_/Q _09738_/S VDD VSS sg13g2_mux2_1
XFILLER_41_1096 VDD VSS sg13g2_decap_8
X_09659_ _14252_/D _09923_/A1 _14252_/Q _09659_/S VDD VSS sg13g2_mux2_1
XFILLER_43_724 VDD VSS sg13g2_decap_8
X_13802__2400 _13802_/RESET_B VDD VSS sg13g2_tiehi
XFILLER_15_426 VDD VSS sg13g2_decap_8
X_14562__1640 _14562_/RESET_B VDD VSS sg13g2_tiehi
XFILLER_82_381 VDD VSS sg13g2_decap_8
XFILLER_167_1276 VDD VSS sg13g2_decap_8
X_12670_ _12670_/X _13842_/Q _13874_/Q _13906_/Q _13938_/Q _12675_/S0 _12675_/S1 VDD
+ VSS sg13g2_mux4_1
XFILLER_93_1440 VDD VSS sg13g2_decap_8
XFILLER_163_1129 VDD VSS sg13g2_decap_8
XFILLER_70_554 VDD VSS sg13g2_decap_4
XFILLER_54_1402 VDD VSS sg13g2_decap_8
XFILLER_43_779 VDD VSS sg13g2_decap_8
XFILLER_24_960 VDD VSS sg13g2_decap_4
X_11621_ _11621_/X _14694_/Q _14726_/Q _13766_/Q _13798_/Q _11621_/S0 _11391_/B VDD
+ VSS sg13g2_mux4_1
XFILLER_70_587 VDD VSS sg13g2_decap_8
XFILLER_144_2 VDD VSS sg13g2_fill_1
XFILLER_179_67 VDD VSS sg13g2_decap_8
X_15234__3025 _15234_/RESET_B VDD VSS sg13g2_tiehi
XFILLER_169_965 VDD VSS sg13g2_decap_8
XFILLER_8_18 VDD VSS sg13g2_decap_8
XFILLER_129_818 VDD VSS sg13g2_decap_8
XFILLER_184_913 VDD VSS sg13g2_decap_8
XFILLER_23_492 VDD VSS sg13g2_decap_8
X_14340_ _14340_/Q clkload52/A _14340_/D _14340_/RESET_B VDD VSS sg13g2_dfrbpq_1
XFILLER_180_1476 VDD VSS sg13g2_fill_2
X_11552_ _11552_/Y _11551_/A1 _13892_/Q VDD VSS sg13g2_nand2b_1
XFILLER_11_676 VDD VSS sg13g2_decap_8
XFILLER_13_1110 VDD VSS sg13g2_decap_8
X_13835__2367 _13835_/RESET_B VDD VSS sg13g2_tiehi
X_10503_ _10507_/D _14854_/Q _14853_/Q VDD VSS sg13g2_and2_1
XFILLER_6_102 VDD VSS sg13g2_decap_8
XFILLER_184_968 VDD VSS sg13g2_decap_8
X_14271_ _14271_/Q clkload61/A _14271_/D _14271_/RESET_B VDD VSS sg13g2_dfrbpq_1
X_11483_ _11485_/A _11483_/A _13686_/Q VDD VSS sg13g2_xnor2_1
XFILLER_10_175 VDD VSS sg13g2_decap_8
XFILLER_183_445 VDD VSS sg13g2_decap_8
XFILLER_7_658 VDD VSS sg13g2_decap_8
XFILLER_109_553 VDD VSS sg13g2_decap_8
X_13222_ _13222_/Y _13265_/A1 _13217_/X _13221_/Y VDD VSS sg13g2_a21oi_1
X_10434_ _10443_/D _14834_/Q _14833_/Q _10434_/C VDD VSS sg13g2_and3_1
XFILLER_171_629 VDD VSS sg13g2_fill_2
XFILLER_164_670 VDD VSS sg13g2_decap_8
XFILLER_100_1135 VDD VSS sg13g2_decap_8
XFILLER_13_1187 VDD VSS sg13g2_decap_8
XFILLER_152_821 VDD VSS sg13g2_decap_4
XFILLER_6_179 VDD VSS sg13g2_decap_8
XFILLER_100_1146 VDD VSS sg13g2_fill_2
XFILLER_124_523 VDD VSS sg13g2_decap_8
XFILLER_174_1203 VDD VSS sg13g2_decap_8
XFILLER_87_1255 VDD VSS sg13g2_decap_8
XFILLER_100_1168 VDD VSS sg13g2_decap_8
XFILLER_178_1383 VDD VSS sg13g2_decap_8
X_13153_ _13153_/Y _13150_/Y _13151_/Y _13152_/Y VDD VSS sg13g2_a21oi_1
X_10365_ _14813_/D _10365_/A _10365_/B _10365_/C VDD VSS sg13g2_and3_1
XFILLER_88_42 VDD VSS sg13g2_decap_8
X_12104_ _12104_/Y _12105_/A1 _14484_/Q VDD VSS sg13g2_nand2b_1
X_13084_ _13085_/C _13084_/A _13106_/B VDD VSS sg13g2_nand2_1
XFILLER_97_418 VDD VSS sg13g2_fill_1
X_10296_ _10297_/C _14788_/Q _14789_/Q _14791_/Q _14792_/Q VDD VSS sg13g2_nand4_1
XFILLER_3_886 VDD VSS sg13g2_decap_8
X_12035_ _12036_/A _14258_/Q _14290_/Q _14322_/Q _14354_/Q _12025_/A _12026_/C VDD
+ VSS sg13g2_mux4_1
XFILLER_2_385 VDD VSS sg13g2_decap_8
XFILLER_104_280 VDD VSS sg13g2_decap_8
XFILLER_61_1428 VDD VSS sg13g2_decap_8
XFILLER_78_665 VDD VSS sg13g2_fill_2
XFILLER_120_773 VDD VSS sg13g2_fill_1
XFILLER_93_613 VDD VSS sg13g2_decap_8
XFILLER_19_7 VDD VSS sg13g2_decap_8
XFILLER_19_710 VDD VSS sg13g2_decap_8
XFILLER_65_315 VDD VSS sg13g2_fill_2
XFILLER_4_1344 VDD VSS sg13g2_decap_8
XFILLER_111_1242 VDD VSS sg13g2_fill_2
X_13986_ _13986_/Q _14727_/CLK _13986_/D _13986_/RESET_B VDD VSS sg13g2_dfrbpq_1
XFILLER_0_1219 VDD VSS sg13g2_decap_8
XFILLER_20_1158 VDD VSS sg13g2_decap_8
XFILLER_59_1324 VDD VSS sg13g2_decap_8
X_12937_ _12937_/Y _12937_/A _12936_/Y VDD VSS sg13g2_nor2b_1
XFILLER_37_90 VDD VSS sg13g2_decap_8
XFILLER_80_329 VDD VSS sg13g2_fill_1
XFILLER_146_1305 VDD VSS sg13g2_fill_2
XFILLER_18_286 VDD VSS sg13g2_decap_8
XFILLER_146_1327 VDD VSS sg13g2_decap_8
XFILLER_185_1376 VDD VSS sg13g2_decap_8
XFILLER_181_1218 VDD VSS sg13g2_decap_8
X_12868_ _12868_/Y input30/X _12841_/B _12803_/X input7/X _12866_/X VDD VSS sg13g2_a221oi_1
XFILLER_33_256 VDD VSS sg13g2_decap_8
X_14607_ _14607_/Q clkload34/A _14607_/D _14607_/RESET_B VDD VSS sg13g2_dfrbpq_1
X_11819_ _11819_/Y _11821_/S0 _14508_/Q _11894_/B VDD VSS sg13g2_a21oi_1
X_12799_ _12799_/X _12799_/A _12936_/B VDD VSS sg13g2_and2_1
X_14538_ _14538_/Q _14602_/CLK _14538_/D _14538_/RESET_B VDD VSS sg13g2_dfrbpq_1
XFILLER_147_626 VDD VSS sg13g2_fill_2
XFILLER_18_1098 VDD VSS sg13g2_decap_8
XFILLER_105_1057 VDD VSS sg13g2_decap_8
XFILLER_186_294 VDD VSS sg13g2_decap_8
X_14425__1777 _14425_/RESET_B VDD VSS sg13g2_tiehi
X_14469_ _14469_/Q clkload26/A _14469_/D _14469_/RESET_B VDD VSS sg13g2_dfrbpq_1
XFILLER_146_147 VDD VSS sg13g2_decap_8
XFILLER_174_456 VDD VSS sg13g2_decap_4
XFILLER_122_1382 VDD VSS sg13g2_decap_8
XFILLER_31_1265 VDD VSS sg13g2_decap_8
XFILLER_179_1169 VDD VSS sg13g2_decap_8
X_15208__2999 _15208_/RESET_B VDD VSS sg13g2_tiehi
XFILLER_127_383 VDD VSS sg13g2_decap_8
XFILLER_142_320 VDD VSS sg13g2_fill_2
XFILLER_157_1434 VDD VSS sg13g2_decap_8
XFILLER_170_640 VDD VSS sg13g2_decap_8
X_08961_ _09641_/D _15060_/Q _08969_/C _07753_/B VDD VSS sg13g2_o21ai_1
XFILLER_64_1030 VDD VSS sg13g2_decap_8
X_14640__1562 _14640_/RESET_B VDD VSS sg13g2_tiehi
X_07912_ _07912_/Y _08174_/A _07912_/B VDD VSS sg13g2_nand2b_1
XFILLER_155_1180 VDD VSS sg13g2_decap_8
XFILLER_9_1255 VDD VSS sg13g2_decap_8
X_08892_ _13706_/D _16868_/A _08891_/X _08935_/S VDD VSS sg13g2_mux2_1
XFILLER_96_440 VDD VSS sg13g2_decap_8
XFILLER_64_1074 VDD VSS sg13g2_decap_8
XFILLER_151_1044 VDD VSS sg13g2_decap_8
X_07843_ _08678_/B _15017_/Q _12203_/A VDD VSS sg13g2_or2_1
XFILLER_97_996 VDD VSS sg13g2_decap_8
XFILLER_68_175 VDD VSS sg13g2_decap_4
XFILLER_151_1077 VDD VSS sg13g2_decap_8
XFILLER_99_1137 VDD VSS sg13g2_decap_4
XFILLER_112_1039 VDD VSS sg13g2_fill_2
XFILLER_110_294 VDD VSS sg13g2_fill_2
X_07774_ _08315_/B _08306_/C _08306_/B VDD VSS sg13g2_xnor2_1
XFILLER_42_1394 VDD VSS sg13g2_decap_8
XFILLER_71_307 VDD VSS sg13g2_decap_8
XFILLER_17_49 VDD VSS sg13g2_decap_8
X_13913__2289 _13913_/RESET_B VDD VSS sg13g2_tiehi
X_09513_ _14112_/D _09612_/A0 _14112_/Q _09524_/S VDD VSS sg13g2_mux2_1
XFILLER_77_1446 VDD VSS sg13g2_decap_8
XFILLER_80_830 VDD VSS sg13g2_fill_1
XFILLER_64_392 VDD VSS sg13g2_fill_2
XFILLER_38_1419 VDD VSS sg13g2_decap_8
X_09444_ _14045_/D _10040_/A0 _14045_/Q _09471_/S VDD VSS sg13g2_mux2_1
XFILLER_164_1427 VDD VSS sg13g2_decap_8
XFILLER_25_768 VDD VSS sg13g2_decap_8
XFILLER_25_779 VDD VSS sg13g2_decap_8
X_09375_ _09375_/Y _10004_/B _10004_/C _09441_/D VDD VSS sg13g2_nand3_1
XFILLER_75_1181 VDD VSS sg13g2_decap_8
XFILLER_178_773 VDD VSS sg13g2_decap_8
X_08326_ _08335_/B _08414_/B _08306_/A _07796_/B _08359_/A2 _08325_/Y VDD VSS sg13g2_a221oi_1
XFILLER_149_37 VDD VSS sg13g2_decap_8
XFILLER_166_935 VDD VSS sg13g2_decap_8
XFILLER_137_103 VDD VSS sg13g2_decap_8
XFILLER_36_1187 VDD VSS sg13g2_decap_8
X_08257_ _08257_/Y _08045_/Y _08270_/B _08027_/Y VDD VSS sg13g2_a21oi_1
XFILLER_101_1411 VDD VSS sg13g2_decap_8
XFILLER_125_309 VDD VSS sg13g2_decap_8
XFILLER_10_1316 VDD VSS sg13g2_decap_8
X_08188_ _08188_/Y _08188_/A _08188_/B _08188_/C VDD VSS sg13g2_nor3_1
XFILLER_106_501 VDD VSS sg13g2_fill_2
XFILLER_134_810 VDD VSS sg13g2_fill_2
XFILLER_106_512 VDD VSS sg13g2_decap_8
XFILLER_165_25 VDD VSS sg13g2_decap_8
XFILLER_3_116 VDD VSS sg13g2_decap_8
XFILLER_84_1428 VDD VSS sg13g2_decap_8
X_10150_ _14727_/D _14727_/Q _10150_/A1 _10156_/S VDD VSS sg13g2_mux2_1
XFILLER_160_172 VDD VSS sg13g2_decap_8
XFILLER_0_834 VDD VSS sg13g2_decap_8
XFILLER_82_1141 VDD VSS sg13g2_fill_1
X_10081_ _14661_/D _10081_/A0 _14661_/Q _10092_/S VDD VSS sg13g2_mux2_1
XFILLER_58_56 VDD VSS sg13g2_decap_8
XFILLER_181_35 VDD VSS sg13g2_decap_8
XFILLER_88_974 VDD VSS sg13g2_decap_8
XFILLER_43_1147 VDD VSS sg13g2_decap_8
XFILLER_74_101 VDD VSS sg13g2_decap_4
XFILLER_47_326 VDD VSS sg13g2_fill_1
XFILLER_101_283 VDD VSS sg13g2_fill_2
X_13840_ _13840_/Q _14704_/CLK _13840_/D _13840_/RESET_B VDD VSS sg13g2_dfrbpq_1
XFILLER_74_11 VDD VSS sg13g2_fill_2
XFILLER_63_808 VDD VSS sg13g2_decap_4
XFILLER_47_359 VDD VSS sg13g2_decap_8
XFILLER_21_1456 VDD VSS sg13g2_decap_8
XFILLER_62_318 VDD VSS sg13g2_decap_8
X_13771_ _13771_/Q clkload12/A _13771_/D _13771_/RESET_B VDD VSS sg13g2_dfrbpq_1
X_14503__1699 _14503_/RESET_B VDD VSS sg13g2_tiehi
XFILLER_62_329 VDD VSS sg13g2_fill_2
X_10983_ _10984_/A _11017_/A1 _10982_/X _10969_/B VDD VSS sg13g2_o21ai_1
X_12722_ _15015_/D _12722_/A _12722_/B VDD VSS sg13g2_nor2_1
XFILLER_70_351 VDD VSS sg13g2_fill_2
XFILLER_31_705 VDD VSS sg13g2_decap_8
X_12653_ _12666_/A _13005_/C _07737_/B _13566_/A VDD VSS sg13g2_a21oi_1
XFILLER_106_1300 VDD VSS sg13g2_decap_8
XFILLER_70_384 VDD VSS sg13g2_decap_8
XFILLER_19_1352 VDD VSS sg13g2_decap_8
XFILLER_145_1371 VDD VSS sg13g2_decap_8
X_11604_ _11604_/Y _11617_/A1 _14630_/Q VDD VSS sg13g2_nand2b_1
XFILLER_180_1273 VDD VSS sg13g2_decap_8
X_12584_ _12597_/A _13499_/B _13300_/C _15006_/Q VDD VSS sg13g2_a21oi_1
XFILLER_54_1276 VDD VSS sg13g2_decap_8
XFILLER_184_721 VDD VSS sg13g2_decap_8
X_14323_ _14323_/Q clkload36/A _14323_/D _14323_/RESET_B VDD VSS sg13g2_dfrbpq_1
X_11535_ _11535_/Y _11535_/A _11696_/B VDD VSS sg13g2_nand2_1
XFILLER_102_1219 VDD VSS sg13g2_decap_4
XFILLER_8_956 VDD VSS sg13g2_decap_8
XFILLER_157_979 VDD VSS sg13g2_fill_2
XFILLER_183_242 VDD VSS sg13g2_decap_8
XFILLER_172_927 VDD VSS sg13g2_decap_8
XFILLER_7_455 VDD VSS sg13g2_decap_8
X_14254_ _14254_/Q clkload19/A _14254_/D _14254_/RESET_B VDD VSS sg13g2_dfrbpq_1
XFILLER_99_30 VDD VSS sg13g2_decap_8
XFILLER_143_106 VDD VSS sg13g2_decap_8
XFILLER_184_798 VDD VSS sg13g2_decap_8
X_11466_ _11466_/X _14113_/Q _14145_/Q _14177_/Q _14209_/Q _11493_/S0 _11473_/S1 VDD
+ VSS sg13g2_mux4_1
XFILLER_137_681 VDD VSS sg13g2_fill_1
X_13205_ _13205_/X input22/X _13264_/A2 _13264_/B1 VDD VSS sg13g2_a21o_1
XFILLER_174_1000 VDD VSS sg13g2_fill_1
X_10417_ _14828_/D _14828_/Q _10415_/A _10416_/Y VDD VSS sg13g2_a21oi_1
XFILLER_178_1180 VDD VSS sg13g2_decap_8
X_14185_ _14185_/Q _14417_/CLK _14185_/D _14185_/RESET_B VDD VSS sg13g2_dfrbpq_1
X_11397_ _11397_/Y _11403_/S0 _14559_/Q VDD VSS sg13g2_nand2b_1
XFILLER_125_865 VDD VSS sg13g2_decap_4
XFILLER_87_1085 VDD VSS sg13g2_fill_1
XFILLER_125_887 VDD VSS sg13g2_decap_4
X_13136_ _13136_/X input17/X _12914_/A _13272_/B1 VDD VSS sg13g2_a21o_1
XFILLER_125_898 VDD VSS sg13g2_decap_4
X_10348_ _10350_/A _14809_/Q _10352_/C VDD VSS sg13g2_or2_1
XFILLER_174_1066 VDD VSS sg13g2_decap_4
XFILLER_112_537 VDD VSS sg13g2_decap_8
XFILLER_79_930 VDD VSS sg13g2_decap_8
XFILLER_3_683 VDD VSS sg13g2_decap_8
XFILLER_65_1361 VDD VSS sg13g2_decap_8
XFILLER_26_1312 VDD VSS sg13g2_decap_8
XFILLER_140_857 VDD VSS sg13g2_decap_8
XFILLER_97_248 VDD VSS sg13g2_decap_4
X_13067_ _13067_/Y _13066_/Y _13079_/C _13067_/C VDD VSS sg13g2_nand3b_1
X_10279_ _14787_/D _12812_/A _10279_/B _10311_/A VDD VSS sg13g2_nor3_1
XFILLER_2_182 VDD VSS sg13g2_decap_8
XFILLER_61_1225 VDD VSS sg13g2_decap_8
X_12018_ _12019_/B _12018_/A _12018_/B _12026_/C VDD VSS sg13g2_nand3_1
XFILLER_66_613 VDD VSS sg13g2_decap_8
XFILLER_38_304 VDD VSS sg13g2_decap_8
XFILLER_22_1209 VDD VSS sg13g2_decap_8
XFILLER_6_1439 VDD VSS sg13g2_decap_8
XFILLER_39_849 VDD VSS sg13g2_fill_1
XFILLER_26_1389 VDD VSS sg13g2_decap_8
XFILLER_120_592 VDD VSS sg13g2_decap_8
XFILLER_93_432 VDD VSS sg13g2_decap_8
XFILLER_94_966 VDD VSS sg13g2_decap_8
XFILLER_65_134 VDD VSS sg13g2_decap_8
XFILLER_4_1141 VDD VSS sg13g2_decap_8
XFILLER_94_999 VDD VSS sg13g2_decap_8
XFILLER_0_1016 VDD VSS sg13g2_decap_8
X_13969_ _13969_/Q clkload33/A _13969_/D _13969_/RESET_B VDD VSS sg13g2_dfrbpq_1
XFILLER_80_115 VDD VSS sg13g2_decap_8
XFILLER_0_63 VDD VSS sg13g2_decap_8
XFILLER_98_1181 VDD VSS sg13g2_fill_1
XFILLER_94_1023 VDD VSS sg13g2_fill_1
XFILLER_181_1004 VDD VSS sg13g2_fill_2
XFILLER_185_1173 VDD VSS sg13g2_decap_8
XFILLER_94_1056 VDD VSS sg13g2_decap_8
XFILLER_62_874 VDD VSS sg13g2_decap_8
XFILLER_59_1198 VDD VSS sg13g2_decap_8
XFILLER_72_1321 VDD VSS sg13g2_decap_8
XFILLER_37_1441 VDD VSS sg13g2_decap_8
X_09160_ _13785_/D _13785_/Q _10168_/A1 _09167_/S VDD VSS sg13g2_mux2_1
XFILLER_163_1471 VDD VSS sg13g2_decap_8
X_14658__1544 _14658_/RESET_B VDD VSS sg13g2_tiehi
X_08111_ _08112_/A _08359_/B2 _08087_/X _08098_/Y _08104_/Y _08093_/Y VDD VSS sg13g2_a221oi_1
XFILLER_33_1338 VDD VSS sg13g2_decap_8
XFILLER_72_1398 VDD VSS sg13g2_decap_8
XFILLER_124_1466 VDD VSS sg13g2_decap_8
X_09091_ _09091_/Y _09158_/A _09086_/Y _09090_/Y VDD VSS sg13g2_o21ai_1
XFILLER_147_456 VDD VSS sg13g2_fill_2
XFILLER_163_927 VDD VSS sg13g2_decap_4
XFILLER_174_253 VDD VSS sg13g2_decap_8
X_08042_ _08042_/X _11798_/A _08493_/B2 _08909_/A1 _08915_/A1 _08151_/S1 _08402_/A
+ VDD VSS sg13g2_mux4_1
XFILLER_134_106 VDD VSS sg13g2_fill_1
XFILLER_162_415 VDD VSS sg13g2_decap_8
X_14802__2934 _14802_/RESET_B VDD VSS sg13g2_tiehi
XFILLER_116_832 VDD VSS sg13g2_decap_8
XFILLER_116_843 VDD VSS sg13g2_fill_1
XFILLER_157_1231 VDD VSS sg13g2_decap_8
XFILLER_143_651 VDD VSS sg13g2_decap_8
XFILLER_115_353 VDD VSS sg13g2_decap_8
XFILLER_1_609 VDD VSS sg13g2_decap_8
XFILLER_131_824 VDD VSS sg13g2_decap_8
XFILLER_142_150 VDD VSS sg13g2_decap_8
XFILLER_143_684 VDD VSS sg13g2_decap_8
X_15026__2584 _15026_/RESET_B VDD VSS sg13g2_tiehi
X_09993_ _14576_/D _10159_/A1 _14576_/Q _09997_/S VDD VSS sg13g2_mux2_1
XFILLER_88_215 VDD VSS sg13g2_decap_8
XFILLER_66_1158 VDD VSS sg13g2_decap_8
XFILLER_0_119 VDD VSS sg13g2_decap_8
XFILLER_103_548 VDD VSS sg13g2_fill_2
Xhold3047 hold3047/X input26/X VDD VSS sg13g2_dlygate4sd3_1
X_08944_ _08944_/Y _08942_/Y _08943_/Y _08955_/S VDD VSS sg13g2_a21oi_1
XFILLER_170_1431 VDD VSS sg13g2_decap_8
X_15233__3024 _15233_/RESET_B VDD VSS sg13g2_tiehi
Xhold3058 input4/A mem_axi_rdata[0] VDD VSS sg13g2_dlygate4sd3_1
XFILLER_69_440 VDD VSS sg13g2_decap_8
Xhold3069 hold3069/X input19/X VDD VSS sg13g2_dlygate4sd3_1
XFILLER_44_1445 VDD VSS sg13g2_decap_8
X_14843__2881 _14843_/RESET_B VDD VSS sg13g2_tiehi
XFILLER_131_1415 VDD VSS sg13g2_decap_8
X_08875_ _08875_/X _08874_/X _11591_/A _08875_/S VDD VSS sg13g2_mux2_1
XFILLER_9_1085 VDD VSS sg13g2_decap_8
XFILLER_111_581 VDD VSS sg13g2_decap_8
XFILLER_29_337 VDD VSS sg13g2_decap_8
X_07826_ _07826_/X _15005_/Q _07946_/B VDD VSS sg13g2_and2_1
XFILLER_42_1191 VDD VSS sg13g2_decap_8
XFILLER_84_476 VDD VSS sg13g2_decap_4
X_07757_ _07757_/Y _07751_/Y _13300_/B _13305_/B VDD VSS sg13g2_a21oi_1
XFILLER_44_14 VDD VSS sg13g2_decap_8
XFILLER_77_1243 VDD VSS sg13g2_decap_8
XFILLER_25_543 VDD VSS sg13g2_decap_4
XFILLER_129_1333 VDD VSS sg13g2_decap_8
XFILLER_38_1216 VDD VSS sg13g2_decap_8
XFILLER_164_1224 VDD VSS sg13g2_decap_8
X_07688_ _07696_/A _07697_/A _13601_/B VDD VSS sg13g2_nand2_1
X_09427_ _14029_/D _10089_/A0 _14029_/Q _09430_/S VDD VSS sg13g2_mux2_1
XFILLER_90_1421 VDD VSS sg13g2_decap_8
XFILLER_129_1399 VDD VSS sg13g2_decap_4
XFILLER_100_42 VDD VSS sg13g2_decap_8
XFILLER_185_518 VDD VSS sg13g2_decap_8
XFILLER_12_259 VDD VSS sg13g2_decap_8
XFILLER_139_924 VDD VSS sg13g2_decap_8
X_09358_ _13962_/D _09723_/A0 _13962_/Q _09362_/S VDD VSS sg13g2_mux2_1
XFILLER_90_1465 VDD VSS sg13g2_decap_8
XFILLER_21_760 VDD VSS sg13g2_decap_8
XFILLER_51_1438 VDD VSS sg13g2_decap_8
XFILLER_166_743 VDD VSS sg13g2_decap_8
X_08309_ _08312_/B _07629_/A _08122_/Y _08308_/X VDD VSS sg13g2_a21oi_1
XFILLER_165_231 VDD VSS sg13g2_decap_8
X_09289_ _13897_/D _13897_/Q _09920_/A1 _09300_/S VDD VSS sg13g2_mux2_1
XFILLER_121_4 VDD VSS sg13g2_fill_1
XFILLER_176_35 VDD VSS sg13g2_decap_8
XFILLER_138_478 VDD VSS sg13g2_decap_8
X_11320_ _11320_/X _14237_/Q _14269_/Q _14301_/Q _14333_/Q _11715_/S0 _11715_/S1 VDD
+ VSS sg13g2_mux4_1
XFILLER_166_798 VDD VSS sg13g2_decap_8
XFILLER_10_1113 VDD VSS sg13g2_decap_8
XFILLER_14_1282 VDD VSS sg13g2_decap_8
X_13752__2450 _13752_/RESET_B VDD VSS sg13g2_tiehi
XFILLER_107_821 VDD VSS sg13g2_fill_1
XFILLER_119_692 VDD VSS sg13g2_decap_8
X_11251_ _11251_/Y _11277_/S _14556_/Q VDD VSS sg13g2_nand2b_1
XFILLER_5_959 VDD VSS sg13g2_decap_8
XFILLER_101_1263 VDD VSS sg13g2_decap_8
XFILLER_69_11 VDD VSS sg13g2_decap_8
XFILLER_180_245 VDD VSS sg13g2_decap_8
XFILLER_88_1383 VDD VSS sg13g2_decap_8
XFILLER_175_1342 VDD VSS sg13g2_decap_8
XFILLER_4_469 VDD VSS sg13g2_decap_8
XFILLER_49_1345 VDD VSS sg13g2_decap_8
XFILLER_101_1296 VDD VSS sg13g2_decap_8
XFILLER_122_813 VDD VSS sg13g2_decap_8
X_10202_ _14758_/D _15182_/D _14758_/Q _10202_/S VDD VSS sg13g2_mux2_1
XFILLER_106_364 VDD VSS sg13g2_fill_1
XFILLER_107_898 VDD VSS sg13g2_decap_8
XFILLER_133_150 VDD VSS sg13g2_fill_1
X_11182_ _11182_/Y _11181_/X _11151_/A _11179_/X _11177_/X _11193_/A2 VDD VSS sg13g2_a221oi_1
XFILLER_84_1247 VDD VSS sg13g2_decap_8
XFILLER_134_684 VDD VSS sg13g2_fill_2
XFILLER_134_695 VDD VSS sg13g2_decap_8
XFILLER_121_323 VDD VSS sg13g2_decap_8
XFILLER_136_1337 VDD VSS sg13g2_decap_8
XFILLER_171_1217 VDD VSS sg13g2_decap_8
X_14096__2106 _14096_/RESET_B VDD VSS sg13g2_tiehi
X_10133_ _14711_/D _10166_/A1 _14711_/Q _10134_/S VDD VSS sg13g2_mux2_1
XFILLER_122_868 VDD VSS sg13g2_decap_8
X_14132__2070 _14132_/RESET_B VDD VSS sg13g2_tiehi
XFILLER_94_207 VDD VSS sg13g2_decap_8
XFILLER_48_602 VDD VSS sg13g2_fill_1
XFILLER_125_72 VDD VSS sg13g2_fill_2
XFILLER_134_1050 VDD VSS sg13g2_decap_8
X_14941_ _14941_/Q _15228_/CLK _14941_/D _14941_/RESET_B VDD VSS sg13g2_dfrbpq_1
X_10064_ _14645_/D _10064_/A0 _14645_/Q _10068_/S VDD VSS sg13g2_mux2_1
XFILLER_0_686 VDD VSS sg13g2_decap_8
XFILLER_94_229 VDD VSS sg13g2_fill_2
XFILLER_134_1083 VDD VSS sg13g2_decap_8
XFILLER_75_421 VDD VSS sg13g2_decap_8
X_14736__1466 _14736_/RESET_B VDD VSS sg13g2_tiehi
X_14872_ _14872_/Q clkload83/A _14872_/D _14872_/RESET_B VDD VSS sg13g2_dfrbpq_1
XFILLER_78_1018 VDD VSS sg13g2_decap_4
XFILLER_75_465 VDD VSS sg13g2_decap_8
XFILLER_60_1280 VDD VSS sg13g2_decap_8
XFILLER_75_476 VDD VSS sg13g2_fill_2
XFILLER_21_1253 VDD VSS sg13g2_decap_8
X_13823_ _13823_/Q clkload61/A _13823_/D _13823_/RESET_B VDD VSS sg13g2_dfrbpq_1
XFILLER_95_1310 VDD VSS sg13g2_decap_8
XFILLER_169_1168 VDD VSS sg13g2_decap_8
XFILLER_18_81 VDD VSS sg13g2_decap_8
XFILLER_147_1400 VDD VSS sg13g2_fill_1
X_15207__2998 _15207_/RESET_B VDD VSS sg13g2_tiehi
XFILLER_90_435 VDD VSS sg13g2_fill_1
XFILLER_62_126 VDD VSS sg13g2_decap_8
XFILLER_44_830 VDD VSS sg13g2_fill_1
XFILLER_1_1358 VDD VSS sg13g2_decap_8
XFILLER_44_841 VDD VSS sg13g2_fill_1
XFILLER_141_82 VDD VSS sg13g2_decap_8
XFILLER_186_1471 VDD VSS sg13g2_fill_1
X_13754_ _13754_/Q clkload77/A _13754_/D _13754_/RESET_B VDD VSS sg13g2_dfrbpq_1
XFILLER_147_1433 VDD VSS sg13g2_decap_8
XFILLER_182_1313 VDD VSS sg13g2_decap_8
X_10966_ _10966_/Y _11015_/A _11015_/C _11017_/A1 VDD VSS sg13g2_a21oi_1
XFILLER_16_576 VDD VSS sg13g2_decap_8
XFILLER_91_1218 VDD VSS sg13g2_decap_8
XFILLER_16_587 VDD VSS sg13g2_fill_1
X_12705_ _12705_/X _12703_/X _12702_/X _12697_/X _12696_/X _12705_/S0 _12705_/S1 VDD
+ VSS sg13g2_mux4_1
XFILLER_44_896 VDD VSS sg13g2_decap_8
XFILLER_108_1428 VDD VSS sg13g2_fill_2
X_13685_ _13685_/Q clkload62/A _13685_/D _13685_/RESET_B VDD VSS sg13g2_dfrbpq_1
X_10897_ _10936_/A _10897_/A _10897_/B _10923_/A _10897_/D VDD VSS sg13g2_nor4_1
X_12636_ _12636_/X _12634_/X _12635_/X _12776_/S VDD VSS sg13g2_mux2_1
XFILLER_86_7 VDD VSS sg13g2_decap_8
XFILLER_157_732 VDD VSS sg13g2_decap_8
XFILLER_12_782 VDD VSS sg13g2_decap_8
XFILLER_11_270 VDD VSS sg13g2_decap_8
X_12567_ _12567_/X _12566_/X _12565_/X _12567_/S VDD VSS sg13g2_mux2_1
XFILLER_129_456 VDD VSS sg13g2_decap_8
XFILLER_8_753 VDD VSS sg13g2_decap_8
XFILLER_157_776 VDD VSS sg13g2_decap_8
XFILLER_15_1068 VDD VSS sg13g2_decap_8
X_14306_ _14306_/Q _14722_/CLK _14306_/D _14306_/RESET_B VDD VSS sg13g2_dfrbpq_1
XFILLER_89_1136 VDD VSS sg13g2_fill_1
XFILLER_117_629 VDD VSS sg13g2_fill_1
XFILLER_184_573 VDD VSS sg13g2_decap_8
X_11518_ _11518_/Y _11974_/B1 _11516_/Y _11858_/A VDD VSS sg13g2_a21oi_1
XFILLER_7_252 VDD VSS sg13g2_decap_8
X_12498_ _12499_/B _13683_/Q _12777_/A2 _12497_/X _12624_/B2 _12624_/C1 VDD VSS sg13g2_a221oi_1
XFILLER_116_128 VDD VSS sg13g2_decap_8
XFILLER_144_437 VDD VSS sg13g2_decap_8
X_14342__1860 _14342_/RESET_B VDD VSS sg13g2_tiehi
XFILLER_176_1128 VDD VSS sg13g2_decap_8
XFILLER_32_1393 VDD VSS sg13g2_decap_8
X_14237_ _14237_/Q clkload28/A _14237_/D _14237_/RESET_B VDD VSS sg13g2_dfrbpq_1
X_11449_ _11449_/X _11441_/X _11440_/X _11435_/X _11434_/X _12092_/C _11446_/A VDD
+ VSS sg13g2_mux4_1
XFILLER_67_1423 VDD VSS sg13g2_decap_8
XFILLER_153_971 VDD VSS sg13g2_decap_8
XFILLER_98_502 VDD VSS sg13g2_decap_8
XFILLER_154_1415 VDD VSS sg13g2_decap_8
X_14168_ _14168_/Q _14514_/CLK _14168_/D _14168_/RESET_B VDD VSS sg13g2_dfrbpq_1
XFILLER_140_621 VDD VSS sg13g2_decap_4
XFILLER_63_1309 VDD VSS sg13g2_decap_8
XFILLER_113_846 VDD VSS sg13g2_decap_8
XFILLER_3_480 VDD VSS sg13g2_decap_8
XFILLER_112_334 VDD VSS sg13g2_decap_8
X_13119_ _13132_/A _13170_/A _13120_/A VDD VSS sg13g2_nor2_1
XFILLER_86_708 VDD VSS sg13g2_decap_4
X_14099_ _14099_/Q _15160_/CLK _14099_/D _14099_/RESET_B VDD VSS sg13g2_dfrbpq_1
XFILLER_39_602 VDD VSS sg13g2_decap_8
XFILLER_112_378 VDD VSS sg13g2_fill_1
XFILLER_140_687 VDD VSS sg13g2_decap_4
XFILLER_6_1236 VDD VSS sg13g2_decap_8
XFILLER_117_1292 VDD VSS sg13g2_decap_4
Xfanout1270 _12237_/C _12308_/C VDD VSS sg13g2_buf_1
XFILLER_67_955 VDD VSS sg13g2_decap_4
XFILLER_26_1186 VDD VSS sg13g2_decap_8
XFILLER_113_1145 VDD VSS sg13g2_decap_8
Xfanout1281 fanout1281/X _11444_/S1 VDD VSS sg13g2_buf_1
X_08660_ _08661_/D _08678_/A _08522_/C _08341_/Y _08544_/B _08654_/Y VDD VSS sg13g2_a221oi_1
XFILLER_94_752 VDD VSS sg13g2_decap_8
XFILLER_38_134 VDD VSS sg13g2_fill_1
Xfanout1292 _11897_/C fanout1293/X VDD VSS sg13g2_buf_1
XFILLER_39_679 VDD VSS sg13g2_fill_2
XFILLER_38_156 VDD VSS sg13g2_decap_8
XFILLER_96_1118 VDD VSS sg13g2_decap_8
XFILLER_82_925 VDD VSS sg13g2_decap_8
X_08591_ _08591_/X _12084_/A _07861_/B _08591_/A2 _07812_/B _13517_/A _13521_/A VDD
+ VSS sg13g2_mux4_1
XFILLER_38_189 VDD VSS sg13g2_decap_4
X_13794__2408 _13794_/RESET_B VDD VSS sg13g2_tiehi
XFILLER_93_295 VDD VSS sg13g2_fill_1
XFILLER_81_435 VDD VSS sg13g2_decap_8
XFILLER_35_852 VDD VSS sg13g2_fill_2
X_13830__2372 _13830_/RESET_B VDD VSS sg13g2_tiehi
XFILLER_161_1408 VDD VSS sg13g2_decap_8
XFILLER_61_170 VDD VSS sg13g2_decap_8
XFILLER_14_28 VDD VSS sg13g2_decap_8
X_09212_ _13823_/D _09745_/A1 _13823_/Q _09225_/S VDD VSS sg13g2_mux2_1
XFILLER_50_866 VDD VSS sg13g2_decap_8
X_14174__2028 _14174_/RESET_B VDD VSS sg13g2_tiehi
XFILLER_148_732 VDD VSS sg13g2_decap_8
XFILLER_148_743 VDD VSS sg13g2_fill_1
X_09143_ _09143_/Y _10793_/B _07613_/Y _09157_/D _09157_/C VDD VSS sg13g2_a22oi_1
XFILLER_33_1135 VDD VSS sg13g2_decap_8
XFILLER_72_1195 VDD VSS sg13g2_decap_8
XFILLER_124_1296 VDD VSS sg13g2_decap_8
XFILLER_159_1304 VDD VSS sg13g2_decap_8
X_09074_ _09074_/Y _13088_/A _09103_/C _09074_/B1 VDD VSS sg13g2_o21ai_1
XFILLER_148_798 VDD VSS sg13g2_decap_8
XFILLER_11_1422 VDD VSS sg13g2_decap_8
XFILLER_68_1209 VDD VSS sg13g2_decap_8
XFILLER_163_746 VDD VSS sg13g2_decap_8
X_08025_ _08032_/C _08270_/B _08194_/B _08025_/C VDD VSS sg13g2_nor3_1
XFILLER_116_640 VDD VSS sg13g2_decap_4
XFILLER_1_406 VDD VSS sg13g2_decap_8
XFILLER_118_1001 VDD VSS sg13g2_fill_1
XFILLER_89_513 VDD VSS sg13g2_decap_8
XFILLER_116_695 VDD VSS sg13g2_fill_2
XFILLER_171_790 VDD VSS sg13g2_decap_8
XFILLER_115_183 VDD VSS sg13g2_fill_2
XFILLER_104_857 VDD VSS sg13g2_decap_8
XFILLER_131_654 VDD VSS sg13g2_decap_8
XFILLER_39_25 VDD VSS sg13g2_decap_8
X_09976_ _14559_/D _10142_/A1 _14559_/Q _09997_/S VDD VSS sg13g2_mux2_1
XFILLER_103_356 VDD VSS sg13g2_decap_8
XFILLER_118_1089 VDD VSS sg13g2_decap_8
XFILLER_83_1291 VDD VSS sg13g2_decap_8
XFILLER_44_1242 VDD VSS sg13g2_decap_8
X_08927_ _08927_/X _15045_/Q _14949_/Q _10767_/A VDD VSS sg13g2_mux2_1
XFILLER_69_270 VDD VSS sg13g2_decap_8
X_14205__1997 _14205_/RESET_B VDD VSS sg13g2_tiehi
X_14981__2629 _14981_/RESET_B VDD VSS sg13g2_tiehi
XFILLER_29_134 VDD VSS sg13g2_decap_8
X_08858_ _13697_/D _16859_/A _08857_/X _08861_/S VDD VSS sg13g2_mux2_1
XFILLER_57_454 VDD VSS sg13g2_fill_1
XFILLER_73_914 VDD VSS sg13g2_decap_8
XFILLER_58_988 VDD VSS sg13g2_decap_8
X_07809_ _08553_/A _15012_/Q _12009_/A VDD VSS sg13g2_xor2_1
XFILLER_57_498 VDD VSS sg13g2_decap_8
XFILLER_55_46 VDD VSS sg13g2_decap_8
X_08789_ _13681_/D _08728_/Y _08788_/Y _08787_/Y VDD VSS sg13g2_a21oi_1
X_14384__1818 _14384_/RESET_B VDD VSS sg13g2_tiehi
X_10820_ _10821_/C _10803_/Y _10805_/Y _10804_/Y VDD VSS sg13g2_o21ai_1
XFILLER_60_619 VDD VSS sg13g2_decap_8
XFILLER_38_1013 VDD VSS sg13g2_fill_2
XFILLER_129_1130 VDD VSS sg13g2_decap_8
X_14420__1782 _14420_/RESET_B VDD VSS sg13g2_tiehi
XFILLER_0_1380 VDD VSS sg13g2_decap_8
X_10751_ _14915_/D _13279_/D _11078_/B _10750_/Y VDD VSS sg13g2_o21ai_1
XFILLER_125_1005 VDD VSS sg13g2_decap_8
XFILLER_186_805 VDD VSS sg13g2_decap_8
XFILLER_80_490 VDD VSS sg13g2_decap_8
XFILLER_111_85 VDD VSS sg13g2_fill_1
XFILLER_41_855 VDD VSS sg13g2_decap_8
XFILLER_111_96 VDD VSS sg13g2_decap_8
XFILLER_13_557 VDD VSS sg13g2_decap_8
XFILLER_40_343 VDD VSS sg13g2_decap_8
XFILLER_38_1079 VDD VSS sg13g2_fill_2
XFILLER_185_315 VDD VSS sg13g2_decap_8
X_13470_ _15109_/D _15109_/Q _13470_/A2 _13469_/X VDD VSS sg13g2_a21o_1
XFILLER_71_56 VDD VSS sg13g2_decap_8
X_10682_ _14897_/D _10886_/B1 _10818_/B _10681_/Y VDD VSS sg13g2_o21ai_1
XFILLER_179_890 VDD VSS sg13g2_fill_1
XFILLER_139_732 VDD VSS sg13g2_decap_8
XFILLER_9_539 VDD VSS sg13g2_decap_8
XFILLER_16_1344 VDD VSS sg13g2_decap_8
X_12421_ _12421_/X _14240_/Q _14272_/Q _14304_/Q _14336_/Q _12698_/S0 _12698_/S1 VDD
+ VSS sg13g2_mux4_1
XFILLER_51_1235 VDD VSS sg13g2_decap_8
XFILLER_12_1208 VDD VSS sg13g2_decap_8
XFILLER_126_404 VDD VSS sg13g2_decap_8
X_15140_ _15140_/Q clkload33/A _15140_/D _15140_/RESET_B VDD VSS sg13g2_dfrbpq_1
XFILLER_139_798 VDD VSS sg13g2_decap_8
X_12352_ _12352_/X _14235_/Q _14267_/Q _14299_/Q _14331_/Q _12352_/S0 _12352_/S1 VDD
+ VSS sg13g2_mux4_1
XFILLER_103_1358 VDD VSS sg13g2_fill_1
XFILLER_177_1415 VDD VSS sg13g2_decap_8
XFILLER_112_0 VDD VSS sg13g2_decap_8
XFILLER_153_223 VDD VSS sg13g2_fill_1
X_11303_ _11303_/Y _11328_/S0 _14589_/Q _11328_/S1 VDD VSS sg13g2_a21oi_1
X_15071_ _15071_/Q _15212_/CLK _15071_/D _15071_/RESET_B VDD VSS sg13g2_dfrbpq_1
X_12283_ _12283_/X _13849_/Q _13881_/Q _13913_/Q _13945_/Q _12286_/S0 _12283_/S1 VDD
+ VSS sg13g2_mux4_1
XFILLER_5_756 VDD VSS sg13g2_decap_8
XFILLER_153_256 VDD VSS sg13g2_decap_4
XFILLER_135_982 VDD VSS sg13g2_decap_8
X_14022_ _14022_/Q clkload50/A _14022_/D _14022_/RESET_B VDD VSS sg13g2_dfrbpq_1
XFILLER_101_1093 VDD VSS sg13g2_decap_8
X_11234_ _11425_/B _11232_/Y _11233_/Y _15217_/Q VDD VSS sg13g2_a21oi_1
XFILLER_4_266 VDD VSS sg13g2_decap_8
XFILLER_122_621 VDD VSS sg13g2_decap_8
XFILLER_171_1014 VDD VSS sg13g2_decap_8
X_11165_ _11165_/X _11191_/A _11181_/B VDD VSS sg13g2_or2_1
XFILLER_45_1039 VDD VSS sg13g2_decap_8
XFILLER_136_93 VDD VSS sg13g2_decap_8
XFILLER_110_816 VDD VSS sg13g2_decap_8
XFILLER_62_1320 VDD VSS sg13g2_decap_8
XFILLER_1_973 VDD VSS sg13g2_decap_8
X_10116_ _14694_/D _10149_/A1 _14694_/Q _10130_/S VDD VSS sg13g2_mux2_1
XFILLER_49_922 VDD VSS sg13g2_decap_8
XFILLER_23_1304 VDD VSS sg13g2_decap_8
X_11096_ _11096_/Y _11097_/A _11097_/C _11115_/A VDD VSS sg13g2_o21ai_1
XFILLER_95_538 VDD VSS sg13g2_fill_1
XFILLER_0_483 VDD VSS sg13g2_decap_8
XFILLER_96_97 VDD VSS sg13g2_fill_2
XFILLER_48_421 VDD VSS sg13g2_fill_2
XFILLER_49_955 VDD VSS sg13g2_decap_8
X_14924_ _14924_/Q _15052_/CLK _14924_/D _14924_/RESET_B VDD VSS sg13g2_dfrbpq_1
X_10047_ _14628_/D _10147_/A1 _14628_/Q _10063_/S VDD VSS sg13g2_mux2_1
XFILLER_114_1465 VDD VSS sg13g2_decap_8
XFILLER_62_1397 VDD VSS sg13g2_decap_8
X_14957__2653 _14957_/RESET_B VDD VSS sg13g2_tiehi
XFILLER_48_465 VDD VSS sg13g2_decap_8
XFILLER_64_925 VDD VSS sg13g2_decap_8
X_14855_ _14855_/Q clkload83/A _14855_/D _14855_/RESET_B VDD VSS sg13g2_dfrbpq_1
XFILLER_97_1449 VDD VSS sg13g2_decap_8
XFILLER_184_1408 VDD VSS sg13g2_decap_8
XFILLER_36_649 VDD VSS sg13g2_decap_8
XFILLER_21_1061 VDD VSS sg13g2_decap_8
XFILLER_17_841 VDD VSS sg13g2_decap_8
X_13806_ _13806_/Q _14670_/CLK _13806_/D _13806_/RESET_B VDD VSS sg13g2_dfrbpq_1
XFILLER_1_1155 VDD VSS sg13g2_decap_8
XFILLER_91_777 VDD VSS sg13g2_decap_8
XFILLER_35_159 VDD VSS sg13g2_decap_8
X_14786_ _14786_/Q clkload89/A _14786_/D _14786_/RESET_B VDD VSS sg13g2_dfrbpq_1
XFILLER_51_619 VDD VSS sg13g2_decap_8
XFILLER_182_1110 VDD VSS sg13g2_decap_8
X_11998_ _11998_/X _11994_/X _11995_/X _11993_/X _11992_/X _12237_/C _11999_/S1 VDD
+ VSS sg13g2_mux4_1
XFILLER_95_1162 VDD VSS sg13g2_decap_8
XFILLER_50_107 VDD VSS sg13g2_decap_8
XFILLER_44_671 VDD VSS sg13g2_decap_8
X_13737_ _13737_/Q _14665_/CLK _13737_/D _13737_/RESET_B VDD VSS sg13g2_dfrbpq_1
XFILLER_108_1214 VDD VSS sg13g2_decap_8
X_10949_ _10949_/Y _10893_/X _11005_/A _11007_/B VDD VSS sg13g2_o21ai_1
XFILLER_91_1026 VDD VSS sg13g2_fill_2
XFILLER_16_395 VDD VSS sg13g2_fill_1
XFILLER_56_1157 VDD VSS sg13g2_decap_8
XFILLER_149_507 VDD VSS sg13g2_decap_8
XFILLER_17_1119 VDD VSS sg13g2_decap_8
XFILLER_91_1048 VDD VSS sg13g2_fill_2
XFILLER_149_518 VDD VSS sg13g2_fill_1
XFILLER_177_849 VDD VSS sg13g2_decap_8
XFILLER_182_1187 VDD VSS sg13g2_decap_8
X_13668_ _13668_/Q clkload72/A _13668_/D _13668_/RESET_B VDD VSS sg13g2_dfrbpq_1
XFILLER_34_1411 VDD VSS sg13g2_decap_8
XFILLER_108_1269 VDD VSS sg13g2_decap_8
XFILLER_160_1430 VDD VSS sg13g2_decap_8
XFILLER_176_337 VDD VSS sg13g2_decap_8
X_15232__3023 _15232_/RESET_B VDD VSS sg13g2_tiehi
XFILLER_32_899 VDD VSS sg13g2_decap_4
X_12619_ _12619_/X _13838_/Q _13870_/Q _13902_/Q _13934_/Q _12620_/S0 _12620_/S1 VDD
+ VSS sg13g2_mux4_1
XFILLER_31_398 VDD VSS sg13g2_decap_4
XFILLER_118_905 VDD VSS sg13g2_decap_8
X_13599_ _13599_/Y _13600_/A _10173_/B _15165_/Q VDD VSS sg13g2_a21oi_1
XFILLER_157_562 VDD VSS sg13g2_decap_8
XFILLER_185_871 VDD VSS sg13g2_decap_8
XFILLER_8_550 VDD VSS sg13g2_decap_8
XFILLER_118_938 VDD VSS sg13g2_decap_4
XFILLER_117_415 VDD VSS sg13g2_decap_8
XFILLER_129_286 VDD VSS sg13g2_decap_8
XFILLER_121_1469 VDD VSS sg13g2_fill_1
XFILLER_129_297 VDD VSS sg13g2_fill_2
XFILLER_133_908 VDD VSS sg13g2_decap_8
XFILLER_144_234 VDD VSS sg13g2_fill_2
XFILLER_32_1190 VDD VSS sg13g2_decap_8
XFILLER_133_919 VDD VSS sg13g2_fill_2
XFILLER_160_705 VDD VSS sg13g2_decap_8
XFILLER_160_716 VDD VSS sg13g2_fill_2
XFILLER_67_1220 VDD VSS sg13g2_decap_8
XFILLER_119_1310 VDD VSS sg13g2_fill_2
XFILLER_99_833 VDD VSS sg13g2_decap_8
XFILLER_6_95 VDD VSS sg13g2_decap_8
XFILLER_98_321 VDD VSS sg13g2_decap_8
XFILLER_119_1343 VDD VSS sg13g2_decap_8
XFILLER_63_1106 VDD VSS sg13g2_fill_1
Xfanout507 _08685_/A1 _08424_/A1 VDD VSS sg13g2_buf_1
X_09830_ _14418_/D _09830_/A0 _14418_/Q _09837_/S VDD VSS sg13g2_mux2_1
X_13848__2354 _13848_/RESET_B VDD VSS sg13g2_tiehi
Xfanout518 _13480_/S _07989_/Y VDD VSS sg13g2_buf_1
XFILLER_67_1297 VDD VSS sg13g2_decap_8
XFILLER_63_1128 VDD VSS sg13g2_decap_8
XFILLER_115_1207 VDD VSS sg13g2_decap_8
Xfanout529 _12841_/B _12798_/Y VDD VSS sg13g2_buf_1
XFILLER_28_1259 VDD VSS sg13g2_decap_8
XFILLER_140_451 VDD VSS sg13g2_decap_8
XFILLER_154_1267 VDD VSS sg13g2_decap_4
X_09761_ _14351_/D _14351_/Q _10158_/A1 _09771_/S VDD VSS sg13g2_mux2_1
XFILLER_98_398 VDD VSS sg13g2_decap_8
XFILLER_86_538 VDD VSS sg13g2_fill_1
XFILLER_140_495 VDD VSS sg13g2_fill_1
XFILLER_41_1404 VDD VSS sg13g2_decap_8
XFILLER_67_730 VDD VSS sg13g2_fill_2
XFILLER_39_421 VDD VSS sg13g2_fill_2
XFILLER_6_1033 VDD VSS sg13g2_decap_8
X_08712_ _13661_/D _15188_/D _14760_/Q _13648_/S VDD VSS sg13g2_mux2_1
XFILLER_80_1475 VDD VSS sg13g2_decap_4
XFILLER_100_359 VDD VSS sg13g2_decap_8
X_09692_ _14284_/D _09923_/A1 _14284_/Q _09692_/S VDD VSS sg13g2_mux2_1
XFILLER_82_700 VDD VSS sg13g2_decap_4
XFILLER_55_914 VDD VSS sg13g2_decap_8
X_08643_ _08646_/B _08643_/A _08646_/A _08643_/C _08643_/D VDD VSS sg13g2_nand4_1
XFILLER_81_210 VDD VSS sg13g2_decap_8
XFILLER_148_1005 VDD VSS sg13g2_decap_8
XFILLER_27_649 VDD VSS sg13g2_decap_4
XFILLER_26_126 VDD VSS sg13g2_decap_8
XFILLER_54_446 VDD VSS sg13g2_decap_8
XFILLER_81_243 VDD VSS sg13g2_decap_8
X_08574_ _08575_/B _08574_/A _08574_/B _08574_/C _08574_/D VDD VSS sg13g2_nand4_1
XFILLER_26_159 VDD VSS sg13g2_fill_1
XFILLER_39_1322 VDD VSS sg13g2_decap_8
XFILLER_70_939 VDD VSS sg13g2_decap_8
XFILLER_161_1205 VDD VSS sg13g2_decap_8
XFILLER_168_816 VDD VSS sg13g2_fill_1
XFILLER_23_855 VDD VSS sg13g2_decap_8
XFILLER_165_1385 VDD VSS sg13g2_decap_8
XFILLER_74_1268 VDD VSS sg13g2_decap_8
XFILLER_35_1219 VDD VSS sg13g2_decap_8
XFILLER_39_1399 VDD VSS sg13g2_decap_8
XFILLER_167_326 VDD VSS sg13g2_decap_8
XFILLER_179_186 VDD VSS sg13g2_decap_8
XFILLER_37_1090 VDD VSS sg13g2_decap_8
XFILLER_183_819 VDD VSS sg13g2_decap_8
XFILLER_41_37 VDD VSS sg13g2_fill_1
XFILLER_176_860 VDD VSS sg13g2_fill_1
XFILLER_124_1082 VDD VSS sg13g2_fill_1
X_09126_ _09126_/Y _09151_/A _10767_/B _09125_/X VDD VSS sg13g2_o21ai_1
XFILLER_108_415 VDD VSS sg13g2_fill_2
XFILLER_136_735 VDD VSS sg13g2_decap_8
XFILLER_135_212 VDD VSS sg13g2_decap_8
XFILLER_159_1112 VDD VSS sg13g2_fill_1
X_09057_ _09057_/X _09069_/A _09057_/B _09089_/C VDD VSS sg13g2_or3_1
XFILLER_136_779 VDD VSS sg13g2_decap_8
XFILLER_151_705 VDD VSS sg13g2_decap_8
XFILLER_68_1039 VDD VSS sg13g2_decap_8
XFILLER_117_971 VDD VSS sg13g2_decap_8
X_15206__2997 _15206_/RESET_B VDD VSS sg13g2_tiehi
XFILLER_159_1178 VDD VSS sg13g2_decap_8
XFILLER_163_587 VDD VSS sg13g2_decap_8
X_08008_ _08008_/Y _08241_/A _08008_/B VDD VSS sg13g2_nor2_1
XFILLER_11_1296 VDD VSS sg13g2_decap_8
XFILLER_151_749 VDD VSS sg13g2_decap_8
XFILLER_173_14 VDD VSS sg13g2_decap_8
XFILLER_1_203 VDD VSS sg13g2_decap_8
XFILLER_172_1312 VDD VSS sg13g2_decap_8
XFILLER_46_1337 VDD VSS sg13g2_decap_8
XFILLER_85_1397 VDD VSS sg13g2_decap_8
X_14438__1764 _14438_/RESET_B VDD VSS sg13g2_tiehi
XFILLER_104_687 VDD VSS sg13g2_decap_8
XFILLER_104_698 VDD VSS sg13g2_decap_4
XFILLER_103_175 VDD VSS sg13g2_fill_2
XFILLER_172_1389 VDD VSS sg13g2_decap_8
X_09959_ _14543_/D _14543_/Q _10125_/A0 _09969_/S VDD VSS sg13g2_mux2_1
XFILLER_49_229 VDD VSS sg13g2_decap_8
XFILLER_44_1050 VDD VSS sg13g2_fill_2
XFILLER_131_1031 VDD VSS sg13g2_decap_8
X_12970_ _12970_/Y _12969_/Y _13004_/A2 _12966_/Y VDD VSS sg13g2_a21oi_1
XFILLER_73_700 VDD VSS sg13g2_decap_8
XFILLER_100_882 VDD VSS sg13g2_decap_8
X_11921_ _11921_/X _14703_/Q _14735_/Q _13775_/Q _13807_/Q _12072_/S0 _12072_/S1 VDD
+ VSS sg13g2_mux4_1
XFILLER_79_1124 VDD VSS sg13g2_fill_1
XFILLER_57_284 VDD VSS sg13g2_decap_8
XFILLER_17_126 VDD VSS sg13g2_decap_8
XFILLER_18_649 VDD VSS sg13g2_decap_8
XFILLER_57_295 VDD VSS sg13g2_fill_2
XFILLER_22_1370 VDD VSS sg13g2_decap_8
XFILLER_2_1442 VDD VSS sg13g2_decap_8
XFILLER_73_755 VDD VSS sg13g2_decap_4
X_14640_ _14640_/Q clkload14/A _14640_/D _14640_/RESET_B VDD VSS sg13g2_dfrbpq_1
XFILLER_82_11 VDD VSS sg13g2_fill_2
X_11852_ _11852_/X _13965_/Q _13997_/Q _14029_/Q _14061_/Q _11963_/S0 _11963_/S1 VDD
+ VSS sg13g2_mux4_1
XFILLER_61_917 VDD VSS sg13g2_decap_8
XFILLER_72_265 VDD VSS sg13g2_decap_8
XFILLER_57_1422 VDD VSS sg13g2_decap_8
X_10803_ _10803_/Y _10675_/A _08971_/X _10802_/Y VDD VSS sg13g2_o21ai_1
XFILLER_26_682 VDD VSS sg13g2_decap_4
X_14571_ _14571_/Q clkload13/A _14571_/D _14571_/RESET_B VDD VSS sg13g2_dfrbpq_1
XFILLER_18_1406 VDD VSS sg13g2_decap_8
X_11783_ _11783_/X _14571_/Q _14603_/Q _14635_/Q _14667_/Q _11786_/S0 _11786_/S1 VDD
+ VSS sg13g2_mux4_1
XFILLER_183_1463 VDD VSS sg13g2_decap_8
XFILLER_183_1474 VDD VSS sg13g2_fill_1
XFILLER_186_602 VDD VSS sg13g2_decap_8
X_13522_ _13522_/Y _13521_/A _13563_/C _14998_/Q _13546_/B2 VDD VSS sg13g2_a22oi_1
XFILLER_13_354 VDD VSS sg13g2_decap_8
XFILLER_159_838 VDD VSS sg13g2_decap_8
X_10734_ _14911_/D _10734_/A VDD VSS sg13g2_inv_1
XFILLER_185_112 VDD VSS sg13g2_decap_8
XFILLER_9_336 VDD VSS sg13g2_decap_8
XFILLER_16_1141 VDD VSS sg13g2_decap_8
X_13453_ _13454_/D _15186_/Q _15187_/Q _15188_/Q _15171_/Q VDD VSS sg13g2_nor4_1
X_13926__2276 _13926_/RESET_B VDD VSS sg13g2_tiehi
XFILLER_186_679 VDD VSS sg13g2_decap_8
X_10665_ _10667_/B _14893_/Q _10661_/C hold3163/X VDD VSS sg13g2_a21oi_1
XFILLER_12_1005 VDD VSS sg13g2_decap_8
XFILLER_142_1171 VDD VSS sg13g2_decap_8
X_12404_ _12404_/X _14111_/Q _14143_/Q _14175_/Q _14207_/Q _12506_/S0 _12506_/S1 VDD
+ VSS sg13g2_mux4_1
XFILLER_51_1054 VDD VSS sg13g2_decap_8
XFILLER_142_1182 VDD VSS sg13g2_fill_1
XFILLER_185_189 VDD VSS sg13g2_decap_8
X_13384_ _13384_/Y _13446_/A1 _08723_/B _15081_/Q VDD VSS sg13g2_o21ai_1
X_10596_ _10599_/B _14875_/Q _10607_/C _14876_/Q VDD VSS sg13g2_a21oi_1
XFILLER_177_1212 VDD VSS sg13g2_decap_8
XFILLER_63_9 VDD VSS sg13g2_fill_1
X_15123_ _15123_/Q _15214_/CLK _15123_/D _15123_/RESET_B VDD VSS sg13g2_dfrbpq_1
X_12335_ _12335_/Y _12315_/Y _12317_/X _12192_/A VDD VSS sg13g2_o21ai_1
XFILLER_31_70 VDD VSS sg13g2_decap_8
XFILLER_103_1188 VDD VSS sg13g2_decap_8
XFILLER_127_779 VDD VSS sg13g2_decap_8
XFILLER_142_705 VDD VSS sg13g2_decap_8
XFILLER_86_1139 VDD VSS sg13g2_decap_8
XFILLER_5_553 VDD VSS sg13g2_decap_8
XFILLER_99_107 VDD VSS sg13g2_decap_8
X_15054_ _15054_/Q clkload73/A _15054_/D _15054_/RESET_B VDD VSS sg13g2_dfrbpq_1
XFILLER_142_749 VDD VSS sg13g2_decap_8
XFILLER_177_1289 VDD VSS sg13g2_decap_8
X_12266_ _12266_/Y _12264_/Y _12265_/Y _12223_/A VDD VSS sg13g2_a21oi_1
XFILLER_49_7 VDD VSS sg13g2_decap_8
X_14005_ _14005_/Q _14677_/CLK _14005_/D _14005_/RESET_B VDD VSS sg13g2_dfrbpq_1
X_11217_ _11217_/X _14555_/Q _14587_/Q _11218_/S VDD VSS sg13g2_mux2_1
XFILLER_122_440 VDD VSS sg13g2_decap_4
Xoutput70 mem_axi_arvalid _07659_/Y VDD VSS sg13g2_buf_1
X_12197_ _12197_/Y _12197_/A _12197_/B _12198_/B _12198_/D VDD VSS sg13g2_nor4_1
XFILLER_96_814 VDD VSS sg13g2_decap_8
XFILLER_110_613 VDD VSS sg13g2_fill_1
Xoutput81 mem_axi_awaddr[20] _16873_/X VDD VSS sg13g2_buf_1
XFILLER_1_770 VDD VSS sg13g2_decap_8
Xoutput92 mem_axi_awaddr[30] _16883_/X VDD VSS sg13g2_buf_1
XFILLER_151_1429 VDD VSS sg13g2_decap_4
X_11148_ _11150_/A _11171_/B _11147_/Y _11173_/B _11128_/A VDD VSS sg13g2_a22oi_1
XFILLER_0_280 VDD VSS sg13g2_decap_8
XFILLER_95_346 VDD VSS sg13g2_decap_4
XFILLER_163_91 VDD VSS sg13g2_decap_8
XFILLER_27_1292 VDD VSS sg13g2_decap_8
XFILLER_83_508 VDD VSS sg13g2_decap_8
XFILLER_114_1251 VDD VSS sg13g2_decap_4
X_11079_ _11079_/Y _11097_/A _11097_/C VDD VSS sg13g2_xnor2_1
XFILLER_95_379 VDD VSS sg13g2_decap_8
XFILLER_97_1202 VDD VSS sg13g2_decap_8
XFILLER_7_1386 VDD VSS sg13g2_decap_8
XFILLER_62_1194 VDD VSS sg13g2_decap_8
XFILLER_48_273 VDD VSS sg13g2_decap_8
XFILLER_23_1178 VDD VSS sg13g2_decap_8
X_14907_ _14907_/Q clkload55/A _14907_/D _14907_/RESET_B VDD VSS sg13g2_dfrbpq_1
XFILLER_64_733 VDD VSS sg13g2_decap_4
XFILLER_36_424 VDD VSS sg13g2_decap_8
XFILLER_184_1205 VDD VSS sg13g2_decap_8
XFILLER_91_541 VDD VSS sg13g2_decap_4
XFILLER_63_232 VDD VSS sg13g2_decap_8
XFILLER_149_1336 VDD VSS sg13g2_decap_8
XFILLER_36_468 VDD VSS sg13g2_decap_8
X_14838_ _14838_/Q _14848_/CLK _14838_/D _14838_/RESET_B VDD VSS sg13g2_dfrbpq_1
XFILLER_91_563 VDD VSS sg13g2_fill_1
XFILLER_149_1358 VDD VSS sg13g2_decap_8
XFILLER_64_799 VDD VSS sg13g2_decap_8
X_14769_ _14769_/Q clkload66/A _14769_/D _14769_/RESET_B VDD VSS sg13g2_dfrbpq_1
XFILLER_147_1082 VDD VSS sg13g2_decap_4
X_08290_ _08290_/X _08286_/Y _08289_/Y _08422_/S VDD VSS sg13g2_mux2_1
XFILLER_31_140 VDD VSS sg13g2_decap_8
XFILLER_176_112 VDD VSS sg13g2_decap_8
XFILLER_31_151 VDD VSS sg13g2_decap_8
XFILLER_32_685 VDD VSS sg13g2_fill_2
XFILLER_108_1077 VDD VSS sg13g2_decap_4
XFILLER_73_1290 VDD VSS sg13g2_decap_8
X_14516__1686 _14516_/RESET_B VDD VSS sg13g2_tiehi
XFILLER_158_871 VDD VSS sg13g2_decap_8
XFILLER_75_0 VDD VSS sg13g2_decap_8
XFILLER_178_1009 VDD VSS sg13g2_decap_8
X_14091__2111 _14091_/RESET_B VDD VSS sg13g2_tiehi
XFILLER_34_1285 VDD VSS sg13g2_decap_8
XFILLER_69_1304 VDD VSS sg13g2_decap_8
XFILLER_11_18 VDD VSS sg13g2_decap_8
XFILLER_173_852 VDD VSS sg13g2_decap_8
XFILLER_121_1288 VDD VSS sg13g2_decap_8
XFILLER_121_1299 VDD VSS sg13g2_fill_2
X_14695__1507 _14695_/RESET_B VDD VSS sg13g2_tiehi
XFILLER_156_1329 VDD VSS sg13g2_decap_8
XFILLER_172_384 VDD VSS sg13g2_decap_8
Xclkbuf_leaf_114_clk_i clkload23/A clkbuf_5_6__f_clk_i/X VDD VSS sg13g2_buf_8
X_14731__1471 _14731_/RESET_B VDD VSS sg13g2_tiehi
XFILLER_114_941 VDD VSS sg13g2_fill_2
XFILLER_67_1061 VDD VSS sg13g2_decap_8
XFILLER_28_1012 VDD VSS sg13g2_decap_8
XFILLER_132_248 VDD VSS sg13g2_decap_8
XFILLER_87_803 VDD VSS sg13g2_fill_1
Xfanout304 _11024_/B _11052_/A VDD VSS sg13g2_buf_1
XFILLER_154_1042 VDD VSS sg13g2_fill_1
Xfanout315 _10101_/S fanout317/X VDD VSS sg13g2_buf_1
XFILLER_8_1117 VDD VSS sg13g2_decap_8
Xfanout326 _09921_/S _09925_/S VDD VSS sg13g2_buf_1
XFILLER_86_302 VDD VSS sg13g2_decap_8
Xfanout337 _09766_/S _09758_/S VDD VSS sg13g2_buf_1
X_09813_ _14401_/D _09912_/A1 _14401_/Q _09828_/S VDD VSS sg13g2_mux2_1
XFILLER_28_1067 VDD VSS sg13g2_decap_8
Xfanout348 _09696_/S _09692_/S VDD VSS sg13g2_buf_1
XFILLER_115_1037 VDD VSS sg13g2_decap_8
Xfanout359 _09493_/S _09500_/S VDD VSS sg13g2_buf_1
XFILLER_41_1201 VDD VSS sg13g2_decap_8
XFILLER_115_1059 VDD VSS sg13g2_fill_1
Xclkbuf_leaf_129_clk_i _14723_/CLK clkload0/A VDD VSS sg13g2_buf_8
X_09744_ _14334_/D _14334_/Q _09744_/A1 _09758_/S VDD VSS sg13g2_mux2_1
XFILLER_100_156 VDD VSS sg13g2_decap_8
XFILLER_101_679 VDD VSS sg13g2_decap_8
XFILLER_100_178 VDD VSS sg13g2_decap_8
XFILLER_39_273 VDD VSS sg13g2_decap_8
X_09675_ _14267_/D _10071_/A0 _14267_/Q _09706_/S VDD VSS sg13g2_mux2_1
XFILLER_41_1278 VDD VSS sg13g2_decap_8
X_08626_ _08633_/B _08652_/B1 _08616_/Y _08625_/Y VDD VSS sg13g2_a21oi_1
XFILLER_36_59 VDD VSS sg13g2_fill_1
XFILLER_167_1458 VDD VSS sg13g2_decap_8
XFILLER_167_1469 VDD VSS sg13g2_fill_1
XFILLER_70_736 VDD VSS sg13g2_decap_8
X_08557_ _08557_/Y _08625_/A _08237_/Y _08397_/Y VDD VSS sg13g2_o21ai_1
XFILLER_74_1021 VDD VSS sg13g2_decap_8
XFILLER_54_298 VDD VSS sg13g2_decap_8
XFILLER_51_950 VDD VSS sg13g2_fill_1
XFILLER_168_613 VDD VSS sg13g2_decap_8
XFILLER_165_1182 VDD VSS sg13g2_decap_8
XFILLER_168_14 VDD VSS sg13g2_decap_8
X_08488_ _08488_/Y _08511_/S _08488_/B VDD VSS sg13g2_nand2_1
XFILLER_39_1196 VDD VSS sg13g2_decap_8
XFILLER_11_825 VDD VSS sg13g2_decap_8
XFILLER_168_646 VDD VSS sg13g2_decap_8
XFILLER_22_151 VDD VSS sg13g2_fill_2
X_14941__2685 _14941_/RESET_B VDD VSS sg13g2_tiehi
XFILLER_167_123 VDD VSS sg13g2_decap_8
XFILLER_50_471 VDD VSS sg13g2_fill_2
XFILLER_22_195 VDD VSS sg13g2_fill_1
XFILLER_109_713 VDD VSS sg13g2_decap_8
XFILLER_10_357 VDD VSS sg13g2_decap_8
X_10450_ _14839_/D _10487_/A _10450_/B _10450_/C VDD VSS sg13g2_nor3_1
XFILLER_182_137 VDD VSS sg13g2_decap_8
XFILLER_52_1396 VDD VSS sg13g2_decap_8
XFILLER_109_757 VDD VSS sg13g2_decap_4
XFILLER_13_1369 VDD VSS sg13g2_decap_8
X_09109_ _09109_/Y _13156_/A _09150_/B _09151_/A VDD VSS sg13g2_o21ai_1
XFILLER_87_1426 VDD VSS sg13g2_decap_8
X_10381_ _10381_/Y _14818_/Q _10379_/A _10630_/C VDD VSS sg13g2_o21ai_1
XFILLER_151_502 VDD VSS sg13g2_decap_8
X_12120_ _12120_/Y _12115_/X _11717_/A _12118_/C VDD VSS sg13g2_a21oi_1
XFILLER_151_535 VDD VSS sg13g2_decap_8
XFILLER_11_1093 VDD VSS sg13g2_decap_8
XFILLER_184_79 VDD VSS sg13g2_decap_8
XFILLER_123_237 VDD VSS sg13g2_decap_8
XFILLER_105_952 VDD VSS sg13g2_fill_1
XFILLER_105_963 VDD VSS sg13g2_fill_1
XFILLER_117_62 VDD VSS sg13g2_decap_8
X_12051_ _12051_/Y _12156_/A _12050_/Y _12298_/B VDD VSS sg13g2_o21ai_1
XFILLER_85_1183 VDD VSS sg13g2_decap_8
XFILLER_77_11 VDD VSS sg13g2_decap_8
XFILLER_132_760 VDD VSS sg13g2_decap_8
XFILLER_78_814 VDD VSS sg13g2_decap_8
XFILLER_2_567 VDD VSS sg13g2_decap_8
XFILLER_120_911 VDD VSS sg13g2_fill_2
XFILLER_104_473 VDD VSS sg13g2_fill_1
XFILLER_105_996 VDD VSS sg13g2_decap_8
XFILLER_133_1104 VDD VSS sg13g2_decap_4
X_11002_ _11022_/A _11042_/D _15117_/Q VDD VSS sg13g2_nand2_1
X_14815__2921 _14815_/RESET_B VDD VSS sg13g2_tiehi
XFILLER_24_1410 VDD VSS sg13g2_decap_8
XFILLER_131_292 VDD VSS sg13g2_decap_8
XFILLER_172_1186 VDD VSS sg13g2_decap_8
Xfanout860 _12717_/S1 fanout867/X VDD VSS sg13g2_buf_1
XFILLER_63_1470 VDD VSS sg13g2_decap_8
X_15231__3022 _15231_/RESET_B VDD VSS sg13g2_tiehi
Xfanout871 _12647_/S0 fanout877/X VDD VSS sg13g2_buf_1
XFILLER_150_1440 VDD VSS sg13g2_decap_8
Xfanout882 _12701_/S0 _12425_/S0 VDD VSS sg13g2_buf_1
XFILLER_77_368 VDD VSS sg13g2_decap_8
XFILLER_111_1402 VDD VSS sg13g2_decap_8
Xfanout893 _12592_/S0 fanout894/X VDD VSS sg13g2_buf_1
XFILLER_133_61 VDD VSS sg13g2_decap_4
XFILLER_19_936 VDD VSS sg13g2_decap_8
X_12953_ _12953_/Y _12951_/Y _12952_/Y _12933_/Y VDD VSS sg13g2_o21ai_1
XFILLER_93_21 VDD VSS sg13g2_decap_8
XFILLER_92_349 VDD VSS sg13g2_decap_8
XFILLER_73_530 VDD VSS sg13g2_decap_8
XFILLER_73_541 VDD VSS sg13g2_fill_1
Xclkbuf_leaf_93_clk_i _14495_/CLK clkbuf_leaf_94_clk_i/A VDD VSS sg13g2_buf_8
X_11904_ _11904_/X _14913_/Q _11433_/B _11903_/Y VDD VSS sg13g2_a21o_1
XFILLER_94_1419 VDD VSS sg13g2_decap_8
XFILLER_45_254 VDD VSS sg13g2_decap_8
X_12884_ _12884_/Y _12900_/B input17/X _12900_/C VDD VSS sg13g2_nand3_1
X_14623_ _14623_/Q _14655_/CLK _14623_/D _14623_/RESET_B VDD VSS sg13g2_dfrbpq_1
X_11835_ _11835_/Y _11833_/Y _11834_/Y _11903_/C1 VDD VSS sg13g2_a21oi_1
XFILLER_26_70 VDD VSS sg13g2_decap_8
XFILLER_18_1203 VDD VSS sg13g2_decap_8
XFILLER_183_1260 VDD VSS sg13g2_decap_8
XFILLER_144_1222 VDD VSS sg13g2_decap_8
XFILLER_148_1391 VDD VSS sg13g2_decap_4
X_14554_ _14554_/Q clkload77/A _14554_/D _14554_/RESET_B VDD VSS sg13g2_dfrbpq_1
X_11766_ _11766_/Y _11765_/Y _11755_/Y _11747_/Y _11737_/Y _11903_/C1 VDD VSS sg13g2_a221oi_1
XFILLER_13_151 VDD VSS sg13g2_decap_8
XFILLER_92_1176 VDD VSS sg13g2_fill_2
XFILLER_57_1296 VDD VSS sg13g2_decap_8
XFILLER_41_460 VDD VSS sg13g2_decap_8
XFILLER_105_1217 VDD VSS sg13g2_decap_8
XFILLER_159_657 VDD VSS sg13g2_decap_8
X_13505_ _15130_/D _15130_/Q _13648_/S _13504_/Y VDD VSS sg13g2_a21o_1
XFILLER_159_668 VDD VSS sg13g2_fill_1
X_10717_ _10965_/A _14938_/Q _10725_/A _10716_/Y VDD VSS sg13g2_a21oi_1
X_14485_ _14485_/Q clkload42/A _14485_/D _14485_/RESET_B VDD VSS sg13g2_dfrbpq_1
XFILLER_9_133 VDD VSS sg13g2_decap_8
X_11697_ _11698_/A _11694_/Y _11696_/Y _11957_/A VDD VSS sg13g2_a21oi_1
XFILLER_70_1441 VDD VSS sg13g2_decap_8
XFILLER_186_476 VDD VSS sg13g2_decap_8
X_13436_ _15100_/D _15100_/Q _13470_/A2 _13435_/Y VDD VSS sg13g2_a21o_1
X_10648_ _10653_/C _14884_/Q _14883_/Q _14880_/Q _14879_/Q VDD VSS sg13g2_and4_1
XFILLER_127_521 VDD VSS sg13g2_decap_8
XFILLER_173_126 VDD VSS sg13g2_decap_8
XFILLER_127_532 VDD VSS sg13g2_fill_2
XFILLER_31_1447 VDD VSS sg13g2_decap_8
XFILLER_177_1020 VDD VSS sg13g2_fill_2
Xclkbuf_leaf_31_clk_i clkload36/A clkbuf_leaf_34_clk_i/A VDD VSS sg13g2_buf_8
X_13367_ _13367_/Y _13438_/B _13438_/D VDD VSS sg13g2_nand2_1
XFILLER_6_851 VDD VSS sg13g2_decap_8
XFILLER_154_351 VDD VSS sg13g2_decap_8
X_10579_ _10580_/A _14871_/Q _10579_/B _10579_/C _10583_/D VDD VSS sg13g2_and4_1
XFILLER_115_716 VDD VSS sg13g2_decap_8
X_15106_ _15106_/Q _15203_/CLK _15106_/D _15106_/RESET_B VDD VSS sg13g2_dfrbpq_1
XFILLER_5_350 VDD VSS sg13g2_decap_8
X_12318_ _12318_/Y _12330_/S0 _14394_/Q VDD VSS sg13g2_nand2b_1
XFILLER_138_1026 VDD VSS sg13g2_decap_8
XFILLER_177_1075 VDD VSS sg13g2_fill_2
X_13298_ _13298_/X _13506_/A _13298_/B VDD VSS sg13g2_and2_1
XFILLER_142_546 VDD VSS sg13g2_fill_1
XFILLER_177_1086 VDD VSS sg13g2_decap_8
XFILLER_29_1310 VDD VSS sg13g2_decap_8
XFILLER_68_1370 VDD VSS sg13g2_decap_8
XFILLER_47_4 VDD VSS sg13g2_decap_8
X_15037_ _15037_/Q clkload57/A _15037_/D _15037_/RESET_B VDD VSS sg13g2_dfrbpq_1
XFILLER_155_1340 VDD VSS sg13g2_decap_8
X_12249_ _12249_/Y _12259_/S0 _14488_/Q VDD VSS sg13g2_nand2b_1
XFILLER_123_760 VDD VSS sg13g2_fill_2
XFILLER_111_922 VDD VSS sg13g2_decap_8
XFILLER_9_1437 VDD VSS sg13g2_decap_8
Xclkbuf_leaf_46_clk_i clkload46/A clkbuf_leaf_48_clk_i/A VDD VSS sg13g2_buf_8
XFILLER_64_1267 VDD VSS sg13g2_decap_8
XFILLER_29_1387 VDD VSS sg13g2_decap_8
XFILLER_25_1229 VDD VSS sg13g2_decap_8
XFILLER_111_966 VDD VSS sg13g2_decap_8
XFILLER_122_292 VDD VSS sg13g2_decap_8
XFILLER_3_74 VDD VSS sg13g2_decap_8
XFILLER_110_465 VDD VSS sg13g2_fill_2
X_07790_ _08412_/A _07790_/A _15003_/Q VDD VSS sg13g2_nand2_1
XFILLER_96_688 VDD VSS sg13g2_decap_8
XFILLER_110_476 VDD VSS sg13g2_decap_8
XFILLER_84_839 VDD VSS sg13g2_fill_1
XFILLER_49_560 VDD VSS sg13g2_decap_8
XFILLER_7_1183 VDD VSS sg13g2_decap_8
XFILLER_97_1010 VDD VSS sg13g2_decap_8
XFILLER_95_198 VDD VSS sg13g2_decap_8
XFILLER_76_390 VDD VSS sg13g2_decap_8
XFILLER_3_1047 VDD VSS sg13g2_decap_8
XFILLER_36_221 VDD VSS sg13g2_decap_8
XFILLER_37_766 VDD VSS sg13g2_decap_8
X_09460_ _14061_/D _10089_/A0 _14061_/Q _09463_/S VDD VSS sg13g2_mux2_1
XFILLER_25_917 VDD VSS sg13g2_decap_4
XFILLER_184_1024 VDD VSS sg13g2_decap_8
XFILLER_58_1027 VDD VSS sg13g2_decap_8
XFILLER_91_371 VDD VSS sg13g2_decap_8
X_08411_ _08411_/Y _08411_/A _08414_/C _08411_/C VDD VSS sg13g2_nor3_1
XFILLER_51_213 VDD VSS sg13g2_decap_8
X_15205__2996 _15205_/RESET_B VDD VSS sg13g2_tiehi
XFILLER_145_1008 VDD VSS sg13g2_fill_1
XFILLER_149_1177 VDD VSS sg13g2_decap_8
X_09391_ _13994_/D _09723_/A0 _13994_/Q _09395_/S VDD VSS sg13g2_mux2_1
XFILLER_184_1079 VDD VSS sg13g2_decap_8
XFILLER_33_950 VDD VSS sg13g2_fill_2
XFILLER_162_1311 VDD VSS sg13g2_decap_8
XFILLER_75_1363 VDD VSS sg13g2_decap_8
X_08342_ _08346_/A _07782_/A _15002_/Q _08523_/B1 VDD VSS sg13g2_o21ai_1
XFILLER_178_955 VDD VSS sg13g2_decap_8
XFILLER_36_1369 VDD VSS sg13g2_decap_8
XFILLER_123_1328 VDD VSS sg13g2_decap_4
XFILLER_178_988 VDD VSS sg13g2_decap_8
X_08273_ _08273_/Y _08603_/B VDD VSS sg13g2_inv_1
XFILLER_162_1388 VDD VSS sg13g2_decap_8
XFILLER_177_476 VDD VSS sg13g2_decap_8
XFILLER_22_28 VDD VSS sg13g2_decap_8
XFILLER_165_638 VDD VSS sg13g2_decap_8
XFILLER_20_688 VDD VSS sg13g2_fill_1
XFILLER_160_1090 VDD VSS sg13g2_fill_1
XFILLER_69_1101 VDD VSS sg13g2_fill_2
XFILLER_118_543 VDD VSS sg13g2_decap_8
XFILLER_180_608 VDD VSS sg13g2_decap_8
XFILLER_121_1063 VDD VSS sg13g2_fill_2
XFILLER_180_619 VDD VSS sg13g2_fill_1
XFILLER_105_204 VDD VSS sg13g2_decap_8
XFILLER_161_822 VDD VSS sg13g2_fill_2
XFILLER_69_1178 VDD VSS sg13g2_decap_8
XFILLER_47_1410 VDD VSS sg13g2_decap_8
XFILLER_121_708 VDD VSS sg13g2_fill_1
XFILLER_156_1159 VDD VSS sg13g2_decap_8
XFILLER_160_354 VDD VSS sg13g2_decap_4
XFILLER_161_877 VDD VSS sg13g2_decap_8
XFILLER_82_1323 VDD VSS sg13g2_decap_8
XFILLER_154_49 VDD VSS sg13g2_decap_8
XFILLER_160_387 VDD VSS sg13g2_decap_8
XFILLER_101_410 VDD VSS sg13g2_decap_8
XFILLER_102_933 VDD VSS sg13g2_fill_2
XFILLER_99_493 VDD VSS sg13g2_decap_4
XFILLER_59_324 VDD VSS sg13g2_decap_8
Xfanout145 _09638_/A0 _09937_/A1 VDD VSS sg13g2_buf_1
XFILLER_43_1329 VDD VSS sg13g2_decap_8
Xfanout156 _10100_/A0 _09152_/Y VDD VSS sg13g2_buf_1
Xfanout167 _09899_/A0 _10164_/A1 VDD VSS sg13g2_buf_1
XFILLER_75_806 VDD VSS sg13g2_decap_8
XFILLER_134_1468 VDD VSS sg13g2_fill_2
Xfanout178 _09963_/A1 _09930_/A1 VDD VSS sg13g2_buf_1
Xfanout189 _09895_/A0 fanout191/X VDD VSS sg13g2_buf_1
X_07988_ _07988_/Y _11243_/B _13289_/C _13320_/C _07988_/D VDD VSS sg13g2_nor4_1
XFILLER_86_165 VDD VSS sg13g2_decap_8
XFILLER_41_1020 VDD VSS sg13g2_fill_1
XFILLER_68_880 VDD VSS sg13g2_decap_8
XFILLER_47_47 VDD VSS sg13g2_decap_8
X_09727_ _14318_/D _10124_/A0 _14318_/Q _09727_/S VDD VSS sg13g2_mux2_1
XFILLER_27_221 VDD VSS sg13g2_decap_8
XFILLER_132_1192 VDD VSS sg13g2_fill_2
XFILLER_27_243 VDD VSS sg13g2_fill_1
X_09658_ _14251_/D _09922_/A1 _14251_/Q _09667_/S VDD VSS sg13g2_mux2_1
XFILLER_55_563 VDD VSS sg13g2_decap_8
XFILLER_43_703 VDD VSS sg13g2_decap_8
XFILLER_15_405 VDD VSS sg13g2_decap_8
XFILLER_82_360 VDD VSS sg13g2_decap_8
XFILLER_55_585 VDD VSS sg13g2_decap_8
XFILLER_167_1255 VDD VSS sg13g2_decap_8
X_08609_ _08643_/A _07857_/X _08608_/B _07858_/X VDD VSS sg13g2_a21o_1
XFILLER_76_1149 VDD VSS sg13g2_decap_8
XFILLER_43_747 VDD VSS sg13g2_fill_1
X_09589_ _14186_/D _14186_/Q _09921_/A1 _09589_/S VDD VSS sg13g2_mux2_1
XFILLER_43_758 VDD VSS sg13g2_decap_8
XFILLER_151_4 VDD VSS sg13g2_fill_2
XFILLER_179_46 VDD VSS sg13g2_decap_8
X_11620_ _11620_/Y _11616_/Y _11617_/Y _11619_/Y _11618_/Y _11615_/B VDD VSS sg13g2_a221oi_1
XFILLER_70_577 VDD VSS sg13g2_fill_2
XFILLER_30_419 VDD VSS sg13g2_decap_8
XFILLER_24_983 VDD VSS sg13g2_decap_8
XFILLER_23_471 VDD VSS sg13g2_decap_8
XFILLER_168_443 VDD VSS sg13g2_decap_4
XFILLER_180_1455 VDD VSS sg13g2_decap_8
XFILLER_54_1458 VDD VSS sg13g2_decap_8
X_11551_ _11551_/Y _11551_/A1 _13860_/Q _11532_/C VDD VSS sg13g2_a21oi_1
XFILLER_156_605 VDD VSS sg13g2_fill_2
XFILLER_11_655 VDD VSS sg13g2_decap_8
XFILLER_128_307 VDD VSS sg13g2_fill_1
X_10502_ _10505_/C _10502_/A _10502_/B _10502_/C VDD VSS sg13g2_nor3_1
XFILLER_10_154 VDD VSS sg13g2_decap_8
XFILLER_17_1280 VDD VSS sg13g2_decap_8
XFILLER_183_424 VDD VSS sg13g2_decap_8
X_14270_ _14270_/Q _14526_/CLK _14270_/D _14270_/RESET_B VDD VSS sg13g2_dfrbpq_1
X_14008__2194 _14008_/RESET_B VDD VSS sg13g2_tiehi
X_11482_ _11777_/A _11483_/A _13686_/Q VDD VSS sg13g2_nor2_1
XFILLER_7_637 VDD VSS sg13g2_decap_8
XFILLER_104_1261 VDD VSS sg13g2_fill_1
XFILLER_52_1193 VDD VSS sg13g2_decap_8
XFILLER_100_1103 VDD VSS sg13g2_fill_2
XFILLER_137_852 VDD VSS sg13g2_decap_8
X_13221_ _13221_/Y _13218_/Y _13219_/Y _13220_/Y VDD VSS sg13g2_a21oi_1
XFILLER_155_159 VDD VSS sg13g2_decap_8
X_10433_ _10435_/B _14833_/Q _10434_/C _14834_/Q VDD VSS sg13g2_a21oi_1
XFILLER_137_874 VDD VSS sg13g2_decap_8
XFILLER_13_1166 VDD VSS sg13g2_decap_8
XFILLER_6_158 VDD VSS sg13g2_decap_8
XFILLER_87_1234 VDD VSS sg13g2_decap_8
XFILLER_124_502 VDD VSS sg13g2_decap_8
XFILLER_178_1362 VDD VSS sg13g2_decap_8
X_13152_ _13152_/Y _14789_/Q _13164_/A2 _13275_/B1 VDD VSS sg13g2_o21ai_1
X_10364_ _10365_/B _14812_/Q _14813_/Q _10364_/C VDD VSS sg13g2_nand3_1
XFILLER_88_21 VDD VSS sg13g2_decap_8
XFILLER_151_321 VDD VSS sg13g2_decap_8
XFILLER_151_332 VDD VSS sg13g2_fill_1
XFILLER_98_909 VDD VSS sg13g2_decap_8
XFILLER_139_1357 VDD VSS sg13g2_decap_8
XFILLER_152_866 VDD VSS sg13g2_decap_8
X_14187__2015 _14187_/RESET_B VDD VSS sg13g2_tiehi
X_12103_ _12103_/Y _12112_/A1 _14420_/Q _12103_/B1 VDD VSS sg13g2_a21oi_1
XFILLER_124_568 VDD VSS sg13g2_decap_8
XFILLER_152_877 VDD VSS sg13g2_fill_2
XFILLER_5_0 VDD VSS sg13g2_decap_8
XFILLER_3_865 VDD VSS sg13g2_decap_8
XFILLER_174_1259 VDD VSS sg13g2_decap_8
X_13083_ _13085_/B _14816_/Q _13068_/B _07728_/C _14880_/Q VDD VSS sg13g2_a22oi_1
XFILLER_105_760 VDD VSS sg13g2_decap_8
X_10295_ _14792_/D _10295_/A _10295_/B _10544_/C VDD VSS sg13g2_and3_1
XFILLER_105_771 VDD VSS sg13g2_fill_2
XFILLER_88_87 VDD VSS sg13g2_decap_8
XFILLER_2_364 VDD VSS sg13g2_decap_8
X_12034_ _12034_/Y _12030_/Y _12031_/Y _12033_/Y _12032_/Y _12036_/B VDD VSS sg13g2_a221oi_1
XFILLER_61_1407 VDD VSS sg13g2_decap_8
XFILLER_78_644 VDD VSS sg13g2_decap_8
XFILLER_77_121 VDD VSS sg13g2_decap_8
XFILLER_120_763 VDD VSS sg13g2_decap_4
Xfanout690 _11868_/A _07683_/X VDD VSS sg13g2_buf_1
XFILLER_4_1323 VDD VSS sg13g2_decap_8
XFILLER_111_1221 VDD VSS sg13g2_decap_8
X_13985_ _13985_/Q clkload6/A _13985_/D _13985_/RESET_B VDD VSS sg13g2_dfrbpq_1
XFILLER_93_658 VDD VSS sg13g2_decap_8
XFILLER_24_1284 VDD VSS sg13g2_decap_8
XFILLER_93_669 VDD VSS sg13g2_fill_1
XFILLER_92_146 VDD VSS sg13g2_fill_2
XFILLER_59_1303 VDD VSS sg13g2_decap_8
XFILLER_19_766 VDD VSS sg13g2_fill_1
XFILLER_20_1137 VDD VSS sg13g2_decap_8
X_12936_ _12936_/Y _12997_/B _12936_/B VDD VSS sg13g2_nand2b_1
XFILLER_19_788 VDD VSS sg13g2_decap_8
XFILLER_94_1216 VDD VSS sg13g2_decap_4
XFILLER_92_179 VDD VSS sg13g2_decap_8
XFILLER_74_883 VDD VSS sg13g2_fill_2
XFILLER_98_1396 VDD VSS sg13g2_fill_2
XFILLER_160_81 VDD VSS sg13g2_decap_8
XFILLER_185_1355 VDD VSS sg13g2_decap_8
XFILLER_94_1249 VDD VSS sg13g2_decap_4
X_12867_ _12867_/Y _12900_/B input16/X _12900_/C VDD VSS sg13g2_nand3_1
X_14218__1984 _14218_/RESET_B VDD VSS sg13g2_tiehi
X_14994__2616 _14994_/RESET_B VDD VSS sg13g2_tiehi
X_14606_ _14606_/Q _14670_/CLK _14606_/D _14606_/RESET_B VDD VSS sg13g2_dfrbpq_1
X_11818_ _11818_/Y _11821_/S0 _14476_/Q VDD VSS sg13g2_nand2b_1
XFILLER_109_1150 VDD VSS sg13g2_fill_2
XFILLER_144_1030 VDD VSS sg13g2_decap_8
XFILLER_14_460 VDD VSS sg13g2_decap_8
X_12798_ _12798_/Y _12911_/B _12801_/B _13600_/B VDD VSS sg13g2_o21ai_1
XFILLER_159_443 VDD VSS sg13g2_decap_8
XFILLER_105_1003 VDD VSS sg13g2_decap_8
X_14537_ _14537_/Q _14665_/CLK _14537_/D _14537_/RESET_B VDD VSS sg13g2_dfrbpq_1
XFILLER_105_1014 VDD VSS sg13g2_fill_2
X_11749_ _11749_/Y _11741_/A _14410_/Q _11742_/C VDD VSS sg13g2_a21oi_1
XFILLER_186_273 VDD VSS sg13g2_decap_8
XFILLER_30_975 VDD VSS sg13g2_decap_8
XFILLER_175_947 VDD VSS sg13g2_decap_8
X_14397__1805 _14397_/RESET_B VDD VSS sg13g2_tiehi
X_14468_ _14468_/Q _14510_/CLK _14468_/D _14468_/RESET_B VDD VSS sg13g2_dfrbpq_1
XFILLER_35_1380 VDD VSS sg13g2_decap_8
XFILLER_88_1009 VDD VSS sg13g2_decap_8
XFILLER_122_1361 VDD VSS sg13g2_decap_8
XFILLER_31_1244 VDD VSS sg13g2_decap_8
XFILLER_179_1148 VDD VSS sg13g2_decap_8
X_13419_ _13419_/Y _13412_/B _13419_/A2 _15094_/Q VDD VSS sg13g2_o21ai_1
X_14399_ _14399_/Q _14495_/CLK _14399_/D _14399_/RESET_B VDD VSS sg13g2_dfrbpq_1
XFILLER_115_513 VDD VSS sg13g2_fill_1
XFILLER_127_373 VDD VSS sg13g2_fill_1
XFILLER_157_1413 VDD VSS sg13g2_decap_8
XFILLER_170_630 VDD VSS sg13g2_decap_4
XFILLER_182_490 VDD VSS sg13g2_decap_8
XFILLER_143_855 VDD VSS sg13g2_fill_2
XFILLER_115_557 VDD VSS sg13g2_decap_8
X_08960_ _09441_/C _13279_/D _09204_/D VDD VSS sg13g2_nor2_1
X_07911_ _07911_/Y _08174_/A _07912_/B VDD VSS sg13g2_nor2b_1
XFILLER_142_398 VDD VSS sg13g2_fill_2
X_13706__2496 _13706_/RESET_B VDD VSS sg13g2_tiehi
XFILLER_9_1234 VDD VSS sg13g2_decap_8
XFILLER_25_1004 VDD VSS sg13g2_fill_2
X_08891_ _08891_/X _08890_/X _11726_/A _08904_/S VDD VSS sg13g2_mux2_1
XFILLER_68_110 VDD VSS sg13g2_fill_2
XFILLER_29_1184 VDD VSS sg13g2_decap_8
XFILLER_151_1023 VDD VSS sg13g2_decap_8
XFILLER_69_655 VDD VSS sg13g2_fill_2
X_07842_ _08678_/A _08654_/A _07841_/Y VDD VSS sg13g2_nor2b_1
XFILLER_84_603 VDD VSS sg13g2_fill_1
XFILLER_68_154 VDD VSS sg13g2_decap_8
XFILLER_112_1007 VDD VSS sg13g2_fill_1
X_07773_ _07773_/Y _08306_/B _08306_/C VDD VSS sg13g2_nor2b_1
XFILLER_42_1373 VDD VSS sg13g2_decap_8
XFILLER_49_390 VDD VSS sg13g2_decap_8
XFILLER_37_530 VDD VSS sg13g2_fill_1
XFILLER_17_28 VDD VSS sg13g2_decap_8
XFILLER_186_1119 VDD VSS sg13g2_decap_8
X_13885__2317 _13885_/RESET_B VDD VSS sg13g2_tiehi
X_09512_ _14111_/D _10075_/A0 _14111_/Q _09523_/S VDD VSS sg13g2_mux2_1
XFILLER_83_179 VDD VSS sg13g2_decap_8
XFILLER_77_1425 VDD VSS sg13g2_decap_8
X_13921__2281 _13921_/RESET_B VDD VSS sg13g2_tiehi
XFILLER_64_371 VDD VSS sg13g2_fill_2
XFILLER_52_522 VDD VSS sg13g2_decap_8
XFILLER_164_1406 VDD VSS sg13g2_decap_8
X_09443_ _14044_/D _10072_/A0 _14044_/Q _09473_/S VDD VSS sg13g2_mux2_1
XFILLER_25_747 VDD VSS sg13g2_decap_8
XFILLER_24_224 VDD VSS sg13g2_decap_8
XFILLER_40_706 VDD VSS sg13g2_decap_8
X_09374_ _13978_/D _10102_/A0 _13978_/Q _09374_/S VDD VSS sg13g2_mux2_1
XFILLER_75_1160 VDD VSS sg13g2_decap_8
XFILLER_178_741 VDD VSS sg13g2_decap_4
X_08325_ _08325_/Y _08414_/A _08325_/B VDD VSS sg13g2_nor2_1
XFILLER_33_791 VDD VSS sg13g2_fill_1
XFILLER_138_605 VDD VSS sg13g2_fill_2
XFILLER_166_914 VDD VSS sg13g2_decap_8
XFILLER_36_1166 VDD VSS sg13g2_decap_8
XFILLER_123_1125 VDD VSS sg13g2_fill_2
XFILLER_21_964 VDD VSS sg13g2_decap_4
XFILLER_71_1057 VDD VSS sg13g2_fill_2
XFILLER_162_1185 VDD VSS sg13g2_decap_8
X_15230__3021 _15230_/RESET_B VDD VSS sg13g2_tiehi
X_08256_ _08256_/Y _08256_/A _08256_/B VDD VSS sg13g2_nand2_1
XFILLER_165_457 VDD VSS sg13g2_decap_4
XFILLER_14_1464 VDD VSS sg13g2_decap_8
X_08187_ _15223_/D _08187_/A _08187_/B _08187_/C VDD VSS sg13g2_nand3_1
XFILLER_119_896 VDD VSS sg13g2_decap_8
XFILLER_180_427 VDD VSS sg13g2_decap_4
XFILLER_101_1467 VDD VSS sg13g2_fill_2
XFILLER_145_170 VDD VSS sg13g2_decap_4
XFILLER_84_1407 VDD VSS sg13g2_decap_8
XFILLER_133_332 VDD VSS sg13g2_decap_8
XFILLER_133_343 VDD VSS sg13g2_fill_1
XFILLER_160_151 VDD VSS sg13g2_decap_8
XFILLER_0_813 VDD VSS sg13g2_decap_8
XFILLER_102_730 VDD VSS sg13g2_decap_4
XFILLER_181_14 VDD VSS sg13g2_decap_8
X_10080_ _14660_/D _10080_/A0 _14660_/Q _10096_/S VDD VSS sg13g2_mux2_1
XFILLER_43_1104 VDD VSS sg13g2_decap_8
XFILLER_173_1281 VDD VSS sg13g2_decap_8
XFILLER_88_953 VDD VSS sg13g2_decap_8
XFILLER_87_430 VDD VSS sg13g2_decap_4
XFILLER_47_1284 VDD VSS sg13g2_decap_8
XFILLER_102_741 VDD VSS sg13g2_fill_2
XFILLER_102_752 VDD VSS sg13g2_fill_2
XFILLER_75_636 VDD VSS sg13g2_decap_8
XFILLER_75_647 VDD VSS sg13g2_fill_1
XFILLER_60_1462 VDD VSS sg13g2_decap_8
XFILLER_60_1473 VDD VSS sg13g2_fill_2
XFILLER_114_74 VDD VSS sg13g2_decap_4
XFILLER_21_1435 VDD VSS sg13g2_decap_8
XFILLER_90_606 VDD VSS sg13g2_decap_8
X_14475__1727 _14475_/RESET_B VDD VSS sg13g2_tiehi
X_13770_ _13770_/Q clkload27/A _13770_/D _13770_/RESET_B VDD VSS sg13g2_dfrbpq_1
XFILLER_74_168 VDD VSS sg13g2_fill_1
X_10982_ _10982_/X _10995_/A _11042_/A VDD VSS sg13g2_xor2_1
XFILLER_16_725 VDD VSS sg13g2_decap_8
XFILLER_56_894 VDD VSS sg13g2_decap_8
X_14511__1691 _14511_/RESET_B VDD VSS sg13g2_tiehi
X_12721_ _12722_/B _13667_/Q _12749_/A2 _12720_/X _12749_/B2 _12749_/C1 VDD VSS sg13g2_a221oi_1
XFILLER_15_224 VDD VSS sg13g2_decap_4
XFILLER_128_1025 VDD VSS sg13g2_fill_2
XFILLER_167_1074 VDD VSS sg13g2_fill_1
X_12652_ _15010_/D _12652_/A _12652_/B VDD VSS sg13g2_nor2_1
XFILLER_70_363 VDD VSS sg13g2_decap_8
XFILLER_19_1331 VDD VSS sg13g2_decap_8
X_14765__2971 _14765_/RESET_B VDD VSS sg13g2_tiehi
XFILLER_130_95 VDD VSS sg13g2_decap_8
XFILLER_93_1282 VDD VSS sg13g2_decap_8
XFILLER_142_0 VDD VSS sg13g2_decap_8
X_11603_ _11603_/Y _11617_/A1 _14598_/Q _11391_/B VDD VSS sg13g2_a21oi_1
XFILLER_24_791 VDD VSS sg13g2_decap_8
XFILLER_169_763 VDD VSS sg13g2_fill_2
XFILLER_180_1252 VDD VSS sg13g2_decap_8
X_14690__1512 _14690_/RESET_B VDD VSS sg13g2_tiehi
XFILLER_54_1255 VDD VSS sg13g2_decap_8
XFILLER_12_953 VDD VSS sg13g2_decap_8
X_12583_ _15005_/D _12583_/A _12583_/B VDD VSS sg13g2_nor2_1
XFILLER_12_964 VDD VSS sg13g2_fill_2
XFILLER_141_1214 VDD VSS sg13g2_fill_2
XFILLER_129_627 VDD VSS sg13g2_decap_8
XFILLER_11_452 VDD VSS sg13g2_decap_8
XFILLER_169_796 VDD VSS sg13g2_decap_4
X_14322_ _14322_/Q _14546_/CLK _14322_/D _14322_/RESET_B VDD VSS sg13g2_dfrbpq_1
XFILLER_141_1247 VDD VSS sg13g2_decap_4
X_11534_ _11535_/A _13956_/Q _13988_/Q _14020_/Q _14052_/Q _11531_/A _11532_/C VDD
+ VSS sg13g2_mux4_1
XFILLER_8_935 VDD VSS sg13g2_decap_8
XFILLER_157_958 VDD VSS sg13g2_decap_8
XFILLER_128_137 VDD VSS sg13g2_decap_8
XFILLER_183_221 VDD VSS sg13g2_decap_8
XFILLER_172_906 VDD VSS sg13g2_decap_8
XFILLER_7_434 VDD VSS sg13g2_decap_8
XFILLER_128_148 VDD VSS sg13g2_fill_2
XFILLER_184_777 VDD VSS sg13g2_decap_8
X_14253_ _14253_/Q clkload24/A _14253_/D _14253_/RESET_B VDD VSS sg13g2_dfrbpq_1
X_11465_ _11465_/Y _11463_/Y _11465_/B VDD VSS sg13g2_nand2b_1
XFILLER_139_93 VDD VSS sg13g2_fill_1
XFILLER_137_671 VDD VSS sg13g2_decap_4
XFILLER_165_980 VDD VSS sg13g2_decap_8
X_13204_ _13204_/Y _13224_/A _13204_/B VDD VSS sg13g2_xnor2_1
XFILLER_171_438 VDD VSS sg13g2_decap_8
XFILLER_183_298 VDD VSS sg13g2_decap_8
X_10416_ _10416_/Y _14828_/Q _10415_/A _10423_/C VDD VSS sg13g2_o21ai_1
XFILLER_109_395 VDD VSS sg13g2_decap_8
XFILLER_125_844 VDD VSS sg13g2_decap_8
XFILLER_136_170 VDD VSS sg13g2_fill_2
X_14184_ _14184_/Q clkload20/A _14184_/D _14184_/RESET_B VDD VSS sg13g2_dfrbpq_1
XFILLER_87_1053 VDD VSS sg13g2_decap_8
XFILLER_174_1012 VDD VSS sg13g2_decap_8
X_11396_ _11396_/Y _11392_/Y _11393_/X _11395_/Y VDD VSS sg13g2_o21ai_1
XFILLER_99_86 VDD VSS sg13g2_decap_8
XFILLER_87_1064 VDD VSS sg13g2_fill_1
X_13963__2239 _13963_/RESET_B VDD VSS sg13g2_tiehi
XFILLER_174_1023 VDD VSS sg13g2_fill_1
X_13135_ _13135_/Y _13170_/B _13131_/Y _13134_/Y VDD VSS sg13g2_a21oi_1
X_10347_ _14808_/D _10352_/C _10490_/A _10347_/C VDD VSS sg13g2_nor3_1
X_15204__2995 _15204_/RESET_B VDD VSS sg13g2_tiehi
XFILLER_3_662 VDD VSS sg13g2_decap_8
XFILLER_112_516 VDD VSS sg13g2_decap_8
XFILLER_65_1340 VDD VSS sg13g2_decap_8
XFILLER_112_527 VDD VSS sg13g2_fill_1
XFILLER_140_836 VDD VSS sg13g2_fill_1
XFILLER_135_1029 VDD VSS sg13g2_fill_2
XFILLER_139_1198 VDD VSS sg13g2_decap_8
XFILLER_2_161 VDD VSS sg13g2_decap_8
XFILLER_117_1430 VDD VSS sg13g2_decap_8
X_13066_ _13066_/Y _13066_/A _13172_/A _13066_/C VDD VSS sg13g2_nor3_1
XFILLER_31_7 VDD VSS sg13g2_decap_8
X_10278_ _10311_/A _14784_/Q _14785_/Q _10278_/C _10305_/B VDD VSS sg13g2_and4_1
XFILLER_61_1204 VDD VSS sg13g2_decap_8
Xfanout1430 _13356_/B _13596_/B VDD VSS sg13g2_buf_1
X_12017_ _12018_/B _12017_/A _13938_/Q VDD VSS sg13g2_nand2_1
XFILLER_6_1418 VDD VSS sg13g2_decap_8
XFILLER_117_1474 VDD VSS sg13g2_fill_1
XFILLER_152_1365 VDD VSS sg13g2_fill_1
XFILLER_39_828 VDD VSS sg13g2_decap_8
XFILLER_26_1368 VDD VSS sg13g2_decap_8
XFILLER_120_571 VDD VSS sg13g2_decap_8
XFILLER_94_945 VDD VSS sg13g2_decap_8
XFILLER_93_411 VDD VSS sg13g2_decap_8
XFILLER_113_1349 VDD VSS sg13g2_decap_8
XFILLER_4_1120 VDD VSS sg13g2_decap_8
XFILLER_38_338 VDD VSS sg13g2_decap_8
X_14882__2803 _14882_/RESET_B VDD VSS sg13g2_tiehi
XFILLER_93_455 VDD VSS sg13g2_fill_1
XFILLER_81_606 VDD VSS sg13g2_decap_8
XFILLER_171_91 VDD VSS sg13g2_decap_8
XFILLER_0_42 VDD VSS sg13g2_decap_8
X_13968_ _13968_/Q _14704_/CLK _13968_/D _13968_/RESET_B VDD VSS sg13g2_dfrbpq_1
XFILLER_59_1133 VDD VSS sg13g2_fill_2
XFILLER_4_1197 VDD VSS sg13g2_decap_8
XFILLER_111_1084 VDD VSS sg13g2_decap_8
XFILLER_146_1103 VDD VSS sg13g2_decap_8
XFILLER_185_1152 VDD VSS sg13g2_decap_8
X_12919_ _12919_/Y _12916_/Y _12917_/Y _12918_/Y VDD VSS sg13g2_a21oi_1
XFILLER_62_853 VDD VSS sg13g2_decap_8
X_13899_ _13899_/Q clkload12/A _13899_/D _13899_/RESET_B VDD VSS sg13g2_dfrbpq_1
XFILLER_59_1177 VDD VSS sg13g2_decap_8
XFILLER_72_1300 VDD VSS sg13g2_decap_8
XFILLER_37_1420 VDD VSS sg13g2_decap_8
XFILLER_163_1450 VDD VSS sg13g2_decap_8
XFILLER_33_1317 VDD VSS sg13g2_decap_8
XFILLER_124_1445 VDD VSS sg13g2_decap_8
XFILLER_147_413 VDD VSS sg13g2_fill_2
XFILLER_148_936 VDD VSS sg13g2_fill_2
X_08110_ _08112_/B _08452_/A _08199_/B _08256_/B _08110_/D VDD VSS sg13g2_nand4_1
XFILLER_72_1377 VDD VSS sg13g2_decap_8
XFILLER_9_84 VDD VSS sg13g2_decap_8
XFILLER_174_210 VDD VSS sg13g2_decap_8
X_09090_ _09090_/Y _09090_/A _09090_/B _09090_/C VDD VSS sg13g2_nand3_1
XFILLER_174_232 VDD VSS sg13g2_decap_8
X_08041_ _15218_/D _08003_/Y _08040_/Y _08002_/Y VDD VSS sg13g2_a21oi_1
XFILLER_135_619 VDD VSS sg13g2_decap_8
XFILLER_175_788 VDD VSS sg13g2_decap_4
XFILLER_116_811 VDD VSS sg13g2_decap_8
XFILLER_122_1180 VDD VSS sg13g2_fill_2
XFILLER_134_118 VDD VSS sg13g2_fill_1
XFILLER_31_1074 VDD VSS sg13g2_fill_1
XFILLER_171_961 VDD VSS sg13g2_fill_2
X_14553__1649 _14553_/RESET_B VDD VSS sg13g2_tiehi
XFILLER_171_972 VDD VSS sg13g2_decap_8
X_13939__2263 _13939_/RESET_B VDD VSS sg13g2_tiehi
XFILLER_103_505 VDD VSS sg13g2_fill_2
XFILLER_118_1216 VDD VSS sg13g2_decap_8
X_09992_ _14575_/D _10125_/A0 _14575_/Q _10002_/S VDD VSS sg13g2_mux2_1
X_15093__2818 _15093_/RESET_B VDD VSS sg13g2_tiehi
XFILLER_157_1287 VDD VSS sg13g2_decap_8
X_08943_ _08943_/Y _08943_/A _14954_/Q VDD VSS sg13g2_nand2_1
XFILLER_170_1410 VDD VSS sg13g2_decap_8
Xhold3048 input29/A mem_axi_rdata[3] VDD VSS sg13g2_dlygate4sd3_1
Xhold3059 hold3059/X input4/X VDD VSS sg13g2_dlygate4sd3_1
XFILLER_83_1473 VDD VSS sg13g2_decap_4
XFILLER_44_1424 VDD VSS sg13g2_decap_8
XFILLER_9_1064 VDD VSS sg13g2_decap_8
XFILLER_111_560 VDD VSS sg13g2_decap_8
X_08874_ _08874_/X _15032_/Q _08873_/A _08873_/Y VDD VSS sg13g2_a21o_1
XFILLER_97_794 VDD VSS sg13g2_fill_2
XFILLER_69_496 VDD VSS sg13g2_decap_8
X_07825_ _08436_/B _15005_/Q _07946_/B VDD VSS sg13g2_or2_1
XFILLER_42_1170 VDD VSS sg13g2_decap_8
X_07756_ _13305_/B _13499_/C _13307_/A VDD VSS sg13g2_nor2b_1
XFILLER_72_639 VDD VSS sg13g2_decap_4
XFILLER_77_1222 VDD VSS sg13g2_decap_8
XFILLER_71_116 VDD VSS sg13g2_fill_2
XFILLER_25_522 VDD VSS sg13g2_decap_8
XFILLER_164_1203 VDD VSS sg13g2_decap_8
XFILLER_71_149 VDD VSS sg13g2_fill_2
X_07687_ _07697_/A _07687_/A _07687_/B _07687_/C VDD VSS sg13g2_or3_1
XFILLER_25_566 VDD VSS sg13g2_decap_8
X_09426_ _14028_/D _09989_/A0 _14028_/Q _09428_/S VDD VSS sg13g2_mux2_1
XFILLER_80_661 VDD VSS sg13g2_decap_8
XFILLER_13_728 VDD VSS sg13g2_decap_8
XFILLER_90_1400 VDD VSS sg13g2_decap_8
XFILLER_77_1299 VDD VSS sg13g2_decap_8
XFILLER_100_21 VDD VSS sg13g2_decap_8
XFILLER_52_396 VDD VSS sg13g2_decap_8
XFILLER_40_536 VDD VSS sg13g2_fill_2
XFILLER_12_238 VDD VSS sg13g2_decap_8
X_09357_ _13961_/D _09953_/A1 _13961_/Q _09368_/S VDD VSS sg13g2_mux2_1
Xclkbuf_5_3__f_clk_i clkbuf_leaf_4_clk_i/A clkbuf_4_1_0_clk_i/X VDD VSS sg13g2_buf_16
XFILLER_51_1417 VDD VSS sg13g2_decap_8
X_08308_ _08308_/X _08131_/Y _08426_/A _08027_/Y VDD VSS sg13g2_a21o_1
XFILLER_60_25 VDD VSS sg13g2_decap_8
X_14753__2986 _14753_/RESET_B VDD VSS sg13g2_tiehi
X_09288_ _13896_/D _13896_/Q _10151_/A1 _09292_/S VDD VSS sg13g2_mux2_1
XFILLER_139_969 VDD VSS sg13g2_decap_8
XFILLER_176_14 VDD VSS sg13g2_decap_8
XFILLER_138_457 VDD VSS sg13g2_decap_8
XFILLER_20_271 VDD VSS sg13g2_decap_4
XFILLER_20_293 VDD VSS sg13g2_decap_8
X_08239_ _08239_/Y _08265_/B _08306_/A _08318_/A _08359_/A2 _08238_/Y VDD VSS sg13g2_a221oi_1
XFILLER_14_1261 VDD VSS sg13g2_decap_8
XFILLER_140_1280 VDD VSS sg13g2_decap_8
XFILLER_5_938 VDD VSS sg13g2_decap_8
XFILLER_181_747 VDD VSS sg13g2_decap_4
XFILLER_165_298 VDD VSS sg13g2_decap_8
XFILLER_180_224 VDD VSS sg13g2_decap_8
X_11250_ _14957_/D _11248_/Y _11237_/Y _11249_/Y VDD VSS sg13g2_a21oi_1
XFILLER_101_1253 VDD VSS sg13g2_decap_4
XFILLER_134_630 VDD VSS sg13g2_fill_2
XFILLER_88_1362 VDD VSS sg13g2_decap_8
XFILLER_175_1321 VDD VSS sg13g2_decap_8
XFILLER_4_448 VDD VSS sg13g2_decap_8
XFILLER_49_1324 VDD VSS sg13g2_decap_8
XFILLER_101_1275 VDD VSS sg13g2_decap_8
XFILLER_69_23 VDD VSS sg13g2_decap_8
XFILLER_106_343 VDD VSS sg13g2_decap_8
XFILLER_10_1169 VDD VSS sg13g2_decap_8
X_10201_ _15182_/D hold3085/X _13389_/B _10203_/S VDD VSS sg13g2_mux2_1
XFILLER_84_1226 VDD VSS sg13g2_decap_8
XFILLER_134_663 VDD VSS sg13g2_decap_8
X_11181_ _11181_/X _11181_/A _11181_/B VDD VSS sg13g2_xor2_1
X_14529__1673 _14529_/RESET_B VDD VSS sg13g2_tiehi
XFILLER_79_205 VDD VSS sg13g2_decap_8
XFILLER_122_836 VDD VSS sg13g2_fill_1
X_10132_ _14710_/D _10165_/A1 _14710_/Q _10136_/S VDD VSS sg13g2_mux2_1
XFILLER_175_1398 VDD VSS sg13g2_decap_8
XFILLER_88_761 VDD VSS sg13g2_decap_8
XFILLER_0_665 VDD VSS sg13g2_decap_8
XFILLER_134_1040 VDD VSS sg13g2_fill_1
XFILLER_121_379 VDD VSS sg13g2_decap_8
X_14940_ _14940_/Q clkload59/A _14940_/D _14940_/RESET_B VDD VSS sg13g2_dfrbpq_1
X_10063_ _14644_/D _10063_/A0 _14644_/Q _10063_/S VDD VSS sg13g2_mux2_1
XFILLER_88_783 VDD VSS sg13g2_decap_8
XFILLER_75_400 VDD VSS sg13g2_decap_8
XFILLER_125_95 VDD VSS sg13g2_decap_8
X_14871_ _14871_/Q clkload83/A _14871_/D _14871_/RESET_B VDD VSS sg13g2_dfrbpq_1
X_15061__2512 _15061_/RESET_B VDD VSS sg13g2_tiehi
XFILLER_91_915 VDD VSS sg13g2_fill_2
XFILLER_85_88 VDD VSS sg13g2_decap_8
XFILLER_25_1390 VDD VSS sg13g2_decap_8
XFILLER_21_1232 VDD VSS sg13g2_decap_8
XFILLER_35_308 VDD VSS sg13g2_fill_2
XFILLER_18_60 VDD VSS sg13g2_decap_8
X_13822_ _13822_/Q _14526_/CLK _13822_/D _13822_/RESET_B VDD VSS sg13g2_dfrbpq_1
XFILLER_112_1382 VDD VSS sg13g2_decap_8
XFILLER_44_820 VDD VSS sg13g2_fill_1
XFILLER_141_61 VDD VSS sg13g2_decap_8
XFILLER_1_1337 VDD VSS sg13g2_decap_8
XFILLER_91_959 VDD VSS sg13g2_fill_2
X_13753_ _13753_/Q clkload44/A _13753_/D _13753_/RESET_B VDD VSS sg13g2_dfrbpq_1
XFILLER_95_1344 VDD VSS sg13g2_decap_4
X_10965_ _11042_/A _10965_/A _10965_/B _10965_/C VDD VSS sg13g2_nor3_1
XFILLER_44_864 VDD VSS sg13g2_decap_8
XFILLER_44_875 VDD VSS sg13g2_fill_2
X_12704_ _12704_/X _12700_/X _12701_/X _12699_/X _12698_/X _12705_/S0 _12609_/S VDD
+ VSS sg13g2_mux4_1
XFILLER_95_1377 VDD VSS sg13g2_decap_8
XFILLER_56_1339 VDD VSS sg13g2_decap_8
XFILLER_108_1418 VDD VSS sg13g2_decap_4
X_13684_ _13684_/Q clkload62/A _13684_/D _13684_/RESET_B VDD VSS sg13g2_dfrbpq_1
X_10896_ _10896_/Y _10948_/A _10893_/X _10895_/Y VDD VSS sg13g2_a21oi_1
XFILLER_43_385 VDD VSS sg13g2_fill_2
XFILLER_182_1369 VDD VSS sg13g2_decap_8
X_12635_ _12635_/X _12633_/X _12632_/X _12629_/X _12628_/X _12663_/S1 _12664_/S VDD
+ VSS sg13g2_mux4_1
XFILLER_54_1041 VDD VSS sg13g2_fill_2
XFILLER_141_1000 VDD VSS sg13g2_decap_8
XFILLER_12_761 VDD VSS sg13g2_decap_8
XFILLER_129_435 VDD VSS sg13g2_decap_8
X_12566_ _12566_/X _12562_/X _12561_/X _12558_/X _12557_/X _12622_/S0 _12623_/S VDD
+ VSS sg13g2_mux4_1
XFILLER_8_732 VDD VSS sg13g2_decap_8
XFILLER_15_1047 VDD VSS sg13g2_decap_8
XFILLER_156_232 VDD VSS sg13g2_decap_8
XFILLER_106_1186 VDD VSS sg13g2_decap_4
XFILLER_184_552 VDD VSS sg13g2_decap_8
XFILLER_7_231 VDD VSS sg13g2_decap_8
X_14305_ _14305_/Q clkload9/A _14305_/D _14305_/RESET_B VDD VSS sg13g2_dfrbpq_1
X_11517_ _11517_/X _11507_/X _11508_/X _11511_/X _11512_/X _11973_/B _11975_/A VDD
+ VSS sg13g2_mux4_1
XFILLER_129_479 VDD VSS sg13g2_decap_8
XFILLER_116_107 VDD VSS sg13g2_decap_8
XFILLER_144_416 VDD VSS sg13g2_decap_8
X_12497_ _12497_/X _12495_/X _12496_/X _12650_/S VDD VSS sg13g2_mux2_1
XFILLER_176_1107 VDD VSS sg13g2_decap_8
XFILLER_32_1372 VDD VSS sg13g2_decap_8
XFILLER_138_991 VDD VSS sg13g2_decap_4
X_14236_ _14236_/Q _14588_/CLK _14236_/D _14236_/RESET_B VDD VSS sg13g2_dfrbpq_1
XFILLER_67_1402 VDD VSS sg13g2_decap_8
X_11448_ _11448_/X _11448_/A _11957_/A _11448_/C VDD VSS sg13g2_and3_1
XFILLER_166_91 VDD VSS sg13g2_decap_8
X_14167_ _14167_/Q clkload43/A _14167_/D _14167_/RESET_B VDD VSS sg13g2_dfrbpq_1
X_11379_ _11379_/Y _11625_/C _11378_/X _11903_/C1 VDD VSS sg13g2_a21oi_1
XFILLER_112_313 VDD VSS sg13g2_decap_8
X_13118_ _13170_/A _14914_/Q _13673_/Q VDD VSS sg13g2_xnor2_1
X_14098_ _14098_/Q _14546_/CLK _14098_/D _14098_/RESET_B VDD VSS sg13g2_dfrbpq_1
XFILLER_98_558 VDD VSS sg13g2_decap_8
XFILLER_117_1260 VDD VSS sg13g2_decap_8
X_13049_ _13049_/X _15062_/Q _15061_/Q VDD VSS sg13g2_or2_1
XFILLER_6_1215 VDD VSS sg13g2_decap_8
XFILLER_26_1165 VDD VSS sg13g2_decap_8
XFILLER_22_1007 VDD VSS sg13g2_decap_8
XFILLER_61_1056 VDD VSS sg13g2_fill_2
XFILLER_113_1124 VDD VSS sg13g2_decap_8
Xfanout1260 _11834_/A2 _12336_/A2 VDD VSS sg13g2_buf_1
XFILLER_94_731 VDD VSS sg13g2_decap_8
Xfanout1271 _12308_/C _13659_/Q VDD VSS sg13g2_buf_1
XFILLER_120_390 VDD VSS sg13g2_decap_8
XFILLER_22_1029 VDD VSS sg13g2_decap_8
Xfanout1282 _11786_/S1 _12091_/C VDD VSS sg13g2_buf_1
XFILLER_39_658 VDD VSS sg13g2_decap_8
XFILLER_27_809 VDD VSS sg13g2_fill_1
Xfanout1293 fanout1293/X fanout1298/X VDD VSS sg13g2_buf_1
XFILLER_67_989 VDD VSS sg13g2_decap_8
X_08590_ _08590_/Y _08625_/A _08590_/B VDD VSS sg13g2_nor2_1
XFILLER_81_414 VDD VSS sg13g2_decap_8
XFILLER_54_639 VDD VSS sg13g2_decap_8
XFILLER_35_831 VDD VSS sg13g2_decap_8
XFILLER_35_886 VDD VSS sg13g2_decap_4
XFILLER_50_823 VDD VSS sg13g2_fill_2
X_14846__2875 _14846_/RESET_B VDD VSS sg13g2_tiehi
X_09211_ _13822_/D _09744_/A1 _13822_/Q _09225_/S VDD VSS sg13g2_mux2_1
XFILLER_148_700 VDD VSS sg13g2_decap_8
X_14607__1595 _14607_/RESET_B VDD VSS sg13g2_tiehi
XFILLER_148_711 VDD VSS sg13g2_fill_2
XFILLER_33_1103 VDD VSS sg13g2_decap_4
XFILLER_33_1114 VDD VSS sg13g2_decap_8
X_09142_ _09157_/D _13245_/A _14921_/Q _13199_/A VDD VSS sg13g2_and3_1
XFILLER_72_1174 VDD VSS sg13g2_decap_8
XFILLER_37_1294 VDD VSS sg13g2_decap_8
X_14182__2020 _14182_/RESET_B VDD VSS sg13g2_tiehi
XFILLER_124_1275 VDD VSS sg13g2_decap_4
XFILLER_148_766 VDD VSS sg13g2_decap_8
XFILLER_30_591 VDD VSS sg13g2_decap_8
XFILLER_120_1117 VDD VSS sg13g2_fill_2
XFILLER_11_1401 VDD VSS sg13g2_decap_8
XFILLER_163_714 VDD VSS sg13g2_fill_1
X_09073_ _10735_/B _09078_/B _15039_/Q _09072_/Y VDD VSS sg13g2_o21ai_1
XFILLER_120_1139 VDD VSS sg13g2_decap_8
XFILLER_147_287 VDD VSS sg13g2_fill_1
X_08024_ _08025_/C _07903_/B _08089_/B2 _07879_/A _11384_/A _07900_/B _07883_/A VDD
+ VSS sg13g2_mux4_1
XFILLER_30_39 VDD VSS sg13g2_decap_4
XFILLER_128_490 VDD VSS sg13g2_fill_1
XFILLER_162_257 VDD VSS sg13g2_decap_8
XFILLER_144_972 VDD VSS sg13g2_fill_1
XFILLER_104_814 VDD VSS sg13g2_decap_4
XFILLER_131_600 VDD VSS sg13g2_decap_8
XFILLER_103_302 VDD VSS sg13g2_decap_8
XFILLER_104_836 VDD VSS sg13g2_decap_8
XFILLER_115_173 VDD VSS sg13g2_decap_4
XFILLER_157_1073 VDD VSS sg13g2_decap_4
XFILLER_115_195 VDD VSS sg13g2_decap_8
X_09975_ _14558_/D _10074_/A0 _14558_/Q _09997_/S VDD VSS sg13g2_mux2_1
XFILLER_118_1057 VDD VSS sg13g2_decap_8
XFILLER_89_569 VDD VSS sg13g2_decap_8
XFILLER_83_1270 VDD VSS sg13g2_decap_8
XFILLER_44_1221 VDD VSS sg13g2_decap_8
X_08926_ _13714_/D _16876_/A _08925_/X _08932_/S VDD VSS sg13g2_mux2_1
XFILLER_130_165 VDD VSS sg13g2_decap_8
XFILLER_131_699 VDD VSS sg13g2_fill_1
XFILLER_85_742 VDD VSS sg13g2_fill_2
XFILLER_131_1235 VDD VSS sg13g2_fill_2
XFILLER_170_1284 VDD VSS sg13g2_decap_8
X_08857_ _08857_/X _08856_/X _11461_/A _08875_/S VDD VSS sg13g2_mux2_1
XFILLER_79_1306 VDD VSS sg13g2_fill_2
XFILLER_44_1298 VDD VSS sg13g2_decap_8
XFILLER_84_241 VDD VSS sg13g2_fill_2
X_07808_ _07808_/Y _15012_/Q _12009_/A VDD VSS sg13g2_nor2_1
XFILLER_57_477 VDD VSS sg13g2_decap_8
XFILLER_55_25 VDD VSS sg13g2_decap_8
XFILLER_79_1339 VDD VSS sg13g2_decap_8
XFILLER_29_179 VDD VSS sg13g2_decap_8
X_08788_ _08788_/Y _11017_/A1 _14757_/Q _13389_/A _07719_/X VDD VSS sg13g2_a22oi_1
XFILLER_72_414 VDD VSS sg13g2_fill_1
XFILLER_44_116 VDD VSS sg13g2_decap_4
XFILLER_44_138 VDD VSS sg13g2_decap_8
X_07739_ _15209_/D _13284_/B _07738_/Y _07714_/Y VDD VSS sg13g2_o21ai_1
X_14392__1810 _14392_/RESET_B VDD VSS sg13g2_tiehi
XFILLER_41_812 VDD VSS sg13g2_fill_2
X_10750_ _10750_/Y _14915_/Q _11102_/B VDD VSS sg13g2_nand2_1
XFILLER_40_300 VDD VSS sg13g2_decap_4
XFILLER_38_1036 VDD VSS sg13g2_decap_8
XFILLER_111_64 VDD VSS sg13g2_decap_8
X_15203__2994 _15203_/RESET_B VDD VSS sg13g2_tiehi
XFILLER_52_171 VDD VSS sg13g2_fill_1
XFILLER_41_834 VDD VSS sg13g2_decap_8
XFILLER_25_385 VDD VSS sg13g2_decap_8
XFILLER_13_536 VDD VSS sg13g2_decap_8
XFILLER_40_322 VDD VSS sg13g2_decap_8
X_09409_ _14011_/D _10138_/A1 _14011_/Q _09440_/S VDD VSS sg13g2_mux2_1
XFILLER_71_35 VDD VSS sg13g2_decap_8
XFILLER_52_182 VDD VSS sg13g2_decap_8
XFILLER_129_1197 VDD VSS sg13g2_decap_8
X_10681_ _10681_/Y _10681_/A _10875_/B VDD VSS sg13g2_nand2_1
XFILLER_9_518 VDD VSS sg13g2_decap_8
XFILLER_16_1323 VDD VSS sg13g2_decap_8
X_12420_ _12420_/X _14368_/Q _14400_/Q _14464_/Q _14496_/Q _12698_/S0 _12698_/S1 VDD
+ VSS sg13g2_mux4_1
XFILLER_51_1214 VDD VSS sg13g2_decap_8
XFILLER_107_1473 VDD VSS sg13g2_decap_4
XFILLER_166_541 VDD VSS sg13g2_decap_8
XFILLER_127_917 VDD VSS sg13g2_decap_8
XFILLER_139_777 VDD VSS sg13g2_decap_8
XFILLER_142_1375 VDD VSS sg13g2_decap_8
XFILLER_166_552 VDD VSS sg13g2_fill_2
X_12351_ _12351_/X _14363_/Q _14395_/Q _14459_/Q _14491_/Q _12352_/S0 _12352_/S1 VDD
+ VSS sg13g2_mux4_1
XFILLER_127_939 VDD VSS sg13g2_decap_8
X_11302_ _11302_/Y _11328_/S0 _14557_/Q VDD VSS sg13g2_nand2b_1
XFILLER_138_298 VDD VSS sg13g2_decap_8
X_15070_ _15070_/Q _15212_/CLK _15070_/D _15070_/RESET_B VDD VSS sg13g2_dfrbpq_1
XFILLER_5_735 VDD VSS sg13g2_decap_8
XFILLER_107_630 VDD VSS sg13g2_decap_8
XFILLER_153_235 VDD VSS sg13g2_decap_8
X_12282_ _12282_/X _13753_/Q _14105_/Q _14457_/Q _14553_/Q _12286_/S0 _12288_/S1 VDD
+ VSS sg13g2_mux4_1
XFILLER_142_909 VDD VSS sg13g2_decap_8
XFILLER_181_566 VDD VSS sg13g2_decap_4
XFILLER_105_0 VDD VSS sg13g2_decap_8
XFILLER_135_961 VDD VSS sg13g2_decap_8
X_14021_ _14021_/Q clkload17/A _14021_/D _14021_/RESET_B VDD VSS sg13g2_dfrbpq_1
XFILLER_4_245 VDD VSS sg13g2_decap_8
X_11233_ _11233_/Y _15117_/Q _15118_/Q _14760_/Q VDD VSS sg13g2_nor3_1
XFILLER_88_1181 VDD VSS sg13g2_decap_8
XFILLER_84_1012 VDD VSS sg13g2_fill_2
XFILLER_107_674 VDD VSS sg13g2_fill_2
XFILLER_141_419 VDD VSS sg13g2_fill_2
XFILLER_153_279 VDD VSS sg13g2_fill_1
XFILLER_181_588 VDD VSS sg13g2_decap_8
XFILLER_136_1113 VDD VSS sg13g2_decap_8
XFILLER_162_791 VDD VSS sg13g2_decap_8
X_14045__2157 _14045_/RESET_B VDD VSS sg13g2_tiehi
X_13880__2322 _13880_/RESET_B VDD VSS sg13g2_tiehi
XFILLER_121_121 VDD VSS sg13g2_fill_2
XFILLER_136_72 VDD VSS sg13g2_decap_8
X_11164_ _11181_/B _11164_/A _11164_/B _11164_/C _11190_/C VDD VSS sg13g2_nor4_1
XFILLER_45_1018 VDD VSS sg13g2_decap_8
XFILLER_136_1146 VDD VSS sg13g2_fill_2
XFILLER_175_1195 VDD VSS sg13g2_decap_8
XFILLER_68_709 VDD VSS sg13g2_decap_8
XFILLER_49_1198 VDD VSS sg13g2_decap_8
XFILLER_1_952 VDD VSS sg13g2_decap_8
XFILLER_171_1048 VDD VSS sg13g2_decap_8
XFILLER_49_901 VDD VSS sg13g2_decap_8
XFILLER_121_154 VDD VSS sg13g2_fill_1
X_10115_ _14693_/D _10148_/A1 _14693_/Q _10123_/S VDD VSS sg13g2_mux2_1
XFILLER_95_517 VDD VSS sg13g2_fill_2
XFILLER_136_1179 VDD VSS sg13g2_decap_8
XFILLER_0_462 VDD VSS sg13g2_decap_8
X_11095_ _11095_/Y _11095_/A _11095_/B VDD VSS sg13g2_nor2_1
XFILLER_48_400 VDD VSS sg13g2_decap_8
XFILLER_27_1474 VDD VSS sg13g2_decap_4
XFILLER_62_1376 VDD VSS sg13g2_decap_8
X_14923_ _14923_/Q clkload74/A _14923_/D _14923_/RESET_B VDD VSS sg13g2_dfrbpq_1
X_10046_ _14627_/D _10113_/A0 _14627_/Q _10059_/S VDD VSS sg13g2_mux2_1
XFILLER_97_1428 VDD VSS sg13g2_decap_8
XFILLER_75_252 VDD VSS sg13g2_decap_8
XFILLER_36_617 VDD VSS sg13g2_decap_8
XFILLER_91_712 VDD VSS sg13g2_decap_8
XFILLER_36_628 VDD VSS sg13g2_fill_1
XFILLER_21_1040 VDD VSS sg13g2_decap_8
X_14854_ _14854_/Q clkload84/A _14854_/D _14854_/RESET_B VDD VSS sg13g2_dfrbpq_1
XFILLER_17_820 VDD VSS sg13g2_decap_8
XFILLER_5_1281 VDD VSS sg13g2_decap_8
XFILLER_1_1134 VDD VSS sg13g2_decap_8
X_13805_ _13805_/Q clkload26/A _13805_/D _13805_/RESET_B VDD VSS sg13g2_dfrbpq_1
X_14785_ _14785_/Q clkload89/A _14785_/D _14785_/RESET_B VDD VSS sg13g2_dfrbpq_1
X_11997_ _11997_/X _13745_/Q _14097_/Q _14449_/Q _14545_/Q _11997_/S0 _11997_/S1 VDD
+ VSS sg13g2_mux4_1
XFILLER_95_1141 VDD VSS sg13g2_decap_8
XFILLER_44_650 VDD VSS sg13g2_decap_8
XFILLER_186_1280 VDD VSS sg13g2_decap_8
XFILLER_72_970 VDD VSS sg13g2_fill_1
XFILLER_17_886 VDD VSS sg13g2_decap_8
X_13736_ _13736_/Q _14728_/CLK _13736_/D _13736_/RESET_B VDD VSS sg13g2_dfrbpq_1
X_10948_ _11005_/A _10948_/A _10948_/B _10948_/C _10948_/D VDD VSS sg13g2_or4_1
XFILLER_72_992 VDD VSS sg13g2_fill_1
XFILLER_32_823 VDD VSS sg13g2_fill_1
XFILLER_147_1264 VDD VSS sg13g2_decap_4
XFILLER_177_806 VDD VSS sg13g2_fill_1
XFILLER_182_1166 VDD VSS sg13g2_decap_8
XFILLER_176_305 VDD VSS sg13g2_fill_2
XFILLER_177_828 VDD VSS sg13g2_decap_8
X_13667_ _13667_/Q clkload72/A _13667_/D _13667_/RESET_B VDD VSS sg13g2_dfrbpq_1
X_10879_ _10879_/Y _14754_/Q _10897_/A VDD VSS sg13g2_nand2b_1
XFILLER_73_1472 VDD VSS sg13g2_decap_8
XFILLER_31_377 VDD VSS sg13g2_decap_8
X_12618_ _12618_/X _13742_/Q _14094_/Q _14446_/Q _14542_/Q _12620_/S0 _12620_/S1 VDD
+ VSS sg13g2_mux4_1
X_13598_ _15164_/D _13597_/Y _10173_/B _13595_/Y VDD VSS sg13g2_a21oi_1
XFILLER_157_541 VDD VSS sg13g2_decap_8
XFILLER_185_850 VDD VSS sg13g2_decap_8
XFILLER_34_1467 VDD VSS sg13g2_decap_8
XFILLER_129_243 VDD VSS sg13g2_decap_4
XFILLER_12_591 VDD VSS sg13g2_decap_8
XFILLER_77_4 VDD VSS sg13g2_decap_8
X_14255__1947 _14255_/RESET_B VDD VSS sg13g2_tiehi
XFILLER_34_1478 VDD VSS sg13g2_fill_1
XFILLER_121_1437 VDD VSS sg13g2_decap_4
X_12549_ _12549_/X _14121_/Q _14153_/Q _14185_/Q _14217_/Q _12550_/S0 _12550_/S1 VDD
+ VSS sg13g2_mux4_1
XFILLER_172_522 VDD VSS sg13g2_decap_8
XFILLER_172_533 VDD VSS sg13g2_fill_2
XANTENNA_1 _09556_/S VDD VSS sg13g2_antennanp
XFILLER_144_268 VDD VSS sg13g2_decap_8
XFILLER_6_74 VDD VSS sg13g2_decap_8
X_14219_ _14219_/Q _14729_/CLK _14219_/D _14219_/RESET_B VDD VSS sg13g2_dfrbpq_1
X_15199_ _15199_/Q clkload64/A _15199_/D _15199_/RESET_B VDD VSS sg13g2_dfrbpq_1
XFILLER_98_300 VDD VSS sg13g2_decap_8
XFILLER_113_611 VDD VSS sg13g2_decap_8
XFILLER_141_920 VDD VSS sg13g2_fill_2
XFILLER_113_622 VDD VSS sg13g2_fill_2
XFILLER_158_1382 VDD VSS sg13g2_decap_8
XFILLER_113_633 VDD VSS sg13g2_fill_1
XFILLER_125_493 VDD VSS sg13g2_decap_4
XFILLER_67_1276 VDD VSS sg13g2_decap_8
X_14470__1732 _14470_/RESET_B VDD VSS sg13g2_tiehi
Xfanout508 _08424_/A1 _08001_/Y VDD VSS sg13g2_buf_1
XFILLER_99_867 VDD VSS sg13g2_decap_8
XFILLER_28_1238 VDD VSS sg13g2_decap_8
Xfanout519 _11241_/A _07672_/X VDD VSS sg13g2_buf_1
XFILLER_99_878 VDD VSS sg13g2_fill_1
XFILLER_101_806 VDD VSS sg13g2_fill_1
XFILLER_113_666 VDD VSS sg13g2_decap_4
XFILLER_86_517 VDD VSS sg13g2_fill_1
X_09760_ _14350_/D _14350_/Q _10124_/A0 _09760_/S VDD VSS sg13g2_mux2_1
XFILLER_112_165 VDD VSS sg13g2_decap_8
XFILLER_98_388 VDD VSS sg13g2_decap_4
XFILLER_58_219 VDD VSS sg13g2_decap_4
XFILLER_6_1012 VDD VSS sg13g2_decap_8
XFILLER_20_0 VDD VSS sg13g2_decap_8
XFILLER_80_1454 VDD VSS sg13g2_decap_8
X_08711_ _15188_/D hold3095/X _15188_/Q _10203_/S VDD VSS sg13g2_mux2_1
XFILLER_117_1090 VDD VSS sg13g2_decap_4
X_09691_ _14283_/D _09922_/A1 _14283_/Q _09700_/S VDD VSS sg13g2_mux2_1
XFILLER_67_753 VDD VSS sg13g2_decap_8
XFILLER_39_444 VDD VSS sg13g2_fill_1
Xfanout1090 _08084_/S1 _14990_/Q VDD VSS sg13g2_buf_1
X_08642_ _08642_/Y _08573_/A _08575_/Y _08641_/Y VDD VSS sg13g2_o21ai_1
XFILLER_94_572 VDD VSS sg13g2_fill_2
XFILLER_6_1089 VDD VSS sg13g2_decap_8
XFILLER_82_723 VDD VSS sg13g2_decap_4
XFILLER_39_488 VDD VSS sg13g2_decap_8
XFILLER_26_105 VDD VSS sg13g2_decap_8
XFILLER_54_425 VDD VSS sg13g2_decap_8
XFILLER_39_499 VDD VSS sg13g2_fill_2
X_13743__2459 _13743_/RESET_B VDD VSS sg13g2_tiehi
XFILLER_66_285 VDD VSS sg13g2_decap_8
X_08573_ _08573_/Y _08573_/A VDD VSS sg13g2_inv_1
XFILLER_39_1301 VDD VSS sg13g2_decap_8
XFILLER_25_39 VDD VSS sg13g2_decap_8
XFILLER_78_1394 VDD VSS sg13g2_decap_8
XFILLER_35_683 VDD VSS sg13g2_decap_8
XFILLER_23_834 VDD VSS sg13g2_decap_8
XFILLER_74_1247 VDD VSS sg13g2_decap_8
XFILLER_35_694 VDD VSS sg13g2_fill_1
XFILLER_165_1364 VDD VSS sg13g2_decap_8
XFILLER_39_1378 VDD VSS sg13g2_decap_8
XFILLER_179_165 VDD VSS sg13g2_decap_8
Xclkbuf_5_21__f_clk_i clkbuf_leaf_94_clk_i/A clkbuf_4_10_0_clk_i/X VDD VSS sg13g2_buf_16
XFILLER_22_344 VDD VSS sg13g2_fill_2
X_14123__2079 _14123_/RESET_B VDD VSS sg13g2_tiehi
XFILLER_10_539 VDD VSS sg13g2_decap_8
XFILLER_124_1061 VDD VSS sg13g2_decap_8
XFILLER_109_917 VDD VSS sg13g2_fill_2
X_09125_ _09125_/X _09137_/A _09125_/B _09157_/C VDD VSS sg13g2_or3_1
XFILLER_41_49 VDD VSS sg13g2_decap_8
XFILLER_182_319 VDD VSS sg13g2_decap_8
X_09056_ _09089_/C _14909_/Q _14908_/Q _09056_/C VDD VSS sg13g2_and3_1
XFILLER_124_909 VDD VSS sg13g2_fill_2
XFILLER_68_1018 VDD VSS sg13g2_decap_8
XFILLER_159_1157 VDD VSS sg13g2_decap_8
XFILLER_135_268 VDD VSS sg13g2_fill_2
X_08007_ _08008_/B _08005_/X _08146_/A _08599_/B VDD VSS sg13g2_mux2_1
XFILLER_11_1275 VDD VSS sg13g2_decap_8
XFILLER_150_205 VDD VSS sg13g2_fill_1
XFILLER_116_482 VDD VSS sg13g2_fill_2
XFILLER_144_791 VDD VSS sg13g2_decap_8
XFILLER_176_1471 VDD VSS sg13g2_decap_4
XFILLER_9_7 VDD VSS sg13g2_decap_8
XFILLER_46_1316 VDD VSS sg13g2_decap_8
XFILLER_2_749 VDD VSS sg13g2_decap_8
XFILLER_85_1376 VDD VSS sg13g2_decap_8
XFILLER_104_644 VDD VSS sg13g2_fill_1
XFILLER_131_430 VDD VSS sg13g2_decap_8
X_14300__1902 _14300_/RESET_B VDD VSS sg13g2_tiehi
XFILLER_104_666 VDD VSS sg13g2_decap_8
XFILLER_1_259 VDD VSS sg13g2_decap_8
XFILLER_89_366 VDD VSS sg13g2_fill_1
XFILLER_77_506 VDD VSS sg13g2_decap_8
XFILLER_172_1368 VDD VSS sg13g2_decap_8
X_09958_ _14542_/D _14542_/Q _10057_/A0 _09958_/S VDD VSS sg13g2_mux2_1
XFILLER_89_399 VDD VSS sg13g2_decap_8
X_13676__2543 _13676_/RESET_B VDD VSS sg13g2_tiehi
XFILLER_131_1010 VDD VSS sg13g2_decap_8
XFILLER_44_1062 VDD VSS sg13g2_decap_8
X_08909_ _08909_/Y _08909_/A1 _08922_/S _08908_/Y VDD VSS sg13g2_a21oi_1
XFILLER_66_35 VDD VSS sg13g2_decap_8
X_09889_ _14475_/D _09889_/A0 _14475_/Q _09894_/S VDD VSS sg13g2_mux2_1
XFILLER_57_263 VDD VSS sg13g2_fill_1
XFILLER_17_105 VDD VSS sg13g2_decap_8
XFILLER_18_628 VDD VSS sg13g2_decap_8
X_11920_ _11920_/X _13839_/Q _13871_/Q _13903_/Q _13935_/Q _12072_/S0 _12072_/S1 VDD
+ VSS sg13g2_mux4_1
XFILLER_131_1076 VDD VSS sg13g2_fill_1
XFILLER_2_1421 VDD VSS sg13g2_decap_8
XFILLER_73_734 VDD VSS sg13g2_fill_2
XFILLER_72_222 VDD VSS sg13g2_fill_2
X_14927__2713 _14927_/RESET_B VDD VSS sg13g2_tiehi
XFILLER_17_149 VDD VSS sg13g2_fill_1
X_14333__1869 _14333_/RESET_B VDD VSS sg13g2_tiehi
X_11851_ _11851_/X _14125_/Q _14157_/Q _14189_/Q _14221_/Q _11963_/S0 _11963_/S1 VDD
+ VSS sg13g2_mux4_1
XFILLER_79_1169 VDD VSS sg13g2_decap_8
XFILLER_122_63 VDD VSS sg13g2_decap_8
X_13719__2483 _13719_/RESET_B VDD VSS sg13g2_tiehi
XFILLER_57_1401 VDD VSS sg13g2_decap_8
XFILLER_54_970 VDD VSS sg13g2_fill_2
X_10802_ _10802_/Y _10802_/A _12346_/A VDD VSS sg13g2_nor2b_1
XFILLER_60_417 VDD VSS sg13g2_decap_8
X_14570_ _14570_/Q _14602_/CLK _14570_/D _14570_/RESET_B VDD VSS sg13g2_dfrbpq_1
XFILLER_60_428 VDD VSS sg13g2_fill_2
XFILLER_32_119 VDD VSS sg13g2_decap_8
XFILLER_183_1442 VDD VSS sg13g2_decap_8
X_11782_ _11782_/X _13835_/Q _13867_/Q _13899_/Q _13931_/Q _11786_/S0 _11786_/S1 VDD
+ VSS sg13g2_mux4_1
XFILLER_72_299 VDD VSS sg13g2_decap_8
XFILLER_41_620 VDD VSS sg13g2_decap_8
XFILLER_144_1415 VDD VSS sg13g2_decap_8
XFILLER_13_333 VDD VSS sg13g2_decap_8
X_13521_ _13521_/X _13521_/A _13566_/C VDD VSS sg13g2_and2_1
X_10733_ _10734_/A _14911_/Q _11001_/B _11056_/B1 _11042_/D VDD VSS sg13g2_a22oi_1
X_15193__2796 _15193_/RESET_B VDD VSS sg13g2_tiehi
X_13898__2304 _13898_/RESET_B VDD VSS sg13g2_tiehi
XFILLER_9_315 VDD VSS sg13g2_decap_8
XFILLER_16_1120 VDD VSS sg13g2_decap_8
XFILLER_186_658 VDD VSS sg13g2_decap_8
X_13452_ _13454_/C _15184_/Q _15185_/Q VDD VSS sg13g2_nor2_1
XFILLER_139_530 VDD VSS sg13g2_decap_8
X_10664_ _14893_/D _10664_/A _13328_/A _10664_/C VDD VSS sg13g2_nor3_1
XFILLER_167_850 VDD VSS sg13g2_decap_8
XFILLER_51_1033 VDD VSS sg13g2_fill_2
XFILLER_185_168 VDD VSS sg13g2_decap_8
X_12403_ _12403_/Y _13499_/B _13300_/C _12403_/B1 VDD VSS sg13g2_a21oi_1
X_13383_ _15080_/D _13378_/C _13455_/A _13380_/Y VDD VSS sg13g2_o21ai_1
XFILLER_126_202 VDD VSS sg13g2_decap_8
XFILLER_166_371 VDD VSS sg13g2_decap_8
X_10595_ _14875_/D _10595_/A _10595_/B _10595_/C VDD VSS sg13g2_nor3_1
XFILLER_142_1194 VDD VSS sg13g2_decap_8
XFILLER_16_1197 VDD VSS sg13g2_decap_8
X_15122_ _15122_/Q clkload82/A _15122_/D _15122_/RESET_B VDD VSS sg13g2_dfrbpq_1
X_12334_ _12334_/Y _12332_/Y _12334_/B _12334_/C VDD VSS sg13g2_nand3b_1
XFILLER_51_1099 VDD VSS sg13g2_fill_2
XFILLER_5_532 VDD VSS sg13g2_decap_8
XFILLER_177_1268 VDD VSS sg13g2_decap_8
X_15053_ _15053_/Q _15165_/CLK _15053_/D _15053_/RESET_B VDD VSS sg13g2_dfrbpq_1
XFILLER_182_897 VDD VSS sg13g2_decap_4
X_12265_ _12265_/Y _12260_/X _12143_/A _11231_/S VDD VSS sg13g2_a21oi_1
XFILLER_108_994 VDD VSS sg13g2_decap_4
X_14004_ _14004_/Q _15005_/CLK _14004_/D _14004_/RESET_B VDD VSS sg13g2_dfrbpq_1
X_11216_ _11224_/B _11216_/A _11216_/B VDD VSS sg13g2_nor2_1
XFILLER_134_290 VDD VSS sg13g2_decap_8
X_12196_ _14984_/D _12156_/Y _12195_/Y _12150_/Y VDD VSS sg13g2_a21oi_1
Xoutput60 mem_axi_araddr[30] _16883_/A VDD VSS sg13g2_buf_1
XFILLER_150_761 VDD VSS sg13g2_decap_8
Xoutput71 mem_axi_awaddr[10] _16863_/X VDD VSS sg13g2_buf_1
XFILLER_64_1449 VDD VSS sg13g2_decap_8
XFILLER_150_772 VDD VSS sg13g2_fill_1
XFILLER_151_1408 VDD VSS sg13g2_decap_8
Xoutput82 mem_axi_awaddr[21] _16874_/X VDD VSS sg13g2_buf_1
XFILLER_95_303 VDD VSS sg13g2_fill_2
Xoutput93 mem_axi_awaddr[31] _16884_/X VDD VSS sg13g2_buf_1
X_11147_ _11147_/Y _11147_/A _11163_/A VDD VSS sg13g2_nand2_1
XFILLER_122_496 VDD VSS sg13g2_decap_8
XFILLER_163_70 VDD VSS sg13g2_decap_8
XFILLER_27_1271 VDD VSS sg13g2_decap_8
XFILLER_110_658 VDD VSS sg13g2_decap_4
X_11078_ _11138_/B _11078_/A _11078_/B _11097_/A _11078_/D VDD VSS sg13g2_nor4_1
XFILLER_7_1365 VDD VSS sg13g2_decap_8
XFILLER_62_1173 VDD VSS sg13g2_decap_8
XFILLER_23_1157 VDD VSS sg13g2_decap_8
XFILLER_37_926 VDD VSS sg13g2_decap_4
X_14906_ _14906_/Q clkload55/A _14906_/D _14906_/RESET_B VDD VSS sg13g2_dfrbpq_1
X_10029_ _14611_/D _10095_/A0 _14611_/Q _10035_/S VDD VSS sg13g2_mux2_1
XFILLER_76_572 VDD VSS sg13g2_decap_8
XFILLER_64_712 VDD VSS sg13g2_decap_8
XFILLER_3_1229 VDD VSS sg13g2_decap_8
XFILLER_36_403 VDD VSS sg13g2_decap_8
XFILLER_76_583 VDD VSS sg13g2_fill_2
XFILLER_63_211 VDD VSS sg13g2_decap_8
XFILLER_149_1315 VDD VSS sg13g2_decap_8
XFILLER_91_531 VDD VSS sg13g2_decap_4
XFILLER_97_1258 VDD VSS sg13g2_decap_8
X_14837_ _14837_/Q _14848_/CLK _14837_/D _14837_/RESET_B VDD VSS sg13g2_dfrbpq_1
X_14309__1893 _14309_/RESET_B VDD VSS sg13g2_tiehi
XFILLER_63_266 VDD VSS sg13g2_decap_8
XFILLER_17_672 VDD VSS sg13g2_decap_4
XFILLER_91_586 VDD VSS sg13g2_decap_8
X_14768_ _14768_/Q clkload66/A _14768_/D _14768_/RESET_B VDD VSS sg13g2_dfrbpq_1
XFILLER_60_951 VDD VSS sg13g2_decap_8
XFILLER_177_614 VDD VSS sg13g2_decap_8
X_13719_ _16881_/A clkload56/A _13719_/D _13719_/RESET_B VDD VSS sg13g2_dfrbpq_1
XFILLER_20_804 VDD VSS sg13g2_fill_1
XFILLER_32_664 VDD VSS sg13g2_decap_4
XFILLER_177_636 VDD VSS sg13g2_decap_8
X_14699_ _14699_/Q clkload12/A _14699_/D _14699_/RESET_B VDD VSS sg13g2_dfrbpq_1
X_14488__1714 _14488_/RESET_B VDD VSS sg13g2_tiehi
XFILLER_108_1089 VDD VSS sg13g2_fill_2
XFILLER_20_859 VDD VSS sg13g2_decap_8
XFILLER_121_1212 VDD VSS sg13g2_fill_1
XFILLER_176_168 VDD VSS sg13g2_decap_8
XFILLER_34_1264 VDD VSS sg13g2_decap_8
XFILLER_160_1283 VDD VSS sg13g2_decap_8
XFILLER_117_202 VDD VSS sg13g2_decap_8
XFILLER_145_511 VDD VSS sg13g2_fill_1
XFILLER_9_882 VDD VSS sg13g2_decap_8
XFILLER_157_393 VDD VSS sg13g2_decap_8
XFILLER_68_0 VDD VSS sg13g2_decap_8
XFILLER_145_566 VDD VSS sg13g2_decap_8
XFILLER_172_352 VDD VSS sg13g2_decap_8
XFILLER_156_1308 VDD VSS sg13g2_decap_8
XFILLER_172_363 VDD VSS sg13g2_decap_8
XFILLER_133_728 VDD VSS sg13g2_decap_8
XFILLER_114_931 VDD VSS sg13g2_decap_4
XFILLER_114_953 VDD VSS sg13g2_fill_2
XFILLER_160_558 VDD VSS sg13g2_fill_1
XFILLER_154_1021 VDD VSS sg13g2_decap_8
Xfanout305 _11052_/A _10736_/Y VDD VSS sg13g2_buf_1
Xfanout316 _10102_/S fanout317/X VDD VSS sg13g2_buf_1
XFILLER_87_815 VDD VSS sg13g2_decap_4
XFILLER_28_1046 VDD VSS sg13g2_decap_8
X_15202__2993 _15202_/RESET_B VDD VSS sg13g2_tiehi
XFILLER_114_997 VDD VSS sg13g2_decap_8
Xfanout327 _09936_/S _09925_/S VDD VSS sg13g2_buf_1
X_09812_ _14400_/D _09911_/A1 _14400_/Q _09828_/S VDD VSS sg13g2_mux2_1
XFILLER_115_1016 VDD VSS sg13g2_decap_8
Xfanout338 _09758_/S _09760_/S VDD VSS sg13g2_buf_1
XFILLER_140_271 VDD VSS sg13g2_fill_1
Xfanout349 _09700_/S _09692_/S VDD VSS sg13g2_buf_1
XFILLER_100_113 VDD VSS sg13g2_decap_8
XFILLER_113_496 VDD VSS sg13g2_fill_2
XFILLER_132_1330 VDD VSS sg13g2_decap_8
X_09743_ _14333_/D _14333_/Q _09743_/A1 _09766_/S VDD VSS sg13g2_mux2_1
XFILLER_45_1382 VDD VSS sg13g2_decap_8
XFILLER_132_1341 VDD VSS sg13g2_fill_1
X_13976__2226 _13976_/RESET_B VDD VSS sg13g2_tiehi
XFILLER_80_1284 VDD VSS sg13g2_decap_8
XFILLER_67_550 VDD VSS sg13g2_decap_4
XFILLER_55_701 VDD VSS sg13g2_decap_4
XFILLER_39_252 VDD VSS sg13g2_decap_8
XFILLER_41_1257 VDD VSS sg13g2_decap_8
X_09674_ _09694_/S _10137_/C _09740_/B VDD VSS sg13g2_or2_1
XFILLER_54_222 VDD VSS sg13g2_fill_1
X_08625_ _08625_/Y _08625_/A _08625_/B VDD VSS sg13g2_nor2_1
XFILLER_167_1437 VDD VSS sg13g2_decap_8
XFILLER_43_918 VDD VSS sg13g2_fill_1
XFILLER_82_564 VDD VSS sg13g2_decap_4
XFILLER_43_929 VDD VSS sg13g2_fill_2
XFILLER_14_119 VDD VSS sg13g2_decap_8
X_08556_ _15241_/D _08555_/Y _08553_/Y _08545_/X VDD VSS sg13g2_o21ai_1
XFILLER_36_992 VDD VSS sg13g2_fill_1
XFILLER_78_1191 VDD VSS sg13g2_decap_8
XFILLER_165_1161 VDD VSS sg13g2_decap_8
XFILLER_23_642 VDD VSS sg13g2_decap_8
XFILLER_161_1003 VDD VSS sg13g2_decap_8
XFILLER_39_1175 VDD VSS sg13g2_decap_8
XFILLER_35_1006 VDD VSS sg13g2_fill_1
XFILLER_11_804 VDD VSS sg13g2_decap_8
XFILLER_22_130 VDD VSS sg13g2_decap_8
X_08487_ _08488_/B _07820_/B _08471_/B _07949_/C _07945_/B _13517_/A _13521_/A VDD
+ VSS sg13g2_mux4_1
XFILLER_146_7 VDD VSS sg13g2_decap_8
XFILLER_167_102 VDD VSS sg13g2_decap_8
XFILLER_51_984 VDD VSS sg13g2_decap_8
XFILLER_149_850 VDD VSS sg13g2_decap_8
XFILLER_10_336 VDD VSS sg13g2_decap_8
XFILLER_17_1462 VDD VSS sg13g2_decap_8
XFILLER_155_308 VDD VSS sg13g2_decap_8
XFILLER_7_819 VDD VSS sg13g2_decap_8
XFILLER_155_319 VDD VSS sg13g2_fill_1
XFILLER_52_1375 VDD VSS sg13g2_decap_8
XFILLER_149_894 VDD VSS sg13g2_fill_2
XFILLER_176_680 VDD VSS sg13g2_decap_8
XFILLER_182_116 VDD VSS sg13g2_decap_8
XFILLER_108_213 VDD VSS sg13g2_decap_8
XFILLER_136_522 VDD VSS sg13g2_decap_8
XFILLER_13_1348 VDD VSS sg13g2_decap_8
XFILLER_148_382 VDD VSS sg13g2_decap_4
XFILLER_176_691 VDD VSS sg13g2_fill_1
XFILLER_108_224 VDD VSS sg13g2_fill_2
X_09108_ _10757_/B _09107_/B _15044_/Q _09107_/Y VDD VSS sg13g2_o21ai_1
XFILLER_87_1405 VDD VSS sg13g2_decap_8
X_10380_ _10380_/X _14815_/Q _14816_/Q _14817_/Q _14818_/Q VDD VSS sg13g2_and4_1
XFILLER_164_875 VDD VSS sg13g2_decap_8
X_15249__2518 _15249_/RESET_B VDD VSS sg13g2_tiehi
X_09039_ _09039_/Y _15231_/Q _09060_/S VDD VSS sg13g2_nand2b_1
XFILLER_11_1072 VDD VSS sg13g2_decap_8
XFILLER_163_385 VDD VSS sg13g2_fill_1
XFILLER_184_58 VDD VSS sg13g2_decap_8
XFILLER_105_931 VDD VSS sg13g2_decap_8
X_12050_ _12050_/Y _13157_/A _12294_/A2 _12046_/Y _12049_/Y VDD VSS sg13g2_a22oi_1
XFILLER_85_1162 VDD VSS sg13g2_decap_8
XFILLER_2_546 VDD VSS sg13g2_decap_8
XFILLER_105_975 VDD VSS sg13g2_decap_8
X_11001_ _11001_/Y _11001_/A _11001_/B VDD VSS sg13g2_nand2_1
XFILLER_77_303 VDD VSS sg13g2_fill_1
XFILLER_77_314 VDD VSS sg13g2_fill_1
XFILLER_172_1165 VDD VSS sg13g2_decap_8
XFILLER_133_1127 VDD VSS sg13g2_fill_1
Xfanout850 _12380_/S1 _12674_/S1 VDD VSS sg13g2_buf_1
XFILLER_89_196 VDD VSS sg13g2_decap_8
Xfanout861 _12731_/S1 _12752_/S1 VDD VSS sg13g2_buf_1
XFILLER_77_347 VDD VSS sg13g2_decap_8
Xfanout872 _12466_/S0 fanout876/X VDD VSS sg13g2_buf_1
Xfanout883 _12698_/S0 _12425_/S0 VDD VSS sg13g2_buf_1
XFILLER_93_829 VDD VSS sg13g2_decap_8
XFILLER_19_915 VDD VSS sg13g2_decap_8
Xfanout894 fanout894/X _12589_/S0 VDD VSS sg13g2_buf_1
X_14566__1636 _14566_/RESET_B VDD VSS sg13g2_tiehi
X_15134__2712 _15134_/RESET_B VDD VSS sg13g2_tiehi
XFILLER_24_1466 VDD VSS sg13g2_decap_8
XFILLER_24_1477 VDD VSS sg13g2_fill_2
XFILLER_20_1319 VDD VSS sg13g2_decap_8
X_12952_ _12952_/Y input21/X _12795_/Y _12937_/Y VDD VSS sg13g2_o21ai_1
XFILLER_85_391 VDD VSS sg13g2_fill_2
X_11903_ _11903_/Y _11902_/Y _11892_/Y _11884_/Y _11876_/Y _11903_/C1 VDD VSS sg13g2_a221oi_1
XFILLER_73_553 VDD VSS sg13g2_decap_8
X_12883_ _12883_/X _12899_/A _12900_/C _12936_/B input25/X VDD VSS sg13g2_and4_1
X_14622_ _14622_/Q _14668_/CLK _14622_/D _14622_/RESET_B VDD VSS sg13g2_dfrbpq_1
X_11834_ _11834_/Y _11829_/X _11834_/A2 _11832_/C VDD VSS sg13g2_a21oi_1
XFILLER_2_1295 VDD VSS sg13g2_decap_8
XFILLER_109_1310 VDD VSS sg13g2_decap_4
XFILLER_60_247 VDD VSS sg13g2_decap_4
XFILLER_13_130 VDD VSS sg13g2_decap_8
X_14553_ _14553_/Q clkload44/A _14553_/D _14553_/RESET_B VDD VSS sg13g2_dfrbpq_1
X_11765_ _11765_/Y _11765_/A _11765_/B VDD VSS sg13g2_nor2_1
XFILLER_92_1155 VDD VSS sg13g2_decap_8
XFILLER_57_1275 VDD VSS sg13g2_decap_8
XFILLER_53_1106 VDD VSS sg13g2_decap_4
XFILLER_144_1234 VDD VSS sg13g2_decap_8
XFILLER_159_636 VDD VSS sg13g2_decap_8
XFILLER_42_984 VDD VSS sg13g2_decap_8
XFILLER_42_995 VDD VSS sg13g2_fill_2
XFILLER_18_1259 VDD VSS sg13g2_decap_8
X_13504_ _13504_/Y _13504_/A _15174_/D VDD VSS sg13g2_nor2b_1
X_10716_ _10716_/Y _10725_/A _10716_/B VDD VSS sg13g2_nor2_1
XFILLER_9_112 VDD VSS sg13g2_decap_8
XFILLER_53_1139 VDD VSS sg13g2_decap_8
XFILLER_70_1420 VDD VSS sg13g2_decap_8
XFILLER_186_455 VDD VSS sg13g2_decap_8
X_14484_ _14484_/Q clkload15/A _14484_/D _14484_/RESET_B VDD VSS sg13g2_dfrbpq_1
X_11696_ _11696_/Y _11696_/A _11696_/B VDD VSS sg13g2_nand2_1
XFILLER_174_628 VDD VSS sg13g2_decap_8
XFILLER_173_105 VDD VSS sg13g2_decap_8
X_13435_ _13435_/Y _13435_/A _13444_/B _13444_/C VDD VSS sg13g2_nor3_1
X_10647_ _10653_/B _10647_/A _14870_/Q _12895_/A _10647_/D VDD VSS sg13g2_and4_1
XFILLER_31_1426 VDD VSS sg13g2_decap_8
XFILLER_9_189 VDD VSS sg13g2_decap_8
XFILLER_42_92 VDD VSS sg13g2_decap_4
XFILLER_158_70 VDD VSS sg13g2_decap_8
XFILLER_167_691 VDD VSS sg13g2_fill_1
XFILLER_6_830 VDD VSS sg13g2_decap_8
XFILLER_154_330 VDD VSS sg13g2_decap_8
XFILLER_177_1010 VDD VSS sg13g2_fill_2
X_13366_ _13366_/Y _13490_/B _13400_/B _15075_/Q VDD VSS sg13g2_nand3_1
XFILLER_61_7 VDD VSS sg13g2_decap_8
X_10578_ _10580_/C _10591_/C _10583_/D _14871_/Q VDD VSS sg13g2_a21oi_1
XFILLER_127_566 VDD VSS sg13g2_fill_1
X_15105_ _15105_/Q _15203_/CLK _15105_/D _15105_/RESET_B VDD VSS sg13g2_dfrbpq_1
XFILLER_114_205 VDD VSS sg13g2_decap_8
XFILLER_127_588 VDD VSS sg13g2_fill_2
XFILLER_177_1054 VDD VSS sg13g2_decap_8
XFILLER_182_683 VDD VSS sg13g2_fill_2
X_12317_ _12317_/X _12317_/A _12324_/B VDD VSS sg13g2_and2_1
XFILLER_142_525 VDD VSS sg13g2_decap_8
X_13297_ _13297_/X _13297_/A0 _07742_/B _13297_/S VDD VSS sg13g2_mux2_1
XFILLER_181_182 VDD VSS sg13g2_decap_8
X_15036_ _15036_/Q _15228_/CLK _15036_/D _15036_/RESET_B VDD VSS sg13g2_dfrbpq_1
X_12248_ _12248_/Y _12259_/S0 _14424_/Q _12236_/C VDD VSS sg13g2_a21oi_1
XFILLER_9_1416 VDD VSS sg13g2_decap_8
XFILLER_111_901 VDD VSS sg13g2_decap_8
XFILLER_69_815 VDD VSS sg13g2_decap_8
XFILLER_116_1314 VDD VSS sg13g2_decap_4
XFILLER_174_91 VDD VSS sg13g2_decap_8
XFILLER_64_1246 VDD VSS sg13g2_decap_8
XFILLER_29_1366 VDD VSS sg13g2_decap_8
XFILLER_25_1208 VDD VSS sg13g2_decap_8
X_12179_ _12179_/Y _12175_/Y _12176_/Y _12178_/Y _12177_/Y _12190_/B VDD VSS sg13g2_a221oi_1
XFILLER_111_945 VDD VSS sg13g2_decap_8
XFILLER_122_271 VDD VSS sg13g2_decap_8
XFILLER_96_634 VDD VSS sg13g2_decap_8
XFILLER_3_53 VDD VSS sg13g2_decap_8
XFILLER_155_1396 VDD VSS sg13g2_decap_8
XFILLER_95_122 VDD VSS sg13g2_fill_2
XFILLER_116_1358 VDD VSS sg13g2_decap_8
XFILLER_96_667 VDD VSS sg13g2_decap_8
XFILLER_84_829 VDD VSS sg13g2_fill_1
XFILLER_83_306 VDD VSS sg13g2_decap_8
XFILLER_7_1162 VDD VSS sg13g2_decap_8
XFILLER_27_1090 VDD VSS sg13g2_decap_8
XFILLER_95_177 VDD VSS sg13g2_fill_1
XFILLER_3_1026 VDD VSS sg13g2_decap_8
XFILLER_37_745 VDD VSS sg13g2_decap_8
XFILLER_114_1093 VDD VSS sg13g2_decap_8
XFILLER_149_1112 VDD VSS sg13g2_fill_1
XFILLER_149_1123 VDD VSS sg13g2_decap_4
XFILLER_184_1003 VDD VSS sg13g2_decap_8
XFILLER_92_873 VDD VSS sg13g2_decap_4
XFILLER_52_704 VDD VSS sg13g2_decap_8
XFILLER_92_884 VDD VSS sg13g2_decap_8
XFILLER_52_715 VDD VSS sg13g2_fill_1
X_08410_ _08410_/X _08410_/A _08410_/B _08410_/C _08410_/D VDD VSS sg13g2_and4_1
XFILLER_149_1156 VDD VSS sg13g2_decap_8
XFILLER_64_586 VDD VSS sg13g2_decap_8
X_09390_ _13993_/D _09953_/A1 _13993_/Q _09401_/S VDD VSS sg13g2_mux2_1
XFILLER_64_597 VDD VSS sg13g2_decap_4
XFILLER_184_1058 VDD VSS sg13g2_decap_8
XFILLER_52_748 VDD VSS sg13g2_fill_2
XFILLER_24_439 VDD VSS sg13g2_decap_8
XFILLER_17_480 VDD VSS sg13g2_decap_8
XFILLER_75_1342 VDD VSS sg13g2_decap_8
X_08341_ _08341_/Y _08340_/A _08339_/Y _08340_/Y VDD VSS sg13g2_o21ai_1
XFILLER_127_1432 VDD VSS sg13g2_decap_4
XFILLER_149_102 VDD VSS sg13g2_decap_8
XFILLER_178_934 VDD VSS sg13g2_decap_8
XFILLER_149_113 VDD VSS sg13g2_fill_2
XFILLER_36_1348 VDD VSS sg13g2_decap_8
XFILLER_33_995 VDD VSS sg13g2_decap_4
XFILLER_32_472 VDD VSS sg13g2_decap_8
XFILLER_178_967 VDD VSS sg13g2_decap_8
X_08272_ _08603_/B _08244_/B _08082_/X _08688_/B VDD VSS sg13g2_o21ai_1
XFILLER_32_483 VDD VSS sg13g2_fill_2
XFILLER_162_1367 VDD VSS sg13g2_decap_8
XFILLER_177_455 VDD VSS sg13g2_decap_8
XFILLER_149_157 VDD VSS sg13g2_decap_8
XFILLER_165_617 VDD VSS sg13g2_decap_8
XFILLER_20_656 VDD VSS sg13g2_decap_8
XFILLER_164_105 VDD VSS sg13g2_decap_8
XFILLER_20_667 VDD VSS sg13g2_fill_2
X_14040__2162 _14040_/RESET_B VDD VSS sg13g2_tiehi
X_14911__2745 _14911_/RESET_B VDD VSS sg13g2_tiehi
X_15171__1452 _15171_/RESET_B VDD VSS sg13g2_tiehi
XFILLER_145_330 VDD VSS sg13g2_fill_1
XFILLER_118_566 VDD VSS sg13g2_fill_1
XFILLER_133_503 VDD VSS sg13g2_fill_1
XFILLER_146_886 VDD VSS sg13g2_decap_8
XFILLER_173_672 VDD VSS sg13g2_decap_8
XFILLER_173_683 VDD VSS sg13g2_fill_2
X_14644__1558 _14644_/RESET_B VDD VSS sg13g2_tiehi
XFILLER_69_1157 VDD VSS sg13g2_decap_8
XFILLER_145_385 VDD VSS sg13g2_decap_4
XFILLER_156_1127 VDD VSS sg13g2_fill_1
XFILLER_160_333 VDD VSS sg13g2_decap_8
XFILLER_161_856 VDD VSS sg13g2_decap_8
XFILLER_172_193 VDD VSS sg13g2_decap_8
XFILLER_133_558 VDD VSS sg13g2_fill_2
X_14944__2679 _14944_/RESET_B VDD VSS sg13g2_tiehi
XFILLER_82_1302 VDD VSS sg13g2_decap_8
XFILLER_154_28 VDD VSS sg13g2_decap_8
XFILLER_87_601 VDD VSS sg13g2_decap_8
XFILLER_173_1463 VDD VSS sg13g2_decap_8
XFILLER_99_472 VDD VSS sg13g2_decap_8
XFILLER_47_1466 VDD VSS sg13g2_decap_8
XFILLER_87_623 VDD VSS sg13g2_decap_4
XFILLER_43_1308 VDD VSS sg13g2_decap_8
Xfanout146 _09937_/A1 _09166_/Y VDD VSS sg13g2_buf_1
XFILLER_82_1379 VDD VSS sg13g2_decap_8
Xfanout157 _10166_/A1 _09145_/Y VDD VSS sg13g2_buf_1
XFILLER_86_133 VDD VSS sg13g2_decap_4
Xfanout168 _10164_/A1 _10064_/A0 VDD VSS sg13g2_buf_1
Xfanout179 _10062_/A0 _10095_/A0 VDD VSS sg13g2_buf_1
X_07987_ _07987_/Y _13290_/B _13307_/A _13506_/A _13290_/A VDD VSS sg13g2_nand4_1
XFILLER_87_678 VDD VSS sg13g2_decap_8
XFILLER_59_369 VDD VSS sg13g2_decap_8
XFILLER_101_466 VDD VSS sg13g2_fill_1
XFILLER_41_1032 VDD VSS sg13g2_decap_8
XFILLER_101_488 VDD VSS sg13g2_decap_8
X_15012__2598 _15012_/RESET_B VDD VSS sg13g2_tiehi
X_09726_ _14317_/D _09726_/A0 _14317_/Q _09729_/S VDD VSS sg13g2_mux2_1
X_09657_ _14250_/D _09723_/A0 _14250_/Q _09663_/S VDD VSS sg13g2_mux2_1
XFILLER_76_1106 VDD VSS sg13g2_decap_8
XFILLER_103_54 VDD VSS sg13g2_fill_2
XFILLER_167_1234 VDD VSS sg13g2_decap_8
XFILLER_28_789 VDD VSS sg13g2_decap_8
XFILLER_83_884 VDD VSS sg13g2_fill_2
XFILLER_76_1128 VDD VSS sg13g2_decap_8
X_15122__2738 _15122_/RESET_B VDD VSS sg13g2_tiehi
X_08608_ _08608_/Y _08608_/A _08608_/B _08641_/C VDD VSS sg13g2_nor3_1
XFILLER_70_523 VDD VSS sg13g2_decap_8
X_14250__1952 _14250_/RESET_B VDD VSS sg13g2_tiehi
X_09588_ _14185_/D _14185_/Q _09656_/A0 _09590_/S VDD VSS sg13g2_mux2_1
XFILLER_128_1229 VDD VSS sg13g2_decap_8
XFILLER_179_25 VDD VSS sg13g2_decap_8
X_08539_ _08539_/Y _08378_/Y _08484_/B _08539_/B1 VDD VSS sg13g2_a21oi_1
XFILLER_23_450 VDD VSS sg13g2_fill_2
XFILLER_93_1475 VDD VSS sg13g2_decap_4
XFILLER_168_422 VDD VSS sg13g2_decap_8
XFILLER_180_1434 VDD VSS sg13g2_decap_8
XFILLER_54_1437 VDD VSS sg13g2_decap_8
X_11550_ _11550_/Y _11551_/A1 _13828_/Q VDD VSS sg13g2_nand2b_1
XFILLER_11_634 VDD VSS sg13g2_decap_8
XFILLER_180_1478 VDD VSS sg13g2_fill_1
XFILLER_10_133 VDD VSS sg13g2_decap_8
XFILLER_183_403 VDD VSS sg13g2_decap_8
X_10501_ _10502_/C _14852_/Q _10513_/D _14850_/Q _14849_/Q VDD VSS sg13g2_nand4_1
XFILLER_7_616 VDD VSS sg13g2_decap_8
X_11481_ _14963_/D _11461_/A _11723_/A2 _11480_/Y VDD VSS sg13g2_a21o_1
XFILLER_137_831 VDD VSS sg13g2_decap_8
XFILLER_52_1172 VDD VSS sg13g2_decap_8
XFILLER_155_138 VDD VSS sg13g2_decap_8
X_13220_ _13220_/Y _14794_/Q _13275_/A2 _13262_/B1 VDD VSS sg13g2_o21ai_1
XFILLER_13_1145 VDD VSS sg13g2_decap_8
X_10432_ _14833_/D _14833_/Q _10434_/C _10431_/Y VDD VSS sg13g2_a21oi_1
XFILLER_87_1213 VDD VSS sg13g2_decap_8
XFILLER_6_137 VDD VSS sg13g2_decap_8
XFILLER_136_341 VDD VSS sg13g2_decap_8
XFILLER_178_1341 VDD VSS sg13g2_decap_8
XFILLER_152_812 VDD VSS sg13g2_fill_1
XFILLER_12_84 VDD VSS sg13g2_decap_8
X_13151_ _13151_/Y _14821_/Q _13068_/B _07728_/C _14885_/Q _13248_/B VDD VSS sg13g2_a221oi_1
XFILLER_139_1325 VDD VSS sg13g2_decap_8
X_10363_ _10365_/A _14812_/Q _10359_/Y _14813_/Q VDD VSS sg13g2_a21o_1
X_12102_ _12102_/Y _12112_/A1 _14388_/Q VDD VSS sg13g2_nand2b_1
XFILLER_174_1238 VDD VSS sg13g2_decap_8
XFILLER_3_844 VDD VSS sg13g2_decap_8
X_13082_ _13085_/A _14784_/Q _13082_/B VDD VSS sg13g2_nand2_1
XFILLER_151_355 VDD VSS sg13g2_fill_2
X_10294_ _10295_/B _14791_/Q _14792_/Q _10294_/C VDD VSS sg13g2_nand3_1
XFILLER_97_409 VDD VSS sg13g2_decap_8
XFILLER_2_343 VDD VSS sg13g2_decap_8
X_12033_ _12033_/Y _12235_/A _14514_/Q _12233_/B VDD VSS sg13g2_a21oi_1
XFILLER_120_742 VDD VSS sg13g2_decap_8
XFILLER_78_667 VDD VSS sg13g2_fill_1
XFILLER_8_1460 VDD VSS sg13g2_decap_8
XFILLER_66_818 VDD VSS sg13g2_decap_4
XFILLER_4_1302 VDD VSS sg13g2_decap_8
Xfanout680 _10824_/C1 _07703_/Y VDD VSS sg13g2_buf_1
XFILLER_92_103 VDD VSS sg13g2_decap_8
XFILLER_65_317 VDD VSS sg13g2_fill_1
Xfanout691 _11722_/B2 _11860_/B1 VDD VSS sg13g2_buf_1
XFILLER_24_1263 VDD VSS sg13g2_decap_8
X_13984_ _13984_/Q _14528_/CLK _13984_/D _13984_/RESET_B VDD VSS sg13g2_dfrbpq_1
XFILLER_19_745 VDD VSS sg13g2_decap_8
XFILLER_20_1116 VDD VSS sg13g2_decap_8
XFILLER_98_1342 VDD VSS sg13g2_decap_8
XFILLER_46_531 VDD VSS sg13g2_decap_4
XFILLER_111_1244 VDD VSS sg13g2_fill_1
XFILLER_98_1353 VDD VSS sg13g2_fill_1
X_12935_ _12937_/A _15061_/Q _15062_/Q VDD VSS sg13g2_nor2b_1
XFILLER_74_862 VDD VSS sg13g2_decap_8
XFILLER_4_1379 VDD VSS sg13g2_decap_8
XFILLER_98_1375 VDD VSS sg13g2_decap_8
XFILLER_160_60 VDD VSS sg13g2_decap_8
XFILLER_185_1334 VDD VSS sg13g2_decap_8
XFILLER_111_1288 VDD VSS sg13g2_decap_4
XFILLER_146_1307 VDD VSS sg13g2_fill_1
XFILLER_59_1359 VDD VSS sg13g2_decap_8
X_12866_ _12866_/X _12866_/A _12866_/B _12899_/C input24/X VDD VSS sg13g2_and4_1
XFILLER_2_1092 VDD VSS sg13g2_decap_8
Xclkbuf_leaf_113_clk_i clkload25/A clkbuf_5_7__f_clk_i/X VDD VSS sg13g2_buf_8
X_14605_ _14605_/Q _14637_/CLK _14605_/D _14605_/RESET_B VDD VSS sg13g2_dfrbpq_1
XFILLER_18_1012 VDD VSS sg13g2_fill_1
X_11817_ _11817_/Y _11373_/A _14412_/Q _11374_/C VDD VSS sg13g2_a21oi_1
XFILLER_18_1023 VDD VSS sg13g2_decap_8
X_12797_ _12900_/B _12997_/B _12866_/A VDD VSS sg13g2_nand2b_1
X_14536_ _14536_/Q _14728_/CLK _14536_/D _14536_/RESET_B VDD VSS sg13g2_dfrbpq_1
X_15201__2992 _15201_/RESET_B VDD VSS sg13g2_tiehi
X_11748_ _11748_/Y _11741_/A _14378_/Q VDD VSS sg13g2_nand2b_1
XFILLER_109_1184 VDD VSS sg13g2_decap_4
XFILLER_186_252 VDD VSS sg13g2_decap_8
XFILLER_30_954 VDD VSS sg13g2_decap_8
XFILLER_119_319 VDD VSS sg13g2_fill_2
XFILLER_169_91 VDD VSS sg13g2_decap_8
XFILLER_128_820 VDD VSS sg13g2_fill_2
X_14467_ _14467_/Q clkload8/A _14467_/D _14467_/RESET_B VDD VSS sg13g2_dfrbpq_1
X_11679_ _11679_/X _11696_/B _11678_/X _11677_/Y VDD VSS sg13g2_a21o_1
XFILLER_31_1223 VDD VSS sg13g2_decap_8
XFILLER_179_1127 VDD VSS sg13g2_decap_8
Xclkbuf_leaf_128_clk_i clkload9/A clkload0/A VDD VSS sg13g2_buf_8
X_13418_ _15093_/D _13444_/B _13490_/D _13416_/Y VDD VSS sg13g2_o21ai_1
XFILLER_70_1294 VDD VSS sg13g2_decap_8
XFILLER_162_609 VDD VSS sg13g2_fill_1
X_14398_ _14398_/Q _14495_/CLK _14398_/D _14398_/RESET_B VDD VSS sg13g2_dfrbpq_1
XFILLER_128_886 VDD VSS sg13g2_decap_8
XFILLER_127_363 VDD VSS sg13g2_decap_4
XFILLER_155_672 VDD VSS sg13g2_decap_8
XFILLER_154_160 VDD VSS sg13g2_decap_8
XFILLER_161_119 VDD VSS sg13g2_decap_8
XFILLER_143_834 VDD VSS sg13g2_decap_8
X_13349_ _15070_/D _13351_/C _13348_/Y _13345_/Y VDD VSS sg13g2_o21ai_1
XFILLER_66_1319 VDD VSS sg13g2_decap_8
XFILLER_157_1469 VDD VSS sg13g2_fill_1
XFILLER_88_409 VDD VSS sg13g2_decap_4
XFILLER_142_377 VDD VSS sg13g2_decap_8
XFILLER_9_1213 VDD VSS sg13g2_decap_8
XFILLER_116_1100 VDD VSS sg13g2_fill_1
X_15019_ _15019_/Q clkload47/A _15019_/D _15019_/RESET_B VDD VSS sg13g2_dfrbpq_1
X_07910_ _07910_/Y _07910_/A _07910_/B VDD VSS sg13g2_nand2_1
X_08890_ _08890_/X _15036_/Q _14940_/Q _10725_/A VDD VSS sg13g2_mux2_1
XFILLER_29_1163 VDD VSS sg13g2_decap_8
XFILLER_69_634 VDD VSS sg13g2_decap_8
X_07841_ _07841_/Y _15018_/Q _08653_/B VDD VSS sg13g2_nand2_1
XFILLER_110_252 VDD VSS sg13g2_decap_8
XFILLER_57_829 VDD VSS sg13g2_decap_8
XFILLER_111_786 VDD VSS sg13g2_decap_8
XFILLER_116_1199 VDD VSS sg13g2_decap_8
XFILLER_42_1352 VDD VSS sg13g2_decap_8
X_07772_ _07797_/A _08318_/A _08318_/B VDD VSS sg13g2_or2_1
XFILLER_110_285 VDD VSS sg13g2_decap_4
XFILLER_84_659 VDD VSS sg13g2_fill_2
X_14058__2144 _14058_/RESET_B VDD VSS sg13g2_tiehi
X_09511_ _14110_/D _09942_/A1 _14110_/Q _09523_/S VDD VSS sg13g2_mux2_1
XFILLER_77_1404 VDD VSS sg13g2_decap_8
XFILLER_65_884 VDD VSS sg13g2_decap_4
XFILLER_64_350 VDD VSS sg13g2_decap_8
XFILLER_52_501 VDD VSS sg13g2_decap_8
XFILLER_25_726 VDD VSS sg13g2_decap_8
X_09442_ _14043_/D _10138_/A1 _14043_/Q _09473_/S VDD VSS sg13g2_mux2_1
XFILLER_80_821 VDD VSS sg13g2_decap_8
XFILLER_24_203 VDD VSS sg13g2_decap_8
XFILLER_52_545 VDD VSS sg13g2_decap_8
X_15195__2788 _15195_/RESET_B VDD VSS sg13g2_tiehi
X_09373_ _13977_/D _10101_/A0 _13977_/Q _09374_/S VDD VSS sg13g2_mux2_1
XFILLER_36_1101 VDD VSS sg13g2_decap_4
XFILLER_24_258 VDD VSS sg13g2_decap_4
XFILLER_178_720 VDD VSS sg13g2_decap_8
XFILLER_36_1112 VDD VSS sg13g2_fill_1
XFILLER_80_898 VDD VSS sg13g2_fill_2
XFILLER_162_1120 VDD VSS sg13g2_decap_4
X_08324_ _08335_/A _07796_/B _08322_/Y _08323_/Y VDD VSS sg13g2_a21o_1
XFILLER_33_39 VDD VSS sg13g2_decap_8
XFILLER_178_753 VDD VSS sg13g2_fill_2
XFILLER_36_1145 VDD VSS sg13g2_decap_8
XFILLER_123_1104 VDD VSS sg13g2_decap_8
XFILLER_162_1164 VDD VSS sg13g2_decap_8
XFILLER_138_617 VDD VSS sg13g2_decap_8
XFILLER_138_628 VDD VSS sg13g2_fill_1
XFILLER_165_414 VDD VSS sg13g2_decap_8
X_08255_ _08590_/B _08431_/A _08234_/Y _08234_/B _08426_/B VDD VSS sg13g2_a22oi_1
XFILLER_165_425 VDD VSS sg13g2_fill_1
XFILLER_166_959 VDD VSS sg13g2_decap_8
XFILLER_119_831 VDD VSS sg13g2_decap_4
XFILLER_14_1443 VDD VSS sg13g2_decap_8
XFILLER_177_296 VDD VSS sg13g2_decap_8
XFILLER_20_475 VDD VSS sg13g2_fill_1
XFILLER_137_138 VDD VSS sg13g2_decap_8
XFILLER_119_853 VDD VSS sg13g2_decap_8
XFILLER_140_1462 VDD VSS sg13g2_decap_4
X_08186_ _08187_/A _07876_/Y _08184_/Y _08185_/Y VDD VSS sg13g2_o21ai_1
XFILLER_101_1446 VDD VSS sg13g2_decap_8
XFILLER_106_503 VDD VSS sg13g2_fill_1
XFILLER_152_108 VDD VSS sg13g2_fill_2
XFILLER_118_374 VDD VSS sg13g2_fill_1
XFILLER_134_823 VDD VSS sg13g2_decap_8
X_15151__2678 _15151_/RESET_B VDD VSS sg13g2_tiehi
XFILLER_145_160 VDD VSS sg13g2_decap_4
XFILLER_133_311 VDD VSS sg13g2_decap_8
Xclkbuf_leaf_92_clk_i clkload67/A clkbuf_leaf_92_clk_i/A VDD VSS sg13g2_buf_8
XFILLER_106_558 VDD VSS sg13g2_fill_2
XFILLER_106_569 VDD VSS sg13g2_decap_8
XFILLER_160_130 VDD VSS sg13g2_decap_8
XFILLER_133_366 VDD VSS sg13g2_decap_8
XFILLER_82_1110 VDD VSS sg13g2_decap_8
XFILLER_161_686 VDD VSS sg13g2_decap_8
XFILLER_58_14 VDD VSS sg13g2_decap_4
XFILLER_121_539 VDD VSS sg13g2_decap_8
X_14268__1934 _14268_/RESET_B VDD VSS sg13g2_tiehi
XFILLER_59_100 VDD VSS sg13g2_decap_4
XFILLER_173_1260 VDD VSS sg13g2_decap_8
XFILLER_47_1263 VDD VSS sg13g2_decap_8
XFILLER_138_1391 VDD VSS sg13g2_decap_8
XFILLER_0_869 VDD VSS sg13g2_decap_8
XFILLER_87_453 VDD VSS sg13g2_decap_8
XFILLER_102_775 VDD VSS sg13g2_fill_1
XFILLER_134_1266 VDD VSS sg13g2_decap_8
XFILLER_75_615 VDD VSS sg13g2_decap_8
XFILLER_60_1441 VDD VSS sg13g2_decap_8
X_14888__2791 _14888_/RESET_B VDD VSS sg13g2_tiehi
XFILLER_21_1414 VDD VSS sg13g2_decap_8
XFILLER_74_13 VDD VSS sg13g2_fill_1
XFILLER_169_1329 VDD VSS sg13g2_decap_8
XFILLER_56_840 VDD VSS sg13g2_fill_2
X_09709_ _14300_/D _09907_/A1 _14300_/Q _09739_/S VDD VSS sg13g2_mux2_1
X_10981_ _10981_/Y _11009_/D _10978_/Y _10980_/Y VDD VSS sg13g2_o21ai_1
XFILLER_56_873 VDD VSS sg13g2_decap_8
Xclkbuf_leaf_30_clk_i _14546_/CLK clkbuf_leaf_30_clk_i/A VDD VSS sg13g2_buf_8
XFILLER_167_1020 VDD VSS sg13g2_fill_1
XFILLER_28_575 VDD VSS sg13g2_decap_8
XFILLER_15_203 VDD VSS sg13g2_decap_8
XFILLER_83_681 VDD VSS sg13g2_decap_8
X_12720_ _12720_/X _12718_/X _12719_/X _12748_/S VDD VSS sg13g2_mux2_1
XFILLER_167_1053 VDD VSS sg13g2_decap_8
XFILLER_71_843 VDD VSS sg13g2_decap_8
XFILLER_3_1390 VDD VSS sg13g2_decap_8
XFILLER_82_180 VDD VSS sg13g2_fill_2
XFILLER_55_394 VDD VSS sg13g2_decap_8
XFILLER_71_854 VDD VSS sg13g2_fill_1
XFILLER_19_1310 VDD VSS sg13g2_decap_8
XFILLER_43_567 VDD VSS sg13g2_decap_8
X_12651_ _12652_/B _13129_/B _12651_/A2 _12650_/X _12386_/A _12651_/C1 VDD VSS sg13g2_a221oi_1
XFILLER_128_1059 VDD VSS sg13g2_decap_8
XFILLER_130_74 VDD VSS sg13g2_decap_8
XFILLER_169_742 VDD VSS sg13g2_decap_8
XFILLER_58_1392 VDD VSS sg13g2_decap_8
XFILLER_12_932 VDD VSS sg13g2_decap_8
XFILLER_180_1231 VDD VSS sg13g2_decap_8
X_11602_ _11602_/Y _11617_/A1 _14566_/Q VDD VSS sg13g2_nand2b_1
XFILLER_54_1234 VDD VSS sg13g2_decap_8
X_12582_ _12583_/B _13064_/B _12651_/A2 _12581_/X _12386_/A _12651_/C1 VDD VSS sg13g2_a221oi_1
XFILLER_90_56 VDD VSS sg13g2_decap_8
XFILLER_30_239 VDD VSS sg13g2_decap_8
XFILLER_141_1204 VDD VSS sg13g2_decap_4
XFILLER_168_241 VDD VSS sg13g2_decap_8
Xclkbuf_leaf_45_clk_i clkload68/A clkbuf_leaf_52_clk_i/A VDD VSS sg13g2_buf_8
XFILLER_11_431 VDD VSS sg13g2_decap_8
XFILLER_19_1387 VDD VSS sg13g2_decap_8
XFILLER_141_1226 VDD VSS sg13g2_decap_8
XFILLER_156_403 VDD VSS sg13g2_fill_1
XFILLER_15_1229 VDD VSS sg13g2_decap_8
XFILLER_168_263 VDD VSS sg13g2_fill_2
X_13756__2446 _13756_/RESET_B VDD VSS sg13g2_tiehi
XFILLER_8_914 VDD VSS sg13g2_decap_8
XFILLER_156_414 VDD VSS sg13g2_decap_8
XFILLER_157_937 VDD VSS sg13g2_decap_8
X_14321_ _14321_/Q _14417_/CLK _14321_/D _14321_/RESET_B VDD VSS sg13g2_dfrbpq_1
XFILLER_183_200 VDD VSS sg13g2_decap_8
X_11533_ _11533_/Y _11533_/A _11533_/B _11898_/C VDD VSS sg13g2_nand3_1
XFILLER_106_1368 VDD VSS sg13g2_fill_1
XFILLER_11_464 VDD VSS sg13g2_decap_8
XFILLER_7_413 VDD VSS sg13g2_decap_8
XFILLER_12_998 VDD VSS sg13g2_decap_8
XFILLER_184_756 VDD VSS sg13g2_decap_8
X_14252_ _14252_/Q _14508_/CLK _14252_/D _14252_/RESET_B VDD VSS sg13g2_dfrbpq_1
X_11464_ _11465_/B _11463_/A _11463_/C _11463_/B VDD VSS sg13g2_o21ai_1
XFILLER_137_650 VDD VSS sg13g2_decap_8
XFILLER_171_417 VDD VSS sg13g2_decap_8
XFILLER_183_277 VDD VSS sg13g2_decap_8
X_13203_ _13203_/Y _13202_/A _13202_/B _13224_/A VDD VSS sg13g2_a21oi_1
X_10415_ _14827_/D _10415_/A _10623_/A _10415_/C VDD VSS sg13g2_nor3_1
XFILLER_87_1032 VDD VSS sg13g2_decap_8
XFILLER_99_65 VDD VSS sg13g2_decap_8
X_14183_ _14183_/Q clkload5/A _14183_/D _14183_/RESET_B VDD VSS sg13g2_dfrbpq_1
X_11395_ _11395_/Y _11395_/A _11422_/B VDD VSS sg13g2_nand2_1
XFILLER_136_182 VDD VSS sg13g2_decap_8
XFILLER_152_642 VDD VSS sg13g2_decap_4
X_13971__2231 _13971_/RESET_B VDD VSS sg13g2_tiehi
X_14136__2066 _14136_/RESET_B VDD VSS sg13g2_tiehi
X_13134_ _13134_/Y _13146_/B _13146_/C _13134_/C VDD VSS sg13g2_nand3_1
X_10346_ _10352_/C _10400_/A _10397_/B VDD VSS sg13g2_nor2_1
XFILLER_3_641 VDD VSS sg13g2_decap_8
XFILLER_151_141 VDD VSS sg13g2_decap_8
XFILLER_152_675 VDD VSS sg13g2_fill_2
XFILLER_155_60 VDD VSS sg13g2_decap_4
XFILLER_2_140 VDD VSS sg13g2_decap_8
X_13065_ _13067_/C _13066_/A _13066_/C _13172_/A VDD VSS sg13g2_o21ai_1
X_10277_ _10305_/B _14786_/Q _14787_/Q VDD VSS sg13g2_and2_1
X_14748__1453 _14748_/RESET_B VDD VSS sg13g2_tiehi
Xfanout1420 _13400_/B _13405_/B VDD VSS sg13g2_buf_1
X_12016_ _12018_/A _12235_/A _13906_/Q VDD VSS sg13g2_nand2b_1
Xfanout1431 _13600_/C _13596_/B VDD VSS sg13g2_buf_1
XFILLER_65_1396 VDD VSS sg13g2_decap_8
XFILLER_26_1347 VDD VSS sg13g2_decap_8
XFILLER_79_987 VDD VSS sg13g2_fill_1
XFILLER_24_7 VDD VSS sg13g2_decap_8
XFILLER_94_924 VDD VSS sg13g2_decap_8
XFILLER_113_1328 VDD VSS sg13g2_decap_8
XFILLER_24_1060 VDD VSS sg13g2_decap_4
XFILLER_171_70 VDD VSS sg13g2_decap_8
XFILLER_0_21 VDD VSS sg13g2_decap_8
XFILLER_53_309 VDD VSS sg13g2_decap_4
XFILLER_111_1052 VDD VSS sg13g2_decap_8
XFILLER_19_564 VDD VSS sg13g2_decap_8
X_13967_ _13967_/Q _15162_/CLK _13967_/D _13967_/RESET_B VDD VSS sg13g2_dfrbpq_1
XFILLER_4_1176 VDD VSS sg13g2_decap_8
XFILLER_111_1063 VDD VSS sg13g2_fill_2
XFILLER_34_501 VDD VSS sg13g2_decap_8
XFILLER_185_1131 VDD VSS sg13g2_decap_8
X_12918_ _12918_/Y _14774_/Q _12918_/A2 _12918_/B1 VDD VSS sg13g2_o21ai_1
XFILLER_62_832 VDD VSS sg13g2_decap_8
XFILLER_0_98 VDD VSS sg13g2_decap_8
X_13898_ _13898_/Q clkload27/A _13898_/D _13898_/RESET_B VDD VSS sg13g2_dfrbpq_1
XFILLER_181_1006 VDD VSS sg13g2_fill_1
XFILLER_61_353 VDD VSS sg13g2_decap_8
X_12849_ _12849_/Y _12848_/X _12846_/Y _12878_/D VDD VSS sg13g2_o21ai_1
XFILLER_34_578 VDD VSS sg13g2_decap_8
XFILLER_61_397 VDD VSS sg13g2_decap_8
XFILLER_72_1356 VDD VSS sg13g2_decap_8
XFILLER_37_1476 VDD VSS sg13g2_fill_2
XFILLER_14_291 VDD VSS sg13g2_decap_8
XFILLER_9_63 VDD VSS sg13g2_decap_8
XFILLER_30_740 VDD VSS sg13g2_fill_1
X_14346__1856 _14346_/RESET_B VDD VSS sg13g2_tiehi
X_14519_ _14519_/Q clkload43/A _14519_/D _14519_/RESET_B VDD VSS sg13g2_dfrbpq_1
X_08040_ _08040_/Y _08334_/A1 _08016_/Y _08021_/Y _08032_/Y _08039_/Y VDD VSS sg13g2_a221oi_1
XFILLER_147_469 VDD VSS sg13g2_decap_4
XFILLER_115_300 VDD VSS sg13g2_fill_1
XFILLER_127_160 VDD VSS sg13g2_fill_1
XFILLER_174_288 VDD VSS sg13g2_decap_8
XFILLER_7_980 VDD VSS sg13g2_decap_8
XFILLER_115_311 VDD VSS sg13g2_fill_2
XFILLER_174_299 VDD VSS sg13g2_fill_2
XFILLER_157_1211 VDD VSS sg13g2_decap_8
XFILLER_171_940 VDD VSS sg13g2_decap_8
X_13801__2401 _13801_/RESET_B VDD VSS sg13g2_tiehi
X_14561__1641 _14561_/RESET_B VDD VSS sg13g2_tiehi
XFILLER_131_815 VDD VSS sg13g2_decap_4
X_09991_ _14574_/D _10057_/A0 _14574_/Q _09991_/S VDD VSS sg13g2_mux2_1
XFILLER_157_1266 VDD VSS sg13g2_decap_8
XFILLER_103_528 VDD VSS sg13g2_decap_8
XFILLER_118_1239 VDD VSS sg13g2_fill_2
XFILLER_142_185 VDD VSS sg13g2_decap_8
X_08942_ _08942_/Y _10793_/A _10793_/B _15050_/Q VDD VSS sg13g2_nand3_1
XFILLER_83_1452 VDD VSS sg13g2_decap_8
XFILLER_44_1403 VDD VSS sg13g2_decap_8
XFILLER_131_859 VDD VSS sg13g2_decap_8
Xhold3049 hold3049/X input29/X VDD VSS sg13g2_dlygate4sd3_1
XFILLER_97_740 VDD VSS sg13g2_decap_8
XFILLER_9_1043 VDD VSS sg13g2_decap_8
XFILLER_130_358 VDD VSS sg13g2_decap_8
XFILLER_85_902 VDD VSS sg13g2_decap_8
X_08873_ _08873_/Y _08873_/A _14936_/Q VDD VSS sg13g2_nor2b_1
XFILLER_97_773 VDD VSS sg13g2_decap_8
XFILLER_170_1466 VDD VSS sg13g2_decap_4
XFILLER_69_475 VDD VSS sg13g2_decap_8
XFILLER_85_946 VDD VSS sg13g2_decap_8
X_07824_ _07829_/A _08553_/A _07954_/B _08527_/A _08527_/B VDD VSS sg13g2_nor4_1
XFILLER_84_434 VDD VSS sg13g2_fill_1
X_13834__2368 _13834_/RESET_B VDD VSS sg13g2_tiehi
XFILLER_72_607 VDD VSS sg13g2_fill_1
X_07755_ _07755_/Y _08832_/D _11664_/A _13320_/C VDD VSS sg13g2_o21ai_1
XFILLER_77_1201 VDD VSS sg13g2_decap_8
XFILLER_56_169 VDD VSS sg13g2_decap_8
XFILLER_44_309 VDD VSS sg13g2_decap_8
XFILLER_25_501 VDD VSS sg13g2_decap_8
XFILLER_71_128 VDD VSS sg13g2_decap_8
XFILLER_37_383 VDD VSS sg13g2_decap_8
X_07686_ _07687_/C _13300_/B _07684_/B _07684_/Y VDD VSS sg13g2_o21ai_1
XFILLER_168_1384 VDD VSS sg13g2_decap_8
XFILLER_52_331 VDD VSS sg13g2_fill_1
XFILLER_44_38 VDD VSS sg13g2_decap_8
XFILLER_77_1278 VDD VSS sg13g2_decap_8
XFILLER_13_707 VDD VSS sg13g2_decap_8
X_09425_ _14027_/D _10154_/A1 _14027_/Q _09434_/S VDD VSS sg13g2_mux2_1
XFILLER_40_515 VDD VSS sg13g2_decap_8
XFILLER_164_1259 VDD VSS sg13g2_decap_8
XFILLER_12_217 VDD VSS sg13g2_decap_8
X_09356_ _13960_/D _09620_/A0 _13960_/Q _09362_/S VDD VSS sg13g2_mux2_1
XFILLER_166_701 VDD VSS sg13g2_decap_8
XFILLER_138_403 VDD VSS sg13g2_fill_2
X_08307_ _08312_/A _08303_/Y _08305_/Y _08306_/Y VDD VSS sg13g2_o21ai_1
XFILLER_100_77 VDD VSS sg13g2_decap_8
X_09287_ _13895_/D _13895_/Q _09720_/A0 _09296_/S VDD VSS sg13g2_mux2_1
XFILLER_100_88 VDD VSS sg13g2_decap_4
XFILLER_138_436 VDD VSS sg13g2_decap_8
XFILLER_21_795 VDD VSS sg13g2_decap_4
XFILLER_60_59 VDD VSS sg13g2_fill_1
XFILLER_14_1240 VDD VSS sg13g2_decap_8
X_08238_ _08238_/Y _08265_/A _08325_/B VDD VSS sg13g2_nor2_1
XFILLER_5_917 VDD VSS sg13g2_decap_8
XFILLER_119_672 VDD VSS sg13g2_fill_2
XFILLER_180_203 VDD VSS sg13g2_decap_8
XFILLER_181_726 VDD VSS sg13g2_decap_8
XFILLER_125_119 VDD VSS sg13g2_decap_8
XFILLER_147_992 VDD VSS sg13g2_decap_8
XFILLER_158_1019 VDD VSS sg13g2_decap_8
XFILLER_175_1300 VDD VSS sg13g2_decap_8
X_08169_ _08169_/Y _08599_/B _08052_/Y _08688_/A VDD VSS sg13g2_o21ai_1
XFILLER_4_427 VDD VSS sg13g2_decap_8
XFILLER_49_1303 VDD VSS sg13g2_decap_8
XFILLER_109_53 VDD VSS sg13g2_decap_8
XFILLER_146_480 VDD VSS sg13g2_decap_8
XFILLER_10_1148 VDD VSS sg13g2_decap_8
XFILLER_84_1205 VDD VSS sg13g2_decap_8
XFILLER_107_856 VDD VSS sg13g2_decap_8
XFILLER_118_193 VDD VSS sg13g2_decap_8
X_10200_ _14757_/D _15181_/D _14757_/Q _10202_/S VDD VSS sg13g2_mux2_1
XFILLER_162_962 VDD VSS sg13g2_fill_1
X_11180_ _11190_/A _11180_/A _11181_/A _11180_/C VDD VSS sg13g2_nand3_1
XFILLER_109_97 VDD VSS sg13g2_decap_8
XFILLER_136_1317 VDD VSS sg13g2_decap_8
XFILLER_175_1377 VDD VSS sg13g2_decap_8
X_10131_ _14709_/D _10164_/A1 _14709_/Q _10134_/S VDD VSS sg13g2_mux2_1
XFILLER_161_494 VDD VSS sg13g2_decap_4
XFILLER_0_644 VDD VSS sg13g2_decap_8
XFILLER_88_740 VDD VSS sg13g2_decap_8
X_10062_ _14643_/D _10062_/A0 _14643_/Q _10068_/S VDD VSS sg13g2_mux2_1
X_15200__2991 _15200_/RESET_B VDD VSS sg13g2_tiehi
XFILLER_47_1093 VDD VSS sg13g2_decap_8
XFILLER_48_637 VDD VSS sg13g2_decap_8
XFILLER_47_114 VDD VSS sg13g2_fill_2
X_14870_ _14870_/Q clkload83/A _14870_/D _14870_/RESET_B VDD VSS sg13g2_dfrbpq_1
XFILLER_87_294 VDD VSS sg13g2_decap_8
XFILLER_76_957 VDD VSS sg13g2_decap_8
XFILLER_76_968 VDD VSS sg13g2_fill_1
XFILLER_21_1211 VDD VSS sg13g2_decap_8
X_13821_ _13821_/Q clkload30/A _13821_/D _13821_/RESET_B VDD VSS sg13g2_dfrbpq_1
X_14424__1778 _14424_/RESET_B VDD VSS sg13g2_tiehi
XFILLER_5_1463 VDD VSS sg13g2_decap_8
XFILLER_90_404 VDD VSS sg13g2_decap_8
XFILLER_5_1474 VDD VSS sg13g2_fill_1
XFILLER_112_1361 VDD VSS sg13g2_decap_8
XFILLER_1_1316 VDD VSS sg13g2_decap_8
XFILLER_28_350 VDD VSS sg13g2_fill_2
XFILLER_141_40 VDD VSS sg13g2_decap_8
XFILLER_90_415 VDD VSS sg13g2_fill_1
XFILLER_62_106 VDD VSS sg13g2_fill_2
XFILLER_29_884 VDD VSS sg13g2_decap_8
XFILLER_95_1323 VDD VSS sg13g2_decap_8
XFILLER_56_692 VDD VSS sg13g2_decap_8
XFILLER_28_383 VDD VSS sg13g2_decap_8
XFILLER_21_1288 VDD VSS sg13g2_decap_8
X_13752_ _13752_/Q clkload46/A _13752_/D _13752_/RESET_B VDD VSS sg13g2_dfrbpq_1
XFILLER_186_1462 VDD VSS sg13g2_decap_8
X_10964_ _10964_/Y _11004_/B _10964_/B VDD VSS sg13g2_xnor2_1
XFILLER_90_459 VDD VSS sg13g2_decap_8
XFILLER_56_1318 VDD VSS sg13g2_decap_8
X_12703_ _12703_/X _13748_/Q _14100_/Q _14452_/Q _14548_/Q _12703_/S0 _12703_/S1 VDD
+ VSS sg13g2_mux4_1
X_13683_ _13683_/Q clkload62/A _13683_/D _13683_/RESET_B VDD VSS sg13g2_dfrbpq_1
XFILLER_147_1468 VDD VSS sg13g2_decap_8
XFILLER_182_1348 VDD VSS sg13g2_decap_8
X_10895_ _10895_/Y _10948_/A _10893_/X _10898_/B1 VDD VSS sg13g2_o21ai_1
X_13989__2213 _13989_/RESET_B VDD VSS sg13g2_tiehi
X_12634_ _12634_/X _12631_/X _12630_/X _12627_/X _12626_/X _12663_/S1 _12664_/S VDD
+ VSS sg13g2_mux4_1
XFILLER_31_559 VDD VSS sg13g2_decap_8
XFILLER_145_1170 VDD VSS sg13g2_decap_8
XFILLER_19_1184 VDD VSS sg13g2_decap_8
XFILLER_15_1026 VDD VSS sg13g2_decap_8
XFILLER_8_711 VDD VSS sg13g2_decap_8
X_12565_ _12565_/X _12564_/X _12563_/X _12560_/X _12559_/X _12622_/S0 _12623_/S VDD
+ VSS sg13g2_mux4_1
XFILLER_54_1086 VDD VSS sg13g2_decap_8
XFILLER_184_531 VDD VSS sg13g2_decap_8
XFILLER_7_210 VDD VSS sg13g2_decap_8
XFILLER_106_1165 VDD VSS sg13g2_decap_8
XFILLER_157_767 VDD VSS sg13g2_decap_4
X_14304_ _14304_/Q clkload25/A _14304_/D _14304_/RESET_B VDD VSS sg13g2_dfrbpq_1
XFILLER_117_609 VDD VSS sg13g2_fill_2
X_11516_ _11516_/Y _11516_/A VDD VSS sg13g2_inv_1
XFILLER_89_1127 VDD VSS sg13g2_decap_8
XFILLER_141_1078 VDD VSS sg13g2_decap_8
XFILLER_32_1351 VDD VSS sg13g2_decap_8
XFILLER_138_970 VDD VSS sg13g2_decap_8
X_12496_ _12496_/X _12494_/X _12493_/X _12490_/X _12489_/X _12608_/S1 _12608_/S0 VDD
+ VSS sg13g2_mux4_1
XFILLER_8_788 VDD VSS sg13g2_decap_8
X_14235_ _14235_/Q clkload79/A _14235_/D _14235_/RESET_B VDD VSS sg13g2_dfrbpq_1
X_11447_ _11448_/A _12092_/C _11444_/X _11446_/Y VDD VSS sg13g2_o21ai_1
XFILLER_7_287 VDD VSS sg13g2_decap_8
XFILLER_172_759 VDD VSS sg13g2_decap_8
XFILLER_166_70 VDD VSS sg13g2_decap_8
XFILLER_125_653 VDD VSS sg13g2_fill_2
X_14166_ _14166_/Q _14588_/CLK _14166_/D _14166_/RESET_B VDD VSS sg13g2_dfrbpq_1
X_11378_ _11378_/X _11369_/Y _11377_/Y _11765_/A VDD VSS sg13g2_mux2_1
XFILLER_67_1458 VDD VSS sg13g2_decap_8
XFILLER_124_163 VDD VSS sg13g2_decap_8
XFILLER_125_697 VDD VSS sg13g2_decap_8
XFILLER_180_781 VDD VSS sg13g2_fill_2
X_13117_ _13120_/A _13078_/A _13113_/X _13171_/A VDD VSS sg13g2_a21oi_1
X_10329_ _10331_/A _10405_/C _10345_/C _14803_/Q VDD VSS sg13g2_a21o_1
XFILLER_98_537 VDD VSS sg13g2_decap_8
XFILLER_4_994 VDD VSS sg13g2_decap_8
X_14097_ _14097_/Q _15139_/CLK _14097_/D _14097_/RESET_B VDD VSS sg13g2_dfrbpq_1
XFILLER_140_656 VDD VSS sg13g2_decap_8
XFILLER_61_1002 VDD VSS sg13g2_fill_2
X_13048_ _13048_/X _13048_/A _13048_/B VDD VSS sg13g2_and2_1
XFILLER_65_1193 VDD VSS sg13g2_decap_8
XFILLER_26_1144 VDD VSS sg13g2_decap_8
XFILLER_79_784 VDD VSS sg13g2_decap_8
Xfanout1250 _12142_/S1 _11999_/S1 VDD VSS sg13g2_buf_1
Xfanout1261 _12143_/A _12291_/A VDD VSS sg13g2_buf_1
Xfanout1272 _07654_/A fanout1281/X VDD VSS sg13g2_buf_1
Xfanout1283 _12091_/C _12114_/S1 VDD VSS sg13g2_buf_1
Xfanout1294 _11391_/B fanout1298/X VDD VSS sg13g2_buf_1
XFILLER_93_242 VDD VSS sg13g2_decap_4
XFILLER_94_787 VDD VSS sg13g2_decap_4
XFILLER_54_618 VDD VSS sg13g2_decap_8
XFILLER_130_1461 VDD VSS sg13g2_decap_8
X_14999_ _14999_/Q clkload22/A _14999_/D _14999_/RESET_B VDD VSS sg13g2_dfrbpq_1
XFILLER_35_810 VDD VSS sg13g2_decap_8
XFILLER_75_990 VDD VSS sg13g2_fill_2
XFILLER_19_383 VDD VSS sg13g2_decap_8
XFILLER_35_854 VDD VSS sg13g2_fill_1
XFILLER_35_865 VDD VSS sg13g2_decap_8
XFILLER_179_314 VDD VSS sg13g2_decap_8
XFILLER_74_1429 VDD VSS sg13g2_decap_8
XFILLER_34_353 VDD VSS sg13g2_decap_8
XFILLER_179_325 VDD VSS sg13g2_fill_2
XFILLER_179_358 VDD VSS sg13g2_fill_2
X_09210_ _13821_/D _09875_/A0 _13821_/Q _09238_/S VDD VSS sg13g2_mux2_1
X_14579__1623 _14579_/RESET_B VDD VSS sg13g2_tiehi
XFILLER_98_0 VDD VSS sg13g2_decap_8
XFILLER_72_1153 VDD VSS sg13g2_decap_8
X_09141_ _09145_/A _09141_/A _10781_/A _10793_/B VDD VSS sg13g2_nand3_1
XFILLER_37_1273 VDD VSS sg13g2_decap_8
XFILLER_30_570 VDD VSS sg13g2_decap_8
XFILLER_108_609 VDD VSS sg13g2_fill_1
X_09072_ _09072_/Y _15236_/Q _09078_/B VDD VSS sg13g2_nand2b_1
XFILLER_129_970 VDD VSS sg13g2_decap_8
XFILLER_107_108 VDD VSS sg13g2_fill_1
XFILLER_135_417 VDD VSS sg13g2_decap_8
XFILLER_175_586 VDD VSS sg13g2_decap_8
XFILLER_30_18 VDD VSS sg13g2_decap_8
X_08023_ _08023_/Y _08023_/A _08023_/B VDD VSS sg13g2_nand2_1
XFILLER_162_214 VDD VSS sg13g2_fill_1
XFILLER_159_1339 VDD VSS sg13g2_decap_8
XFILLER_162_236 VDD VSS sg13g2_decap_8
XFILLER_11_1457 VDD VSS sg13g2_decap_8
XFILLER_146_29 VDD VSS sg13g2_decap_8
XFILLER_116_697 VDD VSS sg13g2_fill_1
XFILLER_89_548 VDD VSS sg13g2_decap_8
XFILLER_118_1036 VDD VSS sg13g2_decap_8
XFILLER_130_111 VDD VSS sg13g2_fill_1
X_09974_ _14557_/D _10040_/A0 _14557_/Q _10002_/S VDD VSS sg13g2_mux2_1
XFILLER_44_1200 VDD VSS sg13g2_decap_8
XFILLER_130_144 VDD VSS sg13g2_decap_8
XFILLER_48_1391 VDD VSS sg13g2_decap_8
XFILLER_135_1350 VDD VSS sg13g2_fill_2
X_08925_ _08925_/X _08924_/X _08925_/A1 _08928_/S VDD VSS sg13g2_mux2_1
XFILLER_131_689 VDD VSS sg13g2_fill_1
XFILLER_162_39 VDD VSS sg13g2_decap_8
XFILLER_85_721 VDD VSS sg13g2_decap_8
XFILLER_58_935 VDD VSS sg13g2_fill_1
XFILLER_112_892 VDD VSS sg13g2_fill_2
XFILLER_170_1263 VDD VSS sg13g2_decap_8
XFILLER_44_1277 VDD VSS sg13g2_decap_8
X_08856_ _08856_/X _15027_/Q _14931_/Q _10675_/A VDD VSS sg13g2_mux2_1
XFILLER_111_391 VDD VSS sg13g2_decap_8
XFILLER_85_765 VDD VSS sg13g2_fill_1
XFILLER_79_1318 VDD VSS sg13g2_decap_8
X_07807_ _07828_/C _07950_/A _07949_/B _07807_/C _08476_/A VDD VSS sg13g2_nand4_1
XFILLER_45_618 VDD VSS sg13g2_fill_2
X_08787_ _08787_/Y _13681_/Q _08787_/B VDD VSS sg13g2_nor2_1
XFILLER_176_7 VDD VSS sg13g2_decap_8
XFILLER_73_949 VDD VSS sg13g2_decap_8
XFILLER_38_692 VDD VSS sg13g2_decap_4
X_07738_ _07738_/Y _13356_/B _13297_/S _07754_/B VDD VSS sg13g2_nand3_1
XFILLER_77_1053 VDD VSS sg13g2_fill_1
XFILLER_168_1181 VDD VSS sg13g2_decap_8
XFILLER_25_353 VDD VSS sg13g2_decap_8
XFILLER_111_43 VDD VSS sg13g2_decap_8
XFILLER_13_515 VDD VSS sg13g2_decap_8
X_07669_ _10172_/C _13508_/B _13477_/S _10171_/D VDD VSS sg13g2_o21ai_1
XFILLER_71_14 VDD VSS sg13g2_decap_8
X_09408_ _09408_/Y _10037_/B _09441_/D VDD VSS sg13g2_nand2_1
X_10680_ _10844_/B _08980_/X _08844_/A _08844_/Y VDD VSS sg13g2_a21o_1
XFILLER_139_701 VDD VSS sg13g2_decap_8
XFILLER_16_1302 VDD VSS sg13g2_decap_8
XFILLER_107_1452 VDD VSS sg13g2_decap_8
XFILLER_138_211 VDD VSS sg13g2_fill_2
XFILLER_166_520 VDD VSS sg13g2_decap_8
X_09339_ _13946_/D _09904_/A0 _13946_/Q _09339_/S VDD VSS sg13g2_mux2_1
XFILLER_55_1384 VDD VSS sg13g2_decap_8
XFILLER_178_380 VDD VSS sg13g2_decap_8
XFILLER_142_1354 VDD VSS sg13g2_decap_8
XFILLER_16_1379 VDD VSS sg13g2_decap_8
XFILLER_138_255 VDD VSS sg13g2_decap_8
XFILLER_166_564 VDD VSS sg13g2_decap_8
X_12350_ _12350_/X _14683_/Q _14715_/Q _13755_/Q _13787_/Q _12352_/S0 _12352_/S1 VDD
+ VSS sg13g2_mux4_1
XFILLER_103_1349 VDD VSS sg13g2_decap_8
XFILLER_5_714 VDD VSS sg13g2_decap_8
XFILLER_153_214 VDD VSS sg13g2_decap_8
X_11301_ _11301_/Y _11300_/X _12108_/B _11299_/Y VDD VSS sg13g2_a21oi_1
X_12281_ _12281_/X _14585_/Q _14617_/Q _14649_/Q _14681_/Q _12288_/S0 _12288_/S1 VDD
+ VSS sg13g2_mux4_1
XFILLER_119_491 VDD VSS sg13g2_fill_1
XFILLER_4_224 VDD VSS sg13g2_decap_8
XFILLER_49_1100 VDD VSS sg13g2_decap_4
XFILLER_101_1051 VDD VSS sg13g2_fill_1
XFILLER_107_653 VDD VSS sg13g2_decap_8
X_14020_ _14020_/Q clkload49/A _14020_/D _14020_/RESET_B VDD VSS sg13g2_dfrbpq_1
X_11232_ _11232_/Y _15115_/Q _15116_/Q VDD VSS sg13g2_nor2_1
XFILLER_162_770 VDD VSS sg13g2_decap_8
XFILLER_107_686 VDD VSS sg13g2_fill_2
XFILLER_84_1035 VDD VSS sg13g2_fill_2
XFILLER_136_51 VDD VSS sg13g2_decap_8
XFILLER_150_932 VDD VSS sg13g2_decap_4
XFILLER_20_84 VDD VSS sg13g2_decap_8
XFILLER_121_100 VDD VSS sg13g2_decap_8
XFILLER_175_1174 VDD VSS sg13g2_decap_8
X_11163_ _11180_/A _11163_/A _11164_/C VDD VSS sg13g2_nor2_1
XFILLER_96_11 VDD VSS sg13g2_decap_8
XFILLER_49_1177 VDD VSS sg13g2_decap_8
XFILLER_134_494 VDD VSS sg13g2_fill_1
XFILLER_1_931 VDD VSS sg13g2_decap_8
XFILLER_96_22 VDD VSS sg13g2_fill_1
XFILLER_84_1079 VDD VSS sg13g2_decap_8
XFILLER_136_1158 VDD VSS sg13g2_decap_8
XFILLER_150_976 VDD VSS sg13g2_fill_2
X_10114_ _14692_/D _10147_/A1 _14692_/Q _10130_/S VDD VSS sg13g2_mux2_1
XFILLER_0_441 VDD VSS sg13g2_decap_8
XFILLER_136_1169 VDD VSS sg13g2_fill_1
X_11094_ _11095_/B _11118_/C _11094_/B VDD VSS sg13g2_nor2_1
XFILLER_67_209 VDD VSS sg13g2_decap_8
XFILLER_27_1453 VDD VSS sg13g2_decap_8
XFILLER_114_1412 VDD VSS sg13g2_fill_2
XFILLER_62_1355 VDD VSS sg13g2_decap_8
XFILLER_76_721 VDD VSS sg13g2_decap_8
XFILLER_103_892 VDD VSS sg13g2_fill_2
X_14657__1545 _14657_/RESET_B VDD VSS sg13g2_tiehi
X_14922_ _14922_/Q clkload76/A _14922_/D _14922_/RESET_B VDD VSS sg13g2_dfrbpq_1
X_10045_ _14626_/D _10045_/A0 _14626_/Q _10059_/S VDD VSS sg13g2_mux2_1
XFILLER_96_99 VDD VSS sg13g2_fill_1
XFILLER_48_423 VDD VSS sg13g2_fill_1
XFILLER_48_434 VDD VSS sg13g2_fill_2
XFILLER_23_1339 VDD VSS sg13g2_decap_8
XFILLER_76_754 VDD VSS sg13g2_fill_1
XFILLER_75_231 VDD VSS sg13g2_decap_8
XFILLER_97_1407 VDD VSS sg13g2_decap_8
X_14853_ _14853_/Q clkload84/A _14853_/D _14853_/RESET_B VDD VSS sg13g2_dfrbpq_1
XFILLER_5_1260 VDD VSS sg13g2_decap_8
XFILLER_152_94 VDD VSS sg13g2_decap_8
XFILLER_1_1113 VDD VSS sg13g2_decap_8
X_13804_ _13804_/Q _14508_/CLK _13804_/D _13804_/RESET_B VDD VSS sg13g2_dfrbpq_1
XFILLER_112_1180 VDD VSS sg13g2_decap_4
X_14801__2935 _14801_/RESET_B VDD VSS sg13g2_tiehi
XFILLER_95_1120 VDD VSS sg13g2_decap_8
XFILLER_16_320 VDD VSS sg13g2_fill_2
X_14784_ _14784_/Q clkload89/A _14784_/D _14784_/RESET_B VDD VSS sg13g2_dfrbpq_1
X_11996_ _11996_/X _14577_/Q _14609_/Q _14641_/Q _14673_/Q _11997_/S0 _11997_/S1 VDD
+ VSS sg13g2_mux4_1
X_13735_ _13735_/Q _14727_/CLK _13735_/D _13735_/RESET_B VDD VSS sg13g2_dfrbpq_1
X_10947_ _11007_/B _10932_/B _10946_/Y _10945_/Y _10944_/Y VDD VSS sg13g2_a22oi_1
XFILLER_182_1145 VDD VSS sg13g2_decap_8
XFILLER_31_323 VDD VSS sg13g2_fill_2
XFILLER_177_818 VDD VSS sg13g2_decap_4
X_15025__2585 _15025_/RESET_B VDD VSS sg13g2_tiehi
XFILLER_147_1287 VDD VSS sg13g2_decap_8
X_13666_ _13666_/Q clkload72/A _13666_/D _13666_/RESET_B VDD VSS sg13g2_dfrbpq_1
X_10878_ _10878_/Y _10923_/D _10878_/B VDD VSS sg13g2_nand2_1
XFILLER_73_1451 VDD VSS sg13g2_decap_8
XFILLER_31_356 VDD VSS sg13g2_decap_8
X_12617_ _12617_/X _14574_/Q _14606_/Q _14638_/Q _14670_/Q _12620_/S0 _12620_/S1 VDD
+ VSS sg13g2_mux4_1
XFILLER_157_520 VDD VSS sg13g2_decap_8
XFILLER_129_222 VDD VSS sg13g2_decap_8
XFILLER_12_570 VDD VSS sg13g2_decap_8
X_13597_ _13597_/Y _12798_/Y _13596_/Y _08830_/X VDD VSS sg13g2_o21ai_1
XFILLER_34_1446 VDD VSS sg13g2_decap_8
XFILLER_121_1416 VDD VSS sg13g2_decap_8
XFILLER_160_1465 VDD VSS sg13g2_decap_4
XFILLER_118_918 VDD VSS sg13g2_decap_8
XFILLER_61_80 VDD VSS sg13g2_decap_8
X_12548_ _12548_/X _13737_/Q _14089_/Q _14441_/Q _14537_/Q _12550_/S0 _12550_/S1 VDD
+ VSS sg13g2_mux4_1
XFILLER_172_501 VDD VSS sg13g2_decap_8
XFILLER_145_726 VDD VSS sg13g2_fill_1
XFILLER_185_895 VDD VSS sg13g2_decap_8
XFILLER_157_597 VDD VSS sg13g2_decap_8
XFILLER_8_585 VDD VSS sg13g2_decap_8
XFILLER_184_394 VDD VSS sg13g2_decap_8
XANTENNA_2 _09556_/S VDD VSS sg13g2_antennanp
X_12479_ _12479_/X _13828_/Q _13860_/Q _13892_/Q _13924_/Q _12480_/S0 _12480_/S1 VDD
+ VSS sg13g2_mux4_1
XFILLER_144_247 VDD VSS sg13g2_decap_8
XFILLER_172_556 VDD VSS sg13g2_fill_1
XFILLER_6_53 VDD VSS sg13g2_decap_8
X_14849__2869 _14849_/RESET_B VDD VSS sg13g2_tiehi
X_14218_ _14218_/Q clkload19/A _14218_/D _14218_/RESET_B VDD VSS sg13g2_dfrbpq_1
XFILLER_172_578 VDD VSS sg13g2_fill_1
XFILLER_126_984 VDD VSS sg13g2_decap_8
X_15198_ _15198_/Q clkload65/A _15198_/D _15198_/RESET_B VDD VSS sg13g2_dfrbpq_1
XFILLER_158_1361 VDD VSS sg13g2_decap_8
XFILLER_67_1255 VDD VSS sg13g2_decap_8
XFILLER_28_1217 VDD VSS sg13g2_decap_8
X_14149_ _14149_/Q clkload17/A _14149_/D _14149_/RESET_B VDD VSS sg13g2_dfrbpq_1
XFILLER_4_791 VDD VSS sg13g2_decap_8
XFILLER_113_645 VDD VSS sg13g2_decap_8
XFILLER_140_431 VDD VSS sg13g2_fill_1
Xfanout509 _08499_/B1 _08588_/B VDD VSS sg13g2_buf_1
XFILLER_112_133 VDD VSS sg13g2_decap_4
XFILLER_119_1367 VDD VSS sg13g2_decap_8
XFILLER_98_356 VDD VSS sg13g2_decap_4
XFILLER_100_306 VDD VSS sg13g2_decap_8
XFILLER_80_1433 VDD VSS sg13g2_decap_8
X_08710_ _13660_/D _15187_/D _15118_/Q _13652_/S VDD VSS sg13g2_mux2_1
X_09690_ _14282_/D _09723_/A0 _14282_/Q _09696_/S VDD VSS sg13g2_mux2_1
XFILLER_41_1439 VDD VSS sg13g2_decap_8
Xfanout1080 _13510_/A1 _08635_/S1 VDD VSS sg13g2_buf_1
XFILLER_94_551 VDD VSS sg13g2_decap_8
XFILLER_6_1068 VDD VSS sg13g2_decap_8
Xfanout1091 _08337_/S0 _13509_/A1 VDD VSS sg13g2_buf_1
X_08641_ _08641_/Y _08641_/A _08641_/B _08641_/C _08641_/D VDD VSS sg13g2_nor4_1
XFILLER_66_253 VDD VSS sg13g2_decap_4
XFILLER_54_404 VDD VSS sg13g2_decap_8
XFILLER_82_746 VDD VSS sg13g2_fill_2
X_13751__2451 _13751_/RESET_B VDD VSS sg13g2_tiehi
X_08572_ _08573_/A _08445_/Y _08571_/Y _08570_/Y VDD VSS sg13g2_o21ai_1
XFILLER_19_191 VDD VSS sg13g2_decap_8
XFILLER_82_779 VDD VSS sg13g2_fill_2
XFILLER_25_18 VDD VSS sg13g2_decap_8
XFILLER_78_1373 VDD VSS sg13g2_decap_8
XFILLER_63_971 VDD VSS sg13g2_decap_8
XFILLER_35_662 VDD VSS sg13g2_decap_8
XFILLER_23_813 VDD VSS sg13g2_decap_8
XFILLER_63_982 VDD VSS sg13g2_fill_2
XFILLER_165_1343 VDD VSS sg13g2_decap_8
X_14702__1500 _14702_/RESET_B VDD VSS sg13g2_tiehi
XFILLER_74_1226 VDD VSS sg13g2_decap_8
XFILLER_39_1357 VDD VSS sg13g2_decap_8
XFILLER_179_144 VDD VSS sg13g2_decap_8
XFILLER_167_306 VDD VSS sg13g2_decap_8
X_14095__2107 _14095_/RESET_B VDD VSS sg13g2_tiehi
XFILLER_126_1349 VDD VSS sg13g2_decap_8
XFILLER_10_518 VDD VSS sg13g2_decap_8
X_14131__2071 _14131_/RESET_B VDD VSS sg13g2_tiehi
XFILLER_50_698 VDD VSS sg13g2_decap_4
XFILLER_41_28 VDD VSS sg13g2_decap_8
X_09124_ _09157_/C _14919_/Q _13189_/A _13156_/A _09150_/B VDD VSS sg13g2_and4_1
XFILLER_148_575 VDD VSS sg13g2_decap_8
XFILLER_157_39 VDD VSS sg13g2_decap_8
X_14735__1467 _14735_/RESET_B VDD VSS sg13g2_tiehi
X_09055_ _09057_/B _14908_/Q _09056_/C _14909_/Q VDD VSS sg13g2_a21oi_1
XFILLER_15_1390 VDD VSS sg13g2_decap_8
XFILLER_117_940 VDD VSS sg13g2_decap_8
XFILLER_135_236 VDD VSS sg13g2_decap_8
XFILLER_50_1281 VDD VSS sg13g2_decap_8
XFILLER_102_1360 VDD VSS sg13g2_decap_8
XFILLER_11_1254 VDD VSS sg13g2_decap_8
XFILLER_163_567 VDD VSS sg13g2_fill_2
X_08006_ _08146_/A _08915_/A1 _08919_/A1 _08922_/A1 _08925_/A1 _08009_/S _07627_/A
+ VDD VSS sg13g2_mux4_1
XFILLER_102_1382 VDD VSS sg13g2_decap_8
XFILLER_116_450 VDD VSS sg13g2_decap_4
XFILLER_104_601 VDD VSS sg13g2_decap_8
XFILLER_176_1450 VDD VSS sg13g2_decap_8
XFILLER_89_301 VDD VSS sg13g2_fill_1
XFILLER_104_612 VDD VSS sg13g2_fill_1
XFILLER_2_728 VDD VSS sg13g2_decap_8
XFILLER_137_1423 VDD VSS sg13g2_decap_8
XFILLER_85_1355 VDD VSS sg13g2_decap_8
XFILLER_137_1434 VDD VSS sg13g2_fill_2
XFILLER_173_49 VDD VSS sg13g2_decap_8
XFILLER_1_238 VDD VSS sg13g2_decap_8
XFILLER_172_1347 VDD VSS sg13g2_decap_8
XFILLER_106_32 VDD VSS sg13g2_decap_4
X_09957_ _14541_/D _14541_/Q _10023_/A0 _09957_/S VDD VSS sg13g2_mux2_1
XFILLER_131_475 VDD VSS sg13g2_fill_1
XFILLER_58_710 VDD VSS sg13g2_fill_1
XFILLER_103_188 VDD VSS sg13g2_decap_8
XFILLER_66_14 VDD VSS sg13g2_decap_8
XFILLER_103_199 VDD VSS sg13g2_fill_1
X_08908_ _08908_/Y _08906_/Y _08907_/Y _08922_/S VDD VSS sg13g2_a21oi_1
XFILLER_135_1180 VDD VSS sg13g2_decap_8
XFILLER_58_743 VDD VSS sg13g2_decap_8
XFILLER_57_220 VDD VSS sg13g2_fill_1
XFILLER_100_840 VDD VSS sg13g2_decap_8
X_09888_ _14474_/D _09921_/A1 _14474_/Q _09890_/S VDD VSS sg13g2_mux2_1
XFILLER_57_231 VDD VSS sg13g2_decap_8
XFILLER_58_776 VDD VSS sg13g2_fill_1
X_08839_ _10805_/B _10669_/S _14927_/Q VDD VSS sg13g2_nor2b_1
XFILLER_2_1400 VDD VSS sg13g2_decap_8
XFILLER_85_584 VDD VSS sg13g2_decap_8
XFILLER_72_201 VDD VSS sg13g2_decap_8
XFILLER_39_990 VDD VSS sg13g2_decap_8
XFILLER_122_42 VDD VSS sg13g2_decap_8
X_11850_ _11850_/X _14701_/Q _14733_/Q _13773_/Q _13805_/Q _11756_/S _11760_/C VDD
+ VSS sg13g2_mux4_1
X_14341__1861 _14341_/RESET_B VDD VSS sg13g2_tiehi
XFILLER_82_13 VDD VSS sg13g2_fill_1
X_14953__2661 _14953_/RESET_B VDD VSS sg13g2_tiehi
XFILLER_96_1462 VDD VSS sg13g2_decap_8
XFILLER_2_1477 VDD VSS sg13g2_fill_2
XFILLER_183_1421 VDD VSS sg13g2_decap_8
X_10801_ _10801_/Y _13345_/B _10844_/A _10429_/D VDD VSS sg13g2_o21ai_1
XFILLER_96_1473 VDD VSS sg13g2_fill_2
XFILLER_92_1304 VDD VSS sg13g2_fill_1
XFILLER_82_46 VDD VSS sg13g2_decap_8
XFILLER_72_278 VDD VSS sg13g2_decap_8
X_11781_ _11781_/X _14699_/Q _14731_/Q _13771_/Q _13803_/Q _11786_/S0 _11786_/S1 VDD
+ VSS sg13g2_mux4_1
XFILLER_13_312 VDD VSS sg13g2_decap_8
XFILLER_81_790 VDD VSS sg13g2_fill_2
XFILLER_57_1457 VDD VSS sg13g2_decap_8
X_13520_ _15140_/D _13565_/S _13518_/Y _13519_/Y VDD VSS sg13g2_a21oi_1
XFILLER_53_492 VDD VSS sg13g2_decap_8
X_10732_ _11042_/D _10735_/A _09066_/Y _08898_/Y VDD VSS sg13g2_o21ai_1
XFILLER_15_84 VDD VSS sg13g2_decap_8
XFILLER_186_637 VDD VSS sg13g2_decap_8
X_13451_ _13455_/C _15174_/Q _15175_/Q VDD VSS sg13g2_nand2_1
XFILLER_90_1050 VDD VSS sg13g2_decap_8
XFILLER_40_164 VDD VSS sg13g2_decap_8
XFILLER_13_389 VDD VSS sg13g2_decap_8
X_10663_ _10664_/A _14893_/Q _14892_/Q _14891_/Q _10663_/D VDD VSS sg13g2_and4_1
XFILLER_55_1181 VDD VSS sg13g2_decap_8
XFILLER_51_1012 VDD VSS sg13g2_decap_8
XFILLER_185_147 VDD VSS sg13g2_decap_8
XFILLER_90_1083 VDD VSS sg13g2_decap_8
X_12402_ _14992_/D _08256_/B _12596_/C1 _12401_/Y _12400_/Y VDD VSS sg13g2_a22oi_1
XFILLER_139_564 VDD VSS sg13g2_decap_8
XFILLER_107_1293 VDD VSS sg13g2_fill_2
XFILLER_166_350 VDD VSS sg13g2_decap_8
XFILLER_167_884 VDD VSS sg13g2_decap_8
XFILLER_16_1176 VDD VSS sg13g2_decap_8
X_13382_ _13455_/A _13389_/B _13382_/B VDD VSS sg13g2_nand2_1
X_10594_ _10595_/A _14875_/Q _14874_/Q _14873_/Q _10594_/D VDD VSS sg13g2_and4_1
X_15121_ _15121_/Q clkload63/A _15121_/D _15121_/RESET_B VDD VSS sg13g2_dfrbpq_1
XFILLER_127_748 VDD VSS sg13g2_decap_8
X_12333_ _12334_/B _12322_/Y _12324_/X _12174_/A VDD VSS sg13g2_o21ai_1
XFILLER_5_511 VDD VSS sg13g2_decap_8
XFILLER_166_394 VDD VSS sg13g2_fill_1
XFILLER_182_865 VDD VSS sg13g2_decap_4
XFILLER_177_1247 VDD VSS sg13g2_decap_8
XFILLER_142_718 VDD VSS sg13g2_decap_4
X_15052_ _15052_/Q _15052_/CLK _15052_/D _15052_/RESET_B VDD VSS sg13g2_dfrbpq_1
X_13793__2409 _13793_/RESET_B VDD VSS sg13g2_tiehi
X_12264_ _12264_/Y _12244_/Y _12246_/X _12217_/A VDD VSS sg13g2_o21ai_1
XFILLER_147_83 VDD VSS sg13g2_decap_8
XFILLER_181_375 VDD VSS sg13g2_decap_8
XFILLER_5_588 VDD VSS sg13g2_decap_8
XFILLER_135_792 VDD VSS sg13g2_decap_4
X_14003_ _14003_/Q clkload36/A _14003_/D _14003_/RESET_B VDD VSS sg13g2_dfrbpq_1
X_14819__2917 _14819_/RESET_B VDD VSS sg13g2_tiehi
XFILLER_123_943 VDD VSS sg13g2_decap_8
X_11215_ _11216_/B _12308_/C _11210_/X _11231_/S VDD VSS sg13g2_o21ai_1
X_12195_ _12195_/Y _12194_/X _11664_/A _12271_/A VDD VSS sg13g2_a21oi_1
Xoutput50 mem_axi_araddr[21] _16874_/A VDD VSS sg13g2_buf_1
XFILLER_64_1428 VDD VSS sg13g2_decap_8
Xoutput61 mem_axi_araddr[31] _16884_/A VDD VSS sg13g2_buf_1
Xoutput72 mem_axi_awaddr[11] _16864_/X VDD VSS sg13g2_buf_1
XFILLER_123_998 VDD VSS sg13g2_decap_4
Xoutput83 mem_axi_awaddr[22] _16875_/X VDD VSS sg13g2_buf_1
X_11146_ _11173_/B _11146_/A _11146_/B VDD VSS sg13g2_nor2_1
XFILLER_122_475 VDD VSS sg13g2_decap_8
Xoutput94 mem_axi_awaddr[3] _16856_/X VDD VSS sg13g2_buf_1
XFILLER_27_1250 VDD VSS sg13g2_decap_8
XFILLER_62_1152 VDD VSS sg13g2_decap_8
X_11077_ _11077_/Y _11118_/B _11077_/B VDD VSS sg13g2_xnor2_1
XFILLER_7_1344 VDD VSS sg13g2_decap_8
X_14173__2029 _14173_/RESET_B VDD VSS sg13g2_tiehi
XFILLER_153_1291 VDD VSS sg13g2_decap_8
XFILLER_23_1136 VDD VSS sg13g2_decap_8
XFILLER_76_551 VDD VSS sg13g2_decap_8
XFILLER_3_1208 VDD VSS sg13g2_decap_8
X_14905_ _14905_/Q clkload55/A _14905_/D _14905_/RESET_B VDD VSS sg13g2_dfrbpq_1
X_10028_ _14610_/D _10094_/A0 _14610_/Q _10035_/S VDD VSS sg13g2_mux2_1
XFILLER_114_1275 VDD VSS sg13g2_decap_8
XFILLER_110_1128 VDD VSS sg13g2_decap_8
XFILLER_97_1237 VDD VSS sg13g2_decap_8
X_14836_ _14836_/Q clkload67/A _14836_/D _14836_/RESET_B VDD VSS sg13g2_dfrbpq_1
XFILLER_64_757 VDD VSS sg13g2_decap_8
X_14767_ _14767_/Q clkload66/A _14767_/D _14767_/RESET_B VDD VSS sg13g2_dfrbpq_1
X_11979_ _14978_/D _11939_/Y _11978_/Y _11934_/Y VDD VSS sg13g2_a21oi_1
XFILLER_60_930 VDD VSS sg13g2_decap_8
X_13718_ _16880_/A clkload56/A _13718_/D _13718_/RESET_B VDD VSS sg13g2_dfrbpq_1
X_14698_ _14698_/Q clkload27/A _14698_/D _14698_/RESET_B VDD VSS sg13g2_dfrbpq_1
XFILLER_149_328 VDD VSS sg13g2_decap_8
X_13649_ _15115_/D _15184_/D _15115_/Q _13651_/S VDD VSS sg13g2_mux2_1
XFILLER_176_147 VDD VSS sg13g2_decap_8
XFILLER_34_1243 VDD VSS sg13g2_decap_8
XFILLER_160_1262 VDD VSS sg13g2_decap_8
X_14204__1998 _14204_/RESET_B VDD VSS sg13g2_tiehi
XFILLER_9_861 VDD VSS sg13g2_decap_8
XFILLER_125_1393 VDD VSS sg13g2_fill_2
XFILLER_173_810 VDD VSS sg13g2_decap_8
XFILLER_158_895 VDD VSS sg13g2_decap_8
XFILLER_30_1118 VDD VSS sg13g2_fill_1
XFILLER_121_1246 VDD VSS sg13g2_decap_8
XFILLER_118_759 VDD VSS sg13g2_decap_4
XFILLER_8_382 VDD VSS sg13g2_decap_8
XFILLER_145_545 VDD VSS sg13g2_fill_1
XFILLER_172_331 VDD VSS sg13g2_decap_8
XFILLER_184_191 VDD VSS sg13g2_decap_8
XFILLER_145_556 VDD VSS sg13g2_decap_4
XFILLER_69_1339 VDD VSS sg13g2_decap_8
XFILLER_133_707 VDD VSS sg13g2_decap_8
XFILLER_173_887 VDD VSS sg13g2_decap_8
XFILLER_114_910 VDD VSS sg13g2_fill_2
XFILLER_160_526 VDD VSS sg13g2_decap_8
X_14383__1819 _14383_/RESET_B VDD VSS sg13g2_tiehi
XFILLER_99_610 VDD VSS sg13g2_decap_8
X_13769__2433 _13769_/RESET_B VDD VSS sg13g2_tiehi
XFILLER_99_621 VDD VSS sg13g2_fill_2
XFILLER_114_943 VDD VSS sg13g2_fill_1
XFILLER_99_643 VDD VSS sg13g2_decap_4
XFILLER_119_1142 VDD VSS sg13g2_decap_8
XFILLER_141_751 VDD VSS sg13g2_decap_8
Xfanout306 _10954_/C _10965_/A VDD VSS sg13g2_buf_1
Xfanout317 fanout317/X _10070_/Y VDD VSS sg13g2_buf_1
X_09811_ _14399_/D _09910_/A1 _14399_/Q _09822_/S VDD VSS sg13g2_mux2_1
XFILLER_98_153 VDD VSS sg13g2_decap_4
XFILLER_67_1096 VDD VSS sg13g2_decap_8
XFILLER_101_604 VDD VSS sg13g2_decap_8
Xfanout328 _09937_/S _09925_/S VDD VSS sg13g2_buf_1
XFILLER_154_1066 VDD VSS sg13g2_decap_8
Xfanout339 _09771_/S _09760_/S VDD VSS sg13g2_buf_1
XFILLER_99_698 VDD VSS sg13g2_decap_8
XFILLER_87_838 VDD VSS sg13g2_decap_4
XFILLER_154_1088 VDD VSS sg13g2_fill_1
XFILLER_45_1361 VDD VSS sg13g2_decap_8
XFILLER_101_648 VDD VSS sg13g2_decap_4
X_09742_ _14332_/D _14332_/Q _09742_/A1 _09772_/S VDD VSS sg13g2_mux2_1
XFILLER_80_1263 VDD VSS sg13g2_decap_8
XFILLER_39_231 VDD VSS sg13g2_decap_8
XFILLER_41_1236 VDD VSS sg13g2_decap_8
XFILLER_28_905 VDD VSS sg13g2_decap_8
X_14149__2053 _14149_/RESET_B VDD VSS sg13g2_tiehi
X_09673_ _14266_/D _10169_/A1 _14266_/Q _09673_/S VDD VSS sg13g2_mux2_1
XFILLER_95_882 VDD VSS sg13g2_decap_8
XFILLER_36_28 VDD VSS sg13g2_decap_4
XFILLER_132_1397 VDD VSS sg13g2_decap_8
XFILLER_167_1416 VDD VSS sg13g2_decap_8
X_08624_ _08633_/C _07849_/X _08692_/A _08623_/Y _08643_/C _08622_/Y VDD VSS sg13g2_a221oi_1
XFILLER_82_543 VDD VSS sg13g2_decap_8
XFILLER_42_407 VDD VSS sg13g2_fill_1
X_08555_ _08555_/Y _08554_/Y _08549_/Y _08588_/B VDD VSS sg13g2_o21ai_1
XFILLER_78_1170 VDD VSS sg13g2_decap_8
XFILLER_74_1001 VDD VSS sg13g2_fill_1
XFILLER_23_621 VDD VSS sg13g2_decap_8
X_13679__2537 _13679_/RESET_B VDD VSS sg13g2_tiehi
XFILLER_39_1154 VDD VSS sg13g2_decap_8
X_08486_ _08501_/C _07822_/B _08541_/A _08485_/Y _07820_/X _08484_/Y VDD VSS sg13g2_a221oi_1
XFILLER_74_1056 VDD VSS sg13g2_decap_4
XFILLER_74_1078 VDD VSS sg13g2_decap_4
XFILLER_161_1037 VDD VSS sg13g2_fill_1
XFILLER_52_49 VDD VSS sg13g2_fill_1
XFILLER_126_1157 VDD VSS sg13g2_decap_8
XFILLER_22_164 VDD VSS sg13g2_decap_8
XFILLER_10_315 VDD VSS sg13g2_decap_8
XFILLER_17_1441 VDD VSS sg13g2_decap_8
XFILLER_139_7 VDD VSS sg13g2_decap_4
XFILLER_168_49 VDD VSS sg13g2_decap_8
XFILLER_91_1381 VDD VSS sg13g2_decap_8
XFILLER_143_1460 VDD VSS sg13g2_decap_8
XFILLER_167_158 VDD VSS sg13g2_fill_2
XFILLER_22_186 VDD VSS sg13g2_decap_8
XFILLER_183_618 VDD VSS sg13g2_decap_8
XFILLER_52_1354 VDD VSS sg13g2_decap_8
XFILLER_13_1327 VDD VSS sg13g2_decap_8
XFILLER_6_319 VDD VSS sg13g2_decap_8
XFILLER_104_1455 VDD VSS sg13g2_decap_8
XFILLER_164_832 VDD VSS sg13g2_decap_4
X_09107_ _09107_/Y _15241_/Q _09107_/B VDD VSS sg13g2_nand2b_1
XFILLER_108_247 VDD VSS sg13g2_fill_2
XFILLER_11_1051 VDD VSS sg13g2_decap_8
XFILLER_184_37 VDD VSS sg13g2_decap_8
X_09038_ _13767_/D _13767_/Q _10083_/A0 _09077_/S VDD VSS sg13g2_mux2_1
XFILLER_136_589 VDD VSS sg13g2_decap_8
XFILLER_2_525 VDD VSS sg13g2_decap_8
XFILLER_117_42 VDD VSS sg13g2_fill_2
X_14359__1843 _14359_/RESET_B VDD VSS sg13g2_tiehi
X_15178__2878 _15178_/RESET_B VDD VSS sg13g2_tiehi
XFILLER_137_1231 VDD VSS sg13g2_decap_8
XFILLER_89_120 VDD VSS sg13g2_decap_8
XFILLER_116_291 VDD VSS sg13g2_fill_2
XFILLER_104_453 VDD VSS sg13g2_fill_2
X_11000_ _14941_/D _10999_/X _10998_/Y _10987_/Y VDD VSS sg13g2_o21ai_1
XFILLER_120_913 VDD VSS sg13g2_fill_1
XFILLER_172_1144 VDD VSS sg13g2_decap_8
XFILLER_77_46 VDD VSS sg13g2_fill_2
XFILLER_46_1169 VDD VSS sg13g2_decap_8
XFILLER_104_486 VDD VSS sg13g2_decap_8
XFILLER_78_849 VDD VSS sg13g2_decap_8
XFILLER_77_326 VDD VSS sg13g2_decap_8
Xfanout840 _12620_/S1 fanout841/X VDD VSS sg13g2_buf_1
XFILLER_133_1139 VDD VSS sg13g2_decap_8
Xfanout851 _12686_/S1 _12674_/S1 VDD VSS sg13g2_buf_1
Xfanout862 _12725_/S1 _12752_/S1 VDD VSS sg13g2_buf_1
Xfanout873 _12494_/S0 fanout876/X VDD VSS sg13g2_buf_1
Xfanout884 _12425_/S0 fanout915/X VDD VSS sg13g2_buf_1
XFILLER_24_1445 VDD VSS sg13g2_decap_8
Xfanout895 _12614_/S0 _12589_/S0 VDD VSS sg13g2_buf_1
XFILLER_58_562 VDD VSS sg13g2_decap_8
XFILLER_18_404 VDD VSS sg13g2_fill_2
X_12951_ _12951_/Y _12900_/A _12866_/B input35/X VDD VSS sg13g2_a21oi_1
XFILLER_100_670 VDD VSS sg13g2_decap_8
XFILLER_111_1437 VDD VSS sg13g2_decap_8
XFILLER_73_521 VDD VSS sg13g2_decap_4
X_15160__2660 _15160_/RESET_B VDD VSS sg13g2_tiehi
X_11902_ _11902_/Y _11902_/A _11625_/C VDD VSS sg13g2_nor2b_1
XFILLER_18_448 VDD VSS sg13g2_decap_4
XFILLER_93_56 VDD VSS sg13g2_decap_8
X_12882_ _12882_/Y _12879_/Y _12880_/Y _12881_/Y VDD VSS sg13g2_a21oi_1
XFILLER_93_67 VDD VSS sg13g2_fill_1
XFILLER_46_779 VDD VSS sg13g2_decap_8
XFILLER_33_407 VDD VSS sg13g2_fill_2
X_14621_ _14621_/Q clkload32/A _14621_/D _14621_/RESET_B VDD VSS sg13g2_dfrbpq_1
XFILLER_93_89 VDD VSS sg13g2_decap_8
X_11833_ _11833_/Y _11813_/Y _11815_/X _11765_/A VDD VSS sg13g2_o21ai_1
XFILLER_61_727 VDD VSS sg13g2_decap_8
XFILLER_60_204 VDD VSS sg13g2_decap_8
XFILLER_2_1274 VDD VSS sg13g2_decap_8
XFILLER_73_598 VDD VSS sg13g2_decap_8
XFILLER_60_215 VDD VSS sg13g2_fill_1
XFILLER_45_289 VDD VSS sg13g2_fill_2
XFILLER_92_1134 VDD VSS sg13g2_decap_8
XFILLER_57_1254 VDD VSS sg13g2_decap_8
X_14552_ _14552_/Q _14742_/CLK _14552_/D _14552_/RESET_B VDD VSS sg13g2_dfrbpq_1
X_11764_ _11765_/B _11761_/Y _11763_/Y _11559_/C VDD VSS sg13g2_a21oi_1
XFILLER_14_665 VDD VSS sg13g2_decap_8
XFILLER_18_1238 VDD VSS sg13g2_decap_8
X_13847__2355 _13847_/RESET_B VDD VSS sg13g2_tiehi
XFILLER_109_1366 VDD VSS sg13g2_fill_2
XFILLER_183_1295 VDD VSS sg13g2_decap_8
X_13503_ _15129_/D _15174_/D _13504_/A _13501_/Y VDD VSS sg13g2_o21ai_1
XFILLER_186_434 VDD VSS sg13g2_decap_8
X_10715_ _14906_/D _10985_/B1 _10954_/B _10714_/Y VDD VSS sg13g2_o21ai_1
X_14483_ _14483_/Q _14546_/CLK _14483_/D _14483_/RESET_B VDD VSS sg13g2_dfrbpq_1
X_11695_ _11696_/A _13960_/Q _13992_/Q _14024_/Q _14056_/Q _11692_/A _11693_/C VDD
+ VSS sg13g2_mux4_1
XFILLER_13_186 VDD VSS sg13g2_decap_8
XFILLER_144_1279 VDD VSS sg13g2_fill_1
XFILLER_174_607 VDD VSS sg13g2_decap_8
X_13434_ _15099_/D _15099_/Q _13470_/A2 _13433_/Y VDD VSS sg13g2_a21o_1
XFILLER_31_1405 VDD VSS sg13g2_decap_8
XFILLER_179_1309 VDD VSS sg13g2_decap_8
X_10646_ _10655_/C _14889_/Q _10643_/C hold3172/X VDD VSS sg13g2_a21oi_1
XFILLER_42_71 VDD VSS sg13g2_decap_8
XFILLER_127_501 VDD VSS sg13g2_fill_1
XFILLER_9_168 VDD VSS sg13g2_decap_8
XFILLER_70_1476 VDD VSS sg13g2_fill_2
XFILLER_155_821 VDD VSS sg13g2_fill_1
XFILLER_177_1000 VDD VSS sg13g2_fill_1
XFILLER_10_882 VDD VSS sg13g2_decap_8
X_13365_ _15074_/D _13361_/C _13435_/A _13363_/Y VDD VSS sg13g2_o21ai_1
X_10577_ _14870_/D _10586_/D _10595_/B _10577_/C VDD VSS sg13g2_nor3_1
XFILLER_177_1033 VDD VSS sg13g2_decap_8
XFILLER_182_662 VDD VSS sg13g2_decap_8
X_15104_ _15104_/Q clkload69/A _15104_/D _15104_/RESET_B VDD VSS sg13g2_dfrbpq_1
XFILLER_155_887 VDD VSS sg13g2_fill_2
X_12316_ _12317_/A _13754_/Q _14106_/Q _14458_/Q _14554_/Q _12306_/A _12307_/C VDD
+ VSS sg13g2_mux4_1
XFILLER_138_1006 VDD VSS sg13g2_decap_8
XFILLER_138_1017 VDD VSS sg13g2_fill_1
XFILLER_181_161 VDD VSS sg13g2_decap_8
X_13296_ _15056_/D _13613_/A _07710_/Y _13295_/Y VDD VSS sg13g2_a21o_1
XFILLER_6_886 VDD VSS sg13g2_decap_8
XFILLER_54_7 VDD VSS sg13g2_decap_8
XFILLER_154_386 VDD VSS sg13g2_decap_4
XFILLER_177_1077 VDD VSS sg13g2_fill_1
X_15035_ _15035_/Q _15228_/CLK _15035_/D _15035_/RESET_B VDD VSS sg13g2_dfrbpq_1
XFILLER_5_385 VDD VSS sg13g2_decap_8
X_12247_ _12247_/Y _12259_/S0 _14392_/Q VDD VSS sg13g2_nand2b_1
XFILLER_174_70 VDD VSS sg13g2_decap_8
XFILLER_64_1225 VDD VSS sg13g2_decap_8
XFILLER_29_1345 VDD VSS sg13g2_decap_8
XFILLER_122_250 VDD VSS sg13g2_decap_8
XFILLER_155_1375 VDD VSS sg13g2_decap_8
X_12178_ _12178_/Y _11277_/S _14518_/Q _12184_/B VDD VSS sg13g2_a21oi_1
XFILLER_3_32 VDD VSS sg13g2_decap_8
XFILLER_151_1239 VDD VSS sg13g2_decap_8
X_11129_ _11129_/Y _11128_/A _11128_/B _11151_/A VDD VSS sg13g2_a21oi_1
XFILLER_84_808 VDD VSS sg13g2_decap_8
XFILLER_7_1141 VDD VSS sg13g2_decap_8
XFILLER_110_467 VDD VSS sg13g2_fill_1
X_15067__2896 _15067_/RESET_B VDD VSS sg13g2_tiehi
XFILLER_67_90 VDD VSS sg13g2_decap_8
XFILLER_3_1005 VDD VSS sg13g2_decap_8
XFILLER_37_724 VDD VSS sg13g2_decap_8
XFILLER_76_370 VDD VSS sg13g2_fill_1
XFILLER_36_201 VDD VSS sg13g2_fill_2
XFILLER_64_532 VDD VSS sg13g2_decap_4
XFILLER_149_1102 VDD VSS sg13g2_fill_1
XFILLER_91_340 VDD VSS sg13g2_decap_8
XFILLER_64_565 VDD VSS sg13g2_decap_8
XFILLER_64_576 VDD VSS sg13g2_fill_1
XFILLER_40_1291 VDD VSS sg13g2_decap_8
X_14819_ _14819_/Q clkload88/A _14819_/D _14819_/RESET_B VDD VSS sg13g2_dfrbpq_1
XFILLER_52_727 VDD VSS sg13g2_decap_8
XFILLER_24_418 VDD VSS sg13g2_fill_2
XFILLER_75_1321 VDD VSS sg13g2_decap_8
XFILLER_127_1411 VDD VSS sg13g2_fill_2
XFILLER_178_913 VDD VSS sg13g2_decap_8
X_08340_ _08340_/Y _08340_/A _08340_/B VDD VSS sg13g2_nand2_1
XFILLER_32_440 VDD VSS sg13g2_fill_1
XFILLER_36_1327 VDD VSS sg13g2_decap_8
XFILLER_33_985 VDD VSS sg13g2_decap_4
XFILLER_162_1346 VDD VSS sg13g2_decap_8
XFILLER_177_434 VDD VSS sg13g2_decap_8
X_08271_ _08271_/Y _08098_/B _08426_/A _08027_/Y VDD VSS sg13g2_a21oi_1
XFILLER_75_1398 VDD VSS sg13g2_decap_8
XFILLER_71_1229 VDD VSS sg13g2_decap_8
XFILLER_123_1308 VDD VSS sg13g2_fill_2
XFILLER_127_1477 VDD VSS sg13g2_fill_2
X_14437__1765 _14437_/RESET_B VDD VSS sg13g2_tiehi
XFILLER_149_136 VDD VSS sg13g2_decap_8
XFILLER_80_0 VDD VSS sg13g2_decap_8
XFILLER_20_679 VDD VSS sg13g2_decap_8
XFILLER_121_1043 VDD VSS sg13g2_decap_8
XFILLER_146_865 VDD VSS sg13g2_decap_8
XFILLER_106_707 VDD VSS sg13g2_fill_2
XFILLER_161_802 VDD VSS sg13g2_decap_8
XFILLER_69_1136 VDD VSS sg13g2_decap_8
XFILLER_106_729 VDD VSS sg13g2_decap_8
XFILLER_156_1106 VDD VSS sg13g2_decap_8
X_14652__1550 _14652_/RESET_B VDD VSS sg13g2_tiehi
XFILLER_160_312 VDD VSS sg13g2_decap_8
XFILLER_173_695 VDD VSS sg13g2_decap_8
XFILLER_133_537 VDD VSS sg13g2_decap_8
XFILLER_172_172 VDD VSS sg13g2_decap_8
XFILLER_86_1461 VDD VSS sg13g2_decap_8
XFILLER_114_740 VDD VSS sg13g2_decap_8
XFILLER_114_751 VDD VSS sg13g2_fill_1
XFILLER_173_1442 VDD VSS sg13g2_decap_8
XFILLER_99_451 VDD VSS sg13g2_decap_8
XFILLER_47_1445 VDD VSS sg13g2_decap_8
XFILLER_114_762 VDD VSS sg13g2_decap_8
XFILLER_102_935 VDD VSS sg13g2_fill_1
XFILLER_82_1358 VDD VSS sg13g2_decap_8
XFILLER_102_946 VDD VSS sg13g2_decap_8
Xfanout147 _10168_/A1 _09903_/A0 VDD VSS sg13g2_buf_1
XFILLER_101_434 VDD VSS sg13g2_decap_4
XFILLER_102_957 VDD VSS sg13g2_fill_2
Xfanout158 _09934_/A1 _09145_/Y VDD VSS sg13g2_buf_1
XFILLER_87_668 VDD VSS sg13g2_fill_1
Xfanout169 _10097_/A0 _10064_/A0 VDD VSS sg13g2_buf_1
X_07986_ _07988_/D _13290_/A _13290_/B VDD VSS sg13g2_nand2_1
X_13925__2277 _13925_/RESET_B VDD VSS sg13g2_tiehi
X_09725_ _14316_/D _09923_/A1 _14316_/Q _09725_/S VDD VSS sg13g2_mux2_1
XFILLER_170_39 VDD VSS sg13g2_decap_8
X_15020__2590 _15020_/RESET_B VDD VSS sg13g2_tiehi
XFILLER_132_1194 VDD VSS sg13g2_fill_1
X_09656_ _14249_/D _09656_/A0 _14249_/Q _09667_/S VDD VSS sg13g2_mux2_1
XFILLER_167_1213 VDD VSS sg13g2_decap_8
XFILLER_16_919 VDD VSS sg13g2_fill_2
X_08607_ _08615_/C _08652_/B1 _08603_/Y _08606_/Y VDD VSS sg13g2_a21oi_1
XFILLER_70_502 VDD VSS sg13g2_decap_8
XFILLER_83_896 VDD VSS sg13g2_decap_8
XFILLER_42_204 VDD VSS sg13g2_decap_8
X_09587_ _14184_/D _14184_/Q _09620_/A0 _09589_/S VDD VSS sg13g2_mux2_1
XFILLER_43_738 VDD VSS sg13g2_decap_8
XFILLER_82_395 VDD VSS sg13g2_decap_8
XFILLER_63_48 VDD VSS sg13g2_decap_8
X_08538_ _08538_/X _08465_/X _08537_/X _08597_/B VDD VSS sg13g2_mux2_1
XFILLER_93_1454 VDD VSS sg13g2_decap_8
XFILLER_180_1413 VDD VSS sg13g2_decap_8
XFILLER_54_1416 VDD VSS sg13g2_decap_8
XFILLER_11_613 VDD VSS sg13g2_decap_8
X_15137__2706 _15137_/RESET_B VDD VSS sg13g2_tiehi
X_08469_ _08475_/C _08469_/A _08469_/B VDD VSS sg13g2_nor2_1
XFILLER_51_793 VDD VSS sg13g2_decap_8
XFILLER_141_1419 VDD VSS sg13g2_decap_4
XFILLER_169_979 VDD VSS sg13g2_decap_8
XFILLER_10_112 VDD VSS sg13g2_decap_8
XFILLER_156_607 VDD VSS sg13g2_fill_1
XFILLER_156_618 VDD VSS sg13g2_fill_1
XFILLER_184_927 VDD VSS sg13g2_decap_8
X_10500_ _10502_/B _10500_/A _14840_/Q _14839_/Q VDD VSS sg13g2_nand3_1
X_11480_ _11480_/Y _11479_/Y _11478_/Y _11465_/Y _11722_/B2 _11723_/A2 VDD VSS sg13g2_a221oi_1
XFILLER_52_1151 VDD VSS sg13g2_decap_8
XFILLER_13_1124 VDD VSS sg13g2_decap_8
XFILLER_149_681 VDD VSS sg13g2_decap_8
XFILLER_6_116 VDD VSS sg13g2_decap_8
X_10431_ _10431_/Y _14833_/Q _10434_/C _10441_/C VDD VSS sg13g2_o21ai_1
XFILLER_10_189 VDD VSS sg13g2_decap_8
XFILLER_178_1320 VDD VSS sg13g2_decap_8
XFILLER_183_459 VDD VSS sg13g2_decap_8
XFILLER_100_1116 VDD VSS sg13g2_fill_1
XFILLER_109_567 VDD VSS sg13g2_decap_4
XFILLER_12_63 VDD VSS sg13g2_decap_8
XFILLER_164_651 VDD VSS sg13g2_decap_8
XFILLER_128_41 VDD VSS sg13g2_decap_8
XFILLER_152_802 VDD VSS sg13g2_fill_2
XFILLER_170_109 VDD VSS sg13g2_decap_8
X_13150_ _13150_/Y _14853_/Q _13150_/B VDD VSS sg13g2_nand2_1
X_10362_ _14812_/D _14812_/Q _10359_/Y _10361_/Y VDD VSS sg13g2_a21oi_1
XFILLER_48_1209 VDD VSS sg13g2_decap_8
XFILLER_136_386 VDD VSS sg13g2_decap_8
XFILLER_139_1337 VDD VSS sg13g2_decap_8
XFILLER_174_1217 VDD VSS sg13g2_decap_8
XFILLER_3_823 VDD VSS sg13g2_decap_8
XFILLER_124_537 VDD VSS sg13g2_decap_8
X_12101_ _12101_/X _12101_/A _12101_/B VDD VSS sg13g2_and2_1
XFILLER_128_96 VDD VSS sg13g2_decap_4
XFILLER_178_1397 VDD VSS sg13g2_decap_8
XFILLER_124_559 VDD VSS sg13g2_decap_4
X_13081_ _13081_/X input12/X _12914_/A _13272_/B1 VDD VSS sg13g2_a21o_1
X_10293_ _10295_/A _14791_/Q _10294_/C _14792_/Q VDD VSS sg13g2_a21o_1
XFILLER_2_322 VDD VSS sg13g2_decap_8
XFILLER_88_56 VDD VSS sg13g2_decap_8
XFILLER_111_209 VDD VSS sg13g2_decap_8
X_12032_ _12032_/Y _12235_/A _14482_/Q VDD VSS sg13g2_nand2b_1
XFILLER_104_261 VDD VSS sg13g2_decap_8
XFILLER_120_710 VDD VSS sg13g2_decap_8
XFILLER_132_592 VDD VSS sg13g2_decap_4
XFILLER_2_399 VDD VSS sg13g2_decap_8
XFILLER_104_294 VDD VSS sg13g2_decap_8
Xfanout670 _13275_/A2 fanout671/X VDD VSS sg13g2_buf_1
Xfanout681 _11168_/B1 _11207_/B1 VDD VSS sg13g2_buf_1
XFILLER_24_1242 VDD VSS sg13g2_decap_8
XFILLER_120_798 VDD VSS sg13g2_fill_2
X_14515__1687 _14515_/RESET_B VDD VSS sg13g2_tiehi
Xfanout692 _11631_/A2 _11860_/B1 VDD VSS sg13g2_buf_1
XFILLER_93_627 VDD VSS sg13g2_decap_4
XFILLER_19_724 VDD VSS sg13g2_decap_8
X_13983_ _13983_/Q _14655_/CLK _13983_/D _13983_/RESET_B VDD VSS sg13g2_dfrbpq_1
XFILLER_58_370 VDD VSS sg13g2_decap_8
XFILLER_115_1392 VDD VSS sg13g2_decap_8
XFILLER_18_212 VDD VSS sg13g2_decap_8
X_14090__2112 _14090_/RESET_B VDD VSS sg13g2_tiehi
XFILLER_92_137 VDD VSS sg13g2_decap_4
XFILLER_4_1358 VDD VSS sg13g2_decap_8
X_12934_ _12934_/Y _13600_/B _12997_/A input34/X VDD VSS sg13g2_a21oi_1
XFILLER_92_148 VDD VSS sg13g2_fill_1
XFILLER_185_1313 VDD VSS sg13g2_decap_8
X_14769__2967 _14769_/RESET_B VDD VSS sg13g2_tiehi
XFILLER_59_1338 VDD VSS sg13g2_decap_8
XFILLER_33_204 VDD VSS sg13g2_fill_1
X_12865_ _12865_/Y _12862_/Y _12863_/Y _12864_/Y VDD VSS sg13g2_a21oi_1
XFILLER_2_1071 VDD VSS sg13g2_decap_8
X_14694__1508 _14694_/RESET_B VDD VSS sg13g2_tiehi
X_14604_ _14604_/Q _14668_/CLK _14604_/D _14604_/RESET_B VDD VSS sg13g2_dfrbpq_1
X_11816_ _11816_/Y _11373_/A _14380_/Q VDD VSS sg13g2_nand2b_1
X_14730__1472 _14730_/RESET_B VDD VSS sg13g2_tiehi
X_12796_ _12801_/B _13601_/B _12799_/A VDD VSS sg13g2_nor2b_1
X_14535_ _14535_/Q _14727_/CLK _14535_/D _14535_/RESET_B VDD VSS sg13g2_dfrbpq_1
XFILLER_109_1163 VDD VSS sg13g2_decap_8
XFILLER_183_1092 VDD VSS sg13g2_decap_8
X_11747_ _11747_/Y _11957_/A _11747_/B VDD VSS sg13g2_nor2_1
XFILLER_186_231 VDD VSS sg13g2_decap_8
XFILLER_169_70 VDD VSS sg13g2_decap_8
X_14466_ _14466_/Q _14704_/CLK _14466_/D _14466_/RESET_B VDD VSS sg13g2_dfrbpq_1
XFILLER_31_1202 VDD VSS sg13g2_decap_8
XFILLER_179_1106 VDD VSS sg13g2_decap_8
X_11678_ _11678_/X _13736_/Q _14088_/Q _14440_/Q _14536_/Q _11678_/S0 _11693_/C VDD
+ VSS sg13g2_mux4_1
XFILLER_70_1273 VDD VSS sg13g2_decap_8
X_13417_ _13490_/D _15129_/Q _13438_/B _13438_/D VDD VSS sg13g2_nand3_1
X_10629_ _10630_/B _14880_/Q _14879_/Q _10629_/C _10629_/D VDD VSS sg13g2_nand4_1
X_14397_ _14397_/Q clkload30/A _14397_/D _14397_/RESET_B VDD VSS sg13g2_dfrbpq_1
XFILLER_127_342 VDD VSS sg13g2_decap_8
XFILLER_115_504 VDD VSS sg13g2_decap_8
XFILLER_122_1396 VDD VSS sg13g2_decap_8
XFILLER_143_813 VDD VSS sg13g2_decap_8
XFILLER_31_1279 VDD VSS sg13g2_decap_8
X_13348_ _13348_/Y _15171_/D _15169_/D _13486_/B _13485_/B VDD VSS sg13g2_nand4_1
X_13663__2569 _13663_/RESET_B VDD VSS sg13g2_tiehi
XFILLER_183_993 VDD VSS sg13g2_decap_8
XFILLER_6_683 VDD VSS sg13g2_decap_8
XFILLER_52_4 VDD VSS sg13g2_decap_8
XFILLER_127_397 VDD VSS sg13g2_decap_8
XFILLER_143_857 VDD VSS sg13g2_fill_1
XFILLER_157_1448 VDD VSS sg13g2_decap_8
XFILLER_185_91 VDD VSS sg13g2_decap_8
XFILLER_5_182 VDD VSS sg13g2_decap_8
XFILLER_170_654 VDD VSS sg13g2_decap_8
X_13279_ _13279_/Y _15071_/Q _13279_/B _13307_/B _13279_/D VDD VSS sg13g2_nor4_1
XFILLER_142_356 VDD VSS sg13g2_decap_8
XFILLER_130_518 VDD VSS sg13g2_decap_8
X_15018_ _15018_/Q clkload47/A _15018_/D _15018_/RESET_B VDD VSS sg13g2_dfrbpq_1
XFILLER_69_602 VDD VSS sg13g2_decap_8
XFILLER_170_698 VDD VSS sg13g2_decap_8
XFILLER_151_890 VDD VSS sg13g2_decap_8
X_14914__2739 _14914_/RESET_B VDD VSS sg13g2_tiehi
XFILLER_97_944 VDD VSS sg13g2_decap_8
XFILLER_68_112 VDD VSS sg13g2_fill_1
XFILLER_155_1194 VDD VSS sg13g2_decap_8
X_07840_ _08654_/A _15018_/Q _08653_/B VDD VSS sg13g2_nor2_1
XFILLER_9_1269 VDD VSS sg13g2_decap_8
XFILLER_110_231 VDD VSS sg13g2_decap_8
XFILLER_96_454 VDD VSS sg13g2_decap_8
XFILLER_111_765 VDD VSS sg13g2_decap_8
XFILLER_69_679 VDD VSS sg13g2_decap_8
XFILLER_96_465 VDD VSS sg13g2_fill_2
XFILLER_42_1331 VDD VSS sg13g2_decap_8
XFILLER_116_1178 VDD VSS sg13g2_fill_2
XFILLER_151_1058 VDD VSS sg13g2_decap_4
XFILLER_110_264 VDD VSS sg13g2_decap_8
XFILLER_151_1069 VDD VSS sg13g2_decap_4
XFILLER_81_1391 VDD VSS sg13g2_decap_8
X_07771_ _08318_/B _07771_/A _14998_/Q VDD VSS sg13g2_xor2_1
XFILLER_84_638 VDD VSS sg13g2_decap_8
XFILLER_83_126 VDD VSS sg13g2_decap_8
XFILLER_37_521 VDD VSS sg13g2_decap_8
X_09510_ _14109_/D _10140_/A1 _14109_/Q _09524_/S VDD VSS sg13g2_mux2_1
XFILLER_37_565 VDD VSS sg13g2_decap_8
X_09441_ _09441_/Y _09441_/A _10004_/B _09441_/C _09441_/D VDD VSS sg13g2_nand4_1
XFILLER_64_373 VDD VSS sg13g2_fill_1
XFILLER_91_181 VDD VSS sg13g2_decap_8
XFILLER_169_209 VDD VSS sg13g2_decap_8
X_09372_ _13976_/D _09737_/A0 _13976_/Q _09372_/S VDD VSS sg13g2_mux2_1
XFILLER_80_877 VDD VSS sg13g2_decap_8
XFILLER_33_18 VDD VSS sg13g2_decap_8
XFILLER_166_1290 VDD VSS sg13g2_decap_8
X_08323_ _08323_/Y _07796_/B _08322_/Y _08499_/B1 VDD VSS sg13g2_o21ai_1
XFILLER_127_1263 VDD VSS sg13g2_decap_8
XFILLER_162_1143 VDD VSS sg13g2_decap_8
XFILLER_75_1195 VDD VSS sg13g2_decap_8
XFILLER_20_432 VDD VSS sg13g2_decap_8
XFILLER_123_1127 VDD VSS sg13g2_fill_1
XFILLER_178_787 VDD VSS sg13g2_decap_8
X_14814__2922 _14814_/RESET_B VDD VSS sg13g2_tiehi
X_08254_ _08426_/B _08171_/X _08253_/X _08301_/S VDD VSS sg13g2_mux2_1
XFILLER_137_117 VDD VSS sg13g2_decap_4
XFILLER_14_1422 VDD VSS sg13g2_decap_8
XFILLER_140_1430 VDD VSS sg13g2_decap_8
XFILLER_21_999 VDD VSS sg13g2_decap_8
X_08185_ _08185_/Y _08184_/Y _07876_/Y _08395_/A VDD VSS sg13g2_a21oi_1
XFILLER_101_1425 VDD VSS sg13g2_decap_8
XFILLER_4_609 VDD VSS sg13g2_decap_8
X_15038__2572 _15038_/RESET_B VDD VSS sg13g2_tiehi
XFILLER_101_1469 VDD VSS sg13g2_fill_1
XFILLER_106_526 VDD VSS sg13g2_decap_8
XFILLER_165_39 VDD VSS sg13g2_decap_8
XFILLER_106_537 VDD VSS sg13g2_fill_2
XFILLER_121_507 VDD VSS sg13g2_decap_8
XFILLER_47_1242 VDD VSS sg13g2_decap_8
XFILLER_138_1381 VDD VSS sg13g2_decap_4
XFILLER_160_186 VDD VSS sg13g2_decap_8
XFILLER_0_848 VDD VSS sg13g2_decap_8
XFILLER_134_1223 VDD VSS sg13g2_decap_8
XFILLER_48_808 VDD VSS sg13g2_fill_2
XFILLER_181_49 VDD VSS sg13g2_decap_8
XFILLER_88_988 VDD VSS sg13g2_decap_8
XFILLER_60_1420 VDD VSS sg13g2_decap_8
XFILLER_134_1289 VDD VSS sg13g2_decap_8
XFILLER_169_1308 VDD VSS sg13g2_decap_8
X_07969_ _07976_/C _07969_/A _08678_/A _08650_/A _07969_/D VDD VSS sg13g2_nor4_1
XFILLER_28_510 VDD VSS sg13g2_fill_1
X_09708_ _14299_/D _10071_/A0 _14299_/Q _09739_/S VDD VSS sg13g2_mux2_1
X_10980_ _10980_/Y _10978_/Y _11009_/D _11014_/A VDD VSS sg13g2_a21oi_1
XFILLER_83_660 VDD VSS sg13g2_decap_8
X_09639_ _09806_/D _09938_/A _09938_/B VDD VSS sg13g2_and2_1
XFILLER_55_373 VDD VSS sg13g2_decap_8
XFILLER_43_546 VDD VSS sg13g2_decap_8
XFILLER_130_53 VDD VSS sg13g2_decap_8
X_12650_ _12650_/X _12648_/X _12649_/X _12650_/S VDD VSS sg13g2_mux2_1
XFILLER_93_1240 VDD VSS sg13g2_decap_8
XFILLER_58_1371 VDD VSS sg13g2_decap_8
XFILLER_31_719 VDD VSS sg13g2_decap_8
XFILLER_180_1210 VDD VSS sg13g2_decap_8
XFILLER_54_1213 VDD VSS sg13g2_decap_8
XFILLER_24_760 VDD VSS sg13g2_decap_8
XFILLER_12_911 VDD VSS sg13g2_decap_8
X_11601_ _11601_/Y _11601_/A _11615_/B VDD VSS sg13g2_nand2_1
XFILLER_168_220 VDD VSS sg13g2_decap_8
XFILLER_30_218 VDD VSS sg13g2_decap_8
XFILLER_11_410 VDD VSS sg13g2_decap_8
X_12581_ _12581_/X _12580_/X _12579_/X _12609_/S VDD VSS sg13g2_mux2_1
XFILLER_70_398 VDD VSS sg13g2_decap_8
XFILLER_106_1314 VDD VSS sg13g2_decap_8
XFILLER_157_905 VDD VSS sg13g2_fill_1
XFILLER_19_1366 VDD VSS sg13g2_decap_8
XFILLER_157_916 VDD VSS sg13g2_decap_8
XFILLER_15_1208 VDD VSS sg13g2_decap_8
XFILLER_145_1385 VDD VSS sg13g2_decap_8
X_14320_ _14320_/Q _14637_/CLK _14320_/D _14320_/RESET_B VDD VSS sg13g2_dfrbpq_1
XFILLER_106_1347 VDD VSS sg13g2_decap_8
X_11532_ _11533_/B _11532_/A _11532_/B _11532_/C VDD VSS sg13g2_nand3_1
XFILLER_12_977 VDD VSS sg13g2_decap_8
XFILLER_180_1287 VDD VSS sg13g2_decap_8
XFILLER_184_735 VDD VSS sg13g2_decap_8
XFILLER_11_487 VDD VSS sg13g2_decap_8
X_14251_ _14251_/Q _14729_/CLK _14251_/D _14251_/RESET_B VDD VSS sg13g2_dfrbpq_1
XFILLER_156_459 VDD VSS sg13g2_decap_8
X_11463_ _11463_/Y _11463_/A _11463_/B _11463_/C VDD VSS sg13g2_nor3_1
XFILLER_99_11 VDD VSS sg13g2_fill_1
XFILLER_183_256 VDD VSS sg13g2_decap_8
XFILLER_109_353 VDD VSS sg13g2_decap_8
X_13202_ _13204_/B _13202_/A _13202_/B VDD VSS sg13g2_nand2_1
XFILLER_87_1011 VDD VSS sg13g2_decap_8
XFILLER_7_469 VDD VSS sg13g2_decap_8
XFILLER_109_364 VDD VSS sg13g2_fill_2
X_10414_ _10415_/A _14827_/Q _10414_/B _10414_/C _10414_/D VDD VSS sg13g2_and4_1
XFILLER_99_44 VDD VSS sg13g2_decap_8
X_14182_ _14182_/Q clkload50/A _14182_/D _14182_/RESET_B VDD VSS sg13g2_dfrbpq_1
X_11394_ _11395_/A _14687_/Q _14719_/Q _13759_/Q _13791_/Q _11403_/S0 _11419_/C VDD
+ VSS sg13g2_mux4_1
XFILLER_152_621 VDD VSS sg13g2_decap_8
XFILLER_139_1123 VDD VSS sg13g2_decap_4
XFILLER_3_620 VDD VSS sg13g2_decap_8
X_13133_ _13146_/C _14914_/Q _13673_/Q _13133_/C VDD VSS sg13g2_nand3_1
XFILLER_178_1194 VDD VSS sg13g2_decap_8
X_10345_ _10397_/B _14807_/Q _14808_/Q _10345_/C _10345_/D VDD VSS sg13g2_nand4_1
XFILLER_124_356 VDD VSS sg13g2_decap_8
XFILLER_79_900 VDD VSS sg13g2_fill_1
XFILLER_79_911 VDD VSS sg13g2_fill_1
X_13064_ _13172_/A _13064_/A _13064_/B VDD VSS sg13g2_xor2_1
XFILLER_79_922 VDD VSS sg13g2_fill_2
X_10276_ _10279_/B _14786_/Q _10305_/A _14787_/Q VDD VSS sg13g2_a21oi_1
XFILLER_79_944 VDD VSS sg13g2_decap_8
XFILLER_3_697 VDD VSS sg13g2_decap_8
XFILLER_105_592 VDD VSS sg13g2_decap_8
XFILLER_65_1375 VDD VSS sg13g2_decap_8
XFILLER_26_1326 VDD VSS sg13g2_decap_8
Xfanout1410 _10623_/A _10599_/A VDD VSS sg13g2_buf_1
X_12015_ _12019_/A _12014_/X _12233_/B VDD VSS sg13g2_nand2b_1
Xfanout1421 _10322_/C _10444_/C VDD VSS sg13g2_buf_1
XFILLER_2_196 VDD VSS sg13g2_decap_8
Xfanout1432 _13596_/B _13405_/B VDD VSS sg13g2_buf_1
XFILLER_61_1239 VDD VSS sg13g2_decap_8
XFILLER_120_562 VDD VSS sg13g2_decap_4
XFILLER_79_999 VDD VSS sg13g2_decap_8
XFILLER_66_627 VDD VSS sg13g2_decap_8
XFILLER_152_1389 VDD VSS sg13g2_decap_8
XFILLER_17_7 VDD VSS sg13g2_decap_8
XFILLER_93_446 VDD VSS sg13g2_decap_8
XFILLER_150_1080 VDD VSS sg13g2_decap_4
XFILLER_19_543 VDD VSS sg13g2_decap_8
X_13966_ _13966_/Q clkload58/A _13966_/D _13966_/RESET_B VDD VSS sg13g2_dfrbpq_1
XFILLER_93_468 VDD VSS sg13g2_fill_2
XFILLER_4_1155 VDD VSS sg13g2_decap_8
XFILLER_93_479 VDD VSS sg13g2_decap_8
XFILLER_185_1110 VDD VSS sg13g2_decap_8
XFILLER_46_351 VDD VSS sg13g2_decap_8
XFILLER_62_811 VDD VSS sg13g2_decap_8
X_12917_ _12917_/Y _14806_/Q _12851_/B _12930_/C1 VDD VSS sg13g2_a21oi_1
XFILLER_59_1135 VDD VSS sg13g2_fill_1
XFILLER_0_77 VDD VSS sg13g2_decap_8
X_13897_ _13897_/Q clkload28/A _13897_/D _13897_/RESET_B VDD VSS sg13g2_dfrbpq_1
XFILLER_94_1048 VDD VSS sg13g2_decap_4
XFILLER_61_332 VDD VSS sg13g2_decap_8
XFILLER_185_1187 VDD VSS sg13g2_decap_8
X_12848_ _12848_/X _14897_/Q _13690_/Q VDD VSS sg13g2_xor2_1
XFILLER_62_888 VDD VSS sg13g2_decap_8
XFILLER_76_1471 VDD VSS sg13g2_decap_8
XFILLER_159_220 VDD VSS sg13g2_decap_8
XFILLER_21_229 VDD VSS sg13g2_decap_8
XFILLER_72_1335 VDD VSS sg13g2_decap_8
XFILLER_37_1455 VDD VSS sg13g2_decap_8
XFILLER_14_270 VDD VSS sg13g2_decap_8
XFILLER_159_231 VDD VSS sg13g2_fill_2
X_12779_ _12792_/A _13400_/B _12779_/A2 hold3149/X VDD VSS sg13g2_a21oi_1
XFILLER_9_42 VDD VSS sg13g2_decap_8
XFILLER_159_264 VDD VSS sg13g2_decap_4
XFILLER_175_713 VDD VSS sg13g2_fill_2
X_14518_ _14518_/Q _14742_/CLK _14518_/D _14518_/RESET_B VDD VSS sg13g2_dfrbpq_1
XFILLER_119_106 VDD VSS sg13g2_decap_8
XFILLER_147_415 VDD VSS sg13g2_fill_1
XFILLER_80_90 VDD VSS sg13g2_decap_8
XFILLER_30_796 VDD VSS sg13g2_decap_8
X_14449_ _14449_/Q clkload33/A _14449_/D _14449_/RESET_B VDD VSS sg13g2_dfrbpq_1
XFILLER_31_1043 VDD VSS sg13g2_fill_2
XFILLER_156_971 VDD VSS sg13g2_decap_8
XFILLER_174_267 VDD VSS sg13g2_decap_8
XFILLER_122_1182 VDD VSS sg13g2_fill_1
XFILLER_162_429 VDD VSS sg13g2_decap_4
XFILLER_143_610 VDD VSS sg13g2_decap_8
XFILLER_31_1087 VDD VSS sg13g2_decap_8
XFILLER_116_857 VDD VSS sg13g2_decap_8
XFILLER_6_480 VDD VSS sg13g2_decap_8
XFILLER_157_1245 VDD VSS sg13g2_decap_8
X_09990_ _14573_/D _10023_/A0 _14573_/Q _09990_/S VDD VSS sg13g2_mux2_1
XFILLER_131_805 VDD VSS sg13g2_decap_4
XFILLER_115_367 VDD VSS sg13g2_decap_8
XFILLER_115_378 VDD VSS sg13g2_fill_1
XFILLER_83_1431 VDD VSS sg13g2_decap_8
XFILLER_143_698 VDD VSS sg13g2_decap_8
X_08941_ _13719_/D _16881_/A _08940_/X _08956_/S VDD VSS sg13g2_mux2_1
XFILLER_88_229 VDD VSS sg13g2_fill_2
XFILLER_9_1022 VDD VSS sg13g2_decap_8
X_08872_ _13701_/D _16863_/A _08871_/X _08876_/S VDD VSS sg13g2_mux2_1
XFILLER_69_454 VDD VSS sg13g2_decap_8
XFILLER_170_1445 VDD VSS sg13g2_decap_8
XFILLER_57_605 VDD VSS sg13g2_fill_1
XFILLER_44_1459 VDD VSS sg13g2_decap_8
XFILLER_28_18 VDD VSS sg13g2_decap_8
XFILLER_131_1429 VDD VSS sg13g2_decap_8
X_07823_ _07823_/Y _07822_/A _07822_/B _07818_/Y VDD VSS sg13g2_o21ai_1
XFILLER_97_796 VDD VSS sg13g2_fill_1
XFILLER_28_29 VDD VSS sg13g2_fill_1
Xclkbuf_5_15__f_clk_i clkbuf_leaf_48_clk_i/A clkbuf_4_7_0_clk_i/X VDD VSS sg13g2_buf_16
XFILLER_9_1099 VDD VSS sg13g2_decap_8
XFILLER_111_595 VDD VSS sg13g2_decap_8
XFILLER_56_126 VDD VSS sg13g2_decap_8
XFILLER_56_137 VDD VSS sg13g2_fill_1
X_13842__2360 _13842_/RESET_B VDD VSS sg13g2_tiehi
X_14007__2195 _14007_/RESET_B VDD VSS sg13g2_tiehi
X_07754_ _07754_/Y _13266_/A _07754_/B VDD VSS sg13g2_nor2_1
X_14858__2851 _14858_/RESET_B VDD VSS sg13g2_tiehi
XFILLER_65_660 VDD VSS sg13g2_decap_8
XFILLER_38_874 VDD VSS sg13g2_decap_8
X_07685_ _07687_/B _15055_/Q _11243_/B _13324_/A VDD VSS sg13g2_a21o_1
XFILLER_168_1363 VDD VSS sg13g2_decap_8
XFILLER_77_1257 VDD VSS sg13g2_decap_8
X_09424_ _14026_/D _09723_/A0 _14026_/Q _09428_/S VDD VSS sg13g2_mux2_1
XFILLER_129_1347 VDD VSS sg13g2_decap_8
XFILLER_129_1358 VDD VSS sg13g2_fill_1
XFILLER_164_1238 VDD VSS sg13g2_decap_8
X_14186__2016 _14186_/RESET_B VDD VSS sg13g2_tiehi
X_09355_ _13959_/D _10150_/A1 _13959_/Q _09364_/S VDD VSS sg13g2_mux2_1
XFILLER_40_538 VDD VSS sg13g2_fill_1
XFILLER_21_741 VDD VSS sg13g2_fill_1
XFILLER_100_56 VDD VSS sg13g2_decap_8
X_08306_ _08306_/Y _08306_/A _08306_/B _08306_/C VDD VSS sg13g2_nand3_1
XFILLER_139_938 VDD VSS sg13g2_decap_8
XFILLER_138_415 VDD VSS sg13g2_decap_8
X_09286_ _13894_/D _13894_/Q _10149_/A1 _09292_/S VDD VSS sg13g2_mux2_1
XFILLER_21_774 VDD VSS sg13g2_fill_1
XFILLER_60_38 VDD VSS sg13g2_decap_8
XFILLER_166_757 VDD VSS sg13g2_decap_8
XFILLER_166_768 VDD VSS sg13g2_fill_2
X_08237_ _08237_/Y _08036_/A _08234_/Y _08431_/C _08236_/X VDD VSS sg13g2_a22oi_1
XFILLER_165_245 VDD VSS sg13g2_decap_8
XFILLER_176_49 VDD VSS sg13g2_decap_8
XFILLER_101_1211 VDD VSS sg13g2_decap_8
XFILLER_105_1380 VDD VSS sg13g2_decap_8
XFILLER_125_109 VDD VSS sg13g2_decap_4
XFILLER_109_32 VDD VSS sg13g2_decap_8
XFILLER_153_429 VDD VSS sg13g2_decap_8
XFILLER_4_406 VDD VSS sg13g2_decap_8
XFILLER_10_1127 VDD VSS sg13g2_decap_8
X_08168_ _08168_/Y _08363_/S1 _08044_/X _08167_/X VDD VSS sg13g2_o21ai_1
XFILLER_118_172 VDD VSS sg13g2_decap_8
XFILLER_14_1296 VDD VSS sg13g2_decap_8
XFILLER_174_790 VDD VSS sg13g2_fill_2
XFILLER_179_1470 VDD VSS sg13g2_decap_8
XFILLER_162_941 VDD VSS sg13g2_decap_8
XFILLER_180_259 VDD VSS sg13g2_decap_8
X_08099_ _08200_/C _08278_/A3 _11526_/A _08253_/A1 _07929_/B _08102_/S0 _08048_/A
+ VDD VSS sg13g2_mux4_1
XFILLER_88_1397 VDD VSS sg13g2_decap_8
XFILLER_175_1356 VDD VSS sg13g2_decap_8
XFILLER_69_47 VDD VSS sg13g2_fill_1
XFILLER_49_1359 VDD VSS sg13g2_decap_8
XFILLER_122_827 VDD VSS sg13g2_decap_8
XFILLER_161_473 VDD VSS sg13g2_decap_8
X_10130_ _14708_/D _10130_/A0 _14708_/Q _10130_/S VDD VSS sg13g2_mux2_1
X_14217__1985 _14217_/RESET_B VDD VSS sg13g2_tiehi
Xclkbuf_leaf_112_clk_i _14602_/CLK clkbuf_5_7__f_clk_i/X VDD VSS sg13g2_buf_8
XFILLER_0_623 VDD VSS sg13g2_decap_8
XFILLER_121_337 VDD VSS sg13g2_decap_8
X_14993__2617 _14993_/RESET_B VDD VSS sg13g2_tiehi
X_10061_ _14642_/D _10094_/A0 _14642_/Q _10068_/S VDD VSS sg13g2_mux2_1
XFILLER_102_540 VDD VSS sg13g2_fill_2
XFILLER_76_903 VDD VSS sg13g2_decap_8
XFILLER_125_53 VDD VSS sg13g2_decap_4
XFILLER_48_616 VDD VSS sg13g2_decap_8
XFILLER_87_273 VDD VSS sg13g2_decap_8
XFILLER_134_1097 VDD VSS sg13g2_decap_4
XFILLER_75_435 VDD VSS sg13g2_decap_8
X_14396__1806 _14396_/RESET_B VDD VSS sg13g2_tiehi
XFILLER_5_1442 VDD VSS sg13g2_decap_8
X_13820_ _13820_/Q clkload76/A _13820_/D _13820_/RESET_B VDD VSS sg13g2_dfrbpq_1
Xclkbuf_leaf_127_clk_i clkload8/A clkload0/A VDD VSS sg13g2_buf_8
XFILLER_29_863 VDD VSS sg13g2_decap_8
X_14432__1770 _14432_/RESET_B VDD VSS sg13g2_tiehi
XFILLER_60_1294 VDD VSS sg13g2_decap_8
XFILLER_16_502 VDD VSS sg13g2_decap_4
XFILLER_44_811 VDD VSS sg13g2_decap_8
XFILLER_21_1267 VDD VSS sg13g2_decap_8
XFILLER_186_1441 VDD VSS sg13g2_decap_8
X_13751_ _13751_/Q clkload41/A _13751_/D _13751_/RESET_B VDD VSS sg13g2_dfrbpq_1
XFILLER_18_95 VDD VSS sg13g2_decap_8
X_10963_ _10964_/B _10949_/Y _11004_/A _10942_/Y VDD VSS sg13g2_a21oi_1
XFILLER_141_96 VDD VSS sg13g2_fill_2
X_12702_ _12702_/X _14580_/Q _14612_/Q _14644_/Q _14676_/Q _12703_/S0 _12703_/S1 VDD
+ VSS sg13g2_mux4_1
XFILLER_147_1447 VDD VSS sg13g2_decap_8
XFILLER_182_1327 VDD VSS sg13g2_decap_8
X_13682_ _13682_/Q _15214_/CLK _13682_/D _13682_/RESET_B VDD VSS sg13g2_dfrbpq_1
X_10894_ _10904_/B _10893_/A _10893_/B _10948_/A VDD VSS sg13g2_a21o_1
XFILLER_31_527 VDD VSS sg13g2_decap_8
X_12633_ _12633_/X _14703_/Q _14735_/Q _13775_/Q _13807_/Q _12686_/S0 _12686_/S1 VDD
+ VSS sg13g2_mux4_1
XFILLER_43_387 VDD VSS sg13g2_fill_1
XFILLER_157_702 VDD VSS sg13g2_decap_4
XFILLER_19_1163 VDD VSS sg13g2_decap_8
XFILLER_106_1122 VDD VSS sg13g2_decap_8
XFILLER_15_1005 VDD VSS sg13g2_decap_8
X_13705__2497 _13705_/RESET_B VDD VSS sg13g2_tiehi
XFILLER_54_1054 VDD VSS sg13g2_decap_8
XFILLER_129_404 VDD VSS sg13g2_decap_8
XFILLER_169_573 VDD VSS sg13g2_decap_8
XFILLER_169_584 VDD VSS sg13g2_decap_8
X_12564_ _12564_/X _13962_/Q _13994_/Q _14026_/Q _14058_/Q _12605_/S0 _12605_/S1 VDD
+ VSS sg13g2_mux4_1
XFILLER_156_212 VDD VSS sg13g2_decap_4
XFILLER_141_1035 VDD VSS sg13g2_fill_2
XFILLER_157_746 VDD VSS sg13g2_decap_8
XFILLER_180_1084 VDD VSS sg13g2_decap_8
X_14303_ _14303_/Q _14495_/CLK _14303_/D _14303_/RESET_B VDD VSS sg13g2_dfrbpq_1
XFILLER_89_1106 VDD VSS sg13g2_decap_8
XFILLER_12_796 VDD VSS sg13g2_decap_8
X_11515_ _11516_/A _11509_/X _11510_/X _11513_/X _11514_/X _11973_/B _11975_/A VDD
+ VSS sg13g2_mux4_1
XFILLER_32_1330 VDD VSS sg13g2_decap_8
XFILLER_11_284 VDD VSS sg13g2_decap_8
XFILLER_71_1390 VDD VSS sg13g2_decap_8
XFILLER_172_705 VDD VSS sg13g2_decap_8
X_12495_ _12495_/X _12492_/X _12491_/X _12488_/X _12487_/X _12608_/S1 _12608_/S0 VDD
+ VSS sg13g2_mux4_1
XFILLER_8_767 VDD VSS sg13g2_decap_8
XFILLER_172_716 VDD VSS sg13g2_fill_2
XFILLER_156_267 VDD VSS sg13g2_decap_8
XFILLER_184_587 VDD VSS sg13g2_decap_8
X_14234_ _14234_/Q _14682_/CLK _14234_/D _14234_/RESET_B VDD VSS sg13g2_dfrbpq_1
XFILLER_7_266 VDD VSS sg13g2_decap_8
XFILLER_172_738 VDD VSS sg13g2_decap_8
X_11446_ _11446_/Y _11446_/A _11446_/B VDD VSS sg13g2_nor2_1
X_13884__2318 _13884_/RESET_B VDD VSS sg13g2_tiehi
XFILLER_125_632 VDD VSS sg13g2_decap_8
XFILLER_50_93 VDD VSS sg13g2_decap_8
X_13920__2282 _13920_/RESET_B VDD VSS sg13g2_tiehi
X_14165_ _14165_/Q clkload42/A _14165_/D _14165_/RESET_B VDD VSS sg13g2_dfrbpq_1
XFILLER_67_1437 VDD VSS sg13g2_decap_8
XFILLER_152_440 VDD VSS sg13g2_decap_4
X_11377_ _11377_/Y _11375_/Y _11374_/Y _11822_/B _11376_/X VDD VSS sg13g2_a22oi_1
XFILLER_153_985 VDD VSS sg13g2_decap_8
XFILLER_98_516 VDD VSS sg13g2_decap_8
XFILLER_4_973 VDD VSS sg13g2_decap_8
XFILLER_113_827 VDD VSS sg13g2_fill_2
X_13116_ _13171_/A _13116_/A _13116_/B _13116_/C VDD VSS sg13g2_nand3_1
XFILLER_154_1429 VDD VSS sg13g2_decap_8
X_10328_ _14802_/D _10405_/C _10345_/C _10325_/B _07646_/Y _10435_/A VDD VSS sg13g2_a221oi_1
XFILLER_112_326 VDD VSS sg13g2_fill_2
XFILLER_140_635 VDD VSS sg13g2_fill_1
X_14096_ _14096_/Q clkload14/A _14096_/D _14096_/RESET_B VDD VSS sg13g2_dfrbpq_1
XFILLER_124_186 VDD VSS sg13g2_decap_8
XFILLER_140_646 VDD VSS sg13g2_decap_4
XFILLER_3_494 VDD VSS sg13g2_decap_8
XFILLER_112_348 VDD VSS sg13g2_decap_8
XFILLER_112_359 VDD VSS sg13g2_fill_2
XFILLER_117_1240 VDD VSS sg13g2_fill_2
XFILLER_152_1120 VDD VSS sg13g2_decap_8
X_13047_ _13048_/A _12937_/A _13046_/Y _12933_/Y VDD VSS sg13g2_o21ai_1
X_14969__2641 _14969_/RESET_B VDD VSS sg13g2_tiehi
XFILLER_65_1172 VDD VSS sg13g2_decap_8
XFILLER_26_1123 VDD VSS sg13g2_decap_8
XFILLER_152_1131 VDD VSS sg13g2_fill_2
X_10259_ _10259_/Y _10265_/A _10265_/D _10365_/C VDD VSS sg13g2_o21ai_1
XFILLER_79_763 VDD VSS sg13g2_decap_8
XFILLER_67_903 VDD VSS sg13g2_decap_8
XFILLER_61_1014 VDD VSS sg13g2_fill_2
XFILLER_61_1025 VDD VSS sg13g2_decap_8
XFILLER_152_1153 VDD VSS sg13g2_decap_8
XFILLER_182_81 VDD VSS sg13g2_decap_8
Xfanout1240 _13064_/B _13677_/Q VDD VSS sg13g2_buf_1
Xfanout1251 _12263_/C _11999_/S1 VDD VSS sg13g2_buf_1
Xfanout1262 _12291_/A _12174_/A VDD VSS sg13g2_buf_1
XFILLER_38_115 VDD VSS sg13g2_fill_1
Xfanout1273 _11473_/S1 fanout1281/X VDD VSS sg13g2_buf_1
XFILLER_61_1069 VDD VSS sg13g2_decap_8
XFILLER_93_221 VDD VSS sg13g2_decap_8
XFILLER_113_1159 VDD VSS sg13g2_decap_8
Xfanout1284 _11715_/S1 _12114_/S1 VDD VSS sg13g2_buf_1
XFILLER_82_906 VDD VSS sg13g2_decap_8
Xfanout1295 _11419_/C fanout1298/X VDD VSS sg13g2_buf_1
XFILLER_94_766 VDD VSS sg13g2_decap_8
XFILLER_130_1440 VDD VSS sg13g2_decap_8
X_14998_ _14998_/Q _15230_/CLK _14998_/D _14998_/RESET_B VDD VSS sg13g2_dfrbpq_1
XFILLER_82_939 VDD VSS sg13g2_decap_8
XFILLER_19_362 VDD VSS sg13g2_decap_8
X_13949_ _13949_/Q clkload29/A _13949_/D _13949_/RESET_B VDD VSS sg13g2_dfrbpq_1
XFILLER_81_449 VDD VSS sg13g2_decap_8
XFILLER_74_1408 VDD VSS sg13g2_decap_8
Xclkbuf_leaf_91_clk_i clkload66/A clkbuf_leaf_92_clk_i/A VDD VSS sg13g2_buf_8
XFILLER_90_972 VDD VSS sg13g2_fill_1
XFILLER_62_674 VDD VSS sg13g2_decap_4
XFILLER_50_825 VDD VSS sg13g2_fill_1
XFILLER_34_387 VDD VSS sg13g2_decap_8
XFILLER_61_184 VDD VSS sg13g2_decap_8
XFILLER_37_1252 VDD VSS sg13g2_decap_8
XFILLER_128_1380 VDD VSS sg13g2_decap_8
X_09140_ _10781_/A _15049_/Q _15246_/Q _09147_/B VDD VSS sg13g2_mux2_1
XFILLER_163_1282 VDD VSS sg13g2_decap_8
XFILLER_147_223 VDD VSS sg13g2_decap_4
XFILLER_175_543 VDD VSS sg13g2_fill_1
XFILLER_33_1149 VDD VSS sg13g2_decap_8
X_09071_ _13772_/D _13772_/Q _10155_/A1 _09084_/S VDD VSS sg13g2_mux2_1
XFILLER_163_705 VDD VSS sg13g2_decap_8
XFILLER_175_565 VDD VSS sg13g2_decap_8
XFILLER_147_267 VDD VSS sg13g2_fill_2
XFILLER_159_1318 VDD VSS sg13g2_decap_8
X_08022_ _08402_/C _08452_/C _08452_/D VDD VSS sg13g2_nand2_1
XFILLER_50_1463 VDD VSS sg13g2_decap_8
XFILLER_11_1436 VDD VSS sg13g2_decap_8
X_14474__1728 _14474_/RESET_B VDD VSS sg13g2_tiehi
XFILLER_144_952 VDD VSS sg13g2_decap_4
XFILLER_144_963 VDD VSS sg13g2_decap_8
X_14510__1692 _14510_/RESET_B VDD VSS sg13g2_tiehi
XFILLER_89_527 VDD VSS sg13g2_decap_8
XFILLER_131_624 VDD VSS sg13g2_decap_8
X_09973_ _14556_/D _10072_/A0 _14556_/Q _10003_/S VDD VSS sg13g2_mux2_1
XFILLER_130_123 VDD VSS sg13g2_decap_8
XFILLER_48_1370 VDD VSS sg13g2_decap_8
XFILLER_131_668 VDD VSS sg13g2_decap_8
X_08924_ _08924_/X _15044_/Q _14948_/Q _10757_/A VDD VSS sg13g2_mux2_1
XFILLER_39_39 VDD VSS sg13g2_fill_1
XFILLER_162_18 VDD VSS sg13g2_decap_8
XFILLER_170_1242 VDD VSS sg13g2_decap_8
XFILLER_97_560 VDD VSS sg13g2_decap_8
Xclkbuf_leaf_44_clk_i _14742_/CLK clkbuf_leaf_48_clk_i/A VDD VSS sg13g2_buf_8
XFILLER_44_1256 VDD VSS sg13g2_decap_8
X_08855_ _13696_/D _16858_/A _08854_/X _08861_/S VDD VSS sg13g2_mux2_1
XFILLER_97_593 VDD VSS sg13g2_decap_8
XFILLER_85_744 VDD VSS sg13g2_fill_1
XFILLER_57_435 VDD VSS sg13g2_decap_8
XFILLER_131_1248 VDD VSS sg13g2_fill_2
X_07806_ _07948_/A _07807_/C _08476_/A VDD VSS sg13g2_and2_1
X_08786_ _13680_/D _08728_/Y _08785_/Y _08784_/Y VDD VSS sg13g2_a21oi_1
XFILLER_73_928 VDD VSS sg13g2_decap_8
XFILLER_72_405 VDD VSS sg13g2_decap_8
XFILLER_77_1010 VDD VSS sg13g2_fill_1
X_07737_ _07737_/Y _07737_/A _07737_/B VDD VSS sg13g2_nand2_1
Xclkbuf_leaf_59_clk_i _14588_/CLK clkbuf_leaf_60_clk_i/A VDD VSS sg13g2_buf_8
XFILLER_25_321 VDD VSS sg13g2_fill_1
XFILLER_168_1160 VDD VSS sg13g2_decap_8
XFILLER_169_7 VDD VSS sg13g2_decap_8
XFILLER_37_192 VDD VSS sg13g2_decap_8
XFILLER_25_332 VDD VSS sg13g2_decap_8
X_07668_ _10171_/D _13613_/B _13613_/C VDD VSS sg13g2_nand2_1
XFILLER_41_814 VDD VSS sg13g2_fill_1
XFILLER_81_994 VDD VSS sg13g2_decap_8
X_09407_ _14010_/D _09638_/A0 _14010_/Q _09407_/S VDD VSS sg13g2_mux2_1
XFILLER_0_1394 VDD VSS sg13g2_decap_8
XFILLER_125_1019 VDD VSS sg13g2_decap_8
XFILLER_186_819 VDD VSS sg13g2_decap_8
XFILLER_179_860 VDD VSS sg13g2_decap_8
XFILLER_142_1300 VDD VSS sg13g2_fill_2
XFILLER_164_1079 VDD VSS sg13g2_decap_4
XFILLER_41_869 VDD VSS sg13g2_decap_8
XFILLER_107_1431 VDD VSS sg13g2_decap_8
XFILLER_55_1363 VDD VSS sg13g2_decap_8
XFILLER_40_357 VDD VSS sg13g2_decap_8
XFILLER_185_329 VDD VSS sg13g2_decap_8
X_09338_ _13945_/D _10168_/A1 _13945_/Q _09339_/S VDD VSS sg13g2_mux2_1
XFILLER_142_1333 VDD VSS sg13g2_decap_8
XFILLER_181_1393 VDD VSS sg13g2_decap_8
XFILLER_139_746 VDD VSS sg13g2_decap_4
XFILLER_90_1287 VDD VSS sg13g2_decap_8
XFILLER_16_1358 VDD VSS sg13g2_decap_8
XFILLER_127_908 VDD VSS sg13g2_decap_4
XFILLER_51_1249 VDD VSS sg13g2_decap_8
X_09269_ _13878_/D _13878_/Q _09933_/A1 _09273_/S VDD VSS sg13g2_mux2_1
XFILLER_142_1399 VDD VSS sg13g2_fill_1
XFILLER_126_418 VDD VSS sg13g2_decap_8
X_11300_ _11300_/X _14685_/Q _14717_/Q _13757_/Q _13789_/Q _11315_/A1 _12100_/S1 VDD
+ VSS sg13g2_mux4_1
XFILLER_177_1429 VDD VSS sg13g2_decap_8
X_12280_ _12280_/Y _12280_/A _12280_/B VDD VSS sg13g2_xnor2_1
XFILLER_4_203 VDD VSS sg13g2_decap_8
XFILLER_14_1093 VDD VSS sg13g2_decap_8
XFILLER_106_120 VDD VSS sg13g2_fill_1
X_11231_ _11231_/X _11230_/X _11227_/X _11231_/S VDD VSS sg13g2_mux2_1
XFILLER_106_131 VDD VSS sg13g2_decap_8
XFILLER_84_1003 VDD VSS sg13g2_decap_4
XFILLER_49_1123 VDD VSS sg13g2_fill_2
XFILLER_84_1014 VDD VSS sg13g2_fill_1
XFILLER_150_911 VDD VSS sg13g2_decap_8
XFILLER_20_63 VDD VSS sg13g2_decap_8
XFILLER_135_996 VDD VSS sg13g2_decap_8
XFILLER_175_1153 VDD VSS sg13g2_decap_8
XFILLER_134_473 VDD VSS sg13g2_decap_8
XFILLER_1_910 VDD VSS sg13g2_decap_8
XFILLER_106_175 VDD VSS sg13g2_decap_8
XFILLER_161_270 VDD VSS sg13g2_fill_2
X_11162_ _11162_/Y _14953_/Q _08943_/A _11152_/B _11180_/C _10781_/X VDD VSS sg13g2_a221oi_1
XFILLER_106_186 VDD VSS sg13g2_fill_2
XFILLER_122_635 VDD VSS sg13g2_decap_8
XFILLER_84_1058 VDD VSS sg13g2_decap_8
XFILLER_0_420 VDD VSS sg13g2_decap_8
XFILLER_121_123 VDD VSS sg13g2_fill_1
XFILLER_171_1028 VDD VSS sg13g2_decap_8
XFILLER_121_134 VDD VSS sg13g2_fill_1
X_10113_ _14691_/D _10113_/A0 _14691_/Q _10123_/S VDD VSS sg13g2_mux2_1
XFILLER_27_1432 VDD VSS sg13g2_decap_8
XFILLER_121_145 VDD VSS sg13g2_decap_8
X_11093_ _11093_/Y _11094_/B _11118_/C VDD VSS sg13g2_nand2_1
XFILLER_95_519 VDD VSS sg13g2_fill_1
XFILLER_76_700 VDD VSS sg13g2_decap_8
XFILLER_62_1334 VDD VSS sg13g2_decap_8
XFILLER_103_871 VDD VSS sg13g2_decap_8
XFILLER_1_987 VDD VSS sg13g2_decap_8
XFILLER_49_936 VDD VSS sg13g2_decap_8
XFILLER_23_1318 VDD VSS sg13g2_decap_8
X_14921_ _14921_/Q clkload68/A _14921_/D _14921_/RESET_B VDD VSS sg13g2_dfrbpq_1
X_10044_ _14625_/D _10077_/A0 _14625_/Q _10059_/S VDD VSS sg13g2_mux2_1
XFILLER_49_947 VDD VSS sg13g2_fill_1
XFILLER_29_50 VDD VSS sg13g2_fill_1
XFILLER_0_497 VDD VSS sg13g2_decap_8
XFILLER_114_1446 VDD VSS sg13g2_fill_1
XFILLER_49_969 VDD VSS sg13g2_decap_8
X_14852_ _14852_/Q clkload84/A _14852_/D _14852_/RESET_B VDD VSS sg13g2_dfrbpq_1
XFILLER_63_405 VDD VSS sg13g2_fill_1
XFILLER_75_276 VDD VSS sg13g2_decap_8
XFILLER_64_939 VDD VSS sg13g2_decap_8
XFILLER_91_736 VDD VSS sg13g2_fill_1
XFILLER_75_287 VDD VSS sg13g2_fill_1
XFILLER_63_427 VDD VSS sg13g2_decap_8
XFILLER_29_671 VDD VSS sg13g2_decap_8
X_13803_ _13803_/Q _14729_/CLK _13803_/D _13803_/RESET_B VDD VSS sg13g2_dfrbpq_1
XFILLER_90_213 VDD VSS sg13g2_decap_8
XFILLER_29_682 VDD VSS sg13g2_fill_2
X_14783_ _14783_/Q clkload87/A _14783_/D _14783_/RESET_B VDD VSS sg13g2_dfrbpq_1
XFILLER_21_1075 VDD VSS sg13g2_decap_8
X_11995_ _11995_/X _13841_/Q _13873_/Q _13905_/Q _13937_/Q _11997_/S0 _11997_/S1 VDD
+ VSS sg13g2_mux4_1
XFILLER_63_449 VDD VSS sg13g2_decap_8
XFILLER_147_1200 VDD VSS sg13g2_decap_4
XFILLER_17_855 VDD VSS sg13g2_decap_8
XFILLER_147_1211 VDD VSS sg13g2_fill_2
XFILLER_1_1169 VDD VSS sg13g2_decap_8
X_13734_ _13734_/Q _14724_/CLK _13734_/D _13734_/RESET_B VDD VSS sg13g2_dfrbpq_1
X_10946_ _10946_/Y _10946_/A _10946_/B VDD VSS sg13g2_nand2_1
XFILLER_32_803 VDD VSS sg13g2_decap_8
XFILLER_182_1124 VDD VSS sg13g2_decap_8
XFILLER_72_983 VDD VSS sg13g2_decap_8
XFILLER_44_685 VDD VSS sg13g2_decap_8
X_13938__2264 _13938_/RESET_B VDD VSS sg13g2_tiehi
XFILLER_31_302 VDD VSS sg13g2_decap_8
XFILLER_95_1198 VDD VSS sg13g2_decap_8
XFILLER_108_1228 VDD VSS sg13g2_decap_8
X_13665_ _13665_/Q clkload74/A _13665_/D _13665_/RESET_B VDD VSS sg13g2_dfrbpq_1
XFILLER_73_1430 VDD VSS sg13g2_decap_8
XFILLER_143_1119 VDD VSS sg13g2_decap_8
X_10877_ _10878_/B _10897_/D _10897_/B _10897_/A VDD VSS sg13g2_o21ai_1
XFILLER_31_335 VDD VSS sg13g2_decap_8
X_12616_ _12616_/X _14254_/Q _14286_/Q _14318_/Q _14350_/Q _12616_/S0 _12616_/S1 VDD
+ VSS sg13g2_mux4_1
XFILLER_129_201 VDD VSS sg13g2_decap_8
XFILLER_34_1425 VDD VSS sg13g2_decap_8
X_13596_ _13596_/Y _13600_/A _13596_/B VDD VSS sg13g2_nand2_1
XFILLER_160_1444 VDD VSS sg13g2_decap_8
XFILLER_169_381 VDD VSS sg13g2_decap_8
XFILLER_169_392 VDD VSS sg13g2_fill_2
X_14842__2883 _14842_/RESET_B VDD VSS sg13g2_tiehi
XFILLER_40_891 VDD VSS sg13g2_decap_8
X_12547_ _12547_/X _14569_/Q _14601_/Q _14633_/Q _14665_/Q _12550_/S0 _12550_/S1 VDD
+ VSS sg13g2_mux4_1
XFILLER_157_576 VDD VSS sg13g2_decap_8
XFILLER_185_885 VDD VSS sg13g2_decap_4
XFILLER_8_564 VDD VSS sg13g2_decap_8
XFILLER_177_81 VDD VSS sg13g2_decap_8
XFILLER_184_373 VDD VSS sg13g2_decap_8
XFILLER_117_429 VDD VSS sg13g2_decap_8
X_12478_ _12478_/X _13732_/Q _14084_/Q _14436_/Q _14532_/Q _12480_/S0 _12480_/S1 VDD
+ VSS sg13g2_mux4_1
XFILLER_6_32 VDD VSS sg13g2_decap_8
XANTENNA_3 _09225_/S VDD VSS sg13g2_antennanp
X_14217_ _14217_/Q clkload28/A _14217_/D _14217_/RESET_B VDD VSS sg13g2_dfrbpq_1
X_11429_ _11430_/B _11385_/B _11385_/A _11383_/Y VDD VSS sg13g2_o21ai_1
XFILLER_158_1340 VDD VSS sg13g2_decap_8
X_15197_ _15197_/Q clkload64/A _15197_/D _15197_/RESET_B VDD VSS sg13g2_dfrbpq_1
XFILLER_141_900 VDD VSS sg13g2_fill_2
XFILLER_153_760 VDD VSS sg13g2_decap_8
XFILLER_67_1234 VDD VSS sg13g2_decap_8
XFILLER_153_771 VDD VSS sg13g2_fill_2
XFILLER_154_1204 VDD VSS sg13g2_decap_8
X_14148_ _14148_/Q _14510_/CLK _14148_/D _14148_/RESET_B VDD VSS sg13g2_dfrbpq_1
XFILLER_4_770 VDD VSS sg13g2_decap_8
XFILLER_112_101 VDD VSS sg13g2_decap_4
XFILLER_98_335 VDD VSS sg13g2_decap_8
XFILLER_119_1357 VDD VSS sg13g2_fill_2
XFILLER_86_508 VDD VSS sg13g2_decap_8
XFILLER_80_1412 VDD VSS sg13g2_decap_8
XFILLER_3_291 VDD VSS sg13g2_decap_8
X_14079_ _14079_/Q clkload61/A _14079_/D _14079_/RESET_B VDD VSS sg13g2_dfrbpq_1
XFILLER_140_465 VDD VSS sg13g2_fill_2
XFILLER_39_402 VDD VSS sg13g2_decap_4
XFILLER_79_593 VDD VSS sg13g2_decap_8
XFILLER_41_1418 VDD VSS sg13g2_decap_8
XFILLER_94_530 VDD VSS sg13g2_decap_8
XFILLER_6_1047 VDD VSS sg13g2_decap_8
Xfanout1070 _08360_/A1 _14992_/Q VDD VSS sg13g2_buf_1
X_14752__2987 _14752_/RESET_B VDD VSS sg13g2_tiehi
Xfanout1081 _13521_/A _08635_/S1 VDD VSS sg13g2_buf_1
X_08640_ _08640_/X _08640_/A _08640_/B _08640_/C _08640_/D VDD VSS sg13g2_and4_1
Xfanout1092 _13509_/A1 _08635_/S0 VDD VSS sg13g2_buf_1
XFILLER_94_574 VDD VSS sg13g2_fill_1
XFILLER_55_928 VDD VSS sg13g2_decap_4
XFILLER_27_619 VDD VSS sg13g2_fill_2
X_08571_ _08571_/Y _08574_/C _08574_/D VDD VSS sg13g2_nand2_1
XFILLER_81_224 VDD VSS sg13g2_fill_2
XFILLER_148_1019 VDD VSS sg13g2_fill_1
XFILLER_19_170 VDD VSS sg13g2_decap_8
XFILLER_130_1292 VDD VSS sg13g2_decap_8
XFILLER_78_1352 VDD VSS sg13g2_decap_8
XFILLER_35_641 VDD VSS sg13g2_decap_8
XFILLER_81_257 VDD VSS sg13g2_decap_8
XFILLER_165_1322 VDD VSS sg13g2_decap_8
XFILLER_74_1205 VDD VSS sg13g2_decap_8
XFILLER_81_279 VDD VSS sg13g2_decap_8
XFILLER_39_1336 VDD VSS sg13g2_decap_8
XFILLER_34_140 VDD VSS sg13g2_fill_1
XFILLER_34_151 VDD VSS sg13g2_fill_2
XFILLER_179_123 VDD VSS sg13g2_decap_8
XFILLER_22_302 VDD VSS sg13g2_decap_4
X_14528__1674 _14528_/RESET_B VDD VSS sg13g2_tiehi
XFILLER_34_184 VDD VSS sg13g2_decap_8
XFILLER_161_1219 VDD VSS sg13g2_decap_8
XFILLER_23_869 VDD VSS sg13g2_decap_8
XFILLER_165_1399 VDD VSS sg13g2_decap_8
XFILLER_22_346 VDD VSS sg13g2_fill_1
XFILLER_50_655 VDD VSS sg13g2_decap_8
XFILLER_50_677 VDD VSS sg13g2_decap_8
X_09123_ _09150_/C _14919_/Q _13189_/A _13156_/A VDD VSS sg13g2_and3_1
XFILLER_157_18 VDD VSS sg13g2_decap_8
XFILLER_176_885 VDD VSS sg13g2_decap_4
XFILLER_124_1096 VDD VSS sg13g2_fill_2
XFILLER_175_373 VDD VSS sg13g2_decap_4
XFILLER_108_429 VDD VSS sg13g2_fill_1
X_09054_ _10725_/B _09060_/S _15036_/Q _09053_/Y VDD VSS sg13g2_o21ai_1
XFILLER_50_1260 VDD VSS sg13g2_decap_8
XFILLER_136_749 VDD VSS sg13g2_decap_8
XFILLER_11_1233 VDD VSS sg13g2_decap_8
X_08005_ _08005_/X _08465_/A3 _11798_/A _08493_/B2 _08909_/A1 _08083_/S0 _08102_/S0
+ VDD VSS sg13g2_mux4_1
XFILLER_151_719 VDD VSS sg13g2_decap_8
XFILLER_2_707 VDD VSS sg13g2_decap_8
XFILLER_117_985 VDD VSS sg13g2_fill_2
XFILLER_85_1334 VDD VSS sg13g2_decap_8
XFILLER_89_313 VDD VSS sg13g2_decap_8
XFILLER_116_484 VDD VSS sg13g2_fill_1
XFILLER_173_28 VDD VSS sg13g2_decap_8
XFILLER_1_217 VDD VSS sg13g2_decap_8
XFILLER_104_635 VDD VSS sg13g2_decap_8
XFILLER_132_944 VDD VSS sg13g2_decap_8
Xclkbuf_5_30__f_clk_i clkbuf_leaf_78_clk_i/A clkbuf_4_15_0_clk_i/X VDD VSS sg13g2_buf_16
XFILLER_81_1209 VDD VSS sg13g2_decap_8
XFILLER_172_1326 VDD VSS sg13g2_decap_8
XFILLER_106_11 VDD VSS sg13g2_fill_2
X_09956_ _14540_/D _14540_/Q _09989_/A0 _09958_/S VDD VSS sg13g2_mux2_1
XFILLER_44_1031 VDD VSS sg13g2_decap_8
XFILLER_131_487 VDD VSS sg13g2_decap_8
X_08907_ _08907_/Y _10735_/A _14944_/Q VDD VSS sg13g2_nand2_1
XFILLER_58_722 VDD VSS sg13g2_decap_8
X_09887_ _14473_/D _09920_/A1 _14473_/Q _09898_/S VDD VSS sg13g2_mux2_1
XFILLER_106_99 VDD VSS sg13g2_decap_8
XFILLER_58_755 VDD VSS sg13g2_decap_8
XFILLER_131_1045 VDD VSS sg13g2_decap_8
X_08838_ _08838_/Y _10697_/C _08977_/C VDD VSS sg13g2_nand2_1
XFILLER_85_563 VDD VSS sg13g2_decap_8
XFILLER_79_1105 VDD VSS sg13g2_fill_1
XFILLER_73_714 VDD VSS sg13g2_decap_8
XFILLER_46_939 VDD VSS sg13g2_decap_4
XFILLER_45_416 VDD VSS sg13g2_fill_2
XFILLER_100_896 VDD VSS sg13g2_decap_8
XFILLER_79_1138 VDD VSS sg13g2_decap_8
XFILLER_73_736 VDD VSS sg13g2_fill_1
XFILLER_79_1149 VDD VSS sg13g2_fill_2
X_08769_ _08769_/Y _13675_/Q _08810_/B VDD VSS sg13g2_nor2_1
XFILLER_72_224 VDD VSS sg13g2_fill_1
XFILLER_22_1384 VDD VSS sg13g2_decap_8
XFILLER_96_1441 VDD VSS sg13g2_decap_8
XFILLER_72_235 VDD VSS sg13g2_fill_2
XFILLER_2_1456 VDD VSS sg13g2_decap_8
XFILLER_183_1400 VDD VSS sg13g2_decap_8
XFILLER_54_950 VDD VSS sg13g2_fill_2
XFILLER_167_4 VDD VSS sg13g2_decap_8
X_10800_ _10800_/Y _10800_/A _10800_/B VDD VSS sg13g2_nand2_1
XFILLER_82_25 VDD VSS sg13g2_decap_8
X_11780_ _11780_/Y _11910_/A _11912_/A VDD VSS sg13g2_xnor2_1
XFILLER_54_972 VDD VSS sg13g2_fill_1
XFILLER_57_1436 VDD VSS sg13g2_decap_8
XFILLER_92_1327 VDD VSS sg13g2_decap_8
XFILLER_53_471 VDD VSS sg13g2_decap_8
X_10731_ _14910_/D _11045_/B1 _10995_/B _10730_/Y VDD VSS sg13g2_o21ai_1
XFILLER_14_858 VDD VSS sg13g2_decap_8
XFILLER_40_110 VDD VSS sg13g2_decap_8
XFILLER_0_1191 VDD VSS sg13g2_decap_8
XFILLER_40_121 VDD VSS sg13g2_fill_2
XFILLER_144_1439 VDD VSS sg13g2_decap_8
XFILLER_14_869 VDD VSS sg13g2_fill_1
XFILLER_15_63 VDD VSS sg13g2_decap_8
XFILLER_186_616 VDD VSS sg13g2_decap_8
XFILLER_13_368 VDD VSS sg13g2_decap_8
X_13450_ _13455_/B _15172_/Q _15173_/Q VDD VSS sg13g2_nand2b_1
XFILLER_55_1160 VDD VSS sg13g2_decap_8
X_10662_ _10664_/C _14892_/Q _10666_/D _14893_/Q VDD VSS sg13g2_a21oi_1
XFILLER_185_126 VDD VSS sg13g2_decap_8
XFILLER_90_1062 VDD VSS sg13g2_decap_8
XFILLER_181_1190 VDD VSS sg13g2_decap_8
X_12401_ _12401_/Y _15122_/Q _12348_/A _12596_/A2 _13690_/Q _12596_/C1 VDD VSS sg13g2_a221oi_1
XFILLER_107_1272 VDD VSS sg13g2_decap_8
XFILLER_16_1155 VDD VSS sg13g2_decap_8
XFILLER_51_1035 VDD VSS sg13g2_fill_1
X_13381_ _13382_/B _13389_/A _13391_/A VDD VSS sg13g2_nor2_1
XFILLER_127_705 VDD VSS sg13g2_decap_4
X_10593_ _10595_/C _14874_/Q _10597_/D _14875_/Q VDD VSS sg13g2_a21oi_1
XFILLER_103_1125 VDD VSS sg13g2_decap_8
XFILLER_127_716 VDD VSS sg13g2_fill_2
XFILLER_12_1019 VDD VSS sg13g2_decap_8
XFILLER_154_513 VDD VSS sg13g2_decap_8
X_15120_ _15120_/Q _15212_/CLK _15120_/D _15120_/RESET_B VDD VSS sg13g2_dfrbpq_1
XFILLER_51_1068 VDD VSS sg13g2_decap_8
X_12332_ _12332_/Y _12308_/Y _12310_/Y _12174_/A VDD VSS sg13g2_a21oi_1
XFILLER_103_1169 VDD VSS sg13g2_decap_8
XFILLER_182_844 VDD VSS sg13g2_decap_8
XFILLER_110_0 VDD VSS sg13g2_decap_8
XFILLER_177_1226 VDD VSS sg13g2_decap_8
X_15051_ _15051_/Q _15052_/CLK _15051_/D _15051_/RESET_B VDD VSS sg13g2_dfrbpq_1
XFILLER_31_84 VDD VSS sg13g2_decap_8
XFILLER_147_62 VDD VSS sg13g2_decap_8
X_12263_ _12263_/Y _12261_/Y _12263_/B _12263_/C VDD VSS sg13g2_nand3b_1
XFILLER_135_760 VDD VSS sg13g2_decap_8
XFILLER_5_567 VDD VSS sg13g2_decap_8
XFILLER_141_207 VDD VSS sg13g2_decap_8
X_14002_ _14002_/Q clkload40/A _14002_/D _14002_/RESET_B VDD VSS sg13g2_dfrbpq_1
XFILLER_107_473 VDD VSS sg13g2_decap_8
X_11214_ _11216_/A _12184_/B _11211_/X _11213_/X VDD VSS sg13g2_a21oi_1
XFILLER_64_1407 VDD VSS sg13g2_decap_8
X_12194_ _12194_/X _14921_/Q _12338_/A2 _12193_/Y VDD VSS sg13g2_a21o_1
Xoutput40 mem_axi_araddr[11] _16864_/A VDD VSS sg13g2_buf_1
XFILLER_150_741 VDD VSS sg13g2_fill_1
Xoutput51 mem_axi_araddr[22] _16875_/A VDD VSS sg13g2_buf_1
Xoutput62 mem_axi_araddr[3] _16856_/A VDD VSS sg13g2_buf_1
XFILLER_123_977 VDD VSS sg13g2_decap_8
Xoutput73 mem_axi_awaddr[12] _16865_/X VDD VSS sg13g2_buf_1
X_11145_ _11150_/B _11172_/A _11164_/B VDD VSS sg13g2_xnor2_1
Xoutput84 mem_axi_awaddr[23] _16876_/X VDD VSS sg13g2_buf_1
XFILLER_96_828 VDD VSS sg13g2_fill_2
Xoutput95 mem_axi_awaddr[4] _16857_/X VDD VSS sg13g2_buf_1
XFILLER_62_1131 VDD VSS sg13g2_decap_8
XFILLER_1_784 VDD VSS sg13g2_decap_8
XFILLER_7_1323 VDD VSS sg13g2_decap_8
X_14606__1596 _14606_/RESET_B VDD VSS sg13g2_tiehi
XFILLER_89_891 VDD VSS sg13g2_fill_1
X_11076_ _11077_/B _11088_/A _11118_/A _11058_/Y VDD VSS sg13g2_a21oi_1
XFILLER_88_390 VDD VSS sg13g2_decap_8
XFILLER_0_294 VDD VSS sg13g2_decap_8
X_14181__2021 _14181_/RESET_B VDD VSS sg13g2_tiehi
X_14904_ _14904_/Q clkload62/A _14904_/D _14904_/RESET_B VDD VSS sg13g2_dfrbpq_1
X_10027_ _14609_/D _10160_/A1 _14609_/Q _10035_/S VDD VSS sg13g2_mux2_1
XFILLER_110_1107 VDD VSS sg13g2_fill_2
XFILLER_97_1216 VDD VSS sg13g2_decap_8
XFILLER_97_1227 VDD VSS sg13g2_decap_4
XFILLER_36_438 VDD VSS sg13g2_decap_8
X_14835_ _14835_/Q clkload67/A _14835_/D _14835_/RESET_B VDD VSS sg13g2_dfrbpq_1
XFILLER_40_1473 VDD VSS sg13g2_fill_2
XFILLER_36_449 VDD VSS sg13g2_fill_2
XFILLER_184_1219 VDD VSS sg13g2_decap_8
XFILLER_56_92 VDD VSS sg13g2_decap_8
X_14766_ _14766_/Q _15165_/CLK _14766_/D _14766_/RESET_B VDD VSS sg13g2_dfrbpq_1
X_11978_ _11978_/Y _11977_/X _11458_/A _11978_/B1 VDD VSS sg13g2_a21oi_1
XFILLER_147_1041 VDD VSS sg13g2_decap_8
XFILLER_32_622 VDD VSS sg13g2_fill_2
XFILLER_16_184 VDD VSS sg13g2_fill_2
X_13717_ _16879_/A clkload56/A _13717_/D _13717_/RESET_B VDD VSS sg13g2_dfrbpq_1
X_10929_ _10929_/Y _10929_/A _10929_/B VDD VSS sg13g2_nand2_1
X_14697_ _14697_/Q _14729_/CLK _14697_/D _14697_/RESET_B VDD VSS sg13g2_dfrbpq_1
XFILLER_149_307 VDD VSS sg13g2_decap_8
XFILLER_108_1036 VDD VSS sg13g2_decap_8
XFILLER_176_126 VDD VSS sg13g2_decap_8
X_13648_ _14760_/D _15188_/D _14760_/Q _13648_/S VDD VSS sg13g2_mux2_1
XFILLER_34_1222 VDD VSS sg13g2_decap_8
XFILLER_31_165 VDD VSS sg13g2_decap_8
XFILLER_82_4 VDD VSS sg13g2_decap_8
XFILLER_38_1391 VDD VSS sg13g2_decap_8
XFILLER_160_1241 VDD VSS sg13g2_decap_8
XFILLER_9_840 VDD VSS sg13g2_decap_8
XFILLER_121_1203 VDD VSS sg13g2_decap_8
XFILLER_125_1372 VDD VSS sg13g2_fill_2
X_13579_ _15158_/D _13590_/B _13577_/Y _13578_/Y VDD VSS sg13g2_a21oi_1
X_14212__1990 _14212_/RESET_B VDD VSS sg13g2_tiehi
XFILLER_8_361 VDD VSS sg13g2_decap_8
XFILLER_172_310 VDD VSS sg13g2_decap_8
XFILLER_34_1299 VDD VSS sg13g2_decap_8
XFILLER_184_170 VDD VSS sg13g2_decap_8
XFILLER_69_1318 VDD VSS sg13g2_decap_8
XFILLER_117_248 VDD VSS sg13g2_fill_2
XFILLER_173_866 VDD VSS sg13g2_fill_2
X_15249_ _15249_/Q clkload46/A _15249_/D _15249_/RESET_B VDD VSS sg13g2_dfrbpq_1
XFILLER_132_207 VDD VSS sg13g2_fill_2
XFILLER_172_398 VDD VSS sg13g2_decap_8
X_14391__1811 _14391_/RESET_B VDD VSS sg13g2_tiehi
XFILLER_67_1075 VDD VSS sg13g2_decap_8
Xfanout307 _10156_/S _10163_/S VDD VSS sg13g2_buf_1
X_09810_ _14398_/D _10074_/A0 _14398_/Q _09822_/S VDD VSS sg13g2_mux2_1
XFILLER_119_1165 VDD VSS sg13g2_decap_8
Xfanout318 _09957_/S _09964_/S VDD VSS sg13g2_buf_1
XFILLER_141_774 VDD VSS sg13g2_decap_8
Xfanout329 _09925_/S _09905_/X VDD VSS sg13g2_buf_1
XFILLER_140_262 VDD VSS sg13g2_decap_8
XFILLER_45_1340 VDD VSS sg13g2_decap_8
XFILLER_101_627 VDD VSS sg13g2_fill_2
X_09741_ _14331_/D _14331_/Q _09741_/A1 _09772_/S VDD VSS sg13g2_mux2_1
XFILLER_80_1242 VDD VSS sg13g2_decap_8
XFILLER_140_284 VDD VSS sg13g2_decap_4
XFILLER_86_349 VDD VSS sg13g2_decap_8
XFILLER_41_1215 VDD VSS sg13g2_decap_8
XFILLER_171_1392 VDD VSS sg13g2_decap_8
XFILLER_132_1354 VDD VSS sg13g2_decap_8
X_09672_ _14265_/D _09903_/A0 _14265_/Q _09672_/S VDD VSS sg13g2_mux2_1
X_13672__2551 _13672_/RESET_B VDD VSS sg13g2_tiehi
X_08623_ _08623_/Y _07849_/X _08001_/A _08001_/C VDD VSS sg13g2_o21ai_1
XFILLER_55_736 VDD VSS sg13g2_decap_4
XFILLER_39_287 VDD VSS sg13g2_decap_8
XFILLER_94_393 VDD VSS sg13g2_fill_2
X_08554_ _08554_/Y _08612_/S _08550_/Y _08553_/A VDD VSS sg13g2_o21ai_1
XFILLER_63_780 VDD VSS sg13g2_decap_8
XFILLER_74_1035 VDD VSS sg13g2_decap_8
X_14923__2721 _14923_/RESET_B VDD VSS sg13g2_tiehi
X_08485_ _08485_/Y _07822_/B _08001_/A _08001_/C VDD VSS sg13g2_o21ai_1
X_14044__2158 _14044_/RESET_B VDD VSS sg13g2_tiehi
XFILLER_62_290 VDD VSS sg13g2_decap_8
XFILLER_126_1136 VDD VSS sg13g2_decap_8
XFILLER_168_627 VDD VSS sg13g2_fill_1
XFILLER_165_1196 VDD VSS sg13g2_decap_8
XFILLER_17_1420 VDD VSS sg13g2_decap_8
XFILLER_23_677 VDD VSS sg13g2_decap_8
XFILLER_168_28 VDD VSS sg13g2_decap_8
XFILLER_91_1360 VDD VSS sg13g2_decap_8
XFILLER_11_839 VDD VSS sg13g2_decap_8
XFILLER_167_137 VDD VSS sg13g2_decap_8
XFILLER_52_1333 VDD VSS sg13g2_decap_8
XFILLER_13_1306 VDD VSS sg13g2_decap_8
XFILLER_148_340 VDD VSS sg13g2_fill_1
XFILLER_104_1434 VDD VSS sg13g2_decap_8
XFILLER_109_727 VDD VSS sg13g2_decap_8
X_09106_ _13777_/D _13777_/Q _10160_/A1 _09153_/S VDD VSS sg13g2_mux2_1
X_14956__2655 _14956_/RESET_B VDD VSS sg13g2_tiehi
XFILLER_100_1309 VDD VSS sg13g2_decap_4
XFILLER_108_226 VDD VSS sg13g2_fill_1
XFILLER_11_1030 VDD VSS sg13g2_decap_8
XFILLER_163_343 VDD VSS sg13g2_fill_2
XFILLER_184_16 VDD VSS sg13g2_decap_8
XFILLER_124_708 VDD VSS sg13g2_decap_8
X_09037_ _09037_/X _09069_/A _09034_/X _09036_/Y VDD VSS sg13g2_a21o_1
XFILLER_151_516 VDD VSS sg13g2_fill_2
XFILLER_2_504 VDD VSS sg13g2_decap_8
XFILLER_117_21 VDD VSS sg13g2_decap_8
XFILLER_117_782 VDD VSS sg13g2_decap_8
XFILLER_85_1131 VDD VSS sg13g2_decap_8
XFILLER_85_1142 VDD VSS sg13g2_fill_1
XFILLER_116_270 VDD VSS sg13g2_decap_8
XFILLER_151_549 VDD VSS sg13g2_decap_8
XFILLER_172_1123 VDD VSS sg13g2_decap_8
XFILLER_117_76 VDD VSS sg13g2_fill_2
XFILLER_77_25 VDD VSS sg13g2_decap_8
XFILLER_46_1148 VDD VSS sg13g2_decap_8
XFILLER_132_774 VDD VSS sg13g2_fill_1
XFILLER_85_1197 VDD VSS sg13g2_decap_8
XFILLER_78_828 VDD VSS sg13g2_decap_8
XFILLER_120_925 VDD VSS sg13g2_decap_8
XFILLER_133_1118 VDD VSS sg13g2_decap_8
Xfanout830 _12576_/S1 _12699_/S1 VDD VSS sg13g2_buf_1
XFILLER_77_58 VDD VSS sg13g2_decap_8
Xfanout841 fanout841/X _12589_/S1 VDD VSS sg13g2_buf_1
XFILLER_104_498 VDD VSS sg13g2_decap_8
Xfanout852 _12674_/S1 _12717_/S1 VDD VSS sg13g2_buf_1
X_09939_ _14523_/D _14523_/Q _10005_/A0 _09970_/S VDD VSS sg13g2_mux2_1
XFILLER_24_1424 VDD VSS sg13g2_decap_8
Xfanout863 _12752_/S1 fanout867/X VDD VSS sg13g2_buf_1
Xfanout874 _12643_/S0 fanout876/X VDD VSS sg13g2_buf_1
XFILLER_58_541 VDD VSS sg13g2_decap_8
Xfanout885 _12536_/S0 fanout889/X VDD VSS sg13g2_buf_1
XFILLER_150_1454 VDD VSS sg13g2_decap_8
X_12950_ _12950_/Y _12947_/Y _12948_/Y _12949_/Y VDD VSS sg13g2_a21oi_1
Xfanout896 _12589_/S0 fanout915/X VDD VSS sg13g2_buf_1
XFILLER_111_1416 VDD VSS sg13g2_decap_8
XFILLER_86_883 VDD VSS sg13g2_fill_2
X_14254__1948 _14254_/RESET_B VDD VSS sg13g2_tiehi
XFILLER_18_427 VDD VSS sg13g2_decap_8
X_11901_ _11902_/A _11898_/Y _11900_/Y _11901_/B1 VDD VSS sg13g2_a21oi_1
XFILLER_45_213 VDD VSS sg13g2_fill_1
XFILLER_93_35 VDD VSS sg13g2_decap_8
XFILLER_45_224 VDD VSS sg13g2_fill_2
X_12881_ _12881_/Y _14772_/Q _12918_/A2 _12918_/B1 VDD VSS sg13g2_o21ai_1
XFILLER_85_393 VDD VSS sg13g2_fill_1
XFILLER_34_909 VDD VSS sg13g2_fill_1
XFILLER_22_1181 VDD VSS sg13g2_decap_8
XFILLER_2_1253 VDD VSS sg13g2_decap_8
X_14620_ _14620_/Q clkload77/A _14620_/D _14620_/RESET_B VDD VSS sg13g2_dfrbpq_1
X_11832_ _11832_/Y _11830_/Y _11832_/B _11832_/C VDD VSS sg13g2_nand3b_1
XFILLER_45_268 VDD VSS sg13g2_decap_8
XFILLER_96_1282 VDD VSS sg13g2_decap_8
XFILLER_57_1233 VDD VSS sg13g2_decap_8
X_14551_ _14551_/Q clkload43/A _14551_/D _14551_/RESET_B VDD VSS sg13g2_dfrbpq_1
XFILLER_26_84 VDD VSS sg13g2_decap_8
XFILLER_158_0 VDD VSS sg13g2_decap_8
X_11763_ _11763_/Y _11763_/A _11875_/B VDD VSS sg13g2_nand2_1
XFILLER_14_644 VDD VSS sg13g2_decap_8
XFILLER_18_1217 VDD VSS sg13g2_decap_8
XFILLER_183_1274 VDD VSS sg13g2_decap_8
XFILLER_109_1345 VDD VSS sg13g2_decap_8
XFILLER_186_413 VDD VSS sg13g2_decap_8
X_13502_ _13504_/A _13656_/S _13502_/B _15175_/D _13502_/D VDD VSS sg13g2_or4_1
X_10714_ _10714_/Y _14906_/Q _10973_/B VDD VSS sg13g2_nand2_1
X_14482_ _14482_/Q _14546_/CLK _14482_/D _14482_/RESET_B VDD VSS sg13g2_dfrbpq_1
XFILLER_13_165 VDD VSS sg13g2_decap_8
XFILLER_144_1258 VDD VSS sg13g2_decap_8
XFILLER_158_126 VDD VSS sg13g2_fill_2
X_11694_ _11694_/Y _11694_/A _11694_/B _11898_/C VDD VSS sg13g2_nand3_1
XFILLER_41_474 VDD VSS sg13g2_decap_8
X_13433_ _13433_/Y _13433_/A _13442_/B _13444_/C VDD VSS sg13g2_nor3_1
X_10645_ _14889_/D _14889_/Q _10643_/C _10644_/Y VDD VSS sg13g2_a21oi_1
XFILLER_9_147 VDD VSS sg13g2_decap_8
XFILLER_70_1455 VDD VSS sg13g2_decap_8
XFILLER_10_861 VDD VSS sg13g2_decap_8
XFILLER_154_310 VDD VSS sg13g2_decap_8
X_13364_ _13435_/A _13429_/A _13364_/B VDD VSS sg13g2_nand2_1
X_10576_ _10584_/C _14870_/Q _12895_/A _10576_/C _10576_/D VDD VSS sg13g2_and4_1
X_14199__2003 _14199_/RESET_B VDD VSS sg13g2_tiehi
X_15103_ _15103_/Q clkload71/A _15103_/D _15103_/RESET_B VDD VSS sg13g2_dfrbpq_1
X_12315_ _12315_/Y _12311_/Y _12312_/Y _12314_/Y _12313_/Y _12324_/B VDD VSS sg13g2_a221oi_1
XFILLER_181_140 VDD VSS sg13g2_decap_8
XFILLER_6_865 VDD VSS sg13g2_decap_8
XFILLER_142_505 VDD VSS sg13g2_fill_2
XFILLER_154_365 VDD VSS sg13g2_decap_8
X_13295_ _13295_/Y _07672_/X _15053_/Q _13294_/Y VDD VSS sg13g2_a21oi_1
XFILLER_182_685 VDD VSS sg13g2_fill_1
XFILLER_108_771 VDD VSS sg13g2_fill_2
XFILLER_5_364 VDD VSS sg13g2_decap_8
XFILLER_108_782 VDD VSS sg13g2_fill_2
X_15034_ _15034_/Q clkload59/A _15034_/D _15034_/RESET_B VDD VSS sg13g2_dfrbpq_1
XFILLER_170_847 VDD VSS sg13g2_decap_8
X_12246_ _12246_/X _12246_/A _12253_/B VDD VSS sg13g2_and2_1
XFILLER_170_858 VDD VSS sg13g2_fill_2
XFILLER_64_1204 VDD VSS sg13g2_decap_8
XFILLER_107_281 VDD VSS sg13g2_fill_2
XFILLER_29_1324 VDD VSS sg13g2_decap_8
XFILLER_68_1384 VDD VSS sg13g2_decap_8
XFILLER_155_1354 VDD VSS sg13g2_decap_8
XFILLER_96_603 VDD VSS sg13g2_decap_8
XFILLER_3_11 VDD VSS sg13g2_decap_8
X_12177_ _12177_/Y _12189_/S0 _14486_/Q VDD VSS sg13g2_nand2b_1
XFILLER_96_614 VDD VSS sg13g2_fill_1
XFILLER_111_936 VDD VSS sg13g2_decap_4
XFILLER_110_413 VDD VSS sg13g2_decap_8
X_11128_ _11128_/Y _11128_/A _11128_/B VDD VSS sg13g2_nand2_1
XFILLER_7_1120 VDD VSS sg13g2_decap_8
XFILLER_1_581 VDD VSS sg13g2_decap_8
XFILLER_68_349 VDD VSS sg13g2_decap_8
XFILLER_3_88 VDD VSS sg13g2_decap_8
XFILLER_114_1040 VDD VSS sg13g2_decap_8
XFILLER_95_168 VDD VSS sg13g2_decap_8
X_11059_ _11118_/A _11086_/A _11078_/B VDD VSS sg13g2_xnor2_1
XFILLER_77_883 VDD VSS sg13g2_decap_8
XFILLER_49_574 VDD VSS sg13g2_decap_4
XFILLER_7_1197 VDD VSS sg13g2_decap_8
XFILLER_49_596 VDD VSS sg13g2_decap_4
XFILLER_97_1024 VDD VSS sg13g2_decap_8
XFILLER_64_522 VDD VSS sg13g2_fill_1
XFILLER_92_842 VDD VSS sg13g2_decap_4
XFILLER_64_544 VDD VSS sg13g2_decap_8
XFILLER_40_1270 VDD VSS sg13g2_decap_8
X_14818_ _14818_/Q clkload88/A _14818_/D _14818_/RESET_B VDD VSS sg13g2_dfrbpq_1
XFILLER_75_1300 VDD VSS sg13g2_decap_8
XFILLER_51_227 VDD VSS sg13g2_decap_8
XFILLER_166_1472 VDD VSS sg13g2_fill_2
X_14749_ _14749_/Q _15196_/CLK _14749_/D _14749_/RESET_B VDD VSS sg13g2_dfrbpq_1
XFILLER_36_1306 VDD VSS sg13g2_decap_8
XFILLER_33_964 VDD VSS sg13g2_decap_8
XFILLER_162_1325 VDD VSS sg13g2_decap_8
XFILLER_75_1377 VDD VSS sg13g2_decap_8
XFILLER_71_1208 VDD VSS sg13g2_decap_8
XFILLER_60_761 VDD VSS sg13g2_decap_8
X_08270_ _08270_/Y _08270_/A _08270_/B _08270_/C VDD VSS sg13g2_nand3_1
XFILLER_34_1041 VDD VSS sg13g2_decap_8
XFILLER_121_1000 VDD VSS sg13g2_decap_8
XFILLER_121_1011 VDD VSS sg13g2_fill_2
XFILLER_186_980 VDD VSS sg13g2_decap_8
XFILLER_118_513 VDD VSS sg13g2_decap_8
XFILLER_73_0 VDD VSS sg13g2_decap_8
XFILLER_145_321 VDD VSS sg13g2_decap_8
XFILLER_185_490 VDD VSS sg13g2_decap_8
XFILLER_69_1115 VDD VSS sg13g2_fill_2
XFILLER_118_557 VDD VSS sg13g2_decap_8
XFILLER_69_1126 VDD VSS sg13g2_decap_4
XFILLER_121_1099 VDD VSS sg13g2_decap_8
XFILLER_133_516 VDD VSS sg13g2_decap_8
XFILLER_172_151 VDD VSS sg13g2_decap_8
XFILLER_105_218 VDD VSS sg13g2_decap_8
XFILLER_12_1383 VDD VSS sg13g2_decap_8
X_13718__2484 _13718_/RESET_B VDD VSS sg13g2_tiehi
XFILLER_86_1440 VDD VSS sg13g2_decap_8
XFILLER_173_1421 VDD VSS sg13g2_decap_8
XFILLER_47_1424 VDD VSS sg13g2_decap_8
XFILLER_82_1337 VDD VSS sg13g2_decap_8
XFILLER_114_774 VDD VSS sg13g2_decap_8
XFILLER_114_785 VDD VSS sg13g2_fill_2
XFILLER_141_571 VDD VSS sg13g2_decap_4
Xfanout148 _09903_/A0 _09936_/A1 VDD VSS sg13g2_buf_1
XFILLER_87_647 VDD VSS sg13g2_decap_8
X_13897__2305 _13897_/RESET_B VDD VSS sg13g2_tiehi
Xfanout159 _10066_/A0 _10099_/A0 VDD VSS sg13g2_buf_1
X_07985_ _13290_/B _07985_/A _07985_/B _07985_/C _07985_/D VDD VSS sg13g2_nand4_1
XFILLER_87_658 VDD VSS sg13g2_fill_1
X_09724_ _14315_/D _09922_/A1 _14315_/Q _09733_/S VDD VSS sg13g2_mux2_1
XFILLER_170_18 VDD VSS sg13g2_decap_8
XFILLER_86_179 VDD VSS sg13g2_decap_8
XFILLER_68_894 VDD VSS sg13g2_decap_8
XFILLER_28_736 VDD VSS sg13g2_fill_1
X_09655_ _14248_/D _09919_/A1 _14248_/Q _09659_/S VDD VSS sg13g2_mux2_1
XFILLER_41_1089 VDD VSS sg13g2_decap_8
X_08606_ _08606_/Y _08282_/Y _08625_/A _08605_/X VDD VSS sg13g2_o21ai_1
XFILLER_43_717 VDD VSS sg13g2_decap_8
XFILLER_15_419 VDD VSS sg13g2_decap_8
X_09586_ _14183_/D _14183_/Q _09654_/A0 _09599_/S VDD VSS sg13g2_mux2_1
X_15130__2720 _15130_/RESET_B VDD VSS sg13g2_tiehi
XFILLER_82_374 VDD VSS sg13g2_decap_8
XFILLER_55_599 VDD VSS sg13g2_decap_8
XFILLER_167_1269 VDD VSS sg13g2_decap_8
XFILLER_93_1433 VDD VSS sg13g2_decap_8
X_08537_ _08537_/X _08591_/A2 _07812_/B _07818_/B _07820_/B _13517_/A _13521_/A VDD
+ VSS sg13g2_mux4_1
XFILLER_70_547 VDD VSS sg13g2_decap_8
XFILLER_70_558 VDD VSS sg13g2_fill_2
XFILLER_24_953 VDD VSS sg13g2_decap_8
XFILLER_24_964 VDD VSS sg13g2_fill_2
XFILLER_23_452 VDD VSS sg13g2_fill_1
XFILLER_169_958 VDD VSS sg13g2_decap_8
X_08468_ _08469_/B _08431_/C _08301_/X _08036_/B VDD VSS sg13g2_o21ai_1
XFILLER_24_997 VDD VSS sg13g2_decap_8
XFILLER_23_485 VDD VSS sg13g2_decap_8
XFILLER_180_1469 VDD VSS sg13g2_decap_8
XFILLER_50_293 VDD VSS sg13g2_decap_8
XFILLER_13_1103 VDD VSS sg13g2_decap_8
X_15163__2654 _15163_/RESET_B VDD VSS sg13g2_tiehi
X_08399_ _08410_/C _08483_/A1 _08016_/Y _08688_/C VDD VSS sg13g2_o21ai_1
XFILLER_11_669 VDD VSS sg13g2_decap_8
XFILLER_109_513 VDD VSS sg13g2_fill_1
XFILLER_137_822 VDD VSS sg13g2_fill_1
XFILLER_10_168 VDD VSS sg13g2_decap_8
XFILLER_17_1294 VDD VSS sg13g2_decap_8
XFILLER_183_438 VDD VSS sg13g2_decap_8
X_10430_ _14832_/D _10434_/C _10487_/A _10430_/C VDD VSS sg13g2_nor3_1
XFILLER_12_42 VDD VSS sg13g2_decap_8
XFILLER_164_630 VDD VSS sg13g2_decap_8
XFILLER_109_546 VDD VSS sg13g2_decap_8
XFILLER_148_192 VDD VSS sg13g2_decap_8
XFILLER_137_866 VDD VSS sg13g2_fill_2
XFILLER_100_1128 VDD VSS sg13g2_decap_8
XFILLER_104_1297 VDD VSS sg13g2_decap_8
X_10361_ _10361_/Y _14812_/Q _10359_/Y _10365_/C VDD VSS sg13g2_o21ai_1
XFILLER_136_365 VDD VSS sg13g2_decap_4
XFILLER_87_1248 VDD VSS sg13g2_decap_8
XFILLER_3_802 VDD VSS sg13g2_decap_8
XFILLER_30_1461 VDD VSS sg13g2_decap_8
XFILLER_124_516 VDD VSS sg13g2_decap_8
XFILLER_178_1376 VDD VSS sg13g2_decap_8
X_12100_ _12101_/A _13748_/Q _14100_/Q _14452_/Q _14548_/Q _12100_/S0 _12100_/S1 VDD
+ VSS sg13g2_mux4_1
XFILLER_2_301 VDD VSS sg13g2_decap_8
X_13080_ _13080_/Y _13067_/C _13076_/Y _13079_/Y VDD VSS sg13g2_a21oi_1
XFILLER_88_35 VDD VSS sg13g2_decap_8
XFILLER_163_195 VDD VSS sg13g2_decap_8
X_14308__1894 _14308_/RESET_B VDD VSS sg13g2_tiehi
X_10292_ _14791_/D _12812_/A _10292_/B _10292_/C VDD VSS sg13g2_nor3_1
X_12031_ _12031_/Y _12235_/A _14418_/Q _12236_/C VDD VSS sg13g2_a21oi_1
XFILLER_3_879 VDD VSS sg13g2_decap_8
XFILLER_2_378 VDD VSS sg13g2_decap_8
XFILLER_104_273 VDD VSS sg13g2_decap_8
XFILLER_144_41 VDD VSS sg13g2_fill_2
XFILLER_78_658 VDD VSS sg13g2_decap_8
XFILLER_77_135 VDD VSS sg13g2_fill_1
X_14487__1715 _14487_/RESET_B VDD VSS sg13g2_tiehi
Xfanout660 _12651_/C1 _12777_/C1 VDD VSS sg13g2_buf_1
XFILLER_24_1221 VDD VSS sg13g2_decap_8
Xfanout671 fanout671/X _07728_/X VDD VSS sg13g2_buf_1
XFILLER_93_606 VDD VSS sg13g2_decap_8
XFILLER_63_1281 VDD VSS sg13g2_decap_8
XFILLER_19_703 VDD VSS sg13g2_decap_8
XFILLER_65_308 VDD VSS sg13g2_decap_8
Xfanout682 _11207_/B1 _13279_/D VDD VSS sg13g2_buf_1
X_13982_ _13982_/Q _14668_/CLK _13982_/D _13982_/RESET_B VDD VSS sg13g2_dfrbpq_1
Xfanout693 _11837_/A1 _11860_/B1 VDD VSS sg13g2_buf_1
XFILLER_4_1337 VDD VSS sg13g2_decap_8
XFILLER_74_831 VDD VSS sg13g2_decap_8
XFILLER_111_1235 VDD VSS sg13g2_decap_8
X_12933_ _12933_/Y _12933_/A _15062_/Q VDD VSS sg13g2_nand2_1
XFILLER_24_1298 VDD VSS sg13g2_decap_8
XFILLER_59_1317 VDD VSS sg13g2_decap_8
XFILLER_18_257 VDD VSS sg13g2_fill_1
XFILLER_73_352 VDD VSS sg13g2_decap_8
XFILLER_37_83 VDD VSS sg13g2_decap_8
XFILLER_2_1050 VDD VSS sg13g2_decap_8
XFILLER_18_279 VDD VSS sg13g2_decap_8
XFILLER_74_897 VDD VSS sg13g2_decap_8
X_12864_ _12864_/Y _14771_/Q _12918_/A2 _12918_/B1 VDD VSS sg13g2_o21ai_1
XFILLER_34_739 VDD VSS sg13g2_decap_8
XFILLER_160_95 VDD VSS sg13g2_decap_8
XFILLER_185_1369 VDD VSS sg13g2_decap_8
XFILLER_61_536 VDD VSS sg13g2_decap_4
X_14603_ _14603_/Q clkload13/A _14603_/D _14603_/RESET_B VDD VSS sg13g2_dfrbpq_1
X_11815_ _11815_/X _11815_/A _11822_/B VDD VSS sg13g2_and2_1
XFILLER_96_1090 VDD VSS sg13g2_decap_8
XFILLER_61_558 VDD VSS sg13g2_fill_2
XFILLER_33_249 VDD VSS sg13g2_decap_8
X_12795_ _12795_/Y _12997_/B _12899_/C _12900_/C VDD VSS sg13g2_o21ai_1
XFILLER_183_1071 VDD VSS sg13g2_decap_8
XFILLER_186_210 VDD VSS sg13g2_decap_8
X_14534_ _14534_/Q clkload52/A _14534_/D _14534_/RESET_B VDD VSS sg13g2_dfrbpq_1
X_11746_ _11747_/B _11743_/Y _11745_/Y _11559_/C VDD VSS sg13g2_a21oi_1
XFILLER_14_474 VDD VSS sg13g2_decap_4
XFILLER_42_783 VDD VSS sg13g2_fill_2
XFILLER_53_82 VDD VSS sg13g2_fill_1
XFILLER_159_457 VDD VSS sg13g2_fill_2
XFILLER_144_1077 VDD VSS sg13g2_fill_2
X_14465_ _14465_/Q clkload8/A _14465_/D _14465_/RESET_B VDD VSS sg13g2_dfrbpq_1
X_11677_ _11677_/Y _11673_/Y _11674_/Y _11676_/Y _11675_/Y _11696_/B VDD VSS sg13g2_a221oi_1
XFILLER_175_939 VDD VSS sg13g2_decap_4
XFILLER_70_1252 VDD VSS sg13g2_decap_8
XFILLER_186_287 VDD VSS sg13g2_decap_8
XFILLER_30_989 VDD VSS sg13g2_fill_1
XFILLER_161_1380 VDD VSS sg13g2_decap_8
X_13416_ _13416_/Y _13412_/B _13419_/A2 _15093_/Q VDD VSS sg13g2_o21ai_1
X_10628_ _10629_/D _14884_/Q _14883_/Q _14882_/Q _10651_/D VDD VSS sg13g2_and4_1
XFILLER_35_1394 VDD VSS sg13g2_decap_8
XFILLER_127_321 VDD VSS sg13g2_decap_8
XFILLER_128_844 VDD VSS sg13g2_fill_1
XFILLER_174_449 VDD VSS sg13g2_decap_8
X_13975__2227 _13975_/RESET_B VDD VSS sg13g2_tiehi
X_14396_ _14396_/Q clkload76/A _14396_/D _14396_/RESET_B VDD VSS sg13g2_dfrbpq_1
XFILLER_122_1375 VDD VSS sg13g2_decap_8
XFILLER_31_1258 VDD VSS sg13g2_decap_8
XFILLER_183_972 VDD VSS sg13g2_decap_8
X_13347_ _13351_/C _13347_/A _15174_/D _15175_/D VDD VSS sg13g2_nand3_1
X_10559_ _10561_/C _13273_/A _14861_/Q _14860_/Q _14855_/Q VDD VSS sg13g2_nand4_1
XFILLER_6_662 VDD VSS sg13g2_decap_8
XFILLER_185_70 VDD VSS sg13g2_decap_8
XFILLER_142_313 VDD VSS sg13g2_decap_8
XFILLER_157_1427 VDD VSS sg13g2_decap_8
XFILLER_5_161 VDD VSS sg13g2_decap_8
X_13278_ _15052_/D _13271_/Y _13277_/Y _13266_/A VDD VSS sg13g2_a21oi_1
XFILLER_45_4 VDD VSS sg13g2_decap_8
XFILLER_68_1181 VDD VSS sg13g2_decap_8
X_15017_ _15017_/Q clkload47/A _15017_/D _15017_/RESET_B VDD VSS sg13g2_dfrbpq_1
X_12229_ _12231_/A _12229_/A _13664_/Q VDD VSS sg13g2_xor2_1
XFILLER_64_1023 VDD VSS sg13g2_decap_8
XFILLER_155_1173 VDD VSS sg13g2_decap_8
XFILLER_110_210 VDD VSS sg13g2_decap_8
XFILLER_111_733 VDD VSS sg13g2_fill_1
XFILLER_116_1135 VDD VSS sg13g2_decap_8
XFILLER_9_1248 VDD VSS sg13g2_decap_8
XFILLER_96_433 VDD VSS sg13g2_decap_8
X_14940__2687 _14940_/RESET_B VDD VSS sg13g2_tiehi
XFILLER_29_1198 VDD VSS sg13g2_decap_8
XFILLER_151_1037 VDD VSS sg13g2_decap_8
XFILLER_42_1310 VDD VSS sg13g2_decap_8
XFILLER_81_1370 VDD VSS sg13g2_decap_8
XFILLER_68_168 VDD VSS sg13g2_decap_8
XFILLER_56_308 VDD VSS sg13g2_decap_4
X_07770_ _08315_/A _08258_/C _14998_/Q VDD VSS sg13g2_nor2_1
XFILLER_68_179 VDD VSS sg13g2_fill_1
XFILLER_133_1471 VDD VSS sg13g2_decap_4
XFILLER_49_371 VDD VSS sg13g2_decap_8
XFILLER_77_691 VDD VSS sg13g2_decap_8
XFILLER_42_1387 VDD VSS sg13g2_decap_8
X_09440_ _14042_/D _09638_/A0 _14042_/Q _09440_/S VDD VSS sg13g2_mux2_1
XFILLER_77_1439 VDD VSS sg13g2_decap_8
XFILLER_52_536 VDD VSS sg13g2_decap_4
X_09371_ _13975_/D _09635_/A0 _13975_/Q _09372_/S VDD VSS sg13g2_mux2_1
XFILLER_17_290 VDD VSS sg13g2_fill_2
XFILLER_127_1220 VDD VSS sg13g2_fill_1
X_08322_ _08322_/Y _08369_/B _08366_/D _08321_/Y VDD VSS sg13g2_o21ai_1
XFILLER_127_1242 VDD VSS sg13g2_decap_8
XFILLER_75_1174 VDD VSS sg13g2_decap_8
XFILLER_178_755 VDD VSS sg13g2_fill_1
XFILLER_178_766 VDD VSS sg13g2_decap_8
XFILLER_60_591 VDD VSS sg13g2_decap_8
X_08253_ _08253_/X _08278_/A3 _08253_/A1 _08258_/C _07768_/A _08337_/S0 _13553_/A1
+ VDD VSS sg13g2_mux4_1
XFILLER_14_1401 VDD VSS sg13g2_decap_8
XFILLER_166_928 VDD VSS sg13g2_decap_8
X_15090__2828 _15090_/RESET_B VDD VSS sg13g2_tiehi
XFILLER_53_1461 VDD VSS sg13g2_decap_8
XFILLER_140_1420 VDD VSS sg13g2_fill_2
XFILLER_162_1199 VDD VSS sg13g2_decap_8
X_08184_ _08184_/Y _08190_/A _07920_/Y _08183_/Y VDD VSS sg13g2_a21oi_1
XFILLER_101_1404 VDD VSS sg13g2_decap_8
XFILLER_146_641 VDD VSS sg13g2_decap_8
X_14565__1637 _14565_/RESET_B VDD VSS sg13g2_tiehi
XFILLER_10_1309 VDD VSS sg13g2_decap_8
XFILLER_14_1478 VDD VSS sg13g2_fill_1
XFILLER_134_803 VDD VSS sg13g2_decap_8
XFILLER_146_663 VDD VSS sg13g2_fill_2
XFILLER_174_972 VDD VSS sg13g2_fill_2
XFILLER_165_18 VDD VSS sg13g2_decap_8
XFILLER_161_600 VDD VSS sg13g2_decap_8
XFILLER_173_460 VDD VSS sg13g2_fill_1
XFILLER_173_471 VDD VSS sg13g2_decap_8
XFILLER_3_109 VDD VSS sg13g2_decap_8
XFILLER_118_387 VDD VSS sg13g2_fill_1
XFILLER_173_482 VDD VSS sg13g2_fill_1
XFILLER_118_398 VDD VSS sg13g2_fill_2
XFILLER_12_1180 VDD VSS sg13g2_decap_8
XFILLER_173_493 VDD VSS sg13g2_decap_8
XFILLER_47_1221 VDD VSS sg13g2_decap_8
XFILLER_86_1292 VDD VSS sg13g2_decap_8
XFILLER_138_1360 VDD VSS sg13g2_decap_8
XFILLER_160_165 VDD VSS sg13g2_decap_8
XFILLER_88_923 VDD VSS sg13g2_fill_1
XFILLER_87_400 VDD VSS sg13g2_decap_8
XFILLER_82_1134 VDD VSS sg13g2_decap_8
XFILLER_0_827 VDD VSS sg13g2_decap_8
XFILLER_134_1202 VDD VSS sg13g2_decap_8
XFILLER_142_880 VDD VSS sg13g2_fill_2
XFILLER_87_411 VDD VSS sg13g2_fill_1
XFILLER_99_282 VDD VSS sg13g2_decap_8
XFILLER_181_28 VDD VSS sg13g2_decap_8
XFILLER_82_1167 VDD VSS sg13g2_fill_2
XFILLER_43_1118 VDD VSS sg13g2_decap_4
XFILLER_88_967 VDD VSS sg13g2_fill_2
XFILLER_47_1298 VDD VSS sg13g2_decap_8
XFILLER_173_1295 VDD VSS sg13g2_decap_8
XFILLER_102_766 VDD VSS sg13g2_decap_4
X_07968_ _07969_/D _08641_/A _07966_/Y _07967_/Y VDD VSS sg13g2_a21oi_1
XFILLER_74_105 VDD VSS sg13g2_fill_1
XFILLER_59_179 VDD VSS sg13g2_fill_2
XFILLER_101_276 VDD VSS sg13g2_fill_2
X_09707_ _09707_/X _09740_/B _09806_/B _09707_/C VDD VSS sg13g2_or3_1
XFILLER_56_842 VDD VSS sg13g2_fill_1
XFILLER_28_533 VDD VSS sg13g2_fill_2
XFILLER_21_1449 VDD VSS sg13g2_decap_8
X_07899_ _08073_/B _07903_/B _08063_/A VDD VSS sg13g2_nor2_1
XFILLER_55_352 VDD VSS sg13g2_decap_8
X_09638_ _14234_/D _09638_/A0 _14234_/Q _09638_/S VDD VSS sg13g2_mux2_1
XFILLER_82_182 VDD VSS sg13g2_fill_1
XFILLER_130_32 VDD VSS sg13g2_decap_8
X_09569_ _14167_/D _09635_/A0 _14167_/Q _09571_/S VDD VSS sg13g2_mux2_1
XFILLER_93_1230 VDD VSS sg13g2_fill_1
XFILLER_58_1350 VDD VSS sg13g2_decap_8
XFILLER_70_344 VDD VSS sg13g2_decap_8
X_11600_ _11601_/A _13958_/Q _13990_/Q _14022_/Q _14054_/Q _11804_/A _11805_/C VDD
+ VSS sg13g2_mux4_1
XFILLER_71_889 VDD VSS sg13g2_fill_2
XFILLER_184_1380 VDD VSS sg13g2_decap_8
XFILLER_70_377 VDD VSS sg13g2_decap_8
XFILLER_19_1345 VDD VSS sg13g2_decap_8
X_12580_ _12580_/X _12572_/X _12576_/X _12571_/X _12575_/X _12706_/S _12705_/S0 VDD
+ VSS sg13g2_mux4_1
XFILLER_145_1364 VDD VSS sg13g2_decap_8
XFILLER_93_1296 VDD VSS sg13g2_fill_1
XFILLER_180_1266 VDD VSS sg13g2_decap_8
X_11531_ _11532_/B _11531_/A _14212_/Q VDD VSS sg13g2_nand2_1
XFILLER_54_1269 VDD VSS sg13g2_decap_8
XFILLER_184_714 VDD VSS sg13g2_decap_8
XFILLER_168_265 VDD VSS sg13g2_fill_1
X_14250_ _14250_/Q clkload20/A _14250_/D _14250_/RESET_B VDD VSS sg13g2_dfrbpq_1
XFILLER_8_949 VDD VSS sg13g2_decap_8
XFILLER_139_52 VDD VSS sg13g2_decap_4
XFILLER_17_1091 VDD VSS sg13g2_decap_8
X_11462_ _11463_/C _14962_/Q _13688_/Q _11430_/B _11430_/A _11427_/X VDD VSS sg13g2_a221oi_1
XFILLER_183_235 VDD VSS sg13g2_decap_8
XFILLER_104_1050 VDD VSS sg13g2_fill_1
XFILLER_109_332 VDD VSS sg13g2_decap_8
XFILLER_7_448 VDD VSS sg13g2_decap_8
X_13201_ _13202_/B _14919_/Q _13668_/Q _13189_/X VDD VSS sg13g2_a21oi_1
XFILLER_99_23 VDD VSS sg13g2_decap_8
X_10413_ _10422_/D _14827_/Q _10413_/B _10414_/D VDD VSS sg13g2_and3_1
X_14181_ _14181_/Q clkload17/A _14181_/D _14181_/RESET_B VDD VSS sg13g2_dfrbpq_1
XFILLER_152_600 VDD VSS sg13g2_decap_4
X_11393_ _11393_/X _11388_/Y _11389_/Y _11615_/B VDD VSS sg13g2_a21o_1
XFILLER_139_1102 VDD VSS sg13g2_decap_8
XFILLER_165_994 VDD VSS sg13g2_decap_8
XFILLER_137_696 VDD VSS sg13g2_decap_8
XFILLER_178_1173 VDD VSS sg13g2_decap_8
X_13132_ _13146_/B _13132_/A _13133_/C VDD VSS sg13g2_nand2_1
XFILLER_125_858 VDD VSS sg13g2_decap_8
X_10344_ _10347_/C _14808_/Q _10343_/B VDD VSS sg13g2_nor2b_1
XFILLER_125_869 VDD VSS sg13g2_fill_2
XFILLER_139_1157 VDD VSS sg13g2_decap_8
XFILLER_140_817 VDD VSS sg13g2_fill_2
XFILLER_117_1400 VDD VSS sg13g2_decap_4
XFILLER_174_1059 VDD VSS sg13g2_decap_8
X_13063_ _13078_/A _13066_/C _13063_/B VDD VSS sg13g2_nand2b_1
X_10275_ _14786_/D _14786_/Q _10305_/A _10274_/Y VDD VSS sg13g2_a21oi_1
XFILLER_3_676 VDD VSS sg13g2_decap_8
XFILLER_65_1354 VDD VSS sg13g2_decap_8
XFILLER_26_1305 VDD VSS sg13g2_decap_8
XFILLER_105_582 VDD VSS sg13g2_decap_4
Xfanout1400 _12984_/A fanout1413/X VDD VSS sg13g2_buf_1
X_12014_ _12014_/X _13842_/Q _13874_/Q _12025_/A VDD VSS sg13g2_mux2_1
XFILLER_2_175 VDD VSS sg13g2_decap_8
Xfanout1411 _10655_/B _10599_/A VDD VSS sg13g2_buf_1
Xfanout1422 _10337_/C _10444_/C VDD VSS sg13g2_buf_1
XFILLER_78_444 VDD VSS sg13g2_decap_4
XFILLER_61_1218 VDD VSS sg13g2_decap_8
XFILLER_120_541 VDD VSS sg13g2_fill_1
Xfanout1433 _10544_/C _10423_/C VDD VSS sg13g2_buf_1
XFILLER_152_1357 VDD VSS sg13g2_fill_2
XFILLER_66_606 VDD VSS sg13g2_decap_8
XFILLER_120_585 VDD VSS sg13g2_decap_8
Xfanout490 _09238_/S _09227_/S VDD VSS sg13g2_buf_1
XFILLER_94_959 VDD VSS sg13g2_decap_8
XFILLER_93_425 VDD VSS sg13g2_decap_8
XFILLER_59_680 VDD VSS sg13g2_decap_8
XFILLER_19_522 VDD VSS sg13g2_decap_8
XFILLER_8_1292 VDD VSS sg13g2_decap_8
XFILLER_65_127 VDD VSS sg13g2_decap_8
XFILLER_48_93 VDD VSS sg13g2_fill_2
XFILLER_4_1134 VDD VSS sg13g2_decap_8
X_13965_ _13965_/Q clkload24/A _13965_/D _13965_/RESET_B VDD VSS sg13g2_dfrbpq_1
XFILLER_59_1103 VDD VSS sg13g2_decap_4
XFILLER_47_864 VDD VSS sg13g2_fill_1
XFILLER_0_1009 VDD VSS sg13g2_decap_8
XFILLER_47_875 VDD VSS sg13g2_fill_2
XFILLER_80_108 VDD VSS sg13g2_decap_8
XFILLER_0_56 VDD VSS sg13g2_decap_8
X_12916_ _12916_/Y _14838_/Q _12976_/B _12895_/B _14870_/Q VDD VSS sg13g2_a22oi_1
XFILLER_98_1174 VDD VSS sg13g2_decap_8
XFILLER_74_683 VDD VSS sg13g2_fill_2
X_13896_ _13896_/Q clkload21/A _13896_/D _13896_/RESET_B VDD VSS sg13g2_dfrbpq_1
X_14643__1559 _14643_/RESET_B VDD VSS sg13g2_tiehi
XFILLER_98_1196 VDD VSS sg13g2_decap_8
XFILLER_61_311 VDD VSS sg13g2_decap_8
XFILLER_73_182 VDD VSS sg13g2_decap_8
XFILLER_146_1117 VDD VSS sg13g2_decap_8
XFILLER_185_1166 VDD VSS sg13g2_decap_8
XFILLER_62_867 VDD VSS sg13g2_decap_8
X_12847_ _12847_/X _14897_/Q _13690_/Q VDD VSS sg13g2_and2_1
XFILLER_76_1450 VDD VSS sg13g2_decap_8
XFILLER_72_1314 VDD VSS sg13g2_decap_8
XFILLER_37_1434 VDD VSS sg13g2_decap_8
XFILLER_9_21 VDD VSS sg13g2_decap_8
XFILLER_15_783 VDD VSS sg13g2_decap_8
X_12778_ _15019_/D _12778_/A _12778_/B VDD VSS sg13g2_nor2_1
XFILLER_163_1464 VDD VSS sg13g2_decap_8
XFILLER_37_1478 VDD VSS sg13g2_fill_1
X_14517_ _14517_/Q clkload42/A _14517_/D _14517_/RESET_B VDD VSS sg13g2_dfrbpq_1
X_11729_ _11729_/Y _13020_/A1 _15208_/Q _11728_/Y VDD VSS sg13g2_o21ai_1
XFILLER_124_1459 VDD VSS sg13g2_decap_8
XFILLER_9_98 VDD VSS sg13g2_decap_8
XFILLER_174_224 VDD VSS sg13g2_decap_4
XFILLER_128_630 VDD VSS sg13g2_decap_8
X_14448_ _14448_/Q _14528_/CLK _14448_/D _14448_/RESET_B VDD VSS sg13g2_dfrbpq_1
XFILLER_35_1191 VDD VSS sg13g2_decap_8
XFILLER_31_1022 VDD VSS sg13g2_decap_8
XFILLER_156_950 VDD VSS sg13g2_decap_8
XFILLER_174_246 VDD VSS sg13g2_decap_8
XFILLER_162_408 VDD VSS sg13g2_decap_8
X_15011__2599 _15011_/RESET_B VDD VSS sg13g2_tiehi
XFILLER_116_825 VDD VSS sg13g2_decap_8
X_14379_ _14379_/Q clkload11/A _14379_/D _14379_/RESET_B VDD VSS sg13g2_dfrbpq_1
XFILLER_115_313 VDD VSS sg13g2_fill_1
XFILLER_183_791 VDD VSS sg13g2_decap_8
XFILLER_115_324 VDD VSS sg13g2_decap_4
XFILLER_143_644 VDD VSS sg13g2_decap_8
XFILLER_115_346 VDD VSS sg13g2_decap_8
XFILLER_143_666 VDD VSS sg13g2_decap_8
XFILLER_83_1410 VDD VSS sg13g2_decap_8
XFILLER_142_143 VDD VSS sg13g2_decap_8
XFILLER_171_986 VDD VSS sg13g2_decap_4
XFILLER_88_208 VDD VSS sg13g2_decap_8
X_08940_ _08940_/X _08939_/X _12203_/A _08955_/S VDD VSS sg13g2_mux2_1
XFILLER_9_1001 VDD VSS sg13g2_decap_8
XFILLER_36_0 VDD VSS sg13g2_decap_8
XFILLER_170_1424 VDD VSS sg13g2_decap_8
X_08871_ _08871_/X _08870_/X _11570_/A _08875_/S VDD VSS sg13g2_mux2_1
XFILLER_69_433 VDD VSS sg13g2_decap_8
XFILLER_111_530 VDD VSS sg13g2_decap_8
XFILLER_44_1438 VDD VSS sg13g2_decap_8
XFILLER_131_1408 VDD VSS sg13g2_decap_8
X_07822_ _08527_/B _07822_/A _07822_/B VDD VSS sg13g2_nor2_1
XFILLER_9_1078 VDD VSS sg13g2_decap_8
XFILLER_111_574 VDD VSS sg13g2_decap_8
XFILLER_84_403 VDD VSS sg13g2_fill_2
X_07753_ _15206_/D _10647_/D _07753_/B _07754_/B _07753_/D VDD VSS sg13g2_and4_1
XFILLER_84_469 VDD VSS sg13g2_decap_8
XFILLER_42_1184 VDD VSS sg13g2_decap_8
XFILLER_53_801 VDD VSS sg13g2_fill_1
XFILLER_168_1342 VDD VSS sg13g2_decap_8
X_15248__3039 _15248_/RESET_B VDD VSS sg13g2_tiehi
X_07684_ _07684_/Y _11241_/A _07684_/B _11241_/C VDD VSS sg13g2_nand3_1
XFILLER_77_1236 VDD VSS sg13g2_decap_8
XFILLER_25_536 VDD VSS sg13g2_decap_8
X_09423_ _14025_/D _09953_/A1 _14025_/Q _09434_/S VDD VSS sg13g2_mux2_1
XFILLER_38_1209 VDD VSS sg13g2_decap_8
XFILLER_164_1217 VDD VSS sg13g2_decap_8
XFILLER_25_547 VDD VSS sg13g2_fill_2
X_14619__1583 _14619_/RESET_B VDD VSS sg13g2_tiehi
XFILLER_53_867 VDD VSS sg13g2_fill_2
X_09354_ _13958_/D _09686_/A0 _13958_/Q _09368_/S VDD VSS sg13g2_mux2_1
XFILLER_90_1414 VDD VSS sg13g2_decap_8
XFILLER_80_697 VDD VSS sg13g2_decap_8
XFILLER_100_35 VDD VSS sg13g2_decap_8
XFILLER_21_720 VDD VSS sg13g2_decap_8
XFILLER_139_917 VDD VSS sg13g2_decap_8
X_08305_ _08305_/Y _08359_/A2 _08304_/Y _08523_/B1 VDD VSS sg13g2_a21oi_1
XFILLER_21_753 VDD VSS sg13g2_decap_8
X_09285_ _13893_/D _13893_/Q _10148_/A1 _09296_/S VDD VSS sg13g2_mux2_1
XFILLER_20_252 VDD VSS sg13g2_decap_8
XFILLER_165_224 VDD VSS sg13g2_decap_8
X_08236_ _08236_/X _08151_/X _08235_/X _08428_/S VDD VSS sg13g2_mux2_1
XFILLER_176_28 VDD VSS sg13g2_decap_8
XFILLER_109_11 VDD VSS sg13g2_fill_2
XFILLER_147_972 VDD VSS sg13g2_decap_8
XFILLER_10_1106 VDD VSS sg13g2_decap_8
XFILLER_14_1275 VDD VSS sg13g2_decap_8
X_08167_ _08167_/X _08452_/D _08167_/B VDD VSS sg13g2_or2_1
XFILLER_114_7 VDD VSS sg13g2_decap_4
XFILLER_119_685 VDD VSS sg13g2_decap_8
XFILLER_162_920 VDD VSS sg13g2_decap_8
XFILLER_180_238 VDD VSS sg13g2_decap_8
XFILLER_88_1376 VDD VSS sg13g2_decap_8
XFILLER_173_290 VDD VSS sg13g2_decap_8
XFILLER_175_1335 VDD VSS sg13g2_decap_8
X_08098_ _08098_/Y _08200_/A _08098_/B VDD VSS sg13g2_nand2_1
XFILLER_49_1338 VDD VSS sg13g2_decap_8
XFILLER_101_1289 VDD VSS sg13g2_decap_8
XFILLER_106_357 VDD VSS sg13g2_decap_8
XFILLER_122_806 VDD VSS sg13g2_decap_8
XFILLER_161_452 VDD VSS sg13g2_decap_8
XFILLER_134_677 VDD VSS sg13g2_decap_8
XFILLER_0_602 VDD VSS sg13g2_decap_8
XFILLER_121_316 VDD VSS sg13g2_decap_8
X_10060_ _14641_/D _10160_/A1 _14641_/Q _10068_/S VDD VSS sg13g2_mux2_1
XFILLER_114_390 VDD VSS sg13g2_decap_8
XFILLER_173_1070 VDD VSS sg13g2_fill_1
XFILLER_173_1092 VDD VSS sg13g2_decap_8
XFILLER_88_775 VDD VSS sg13g2_decap_4
XFILLER_0_679 VDD VSS sg13g2_decap_8
XFILLER_102_563 VDD VSS sg13g2_fill_1
XFILLER_87_252 VDD VSS sg13g2_decap_8
XFILLER_85_14 VDD VSS sg13g2_decap_4
XFILLER_75_414 VDD VSS sg13g2_decap_8
XFILLER_134_1076 VDD VSS sg13g2_decap_8
XFILLER_5_1421 VDD VSS sg13g2_decap_8
XFILLER_47_116 VDD VSS sg13g2_fill_1
XFILLER_29_820 VDD VSS sg13g2_fill_1
XFILLER_112_1330 VDD VSS sg13g2_decap_8
XFILLER_47_138 VDD VSS sg13g2_fill_2
XFILLER_75_458 VDD VSS sg13g2_decap_8
XFILLER_60_1273 VDD VSS sg13g2_decap_8
XFILLER_186_1420 VDD VSS sg13g2_decap_8
XFILLER_21_1246 VDD VSS sg13g2_decap_8
XFILLER_99_1472 VDD VSS sg13g2_fill_2
XFILLER_18_74 VDD VSS sg13g2_decap_8
X_13750_ _13750_/Q clkload75/A _13750_/D _13750_/RESET_B VDD VSS sg13g2_dfrbpq_1
X_10962_ _11004_/B _14759_/Q _11015_/C VDD VSS sg13g2_xor2_1
XFILLER_90_428 VDD VSS sg13g2_decap_8
XFILLER_62_119 VDD VSS sg13g2_decap_8
XFILLER_112_1396 VDD VSS sg13g2_decap_8
XFILLER_141_75 VDD VSS sg13g2_decap_8
XFILLER_182_1306 VDD VSS sg13g2_decap_8
X_12701_ _12701_/X _13844_/Q _13876_/Q _13908_/Q _13940_/Q _12701_/S0 _12701_/S1 VDD
+ VSS sg13g2_mux4_1
X_13681_ _13681_/Q clkload57/A _13681_/D _13681_/RESET_B VDD VSS sg13g2_dfrbpq_1
X_10893_ _10893_/X _10893_/A _10893_/B VDD VSS sg13g2_and2_1
XFILLER_44_889 VDD VSS sg13g2_decap_8
XFILLER_70_152 VDD VSS sg13g2_decap_4
X_12632_ _12632_/X _13839_/Q _13871_/Q _13903_/Q _13935_/Q _12674_/S0 _12674_/S1 VDD
+ VSS sg13g2_mux4_1
XFILLER_19_1142 VDD VSS sg13g2_decap_8
XFILLER_93_1071 VDD VSS sg13g2_fill_1
XFILLER_106_1101 VDD VSS sg13g2_decap_8
XFILLER_12_731 VDD VSS sg13g2_fill_2
XFILLER_145_1150 VDD VSS sg13g2_decap_4
X_12563_ _12563_/X _14122_/Q _14154_/Q _14186_/Q _14218_/Q _12616_/S0 _12616_/S1 VDD
+ VSS sg13g2_mux4_1
XFILLER_157_725 VDD VSS sg13g2_decap_8
XFILLER_12_775 VDD VSS sg13g2_decap_8
X_14302_ _14302_/Q _14526_/CLK _14302_/D _14302_/RESET_B VDD VSS sg13g2_dfrbpq_1
X_11514_ _11514_/X _13955_/Q _13987_/Q _14019_/Q _14051_/Q _11514_/S0 _11514_/S1 VDD
+ VSS sg13g2_mux4_1
XFILLER_11_263 VDD VSS sg13g2_decap_8
XFILLER_129_449 VDD VSS sg13g2_decap_8
X_12494_ _12494_/X _13957_/Q _13989_/Q _14021_/Q _14053_/Q _12494_/S0 _12494_/S1 VDD
+ VSS sg13g2_mux4_1
XFILLER_8_746 VDD VSS sg13g2_decap_8
XFILLER_156_246 VDD VSS sg13g2_decap_4
XFILLER_184_566 VDD VSS sg13g2_decap_8
XFILLER_7_245 VDD VSS sg13g2_decap_8
XFILLER_50_50 VDD VSS sg13g2_fill_1
X_14233_ _14233_/Q clkload45/A _14233_/D _14233_/RESET_B VDD VSS sg13g2_dfrbpq_1
X_11445_ _11448_/C _11445_/A _11446_/A _11445_/C VDD VSS sg13g2_nand3_1
XFILLER_171_205 VDD VSS sg13g2_decap_4
X_14057__2145 _14057_/RESET_B VDD VSS sg13g2_tiehi
XFILLER_32_1386 VDD VSS sg13g2_decap_8
XFILLER_137_482 VDD VSS sg13g2_decap_8
X_13892__2310 _13892_/RESET_B VDD VSS sg13g2_tiehi
XFILLER_109_184 VDD VSS sg13g2_decap_4
X_14164_ _14164_/Q clkload11/A _14164_/D _14164_/RESET_B VDD VSS sg13g2_dfrbpq_1
XFILLER_67_1416 VDD VSS sg13g2_decap_8
X_11376_ _11376_/X _13950_/Q _13982_/Q _14014_/Q _14046_/Q _11373_/A _11374_/C VDD
+ VSS sg13g2_mux4_1
XFILLER_125_655 VDD VSS sg13g2_fill_1
XFILLER_153_964 VDD VSS sg13g2_decap_8
XFILLER_4_952 VDD VSS sg13g2_decap_8
XFILLER_154_1408 VDD VSS sg13g2_decap_8
X_13115_ _13116_/C _14913_/Q _13674_/Q _13088_/X VDD VSS sg13g2_o21ai_1
X_10327_ _10336_/D _10342_/A _10327_/B _10327_/C _10345_/C VDD VSS sg13g2_and4_1
XFILLER_113_839 VDD VSS sg13g2_decap_8
XFILLER_180_783 VDD VSS sg13g2_fill_1
X_14095_ _14095_/Q _15162_/CLK _14095_/D _14095_/RESET_B VDD VSS sg13g2_dfrbpq_1
XFILLER_3_473 VDD VSS sg13g2_decap_8
XFILLER_26_1102 VDD VSS sg13g2_fill_2
X_13046_ _13046_/Y _13050_/C _15061_/Q VDD VSS sg13g2_nor2b_1
X_10258_ _10262_/B _14779_/Q _14780_/Q _14781_/Q _10258_/D VDD VSS sg13g2_nand4_1
XFILLER_182_60 VDD VSS sg13g2_decap_8
Xfanout1230 _11086_/A _10206_/A1 VDD VSS sg13g2_buf_1
Xfanout1241 _13129_/B _13672_/Q VDD VSS sg13g2_buf_1
XFILLER_6_1229 VDD VSS sg13g2_decap_8
XFILLER_117_1285 VDD VSS sg13g2_decap_8
Xfanout1252 _11999_/S1 fanout1255/X VDD VSS sg13g2_buf_1
X_10189_ _15195_/D input22/X _15195_/Q _10195_/S VDD VSS sg13g2_mux2_1
XFILLER_93_200 VDD VSS sg13g2_decap_8
XFILLER_67_948 VDD VSS sg13g2_decap_8
XFILLER_26_1179 VDD VSS sg13g2_decap_8
XFILLER_117_1296 VDD VSS sg13g2_fill_1
Xfanout1263 _12174_/A _12336_/A2 VDD VSS sg13g2_buf_1
XFILLER_113_1138 VDD VSS sg13g2_decap_8
Xfanout1274 _11649_/S1 _11970_/C VDD VSS sg13g2_buf_1
XFILLER_94_745 VDD VSS sg13g2_decap_8
XFILLER_38_127 VDD VSS sg13g2_decap_8
Xfanout1285 _12100_/S1 _12114_/S1 VDD VSS sg13g2_buf_1
Xfanout1296 _11374_/C _11805_/C VDD VSS sg13g2_buf_1
XFILLER_82_918 VDD VSS sg13g2_decap_8
XFILLER_19_341 VDD VSS sg13g2_decap_8
X_14997_ _14997_/Q clkload22/A _14997_/D _14997_/RESET_B VDD VSS sg13g2_dfrbpq_1
XFILLER_81_428 VDD VSS sg13g2_decap_8
X_13948_ _13948_/Q clkload77/A _13948_/D _13948_/RESET_B VDD VSS sg13g2_dfrbpq_1
XFILLER_35_845 VDD VSS sg13g2_decap_8
XFILLER_46_182 VDD VSS sg13g2_decap_8
X_13879_ _13879_/Q _14743_/CLK _13879_/D _13879_/RESET_B VDD VSS sg13g2_dfrbpq_1
XFILLER_72_1100 VDD VSS sg13g2_decap_8
XFILLER_61_163 VDD VSS sg13g2_decap_8
XFILLER_37_1231 VDD VSS sg13g2_decap_8
X_14267__1935 _14267_/RESET_B VDD VSS sg13g2_tiehi
XFILLER_163_1261 VDD VSS sg13g2_decap_8
XFILLER_147_202 VDD VSS sg13g2_decap_8
XFILLER_148_725 VDD VSS sg13g2_decap_8
XFILLER_33_1128 VDD VSS sg13g2_decap_8
XFILLER_72_1188 VDD VSS sg13g2_decap_8
X_09070_ _09070_/Y _09074_/B1 _09066_/Y _09069_/X VDD VSS sg13g2_o21ai_1
XFILLER_124_1289 VDD VSS sg13g2_decap_8
XFILLER_50_1442 VDD VSS sg13g2_decap_8
X_08021_ _08021_/Y _08021_/A _08241_/A VDD VSS sg13g2_nand2_1
XFILLER_11_1415 VDD VSS sg13g2_decap_8
XFILLER_128_471 VDD VSS sg13g2_decap_8
XFILLER_116_633 VDD VSS sg13g2_decap_8
X_14482__1720 _14482_/RESET_B VDD VSS sg13g2_tiehi
XFILLER_116_644 VDD VSS sg13g2_fill_2
XFILLER_171_761 VDD VSS sg13g2_decap_8
XFILLER_89_506 VDD VSS sg13g2_decap_8
XFILLER_116_688 VDD VSS sg13g2_decap_8
XFILLER_171_783 VDD VSS sg13g2_decap_8
XFILLER_103_316 VDD VSS sg13g2_decap_4
X_09972_ _14555_/D _10005_/A0 _14555_/Q _10003_/S VDD VSS sg13g2_mux2_1
XFILLER_130_102 VDD VSS sg13g2_decap_8
XFILLER_39_18 VDD VSS sg13g2_decap_8
XFILLER_103_349 VDD VSS sg13g2_decap_8
X_08923_ _13713_/D _16875_/A _08922_/X _08932_/S VDD VSS sg13g2_mux2_1
XFILLER_170_1221 VDD VSS sg13g2_decap_8
X_14764__2973 _14764_/RESET_B VDD VSS sg13g2_tiehi
XFILLER_112_850 VDD VSS sg13g2_decap_8
XFILLER_83_1284 VDD VSS sg13g2_decap_8
XFILLER_44_1235 VDD VSS sg13g2_decap_8
XFILLER_135_1352 VDD VSS sg13g2_fill_1
X_14102__2100 _14102_/RESET_B VDD VSS sg13g2_tiehi
XFILLER_69_263 VDD VSS sg13g2_decap_8
X_08854_ _08854_/X _08853_/X _14962_/Q _08875_/S VDD VSS sg13g2_mux2_1
XFILLER_112_894 VDD VSS sg13g2_fill_1
XFILLER_131_1227 VDD VSS sg13g2_fill_2
X_13755__2447 _13755_/RESET_B VDD VSS sg13g2_tiehi
XFILLER_170_1298 VDD VSS sg13g2_decap_8
X_07805_ _08476_/A _07949_/C _13555_/A VDD VSS sg13g2_nand2b_1
XFILLER_73_907 VDD VSS sg13g2_decap_8
X_08785_ _08785_/Y _11017_/A1 _14758_/Q _13389_/B _07719_/X VDD VSS sg13g2_a22oi_1
XFILLER_55_39 VDD VSS sg13g2_decap_8
X_07736_ _13284_/B _07744_/B _15124_/Q VDD VSS sg13g2_nand2_1
XFILLER_38_683 VDD VSS sg13g2_decap_4
XFILLER_129_1123 VDD VSS sg13g2_decap_8
X_07667_ _07667_/Y _13293_/A _15055_/Q _10174_/B VDD VSS sg13g2_nor3_1
XFILLER_38_1006 VDD VSS sg13g2_decap_8
X_13970__2232 _13970_/RESET_B VDD VSS sg13g2_tiehi
X_14135__2067 _14135_/RESET_B VDD VSS sg13g2_tiehi
XFILLER_26_889 VDD VSS sg13g2_decap_4
XFILLER_0_1373 VDD VSS sg13g2_decap_8
XFILLER_164_1036 VDD VSS sg13g2_fill_2
X_09406_ _14009_/D _09969_/A1 _14009_/Q _09407_/S VDD VSS sg13g2_mux2_1
XFILLER_80_483 VDD VSS sg13g2_decap_8
XFILLER_111_78 VDD VSS sg13g2_decap_8
XFILLER_41_848 VDD VSS sg13g2_decap_8
XFILLER_25_399 VDD VSS sg13g2_decap_8
XFILLER_107_1410 VDD VSS sg13g2_decap_4
XFILLER_90_1222 VDD VSS sg13g2_decap_8
XFILLER_55_1342 VDD VSS sg13g2_decap_8
XFILLER_185_308 VDD VSS sg13g2_decap_8
XFILLER_71_49 VDD VSS sg13g2_decap_8
XFILLER_52_196 VDD VSS sg13g2_decap_8
XFILLER_40_336 VDD VSS sg13g2_decap_8
XFILLER_179_883 VDD VSS sg13g2_decap_8
X_09337_ _13944_/D _10167_/A1 _13944_/Q _09337_/S VDD VSS sg13g2_mux2_1
XFILLER_181_1372 VDD VSS sg13g2_decap_8
XFILLER_16_1337 VDD VSS sg13g2_decap_8
XFILLER_138_213 VDD VSS sg13g2_fill_1
XFILLER_51_1228 VDD VSS sg13g2_decap_8
XFILLER_103_1307 VDD VSS sg13g2_decap_4
X_09268_ _13877_/D _13877_/Q _09899_/A0 _09272_/S VDD VSS sg13g2_mux2_1
XFILLER_177_1408 VDD VSS sg13g2_decap_8
X_08219_ _08247_/B _08219_/A _13545_/A VDD VSS sg13g2_and2_1
X_14881__2805 _14881_/RESET_B VDD VSS sg13g2_tiehi
XFILLER_119_460 VDD VSS sg13g2_fill_1
XFILLER_14_1072 VDD VSS sg13g2_decap_8
X_09199_ _13815_/D _13815_/Q _10166_/A1 _09200_/S VDD VSS sg13g2_mux2_1
XFILLER_101_1042 VDD VSS sg13g2_decap_8
XFILLER_140_1091 VDD VSS sg13g2_fill_2
X_11230_ _11230_/X _11228_/X _11229_/X _12308_/C VDD VSS sg13g2_mux2_1
XFILLER_5_749 VDD VSS sg13g2_decap_8
XFILLER_107_644 VDD VSS sg13g2_decap_4
XFILLER_153_249 VDD VSS sg13g2_decap_8
XFILLER_134_430 VDD VSS sg13g2_decap_8
XFILLER_20_42 VDD VSS sg13g2_decap_8
XFILLER_134_441 VDD VSS sg13g2_fill_1
XFILLER_135_975 VDD VSS sg13g2_decap_8
XFILLER_175_1132 VDD VSS sg13g2_decap_8
XFILLER_4_259 VDD VSS sg13g2_decap_8
XFILLER_49_1135 VDD VSS sg13g2_fill_1
XFILLER_101_1086 VDD VSS sg13g2_decap_8
XFILLER_122_603 VDD VSS sg13g2_decap_8
XFILLER_107_688 VDD VSS sg13g2_fill_1
XFILLER_122_614 VDD VSS sg13g2_decap_8
XFILLER_136_42 VDD VSS sg13g2_decap_4
X_11161_ _11161_/X _11161_/A _11191_/A VDD VSS sg13g2_and2_1
X_10112_ _14690_/D _10145_/A1 _14690_/Q _10123_/S VDD VSS sg13g2_mux2_1
XFILLER_27_1411 VDD VSS sg13g2_decap_8
XFILLER_136_86 VDD VSS sg13g2_decap_8
XFILLER_110_809 VDD VSS sg13g2_fill_2
X_11092_ _11095_/A _11092_/A _11118_/C VDD VSS sg13g2_nor2b_1
XFILLER_62_1313 VDD VSS sg13g2_decap_8
XFILLER_1_966 VDD VSS sg13g2_decap_8
XFILLER_49_915 VDD VSS sg13g2_decap_8
XFILLER_121_168 VDD VSS sg13g2_decap_4
XFILLER_153_1463 VDD VSS sg13g2_decap_8
X_14920_ _14920_/Q clkload74/A _14920_/D _14920_/RESET_B VDD VSS sg13g2_dfrbpq_1
X_10043_ _14624_/D _10110_/A0 _14624_/Q _10059_/S VDD VSS sg13g2_mux2_1
XFILLER_88_572 VDD VSS sg13g2_fill_2
XFILLER_0_476 VDD VSS sg13g2_decap_8
XFILLER_48_414 VDD VSS sg13g2_decap_8
XFILLER_130_680 VDD VSS sg13g2_decap_8
XFILLER_48_436 VDD VSS sg13g2_fill_1
X_14345__1857 _14345_/RESET_B VDD VSS sg13g2_tiehi
X_14851_ _14851_/Q clkload84/A _14851_/D _14851_/RESET_B VDD VSS sg13g2_dfrbpq_1
XFILLER_64_907 VDD VSS sg13g2_fill_2
XFILLER_48_458 VDD VSS sg13g2_decap_8
X_13802_ _13802_/Q clkload27/A _13802_/D _13802_/RESET_B VDD VSS sg13g2_dfrbpq_1
XFILLER_91_726 VDD VSS sg13g2_decap_4
XFILLER_57_981 VDD VSS sg13g2_decap_8
XFILLER_21_1054 VDD VSS sg13g2_decap_8
XFILLER_17_834 VDD VSS sg13g2_decap_8
X_14782_ _14782_/Q clkload87/A _14782_/D _14782_/RESET_B VDD VSS sg13g2_dfrbpq_1
XFILLER_5_1295 VDD VSS sg13g2_decap_8
X_11994_ _11994_/X _14705_/Q _14737_/Q _13777_/Q _13809_/Q _11997_/S0 _11997_/S1 VDD
+ VSS sg13g2_mux4_1
XFILLER_16_322 VDD VSS sg13g2_fill_1
XFILLER_1_1148 VDD VSS sg13g2_decap_8
XFILLER_28_182 VDD VSS sg13g2_decap_8
X_13733_ _13733_/Q _14725_/CLK _13733_/D _13733_/RESET_B VDD VSS sg13g2_dfrbpq_1
XFILLER_182_1103 VDD VSS sg13g2_decap_8
X_10945_ _10945_/Y _10945_/A _10945_/B VDD VSS sg13g2_nor2_1
XFILLER_95_1155 VDD VSS sg13g2_decap_8
XFILLER_90_269 VDD VSS sg13g2_fill_1
XFILLER_44_664 VDD VSS sg13g2_decap_8
XFILLER_186_1294 VDD VSS sg13g2_decap_8
X_13800__2402 _13800_/RESET_B VDD VSS sg13g2_tiehi
XFILLER_43_152 VDD VSS sg13g2_decap_8
XFILLER_108_1207 VDD VSS sg13g2_decap_8
X_14560__1642 _14560_/RESET_B VDD VSS sg13g2_tiehi
XFILLER_95_1188 VDD VSS sg13g2_fill_1
XFILLER_91_1019 VDD VSS sg13g2_decap_8
XFILLER_16_388 VDD VSS sg13g2_decap_8
X_13664_ _13664_/Q clkload74/A _13664_/D _13664_/RESET_B VDD VSS sg13g2_dfrbpq_1
X_10876_ _10923_/D _10876_/A _10897_/B _10897_/A _10876_/D VDD VSS sg13g2_or4_1
XFILLER_34_1404 VDD VSS sg13g2_decap_8
X_12615_ _12615_/X _14382_/Q _14414_/Q _14478_/Q _14510_/Q _12616_/S0 _12616_/S1 VDD
+ VSS sg13g2_mux4_1
XFILLER_160_1423 VDD VSS sg13g2_decap_8
X_13595_ _13595_/Y _13600_/A _10173_/B _15164_/Q VDD VSS sg13g2_a21oi_1
XFILLER_40_870 VDD VSS sg13g2_decap_8
X_12546_ _12546_/X _14249_/Q _14281_/Q _14313_/Q _14345_/Q _12550_/S0 _12550_/S1 VDD
+ VSS sg13g2_mux4_1
XFILLER_157_555 VDD VSS sg13g2_decap_8
XFILLER_185_864 VDD VSS sg13g2_decap_8
XFILLER_8_543 VDD VSS sg13g2_decap_8
XFILLER_177_60 VDD VSS sg13g2_decap_8
XFILLER_184_352 VDD VSS sg13g2_decap_8
XFILLER_129_279 VDD VSS sg13g2_decap_8
XFILLER_6_11 VDD VSS sg13g2_decap_8
XFILLER_126_920 VDD VSS sg13g2_decap_8
X_13833__2369 _13833_/RESET_B VDD VSS sg13g2_tiehi
X_12477_ _12477_/X _14564_/Q _14596_/Q _14628_/Q _14660_/Q _12480_/S0 _12480_/S1 VDD
+ VSS sg13g2_mux4_1
XFILLER_144_227 VDD VSS sg13g2_decap_8
XFILLER_32_1183 VDD VSS sg13g2_decap_8
XANTENNA_4 _09225_/S VDD VSS sg13g2_antennanp
X_14216_ _14216_/Q clkload20/A _14216_/D _14216_/RESET_B VDD VSS sg13g2_dfrbpq_1
X_11428_ _11430_/A _11428_/A _13689_/Q VDD VSS sg13g2_xor2_1
XFILLER_67_1213 VDD VSS sg13g2_decap_8
X_15196_ _15196_/Q _15196_/CLK _15196_/D _15196_/RESET_B VDD VSS sg13g2_dfrbpq_1
X_15247__3038 _15247_/RESET_B VDD VSS sg13g2_tiehi
XFILLER_6_88 VDD VSS sg13g2_decap_8
XFILLER_10_1470 VDD VSS sg13g2_decap_8
XFILLER_99_826 VDD VSS sg13g2_decap_8
X_14147_ _14147_/Q clkload8/A _14147_/D _14147_/RESET_B VDD VSS sg13g2_dfrbpq_1
X_11359_ _11359_/Y _11359_/A _11359_/B VDD VSS sg13g2_nand2_1
XFILLER_98_314 VDD VSS sg13g2_decap_8
XFILLER_119_1336 VDD VSS sg13g2_decap_8
XFILLER_152_271 VDD VSS sg13g2_decap_8
XFILLER_180_580 VDD VSS sg13g2_decap_8
XFILLER_141_956 VDD VSS sg13g2_decap_4
XFILLER_158_1396 VDD VSS sg13g2_decap_8
XFILLER_3_270 VDD VSS sg13g2_decap_8
XFILLER_140_444 VDD VSS sg13g2_decap_8
X_14078_ _14078_/Q _14668_/CLK _14078_/D _14078_/RESET_B VDD VSS sg13g2_dfrbpq_1
X_13029_ _13029_/Y _14813_/Q _13029_/A2 _12976_/B _14845_/Q _13069_/C1 VDD VSS sg13g2_a221oi_1
XFILLER_6_1026 VDD VSS sg13g2_decap_8
XFILLER_80_1468 VDD VSS sg13g2_decap_8
Xfanout1060 _13529_/A _07629_/A VDD VSS sg13g2_buf_1
Xfanout1071 _08377_/B _13525_/A VDD VSS sg13g2_buf_1
XFILLER_55_907 VDD VSS sg13g2_decap_8
Xfanout1082 _08635_/S1 _14990_/Q VDD VSS sg13g2_buf_1
Xfanout1093 _13517_/A _08635_/S0 VDD VSS sg13g2_buf_1
XFILLER_81_203 VDD VSS sg13g2_decap_8
X_08570_ _08570_/Y _08494_/Y _08574_/D _08569_/Y VDD VSS sg13g2_a21oi_1
XFILLER_94_597 VDD VSS sg13g2_decap_4
XFILLER_26_119 VDD VSS sg13g2_decap_8
XFILLER_54_439 VDD VSS sg13g2_decap_8
XFILLER_78_1331 VDD VSS sg13g2_decap_8
XFILLER_66_299 VDD VSS sg13g2_decap_8
XFILLER_35_620 VDD VSS sg13g2_decap_8
XFILLER_47_491 VDD VSS sg13g2_fill_1
XFILLER_165_1301 VDD VSS sg13g2_decap_8
XFILLER_39_1315 VDD VSS sg13g2_decap_8
XFILLER_179_102 VDD VSS sg13g2_decap_8
XFILLER_62_461 VDD VSS sg13g2_decap_8
XFILLER_50_612 VDD VSS sg13g2_fill_2
XFILLER_23_848 VDD VSS sg13g2_decap_8
XFILLER_62_494 VDD VSS sg13g2_decap_8
XFILLER_50_634 VDD VSS sg13g2_decap_4
XFILLER_126_1329 VDD VSS sg13g2_fill_2
XFILLER_165_1378 VDD VSS sg13g2_decap_8
Xclkbuf_leaf_111_clk_i clkload56/A clkbuf_leaf_18_clk_i/A VDD VSS sg13g2_buf_8
XFILLER_179_179 VDD VSS sg13g2_decap_8
XFILLER_37_1083 VDD VSS sg13g2_decap_8
X_09122_ _09125_/B _14919_/Q _09117_/C VDD VSS sg13g2_nor2b_1
XFILLER_124_1075 VDD VSS sg13g2_decap_8
XFILLER_136_706 VDD VSS sg13g2_decap_4
XFILLER_30_380 VDD VSS sg13g2_decap_8
XFILLER_136_717 VDD VSS sg13g2_fill_2
XFILLER_136_728 VDD VSS sg13g2_decap_8
X_09053_ _09053_/Y _15233_/Q _09060_/S VDD VSS sg13g2_nand2b_1
XFILLER_135_205 VDD VSS sg13g2_decap_8
XFILLER_11_1212 VDD VSS sg13g2_decap_8
XFILLER_163_525 VDD VSS sg13g2_fill_2
Xclkbuf_leaf_126_clk_i _14637_/CLK clkbuf_5_4__f_clk_i/X VDD VSS sg13g2_buf_8
X_14423__1779 _14423_/RESET_B VDD VSS sg13g2_tiehi
X_08004_ _08381_/A _08201_/B _08483_/A1 VDD VSS sg13g2_nor2b_1
X_13809__2393 _13809_/RESET_B VDD VSS sg13g2_tiehi
XFILLER_128_290 VDD VSS sg13g2_decap_8
XFILLER_89_1471 VDD VSS sg13g2_decap_4
XFILLER_117_964 VDD VSS sg13g2_decap_8
XFILLER_11_1289 VDD VSS sg13g2_decap_8
XFILLER_131_400 VDD VSS sg13g2_fill_1
XFILLER_172_1305 VDD VSS sg13g2_decap_8
XFILLER_131_444 VDD VSS sg13g2_decap_4
XFILLER_132_978 VDD VSS sg13g2_fill_2
X_09955_ _14539_/D _14539_/Q _10087_/A0 _09964_/S VDD VSS sg13g2_mux2_1
X_13988__2214 _13988_/RESET_B VDD VSS sg13g2_tiehi
XFILLER_135_1160 VDD VSS sg13g2_decap_8
X_08906_ _08906_/Y _10697_/C _08977_/C _15040_/Q VDD VSS sg13g2_nand3_1
XFILLER_83_1092 VDD VSS sg13g2_decap_8
X_09886_ _14472_/D _09919_/A1 _14472_/Q _09890_/S VDD VSS sg13g2_mux2_1
XFILLER_57_211 VDD VSS sg13g2_decap_8
XFILLER_131_1024 VDD VSS sg13g2_decap_8
XFILLER_44_1076 VDD VSS sg13g2_decap_4
XFILLER_85_542 VDD VSS sg13g2_decap_8
XFILLER_66_49 VDD VSS sg13g2_fill_1
X_08837_ _08837_/X _10697_/C _08977_/C VDD VSS sg13g2_and2_1
XFILLER_131_1057 VDD VSS sg13g2_fill_2
XFILLER_181_7 VDD VSS sg13g2_decap_8
XFILLER_100_875 VDD VSS sg13g2_decap_8
XFILLER_57_277 VDD VSS sg13g2_decap_8
XFILLER_17_119 VDD VSS sg13g2_decap_8
XFILLER_22_1363 VDD VSS sg13g2_decap_8
XFILLER_96_1420 VDD VSS sg13g2_decap_8
XFILLER_2_1435 VDD VSS sg13g2_decap_8
X_08768_ _13674_/D _08728_/Y _08767_/Y _08766_/Y VDD VSS sg13g2_a21oi_1
XFILLER_73_748 VDD VSS sg13g2_decap_8
XFILLER_73_759 VDD VSS sg13g2_fill_1
XFILLER_38_491 VDD VSS sg13g2_decap_4
XFILLER_122_77 VDD VSS sg13g2_decap_4
X_07719_ _07719_/X _13343_/B _11288_/A VDD VSS sg13g2_or2_1
XFILLER_57_1415 VDD VSS sg13g2_decap_8
X_08699_ _08699_/Y _08698_/X _08697_/Y _08696_/Y _08695_/Y VDD VSS sg13g2_a22oi_1
XFILLER_0_1170 VDD VSS sg13g2_decap_8
XFILLER_183_1456 VDD VSS sg13g2_decap_8
X_10730_ _10730_/Y _13064_/A _11001_/B VDD VSS sg13g2_nand2_1
XFILLER_81_792 VDD VSS sg13g2_fill_1
XFILLER_41_634 VDD VSS sg13g2_decap_4
XFILLER_144_1429 VDD VSS sg13g2_decap_4
XFILLER_15_42 VDD VSS sg13g2_decap_8
XFILLER_13_347 VDD VSS sg13g2_decap_8
XFILLER_185_105 VDD VSS sg13g2_decap_8
X_10661_ _14892_/D _13328_/A _10661_/B _10661_/C VDD VSS sg13g2_nor3_1
XFILLER_142_1120 VDD VSS sg13g2_decap_8
X_15175__2898 _15175_/RESET_B VDD VSS sg13g2_tiehi
XFILLER_9_329 VDD VSS sg13g2_decap_8
XFILLER_107_1251 VDD VSS sg13g2_decap_8
XFILLER_16_1134 VDD VSS sg13g2_decap_8
XFILLER_22_870 VDD VSS sg13g2_decap_8
X_12400_ _12400_/Y _12415_/A _12400_/B VDD VSS sg13g2_nand2_1
XFILLER_139_544 VDD VSS sg13g2_fill_2
X_13380_ _13380_/Y _08723_/A _08723_/B _15080_/Q VDD VSS sg13g2_o21ai_1
XFILLER_142_1153 VDD VSS sg13g2_decap_4
X_10592_ _14874_/D _10595_/B _10592_/B _10607_/C VDD VSS sg13g2_nor3_1
XFILLER_142_1164 VDD VSS sg13g2_decap_8
XFILLER_51_1047 VDD VSS sg13g2_decap_8
X_12331_ _12331_/X _12324_/B _12330_/X _12329_/Y VDD VSS sg13g2_a21o_1
XFILLER_126_216 VDD VSS sg13g2_fill_2
XFILLER_177_1205 VDD VSS sg13g2_decap_8
XFILLER_166_385 VDD VSS sg13g2_decap_4
XFILLER_181_322 VDD VSS sg13g2_decap_4
XFILLER_31_63 VDD VSS sg13g2_decap_8
XFILLER_120_1451 VDD VSS sg13g2_decap_4
XFILLER_147_41 VDD VSS sg13g2_decap_8
X_15050_ _15050_/Q clkload74/A _15050_/D _15050_/RESET_B VDD VSS sg13g2_dfrbpq_1
X_12262_ _12263_/B _12251_/Y _12253_/X _12143_/A VDD VSS sg13g2_o21ai_1
XFILLER_5_546 VDD VSS sg13g2_decap_8
XFILLER_119_290 VDD VSS sg13g2_decap_8
XFILLER_120_1473 VDD VSS sg13g2_fill_2
XFILLER_107_452 VDD VSS sg13g2_decap_8
XFILLER_103_0 VDD VSS sg13g2_decap_8
X_14001_ _14001_/Q clkload34/A _14001_/D _14001_/RESET_B VDD VSS sg13g2_dfrbpq_1
X_11213_ _11213_/X _11212_/X _11228_/S1 _12324_/B VDD VSS sg13g2_a21o_1
X_12193_ _12193_/Y _12192_/Y _12182_/Y _12174_/Y _12164_/Y _12292_/A VDD VSS sg13g2_a221oi_1
Xclkbuf_leaf_90_clk_i clkload65/A clkbuf_leaf_90_clk_i/A VDD VSS sg13g2_buf_8
XFILLER_162_591 VDD VSS sg13g2_decap_8
Xoutput41 mem_axi_araddr[12] _16865_/A VDD VSS sg13g2_buf_1
XFILLER_122_433 VDD VSS sg13g2_decap_8
Xoutput52 mem_axi_araddr[23] _16876_/A VDD VSS sg13g2_buf_1
XFILLER_122_444 VDD VSS sg13g2_fill_1
X_11144_ _11144_/Y _11172_/A _11164_/B VDD VSS sg13g2_nor2_1
XFILLER_96_807 VDD VSS sg13g2_decap_8
X_14845__2877 _14845_/RESET_B VDD VSS sg13g2_tiehi
Xoutput63 mem_axi_araddr[4] _16857_/A VDD VSS sg13g2_buf_1
Xoutput74 mem_axi_awaddr[13] _16866_/X VDD VSS sg13g2_buf_1
XFILLER_1_763 VDD VSS sg13g2_decap_8
Xoutput85 mem_axi_awaddr[24] _16877_/X VDD VSS sg13g2_buf_1
XFILLER_7_1302 VDD VSS sg13g2_decap_8
X_14578__1624 _14578_/RESET_B VDD VSS sg13g2_tiehi
Xoutput96 mem_axi_awaddr[5] _16858_/X VDD VSS sg13g2_buf_1
X_11075_ _11118_/B _11086_/A _11097_/A VDD VSS sg13g2_xnor2_1
XFILLER_0_273 VDD VSS sg13g2_decap_8
XFILLER_95_339 VDD VSS sg13g2_decap_8
XFILLER_163_84 VDD VSS sg13g2_decap_8
XFILLER_49_745 VDD VSS sg13g2_decap_8
XFILLER_27_1285 VDD VSS sg13g2_decap_8
X_14903_ _14903_/Q clkload62/A _14903_/D _14903_/RESET_B VDD VSS sg13g2_dfrbpq_1
X_10026_ _14608_/D _10159_/A1 _14608_/Q _10030_/S VDD VSS sg13g2_mux2_1
XFILLER_114_1255 VDD VSS sg13g2_fill_1
XFILLER_7_1379 VDD VSS sg13g2_decap_8
XFILLER_62_1187 VDD VSS sg13g2_decap_8
XFILLER_91_512 VDD VSS sg13g2_decap_8
XFILLER_64_726 VDD VSS sg13g2_decap_8
XFILLER_36_417 VDD VSS sg13g2_decap_8
X_14834_ _14834_/Q clkload66/A _14834_/D _14834_/RESET_B VDD VSS sg13g2_dfrbpq_1
XFILLER_64_737 VDD VSS sg13g2_fill_2
XFILLER_40_1452 VDD VSS sg13g2_decap_8
XFILLER_63_225 VDD VSS sg13g2_decap_8
XFILLER_149_1329 VDD VSS sg13g2_decap_8
XFILLER_17_631 VDD VSS sg13g2_decap_8
XFILLER_5_1092 VDD VSS sg13g2_decap_8
XFILLER_16_130 VDD VSS sg13g2_decap_8
X_14765_ _14765_/Q clkload65/A _14765_/D _14765_/RESET_B VDD VSS sg13g2_dfrbpq_1
X_11977_ _11977_/X _14915_/Q _12338_/A2 _11976_/Y VDD VSS sg13g2_a21o_1
XFILLER_44_450 VDD VSS sg13g2_decap_8
XFILLER_17_697 VDD VSS sg13g2_decap_8
X_13716_ _16878_/A clkload56/A _13716_/D _13716_/RESET_B VDD VSS sg13g2_dfrbpq_1
X_10928_ _14936_/D _10927_/Y _10926_/X _10914_/Y VDD VSS sg13g2_o21ai_1
X_14696_ _14696_/Q _14728_/CLK _14696_/D _14696_/RESET_B VDD VSS sg13g2_dfrbpq_1
XFILLER_147_1075 VDD VSS sg13g2_decap_8
XFILLER_60_965 VDD VSS sg13g2_decap_8
XFILLER_31_133 VDD VSS sg13g2_decap_8
XFILLER_176_105 VDD VSS sg13g2_decap_8
XFILLER_34_1201 VDD VSS sg13g2_decap_8
XFILLER_147_1097 VDD VSS sg13g2_decap_8
X_13647_ _14750_/D _15193_/D _14750_/Q _13653_/S VDD VSS sg13g2_mux2_1
XFILLER_38_1370 VDD VSS sg13g2_decap_8
XFILLER_32_678 VDD VSS sg13g2_decap_8
XFILLER_108_1059 VDD VSS sg13g2_fill_2
X_10859_ _10859_/Y _10898_/B1 _10857_/Y _10858_/Y VDD VSS sg13g2_a21oi_1
XFILLER_13_870 VDD VSS sg13g2_decap_8
XFILLER_160_1220 VDD VSS sg13g2_decap_8
XFILLER_13_881 VDD VSS sg13g2_fill_1
XFILLER_73_1283 VDD VSS sg13g2_decap_8
Xclkbuf_leaf_43_clk_i clkload75/A clkbuf_leaf_60_clk_i/A VDD VSS sg13g2_buf_8
X_13578_ _13578_/Y _15158_/Q _13590_/B VDD VSS sg13g2_nor2_1
XFILLER_185_672 VDD VSS sg13g2_decap_8
XFILLER_8_340 VDD VSS sg13g2_decap_8
XFILLER_34_1278 VDD VSS sg13g2_decap_8
XFILLER_160_1297 VDD VSS sg13g2_decap_8
XFILLER_185_683 VDD VSS sg13g2_fill_2
X_12529_ _12529_/X _14120_/Q _14152_/Q _14184_/Q _14216_/Q _12536_/S0 _12536_/S1 VDD
+ VSS sg13g2_mux4_1
XFILLER_117_216 VDD VSS sg13g2_decap_4
XFILLER_9_896 VDD VSS sg13g2_decap_8
XFILLER_173_845 VDD VSS sg13g2_decap_8
X_15248_ _15248_/Q clkload48/A _15248_/D _15248_/RESET_B VDD VSS sg13g2_dfrbpq_1
XFILLER_114_901 VDD VSS sg13g2_fill_1
XFILLER_114_912 VDD VSS sg13g2_fill_1
XFILLER_172_377 VDD VSS sg13g2_decap_8
XFILLER_67_1032 VDD VSS sg13g2_decap_4
Xclkbuf_leaf_58_clk_i clkload76/A clkbuf_leaf_60_clk_i/A VDD VSS sg13g2_buf_8
X_15179_ _15179_/Q clkload87/A _15179_/D _15179_/RESET_B VDD VSS sg13g2_dfrbpq_1
XFILLER_67_1054 VDD VSS sg13g2_decap_8
XFILLER_28_1005 VDD VSS sg13g2_fill_2
XFILLER_125_282 VDD VSS sg13g2_decap_8
XFILLER_158_1193 VDD VSS sg13g2_decap_8
XFILLER_154_1035 VDD VSS sg13g2_decap_8
Xfanout308 _10163_/S _10137_/Y VDD VSS sg13g2_buf_1
Xfanout319 _09964_/S fanout323/X VDD VSS sg13g2_buf_1
XFILLER_113_466 VDD VSS sg13g2_fill_1
XFILLER_87_829 VDD VSS sg13g2_decap_4
XFILLER_80_1221 VDD VSS sg13g2_decap_8
X_09740_ _09740_/Y _09938_/D _09740_/B VDD VSS sg13g2_nor2_1
.ends
