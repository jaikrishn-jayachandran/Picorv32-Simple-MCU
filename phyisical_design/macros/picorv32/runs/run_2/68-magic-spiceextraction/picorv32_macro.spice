* NGSPICE file created from picorv32_macro.ext - technology: ihp-sg13g2

* Black-box entry subcircuit for sg13g2_decap_8 abstract view
.subckt sg13g2_decap_8 VDD VSS
.ends

* Black-box entry subcircuit for sg13g2_mux2_1 abstract view
.subckt sg13g2_mux2_1 X A0 A1 S VDD VSS
.ends

* Black-box entry subcircuit for sg13g2_fill_2 abstract view
.subckt sg13g2_fill_2 VDD VSS
.ends

* Black-box entry subcircuit for sg13g2_nor3_1 abstract view
.subckt sg13g2_nor3_1 Y A B C VDD VSS
.ends

* Black-box entry subcircuit for sg13g2_fill_1 abstract view
.subckt sg13g2_fill_1 VDD VSS
.ends

* Black-box entry subcircuit for sg13g2_tiehi abstract view
.subckt sg13g2_tiehi L_HI VDD VSS
.ends

* Black-box entry subcircuit for sg13g2_nor2_1 abstract view
.subckt sg13g2_nor2_1 Y A B VDD VSS
.ends

* Black-box entry subcircuit for sg13g2_decap_4 abstract view
.subckt sg13g2_decap_4 VDD VSS
.ends

* Black-box entry subcircuit for sg13g2_o21ai_1 abstract view
.subckt sg13g2_o21ai_1 Y A1 A2 B1 VDD VSS
.ends

* Black-box entry subcircuit for sg13g2_a21oi_1 abstract view
.subckt sg13g2_a21oi_1 Y A1 A2 B1 VDD VSS
.ends

* Black-box entry subcircuit for sg13g2_buf_1 abstract view
.subckt sg13g2_buf_1 X A VDD VSS
.ends

* Black-box entry subcircuit for sg13g2_nor4_1 abstract view
.subckt sg13g2_nor4_1 Y A B C D VDD VSS
.ends

* Black-box entry subcircuit for sg13g2_nand2_1 abstract view
.subckt sg13g2_nand2_1 Y A B VDD VSS
.ends

* Black-box entry subcircuit for sg13g2_a221oi_1 abstract view
.subckt sg13g2_a221oi_1 Y A1 A2 B1 B2 C1 VDD VSS
.ends

* Black-box entry subcircuit for sg13g2_dfrbpq_1 abstract view
.subckt sg13g2_dfrbpq_1 Q CLK D RESET_B VDD VSS
.ends

* Black-box entry subcircuit for sg13g2_mux4_1 abstract view
.subckt sg13g2_mux4_1 X A0 A1 A2 A3 S0 S1 VDD VSS
.ends

* Black-box entry subcircuit for sg13g2_inv_1 abstract view
.subckt sg13g2_inv_1 Y A VDD VSS
.ends

* Black-box entry subcircuit for sg13g2_nand3_1 abstract view
.subckt sg13g2_nand3_1 Y A B C VDD VSS
.ends

* Black-box entry subcircuit for sg13g2_a21o_1 abstract view
.subckt sg13g2_a21o_1 X A1 A2 B1 VDD VSS
.ends

* Black-box entry subcircuit for sg13g2_and4_1 abstract view
.subckt sg13g2_and4_1 X A B C D VDD VSS
.ends

* Black-box entry subcircuit for sg13g2_buf_4 abstract view
.subckt sg13g2_buf_4 X A VDD VSS
.ends

* Black-box entry subcircuit for sg13g2_nand3b_1 abstract view
.subckt sg13g2_nand3b_1 Y A_N B C VDD VSS
.ends

* Black-box entry subcircuit for sg13g2_a22oi_1 abstract view
.subckt sg13g2_a22oi_1 Y A1 A2 B1 B2 VDD VSS
.ends

* Black-box entry subcircuit for sg13g2_and2_1 abstract view
.subckt sg13g2_and2_1 X A B VDD VSS
.ends

* Black-box entry subcircuit for sg13g2_buf_16 abstract view
.subckt sg13g2_buf_16 X A VDD VSS
.ends

* Black-box entry subcircuit for sg13g2_nand2b_1 abstract view
.subckt sg13g2_nand2b_1 Y A_N B VDD VSS
.ends

* Black-box entry subcircuit for sg13g2_or2_1 abstract view
.subckt sg13g2_or2_1 X A B VDD VSS
.ends

* Black-box entry subcircuit for sg13g2_buf_2 abstract view
.subckt sg13g2_buf_2 X A VDD VSS
.ends

* Black-box entry subcircuit for sg13g2_nand4_1 abstract view
.subckt sg13g2_nand4_1 Y A B C D VDD VSS
.ends

* Black-box entry subcircuit for sg13g2_xnor2_1 abstract view
.subckt sg13g2_xnor2_1 Y A B VDD VSS
.ends

* Black-box entry subcircuit for sg13g2_and3_1 abstract view
.subckt sg13g2_and3_1 X A B C VDD VSS
.ends

* Black-box entry subcircuit for sg13g2_dlygate4sd3_1 abstract view
.subckt sg13g2_dlygate4sd3_1 X A VDD VSS
.ends

* Black-box entry subcircuit for sg13g2_or4_1 abstract view
.subckt sg13g2_or4_1 X A B C D VDD VSS
.ends

* Black-box entry subcircuit for sg13g2_antennanp abstract view
.subckt sg13g2_antennanp A VDD VSS
.ends

* Black-box entry subcircuit for sg13g2_buf_8 abstract view
.subckt sg13g2_buf_8 X A VDD VSS
.ends

* Black-box entry subcircuit for sg13g2_nor2b_1 abstract view
.subckt sg13g2_nor2b_1 Y A B_N VDD VSS
.ends

* Black-box entry subcircuit for sg13g2_nor4_2 abstract view
.subckt sg13g2_nor4_2 Y A B C D VDD VSS
.ends

* Black-box entry subcircuit for sg13g2_xor2_1 abstract view
.subckt sg13g2_xor2_1 X A B VDD VSS
.ends

* Black-box entry subcircuit for sg13g2_inv_2 abstract view
.subckt sg13g2_inv_2 Y A VDD VSS
.ends

* Black-box entry subcircuit for sg13g2_or3_1 abstract view
.subckt sg13g2_or3_1 X A B C VDD VSS
.ends

* Black-box entry subcircuit for sg13g2_inv_8 abstract view
.subckt sg13g2_inv_8 Y A VDD VSS
.ends

* Black-box entry subcircuit for sg13g2_inv_4 abstract view
.subckt sg13g2_inv_4 Y A VDD VSS
.ends

* Black-box entry subcircuit for sg13g2_nor3_2 abstract view
.subckt sg13g2_nor3_2 Y A B C VDD VSS
.ends

* Black-box entry subcircuit for sg13g2_tielo abstract view
.subckt sg13g2_tielo L_LO VDD VSS
.ends

* Black-box entry subcircuit for sg13g2_a21oi_2 abstract view
.subckt sg13g2_a21oi_2 Y A1 A2 B1 VDD VSS
.ends

.subckt picorv32_macro VDD VSS clk_i mem_axi_araddr[0] mem_axi_araddr[10] mem_axi_araddr[11]
+ mem_axi_araddr[12] mem_axi_araddr[13] mem_axi_araddr[14] mem_axi_araddr[15] mem_axi_araddr[16]
+ mem_axi_araddr[17] mem_axi_araddr[18] mem_axi_araddr[19] mem_axi_araddr[1] mem_axi_araddr[20]
+ mem_axi_araddr[21] mem_axi_araddr[22] mem_axi_araddr[23] mem_axi_araddr[24] mem_axi_araddr[25]
+ mem_axi_araddr[26] mem_axi_araddr[27] mem_axi_araddr[28] mem_axi_araddr[29] mem_axi_araddr[2]
+ mem_axi_araddr[30] mem_axi_araddr[31] mem_axi_araddr[3] mem_axi_araddr[4] mem_axi_araddr[5]
+ mem_axi_araddr[6] mem_axi_araddr[7] mem_axi_araddr[8] mem_axi_araddr[9] mem_axi_arprot[0]
+ mem_axi_arprot[1] mem_axi_arprot[2] mem_axi_arready mem_axi_arvalid mem_axi_awaddr[0]
+ mem_axi_awaddr[10] mem_axi_awaddr[11] mem_axi_awaddr[12] mem_axi_awaddr[13] mem_axi_awaddr[14]
+ mem_axi_awaddr[15] mem_axi_awaddr[16] mem_axi_awaddr[17] mem_axi_awaddr[18] mem_axi_awaddr[19]
+ mem_axi_awaddr[1] mem_axi_awaddr[20] mem_axi_awaddr[21] mem_axi_awaddr[22] mem_axi_awaddr[23]
+ mem_axi_awaddr[24] mem_axi_awaddr[25] mem_axi_awaddr[26] mem_axi_awaddr[27] mem_axi_awaddr[28]
+ mem_axi_awaddr[29] mem_axi_awaddr[2] mem_axi_awaddr[30] mem_axi_awaddr[31] mem_axi_awaddr[3]
+ mem_axi_awaddr[4] mem_axi_awaddr[5] mem_axi_awaddr[6] mem_axi_awaddr[7] mem_axi_awaddr[8]
+ mem_axi_awaddr[9] mem_axi_awprot[0] mem_axi_awprot[1] mem_axi_awprot[2] mem_axi_awready
+ mem_axi_awvalid mem_axi_bready mem_axi_bvalid mem_axi_rdata[0] mem_axi_rdata[10]
+ mem_axi_rdata[11] mem_axi_rdata[12] mem_axi_rdata[13] mem_axi_rdata[14] mem_axi_rdata[15]
+ mem_axi_rdata[16] mem_axi_rdata[17] mem_axi_rdata[18] mem_axi_rdata[19] mem_axi_rdata[1]
+ mem_axi_rdata[20] mem_axi_rdata[21] mem_axi_rdata[22] mem_axi_rdata[23] mem_axi_rdata[24]
+ mem_axi_rdata[25] mem_axi_rdata[26] mem_axi_rdata[27] mem_axi_rdata[28] mem_axi_rdata[29]
+ mem_axi_rdata[2] mem_axi_rdata[30] mem_axi_rdata[31] mem_axi_rdata[3] mem_axi_rdata[4]
+ mem_axi_rdata[5] mem_axi_rdata[6] mem_axi_rdata[7] mem_axi_rdata[8] mem_axi_rdata[9]
+ mem_axi_rready mem_axi_rvalid mem_axi_wdata[0] mem_axi_wdata[10] mem_axi_wdata[11]
+ mem_axi_wdata[12] mem_axi_wdata[13] mem_axi_wdata[14] mem_axi_wdata[15] mem_axi_wdata[16]
+ mem_axi_wdata[17] mem_axi_wdata[18] mem_axi_wdata[19] mem_axi_wdata[1] mem_axi_wdata[20]
+ mem_axi_wdata[21] mem_axi_wdata[22] mem_axi_wdata[23] mem_axi_wdata[24] mem_axi_wdata[25]
+ mem_axi_wdata[26] mem_axi_wdata[27] mem_axi_wdata[28] mem_axi_wdata[29] mem_axi_wdata[2]
+ mem_axi_wdata[30] mem_axi_wdata[31] mem_axi_wdata[3] mem_axi_wdata[4] mem_axi_wdata[5]
+ mem_axi_wdata[6] mem_axi_wdata[7] mem_axi_wdata[8] mem_axi_wdata[9] mem_axi_wready
+ mem_axi_wstrb[0] mem_axi_wstrb[1] mem_axi_wstrb[2] mem_axi_wstrb[3] mem_axi_wvalid
+ rst_ni trap
XFILLER_41_1216 VDD VSS sg13g2_decap_8
X_09671_ _14264_/D _09902_/A0 _14264_/Q wire639/X VDD VSS sg13g2_mux2_1
XFILLER_54_203 VDD VSS sg13g2_fill_2
X_08622_ _08622_/Y _08622_/A _08622_/B _08622_/C VDD VSS sg13g2_nor3_1
XFILLER_67_597 VDD VSS sg13g2_fill_1
X_14226__2338 _14226_/RESET_B VDD VSS sg13g2_tiehi
XFILLER_94_372 VDD VSS sg13g2_decap_8
XFILLER_27_439 VDD VSS sg13g2_decap_8
XFILLER_36_951 VDD VSS sg13g2_fill_2
XFILLER_36_962 VDD VSS sg13g2_decap_8
XFILLER_39_1101 VDD VSS sg13g2_decap_8
X_08553_ _08553_/Y _08553_/A _08553_/B VDD VSS sg13g2_nor2_1
XFILLER_36_973 VDD VSS sg13g2_fill_2
XFILLER_82_578 VDD VSS sg13g2_fill_2
XFILLER_36_984 VDD VSS sg13g2_decap_8
XFILLER_74_1014 VDD VSS sg13g2_fill_2
XFILLER_22_100 VDD VSS sg13g2_decap_8
X_08484_ _08484_/Y _08514_/B _08484_/B _08484_/C VDD VSS sg13g2_nor3_1
XFILLER_39_1167 VDD VSS sg13g2_decap_4
XFILLER_50_431 VDD VSS sg13g2_fill_2
XFILLER_35_1009 VDD VSS sg13g2_decap_8
X_14441__2123 _14441_/RESET_B VDD VSS sg13g2_tiehi
XFILLER_149_864 VDD VSS sg13g2_fill_1
XFILLER_22_199 VDD VSS sg13g2_decap_8
X_09105_ wire198/A _09090_/A _10752_/B _09104_/X VDD VSS sg13g2_o21ai_1
X_09036_ _09036_/Y _14906_/Q _09031_/C _09035_/Y VDD VSS sg13g2_a21oi_1
XFILLER_136_558 VDD VSS sg13g2_fill_2
XFILLER_104_400 VDD VSS sg13g2_decap_8
XFILLER_117_44 VDD VSS sg13g2_fill_1
XFILLER_7_7 VDD VSS sg13g2_decap_8
XFILLER_85_1165 VDD VSS sg13g2_fill_2
XFILLER_116_282 VDD VSS sg13g2_fill_1
XFILLER_137_1233 VDD VSS sg13g2_decap_4
XFILLER_131_230 VDD VSS sg13g2_decap_4
XFILLER_78_818 VDD VSS sg13g2_decap_8
XFILLER_89_144 VDD VSS sg13g2_decap_8
XFILLER_105_978 VDD VSS sg13g2_fill_1
XFILLER_46_1149 VDD VSS sg13g2_decap_8
Xfanout820 _12900_/A _13045_/A1 VDD VSS sg13g2_buf_1
XFILLER_131_263 VDD VSS sg13g2_decap_8
Xfanout831 _11433_/B _11288_/Y VDD VSS sg13g2_buf_1
XFILLER_89_188 VDD VSS sg13g2_decap_8
Xfanout842 _10800_/B _13294_/B VDD VSS sg13g2_buf_1
XFILLER_104_499 VDD VSS sg13g2_fill_1
X_09938_ _09938_/Y _09938_/A _09938_/B _10137_/A _09938_/D VDD VSS sg13g2_nor4_1
Xfanout853 _08943_/A _10675_/A VDD VSS sg13g2_buf_1
Xfanout864 _10669_/S _08848_/A VDD VSS sg13g2_buf_1
Xfanout875 _13508_/C _08828_/Y VDD VSS sg13g2_buf_1
XFILLER_133_32 VDD VSS sg13g2_decap_8
Xfanout886 _08523_/B1 _07998_/X VDD VSS sg13g2_buf_1
Xfanout897 _08674_/A2 _08522_/C VDD VSS sg13g2_buf_1
X_09869_ _14456_/D _14456_/Q _10167_/A1 _09869_/S VDD VSS sg13g2_mux2_1
XFILLER_92_309 VDD VSS sg13g2_decap_8
XFILLER_46_715 VDD VSS sg13g2_fill_2
XFILLER_100_661 VDD VSS sg13g2_decap_4
XFILLER_93_14 VDD VSS sg13g2_decap_8
X_11900_ _11900_/Y _11900_/A _12317_/B VDD VSS sg13g2_nand2_1
XFILLER_18_428 VDD VSS sg13g2_decap_8
XFILLER_58_597 VDD VSS sg13g2_fill_2
XFILLER_133_98 VDD VSS sg13g2_decap_8
X_12880_ _12880_/Y _14804_/Q _12851_/B _12963_/B _14868_/Q _13180_/C1 VDD VSS sg13g2_a221oi_1
X_14651__1913 _14651_/RESET_B VDD VSS sg13g2_tiehi
X_11831_ _11832_/B _11820_/Y _11822_/X _12333_/B1 VDD VSS sg13g2_o21ai_1
XFILLER_57_1212 VDD VSS sg13g2_decap_8
XFILLER_26_63 VDD VSS sg13g2_decap_8
XFILLER_14_601 VDD VSS sg13g2_fill_1
XFILLER_60_217 VDD VSS sg13g2_decap_8
XFILLER_92_1114 VDD VSS sg13g2_fill_1
X_14550_ _14550_/Q _14710_/CLK _14550_/D _14550_/RESET_B VDD VSS sg13g2_dfrbpq_1
X_14080__2484 _14080_/RESET_B VDD VSS sg13g2_tiehi
X_11762_ _11763_/A _14698_/Q _14730_/Q _13770_/Q _13802_/Q _11759_/A _11760_/C VDD
+ VSS sg13g2_mux4_1
XFILLER_92_1147 VDD VSS sg13g2_decap_8
XFILLER_144_1226 VDD VSS sg13g2_decap_8
X_13501_ _13501_/Y _13656_/S _15129_/Q VDD VSS sg13g2_nand2_1
X_10713_ _10936_/B _10954_/B VDD VSS sg13g2_inv_1
XFILLER_92_1169 VDD VSS sg13g2_decap_8
X_14481_ _14481_/Q clkload51/A _14481_/D _14481_/RESET_B VDD VSS sg13g2_dfrbpq_1
X_11693_ _11694_/B _11693_/A _11693_/B _11693_/C VDD VSS sg13g2_nand3_1
XFILLER_42_998 VDD VSS sg13g2_decap_8
XFILLER_139_330 VDD VSS sg13g2_decap_8
X_13432_ _15098_/D _15098_/Q _13353_/Y _13431_/Y VDD VSS sg13g2_a21o_1
X_10644_ _10644_/Y _14889_/Q _10643_/C _10630_/C VDD VSS sg13g2_o21ai_1
XFILLER_9_159 VDD VSS sg13g2_fill_1
XFILLER_155_812 VDD VSS sg13g2_fill_2
XFILLER_42_95 VDD VSS sg13g2_decap_8
X_13363_ _13363_/Y _13427_/A _13363_/B _15074_/Q VDD VSS sg13g2_nand3_1
X_10575_ _10586_/D _14870_/Q _12895_/A _10575_/C _10653_/A VDD VSS sg13g2_and4_1
X_14855__3219 _14855_/RESET_B VDD VSS sg13g2_tiehi
XFILLER_154_322 VDD VSS sg13g2_decap_8
XFILLER_6_833 VDD VSS sg13g2_decap_8
XFILLER_10_895 VDD VSS sg13g2_decap_8
Xmax_cap1159 _12689_/S0 _12630_/S0 VDD VSS sg13g2_buf_4
X_15102_ _15102_/Q clkload67/A _15102_/D _15102_/RESET_B VDD VSS sg13g2_dfrbpq_1
X_12314_ _12314_/Y _12303_/S _14682_/Q _12304_/B VDD VSS sg13g2_a21oi_1
XFILLER_155_889 VDD VSS sg13g2_decap_8
X_13294_ _13294_/Y _15204_/Q _13294_/B _13294_/C VDD VSS sg13g2_nand3b_1
X_15033_ _15033_/Q clkload38/A _15033_/D _15033_/RESET_B VDD VSS sg13g2_dfrbpq_1
X_12245_ _12246_/A _13752_/Q _14104_/Q _14456_/Q _14552_/Q _12255_/A1 _12259_/S1 VDD
+ VSS sg13g2_mux4_1
XFILLER_135_591 VDD VSS sg13g2_decap_4
XFILLER_69_807 VDD VSS sg13g2_fill_2
X_12176_ _12176_/Y _12252_/S0 _14422_/Q _12187_/C VDD VSS sg13g2_a21oi_1
XFILLER_111_904 VDD VSS sg13g2_fill_1
XFILLER_69_818 VDD VSS sg13g2_fill_1
XFILLER_68_306 VDD VSS sg13g2_fill_1
XFILLER_3_56 VDD VSS sg13g2_decap_8
XFILLER_7_1110 VDD VSS sg13g2_decap_8
X_11127_ _11127_/Y _11127_/A _11127_/B _11146_/A VDD VSS sg13g2_nand3_1
XFILLER_68_328 VDD VSS sg13g2_decap_4
XFILLER_95_125 VDD VSS sg13g2_decap_8
XFILLER_122_285 VDD VSS sg13g2_decap_8
XFILLER_27_1082 VDD VSS sg13g2_decap_8
X_11058_ _11058_/Y _11185_/A _11078_/B VDD VSS sg13g2_nor2_1
X_14939__3051 _14939_/RESET_B VDD VSS sg13g2_tiehi
XFILLER_7_1187 VDD VSS sg13g2_decap_8
XFILLER_64_501 VDD VSS sg13g2_decap_4
XFILLER_67_92 VDD VSS sg13g2_decap_8
X_10009_ _14591_/D _10075_/A0 _14591_/Q _10009_/S VDD VSS sg13g2_mux2_1
XFILLER_92_832 VDD VSS sg13g2_decap_8
XFILLER_114_1096 VDD VSS sg13g2_fill_2
X_14817_ _14817_/Q clkload83/A _14817_/D _14817_/RESET_B VDD VSS sg13g2_dfrbpq_1
X_14773__3325 _14773_/RESET_B VDD VSS sg13g2_tiehi
XFILLER_51_206 VDD VSS sg13g2_decap_8
XFILLER_18_995 VDD VSS sg13g2_decap_8
XFILLER_17_472 VDD VSS sg13g2_decap_4
XFILLER_45_781 VDD VSS sg13g2_decap_8
X_14748_ _14748_/Q clkload68/A _14748_/D _14748_/RESET_B VDD VSS sg13g2_dfrbpq_1
XFILLER_149_105 VDD VSS sg13g2_decap_8
XFILLER_33_976 VDD VSS sg13g2_fill_2
XFILLER_32_453 VDD VSS sg13g2_fill_1
X_14679_ _14679_/Q clkload9/A _14679_/D _14679_/RESET_B VDD VSS sg13g2_dfrbpq_1
XFILLER_60_773 VDD VSS sg13g2_decap_8
XFILLER_20_626 VDD VSS sg13g2_fill_2
XFILLER_34_1042 VDD VSS sg13g2_decap_8
X_15117__3110 _15117_/RESET_B VDD VSS sg13g2_tiehi
XFILLER_34_1086 VDD VSS sg13g2_decap_8
XFILLER_66_0 VDD VSS sg13g2_decap_8
Xmax_cap1660 _11514_/S0 _11710_/S0 VDD VSS sg13g2_buf_4
Xmax_cap1671 _12213_/S0 _12162_/S0 VDD VSS sg13g2_buf_4
XFILLER_69_1149 VDD VSS sg13g2_decap_4
X_15220__3373 _15220_/RESET_B VDD VSS sg13g2_tiehi
XFILLER_105_219 VDD VSS sg13g2_decap_8
XFILLER_99_431 VDD VSS sg13g2_decap_8
XFILLER_113_252 VDD VSS sg13g2_decap_8
XFILLER_86_103 VDD VSS sg13g2_decap_8
XFILLER_141_594 VDD VSS sg13g2_fill_2
Xfanout149 _10136_/A0 wire153/X VDD VSS sg13g2_buf_1
X_07984_ _07985_/D _07908_/A _15073_/Q _15215_/Q _07977_/Y VDD VSS sg13g2_a22oi_1
XFILLER_45_1171 VDD VSS sg13g2_fill_2
X_14459__2105 _14459_/RESET_B VDD VSS sg13g2_tiehi
X_09723_ _14314_/D _09789_/A0 _14314_/Q _09737_/S VDD VSS sg13g2_mux2_1
XFILLER_28_704 VDD VSS sg13g2_fill_2
XFILLER_86_169 VDD VSS sg13g2_decap_8
XFILLER_83_810 VDD VSS sg13g2_decap_4
XFILLER_27_203 VDD VSS sg13g2_decap_8
XFILLER_67_372 VDD VSS sg13g2_fill_2
XFILLER_68_895 VDD VSS sg13g2_decap_8
XFILLER_55_523 VDD VSS sg13g2_decap_4
X_09654_ _14247_/D _09918_/A1 _14247_/Q _09666_/S VDD VSS sg13g2_mux2_1
XFILLER_41_1079 VDD VSS sg13g2_decap_8
XFILLER_83_854 VDD VSS sg13g2_fill_2
XFILLER_103_35 VDD VSS sg13g2_decap_8
X_08605_ _08605_/X _08605_/A _08605_/B VDD VSS sg13g2_and2_1
XFILLER_27_269 VDD VSS sg13g2_fill_2
XFILLER_63_17 VDD VSS sg13g2_fill_2
X_09585_ _14182_/D _14182_/Q _09653_/A0 wire329/A VDD VSS sg13g2_mux2_1
X_08536_ _08545_/A _13533_/A _08214_/X _08688_/C VDD VSS sg13g2_o21ai_1
XFILLER_51_751 VDD VSS sg13g2_fill_2
XFILLER_144_7 VDD VSS sg13g2_decap_8
XFILLER_24_987 VDD VSS sg13g2_decap_8
XFILLER_51_773 VDD VSS sg13g2_decap_8
X_08467_ _08469_/A _08621_/A _08617_/B VDD VSS sg13g2_nor2_1
XFILLER_11_648 VDD VSS sg13g2_decap_4
X_08398_ _08398_/Y _08034_/A _08201_/B _08050_/Y VDD VSS sg13g2_o21ai_1
XFILLER_13_1104 VDD VSS sg13g2_decap_8
XFILLER_7_619 VDD VSS sg13g2_decap_8
XFILLER_155_119 VDD VSS sg13g2_decap_8
XFILLER_136_300 VDD VSS sg13g2_decap_8
XFILLER_12_21 VDD VSS sg13g2_decap_8
Xclkbuf_5_6__f_clk_i clkbuf_5_6__f_clk_i/X clkbuf_4_3_0_clk_i/X VDD VSS sg13g2_buf_16
XFILLER_109_536 VDD VSS sg13g2_fill_2
XFILLER_87_1205 VDD VSS sg13g2_fill_1
XFILLER_128_21 VDD VSS sg13g2_decap_8
X_10360_ _14811_/D _10364_/C _10602_/A _10360_/C VDD VSS sg13g2_nor3_1
XFILLER_136_366 VDD VSS sg13g2_decap_8
XFILLER_151_303 VDD VSS sg13g2_decap_4
XFILLER_12_98 VDD VSS sg13g2_decap_8
XFILLER_88_14 VDD VSS sg13g2_decap_4
X_09019_ _09019_/Y _09019_/A _09019_/B VDD VSS sg13g2_nand2_1
X_10291_ _10292_/C _14791_/Q _10294_/C VDD VSS sg13g2_and2_1
XFILLER_3_858 VDD VSS sg13g2_fill_1
X_12030_ _12030_/Y _12040_/A1 _14386_/Q VDD VSS sg13g2_nand2b_1
XFILLER_137_1030 VDD VSS sg13g2_decap_8
XFILLER_2_368 VDD VSS sg13g2_fill_2
Xfanout1604 _11420_/C _11953_/C VDD VSS sg13g2_buf_1
XFILLER_144_42 VDD VSS sg13g2_decap_8
Xfanout1615 _12169_/C _12171_/S1 VDD VSS sg13g2_buf_1
X_14098__2466 _14098_/RESET_B VDD VSS sg13g2_tiehi
Xfanout1626 _11760_/C _12248_/B1 VDD VSS sg13g2_buf_1
XFILLER_120_734 VDD VSS sg13g2_fill_2
XFILLER_77_125 VDD VSS sg13g2_decap_8
XFILLER_24_1211 VDD VSS sg13g2_decap_8
Xfanout1637 _12286_/S1 fanout1639/X VDD VSS sg13g2_buf_1
Xfanout1648 _11828_/S1 fanout1650/X VDD VSS sg13g2_buf_1
Xfanout650 wire651/A wire653/A VDD VSS sg13g2_buf_1
Xfanout1659 _11710_/S0 _11715_/S0 VDD VSS sg13g2_buf_1
Xfanout672 _09473_/S _09441_/Y VDD VSS sg13g2_buf_1
XFILLER_59_862 VDD VSS sg13g2_fill_1
XFILLER_77_169 VDD VSS sg13g2_decap_8
X_13981_ _13981_/Q _14525_/CLK _13981_/D _13981_/RESET_B VDD VSS sg13g2_dfrbpq_1
XFILLER_111_1214 VDD VSS sg13g2_decap_8
XFILLER_74_821 VDD VSS sg13g2_decap_4
X_12932_ wire567/A _12929_/Y _12930_/Y _12931_/Y VDD VSS sg13g2_a21oi_1
XFILLER_100_480 VDD VSS sg13g2_decap_8
XFILLER_46_545 VDD VSS sg13g2_decap_8
X_15037__2935 _15037_/RESET_B VDD VSS sg13g2_tiehi
Xwire1798 _10184_/B input3/X VDD VSS sg13g2_buf_4
XFILLER_74_865 VDD VSS sg13g2_decap_8
XFILLER_37_84 VDD VSS sg13g2_decap_4
XFILLER_46_567 VDD VSS sg13g2_decap_8
X_12863_ _12863_/Y _14803_/Q _12851_/B _13260_/B _14835_/Q _13180_/C1 VDD VSS sg13g2_a221oi_1
XFILLER_2_1073 VDD VSS sg13g2_decap_8
X_14602_ _14602_/Q clkload20/A _14602_/D _14602_/RESET_B VDD VSS sg13g2_dfrbpq_1
XFILLER_57_1020 VDD VSS sg13g2_fill_1
XFILLER_33_228 VDD VSS sg13g2_decap_8
X_11814_ _11815_/A _13740_/Q _14092_/Q _14444_/Q _14540_/Q _11814_/S0 _11828_/S1 VDD
+ VSS sg13g2_mux4_1
XFILLER_15_943 VDD VSS sg13g2_decap_8
XFILLER_57_1042 VDD VSS sg13g2_decap_4
XFILLER_61_559 VDD VSS sg13g2_decap_8
X_12794_ _12794_/X _12997_/B _12844_/C VDD VSS sg13g2_or2_1
X_14533_ _14533_/Q clkload0/A _14533_/D _14533_/RESET_B VDD VSS sg13g2_dfrbpq_1
XFILLER_42_762 VDD VSS sg13g2_decap_8
XFILLER_109_1132 VDD VSS sg13g2_decap_8
XFILLER_15_987 VDD VSS sg13g2_decap_8
X_11745_ _11745_/Y _11745_/A _11763_/B VDD VSS sg13g2_nand2_1
XFILLER_109_1143 VDD VSS sg13g2_fill_2
XFILLER_18_1037 VDD VSS sg13g2_decap_8
X_14464_ _14464_/Q _14917_/CLK _14464_/D _14464_/RESET_B VDD VSS sg13g2_dfrbpq_1
X_11676_ _11676_/Y _11692_/A _14664_/Q _11690_/B VDD VSS sg13g2_a21oi_1
X_13415_ _15092_/D _15129_/Q _13414_/Y _13409_/Y VDD VSS sg13g2_a21o_1
X_10627_ _10630_/A _14883_/Q _10632_/D _14884_/Q VDD VSS sg13g2_a21o_1
XFILLER_155_620 VDD VSS sg13g2_decap_4
X_14395_ _14395_/Q _14776_/CLK _14395_/D _14395_/RESET_B VDD VSS sg13g2_dfrbpq_1
XFILLER_139_182 VDD VSS sg13g2_decap_8
X_14537__2027 _14537_/RESET_B VDD VSS sg13g2_tiehi
Xmax_cap806 _08666_/A _08678_/A VDD VSS sg13g2_buf_2
X_13346_ _13347_/A _13654_/S _15173_/D VDD VSS sg13g2_nor2_1
X_15062__1816 _15062_/RESET_B VDD VSS sg13g2_tiehi
X_10558_ _10561_/B _14859_/Q _10558_/B _10564_/D _14856_/Q VDD VSS sg13g2_nand4_1
XFILLER_5_140 VDD VSS sg13g2_decap_8
XFILLER_127_366 VDD VSS sg13g2_fill_1
XFILLER_155_686 VDD VSS sg13g2_decap_8
X_15105__3136 _15105_/RESET_B VDD VSS sg13g2_tiehi
XFILLER_127_388 VDD VSS sg13g2_decap_8
X_13277_ wire205/A _13048_/X _13272_/X _13276_/Y VDD VSS sg13g2_a21oi_1
XFILLER_154_196 VDD VSS sg13g2_decap_8
X_10489_ _10498_/D _14850_/Q _14849_/Q _14848_/Q _10489_/D VDD VSS sg13g2_and4_1
XFILLER_108_591 VDD VSS sg13g2_decap_8
XFILLER_29_1111 VDD VSS sg13g2_decap_8
X_15016_ _15016_/Q _15160_/CLK _15016_/D _15016_/RESET_B VDD VSS sg13g2_dfrbpq_1
X_12228_ _12274_/B _12229_/A _13664_/Q VDD VSS sg13g2_nor2_1
XFILLER_29_1144 VDD VSS sg13g2_decap_8
XFILLER_64_1024 VDD VSS sg13g2_decap_8
X_14827__3271 _14827_/RESET_B VDD VSS sg13g2_tiehi
XFILLER_96_401 VDD VSS sg13g2_fill_1
XFILLER_155_1163 VDD VSS sg13g2_decap_8
XFILLER_96_423 VDD VSS sg13g2_decap_8
XFILLER_150_380 VDD VSS sg13g2_decap_8
X_13763__2801 _13763_/RESET_B VDD VSS sg13g2_tiehi
X_12159_ _12159_/Y _12168_/A _14198_/Q VDD VSS sg13g2_nand2b_1
X_15146__3050 _15146_/RESET_B VDD VSS sg13g2_tiehi
XFILLER_64_1079 VDD VSS sg13g2_fill_2
XFILLER_111_789 VDD VSS sg13g2_decap_8
XFILLER_49_383 VDD VSS sg13g2_decap_8
XFILLER_37_534 VDD VSS sg13g2_decap_8
XFILLER_49_394 VDD VSS sg13g2_fill_2
XFILLER_65_887 VDD VSS sg13g2_fill_1
X_14143__2421 _14143_/RESET_B VDD VSS sg13g2_tiehi
XFILLER_40_1090 VDD VSS sg13g2_decap_8
X_13796__2768 _13796_/RESET_B VDD VSS sg13g2_tiehi
XFILLER_64_397 VDD VSS sg13g2_decap_4
X_09370_ _13974_/D _10165_/A1 _13974_/Q _09370_/S VDD VSS sg13g2_mux2_1
XFILLER_33_740 VDD VSS sg13g2_decap_8
XFILLER_127_1221 VDD VSS sg13g2_decap_8
X_08321_ _08321_/Y _08369_/B _08350_/B VDD VSS sg13g2_nand2_1
X_14747__1817 _14747_/RESET_B VDD VSS sg13g2_tiehi
XFILLER_21_935 VDD VSS sg13g2_decap_8
XFILLER_60_581 VDD VSS sg13g2_decap_8
X_08252_ _08252_/Y _08344_/A2 _08057_/Y _08241_/Y VDD VSS sg13g2_o21ai_1
XFILLER_20_434 VDD VSS sg13g2_decap_8
XFILLER_119_801 VDD VSS sg13g2_decap_4
X_14176__2388 _14176_/RESET_B VDD VSS sg13g2_tiehi
X_08183_ _08183_/Y _08183_/A _08183_/B _08183_/C VDD VSS sg13g2_nor3_1
XFILLER_119_856 VDD VSS sg13g2_decap_8
XFILLER_145_174 VDD VSS sg13g2_decap_8
XFILLER_0_806 VDD VSS sg13g2_decap_4
X_14391__2173 _14391_/RESET_B VDD VSS sg13g2_tiehi
XFILLER_47_1233 VDD VSS sg13g2_decap_4
XFILLER_82_1113 VDD VSS sg13g2_decap_8
XFILLER_58_28 VDD VSS sg13g2_decap_4
XFILLER_102_734 VDD VSS sg13g2_fill_2
XFILLER_114_594 VDD VSS sg13g2_decap_4
XFILLER_43_1119 VDD VSS sg13g2_decap_8
XFILLER_82_1179 VDD VSS sg13g2_decap_8
XFILLER_101_233 VDD VSS sg13g2_decap_4
XFILLER_59_169 VDD VSS sg13g2_fill_2
XFILLER_75_618 VDD VSS sg13g2_fill_1
X_07967_ _07967_/Y _07964_/Y _07856_/Y _07965_/Y VDD VSS sg13g2_o21ai_1
XFILLER_101_277 VDD VSS sg13g2_decap_4
XFILLER_56_832 VDD VSS sg13g2_decap_8
X_09706_ _14298_/D _10069_/A0 _14298_/Q _09706_/S VDD VSS sg13g2_mux2_1
X_14983__2989 _14983_/RESET_B VDD VSS sg13g2_tiehi
XFILLER_68_692 VDD VSS sg13g2_fill_2
XFILLER_74_139 VDD VSS sg13g2_decap_4
X_07898_ _07905_/B _08183_/B _08188_/A _07879_/Y VDD VSS sg13g2_o21ai_1
XFILLER_83_640 VDD VSS sg13g2_decap_8
XFILLER_56_865 VDD VSS sg13g2_fill_2
X_09637_ _14233_/D _10101_/A0 _14233_/Q _09637_/S VDD VSS sg13g2_mux2_1
XFILLER_70_301 VDD VSS sg13g2_decap_8
XFILLER_83_684 VDD VSS sg13g2_decap_8
XFILLER_55_397 VDD VSS sg13g2_decap_8
X_09568_ _14166_/D _10098_/A0 _14166_/Q wire653/X VDD VSS sg13g2_mux2_1
X_08519_ _08597_/C _08591_/A3 _07815_/B _07820_/B _07801_/B _08598_/S0 _08598_/S1
+ VDD VSS sg13g2_mux4_1
XFILLER_70_367 VDD VSS sg13g2_fill_1
XFILLER_130_77 VDD VSS sg13g2_fill_1
XFILLER_12_913 VDD VSS sg13g2_fill_1
XFILLER_12_924 VDD VSS sg13g2_decap_8
X_09499_ _14099_/D _09963_/A1 _14099_/Q _09500_/S VDD VSS sg13g2_mux2_1
X_14923__3083 _14923_/RESET_B VDD VSS sg13g2_tiehi
XFILLER_90_48 VDD VSS sg13g2_decap_8
X_11530_ _11532_/A _11531_/A _14180_/Q VDD VSS sg13g2_nand2b_1
XFILLER_23_283 VDD VSS sg13g2_decap_8
XFILLER_23_294 VDD VSS sg13g2_decap_8
XFILLER_156_406 VDD VSS sg13g2_decap_4
XFILLER_23_42 VDD VSS sg13g2_decap_8
XFILLER_12_968 VDD VSS sg13g2_decap_8
Xwire303 wire303/X wire303/A VDD VSS sg13g2_buf_2
XFILLER_139_42 VDD VSS sg13g2_decap_8
X_14006__2558 _14006_/RESET_B VDD VSS sg13g2_tiehi
X_11461_ _11463_/B _11461_/A _13687_/Q VDD VSS sg13g2_xnor2_1
X_13841__2723 _13841_/RESET_B VDD VSS sg13g2_tiehi
XFILLER_17_1092 VDD VSS sg13g2_decap_8
XFILLER_104_1040 VDD VSS sg13g2_decap_8
X_13200_ _13224_/A _14920_/Q _13667_/Q VDD VSS sg13g2_xnor2_1
XFILLER_139_86 VDD VSS sg13g2_fill_1
Xwire369 wire369/X wire369/A VDD VSS sg13g2_buf_1
X_10412_ _10415_/C _10413_/B _10414_/D hold3524/X VDD VSS sg13g2_a21oi_1
X_11392_ _11392_/Y _11418_/A _13919_/Q _11391_/Y VDD VSS sg13g2_a21oi_1
X_14180_ _14180_/Q clkload31/A _14180_/D _14180_/RESET_B VDD VSS sg13g2_dfrbpq_1
XFILLER_87_1013 VDD VSS sg13g2_decap_8
XFILLER_104_1095 VDD VSS sg13g2_decap_8
X_13131_ _13131_/Y _14914_/Q _13673_/Q _13132_/A VDD VSS sg13g2_a21oi_1
XFILLER_139_1125 VDD VSS sg13g2_decap_8
X_10343_ _14807_/D _10343_/A _10343_/B _10350_/C VDD VSS sg13g2_and3_1
XFILLER_151_133 VDD VSS sg13g2_decap_8
XFILLER_152_667 VDD VSS sg13g2_decap_8
X_10274_ _10274_/Y _14786_/Q _10305_/A _10271_/B VDD VSS sg13g2_o21ai_1
XFILLER_139_1169 VDD VSS sg13g2_decap_8
XFILLER_3_666 VDD VSS sg13g2_decap_8
X_13062_ _13066_/A _13063_/B VDD VSS sg13g2_inv_1
XFILLER_155_63 VDD VSS sg13g2_decap_8
X_14221__2343 _14221_/RESET_B VDD VSS sg13g2_tiehi
XFILLER_2_154 VDD VSS sg13g2_decap_8
XFILLER_78_412 VDD VSS sg13g2_decap_4
XFILLER_133_892 VDD VSS sg13g2_fill_1
X_12013_ _12013_/Y _11988_/Y _12012_/X _12301_/B1 VDD VSS sg13g2_a21oi_1
Xfanout1412 _08686_/A3 _12203_/A VDD VSS sg13g2_buf_1
XFILLER_120_520 VDD VSS sg13g2_decap_8
XFILLER_2_198 VDD VSS sg13g2_decap_8
Xfanout1423 _07861_/B _08620_/A3 VDD VSS sg13g2_buf_1
Xfanout1434 _11936_/A _14978_/Q VDD VSS sg13g2_buf_1
Xfanout1445 _11843_/A _14975_/Q VDD VSS sg13g2_buf_1
Xfanout1456 _08427_/A1 _11706_/A VDD VSS sg13g2_buf_1
XFILLER_78_478 VDD VSS sg13g2_decap_8
Xfanout1467 _08276_/A _14967_/Q VDD VSS sg13g2_buf_1
Xfanout1478 _11483_/A _14964_/Q VDD VSS sg13g2_buf_1
Xfanout1489 _11384_/A _14960_/Q VDD VSS sg13g2_buf_1
XFILLER_47_843 VDD VSS sg13g2_decap_4
X_13964_ _13964_/Q clkload49/A _13964_/D _13964_/RESET_B VDD VSS sg13g2_dfrbpq_1
XFILLER_115_1191 VDD VSS sg13g2_decap_8
XFILLER_24_1085 VDD VSS sg13g2_decap_8
XFILLER_4_1146 VDD VSS sg13g2_decap_8
XFILLER_62_802 VDD VSS sg13g2_decap_4
XFILLER_74_662 VDD VSS sg13g2_decap_8
X_12915_ _12933_/A input33/X _12798_/Y _12914_/Y VDD VSS sg13g2_a21o_1
XFILLER_80_109 VDD VSS sg13g2_fill_2
XFILLER_47_898 VDD VSS sg13g2_fill_2
X_13895_ _13895_/Q clkload7/A _13895_/D _13895_/RESET_B VDD VSS sg13g2_dfrbpq_1
XFILLER_73_150 VDD VSS sg13g2_decap_4
XFILLER_59_1137 VDD VSS sg13g2_fill_2
XFILLER_98_1186 VDD VSS sg13g2_decap_8
XFILLER_0_79 VDD VSS sg13g2_decap_8
X_12846_ _12846_/Y _12821_/Y _12834_/Y _12833_/Y VDD VSS sg13g2_o21ai_1
X_12777_ wire367/A _13663_/Q _12791_/A2 _12776_/X _12415_/A _12791_/C1 VDD VSS sg13g2_a221oi_1
XFILLER_15_784 VDD VSS sg13g2_fill_2
XFILLER_30_721 VDD VSS sg13g2_fill_1
XFILLER_30_732 VDD VSS sg13g2_decap_8
XFILLER_14_283 VDD VSS sg13g2_fill_2
X_14516_ _14516_/Q clkload8/A _14516_/D _14516_/RESET_B VDD VSS sg13g2_dfrbpq_1
X_11728_ _11728_/Y _11773_/D _11728_/B VDD VSS sg13g2_xnor2_1
XFILLER_9_77 VDD VSS sg13g2_decap_8
XFILLER_30_765 VDD VSS sg13g2_decap_4
XFILLER_80_70 VDD VSS sg13g2_fill_1
X_14447_ _14447_/Q clkload11/A _14447_/D _14447_/RESET_B VDD VSS sg13g2_dfrbpq_1
X_11659_ _11702_/A _11661_/A _11724_/B VDD VSS sg13g2_nor2_1
XFILLER_80_92 VDD VSS sg13g2_fill_1
XFILLER_31_1023 VDD VSS sg13g2_decap_8
XFILLER_156_951 VDD VSS sg13g2_fill_1
XFILLER_122_1162 VDD VSS sg13g2_fill_1
XFILLER_128_653 VDD VSS sg13g2_decap_4
X_14378_ _14378_/Q _14506_/CLK _14378_/D _14378_/RESET_B VDD VSS sg13g2_dfrbpq_1
XFILLER_143_601 VDD VSS sg13g2_decap_8
XFILLER_115_314 VDD VSS sg13g2_fill_1
X_13329_ _13329_/Y _15173_/Q _13336_/S VDD VSS sg13g2_nand2b_1
Xmax_cap647 _09566_/S _09556_/S VDD VSS sg13g2_buf_4
Xmax_cap669 _09472_/S _09446_/S VDD VSS sg13g2_buf_4
X_08870_ _08870_/X _15031_/Q _10694_/S _08869_/Y VDD VSS sg13g2_a21o_1
XFILLER_111_531 VDD VSS sg13g2_decap_8
XFILLER_9_1057 VDD VSS sg13g2_decap_8
XFILLER_29_0 VDD VSS sg13g2_decap_8
XFILLER_57_607 VDD VSS sg13g2_fill_1
X_07821_ _07822_/B _15009_/Q _07821_/B VDD VSS sg13g2_and2_1
XFILLER_69_478 VDD VSS sg13g2_decap_8
XFILLER_38_810 VDD VSS sg13g2_decap_4
XFILLER_96_275 VDD VSS sg13g2_decap_8
X_07752_ _07752_/Y _10935_/A _10510_/B _13308_/B _10671_/B VDD VSS sg13g2_nand4_1
XFILLER_42_1174 VDD VSS sg13g2_fill_1
XFILLER_65_651 VDD VSS sg13g2_fill_1
XFILLER_77_1204 VDD VSS sg13g2_decap_4
XFILLER_77_1226 VDD VSS sg13g2_decap_8
X_07683_ _07683_/X _11243_/B _13289_/C VDD VSS sg13g2_or2_1
X_09422_ _14024_/D _09655_/A0 _14024_/Q _09424_/S VDD VSS sg13g2_mux2_1
XFILLER_80_632 VDD VSS sg13g2_fill_2
XFILLER_25_548 VDD VSS sg13g2_fill_1
X_09353_ _13957_/D _09850_/A1 _13957_/Q _09371_/S VDD VSS sg13g2_mux2_1
XFILLER_52_378 VDD VSS sg13g2_fill_1
XFILLER_40_529 VDD VSS sg13g2_decap_8
XFILLER_33_570 VDD VSS sg13g2_decap_4
X_08304_ _08304_/Y _08306_/C _08306_/B VDD VSS sg13g2_nand2_1
X_09284_ _13892_/D _13892_/Q _09915_/A1 wire496/X VDD VSS sg13g2_mux2_1
XFILLER_127_1073 VDD VSS sg13g2_decap_8
Xclkbuf_5_24__f_clk_i clkbuf_leaf_87_clk_i/A clkbuf_4_12_0_clk_i/X VDD VSS sg13g2_buf_16
X_08235_ _08235_/X _08278_/A3 _14962_/Q _07768_/A _08235_/A3 _08235_/S0 _08048_/A
+ VDD VSS sg13g2_mux4_1
XFILLER_14_1232 VDD VSS sg13g2_decap_4
XFILLER_147_951 VDD VSS sg13g2_decap_8
X_08166_ _15222_/D _08166_/A _08166_/B _08166_/C VDD VSS sg13g2_nand3_1
XFILLER_106_303 VDD VSS sg13g2_fill_1
XFILLER_10_1129 VDD VSS sg13g2_decap_8
X_08097_ _08098_/B _08213_/S _08094_/X _08096_/X VDD VSS sg13g2_a21oi_1
XFILLER_106_325 VDD VSS sg13g2_fill_2
XFILLER_107_7 VDD VSS sg13g2_decap_8
XFILLER_133_144 VDD VSS sg13g2_fill_1
XFILLER_133_166 VDD VSS sg13g2_decap_8
XFILLER_133_177 VDD VSS sg13g2_fill_2
Xhold3520 hold3520/X _13710_/Q VDD VSS sg13g2_dlygate4sd3_1
XFILLER_88_721 VDD VSS sg13g2_fill_2
XFILLER_115_881 VDD VSS sg13g2_fill_2
XFILLER_134_1000 VDD VSS sg13g2_fill_2
Xhold3531 _11102_/A _14949_/Q VDD VSS sg13g2_dlygate4sd3_1
XFILLER_138_1180 VDD VSS sg13g2_decap_4
XFILLER_87_242 VDD VSS sg13g2_decap_8
XFILLER_125_55 VDD VSS sg13g2_fill_1
XFILLER_48_618 VDD VSS sg13g2_decap_8
XFILLER_48_629 VDD VSS sg13g2_fill_1
XFILLER_60_1230 VDD VSS sg13g2_decap_8
X_08999_ _08999_/Y _14900_/Q _08993_/X _09024_/A VDD VSS sg13g2_o21ai_1
XFILLER_75_415 VDD VSS sg13g2_fill_1
XFILLER_87_275 VDD VSS sg13g2_decap_8
XFILLER_29_821 VDD VSS sg13g2_fill_2
XFILLER_102_597 VDD VSS sg13g2_decap_8
XFILLER_18_42 VDD VSS sg13g2_decap_8
XFILLER_141_21 VDD VSS sg13g2_decap_8
XFILLER_21_1236 VDD VSS sg13g2_fill_1
X_13859__2705 _13859_/RESET_B VDD VSS sg13g2_tiehi
XFILLER_56_662 VDD VSS sg13g2_decap_8
X_10961_ _11009_/A _14759_/Q _10965_/B VDD VSS sg13g2_nand2b_1
XFILLER_28_375 VDD VSS sg13g2_fill_2
XFILLER_44_824 VDD VSS sg13g2_fill_2
XFILLER_71_610 VDD VSS sg13g2_decap_8
X_12700_ _12700_/X _14708_/Q _14740_/Q _13780_/Q _13812_/Q _12703_/S0 _12703_/S1 VDD
+ VSS sg13g2_mux4_1
X_13680_ _13680_/Q clkload64/A _13680_/D _13680_/RESET_B VDD VSS sg13g2_dfrbpq_1
XFILLER_141_98 VDD VSS sg13g2_decap_8
X_10892_ _10893_/B _10879_/Y _10863_/X _10880_/Y VDD VSS sg13g2_a21oi_1
X_15130__3082 _15130_/RESET_B VDD VSS sg13g2_tiehi
XFILLER_19_1121 VDD VSS sg13g2_decap_8
X_12631_ _12631_/X _13743_/Q _14095_/Q _14447_/Q _14543_/Q _12686_/S0 _12686_/S1 VDD
+ VSS sg13g2_mux4_1
XFILLER_93_1050 VDD VSS sg13g2_decap_8
XFILLER_43_378 VDD VSS sg13g2_decap_8
XFILLER_12_710 VDD VSS sg13g2_decap_8
XFILLER_71_698 VDD VSS sg13g2_decap_8
X_12562_ _12562_/X _13738_/Q _14090_/Q _14442_/Q _14538_/Q _12564_/S0 _12564_/S1 VDD
+ VSS sg13g2_mux4_1
X_14239__2325 _14239_/RESET_B VDD VSS sg13g2_tiehi
XFILLER_19_1198 VDD VSS sg13g2_decap_8
X_14301_ _14301_/Q _14525_/CLK _14301_/D _14301_/RESET_B VDD VSS sg13g2_dfrbpq_1
XFILLER_156_214 VDD VSS sg13g2_decap_4
X_11513_ _11513_/X _14115_/Q _14147_/Q _14179_/Q _14211_/Q _11514_/S0 _11715_/S1 VDD
+ VSS sg13g2_mux4_1
XFILLER_141_1048 VDD VSS sg13g2_fill_1
X_12493_ _12493_/X _14117_/Q _14149_/Q _14181_/Q _14213_/Q _12494_/S0 _12494_/S1 VDD
+ VSS sg13g2_mux4_1
Xwire144 wire144/X wire144/A VDD VSS sg13g2_buf_2
X_14232_ _14232_/Q clkload32/A _14232_/D _14232_/RESET_B VDD VSS sg13g2_dfrbpq_1
XFILLER_7_257 VDD VSS sg13g2_fill_1
X_11444_ _11444_/X _14688_/Q _14720_/Q _13760_/Q _13792_/Q _12100_/S0 _12026_/C VDD
+ VSS sg13g2_mux4_1
XFILLER_152_420 VDD VSS sg13g2_decap_8
X_14163_ _14163_/Q clkload10/A _14163_/D _14163_/RESET_B VDD VSS sg13g2_dfrbpq_1
XFILLER_109_185 VDD VSS sg13g2_decap_4
X_11375_ _11375_/Y _11370_/Y _11371_/Y _11875_/B VDD VSS sg13g2_a21oi_1
X_14454__2110 _14454_/RESET_B VDD VSS sg13g2_tiehi
XFILLER_113_807 VDD VSS sg13g2_decap_4
XFILLER_152_453 VDD VSS sg13g2_decap_8
X_13114_ _13116_/B _13092_/C _13172_/C VDD VSS sg13g2_nand2b_1
XFILLER_124_144 VDD VSS sg13g2_decap_8
XFILLER_152_464 VDD VSS sg13g2_fill_2
X_10326_ _10345_/C _14799_/Q _14800_/Q _14801_/Q _14802_/Q VDD VSS sg13g2_and4_1
X_14094_ _14094_/Q _14670_/CLK _14094_/D _14094_/RESET_B VDD VSS sg13g2_dfrbpq_1
XFILLER_4_986 VDD VSS sg13g2_decap_8
XFILLER_140_648 VDD VSS sg13g2_decap_8
X_13045_ _13050_/C _13045_/A1 _13044_/Y _12914_/C VDD VSS sg13g2_a21oi_1
XFILLER_124_199 VDD VSS sg13g2_decap_8
X_10257_ _10268_/D _14779_/Q _14780_/Q _14781_/Q _10258_/D VDD VSS sg13g2_and4_1
XFILLER_26_1114 VDD VSS sg13g2_decap_8
XFILLER_152_1133 VDD VSS sg13g2_decap_8
XFILLER_65_1185 VDD VSS sg13g2_decap_8
Xfanout1220 _11236_/A _07682_/A VDD VSS sg13g2_buf_1
XFILLER_6_1208 VDD VSS sg13g2_decap_8
XFILLER_121_862 VDD VSS sg13g2_decap_8
XFILLER_22_7 VDD VSS sg13g2_decap_8
Xfanout1231 _07737_/B _12403_/A2 VDD VSS sg13g2_buf_1
X_10188_ _14751_/D _15194_/D _14751_/Q _10206_/S VDD VSS sg13g2_mux2_1
Xfanout1242 _13601_/B _15203_/Q VDD VSS sg13g2_buf_1
XFILLER_67_938 VDD VSS sg13g2_fill_2
Xfanout1253 _13389_/B _10201_/A1 VDD VSS sg13g2_buf_1
XFILLER_67_949 VDD VSS sg13g2_fill_1
Xfanout1264 _13249_/B _15108_/Q VDD VSS sg13g2_buf_1
X_14487__2077 _14487_/RESET_B VDD VSS sg13g2_tiehi
Xfanout1275 _13273_/B _15107_/Q VDD VSS sg13g2_buf_1
XFILLER_8_1090 VDD VSS sg13g2_decap_8
Xfanout1286 _08183_/A _13427_/C VDD VSS sg13g2_buf_1
XFILLER_94_757 VDD VSS sg13g2_fill_2
X_14996_ _14996_/Q _15001_/CLK _14996_/D _14996_/RESET_B VDD VSS sg13g2_dfrbpq_1
XFILLER_82_908 VDD VSS sg13g2_decap_4
XFILLER_93_245 VDD VSS sg13g2_decap_8
Xfanout1297 _13279_/B fanout1298/X VDD VSS sg13g2_buf_1
XFILLER_93_256 VDD VSS sg13g2_fill_2
X_13947_ _13947_/Q clkload60/A _13947_/D _13947_/RESET_B VDD VSS sg13g2_dfrbpq_1
XFILLER_90_941 VDD VSS sg13g2_fill_2
X_13878_ _13878_/Q clkload24/A _13878_/D _13878_/RESET_B VDD VSS sg13g2_dfrbpq_1
XFILLER_61_142 VDD VSS sg13g2_decap_8
XFILLER_90_985 VDD VSS sg13g2_decap_4
X_12829_ _12829_/Y _14865_/Q _12862_/B VDD VSS sg13g2_nand2_1
XFILLER_34_389 VDD VSS sg13g2_fill_2
X_14664__1900 _14664_/RESET_B VDD VSS sg13g2_tiehi
X_08020_ _08021_/A _08213_/S _08018_/X _08019_/X VDD VSS sg13g2_a21oi_1
XFILLER_129_962 VDD VSS sg13g2_decap_4
X_14093__2471 _14093_/RESET_B VDD VSS sg13g2_tiehi
XFILLER_129_984 VDD VSS sg13g2_fill_2
Xmax_cap400 _10099_/S _10083_/S VDD VSS sg13g2_buf_4
XFILLER_116_623 VDD VSS sg13g2_decap_8
XFILLER_116_634 VDD VSS sg13g2_fill_2
XFILLER_155_280 VDD VSS sg13g2_decap_8
XFILLER_143_420 VDD VSS sg13g2_decap_4
Xmax_cap433 _09870_/S _09844_/S VDD VSS sg13g2_buf_4
XFILLER_89_507 VDD VSS sg13g2_fill_1
Xmax_cap466 _09631_/S _09622_/S VDD VSS sg13g2_buf_4
X_13937__2627 _13937_/RESET_B VDD VSS sg13g2_tiehi
X_14697__1867 _14697_/RESET_B VDD VSS sg13g2_tiehi
XFILLER_89_518 VDD VSS sg13g2_decap_4
XFILLER_118_1006 VDD VSS sg13g2_decap_8
X_09971_ _09971_/Y _10070_/A _09971_/B _10070_/C VDD VSS sg13g2_nand3_1
XFILLER_131_615 VDD VSS sg13g2_fill_1
X_15032__2940 _15032_/RESET_B VDD VSS sg13g2_tiehi
X_08922_ _08922_/X _08921_/X _11983_/A _08955_/S VDD VSS sg13g2_mux2_1
XFILLER_69_220 VDD VSS sg13g2_fill_2
X_08853_ _08853_/X _15026_/Q _10691_/S _08852_/Y VDD VSS sg13g2_a21o_1
X_07804_ _07807_/C _08456_/C _07804_/B VDD VSS sg13g2_nand2b_1
X_14317__2247 _14317_/RESET_B VDD VSS sg13g2_tiehi
XFILLER_57_459 VDD VSS sg13g2_decap_4
X_08784_ _08784_/Y _13680_/Q _08787_/B VDD VSS sg13g2_nor2_1
XFILLER_84_256 VDD VSS sg13g2_decap_4
X_07735_ _07744_/B _15217_/D _07735_/B _07735_/C _07735_/D VDD VSS sg13g2_or4_1
XFILLER_26_868 VDD VSS sg13g2_fill_2
X_07666_ _07708_/A _13613_/A _15055_/Q VDD VSS sg13g2_nor2_1
X_09405_ _14008_/D _09836_/A0 _14008_/Q _09407_/S VDD VSS sg13g2_mux2_1
XFILLER_13_507 VDD VSS sg13g2_decap_8
XFILLER_53_676 VDD VSS sg13g2_decap_8
XFILLER_77_1078 VDD VSS sg13g2_fill_1
XFILLER_129_1146 VDD VSS sg13g2_fill_2
X_14532__2032 _14532_/RESET_B VDD VSS sg13g2_tiehi
XFILLER_52_164 VDD VSS sg13g2_fill_2
XFILLER_40_326 VDD VSS sg13g2_decap_8
XFILLER_71_28 VDD VSS sg13g2_decap_8
X_09336_ _13943_/D _10166_/A1 _13943_/Q _09336_/S VDD VSS sg13g2_mux2_1
XFILLER_21_551 VDD VSS sg13g2_fill_1
X_14786__3312 _14786_/RESET_B VDD VSS sg13g2_tiehi
XFILLER_21_573 VDD VSS sg13g2_decap_8
X_09267_ _13876_/D _13876_/Q _10030_/A0 _09270_/S VDD VSS sg13g2_mux2_1
X_08218_ _08319_/A _08219_/A _13545_/A VDD VSS sg13g2_nor2_1
X_09198_ _13814_/D _13814_/Q _10132_/A0 _09198_/S VDD VSS sg13g2_mux2_1
XFILLER_119_461 VDD VSS sg13g2_fill_2
XFILLER_153_217 VDD VSS sg13g2_decap_8
XFILLER_135_932 VDD VSS sg13g2_decap_8
XFILLER_5_739 VDD VSS sg13g2_fill_1
XFILLER_20_21 VDD VSS sg13g2_decap_8
X_08149_ _08149_/Y _13525_/A _08011_/X _08688_/A VDD VSS sg13g2_o21ai_1
XFILLER_107_634 VDD VSS sg13g2_fill_2
XFILLER_101_1054 VDD VSS sg13g2_fill_1
XFILLER_136_21 VDD VSS sg13g2_decap_8
XFILLER_150_913 VDD VSS sg13g2_decap_4
XFILLER_134_464 VDD VSS sg13g2_decap_8
X_11160_ _11161_/A _11150_/B _11150_/A _11159_/Y VDD VSS sg13g2_o21ai_1
XFILLER_150_935 VDD VSS sg13g2_decap_8
X_10111_ _14689_/D _10144_/A1 _14689_/Q _10134_/S VDD VSS sg13g2_mux2_1
XFILLER_0_422 VDD VSS sg13g2_decap_4
X_11091_ _11094_/B _11091_/A _11091_/B VDD VSS sg13g2_nand2_1
X_10042_ _14623_/D _10075_/A0 _14623_/Q _10061_/S VDD VSS sg13g2_mux2_1
XFILLER_88_562 VDD VSS sg13g2_decap_8
XFILLER_1_989 VDD VSS sg13g2_decap_8
X_13791__2773 _13791_/RESET_B VDD VSS sg13g2_tiehi
XFILLER_152_42 VDD VSS sg13g2_decap_8
X_14850_ _14850_/Q _14854_/CLK _14850_/D _14850_/RESET_B VDD VSS sg13g2_dfrbpq_1
X_14742__1822 _14742_/RESET_B VDD VSS sg13g2_tiehi
XFILLER_57_960 VDD VSS sg13g2_decap_4
X_13801_ _13801_/Q _14633_/CLK _13801_/D _13801_/RESET_B VDD VSS sg13g2_dfrbpq_1
XFILLER_21_1033 VDD VSS sg13g2_decap_8
XFILLER_91_727 VDD VSS sg13g2_decap_4
X_14781_ _14781_/Q clkload77/A _14781_/D _14781_/RESET_B VDD VSS sg13g2_dfrbpq_1
XFILLER_95_1112 VDD VSS sg13g2_decap_4
X_11993_ _11993_/X _14257_/Q _14289_/Q _14321_/Q _14353_/Q _11997_/S0 _11997_/S1 VDD
+ VSS sg13g2_mux4_1
XFILLER_147_1202 VDD VSS sg13g2_decap_8
X_13732_ _13732_/Q clkload23/A _13732_/D _13732_/RESET_B VDD VSS sg13g2_dfrbpq_1
XFILLER_112_1194 VDD VSS sg13g2_decap_4
X_10944_ _10944_/Y _10948_/C _10948_/D VDD VSS sg13g2_nor2_1
XFILLER_95_1145 VDD VSS sg13g2_decap_8
X_14171__2393 _14171_/RESET_B VDD VSS sg13g2_tiehi
XFILLER_95_1156 VDD VSS sg13g2_fill_1
XFILLER_16_356 VDD VSS sg13g2_fill_1
XFILLER_95_1167 VDD VSS sg13g2_fill_2
XFILLER_31_304 VDD VSS sg13g2_decap_8
XFILLER_71_473 VDD VSS sg13g2_decap_8
X_13663_ _13663_/Q _15214_/CLK _13663_/D _13663_/RESET_B VDD VSS sg13g2_dfrbpq_1
XFILLER_44_698 VDD VSS sg13g2_fill_1
X_10875_ _10875_/Y _10875_/A _10903_/B VDD VSS sg13g2_nand2_1
X_12614_ _12614_/X _13966_/Q _13998_/Q _14030_/Q _14062_/Q _12617_/S0 _12617_/S1 VDD
+ VSS sg13g2_mux4_1
X_13594_ _15163_/D _13570_/S _13592_/Y _13593_/Y VDD VSS sg13g2_a21oi_1
XFILLER_8_511 VDD VSS sg13g2_decap_8
XFILLER_61_50 VDD VSS sg13g2_decap_4
X_12545_ _12545_/X _14377_/Q _14409_/Q _14473_/Q _14505_/Q _12550_/S0 _12550_/S1 VDD
+ VSS sg13g2_mux4_1
XFILLER_8_566 VDD VSS sg13g2_decap_8
X_12476_ _12476_/X _14244_/Q _14276_/Q _14308_/Q _14340_/Q _12752_/S0 _12757_/S1 VDD
+ VSS sg13g2_mux4_1
XFILLER_8_577 VDD VSS sg13g2_fill_2
XFILLER_8_588 VDD VSS sg13g2_decap_8
XFILLER_8_599 VDD VSS sg13g2_fill_2
X_14215_ _14215_/Q _14725_/CLK _14215_/D _14215_/RESET_B VDD VSS sg13g2_dfrbpq_1
XANTENNA_5 _16862_/A VDD VSS sg13g2_antennanp
X_11427_ _11427_/X _11428_/A _13689_/Q VDD VSS sg13g2_and2_1
XFILLER_6_56 VDD VSS sg13g2_decap_8
X_15195_ _15195_/Q clkload63/A _15195_/D _15195_/RESET_B VDD VSS sg13g2_dfrbpq_1
XFILLER_126_954 VDD VSS sg13g2_decap_8
XFILLER_137_291 VDD VSS sg13g2_decap_8
XFILLER_67_1225 VDD VSS sg13g2_decap_8
XFILLER_67_1236 VDD VSS sg13g2_fill_1
XFILLER_141_913 VDD VSS sg13g2_decap_8
X_14146_ _14146_/Q clkload6/A _14146_/D _14146_/RESET_B VDD VSS sg13g2_dfrbpq_1
X_11358_ _11359_/A _13726_/Q _14078_/Q _14430_/Q _14526_/Q _11373_/A _11374_/C VDD
+ VSS sg13g2_mux4_1
XFILLER_98_326 VDD VSS sg13g2_decap_8
XFILLER_140_423 VDD VSS sg13g2_decap_8
X_10309_ _10312_/B _14796_/Q _10327_/B _14797_/Q VDD VSS sg13g2_a21oi_1
X_14077_ _14077_/Q clkload52/A _14077_/D _14077_/RESET_B VDD VSS sg13g2_dfrbpq_1
X_11289_ _11289_/Y _14895_/Q _12338_/A2 _07684_/B VDD VSS sg13g2_a21oi_1
XFILLER_140_467 VDD VSS sg13g2_decap_8
XFILLER_112_158 VDD VSS sg13g2_fill_1
X_13028_ _13028_/Y _14877_/Q _13028_/B VDD VSS sg13g2_nand2_1
XFILLER_67_702 VDD VSS sg13g2_decap_8
XFILLER_100_309 VDD VSS sg13g2_fill_2
XFILLER_39_404 VDD VSS sg13g2_fill_1
XFILLER_39_426 VDD VSS sg13g2_decap_4
Xfanout1050 _12497_/S _12692_/S VDD VSS sg13g2_buf_1
XFILLER_67_746 VDD VSS sg13g2_fill_1
Xfanout1061 _12355_/S _12789_/S1 VDD VSS sg13g2_buf_1
X_14864__3201 _14864_/RESET_B VDD VSS sg13g2_tiehi
Xfanout1072 _12595_/S _12790_/S VDD VSS sg13g2_buf_1
XFILLER_82_738 VDD VSS sg13g2_decap_4
X_14979_ _14979_/Q clkload48/A _14979_/D _14979_/RESET_B VDD VSS sg13g2_dfrbpq_1
XFILLER_62_440 VDD VSS sg13g2_fill_2
XFILLER_74_1207 VDD VSS sg13g2_fill_1
X_14001__2563 _14001_/RESET_B VDD VSS sg13g2_tiehi
XFILLER_35_665 VDD VSS sg13g2_decap_4
XFILLER_50_602 VDD VSS sg13g2_fill_1
XFILLER_63_985 VDD VSS sg13g2_decap_8
XFILLER_90_771 VDD VSS sg13g2_decap_8
X_14897__3135 _14897_/RESET_B VDD VSS sg13g2_tiehi
XFILLER_23_849 VDD VSS sg13g2_decap_8
XFILLER_62_484 VDD VSS sg13g2_fill_2
XFILLER_96_0 VDD VSS sg13g2_decap_4
X_14605__1959 _14605_/RESET_B VDD VSS sg13g2_tiehi
XFILLER_148_523 VDD VSS sg13g2_fill_2
XFILLER_37_1084 VDD VSS sg13g2_decap_8
X_09121_ _10767_/B _09161_/S _15046_/Q _09120_/Y VDD VSS sg13g2_o21ai_1
XFILLER_148_545 VDD VSS sg13g2_decap_4
X_09052_ _13769_/D _13769_/Q _10152_/A1 _09146_/S VDD VSS sg13g2_mux2_1
XFILLER_117_921 VDD VSS sg13g2_fill_1
XFILLER_11_1224 VDD VSS sg13g2_decap_8
X_08003_ _08003_/Y wire145/A _15131_/Q _13290_/A VDD VSS sg13g2_nand3_1
XFILLER_11_1235 VDD VSS sg13g2_fill_2
XFILLER_132_913 VDD VSS sg13g2_decap_8
XFILLER_89_315 VDD VSS sg13g2_decap_4
XFILLER_116_475 VDD VSS sg13g2_decap_8
XFILLER_103_114 VDD VSS sg13g2_decap_8
X_09954_ _14538_/D _14538_/Q _10086_/A0 _09954_/S VDD VSS sg13g2_mux2_1
XFILLER_104_659 VDD VSS sg13g2_decap_8
XFILLER_131_434 VDD VSS sg13g2_fill_1
XFILLER_131_445 VDD VSS sg13g2_decap_8
X_08905_ _13709_/D _13709_/Q _08904_/X _08926_/S VDD VSS sg13g2_mux2_1
XFILLER_83_1082 VDD VSS sg13g2_decap_4
X_09885_ _14471_/D _09918_/A1 _14471_/Q _09898_/S VDD VSS sg13g2_mux2_1
XFILLER_98_893 VDD VSS sg13g2_decap_8
XFILLER_112_670 VDD VSS sg13g2_fill_1
XFILLER_135_1172 VDD VSS sg13g2_fill_1
XFILLER_131_1003 VDD VSS sg13g2_decap_4
XFILLER_66_28 VDD VSS sg13g2_decap_8
XFILLER_112_692 VDD VSS sg13g2_fill_1
X_08836_ _08836_/Y _11335_/A _08871_/S VDD VSS sg13g2_nand2_1
XFILLER_100_854 VDD VSS sg13g2_decap_8
XFILLER_44_1099 VDD VSS sg13g2_fill_2
XFILLER_131_1058 VDD VSS sg13g2_decap_8
XFILLER_73_738 VDD VSS sg13g2_decap_4
X_08767_ _08767_/Y _08779_/A1 _14760_/Q _15188_/Q _07719_/X VDD VSS sg13g2_a22oi_1
XFILLER_39_993 VDD VSS sg13g2_decap_8
X_07718_ _08027_/B _15102_/Q _15101_/Q _15094_/Q _15093_/Q VDD VSS sg13g2_or4_1
X_08698_ _08698_/X _08698_/A _08698_/B VDD VSS sg13g2_and2_1
XFILLER_53_440 VDD VSS sg13g2_fill_2
XFILLER_14_816 VDD VSS sg13g2_decap_4
XFILLER_54_996 VDD VSS sg13g2_decap_8
XFILLER_15_21 VDD VSS sg13g2_decap_8
X_07649_ _07649_/Y _11179_/B VDD VSS sg13g2_inv_1
X_10660_ _10661_/C _14892_/Q _14891_/Q _10663_/D VDD VSS sg13g2_and3_1
XFILLER_139_512 VDD VSS sg13g2_fill_2
XFILLER_139_523 VDD VSS sg13g2_fill_2
XFILLER_15_98 VDD VSS sg13g2_decap_4
XFILLER_55_1173 VDD VSS sg13g2_decap_8
X_09319_ _13926_/D _10082_/A0 _13926_/Q _09336_/S VDD VSS sg13g2_mux2_1
XFILLER_90_1064 VDD VSS sg13g2_decap_8
XFILLER_142_1143 VDD VSS sg13g2_decap_4
XFILLER_16_1146 VDD VSS sg13g2_decap_8
XFILLER_142_1154 VDD VSS sg13g2_fill_1
X_10591_ _10607_/C _14874_/Q _12963_/A _10591_/C _10591_/D VDD VSS sg13g2_and4_1
XFILLER_51_1059 VDD VSS sg13g2_decap_8
X_12330_ _12330_/X _14714_/Q _14746_/Q _13786_/Q _13818_/Q _11804_/A _11805_/C VDD
+ VSS sg13g2_mux4_1
XFILLER_31_42 VDD VSS sg13g2_fill_2
XFILLER_108_921 VDD VSS sg13g2_decap_8
XFILLER_147_42 VDD VSS sg13g2_decap_8
X_12261_ _12261_/Y _12237_/Y _12239_/Y _11747_/A VDD VSS sg13g2_a21oi_1
X_14000_ _14000_/Q clkload49/A _14000_/D _14000_/RESET_B VDD VSS sg13g2_dfrbpq_1
X_11212_ _11212_/X _14171_/Q _14203_/Q _11212_/S VDD VSS sg13g2_mux2_1
X_12192_ _12192_/Y _12192_/A _12192_/B VDD VSS sg13g2_nor2_1
Xoutput42 mem_axi_araddr[13] _16866_/A VDD VSS sg13g2_buf_1
Xoutput53 mem_axi_araddr[24] output53/A VDD VSS sg13g2_buf_1
XFILLER_150_743 VDD VSS sg13g2_decap_4
X_14189__2375 _14189_/RESET_B VDD VSS sg13g2_tiehi
X_11143_ _11143_/Y _11143_/A _11170_/B VDD VSS sg13g2_nand2_1
Xoutput64 mem_axi_araddr[5] _16858_/A VDD VSS sg13g2_buf_1
XFILLER_123_968 VDD VSS sg13g2_decap_8
Xoutput75 mem_axi_awaddr[14] _16867_/X VDD VSS sg13g2_buf_1
XFILLER_0_230 VDD VSS sg13g2_decap_4
XFILLER_110_607 VDD VSS sg13g2_decap_8
Xoutput86 mem_axi_awaddr[25] _16878_/X VDD VSS sg13g2_buf_1
Xoutput97 mem_axi_awaddr[6] _16859_/X VDD VSS sg13g2_buf_1
XFILLER_62_1133 VDD VSS sg13g2_fill_1
XFILLER_110_618 VDD VSS sg13g2_fill_1
X_11074_ _11074_/Y _14947_/Q _11074_/B VDD VSS sg13g2_nand2_1
XFILLER_49_735 VDD VSS sg13g2_fill_1
XFILLER_62_1166 VDD VSS sg13g2_fill_2
XFILLER_114_1234 VDD VSS sg13g2_fill_2
X_14902_ _14902_/Q _15229_/CLK _14902_/D _14902_/RESET_B VDD VSS sg13g2_dfrbpq_1
X_10025_ _14607_/D _10091_/A0 _14607_/Q _10029_/S VDD VSS sg13g2_mux2_1
XFILLER_48_256 VDD VSS sg13g2_decap_8
XFILLER_36_407 VDD VSS sg13g2_decap_4
XFILLER_91_513 VDD VSS sg13g2_decap_8
X_14833_ _14833_/Q clkload80/A _14833_/D _14833_/RESET_B VDD VSS sg13g2_dfrbpq_1
XFILLER_17_621 VDD VSS sg13g2_fill_2
X_14764_ _14764_/Q clkload21/A _14764_/D _14764_/RESET_B VDD VSS sg13g2_dfrbpq_1
XFILLER_16_131 VDD VSS sg13g2_decap_4
XFILLER_63_259 VDD VSS sg13g2_decap_8
X_11976_ _11976_/Y _11975_/Y _11965_/Y _11957_/Y _11947_/Y _12292_/A VDD VSS sg13g2_a221oi_1
XFILLER_147_1032 VDD VSS sg13g2_decap_8
X_13715_ _16877_/A _15046_/CLK _13715_/D _13715_/RESET_B VDD VSS sg13g2_dfrbpq_1
XFILLER_72_771 VDD VSS sg13g2_fill_2
X_10927_ _10927_/Y _11044_/C _10936_/C _10939_/B1 VDD VSS sg13g2_o21ai_1
X_14695_ _14695_/Q clkload10/A _14695_/D _14695_/RESET_B VDD VSS sg13g2_dfrbpq_1
XFILLER_16_186 VDD VSS sg13g2_fill_2
XFILLER_108_1016 VDD VSS sg13g2_fill_2
XFILLER_16_197 VDD VSS sg13g2_decap_4
XFILLER_71_292 VDD VSS sg13g2_fill_2
XFILLER_108_1027 VDD VSS sg13g2_fill_2
X_14996__2976 _14996_/RESET_B VDD VSS sg13g2_tiehi
X_13646_ _13754_/D _13646_/A VDD VSS sg13g2_buf_1
X_10858_ _10858_/Y _10885_/A1 _10852_/X _10797_/C VDD VSS sg13g2_o21ai_1
XFILLER_34_1213 VDD VSS sg13g2_decap_8
XFILLER_20_819 VDD VSS sg13g2_fill_1
X_13577_ _13577_/Y _14999_/Q _13589_/A2 _13569_/S _15015_/Q _13525_/X VDD VSS sg13g2_a221oi_1
XFILLER_9_842 VDD VSS sg13g2_fill_2
X_10789_ _11185_/B _10757_/A _09155_/Y _08949_/Y VDD VSS sg13g2_o21ai_1
XFILLER_9_853 VDD VSS sg13g2_fill_1
XFILLER_9_864 VDD VSS sg13g2_fill_1
X_12528_ _12541_/A _10213_/A _07737_/B _15002_/Q VDD VSS sg13g2_a21oi_1
XFILLER_8_352 VDD VSS sg13g2_decap_8
XFILLER_145_515 VDD VSS sg13g2_fill_1
XFILLER_145_526 VDD VSS sg13g2_decap_8
XFILLER_8_363 VDD VSS sg13g2_fill_1
X_15247_ _15247_/Q _15248_/CLK _15247_/D _15247_/RESET_B VDD VSS sg13g2_dfrbpq_1
X_12459_ _12459_/X _13827_/Q _13859_/Q _13891_/Q _13923_/Q _12464_/S0 _12546_/S1 VDD
+ VSS sg13g2_mux4_1
XFILLER_67_1000 VDD VSS sg13g2_decap_8
X_15178_ _15178_/Q _15178_/CLK _15178_/D _15178_/RESET_B VDD VSS sg13g2_dfrbpq_1
XFILLER_119_1112 VDD VSS sg13g2_decap_8
X_14129_ _14129_/Q clkload44/A _14129_/D _14129_/RESET_B VDD VSS sg13g2_dfrbpq_1
X_14019__2545 _14019_/RESET_B VDD VSS sg13g2_tiehi
X_13854__2710 _13854_/RESET_B VDD VSS sg13g2_tiehi
Xfanout309 _10063_/S fanout315/X VDD VSS sg13g2_buf_1
XFILLER_87_819 VDD VSS sg13g2_fill_2
XFILLER_154_1069 VDD VSS sg13g2_fill_2
XFILLER_140_286 VDD VSS sg13g2_decap_8
X_09670_ _14263_/D _10166_/A1 _14263_/Q wire639/A VDD VSS sg13g2_mux2_1
XFILLER_11_0 VDD VSS sg13g2_decap_8
X_08621_ _08622_/B _08621_/A _08621_/B _08621_/C VDD VSS sg13g2_nor3_1
X_14234__2330 _14234_/RESET_B VDD VSS sg13g2_tiehi
X_13887__2677 _13887_/RESET_B VDD VSS sg13g2_tiehi
XFILLER_82_546 VDD VSS sg13g2_decap_8
X_08552_ _08553_/B _08497_/A _08551_/X _08547_/Y _08546_/Y VDD VSS sg13g2_a22oi_1
XFILLER_78_1140 VDD VSS sg13g2_fill_2
XFILLER_70_719 VDD VSS sg13g2_fill_2
XFILLER_35_451 VDD VSS sg13g2_fill_2
Xclkbuf_4_12_0_clk_i clkbuf_4_12_0_clk_i/X clkbuf_0_clk_i/X VDD VSS sg13g2_buf_8
XFILLER_23_613 VDD VSS sg13g2_fill_1
XFILLER_39_1146 VDD VSS sg13g2_decap_8
X_08483_ _08501_/A _08201_/A _08150_/X _08518_/B1 VDD VSS sg13g2_o21ai_1
XFILLER_11_819 VDD VSS sg13g2_fill_2
XFILLER_149_821 VDD VSS sg13g2_decap_4
X_14267__2297 _14267_/RESET_B VDD VSS sg13g2_tiehi
XFILLER_22_178 VDD VSS sg13g2_decap_8
XFILLER_50_487 VDD VSS sg13g2_fill_1
X_09104_ _09104_/X _13142_/A _09136_/B _09102_/Y VDD VSS sg13g2_a21o_1
XFILLER_148_397 VDD VSS sg13g2_decap_4
XFILLER_11_1021 VDD VSS sg13g2_fill_2
X_09035_ _09035_/Y _14906_/Q _09031_/C _09024_/A VDD VSS sg13g2_o21ai_1
XFILLER_117_762 VDD VSS sg13g2_fill_1
XFILLER_105_924 VDD VSS sg13g2_decap_4
XFILLER_137_1201 VDD VSS sg13g2_fill_1
XFILLER_89_101 VDD VSS sg13g2_decap_4
X_14482__2082 _14482_/RESET_B VDD VSS sg13g2_tiehi
XFILLER_11_1098 VDD VSS sg13g2_decap_8
XFILLER_46_1117 VDD VSS sg13g2_fill_1
XFILLER_105_968 VDD VSS sg13g2_fill_1
XFILLER_117_67 VDD VSS sg13g2_decap_8
Xfanout821 _13045_/A1 _13600_/B VDD VSS sg13g2_buf_1
Xfanout832 _11792_/B _12338_/A2 VDD VSS sg13g2_buf_1
X_09937_ _14522_/D _14522_/Q _10136_/A0 _09937_/S VDD VSS sg13g2_mux2_1
XFILLER_77_329 VDD VSS sg13g2_decap_4
Xfanout843 _13294_/B wire844/A VDD VSS sg13g2_buf_1
XFILLER_133_11 VDD VSS sg13g2_decap_8
Xfanout854 _10752_/A _10757_/A VDD VSS sg13g2_buf_1
Xfanout865 _08848_/A fanout866/X VDD VSS sg13g2_buf_1
XFILLER_58_543 VDD VSS sg13g2_decap_4
Xfanout876 _08835_/B _08828_/Y VDD VSS sg13g2_buf_1
X_09868_ _14455_/D _14455_/Q _09967_/A1 _09868_/S VDD VSS sg13g2_mux2_1
Xfanout887 _08542_/A2 _08654_/B VDD VSS sg13g2_buf_1
Xfanout898 _08522_/C _07994_/X VDD VSS sg13g2_buf_1
XFILLER_100_651 VDD VSS sg13g2_fill_2
XFILLER_58_576 VDD VSS sg13g2_decap_8
XFILLER_100_673 VDD VSS sg13g2_fill_1
X_08819_ _13690_/D _08817_/Y _08816_/Y _08818_/Y VDD VSS sg13g2_a21oi_1
X_09799_ _14388_/D _09898_/A0 _14388_/Q _09802_/S VDD VSS sg13g2_mux2_1
XFILLER_45_237 VDD VSS sg13g2_fill_1
XFILLER_45_248 VDD VSS sg13g2_decap_4
X_13717__2847 _13717_/RESET_B VDD VSS sg13g2_tiehi
X_11830_ _11830_/Y _11806_/Y _11808_/Y _12333_/B1 VDD VSS sg13g2_a21oi_1
XFILLER_26_42 VDD VSS sg13g2_decap_8
XFILLER_27_974 VDD VSS sg13g2_fill_2
X_11761_ _11761_/Y _11761_/A _11761_/B _11761_/C VDD VSS sg13g2_nand3_1
XFILLER_92_1126 VDD VSS sg13g2_decap_8
XFILLER_144_1205 VDD VSS sg13g2_decap_8
XFILLER_26_495 VDD VSS sg13g2_decap_4
XFILLER_13_112 VDD VSS sg13g2_decap_8
XFILLER_41_421 VDD VSS sg13g2_fill_1
XFILLER_42_944 VDD VSS sg13g2_fill_2
XFILLER_18_1219 VDD VSS sg13g2_decap_8
XFILLER_13_123 VDD VSS sg13g2_fill_2
XFILLER_41_432 VDD VSS sg13g2_decap_8
X_13500_ _15128_/D _13351_/C _13502_/D _13499_/Y VDD VSS sg13g2_o21ai_1
XFILLER_42_966 VDD VSS sg13g2_fill_1
X_10712_ _10712_/Y _09034_/X _08877_/A _08877_/Y VDD VSS sg13g2_a21oi_1
X_14480_ _14480_/Q clkload46/A _14480_/D _14480_/RESET_B VDD VSS sg13g2_dfrbpq_1
X_11692_ _11693_/B _11692_/A _14216_/Q VDD VSS sg13g2_nand2_1
XFILLER_41_454 VDD VSS sg13g2_fill_2
XFILLER_9_105 VDD VSS sg13g2_fill_2
XFILLER_41_487 VDD VSS sg13g2_decap_8
X_13431_ _13431_/Y _13431_/A _13435_/B _13444_/C VDD VSS sg13g2_nor3_1
X_10643_ _14888_/D _10655_/B _10643_/B _10643_/C VDD VSS sg13g2_nor3_1
X_13932__2632 _13932_/RESET_B VDD VSS sg13g2_tiehi
X_14692__1872 _14692_/RESET_B VDD VSS sg13g2_tiehi
XFILLER_42_74 VDD VSS sg13g2_decap_8
X_13362_ _15073_/D _15073_/Q _13470_/A2 _13361_/Y VDD VSS sg13g2_a21o_1
XFILLER_154_301 VDD VSS sg13g2_decap_8
X_10574_ _10583_/D _14870_/Q _12895_/A VDD VSS sg13g2_and2_1
Xmax_cap1149 _12548_/S0 _12550_/S0 VDD VSS sg13g2_buf_4
XFILLER_5_300 VDD VSS sg13g2_fill_2
X_15101_ _15101_/Q clkload67/A _15101_/D _15101_/RESET_B VDD VSS sg13g2_dfrbpq_1
X_12313_ _12313_/Y _12303_/S _14650_/Q VDD VSS sg13g2_nand2b_1
XFILLER_155_868 VDD VSS sg13g2_decap_8
X_14881__3167 _14881_/RESET_B VDD VSS sg13g2_tiehi
X_13293_ _13294_/C _13613_/A _13308_/A _13293_/C _13312_/A VDD VSS sg13g2_nor4_1
X_15032_ _15032_/Q clkload40/A _15032_/D _15032_/RESET_B VDD VSS sg13g2_dfrbpq_1
XFILLER_108_762 VDD VSS sg13g2_fill_1
X_12244_ _12244_/Y _12240_/Y _12241_/Y _12243_/Y _12242_/Y _12246_/B VDD VSS sg13g2_a221oi_1
XFILLER_6_889 VDD VSS sg13g2_decap_8
XFILLER_107_250 VDD VSS sg13g2_decap_8
XFILLER_108_773 VDD VSS sg13g2_fill_2
XFILLER_142_529 VDD VSS sg13g2_decap_4
X_14312__2252 _14312_/RESET_B VDD VSS sg13g2_tiehi
X_13965__2599 _13965_/RESET_B VDD VSS sg13g2_tiehi
XFILLER_107_283 VDD VSS sg13g2_decap_8
XFILLER_64_1217 VDD VSS sg13g2_decap_8
X_12175_ _12175_/Y _12186_/A _14390_/Q VDD VSS sg13g2_nand2b_1
XFILLER_3_35 VDD VSS sg13g2_decap_8
X_11126_ _11146_/A _11172_/A _11147_/A VDD VSS sg13g2_xnor2_1
XFILLER_123_787 VDD VSS sg13g2_fill_1
Xclkbuf_leaf_110_clk_i _15046_/CLK clkbuf_leaf_88_clk_i/A VDD VSS sg13g2_buf_8
XFILLER_110_415 VDD VSS sg13g2_fill_2
XFILLER_123_798 VDD VSS sg13g2_fill_2
XFILLER_150_595 VDD VSS sg13g2_fill_2
XFILLER_96_649 VDD VSS sg13g2_decap_8
XFILLER_27_1061 VDD VSS sg13g2_decap_8
XFILLER_49_543 VDD VSS sg13g2_fill_1
X_11057_ _14945_/D _11056_/Y _11055_/Y _11048_/Y VDD VSS sg13g2_o21ai_1
XFILLER_7_1166 VDD VSS sg13g2_decap_8
XFILLER_76_351 VDD VSS sg13g2_decap_8
X_10008_ _14590_/D _10074_/A0 _14590_/Q wire601/X VDD VSS sg13g2_mux2_1
XFILLER_97_1015 VDD VSS sg13g2_fill_2
XFILLER_114_1075 VDD VSS sg13g2_decap_8
XFILLER_36_237 VDD VSS sg13g2_decap_4
XFILLER_64_546 VDD VSS sg13g2_decap_4
X_14816_ _14816_/Q clkload83/A _14816_/D _14816_/RESET_B VDD VSS sg13g2_dfrbpq_1
Xclkbuf_leaf_125_clk_i _14633_/CLK clkbuf_5_2__f_clk_i/X VDD VSS sg13g2_buf_8
XFILLER_18_974 VDD VSS sg13g2_decap_8
XFILLER_17_451 VDD VSS sg13g2_decap_4
X_14747_ _14747_/Q clkload68/A _14747_/D _14747_/RESET_B VDD VSS sg13g2_dfrbpq_1
X_11959_ _11959_/Y _11801_/S _14416_/Q _11805_/C VDD VSS sg13g2_a21oi_1
XFILLER_17_495 VDD VSS sg13g2_decap_8
XFILLER_33_966 VDD VSS sg13g2_decap_4
X_14678_ _14678_/Q _14678_/CLK _14678_/D _14678_/RESET_B VDD VSS sg13g2_dfrbpq_1
XFILLER_32_465 VDD VSS sg13g2_decap_8
X_13629_ _13737_/D _13629_/A VDD VSS sg13g2_buf_1
XFILLER_32_498 VDD VSS sg13g2_decap_4
XFILLER_146_846 VDD VSS sg13g2_fill_2
XFILLER_145_312 VDD VSS sg13g2_decap_8
XFILLER_118_537 VDD VSS sg13g2_fill_2
XFILLER_8_171 VDD VSS sg13g2_decap_4
XFILLER_69_1128 VDD VSS sg13g2_decap_8
XFILLER_156_1109 VDD VSS sg13g2_fill_2
XFILLER_59_0 VDD VSS sg13g2_decap_8
XFILLER_141_551 VDD VSS sg13g2_decap_8
XFILLER_141_562 VDD VSS sg13g2_fill_1
XFILLER_99_476 VDD VSS sg13g2_decap_8
XFILLER_114_798 VDD VSS sg13g2_decap_8
X_07983_ _07985_/C _07978_/Y _15077_/Q _07908_/B VDD VSS sg13g2_a21oi_1
XFILLER_68_830 VDD VSS sg13g2_decap_8
X_09722_ _14313_/D _09887_/A0 _14313_/Q wire449/X VDD VSS sg13g2_mux2_1
XFILLER_80_1052 VDD VSS sg13g2_fill_1
XFILLER_68_852 VDD VSS sg13g2_fill_1
XFILLER_41_1058 VDD VSS sg13g2_decap_8
X_09653_ _14246_/D _09653_/A0 _14246_/Q _09666_/S VDD VSS sg13g2_mux2_1
XFILLER_41_1069 VDD VSS sg13g2_fill_2
XFILLER_103_14 VDD VSS sg13g2_decap_8
X_08604_ _08605_/B _08692_/A _07855_/B _08674_/A2 _08643_/D VDD VSS sg13g2_a22oi_1
X_09584_ _14181_/D _14181_/Q _09850_/A1 wire329/X VDD VSS sg13g2_mux2_1
XFILLER_24_911 VDD VSS sg13g2_fill_2
X_08535_ _15240_/D _08535_/A _08535_/B VDD VSS sg13g2_nand2_1
XFILLER_51_730 VDD VSS sg13g2_decap_8
XFILLER_24_966 VDD VSS sg13g2_decap_8
X_08466_ _08617_/B _08376_/X _08465_/X _08538_/S VDD VSS sg13g2_mux2_1
XFILLER_23_465 VDD VSS sg13g2_decap_8
X_08397_ _08397_/Y _08397_/A _08397_/B VDD VSS sg13g2_nor2_1
XFILLER_91_1181 VDD VSS sg13g2_decap_4
XFILLER_137_7 VDD VSS sg13g2_decap_8
XFILLER_91_1192 VDD VSS sg13g2_fill_2
XFILLER_137_802 VDD VSS sg13g2_fill_1
XFILLER_104_1233 VDD VSS sg13g2_decap_4
XFILLER_149_695 VDD VSS sg13g2_decap_8
XFILLER_148_172 VDD VSS sg13g2_fill_1
XFILLER_148_194 VDD VSS sg13g2_decap_8
XFILLER_12_77 VDD VSS sg13g2_decap_8
X_09018_ _09019_/B _12942_/A _09018_/A2 _09017_/Y VDD VSS sg13g2_o21ai_1
X_10290_ _10292_/B _10281_/D _10298_/D _14791_/Q VDD VSS sg13g2_a21oi_1
XFILLER_2_303 VDD VSS sg13g2_decap_8
XFILLER_117_570 VDD VSS sg13g2_fill_2
XFILLER_128_77 VDD VSS sg13g2_fill_2
XFILLER_2_347 VDD VSS sg13g2_decap_8
XFILLER_144_21 VDD VSS sg13g2_decap_8
XFILLER_120_713 VDD VSS sg13g2_decap_8
Xfanout1616 _12171_/S1 fanout1617/X VDD VSS sg13g2_buf_1
Xfanout1627 _12187_/C _12248_/B1 VDD VSS sg13g2_buf_1
Xfanout640 wire641/A _09661_/S VDD VSS sg13g2_buf_1
Xfanout1638 _12288_/S1 fanout1639/X VDD VSS sg13g2_buf_1
Xfanout1649 _11328_/S1 fanout1650/X VDD VSS sg13g2_buf_1
XFILLER_59_841 VDD VSS sg13g2_decap_8
XFILLER_150_1220 VDD VSS sg13g2_decap_8
Xfanout662 fanout662/X _09507_/Y VDD VSS sg13g2_buf_1
X_13980_ _13980_/Q clkload60/A _13980_/D _13980_/RESET_B VDD VSS sg13g2_dfrbpq_1
XFILLER_120_768 VDD VSS sg13g2_decap_4
Xfanout673 _09388_/S _09403_/S VDD VSS sg13g2_buf_1
Xfanout684 _09358_/S _09374_/S VDD VSS sg13g2_buf_1
Xclkbuf_leaf_42_clk_i clkload53/A clkbuf_leaf_48_clk_i/A VDD VSS sg13g2_buf_8
XFILLER_92_107 VDD VSS sg13g2_fill_2
XFILLER_101_971 VDD VSS sg13g2_fill_2
Xfanout695 _09212_/S _09227_/S VDD VSS sg13g2_buf_1
XFILLER_37_30 VDD VSS sg13g2_fill_1
X_12931_ _12931_/Y _14775_/Q _13275_/A2 _12978_/B1 VDD VSS sg13g2_o21ai_1
XFILLER_74_833 VDD VSS sg13g2_decap_8
XFILLER_85_170 VDD VSS sg13g2_fill_2
X_14600__1964 _14600_/RESET_B VDD VSS sg13g2_tiehi
Xwire1799 _12866_/D wire1799/A VDD VSS sg13g2_buf_4
X_14909__3111 _14909_/RESET_B VDD VSS sg13g2_tiehi
X_12862_ _12862_/Y _14867_/Q _12862_/B VDD VSS sg13g2_nand2_1
XFILLER_2_1052 VDD VSS sg13g2_decap_8
X_14601_ _14601_/Q clkload6/A _14601_/D _14601_/RESET_B VDD VSS sg13g2_dfrbpq_1
X_11813_ _11813_/Y _11809_/Y _11810_/Y _11812_/Y _11811_/Y _11822_/B VDD VSS sg13g2_a221oi_1
XFILLER_27_793 VDD VSS sg13g2_decap_8
XFILLER_26_270 VDD VSS sg13g2_decap_4
X_12793_ _12793_/Y _12997_/B _12844_/C VDD VSS sg13g2_nor2_1
XFILLER_42_730 VDD VSS sg13g2_fill_1
Xclkbuf_leaf_57_clk_i clkload72/A clkbuf_leaf_67_clk_i/A VDD VSS sg13g2_buf_8
XFILLER_109_1111 VDD VSS sg13g2_decap_8
X_14532_ _14532_/Q clkload23/A _14532_/D _14532_/RESET_B VDD VSS sg13g2_dfrbpq_1
XFILLER_18_1016 VDD VSS sg13g2_decap_8
X_11744_ _11745_/A _13738_/Q _14090_/Q _14442_/Q _14538_/Q _11741_/A _12248_/B1 VDD
+ VSS sg13g2_mux4_1
XFILLER_148_1193 VDD VSS sg13g2_decap_8
XFILLER_30_903 VDD VSS sg13g2_fill_2
XFILLER_14_454 VDD VSS sg13g2_fill_1
XFILLER_42_785 VDD VSS sg13g2_decap_8
XFILLER_57_1098 VDD VSS sg13g2_decap_8
X_14463_ _14463_/Q _14509_/CLK _14463_/D _14463_/RESET_B VDD VSS sg13g2_dfrbpq_1
X_11675_ _11675_/Y _11692_/A _14632_/Q VDD VSS sg13g2_nand2b_1
X_13414_ _13414_/Y _13438_/B _13494_/B _13435_/B VDD VSS sg13g2_nor3_1
X_10626_ _14883_/D _10626_/A _10626_/B _10626_/C VDD VSS sg13g2_and3_1
XFILLER_139_161 VDD VSS sg13g2_decap_8
XFILLER_31_1216 VDD VSS sg13g2_decap_8
X_14394_ _14394_/Q clkload47/A _14394_/D _14394_/RESET_B VDD VSS sg13g2_dfrbpq_1
XFILLER_6_631 VDD VSS sg13g2_decap_8
X_13345_ _13345_/Y _13502_/A _13345_/B VDD VSS sg13g2_nand2_1
X_10557_ _14867_/D _10557_/A _10557_/B _10557_/C VDD VSS sg13g2_and3_1
XFILLER_6_664 VDD VSS sg13g2_decap_8
XFILLER_154_175 VDD VSS sg13g2_decap_8
XFILLER_52_7 VDD VSS sg13g2_decap_8
X_13276_ _13276_/Y _13273_/Y _13274_/Y _13275_/Y VDD VSS sg13g2_a21oi_1
X_10488_ _10490_/B _10492_/C _10508_/C _14850_/Q VDD VSS sg13g2_a21oi_1
X_15015_ _15015_/Q clkload40/A _15015_/D _15015_/RESET_B VDD VSS sg13g2_dfrbpq_1
XFILLER_68_1161 VDD VSS sg13g2_decap_8
X_12227_ _12270_/A _12229_/A _12227_/B VDD VSS sg13g2_nor2_1
XFILLER_155_1142 VDD VSS sg13g2_decap_8
XFILLER_123_562 VDD VSS sg13g2_decap_4
XFILLER_151_882 VDD VSS sg13g2_fill_1
X_12158_ _12158_/Y _12168_/A _14166_/Q _12169_/C VDD VSS sg13g2_a21oi_1
XFILLER_69_638 VDD VSS sg13g2_decap_8
XFILLER_64_1069 VDD VSS sg13g2_fill_1
XFILLER_111_735 VDD VSS sg13g2_decap_8
XFILLER_1_380 VDD VSS sg13g2_decap_8
XFILLER_97_969 VDD VSS sg13g2_decap_8
XFILLER_151_1039 VDD VSS sg13g2_decap_8
X_11109_ _11109_/Y _11109_/A _11109_/B VDD VSS sg13g2_nand2_1
XFILLER_111_768 VDD VSS sg13g2_decap_8
X_12089_ _12091_/A _12090_/A _14196_/Q VDD VSS sg13g2_nand2b_1
XFILLER_49_362 VDD VSS sg13g2_decap_8
XFILLER_77_682 VDD VSS sg13g2_decap_4
XFILLER_92_630 VDD VSS sg13g2_fill_1
XFILLER_25_708 VDD VSS sg13g2_fill_1
XFILLER_94_80 VDD VSS sg13g2_decap_8
XFILLER_80_803 VDD VSS sg13g2_decap_8
XFILLER_37_579 VDD VSS sg13g2_fill_1
XFILLER_64_365 VDD VSS sg13g2_fill_1
XFILLER_75_1132 VDD VSS sg13g2_fill_2
XFILLER_45_590 VDD VSS sg13g2_decap_8
XFILLER_80_869 VDD VSS sg13g2_fill_2
X_08320_ _08366_/D _08420_/A _08418_/A VDD VSS sg13g2_nor2b_1
XFILLER_36_1105 VDD VSS sg13g2_fill_1
XFILLER_36_1116 VDD VSS sg13g2_decap_4
XFILLER_33_796 VDD VSS sg13g2_decap_8
X_08251_ _15226_/D _08395_/A _08250_/X _08246_/Y VDD VSS sg13g2_o21ai_1
X_08182_ _08188_/C _08183_/B _08182_/B _08182_/C VDD VSS sg13g2_nor3_1
X_14184__2380 _14184_/RESET_B VDD VSS sg13g2_tiehi
XFILLER_118_345 VDD VSS sg13g2_decap_8
XFILLER_118_356 VDD VSS sg13g2_fill_1
XFILLER_146_676 VDD VSS sg13g2_fill_2
XFILLER_118_389 VDD VSS sg13g2_decap_8
XFILLER_12_1193 VDD VSS sg13g2_decap_8
XFILLER_47_1201 VDD VSS sg13g2_fill_1
XFILLER_88_925 VDD VSS sg13g2_decap_8
XFILLER_142_893 VDD VSS sg13g2_fill_1
X_14408__2156 _14408_/RESET_B VDD VSS sg13g2_tiehi
X_07966_ _07966_/Y _15015_/Q _07853_/B VDD VSS sg13g2_nor2b_1
XFILLER_87_479 VDD VSS sg13g2_decap_8
XFILLER_101_256 VDD VSS sg13g2_decap_8
XFILLER_114_35 VDD VSS sg13g2_fill_2
XFILLER_56_811 VDD VSS sg13g2_decap_8
XFILLER_68_671 VDD VSS sg13g2_decap_8
X_09705_ _14297_/D _09705_/A0 _14297_/Q _09705_/S VDD VSS sg13g2_mux2_1
X_07897_ _08037_/B _08023_/A _07903_/B VDD VSS sg13g2_nand2_1
X_14991__2981 _14991_/RESET_B VDD VSS sg13g2_tiehi
XFILLER_114_68 VDD VSS sg13g2_fill_1
XFILLER_55_321 VDD VSS sg13g2_decap_4
XFILLER_83_630 VDD VSS sg13g2_fill_2
X_09636_ _14232_/D _09902_/A0 _14232_/Q _09636_/S VDD VSS sg13g2_mux2_1
XFILLER_16_708 VDD VSS sg13g2_fill_1
XFILLER_43_527 VDD VSS sg13g2_fill_1
X_09567_ _14165_/D _10097_/A0 _14165_/Q _09571_/S VDD VSS sg13g2_mux2_1
XFILLER_93_1210 VDD VSS sg13g2_decap_4
XFILLER_82_184 VDD VSS sg13g2_decap_8
XFILLER_93_1232 VDD VSS sg13g2_decap_4
X_08518_ _08526_/C _08429_/A _08197_/X _08518_/B1 VDD VSS sg13g2_o21ai_1
XFILLER_70_379 VDD VSS sg13g2_decap_8
X_09498_ _14098_/D _09962_/A1 _14098_/Q _09505_/S VDD VSS sg13g2_mux2_1
XFILLER_54_1227 VDD VSS sg13g2_decap_8
XFILLER_23_262 VDD VSS sg13g2_decap_8
XFILLER_11_402 VDD VSS sg13g2_decap_8
XFILLER_51_571 VDD VSS sg13g2_fill_1
XFILLER_51_582 VDD VSS sg13g2_decap_8
XFILLER_23_21 VDD VSS sg13g2_decap_8
X_08449_ _08449_/Y _08448_/Y _07948_/A _08039_/A VDD VSS sg13g2_a21oi_1
Xwire304 wire304/X wire304/A VDD VSS sg13g2_buf_2
XFILLER_139_21 VDD VSS sg13g2_decap_8
XFILLER_17_1071 VDD VSS sg13g2_decap_8
X_11460_ _14962_/D _07909_/B _11522_/A2 _11459_/Y VDD VSS sg13g2_a21oi_1
Xwire326 wire326/X wire327/X VDD VSS sg13g2_buf_2
X_14014__2550 _14014_/RESET_B VDD VSS sg13g2_tiehi
Xwire337 wire337/X wire337/A VDD VSS sg13g2_buf_8
XFILLER_143_1090 VDD VSS sg13g2_decap_8
XFILLER_23_98 VDD VSS sg13g2_decap_4
X_10411_ _14826_/D _10413_/B _10414_/D _10407_/Y _07648_/Y _10655_/B VDD VSS sg13g2_a221oi_1
X_11391_ _11391_/Y _11391_/A _11391_/B VDD VSS sg13g2_nand2_1
XFILLER_99_36 VDD VSS sg13g2_decap_8
XFILLER_139_98 VDD VSS sg13g2_decap_8
XFILLER_99_47 VDD VSS sg13g2_fill_2
XFILLER_152_602 VDD VSS sg13g2_decap_8
XFILLER_136_153 VDD VSS sg13g2_fill_2
XFILLER_104_1085 VDD VSS sg13g2_fill_1
X_13130_ _13170_/B _14915_/Q _13130_/B VDD VSS sg13g2_xnor2_1
X_10342_ _10343_/B _14798_/Q _14807_/Q _10342_/C _10357_/D VDD VSS sg13g2_nand4_1
XFILLER_3_601 VDD VSS sg13g2_decap_4
XFILLER_109_389 VDD VSS sg13g2_decap_8
XFILLER_151_112 VDD VSS sg13g2_decap_8
X_14618__1946 _14618_/RESET_B VDD VSS sg13g2_tiehi
XFILLER_3_634 VDD VSS sg13g2_decap_8
XFILLER_155_42 VDD VSS sg13g2_decap_8
X_13061_ _13063_/B _13026_/A _13058_/B _13060_/Y VDD VSS sg13g2_a21oi_1
X_14800__3298 _14800_/RESET_B VDD VSS sg13g2_tiehi
X_10273_ _14785_/D _10299_/A _10299_/B _10271_/Y VDD VSS sg13g2_a21oi_1
XFILLER_2_133 VDD VSS sg13g2_decap_8
XFILLER_151_156 VDD VSS sg13g2_fill_1
XFILLER_105_551 VDD VSS sg13g2_fill_1
X_12012_ _12012_/X _12012_/A _12055_/D VDD VSS sg13g2_and2_1
XFILLER_105_573 VDD VSS sg13g2_fill_1
Xfanout1402 _08048_/B _08692_/B VDD VSS sg13g2_buf_1
X_13882__2682 _13882_/RESET_B VDD VSS sg13g2_tiehi
XFILLER_120_510 VDD VSS sg13g2_fill_1
Xfanout1413 _12203_/A _14985_/Q VDD VSS sg13g2_buf_1
XFILLER_120_532 VDD VSS sg13g2_decap_8
Xfanout1424 _08620_/A3 _12061_/A VDD VSS sg13g2_buf_1
XFILLER_48_40 VDD VSS sg13g2_decap_8
Xfanout1435 _07820_/B _07821_/B VDD VSS sg13g2_buf_1
Xfanout1446 _07798_/B _07800_/B VDD VSS sg13g2_buf_1
Xfanout1457 _11706_/A _14971_/Q VDD VSS sg13g2_buf_1
XFILLER_94_928 VDD VSS sg13g2_decap_8
Xfanout1468 _08337_/A3 _11570_/A VDD VSS sg13g2_buf_1
Xfanout481 wire482/A _09474_/X VDD VSS sg13g2_buf_1
XFILLER_63_1091 VDD VSS sg13g2_fill_1
Xfanout1479 _07888_/B _08235_/A3 VDD VSS sg13g2_buf_1
XFILLER_4_1125 VDD VSS sg13g2_decap_8
Xfanout492 _09302_/S wire496/A VDD VSS sg13g2_buf_1
XFILLER_24_1064 VDD VSS sg13g2_decap_8
X_13963_ _13963_/Q _14745_/CLK _13963_/D _13963_/RESET_B VDD VSS sg13g2_dfrbpq_1
XFILLER_150_1072 VDD VSS sg13g2_fill_1
Xwire1563 _16862_/A _13700_/Q VDD VSS sg13g2_buf_8
XFILLER_111_1034 VDD VSS sg13g2_decap_4
XFILLER_111_1045 VDD VSS sg13g2_decap_8
X_12914_ _12914_/Y _12914_/A _12914_/B _12914_/C VDD VSS sg13g2_nor3_1
XFILLER_111_1056 VDD VSS sg13g2_decap_8
XFILLER_0_47 VDD VSS sg13g2_decap_8
X_13894_ _13894_/Q clkload17/A _13894_/D _13894_/RESET_B VDD VSS sg13g2_dfrbpq_1
XFILLER_0_58 VDD VSS sg13g2_fill_1
XFILLER_74_685 VDD VSS sg13g2_fill_1
X_12845_ _12845_/Y _12845_/A _12845_/B _12845_/C _12845_/D VDD VSS sg13g2_nand4_1
XFILLER_146_1108 VDD VSS sg13g2_decap_8
XFILLER_73_184 VDD VSS sg13g2_decap_8
XFILLER_146_1119 VDD VSS sg13g2_fill_1
XFILLER_27_590 VDD VSS sg13g2_decap_8
XFILLER_61_335 VDD VSS sg13g2_decap_8
XFILLER_62_869 VDD VSS sg13g2_decap_8
X_15149__3044 _15149_/RESET_B VDD VSS sg13g2_tiehi
X_12776_ _12776_/X _12774_/X _12775_/X _12776_/S VDD VSS sg13g2_mux2_1
XFILLER_30_700 VDD VSS sg13g2_decap_8
XFILLER_30_711 VDD VSS sg13g2_fill_2
X_11727_ _11728_/B _11707_/A _11773_/C _11705_/Y VDD VSS sg13g2_o21ai_1
X_14515_ _14515_/Q clkload7/A _14515_/D _14515_/RESET_B VDD VSS sg13g2_dfrbpq_1
XFILLER_9_56 VDD VSS sg13g2_decap_8
XFILLER_70_1040 VDD VSS sg13g2_fill_1
X_14446_ _14446_/Q _14763_/CLK _14446_/D _14446_/RESET_B VDD VSS sg13g2_dfrbpq_1
XFILLER_31_1002 VDD VSS sg13g2_decap_8
X_11658_ _14969_/D _11635_/A _11701_/C1 _11657_/Y VDD VSS sg13g2_a21o_1
XFILLER_70_1062 VDD VSS sg13g2_decap_8
X_10609_ _10611_/C _14879_/Q _10614_/A VDD VSS sg13g2_nand2b_1
X_14377_ _14377_/Q _14633_/CLK _14377_/D _14377_/RESET_B VDD VSS sg13g2_dfrbpq_1
X_11589_ _11632_/A _11591_/A _11724_/B VDD VSS sg13g2_nor2_1
XFILLER_156_985 VDD VSS sg13g2_fill_2
Xmax_cap615 _09834_/S _09835_/S VDD VSS sg13g2_buf_4
XFILLER_127_153 VDD VSS sg13g2_fill_2
Xmax_cap626 _09801_/S _09802_/S VDD VSS sg13g2_buf_4
XFILLER_7_984 VDD VSS sg13g2_decap_8
X_13328_ _15067_/D _13328_/A _13328_/B VDD VSS sg13g2_nor2_1
XFILLER_142_112 VDD VSS sg13g2_decap_8
XFILLER_66_1109 VDD VSS sg13g2_fill_2
Xmax_cap637 _09666_/S _09667_/S VDD VSS sg13g2_buf_4
XFILLER_142_123 VDD VSS sg13g2_fill_2
Xmax_cap659 _09538_/S _09512_/S VDD VSS sg13g2_buf_4
X_13259_ _13259_/Y _13259_/A _13259_/B VDD VSS sg13g2_xnor2_1
XFILLER_124_882 VDD VSS sg13g2_fill_2
XFILLER_111_510 VDD VSS sg13g2_fill_2
XFILLER_124_893 VDD VSS sg13g2_decap_8
X_13712__2852 _13712_/RESET_B VDD VSS sg13g2_tiehi
XFILLER_69_435 VDD VSS sg13g2_fill_2
X_07820_ _07820_/X _15009_/Q _07820_/B VDD VSS sg13g2_or2_1
XFILLER_69_457 VDD VSS sg13g2_fill_1
XFILLER_85_928 VDD VSS sg13g2_decap_4
XFILLER_85_939 VDD VSS sg13g2_fill_2
XFILLER_97_799 VDD VSS sg13g2_fill_1
X_07751_ _07751_/Y _10935_/A _10510_/B VDD VSS sg13g2_nand2_1
XFILLER_111_598 VDD VSS sg13g2_fill_1
X_14056__2508 _14056_/RESET_B VDD VSS sg13g2_tiehi
X_07682_ wire947/A _07682_/A _11236_/B VDD VSS sg13g2_nor2_1
XFILLER_53_803 VDD VSS sg13g2_fill_2
X_09421_ _14023_/D _10083_/A0 _14023_/Q _09421_/S VDD VSS sg13g2_mux2_1
XFILLER_37_387 VDD VSS sg13g2_decap_8
XFILLER_53_847 VDD VSS sg13g2_fill_2
XFILLER_92_493 VDD VSS sg13g2_decap_8
XFILLER_80_644 VDD VSS sg13g2_decap_8
XFILLER_80_655 VDD VSS sg13g2_fill_2
X_09352_ _13956_/D _09616_/A0 _13956_/Q _09358_/S VDD VSS sg13g2_mux2_1
XFILLER_127_1030 VDD VSS sg13g2_decap_8
X_08303_ _08303_/Y _08306_/C _08306_/B VDD VSS sg13g2_nor2_1
X_09283_ _13891_/D _13891_/Q _10079_/A0 _09303_/S VDD VSS sg13g2_mux2_1
XFILLER_100_48 VDD VSS sg13g2_fill_1
X_08234_ _08234_/Y _08621_/B _08617_/A VDD VSS sg13g2_nor2_1
XFILLER_14_1211 VDD VSS sg13g2_decap_8
XFILLER_21_788 VDD VSS sg13g2_fill_2
X_08165_ _08166_/A _07871_/X _08163_/Y _08164_/Y VDD VSS sg13g2_o21ai_1
XFILLER_118_131 VDD VSS sg13g2_decap_8
XFILLER_119_654 VDD VSS sg13g2_fill_2
XFILLER_10_1108 VDD VSS sg13g2_decap_8
XFILLER_109_46 VDD VSS sg13g2_decap_8
X_08096_ _08096_/X _08199_/C _08198_/S VDD VSS sg13g2_and2_1
XFILLER_133_112 VDD VSS sg13g2_decap_4
XFILLER_69_28 VDD VSS sg13g2_fill_2
Xclkload80 clkload80/Y clkload80/A VDD VSS sg13g2_inv_1
X_14926__3077 _14926_/RESET_B VDD VSS sg13g2_tiehi
Xhold3510 _10796_/A _14926_/Q VDD VSS sg13g2_dlygate4sd3_1
XFILLER_0_615 VDD VSS sg13g2_fill_1
Xhold3521 _07761_/B _15204_/Q VDD VSS sg13g2_dlygate4sd3_1
XFILLER_121_329 VDD VSS sg13g2_decap_8
Xhold3532 hold3532/X _14997_/Q VDD VSS sg13g2_dlygate4sd3_1
XFILLER_114_370 VDD VSS sg13g2_decap_4
XFILLER_48_608 VDD VSS sg13g2_decap_4
XFILLER_130_863 VDD VSS sg13g2_fill_2
XFILLER_87_254 VDD VSS sg13g2_fill_2
X_08998_ _08998_/X _15027_/Q _15224_/Q _09034_/S VDD VSS sg13g2_mux2_1
XFILLER_102_576 VDD VSS sg13g2_decap_8
XFILLER_85_49 VDD VSS sg13g2_decap_8
XFILLER_18_21 VDD VSS sg13g2_decap_8
X_07949_ _07950_/C _08456_/C _07949_/B _07949_/C VDD VSS sg13g2_nand3b_1
XFILLER_29_844 VDD VSS sg13g2_decap_4
XFILLER_21_1215 VDD VSS sg13g2_decap_8
XFILLER_56_641 VDD VSS sg13g2_decap_8
X_10960_ _10978_/A _14759_/Q _10967_/B VDD VSS sg13g2_nor2_1
XFILLER_44_814 VDD VSS sg13g2_fill_2
XFILLER_141_77 VDD VSS sg13g2_decap_8
X_09619_ _14215_/D _10017_/A0 _14215_/Q _09632_/S VDD VSS sg13g2_mux2_1
XFILLER_83_493 VDD VSS sg13g2_decap_4
X_10891_ _10893_/A _10865_/Y _10841_/Y _10890_/Y VDD VSS sg13g2_o21ai_1
XFILLER_19_1100 VDD VSS sg13g2_decap_8
X_12630_ _12630_/X _14575_/Q _14607_/Q _14639_/Q _14671_/Q _12630_/S0 _12689_/S1 VDD
+ VSS sg13g2_mux4_1
XFILLER_93_1040 VDD VSS sg13g2_decap_4
XFILLER_31_519 VDD VSS sg13g2_decap_8
X_12561_ _12561_/X _14570_/Q _14602_/Q _14634_/Q _14666_/Q _12561_/S0 _12564_/S1 VDD
+ VSS sg13g2_mux4_1
XFILLER_54_1035 VDD VSS sg13g2_fill_1
XFILLER_106_1103 VDD VSS sg13g2_fill_2
XFILLER_145_1163 VDD VSS sg13g2_decap_4
XFILLER_19_1177 VDD VSS sg13g2_decap_8
XFILLER_15_1008 VDD VSS sg13g2_fill_1
XFILLER_141_1016 VDD VSS sg13g2_decap_8
X_11512_ _11512_/X _13731_/Q _14083_/Q _14435_/Q _14531_/Q _11514_/S0 _11715_/S1 VDD
+ VSS sg13g2_mux4_1
X_14300_ _14300_/Q _14776_/CLK _14300_/D _14300_/RESET_B VDD VSS sg13g2_dfrbpq_1
X_12492_ _12492_/X _13733_/Q _14085_/Q _14437_/Q _14533_/Q _12492_/S0 _12494_/S1 VDD
+ VSS sg13g2_mux4_1
XFILLER_12_788 VDD VSS sg13g2_decap_4
XFILLER_8_748 VDD VSS sg13g2_fill_2
XFILLER_7_225 VDD VSS sg13g2_decap_8
X_14231_ _14231_/Q _14678_/CLK _14231_/D _14231_/RESET_B VDD VSS sg13g2_dfrbpq_1
XFILLER_126_0 VDD VSS sg13g2_decap_8
XFILLER_138_963 VDD VSS sg13g2_decap_4
X_11443_ _11446_/B _11615_/B _11443_/B VDD VSS sg13g2_nor2_1
Xwire145 wire145/X wire145/A VDD VSS sg13g2_buf_2
XFILLER_138_974 VDD VSS sg13g2_decap_4
XFILLER_125_613 VDD VSS sg13g2_fill_2
X_14162_ _14162_/Q clkload46/A _14162_/D _14162_/RESET_B VDD VSS sg13g2_dfrbpq_1
XFILLER_152_410 VDD VSS sg13g2_decap_4
X_11374_ _11374_/Y _11374_/A _11374_/B _11374_/C VDD VSS sg13g2_nand3_1
XFILLER_4_921 VDD VSS sg13g2_fill_2
XFILLER_153_944 VDD VSS sg13g2_decap_8
X_13113_ _13113_/X _13172_/A _13172_/B _13172_/C VDD VSS sg13g2_and3_1
X_10325_ _14801_/D _10325_/A _10325_/B _10444_/C VDD VSS sg13g2_and3_1
X_14093_ _14093_/Q _14669_/CLK _14093_/D _14093_/RESET_B VDD VSS sg13g2_dfrbpq_1
XFILLER_4_965 VDD VSS sg13g2_decap_8
X_13044_ _13044_/Y input28/X _13609_/A _13601_/B VDD VSS sg13g2_o21ai_1
X_10256_ _14780_/D _10256_/A _10265_/D _10256_/C VDD VSS sg13g2_and3_1
XFILLER_152_1112 VDD VSS sg13g2_decap_8
XFILLER_59_61 VDD VSS sg13g2_fill_1
Xfanout1210 _12620_/S0 _12782_/S0 VDD VSS sg13g2_buf_1
Xfanout1221 _07682_/A _15209_/Q VDD VSS sg13g2_buf_1
Xfanout1232 _12751_/A2 _12403_/A2 VDD VSS sg13g2_buf_1
XFILLER_79_788 VDD VSS sg13g2_decap_8
X_10187_ _15194_/D input21/X _15194_/Q _10205_/S VDD VSS sg13g2_mux2_1
Xfanout1243 _12936_/B _13537_/B VDD VSS sg13g2_buf_1
Xfanout1254 _10201_/A1 _15182_/Q VDD VSS sg13g2_buf_1
Xfanout1265 _12963_/B _13162_/B1 VDD VSS sg13g2_buf_1
XFILLER_152_1189 VDD VSS sg13g2_decap_8
Xfanout1276 _12851_/B _15106_/Q VDD VSS sg13g2_buf_1
XFILLER_15_7 VDD VSS sg13g2_decap_8
XFILLER_66_449 VDD VSS sg13g2_decap_8
Xfanout1287 _13427_/C _15096_/Q VDD VSS sg13g2_buf_1
XFILLER_47_630 VDD VSS sg13g2_decap_8
X_14995_ _14995_/Q _15229_/CLK _14995_/D _14995_/RESET_B VDD VSS sg13g2_dfrbpq_1
XFILLER_47_641 VDD VSS sg13g2_fill_1
Xfanout1298 fanout1298/X _15070_/Q VDD VSS sg13g2_buf_1
X_13946_ _13946_/Q clkload47/A _13946_/D _13946_/RESET_B VDD VSS sg13g2_dfrbpq_1
XFILLER_61_110 VDD VSS sg13g2_fill_2
XFILLER_62_633 VDD VSS sg13g2_decap_8
X_13877_ _13877_/Q clkload14/A _13877_/D _13877_/RESET_B VDD VSS sg13g2_dfrbpq_1
XFILLER_22_519 VDD VSS sg13g2_decap_8
X_12828_ _12828_/Y _12828_/A _12828_/B VDD VSS sg13g2_nand2_1
XFILLER_15_582 VDD VSS sg13g2_fill_1
X_12759_ _12759_/X _13976_/Q _14008_/Q _14040_/Q _14072_/Q _12759_/S0 _12759_/S1 VDD
+ VSS sg13g2_mux4_1
XFILLER_124_1236 VDD VSS sg13g2_fill_1
XFILLER_147_226 VDD VSS sg13g2_fill_2
X_14429_ _14429_/Q clkload52/A _14429_/D _14429_/RESET_B VDD VSS sg13g2_dfrbpq_1
Xmax_cap412 _09954_/S _09964_/S VDD VSS sg13g2_buf_4
XFILLER_128_484 VDD VSS sg13g2_fill_1
X_09970_ _14554_/D _14554_/Q _09970_/A1 _09970_/S VDD VSS sg13g2_mux2_1
XFILLER_143_465 VDD VSS sg13g2_fill_1
XFILLER_104_819 VDD VSS sg13g2_fill_2
XFILLER_103_307 VDD VSS sg13g2_fill_2
Xmax_cap478 _09505_/S _09479_/S VDD VSS sg13g2_buf_4
XFILLER_41_0 VDD VSS sg13g2_decap_8
Xmax_cap489 _09339_/S _09312_/S VDD VSS sg13g2_buf_4
XFILLER_83_1231 VDD VSS sg13g2_decap_4
X_08921_ _08921_/X _15043_/Q _14947_/Q _10752_/A VDD VSS sg13g2_mux2_1
XFILLER_118_1029 VDD VSS sg13g2_decap_8
XFILLER_130_115 VDD VSS sg13g2_decap_8
XFILLER_112_830 VDD VSS sg13g2_decap_4
XFILLER_69_243 VDD VSS sg13g2_decap_8
X_08852_ _08852_/Y _10694_/S _14930_/Q VDD VSS sg13g2_nor2b_1
X_07803_ _08481_/A _07950_/A _07949_/B VDD VSS sg13g2_and2_1
XFILLER_131_1229 VDD VSS sg13g2_decap_8
X_08783_ _13679_/D _08728_/Y _08782_/Y _08781_/Y VDD VSS sg13g2_a21oi_1
XFILLER_84_235 VDD VSS sg13g2_decap_8
XFILLER_111_395 VDD VSS sg13g2_decap_4
X_07734_ _07735_/D _07734_/A _07734_/B _07734_/C VDD VSS sg13g2_nand3_1
X_13978__2586 _13978_/RESET_B VDD VSS sg13g2_tiehi
XFILLER_84_268 VDD VSS sg13g2_decap_8
XFILLER_77_1013 VDD VSS sg13g2_decap_8
XFILLER_77_1024 VDD VSS sg13g2_fill_1
XFILLER_65_482 VDD VSS sg13g2_decap_8
XFILLER_81_931 VDD VSS sg13g2_decap_8
XFILLER_53_633 VDD VSS sg13g2_decap_8
X_07665_ _07665_/X _13508_/B _10205_/S VDD VSS sg13g2_or2_1
XFILLER_52_121 VDD VSS sg13g2_decap_8
XFILLER_111_14 VDD VSS sg13g2_decap_8
XFILLER_111_25 VDD VSS sg13g2_fill_2
XFILLER_129_1125 VDD VSS sg13g2_decap_8
X_09404_ _14007_/D _09967_/A1 _14007_/Q _09404_/S VDD VSS sg13g2_mux2_1
XFILLER_25_357 VDD VSS sg13g2_decap_8
X_09335_ _13942_/D _10132_/A0 _13942_/Q _09335_/S VDD VSS sg13g2_mux2_1
XFILLER_90_1235 VDD VSS sg13g2_fill_2
XFILLER_21_530 VDD VSS sg13g2_decap_4
XFILLER_138_204 VDD VSS sg13g2_decap_8
X_09266_ _13875_/D _13875_/Q _09332_/A0 _09266_/S VDD VSS sg13g2_mux2_1
X_15072__3246 _15072_/RESET_B VDD VSS sg13g2_tiehi
XFILLER_21_585 VDD VSS sg13g2_decap_8
XFILLER_14_1030 VDD VSS sg13g2_decap_8
X_08217_ _08217_/X _08544_/A _08544_/C VDD VSS sg13g2_and2_1
XFILLER_53_1090 VDD VSS sg13g2_decap_4
XFILLER_119_440 VDD VSS sg13g2_decap_8
X_09197_ _13813_/D _13813_/Q _10131_/A0 _09201_/S VDD VSS sg13g2_mux2_1
XFILLER_14_1085 VDD VSS sg13g2_decap_8
X_15133__3076 _15133_/RESET_B VDD VSS sg13g2_tiehi
X_08148_ _08688_/A _08242_/A _08599_/B VDD VSS sg13g2_nand2_1
X_15087__3202 _15087_/RESET_B VDD VSS sg13g2_tiehi
XFILLER_4_228 VDD VSS sg13g2_decap_8
XFILLER_146_292 VDD VSS sg13g2_fill_2
X_08079_ _08079_/X _08241_/B _08009_/X _08079_/S VDD VSS sg13g2_mux2_1
XFILLER_20_77 VDD VSS sg13g2_decap_8
X_10110_ _14688_/D _10143_/A1 _14688_/Q _10135_/S VDD VSS sg13g2_mux2_1
XFILLER_136_77 VDD VSS sg13g2_decap_4
X_11090_ _11092_/A _11086_/A _10754_/X _11088_/A _11087_/X _11058_/Y VDD VSS sg13g2_a221oi_1
X_10041_ _14622_/D _10074_/A0 _14622_/Q _10060_/S VDD VSS sg13g2_mux2_1
XFILLER_102_340 VDD VSS sg13g2_decap_8
XFILLER_29_42 VDD VSS sg13g2_fill_2
XFILLER_152_21 VDD VSS sg13g2_decap_8
XFILLER_48_427 VDD VSS sg13g2_fill_1
XFILLER_5_1220 VDD VSS sg13g2_decap_8
XFILLER_64_909 VDD VSS sg13g2_decap_8
XFILLER_21_1012 VDD VSS sg13g2_decap_8
X_13800_ _13800_/Q _15148_/CLK _13800_/D _13800_/RESET_B VDD VSS sg13g2_dfrbpq_1
X_13808__2756 _13808_/RESET_B VDD VSS sg13g2_tiehi
XFILLER_152_98 VDD VSS sg13g2_decap_8
X_14780_ _14780_/Q clkload77/A _14780_/D _14780_/RESET_B VDD VSS sg13g2_dfrbpq_1
X_14568__1996 _14568_/RESET_B VDD VSS sg13g2_tiehi
X_11992_ _11992_/X _14385_/Q _14417_/Q _14481_/Q _14513_/Q _11992_/S0 _11997_/S1 VDD
+ VSS sg13g2_mux4_1
XFILLER_17_825 VDD VSS sg13g2_decap_8
XFILLER_72_920 VDD VSS sg13g2_decap_4
XFILLER_1_1139 VDD VSS sg13g2_decap_8
XFILLER_44_622 VDD VSS sg13g2_decap_8
XFILLER_56_482 VDD VSS sg13g2_decap_8
XFILLER_90_227 VDD VSS sg13g2_decap_4
XFILLER_17_847 VDD VSS sg13g2_fill_2
X_13731_ _13731_/Q clkload1/A _13731_/D _13731_/RESET_B VDD VSS sg13g2_dfrbpq_1
X_10943_ _11004_/A _14758_/Q _10954_/C VDD VSS sg13g2_xnor2_1
XFILLER_21_1089 VDD VSS sg13g2_decap_8
X_10874_ _14932_/D _10873_/Y _10872_/Y _10862_/Y VDD VSS sg13g2_o21ai_1
X_13662_ _13662_/Q clkload34/A _13662_/D _13662_/RESET_B VDD VSS sg13g2_dfrbpq_1
XFILLER_71_496 VDD VSS sg13g2_fill_1
X_12613_ _12613_/X _14126_/Q _14158_/Q _14190_/Q _14222_/Q _12617_/S0 _12617_/S1 VDD
+ VSS sg13g2_mux4_1
X_13593_ _13593_/Y _15163_/Q _13593_/B VDD VSS sg13g2_nor2_1
X_14964__3008 _14964_/RESET_B VDD VSS sg13g2_tiehi
X_12544_ _12544_/X _14697_/Q _14729_/Q _13769_/Q _13801_/Q _12548_/S0 _12550_/S1 VDD
+ VSS sg13g2_mux4_1
XFILLER_12_574 VDD VSS sg13g2_decap_4
XFILLER_32_1141 VDD VSS sg13g2_fill_2
X_12475_ _12475_/X _14372_/Q _14404_/Q _14468_/Q _14500_/Q _12752_/S0 _12757_/S1 VDD
+ VSS sg13g2_mux4_1
XFILLER_8_556 VDD VSS sg13g2_decap_4
XFILLER_126_911 VDD VSS sg13g2_fill_1
XFILLER_6_35 VDD VSS sg13g2_decap_8
X_14214_ _14214_/Q _14662_/CLK _14214_/D _14214_/RESET_B VDD VSS sg13g2_dfrbpq_1
X_11426_ _11426_/Y _12859_/A _11655_/B _11431_/A1 VDD VSS sg13g2_a21oi_1
XANTENNA_6 _15167_/Q VDD VSS sg13g2_antennanp
X_15194_ _15194_/Q clkload62/A _15194_/D _15194_/RESET_B VDD VSS sg13g2_dfrbpq_1
XFILLER_153_730 VDD VSS sg13g2_fill_2
X_14403__2161 _14403_/RESET_B VDD VSS sg13g2_tiehi
XFILLER_126_966 VDD VSS sg13g2_fill_2
X_14145_ _14145_/Q clkload23/A _14145_/D _14145_/RESET_B VDD VSS sg13g2_dfrbpq_1
X_11357_ _11357_/Y _11374_/C _11353_/X _11356_/Y VDD VSS sg13g2_o21ai_1
XFILLER_99_839 VDD VSS sg13g2_decap_8
XFILLER_154_1218 VDD VSS sg13g2_decap_8
XFILLER_3_261 VDD VSS sg13g2_decap_8
XFILLER_4_784 VDD VSS sg13g2_decap_8
XFILLER_113_638 VDD VSS sg13g2_decap_8
X_10308_ _14796_/D _14796_/Q _10327_/B _10307_/Y VDD VSS sg13g2_a21oi_1
X_14076_ _14076_/Q _14670_/CLK _14076_/D _14076_/RESET_B VDD VSS sg13g2_dfrbpq_1
XFILLER_3_272 VDD VSS sg13g2_fill_1
X_11288_ _11288_/Y _11288_/A _15217_/Q VDD VSS sg13g2_nor2b_1
X_13027_ _13027_/Y _13026_/Y _13247_/D _13042_/B VDD VSS sg13g2_nand3b_1
X_10239_ _14774_/D _10237_/B _10234_/Y _10238_/Y VDD VSS sg13g2_a21oi_1
Xfanout1040 _08649_/S _07612_/Y VDD VSS sg13g2_buf_1
XFILLER_67_725 VDD VSS sg13g2_decap_8
XFILLER_79_585 VDD VSS sg13g2_fill_1
XFILLER_120_170 VDD VSS sg13g2_decap_8
XFILLER_121_693 VDD VSS sg13g2_decap_8
XFILLER_86_81 VDD VSS sg13g2_fill_1
Xfanout1084 _12761_/S0 wire1096/X VDD VSS sg13g2_buf_1
XFILLER_120_192 VDD VSS sg13g2_fill_2
Xfanout1095 wire1096/A _15212_/Q VDD VSS sg13g2_buf_1
XFILLER_35_600 VDD VSS sg13g2_fill_2
XFILLER_47_460 VDD VSS sg13g2_decap_4
X_14978_ _14978_/Q clkload48/A _14978_/D _14978_/RESET_B VDD VSS sg13g2_dfrbpq_1
XFILLER_47_482 VDD VSS sg13g2_decap_8
X_13929_ _13929_/Q _14633_/CLK _13929_/D _13929_/RESET_B VDD VSS sg13g2_dfrbpq_1
XFILLER_90_750 VDD VSS sg13g2_decap_8
XFILLER_23_817 VDD VSS sg13g2_decap_8
XFILLER_62_463 VDD VSS sg13g2_decap_8
XFILLER_37_1063 VDD VSS sg13g2_decap_8
XFILLER_50_669 VDD VSS sg13g2_decap_4
X_09120_ _09120_/Y _15243_/Q _09161_/S VDD VSS sg13g2_nand2b_1
X_14613__1951 _14613_/RESET_B VDD VSS sg13g2_tiehi
XFILLER_31_872 VDD VSS sg13g2_fill_2
XFILLER_89_0 VDD VSS sg13g2_decap_8
XFILLER_37_1096 VDD VSS sg13g2_fill_2
XFILLER_30_371 VDD VSS sg13g2_decap_8
X_09051_ wire268/A _09024_/A _10720_/B _09050_/X VDD VSS sg13g2_o21ai_1
XFILLER_11_1203 VDD VSS sg13g2_decap_8
X_08002_ _08002_/Y _08037_/A _08037_/B _08039_/A VDD VSS sg13g2_a21oi_1
XFILLER_129_782 VDD VSS sg13g2_fill_1
XFILLER_132_903 VDD VSS sg13g2_fill_1
XFILLER_132_947 VDD VSS sg13g2_decap_8
XFILLER_89_338 VDD VSS sg13g2_decap_8
X_09953_ _14537_/D _14537_/Q _10085_/A0 _09967_/S VDD VSS sg13g2_mux2_1
XFILLER_132_969 VDD VSS sg13g2_decap_8
XFILLER_106_14 VDD VSS sg13g2_decap_8
XFILLER_98_850 VDD VSS sg13g2_fill_1
XFILLER_48_1192 VDD VSS sg13g2_decap_8
X_08904_ _08904_/X _08903_/X _11843_/A _08925_/S VDD VSS sg13g2_mux2_1
XFILLER_44_1034 VDD VSS sg13g2_fill_1
X_09884_ _14470_/D _09884_/A0 _14470_/Q _09901_/S VDD VSS sg13g2_mux2_1
XFILLER_85_522 VDD VSS sg13g2_fill_1
XFILLER_112_682 VDD VSS sg13g2_fill_2
XFILLER_58_747 VDD VSS sg13g2_decap_8
XFILLER_100_833 VDD VSS sg13g2_decap_8
XFILLER_85_533 VDD VSS sg13g2_fill_2
X_08835_ _08842_/S _08835_/A _08835_/B VDD VSS sg13g2_nand2_1
XFILLER_131_1037 VDD VSS sg13g2_decap_8
XFILLER_100_877 VDD VSS sg13g2_decap_8
XFILLER_100_888 VDD VSS sg13g2_fill_2
X_08766_ _08766_/Y _13674_/Q _08787_/B VDD VSS sg13g2_nor2_1
XFILLER_122_35 VDD VSS sg13g2_decap_8
XFILLER_122_46 VDD VSS sg13g2_fill_2
X_07717_ _08032_/B _15102_/Q _15101_/Q _15094_/Q _15093_/Q VDD VSS sg13g2_nor4_2
XFILLER_26_633 VDD VSS sg13g2_decap_8
X_08697_ _08697_/Y _08697_/A _08697_/B VDD VSS sg13g2_nand2_1
XFILLER_54_964 VDD VSS sg13g2_fill_1
XFILLER_122_79 VDD VSS sg13g2_fill_2
X_14445__2119 _14445_/RESET_B VDD VSS sg13g2_tiehi
XFILLER_25_143 VDD VSS sg13g2_fill_2
XFILLER_41_603 VDD VSS sg13g2_decap_4
X_07648_ _07648_/Y _14826_/Q VDD VSS sg13g2_inv_1
XFILLER_0_1183 VDD VSS sg13g2_decap_8
XFILLER_41_636 VDD VSS sg13g2_decap_8
XFILLER_80_282 VDD VSS sg13g2_decap_8
XFILLER_0_1194 VDD VSS sg13g2_fill_1
XFILLER_80_293 VDD VSS sg13g2_fill_2
XFILLER_55_1152 VDD VSS sg13g2_decap_8
XFILLER_22_850 VDD VSS sg13g2_fill_1
XFILLER_15_77 VDD VSS sg13g2_decap_8
XFILLER_16_1125 VDD VSS sg13g2_decap_8
X_09318_ _13925_/D _10148_/A1 _13925_/Q _09336_/S VDD VSS sg13g2_mux2_1
X_10590_ _10606_/B _14874_/Q _12963_/A VDD VSS sg13g2_nand2_1
XFILLER_90_1087 VDD VSS sg13g2_fill_1
XFILLER_31_21 VDD VSS sg13g2_decap_8
X_09249_ _13858_/D _13858_/Q _10145_/A1 _09269_/S VDD VSS sg13g2_mux2_1
XFILLER_127_708 VDD VSS sg13g2_decap_8
XFILLER_142_1188 VDD VSS sg13g2_decap_4
X_13671__2915 _13671_/RESET_B VDD VSS sg13g2_tiehi
XFILLER_147_21 VDD VSS sg13g2_decap_8
X_12260_ _12260_/X _12260_/A1 _12259_/X _12258_/Y VDD VSS sg13g2_a21o_1
XFILLER_126_229 VDD VSS sg13g2_decap_8
X_11211_ _11211_/X _14107_/Q _14139_/Q _11212_/S VDD VSS sg13g2_mux2_1
X_12191_ _12192_/B _12188_/Y _12190_/Y _12191_/B1 VDD VSS sg13g2_a21oi_1
XFILLER_108_999 VDD VSS sg13g2_fill_2
Xoutput43 mem_axi_araddr[14] output43/A VDD VSS sg13g2_buf_1
XFILLER_134_284 VDD VSS sg13g2_decap_8
X_14051__2513 _14051_/RESET_B VDD VSS sg13g2_tiehi
X_11142_ _14951_/D _11141_/X _11140_/Y _11133_/Y VDD VSS sg13g2_o21ai_1
XFILLER_122_424 VDD VSS sg13g2_decap_8
Xoutput54 mem_axi_araddr[25] output54/A VDD VSS sg13g2_buf_1
Xoutput65 mem_axi_araddr[6] _16859_/A VDD VSS sg13g2_buf_1
XFILLER_150_766 VDD VSS sg13g2_decap_8
Xoutput76 mem_axi_awaddr[15] _16868_/X VDD VSS sg13g2_buf_1
Xoutput87 mem_axi_awaddr[26] _16879_/X VDD VSS sg13g2_buf_1
X_11073_ _14946_/D _14946_/Q _11074_/B _11072_/Y VDD VSS sg13g2_a21o_1
Xoutput98 mem_axi_awaddr[7] _16860_/X VDD VSS sg13g2_buf_1
XFILLER_89_883 VDD VSS sg13g2_decap_8
XFILLER_114_1202 VDD VSS sg13g2_fill_1
XFILLER_62_1145 VDD VSS sg13g2_fill_2
XFILLER_89_894 VDD VSS sg13g2_fill_2
XFILLER_131_980 VDD VSS sg13g2_fill_1
XFILLER_1_798 VDD VSS sg13g2_decap_4
XFILLER_88_371 VDD VSS sg13g2_fill_2
X_10024_ _14606_/D _10090_/A0 _14606_/Q wire601/A VDD VSS sg13g2_mux2_1
X_14655__1909 _14655_/RESET_B VDD VSS sg13g2_tiehi
X_14901_ _14901_/Q clkload39/A _14901_/D _14901_/RESET_B VDD VSS sg13g2_dfrbpq_1
XFILLER_76_533 VDD VSS sg13g2_decap_8
XFILLER_102_170 VDD VSS sg13g2_fill_1
XFILLER_62_1178 VDD VSS sg13g2_fill_1
XFILLER_37_909 VDD VSS sg13g2_fill_1
XFILLER_62_1189 VDD VSS sg13g2_fill_2
X_14832_ _14832_/Q clkload80/A _14832_/D _14832_/RESET_B VDD VSS sg13g2_dfrbpq_1
XFILLER_56_51 VDD VSS sg13g2_fill_1
XFILLER_76_588 VDD VSS sg13g2_decap_8
XFILLER_63_216 VDD VSS sg13g2_fill_2
XFILLER_5_1094 VDD VSS sg13g2_decap_8
X_14763_ _14763_/Q _14763_/CLK _14763_/D _14763_/RESET_B VDD VSS sg13g2_dfrbpq_1
X_11975_ _11975_/Y _11975_/A _11975_/B VDD VSS sg13g2_nor2_1
XFILLER_17_655 VDD VSS sg13g2_decap_4
XFILLER_45_964 VDD VSS sg13g2_decap_8
XFILLER_17_677 VDD VSS sg13g2_decap_8
X_13714_ _13714_/Q _14916_/CLK _13714_/D _13714_/RESET_B VDD VSS sg13g2_dfrbpq_1
XFILLER_17_688 VDD VSS sg13g2_decap_8
X_10926_ _10926_/X _10926_/A _10926_/B _11044_/C VDD VSS sg13g2_and3_1
XFILLER_16_165 VDD VSS sg13g2_decap_8
X_14694_ _14694_/Q _14726_/CLK _14694_/D _14694_/RESET_B VDD VSS sg13g2_dfrbpq_1
XFILLER_108_1006 VDD VSS sg13g2_fill_2
X_15023__2949 _15023_/RESET_B VDD VSS sg13g2_tiehi
X_10857_ _10857_/Y _10857_/A _10857_/B VDD VSS sg13g2_xnor2_1
X_13645_ _13753_/D _13645_/A VDD VSS sg13g2_buf_1
XFILLER_34_1236 VDD VSS sg13g2_fill_1
XFILLER_82_7 VDD VSS sg13g2_decap_8
XFILLER_12_360 VDD VSS sg13g2_decap_4
X_13576_ _15157_/D _13570_/S _13574_/Y _13575_/Y VDD VSS sg13g2_a21oi_1
X_10788_ _11199_/B _07614_/Y _09155_/Y _10788_/S VDD VSS sg13g2_mux2_1
X_12527_ _15001_/D _12527_/A _12527_/B VDD VSS sg13g2_nor2_1
XFILLER_121_1228 VDD VSS sg13g2_decap_8
X_15246_ _15246_/Q clkload31/A _15246_/D _15246_/RESET_B VDD VSS sg13g2_dfrbpq_1
X_12458_ _12471_/A _10213_/A _07737_/B hold3532/X VDD VSS sg13g2_a21oi_1
XFILLER_126_741 VDD VSS sg13g2_fill_1
X_11409_ _11409_/Y _11814_/S0 _14463_/Q VDD VSS sg13g2_nand2b_1
X_12389_ _12389_/X _14686_/Q _14718_/Q _13758_/Q _13790_/Q _12393_/S0 _12617_/S1 VDD
+ VSS sg13g2_mux4_1
XFILLER_67_1034 VDD VSS sg13g2_decap_4
XFILLER_119_1102 VDD VSS sg13g2_decap_4
X_15177_ _15177_/Q clkload74/A _15177_/D _15177_/RESET_B VDD VSS sg13g2_dfrbpq_1
XFILLER_141_711 VDD VSS sg13g2_decap_8
XFILLER_114_936 VDD VSS sg13g2_fill_2
XFILLER_126_796 VDD VSS sg13g2_fill_2
XFILLER_4_570 VDD VSS sg13g2_decap_8
X_14128_ _14128_/Q clkload49/A _14128_/D _14128_/RESET_B VDD VSS sg13g2_dfrbpq_1
XFILLER_113_424 VDD VSS sg13g2_fill_1
XFILLER_125_284 VDD VSS sg13g2_decap_8
XFILLER_86_308 VDD VSS sg13g2_fill_1
XFILLER_140_265 VDD VSS sg13g2_decap_8
X_14059_ _14059_/Q _14731_/CLK _14059_/D _14059_/RESET_B VDD VSS sg13g2_dfrbpq_1
XFILLER_39_213 VDD VSS sg13g2_fill_2
XFILLER_95_831 VDD VSS sg13g2_fill_2
XFILLER_100_129 VDD VSS sg13g2_decap_8
XFILLER_67_544 VDD VSS sg13g2_decap_8
XFILLER_95_864 VDD VSS sg13g2_fill_2
X_08620_ _08621_/C _07849_/B _08635_/A2 _08635_/A3 _08620_/A3 _08686_/S0 _08686_/S1
+ VDD VSS sg13g2_mux4_1
X_14813__3285 _14813_/RESET_B VDD VSS sg13g2_tiehi
XFILLER_55_728 VDD VSS sg13g2_fill_2
X_15063__1808 _15063_/RESET_B VDD VSS sg13g2_tiehi
XFILLER_94_396 VDD VSS sg13g2_decap_8
X_08551_ _08551_/X _08567_/B _08531_/B _07956_/Y VDD VSS sg13g2_a21o_1
XFILLER_36_953 VDD VSS sg13g2_fill_1
X_08482_ _15237_/D _08039_/A _08481_/X _08475_/Y VDD VSS sg13g2_o21ai_1
XFILLER_51_923 VDD VSS sg13g2_decap_8
XFILLER_78_1196 VDD VSS sg13g2_decap_8
XFILLER_74_1049 VDD VSS sg13g2_decap_8
XFILLER_90_591 VDD VSS sg13g2_decap_4
XFILLER_22_124 VDD VSS sg13g2_decap_4
XFILLER_50_433 VDD VSS sg13g2_fill_1
XFILLER_23_669 VDD VSS sg13g2_decap_4
XFILLER_50_466 VDD VSS sg13g2_decap_8
XFILLER_148_321 VDD VSS sg13g2_decap_8
XFILLER_149_855 VDD VSS sg13g2_fill_2
X_09103_ _09150_/B _13142_/A _14915_/Q _09103_/C _09103_/D VDD VSS sg13g2_and4_1
XFILLER_11_1000 VDD VSS sg13g2_decap_8
X_09034_ _09034_/X _15033_/Q _15230_/Q _09034_/S VDD VSS sg13g2_mux2_1
XFILLER_108_229 VDD VSS sg13g2_decap_8
XFILLER_102_1161 VDD VSS sg13g2_decap_8
XFILLER_144_560 VDD VSS sg13g2_decap_8
XFILLER_11_1077 VDD VSS sg13g2_decap_8
XFILLER_2_529 VDD VSS sg13g2_fill_2
XFILLER_117_35 VDD VSS sg13g2_decap_8
XFILLER_116_295 VDD VSS sg13g2_decap_8
Xfanout800 _08539_/B1 _08035_/X VDD VSS sg13g2_buf_1
Xfanout811 _13264_/B1 _13252_/B1 VDD VSS sg13g2_buf_1
XFILLER_77_308 VDD VSS sg13g2_decap_8
X_09936_ _14521_/D _14521_/Q _10135_/A0 _09936_/S VDD VSS sg13g2_mux2_1
Xfanout822 _13600_/B _12794_/X VDD VSS sg13g2_buf_1
Xfanout833 _12338_/A2 _11288_/Y VDD VSS sg13g2_buf_1
Xfanout855 _10735_/A _10757_/A VDD VSS sg13g2_buf_1
Xfanout866 fanout866/X _10788_/S VDD VSS sg13g2_buf_1
XFILLER_131_298 VDD VSS sg13g2_decap_8
XFILLER_86_842 VDD VSS sg13g2_decap_8
X_09867_ _14454_/D _14454_/Q _10098_/A0 _09869_/S VDD VSS sg13g2_mux2_1
Xfanout877 _08809_/C1 _08724_/Y VDD VSS sg13g2_buf_1
XFILLER_85_330 VDD VSS sg13g2_fill_1
Xfanout888 _08001_/C _08654_/B VDD VSS sg13g2_buf_1
XFILLER_58_566 VDD VSS sg13g2_fill_1
Xfanout899 _08001_/A _08689_/B1 VDD VSS sg13g2_buf_1
XFILLER_46_717 VDD VSS sg13g2_fill_1
XFILLER_133_67 VDD VSS sg13g2_decap_8
X_08818_ _08818_/Y _13690_/Q _13481_/C VDD VSS sg13g2_nor2_1
XFILLER_45_216 VDD VSS sg13g2_decap_8
X_09798_ _14387_/D _09930_/A1 _14387_/Q _09798_/S VDD VSS sg13g2_mux2_1
XFILLER_100_696 VDD VSS sg13g2_decap_4
XFILLER_2_1234 VDD VSS sg13g2_fill_2
XFILLER_26_21 VDD VSS sg13g2_decap_8
XFILLER_27_953 VDD VSS sg13g2_decap_8
XFILLER_22_1184 VDD VSS sg13g2_decap_8
XFILLER_73_558 VDD VSS sg13g2_decap_8
X_08749_ _08749_/Y _13668_/Q _08752_/B VDD VSS sg13g2_nor2_1
XFILLER_73_569 VDD VSS sg13g2_fill_1
X_11760_ _11761_/B _11760_/A _11760_/B _11760_/C VDD VSS sg13g2_nand3_1
XFILLER_26_98 VDD VSS sg13g2_decap_8
X_10711_ _14905_/D _10985_/B1 wire582/A _10708_/Y VDD VSS sg13g2_o21ai_1
XFILLER_81_591 VDD VSS sg13g2_decap_8
X_11691_ _11693_/A _11692_/A _14184_/Q VDD VSS sg13g2_nand2b_1
XFILLER_13_135 VDD VSS sg13g2_fill_2
XFILLER_41_466 VDD VSS sg13g2_decap_8
XFILLER_9_117 VDD VSS sg13g2_decap_8
X_13430_ _15097_/D _15097_/Q _13470_/A2 _13429_/Y VDD VSS sg13g2_a21o_1
X_10642_ _10643_/C _14888_/Q _14887_/Q _10642_/C VDD VSS sg13g2_and3_1
XFILLER_9_128 VDD VSS sg13g2_fill_1
X_13361_ _13361_/Y _13494_/B _13429_/A _13361_/C VDD VSS sg13g2_nor3_1
XFILLER_155_814 VDD VSS sg13g2_fill_1
X_10573_ _10577_/C _12895_/A _10591_/C _14870_/Q VDD VSS sg13g2_a21oi_1
XFILLER_10_864 VDD VSS sg13g2_decap_8
XFILLER_10_875 VDD VSS sg13g2_fill_2
X_15100_ _15100_/Q clkload71/A _15100_/D _15100_/RESET_B VDD VSS sg13g2_dfrbpq_1
XFILLER_155_847 VDD VSS sg13g2_decap_8
X_12312_ _12312_/Y _12303_/S _14618_/Q _12307_/C VDD VSS sg13g2_a21oi_1
X_13292_ _15055_/D _15055_/Q _07710_/Y _07694_/Y VDD VSS sg13g2_a21o_1
X_14709__1855 _14709_/RESET_B VDD VSS sg13g2_tiehi
XFILLER_6_868 VDD VSS sg13g2_decap_8
X_12243_ _12243_/Y _12255_/A1 _14680_/Q _11739_/B VDD VSS sg13g2_a21oi_1
X_15031_ _15031_/Q _15229_/CLK _15031_/D _15031_/RESET_B VDD VSS sg13g2_dfrbpq_1
XFILLER_5_367 VDD VSS sg13g2_fill_1
XFILLER_5_378 VDD VSS sg13g2_decap_8
X_12174_ _12174_/Y _12174_/A _12174_/B VDD VSS sg13g2_nor2_1
X_13973__2591 _13973_/RESET_B VDD VSS sg13g2_tiehi
XFILLER_3_14 VDD VSS sg13g2_decap_8
XFILLER_96_606 VDD VSS sg13g2_decap_8
X_11125_ _11128_/B _11171_/B _11147_/A VDD VSS sg13g2_xnor2_1
XFILLER_111_917 VDD VSS sg13g2_fill_2
XFILLER_96_628 VDD VSS sg13g2_decap_8
XFILLER_150_585 VDD VSS sg13g2_fill_2
XFILLER_49_522 VDD VSS sg13g2_decap_8
XFILLER_77_842 VDD VSS sg13g2_decap_8
X_11056_ _11056_/Y _11029_/C wire577/X _11082_/B1 VDD VSS sg13g2_o21ai_1
XFILLER_7_1145 VDD VSS sg13g2_decap_8
XFILLER_76_330 VDD VSS sg13g2_decap_8
X_10007_ _14589_/D _10107_/A0 _14589_/Q _10009_/S VDD VSS sg13g2_mux2_1
XFILLER_114_1054 VDD VSS sg13g2_decap_8
XFILLER_37_717 VDD VSS sg13g2_decap_8
XFILLER_64_525 VDD VSS sg13g2_decap_8
XFILLER_76_396 VDD VSS sg13g2_fill_2
XFILLER_114_1098 VDD VSS sg13g2_fill_1
X_14815_ _14815_/Q _14854_/CLK _14815_/D _14815_/RESET_B VDD VSS sg13g2_dfrbpq_1
XFILLER_18_953 VDD VSS sg13g2_decap_8
XFILLER_64_558 VDD VSS sg13g2_decap_8
XFILLER_17_430 VDD VSS sg13g2_decap_8
XFILLER_52_709 VDD VSS sg13g2_decap_4
XFILLER_45_750 VDD VSS sg13g2_fill_1
X_14746_ _14746_/Q clkload47/A _14746_/D _14746_/RESET_B VDD VSS sg13g2_dfrbpq_1
XFILLER_44_260 VDD VSS sg13g2_decap_8
X_11958_ _11958_/Y _11801_/S _14384_/Q VDD VSS sg13g2_nand2b_1
XFILLER_60_731 VDD VSS sg13g2_decap_4
XFILLER_72_591 VDD VSS sg13g2_fill_2
X_10909_ _10954_/D _10936_/A _10936_/D VDD VSS sg13g2_nand2_1
X_14677_ _14677_/Q clkload43/A _14677_/D _14677_/RESET_B VDD VSS sg13g2_dfrbpq_1
X_11889_ _11889_/Y _11885_/Y _11886_/Y _11888_/Y _11887_/Y _12317_/B VDD VSS sg13g2_a221oi_1
X_15074__3238 _15074_/RESET_B VDD VSS sg13g2_tiehi
XFILLER_73_1060 VDD VSS sg13g2_decap_8
X_13628_ _13736_/D _13628_/A VDD VSS sg13g2_buf_1
XFILLER_34_1022 VDD VSS sg13g2_fill_2
XFILLER_73_1071 VDD VSS sg13g2_fill_2
XFILLER_13_680 VDD VSS sg13g2_decap_8
XFILLER_125_1161 VDD VSS sg13g2_decap_8
XFILLER_125_1172 VDD VSS sg13g2_fill_1
X_13559_ _13559_/Y _08173_/B _13600_/B _13558_/Y VDD VSS sg13g2_a21oi_1
XFILLER_146_825 VDD VSS sg13g2_decap_8
XFILLER_34_1077 VDD VSS sg13g2_fill_2
Xmax_cap1662 _11578_/S0 _11580_/S0 VDD VSS sg13g2_buf_4
X_15229_ _15229_/Q _15229_/CLK _15229_/D _15229_/RESET_B VDD VSS sg13g2_dfrbpq_1
XFILLER_99_400 VDD VSS sg13g2_decap_4
XFILLER_153_390 VDD VSS sg13g2_decap_8
X_13803__2761 _13803_/RESET_B VDD VSS sg13g2_tiehi
XFILLER_99_455 VDD VSS sg13g2_decap_8
XFILLER_102_906 VDD VSS sg13g2_decap_8
X_07982_ _07985_/B _07834_/B _07980_/Y _15216_/Q VDD VSS sg13g2_o21ai_1
XFILLER_101_427 VDD VSS sg13g2_decap_4
X_09721_ _14312_/D _09787_/A0 _14312_/Q _09737_/S VDD VSS sg13g2_mux2_1
XFILLER_86_138 VDD VSS sg13g2_fill_2
XFILLER_101_449 VDD VSS sg13g2_decap_4
XFILLER_45_1184 VDD VSS sg13g2_decap_8
XFILLER_67_330 VDD VSS sg13g2_decap_8
XFILLER_41_1026 VDD VSS sg13g2_decap_4
XFILLER_80_1075 VDD VSS sg13g2_fill_2
X_14147__2417 _14147_/RESET_B VDD VSS sg13g2_tiehi
XFILLER_41_1037 VDD VSS sg13g2_decap_8
XFILLER_67_352 VDD VSS sg13g2_decap_4
XFILLER_132_1165 VDD VSS sg13g2_decap_4
X_09652_ _14245_/D _09916_/A1 _14245_/Q _09666_/S VDD VSS sg13g2_mux2_1
XFILLER_67_374 VDD VSS sg13g2_fill_1
XFILLER_83_834 VDD VSS sg13g2_fill_2
XFILLER_132_1198 VDD VSS sg13g2_decap_8
XFILLER_55_536 VDD VSS sg13g2_fill_2
Xclkbuf_5_18__f_clk_i clkbuf_leaf_52_clk_i/A clkbuf_4_9_0_clk_i/X VDD VSS sg13g2_buf_16
XFILLER_27_238 VDD VSS sg13g2_fill_2
X_08603_ _08603_/Y _13533_/A _08603_/B VDD VSS sg13g2_nand2b_1
X_09583_ _14180_/D _14180_/Q _09616_/A0 _09587_/S VDD VSS sg13g2_mux2_1
XFILLER_82_344 VDD VSS sg13g2_decap_8
X_08534_ _08535_/A _08567_/B _08532_/Y _08533_/Y VDD VSS sg13g2_o21ai_1
XFILLER_23_400 VDD VSS sg13g2_fill_2
XFILLER_36_783 VDD VSS sg13g2_decap_8
XFILLER_24_945 VDD VSS sg13g2_decap_8
XFILLER_35_282 VDD VSS sg13g2_decap_8
X_14362__2202 _14362_/RESET_B VDD VSS sg13g2_tiehi
XFILLER_35_293 VDD VSS sg13g2_fill_1
X_08465_ _08465_/X _11865_/A _07804_/B _07800_/B _11770_/A _08686_/S0 _08686_/S1 VDD
+ VSS sg13g2_mux4_1
X_08396_ _15233_/D _08395_/Y _08393_/Y _08388_/Y VDD VSS sg13g2_a21o_1
XFILLER_23_499 VDD VSS sg13g2_decap_8
XFILLER_52_1144 VDD VSS sg13g2_decap_8
XFILLER_104_1212 VDD VSS sg13g2_decap_8
Xwire519 wire519/X wire519/A VDD VSS sg13g2_buf_2
XFILLER_13_1139 VDD VSS sg13g2_decap_8
XFILLER_109_538 VDD VSS sg13g2_fill_1
XFILLER_12_56 VDD VSS sg13g2_decap_8
X_14395__2169 _14395_/RESET_B VDD VSS sg13g2_tiehi
X_09017_ _09017_/Y _09141_/A _10697_/B _12942_/A _09018_/A2 VDD VSS sg13g2_a22oi_1
X_14851__3227 _14851_/RESET_B VDD VSS sg13g2_tiehi
XFILLER_2_326 VDD VSS sg13g2_decap_8
XFILLER_88_49 VDD VSS sg13g2_fill_2
XFILLER_105_755 VDD VSS sg13g2_decap_4
Xfanout1606 _11953_/C _12308_/C VDD VSS sg13g2_buf_1
Xfanout1617 fanout1617/X fanout1634/X VDD VSS sg13g2_buf_1
XFILLER_137_1087 VDD VSS sg13g2_decap_8
Xfanout630 _09778_/S wire633/X VDD VSS sg13g2_buf_1
Xfanout1628 _12248_/B1 _12236_/C VDD VSS sg13g2_buf_1
Xfanout1639 fanout1639/X fanout1650/X VDD VSS sg13g2_buf_1
XFILLER_120_747 VDD VSS sg13g2_decap_8
XFILLER_144_77 VDD VSS sg13g2_fill_1
Xfanout652 wire653/A _09540_/Y VDD VSS sg13g2_buf_1
X_09919_ _14504_/D _14504_/Q _09919_/A1 wire423/X VDD VSS sg13g2_mux2_1
XFILLER_19_706 VDD VSS sg13g2_decap_8
XFILLER_58_352 VDD VSS sg13g2_decap_8
X_12930_ _12930_/Y _14807_/Q _07728_/A _12930_/B1 _14839_/Q _13082_/B VDD VSS sg13g2_a221oi_1
XFILLER_86_683 VDD VSS sg13g2_decap_8
XFILLER_18_249 VDD VSS sg13g2_decap_8
X_12861_ _12861_/X _12861_/A _12861_/B VDD VSS sg13g2_xor2_1
X_14600_ _14600_/Q clkload27/A _14600_/D _14600_/RESET_B VDD VSS sg13g2_dfrbpq_1
XFILLER_61_517 VDD VSS sg13g2_decap_8
XFILLER_27_772 VDD VSS sg13g2_decap_8
X_11812_ _11812_/Y _11814_/S0 _14668_/Q _11416_/B VDD VSS sg13g2_a21oi_1
X_12792_ _15020_/D _12792_/A wire366/X VDD VSS sg13g2_nor2_1
XFILLER_14_411 VDD VSS sg13g2_decap_8
XFILLER_109_1101 VDD VSS sg13g2_fill_1
XFILLER_54_591 VDD VSS sg13g2_decap_8
XFILLER_156_0 VDD VSS sg13g2_decap_8
X_14531_ _14531_/Q clkload1/A _14531_/D _14531_/RESET_B VDD VSS sg13g2_dfrbpq_1
X_11743_ _11743_/Y _11743_/A _11743_/B _11761_/C VDD VSS sg13g2_nand3_1
XFILLER_144_1014 VDD VSS sg13g2_fill_1
XFILLER_57_1077 VDD VSS sg13g2_decap_8
X_13845__2719 _13845_/RESET_B VDD VSS sg13g2_tiehi
XFILLER_41_263 VDD VSS sg13g2_decap_8
X_14462_ _14462_/Q _14494_/CLK _14462_/D _14462_/RESET_B VDD VSS sg13g2_dfrbpq_1
X_11674_ _11674_/Y _11692_/A _14600_/Q _11693_/C VDD VSS sg13g2_a21oi_1
X_13413_ _13444_/B _15198_/Q _15199_/Q _13490_/B _13490_/C VDD VSS sg13g2_or4_1
X_10625_ _10626_/A _14883_/Q _14882_/Q _10651_/D _10625_/D VDD VSS sg13g2_nand4_1
X_14393_ _14393_/Q clkload42/A _14393_/D _14393_/RESET_B VDD VSS sg13g2_dfrbpq_1
XFILLER_128_836 VDD VSS sg13g2_decap_4
X_13344_ _15069_/D _13341_/A _15174_/D _13343_/Y VDD VSS sg13g2_o21ai_1
X_10556_ _10557_/B _14867_/Q _14866_/Q _14865_/Q _10556_/D VDD VSS sg13g2_nand4_1
X_14225__2339 _14225_/RESET_B VDD VSS sg13g2_tiehi
XFILLER_154_154 VDD VSS sg13g2_decap_8
XFILLER_143_817 VDD VSS sg13g2_decap_4
X_10487_ _14849_/D _10602_/A _10487_/B _10495_/D VDD VSS sg13g2_nor3_1
X_13275_ _13275_/Y _10330_/A _13275_/A2 _13297_/A0 VDD VSS sg13g2_o21ai_1
XFILLER_68_1140 VDD VSS sg13g2_fill_1
XFILLER_136_891 VDD VSS sg13g2_decap_8
X_15014_ _15014_/Q _15160_/CLK _15014_/D _15014_/RESET_B VDD VSS sg13g2_dfrbpq_1
X_12226_ _14985_/D _12203_/A _12126_/A _12225_/Y VDD VSS sg13g2_a21o_1
XFILLER_45_7 VDD VSS sg13g2_decap_8
XFILLER_9_1218 VDD VSS sg13g2_decap_8
X_12157_ _12157_/Y _12168_/A _14134_/Q VDD VSS sg13g2_nand2b_1
XFILLER_111_714 VDD VSS sg13g2_decap_8
XFILLER_116_1116 VDD VSS sg13g2_decap_8
XFILLER_151_894 VDD VSS sg13g2_decap_8
XFILLER_29_1179 VDD VSS sg13g2_decap_8
X_11108_ _11109_/A _10764_/X _11097_/Y _11107_/Y VDD VSS sg13g2_o21ai_1
XFILLER_110_224 VDD VSS sg13g2_fill_2
XFILLER_155_1198 VDD VSS sg13g2_decap_8
X_14440__2124 _14440_/RESET_B VDD VSS sg13g2_tiehi
X_12088_ _12092_/A _12087_/X _12088_/B VDD VSS sg13g2_nand2b_1
XFILLER_68_149 VDD VSS sg13g2_decap_8
XFILLER_84_609 VDD VSS sg13g2_decap_8
XFILLER_77_661 VDD VSS sg13g2_decap_8
XFILLER_110_268 VDD VSS sg13g2_fill_2
XFILLER_83_108 VDD VSS sg13g2_fill_1
X_11039_ _11043_/B _11040_/A wire239/X _11052_/B VDD VSS sg13g2_o21ai_1
XFILLER_76_171 VDD VSS sg13g2_fill_1
X_15170__2872 _15170_/RESET_B VDD VSS sg13g2_tiehi
XFILLER_92_642 VDD VSS sg13g2_decap_8
XFILLER_64_344 VDD VSS sg13g2_decap_8
XFILLER_65_878 VDD VSS sg13g2_decap_4
XFILLER_64_377 VDD VSS sg13g2_fill_1
XFILLER_91_163 VDD VSS sg13g2_fill_2
XFILLER_17_260 VDD VSS sg13g2_fill_1
X_14729_ _14729_/Q clkload1/A _14729_/D _14729_/RESET_B VDD VSS sg13g2_dfrbpq_1
XFILLER_32_230 VDD VSS sg13g2_decap_8
X_08250_ _08250_/X _08318_/A _08250_/B VDD VSS sg13g2_xor2_1
XFILLER_75_1188 VDD VSS sg13g2_decap_8
XFILLER_75_1199 VDD VSS sg13g2_fill_2
XFILLER_123_1109 VDD VSS sg13g2_decap_8
XFILLER_32_296 VDD VSS sg13g2_decap_8
X_08181_ _08183_/C _07870_/A _08463_/A _08162_/Y VDD VSS sg13g2_a21oi_1
XFILLER_119_814 VDD VSS sg13g2_decap_4
XFILLER_71_0 VDD VSS sg13g2_decap_8
X_14650__1914 _14650_/RESET_B VDD VSS sg13g2_tiehi
XFILLER_12_1172 VDD VSS sg13g2_decap_8
XFILLER_133_349 VDD VSS sg13g2_fill_1
XFILLER_99_252 VDD VSS sg13g2_fill_1
XFILLER_142_872 VDD VSS sg13g2_decap_8
XFILLER_87_425 VDD VSS sg13g2_fill_2
X_07965_ _07965_/Y _15016_/Q _08012_/B VDD VSS sg13g2_nand2b_1
XFILLER_102_769 VDD VSS sg13g2_decap_4
XFILLER_114_14 VDD VSS sg13g2_decap_8
X_09704_ _14296_/D _09902_/A0 _14296_/Q wire458/X VDD VSS sg13g2_mux2_1
X_07896_ _07896_/X _08023_/A _07903_/B VDD VSS sg13g2_and2_1
XFILLER_83_620 VDD VSS sg13g2_fill_2
XFILLER_95_491 VDD VSS sg13g2_decap_8
X_09635_ _14231_/D _10033_/A0 _14231_/Q _09635_/S VDD VSS sg13g2_mux2_1
XFILLER_55_344 VDD VSS sg13g2_fill_1
XFILLER_56_889 VDD VSS sg13g2_fill_2
XFILLER_71_826 VDD VSS sg13g2_decap_4
XFILLER_71_837 VDD VSS sg13g2_fill_1
XFILLER_82_163 VDD VSS sg13g2_decap_8
X_09566_ _14164_/D _10163_/A1 _14164_/Q _09566_/S VDD VSS sg13g2_mux2_1
XFILLER_36_580 VDD VSS sg13g2_decap_8
XFILLER_130_35 VDD VSS sg13g2_decap_8
XFILLER_24_731 VDD VSS sg13g2_fill_1
X_08517_ _15239_/D _08517_/A _08517_/B _08517_/C _08517_/D VDD VSS sg13g2_nand4_1
XFILLER_23_241 VDD VSS sg13g2_decap_4
XFILLER_12_904 VDD VSS sg13g2_decap_8
X_09497_ _14097_/D _09994_/A0 _14097_/Q wire480/X VDD VSS sg13g2_mux2_1
X_08448_ _08448_/Y _08497_/A _08443_/Y _08447_/X VDD VSS sg13g2_a21oi_1
XFILLER_11_436 VDD VSS sg13g2_fill_2
XFILLER_17_1050 VDD VSS sg13g2_decap_8
Xwire305 wire305/X wire305/A VDD VSS sg13g2_buf_2
X_08379_ _08379_/Y _08621_/A _08544_/A VDD VSS sg13g2_nand2_1
XFILLER_104_1020 VDD VSS sg13g2_decap_8
Xwire327 wire327/X wire327/A VDD VSS sg13g2_buf_2
XFILLER_23_77 VDD VSS sg13g2_decap_8
XFILLER_149_482 VDD VSS sg13g2_decap_8
X_10410_ _10414_/D _14823_/Q _14824_/Q _14825_/Q _14826_/Q VDD VSS sg13g2_and4_1
XFILLER_20_981 VDD VSS sg13g2_decap_8
X_11390_ _11391_/A _11418_/A _13887_/Q VDD VSS sg13g2_nand2b_1
XFILLER_139_77 VDD VSS sg13g2_decap_8
XFILLER_104_1064 VDD VSS sg13g2_decap_8
X_10341_ _10343_/A _10405_/C _10357_/D _14807_/Q VDD VSS sg13g2_a21o_1
Xclkbuf_leaf_124_clk_i _14505_/CLK clkbuf_5_2__f_clk_i/X VDD VSS sg13g2_buf_8
X_14772__3326 _14772_/RESET_B VDD VSS sg13g2_tiehi
XFILLER_155_21 VDD VSS sg13g2_decap_8
XFILLER_2_112 VDD VSS sg13g2_decap_8
X_13060_ _13060_/Y _13042_/A _13037_/Y _13057_/C VDD VSS sg13g2_o21ai_1
X_10272_ _10281_/D _10299_/A _10299_/B VDD VSS sg13g2_nor2_1
XFILLER_124_349 VDD VSS sg13g2_decap_4
XFILLER_79_904 VDD VSS sg13g2_fill_2
X_12011_ _12011_/X _12012_/A _11988_/Y _12055_/D VDD VSS sg13g2_a21o_1
XFILLER_155_98 VDD VSS sg13g2_decap_8
Xfanout1403 _08692_/B _12300_/A VDD VSS sg13g2_buf_1
Xfanout1414 _08012_/B _07849_/B VDD VSS sg13g2_buf_1
XFILLER_132_393 VDD VSS sg13g2_decap_8
Xfanout1425 _12061_/A _14981_/Q VDD VSS sg13g2_buf_1
Xfanout1436 _07821_/B _07819_/B VDD VSS sg13g2_buf_1
XFILLER_94_907 VDD VSS sg13g2_decap_8
XFILLER_59_650 VDD VSS sg13g2_decap_8
Xfanout1447 _07800_/B _11798_/A VDD VSS sg13g2_buf_1
Xfanout1458 _07782_/A _11661_/A VDD VSS sg13g2_buf_1
Xfanout471 fanout471/X _09606_/Y VDD VSS sg13g2_buf_1
XFILLER_4_1104 VDD VSS sg13g2_decap_8
Xfanout1469 _11570_/A _14967_/Q VDD VSS sg13g2_buf_1
XFILLER_65_108 VDD VSS sg13g2_decap_8
XFILLER_24_1043 VDD VSS sg13g2_decap_8
X_13962_ _13962_/Q clkload25/A _13962_/D _13962_/RESET_B VDD VSS sg13g2_dfrbpq_1
XFILLER_58_160 VDD VSS sg13g2_decap_8
XFILLER_59_694 VDD VSS sg13g2_decap_8
Xwire1564 _16861_/A _13699_/Q VDD VSS sg13g2_buf_8
XFILLER_58_171 VDD VSS sg13g2_fill_1
XFILLER_111_1024 VDD VSS sg13g2_decap_4
XFILLER_0_15 VDD VSS sg13g2_decap_8
XFILLER_46_322 VDD VSS sg13g2_decap_4
XFILLER_74_631 VDD VSS sg13g2_fill_2
XFILLER_58_193 VDD VSS sg13g2_fill_2
XFILLER_98_1144 VDD VSS sg13g2_fill_1
X_12913_ _12914_/C _13045_/A1 _12844_/B input10/X VDD VSS sg13g2_a21oi_1
XFILLER_0_37 VDD VSS sg13g2_decap_4
X_13893_ _13893_/Q clkload4/A _13893_/D _13893_/RESET_B VDD VSS sg13g2_dfrbpq_1
XFILLER_104_91 VDD VSS sg13g2_decap_8
XFILLER_61_314 VDD VSS sg13g2_decap_8
XFILLER_74_697 VDD VSS sg13g2_fill_1
X_12844_ _12845_/D _12899_/A _12844_/B _12844_/C input23/X VDD VSS sg13g2_nand4_1
X_12775_ _12775_/X _12769_/X _12773_/X _12768_/X _12772_/X _12581_/S _12775_/S1 VDD
+ VSS sg13g2_mux4_1
XFILLER_14_241 VDD VSS sg13g2_fill_1
XFILLER_42_561 VDD VSS sg13g2_decap_8
XFILLER_70_870 VDD VSS sg13g2_fill_2
XFILLER_9_35 VDD VSS sg13g2_decap_8
X_14514_ _14514_/Q clkload48/A _14514_/D _14514_/RESET_B VDD VSS sg13g2_dfrbpq_1
X_11726_ _11773_/D _11726_/A _13678_/Q VDD VSS sg13g2_xnor2_1
XFILLER_14_285 VDD VSS sg13g2_fill_1
X_14445_ _14445_/Q _14669_/CLK _14445_/D _14445_/RESET_B VDD VSS sg13g2_dfrbpq_1
X_11657_ _11657_/Y _11656_/Y _11655_/Y _11643_/Y _12269_/A2 _11701_/C1 VDD VSS sg13g2_a221oi_1
XFILLER_80_83 VDD VSS sg13g2_decap_8
X_14458__2106 _14458_/RESET_B VDD VSS sg13g2_tiehi
XFILLER_35_1194 VDD VSS sg13g2_decap_8
X_10608_ _14878_/D _10629_/C _10623_/A _10608_/C VDD VSS sg13g2_nor3_1
X_14376_ _14376_/Q clkload30/A _14376_/D _14376_/RESET_B VDD VSS sg13g2_dfrbpq_1
X_11588_ _14967_/D _11570_/A _11701_/C1 _11587_/Y VDD VSS sg13g2_a21o_1
XFILLER_6_440 VDD VSS sg13g2_decap_8
XFILLER_128_666 VDD VSS sg13g2_decap_8
Xmax_cap605 _10000_/S _09999_/S VDD VSS sg13g2_buf_4
XFILLER_122_1186 VDD VSS sg13g2_decap_4
XFILLER_155_474 VDD VSS sg13g2_decap_8
X_13327_ _13328_/B _15114_/Q wire810/X _13309_/Y _09905_/A VDD VSS sg13g2_a22oi_1
XFILLER_128_688 VDD VSS sg13g2_decap_8
X_10539_ _14861_/D _10543_/C _10543_/D _10535_/B _07622_/Y _13507_/A VDD VSS sg13g2_a221oi_1
Xmax_cap649 _09571_/S _09564_/S VDD VSS sg13g2_buf_4
XFILLER_6_495 VDD VSS sg13g2_decap_8
XFILLER_142_135 VDD VSS sg13g2_decap_8
X_13258_ _13259_/B _14924_/Q _13663_/Q VDD VSS sg13g2_xnor2_1
XFILLER_142_157 VDD VSS sg13g2_fill_2
X_12209_ _12210_/B _14711_/Q _14743_/Q _13783_/Q _13815_/Q _12213_/S0 _12169_/C VDD
+ VSS sg13g2_mux4_1
XFILLER_69_403 VDD VSS sg13g2_fill_1
X_13189_ _13189_/X _14918_/Q _13189_/B _13225_/B VDD VSS sg13g2_and3_1
XFILLER_97_745 VDD VSS sg13g2_decap_4
XFILLER_111_522 VDD VSS sg13g2_decap_4
XFILLER_123_382 VDD VSS sg13g2_decap_4
XFILLER_150_190 VDD VSS sg13g2_fill_1
XFILLER_97_778 VDD VSS sg13g2_fill_2
XFILLER_111_577 VDD VSS sg13g2_decap_8
XFILLER_56_119 VDD VSS sg13g2_decap_4
X_07750_ _15207_/D _07750_/A _07750_/B VDD VSS sg13g2_or2_1
XFILLER_42_1154 VDD VSS sg13g2_fill_1
XFILLER_65_631 VDD VSS sg13g2_decap_8
XFILLER_93_940 VDD VSS sg13g2_fill_1
XFILLER_38_856 VDD VSS sg13g2_decap_8
X_07681_ _07687_/A _07677_/Y _07680_/Y _08832_/D _11241_/A VDD VSS sg13g2_a22oi_1
X_14064__2500 _14064_/RESET_B VDD VSS sg13g2_tiehi
X_16879_ _16879_/X _16879_/A VDD VSS sg13g2_buf_1
XFILLER_64_130 VDD VSS sg13g2_fill_2
XFILLER_65_675 VDD VSS sg13g2_decap_8
XFILLER_53_826 VDD VSS sg13g2_decap_8
X_09420_ _14022_/D _09653_/A0 _14022_/Q _09421_/S VDD VSS sg13g2_mux2_1
XFILLER_53_837 VDD VSS sg13g2_fill_1
XFILLER_18_580 VDD VSS sg13g2_decap_8
XFILLER_64_185 VDD VSS sg13g2_decap_8
X_09351_ _13955_/D _09650_/A0 _13955_/Q _09371_/S VDD VSS sg13g2_mux2_1
XFILLER_80_667 VDD VSS sg13g2_fill_2
XFILLER_61_870 VDD VSS sg13g2_decap_8
X_14704__1860 _14704_/RESET_B VDD VSS sg13g2_tiehi
X_08302_ _08625_/B _08138_/A _08234_/Y _08617_/A _08301_/X VDD VSS sg13g2_a22oi_1
X_09282_ _13890_/D _13890_/Q _10145_/A1 _09302_/S VDD VSS sg13g2_mux2_1
XFILLER_20_200 VDD VSS sg13g2_fill_1
XFILLER_127_1053 VDD VSS sg13g2_fill_2
X_14097__2467 _14097_/RESET_B VDD VSS sg13g2_tiehi
X_08233_ _15225_/D _08232_/Y _08233_/B _08233_/C VDD VSS sg13g2_nand3b_1
XFILLER_119_600 VDD VSS sg13g2_decap_8
XFILLER_147_920 VDD VSS sg13g2_decap_8
XFILLER_147_942 VDD VSS sg13g2_decap_4
X_08164_ _08164_/Y _08163_/Y _07871_/X _08039_/A VDD VSS sg13g2_a21oi_1
Xclkbuf_leaf_41_clk_i clkload52/A clkbuf_leaf_48_clk_i/A VDD VSS sg13g2_buf_8
XFILLER_109_14 VDD VSS sg13g2_decap_4
XFILLER_119_666 VDD VSS sg13g2_decap_8
XFILLER_101_1226 VDD VSS sg13g2_decap_8
X_08095_ _08199_/C _08337_/A3 _08306_/C _08376_/A3 _07782_/A _08457_/S0 _08099_/S0
+ VDD VSS sg13g2_mux4_1
X_15036__2936 _15036_/RESET_B VDD VSS sg13g2_tiehi
XFILLER_118_176 VDD VSS sg13g2_decap_8
XFILLER_106_327 VDD VSS sg13g2_fill_1
XFILLER_118_187 VDD VSS sg13g2_fill_1
Xclkload70 clkload70/Y clkload70/A VDD VSS sg13g2_inv_2
XFILLER_118_198 VDD VSS sg13g2_decap_8
Xclkload81 clkload81/Y clkload81/A VDD VSS sg13g2_inv_1
XFILLER_134_669 VDD VSS sg13g2_decap_4
Xhold3500 _10987_/A _14941_/Q VDD VSS sg13g2_dlygate4sd3_1
Xclkbuf_leaf_56_clk_i _15212_/CLK clkbuf_leaf_84_clk_i/A VDD VSS sg13g2_buf_8
Xhold3511 hold3511/X _15105_/Q VDD VSS sg13g2_dlygate4sd3_1
XFILLER_121_319 VDD VSS sg13g2_fill_2
Xhold3522 hold3522/X _13708_/Q VDD VSS sg13g2_dlygate4sd3_1
XFILLER_142_680 VDD VSS sg13g2_decap_8
Xhold3533 _13581_/A _15159_/Q VDD VSS sg13g2_dlygate4sd3_1
XFILLER_142_691 VDD VSS sg13g2_fill_1
XFILLER_47_1076 VDD VSS sg13g2_fill_2
XFILLER_102_555 VDD VSS sg13g2_decap_8
X_08997_ _13760_/D _13760_/Q _10143_/A1 _09160_/S VDD VSS sg13g2_mux2_1
XFILLER_85_28 VDD VSS sg13g2_decap_8
XFILLER_130_897 VDD VSS sg13g2_decap_8
XFILLER_75_439 VDD VSS sg13g2_decap_8
X_07948_ _07950_/B _07948_/A _08443_/A _07950_/A _07949_/B VDD VSS sg13g2_nand4_1
XFILLER_84_951 VDD VSS sg13g2_decap_4
X_07879_ _07879_/Y _07879_/A _08200_/B VDD VSS sg13g2_xnor2_1
XFILLER_18_77 VDD VSS sg13g2_decap_8
X_14536__2028 _14536_/RESET_B VDD VSS sg13g2_tiehi
XFILLER_141_56 VDD VSS sg13g2_decap_8
X_09618_ _14214_/D _09884_/A0 _14214_/Q _09631_/S VDD VSS sg13g2_mux2_1
XFILLER_83_472 VDD VSS sg13g2_decap_8
XFILLER_3_1181 VDD VSS sg13g2_decap_8
X_10890_ _10890_/Y _10890_/A _10890_/B _10890_/C VDD VSS sg13g2_nor3_1
XFILLER_71_667 VDD VSS sg13g2_decap_8
XFILLER_34_21 VDD VSS sg13g2_decap_8
X_09549_ _14147_/D _09650_/A0 _14147_/Q _09553_/S VDD VSS sg13g2_mux2_1
X_15084__3210 _15084_/RESET_B VDD VSS sg13g2_tiehi
XFILLER_71_678 VDD VSS sg13g2_fill_1
XFILLER_34_43 VDD VSS sg13g2_fill_2
XFILLER_54_1003 VDD VSS sg13g2_decap_4
XFILLER_34_54 VDD VSS sg13g2_decap_4
X_12560_ _12560_/X _14250_/Q _14282_/Q _14314_/Q _14346_/Q _12564_/S0 _12564_/S1 VDD
+ VSS sg13g2_mux4_1
XFILLER_19_1156 VDD VSS sg13g2_decap_8
X_14826__3272 _14826_/RESET_B VDD VSS sg13g2_tiehi
XFILLER_34_76 VDD VSS sg13g2_decap_8
XFILLER_93_1096 VDD VSS sg13g2_decap_8
XFILLER_34_87 VDD VSS sg13g2_fill_1
XFILLER_12_745 VDD VSS sg13g2_decap_8
XFILLER_145_1175 VDD VSS sg13g2_fill_1
X_13762__2802 _13762_/RESET_B VDD VSS sg13g2_tiehi
X_11511_ _11511_/X _14563_/Q _14595_/Q _14627_/Q _14659_/Q _11514_/S0 _11715_/S1 VDD
+ VSS sg13g2_mux4_1
XFILLER_12_767 VDD VSS sg13g2_decap_8
XFILLER_8_716 VDD VSS sg13g2_fill_1
XFILLER_141_1039 VDD VSS sg13g2_decap_8
XFILLER_138_920 VDD VSS sg13g2_decap_8
X_12491_ _12491_/X _14565_/Q _14597_/Q _14629_/Q _14661_/Q _12492_/S0 _12494_/S1 VDD
+ VSS sg13g2_mux4_1
XFILLER_138_931 VDD VSS sg13g2_fill_2
X_14230_ _14230_/Q _14710_/CLK _14230_/D _14230_/RESET_B VDD VSS sg13g2_dfrbpq_1
X_11442_ _11443_/B _13824_/Q _13856_/Q _13888_/Q _13920_/Q _12100_/S0 _11598_/C VDD
+ VSS sg13g2_mux4_1
Xwire146 wire146/X wire146/A VDD VSS sg13g2_buf_1
XFILLER_153_923 VDD VSS sg13g2_decap_8
X_11373_ _11374_/B _11373_/A _14206_/Q VDD VSS sg13g2_nand2_1
XFILLER_50_75 VDD VSS sg13g2_decap_8
XFILLER_109_165 VDD VSS sg13g2_fill_2
XFILLER_119_0 VDD VSS sg13g2_decap_8
X_14161_ _14161_/Q clkload44/A _14161_/D _14161_/RESET_B VDD VSS sg13g2_dfrbpq_1
XFILLER_3_421 VDD VSS sg13g2_decap_8
X_13112_ _13172_/C _13112_/A _13104_/A VDD VSS sg13g2_nor2b_1
X_10324_ _10325_/B _14799_/Q _14800_/Q _14801_/Q _10405_/C VDD VSS sg13g2_nand4_1
X_14142__2422 _14142_/RESET_B VDD VSS sg13g2_tiehi
X_14092_ _14092_/Q clkload51/A _14092_/D _14092_/RESET_B VDD VSS sg13g2_dfrbpq_1
XFILLER_153_989 VDD VSS sg13g2_decap_8
XFILLER_106_850 VDD VSS sg13g2_fill_1
X_13795__2769 _13795_/RESET_B VDD VSS sg13g2_tiehi
XFILLER_106_861 VDD VSS sg13g2_decap_8
XFILLER_1_0 VDD VSS sg13g2_decap_8
XFILLER_112_308 VDD VSS sg13g2_fill_1
X_10255_ _10265_/D _14778_/Q _14779_/Q _14780_/Q _10255_/D VDD VSS sg13g2_nand4_1
XFILLER_3_476 VDD VSS sg13g2_fill_1
X_13043_ _13043_/Y _13041_/Y _13043_/B _13247_/D VDD VSS sg13g2_nand3b_1
XFILLER_112_319 VDD VSS sg13g2_decap_8
XFILLER_78_211 VDD VSS sg13g2_decap_4
Xfanout1200 _12378_/S0 _12381_/S0 VDD VSS sg13g2_buf_1
XFILLER_3_498 VDD VSS sg13g2_decap_8
Xfanout1211 _12366_/S0 _12351_/S0 VDD VSS sg13g2_buf_1
X_14746__1818 _14746_/RESET_B VDD VSS sg13g2_tiehi
X_10186_ _14749_/D _10185_/Y _14749_/Q _08956_/S VDD VSS sg13g2_a21o_1
Xfanout1222 _13289_/C _11236_/B VDD VSS sg13g2_buf_1
XFILLER_26_1149 VDD VSS sg13g2_decap_8
Xfanout1233 _13300_/C _13293_/C VDD VSS sg13g2_buf_1
Xfanout1244 _13537_/B _13563_/C VDD VSS sg13g2_buf_1
XFILLER_113_1108 VDD VSS sg13g2_decap_4
XFILLER_152_1168 VDD VSS sg13g2_decap_8
Xfanout1255 _13401_/C _10199_/A1 VDD VSS sg13g2_buf_1
XFILLER_120_363 VDD VSS sg13g2_fill_1
Xfanout1266 _13028_/B _13180_/B1 VDD VSS sg13g2_buf_1
XFILLER_19_311 VDD VSS sg13g2_fill_2
X_14994_ _14994_/Q clkload40/A _14994_/D _14994_/RESET_B VDD VSS sg13g2_dfrbpq_1
Xfanout1277 _13206_/B _15106_/Q VDD VSS sg13g2_buf_1
X_14175__2389 _14175_/RESET_B VDD VSS sg13g2_tiehi
Xfanout290 _10150_/A1 _10117_/A0 VDD VSS sg13g2_buf_1
Xfanout1288 _11179_/B _11191_/A VDD VSS sg13g2_buf_1
XFILLER_59_491 VDD VSS sg13g2_decap_8
Xfanout1299 _08751_/A1 _15069_/Q VDD VSS sg13g2_buf_1
X_13945_ _13945_/Q clkload15/A _13945_/D _13945_/RESET_B VDD VSS sg13g2_dfrbpq_1
XFILLER_93_269 VDD VSS sg13g2_decap_8
XFILLER_47_675 VDD VSS sg13g2_fill_2
XFILLER_74_450 VDD VSS sg13g2_fill_2
XFILLER_75_83 VDD VSS sg13g2_decap_8
XFILLER_74_483 VDD VSS sg13g2_decap_8
XFILLER_90_932 VDD VSS sg13g2_decap_4
XFILLER_19_399 VDD VSS sg13g2_fill_2
X_13876_ _13876_/Q clkload32/A _13876_/D _13876_/RESET_B VDD VSS sg13g2_dfrbpq_1
XFILLER_90_943 VDD VSS sg13g2_fill_1
XFILLER_61_133 VDD VSS sg13g2_decap_4
XFILLER_62_667 VDD VSS sg13g2_decap_8
X_12827_ _12828_/A input26/X _12841_/B _12803_/X input5/X _12826_/X VDD VSS sg13g2_a221oi_1
XFILLER_50_829 VDD VSS sg13g2_decap_8
XFILLER_37_1223 VDD VSS sg13g2_decap_8
X_14390__2174 _14390_/RESET_B VDD VSS sg13g2_tiehi
XFILLER_61_177 VDD VSS sg13g2_decap_8
X_12758_ _12758_/X _14136_/Q _14168_/Q _14200_/Q _14232_/Q _12758_/S0 _12758_/S1 VDD
+ VSS sg13g2_mux4_1
XFILLER_124_1204 VDD VSS sg13g2_fill_1
XFILLER_148_717 VDD VSS sg13g2_decap_4
XFILLER_91_93 VDD VSS sg13g2_decap_8
X_11709_ _11709_/X _13737_/Q _14089_/Q _14441_/Q _14537_/Q _11711_/S0 _11714_/S1 VDD
+ VSS sg13g2_mux4_1
XFILLER_72_1169 VDD VSS sg13g2_fill_2
XFILLER_148_739 VDD VSS sg13g2_decap_8
X_12689_ _12689_/X _14259_/Q _14291_/Q _14323_/Q _14355_/Q _12689_/S0 _12689_/S1 VDD
+ VSS sg13g2_mux4_1
X_14428_ _14428_/Q _14670_/CLK _14428_/D _14428_/RESET_B VDD VSS sg13g2_dfrbpq_1
XFILLER_128_441 VDD VSS sg13g2_decap_8
XFILLER_156_761 VDD VSS sg13g2_fill_2
XFILLER_128_452 VDD VSS sg13g2_fill_1
Xmax_cap402 _10096_/S _10084_/S VDD VSS sg13g2_buf_8
X_14359_ _14359_/Q _14726_/CLK _14359_/D _14359_/RESET_B VDD VSS sg13g2_dfrbpq_1
XFILLER_115_102 VDD VSS sg13g2_fill_2
XFILLER_7_793 VDD VSS sg13g2_decap_8
XFILLER_128_496 VDD VSS sg13g2_decap_8
XFILLER_144_978 VDD VSS sg13g2_fill_2
XFILLER_6_292 VDD VSS sg13g2_decap_8
Xmax_cap468 _09637_/S _09611_/S VDD VSS sg13g2_buf_4
XFILLER_83_1210 VDD VSS sg13g2_decap_8
X_08920_ _13712_/D _16874_/A _08919_/X _08956_/S VDD VSS sg13g2_mux2_1
XFILLER_103_319 VDD VSS sg13g2_decap_8
XFILLER_34_0 VDD VSS sg13g2_decap_8
XFILLER_69_222 VDD VSS sg13g2_fill_1
X_08851_ _13695_/D _13695_/Q _08850_/X _08926_/S VDD VSS sg13g2_mux2_1
X_07802_ _07949_/B _08471_/B _15008_/Q VDD VSS sg13g2_nand2b_1
X_08782_ _08782_/Y _13345_/B _14759_/Q _15183_/Q _07719_/X VDD VSS sg13g2_a22oi_1
XFILLER_66_940 VDD VSS sg13g2_fill_1
X_14005__2559 _14005_/RESET_B VDD VSS sg13g2_tiehi
X_13840__2724 _13840_/RESET_B VDD VSS sg13g2_tiehi
XFILLER_38_653 VDD VSS sg13g2_decap_8
X_07733_ _07734_/C _15097_/Q _15077_/Q _15075_/Q _15092_/Q VDD VSS sg13g2_nor4_1
XFILLER_26_804 VDD VSS sg13g2_fill_2
XFILLER_38_664 VDD VSS sg13g2_fill_2
XFILLER_65_461 VDD VSS sg13g2_decap_8
XFILLER_81_910 VDD VSS sg13g2_decap_8
XFILLER_1_91 VDD VSS sg13g2_decap_8
X_07664_ _13508_/B _13613_/B _13613_/C VDD VSS sg13g2_nor2_1
XFILLER_129_1104 VDD VSS sg13g2_decap_4
XFILLER_92_280 VDD VSS sg13g2_decap_8
XFILLER_81_954 VDD VSS sg13g2_decap_8
X_09403_ _14006_/D _10165_/A1 _14006_/Q _09403_/S VDD VSS sg13g2_mux2_1
XFILLER_80_453 VDD VSS sg13g2_fill_2
XFILLER_129_1148 VDD VSS sg13g2_fill_1
XFILLER_52_166 VDD VSS sg13g2_fill_1
XFILLER_80_475 VDD VSS sg13g2_decap_4
XFILLER_40_317 VDD VSS sg13g2_fill_1
XFILLER_80_486 VDD VSS sg13g2_fill_2
X_09334_ _13941_/D _09899_/A0 _13941_/Q _09339_/S VDD VSS sg13g2_mux2_1
X_14220__2344 _14220_/RESET_B VDD VSS sg13g2_tiehi
XFILLER_34_892 VDD VSS sg13g2_decap_8
X_09265_ _13874_/D _13874_/Q _09698_/A0 _09273_/S VDD VSS sg13g2_mux2_1
X_08216_ _08544_/A _08138_/A _08215_/X _08538_/S VDD VSS sg13g2_mux2_1
XFILLER_154_709 VDD VSS sg13g2_fill_2
X_09196_ _13812_/D _13812_/Q _10163_/A1 _09196_/S VDD VSS sg13g2_mux2_1
XFILLER_88_1110 VDD VSS sg13g2_decap_8
XFILLER_140_1061 VDD VSS sg13g2_decap_8
XFILLER_135_912 VDD VSS sg13g2_fill_2
XFILLER_14_1064 VDD VSS sg13g2_decap_8
XFILLER_119_463 VDD VSS sg13g2_fill_1
X_08147_ _08147_/Y _08213_/S _08013_/X _08146_/X VDD VSS sg13g2_a21oi_1
XFILLER_112_7 VDD VSS sg13g2_decap_8
XFILLER_119_474 VDD VSS sg13g2_fill_2
XFILLER_147_794 VDD VSS sg13g2_decap_4
XFILLER_88_1154 VDD VSS sg13g2_decap_4
XFILLER_107_636 VDD VSS sg13g2_fill_1
XFILLER_20_56 VDD VSS sg13g2_decap_8
X_08078_ _15219_/D _08068_/Y _08078_/B _08078_/C VDD VSS sg13g2_nand3b_1
XFILLER_106_168 VDD VSS sg13g2_decap_8
XFILLER_136_1119 VDD VSS sg13g2_decap_4
XFILLER_136_56 VDD VSS sg13g2_decap_8
XFILLER_134_499 VDD VSS sg13g2_decap_8
X_10040_ _14621_/D _10107_/A0 _14621_/Q _10061_/S VDD VSS sg13g2_mux2_1
XFILLER_29_21 VDD VSS sg13g2_decap_8
XFILLER_103_886 VDD VSS sg13g2_decap_8
XFILLER_0_479 VDD VSS sg13g2_decap_8
XFILLER_76_726 VDD VSS sg13g2_decap_8
XFILLER_75_214 VDD VSS sg13g2_decap_8
XFILLER_75_236 VDD VSS sg13g2_decap_8
XFILLER_152_77 VDD VSS sg13g2_decap_8
XFILLER_25_1193 VDD VSS sg13g2_decap_8
XFILLER_56_450 VDD VSS sg13g2_fill_1
X_11991_ _11991_/X _13969_/Q _14001_/Q _14033_/Q _14065_/Q _11997_/S0 _11997_/S1 VDD
+ VSS sg13g2_mux4_1
XFILLER_1_1118 VDD VSS sg13g2_decap_8
XFILLER_57_995 VDD VSS sg13g2_fill_2
XFILLER_21_1068 VDD VSS sg13g2_decap_8
X_13730_ _13730_/Q _14722_/CLK _13730_/D _13730_/RESET_B VDD VSS sg13g2_dfrbpq_1
X_10942_ _10942_/Y _10954_/C _14758_/Q VDD VSS sg13g2_nor2b_1
XFILLER_43_111 VDD VSS sg13g2_decap_8
XFILLER_16_347 VDD VSS sg13g2_decap_8
XFILLER_72_965 VDD VSS sg13g2_decap_4
XFILLER_83_291 VDD VSS sg13g2_decap_4
XFILLER_45_64 VDD VSS sg13g2_fill_1
X_13661_ _13661_/Q clkload73/A _13661_/D _13661_/RESET_B VDD VSS sg13g2_dfrbpq_1
X_10873_ _10873_/Y _10797_/C _10871_/A _10939_/B1 VDD VSS sg13g2_o21ai_1
X_12612_ _12625_/A _10671_/B _12779_/A2 _15008_/Q VDD VSS sg13g2_a21oi_1
XFILLER_31_339 VDD VSS sg13g2_decap_8
X_13592_ _13592_/Y _15004_/Q _13566_/B _13561_/S _08692_/C _13545_/X VDD VSS sg13g2_a221oi_1
XFILLER_40_851 VDD VSS sg13g2_fill_1
X_14972__3000 _14972_/RESET_B VDD VSS sg13g2_tiehi
X_12543_ _12543_/X _13833_/Q _13865_/Q _13897_/Q _13929_/Q _12548_/S0 _12550_/S1 VDD
+ VSS sg13g2_mux4_1
XFILLER_40_873 VDD VSS sg13g2_fill_2
XFILLER_61_85 VDD VSS sg13g2_decap_8
XFILLER_138_750 VDD VSS sg13g2_fill_2
X_12474_ _12474_/X _13956_/Q _13988_/Q _14020_/Q _14052_/Q _12759_/S0 _12759_/S1 VDD
+ VSS sg13g2_mux4_1
XFILLER_6_14 VDD VSS sg13g2_decap_8
X_14213_ _14213_/Q _14405_/CLK _14213_/D _14213_/RESET_B VDD VSS sg13g2_dfrbpq_1
X_11425_ wire255/A _11425_/A _11425_/B _11425_/C VDD VSS sg13g2_nand3_1
XFILLER_138_794 VDD VSS sg13g2_decap_8
X_15193_ _15193_/Q _15214_/CLK _15193_/D _15193_/RESET_B VDD VSS sg13g2_dfrbpq_1
XFILLER_32_1197 VDD VSS sg13g2_decap_8
XANTENNA_7 _15247_/D VDD VSS sg13g2_antennanp
X_14144_ _14144_/Q clkload9/A _14144_/D _14144_/RESET_B VDD VSS sg13g2_dfrbpq_1
XFILLER_4_741 VDD VSS sg13g2_fill_1
X_11356_ _11356_/Y _11355_/Y _11354_/Y _11875_/B VDD VSS sg13g2_a21oi_1
XFILLER_3_240 VDD VSS sg13g2_decap_8
XFILLER_4_763 VDD VSS sg13g2_decap_8
XFILLER_98_317 VDD VSS sg13g2_decap_4
X_10307_ _10307_/Y _14796_/Q _10327_/B _10444_/C VDD VSS sg13g2_o21ai_1
X_14075_ _14075_/Q _14670_/CLK _14075_/D _14075_/RESET_B VDD VSS sg13g2_dfrbpq_1
XFILLER_141_948 VDD VSS sg13g2_decap_8
XFILLER_141_959 VDD VSS sg13g2_fill_2
X_11287_ _11287_/Y _11287_/A _11287_/B _11425_/B VDD VSS sg13g2_nand3_1
XFILLER_152_296 VDD VSS sg13g2_decap_8
X_13026_ _13026_/Y _13026_/A _13057_/A _13026_/C VDD VSS sg13g2_nor3_1
X_10238_ _10238_/Y _10237_/B _10234_/Y _10337_/C VDD VSS sg13g2_o21ai_1
Xfanout1030 _08374_/A _07629_/Y VDD VSS sg13g2_buf_1
Xfanout1041 _11029_/C _11044_/C VDD VSS sg13g2_buf_1
Xfanout1052 _12635_/S1 _12762_/S VDD VSS sg13g2_buf_1
X_10169_ _14746_/D _14746_/Q _10169_/A1 _10169_/S VDD VSS sg13g2_mux2_1
XFILLER_117_1085 VDD VSS sg13g2_fill_1
Xfanout1063 _12789_/S1 _15214_/Q VDD VSS sg13g2_buf_1
XFILLER_0_991 VDD VSS sg13g2_decap_8
Xfanout1074 _12371_/S wire1077/A VDD VSS sg13g2_buf_1
XFILLER_48_962 VDD VSS sg13g2_decap_8
XFILLER_19_141 VDD VSS sg13g2_decap_8
XFILLER_94_578 VDD VSS sg13g2_decap_4
X_14977_ _14977_/Q clkload48/A _14977_/D _14977_/RESET_B VDD VSS sg13g2_dfrbpq_1
XFILLER_81_217 VDD VSS sg13g2_fill_1
XFILLER_63_921 VDD VSS sg13g2_decap_8
X_13928_ _13928_/Q clkload26/A _13928_/D _13928_/RESET_B VDD VSS sg13g2_dfrbpq_1
XFILLER_62_442 VDD VSS sg13g2_fill_1
XFILLER_34_144 VDD VSS sg13g2_decap_8
XFILLER_62_453 VDD VSS sg13g2_decap_4
XFILLER_34_155 VDD VSS sg13g2_fill_2
X_13859_ _13859_/Q clkload1/A _13859_/D _13859_/RESET_B VDD VSS sg13g2_dfrbpq_1
XFILLER_50_626 VDD VSS sg13g2_decap_8
XFILLER_62_486 VDD VSS sg13g2_fill_1
XFILLER_90_795 VDD VSS sg13g2_fill_2
XFILLER_37_1031 VDD VSS sg13g2_decap_8
XFILLER_37_1042 VDD VSS sg13g2_fill_2
XFILLER_31_851 VDD VSS sg13g2_decap_8
XFILLER_124_1045 VDD VSS sg13g2_decap_8
X_09050_ _09050_/X _14908_/Q _09056_/C _09049_/Y VDD VSS sg13g2_a21o_1
XFILLER_148_558 VDD VSS sg13g2_decap_8
X_08001_ _08001_/Y _08001_/A _08001_/B _08001_/C _08001_/D VDD VSS sg13g2_nand4_1
XFILLER_135_219 VDD VSS sg13g2_fill_1
XFILLER_156_591 VDD VSS sg13g2_fill_2
X_13858__2706 _13858_/RESET_B VDD VSS sg13g2_tiehi
XFILLER_116_444 VDD VSS sg13g2_fill_2
XFILLER_104_628 VDD VSS sg13g2_decap_8
X_09952_ _14536_/D _14536_/Q _10084_/A0 _09954_/S VDD VSS sg13g2_mux2_1
XFILLER_131_425 VDD VSS sg13g2_decap_8
X_08903_ _08903_/X _15039_/Q _14943_/Q _10735_/A VDD VSS sg13g2_mux2_1
XFILLER_103_149 VDD VSS sg13g2_fill_2
XFILLER_135_1141 VDD VSS sg13g2_decap_8
X_09883_ _14469_/D _09916_/A1 _14469_/Q _09901_/S VDD VSS sg13g2_mux2_1
XFILLER_112_650 VDD VSS sg13g2_decap_4
XFILLER_44_1046 VDD VSS sg13g2_decap_8
XFILLER_58_726 VDD VSS sg13g2_decap_8
XFILLER_100_812 VDD VSS sg13g2_decap_8
X_14238__2326 _14238_/RESET_B VDD VSS sg13g2_tiehi
X_08834_ _08834_/X _08835_/A _08835_/B VDD VSS sg13g2_and2_1
XFILLER_131_1016 VDD VSS sg13g2_decap_8
XFILLER_135_1185 VDD VSS sg13g2_decap_4
XFILLER_135_1196 VDD VSS sg13g2_decap_8
XFILLER_73_718 VDD VSS sg13g2_decap_8
X_08765_ _13673_/D _08765_/A1 _08763_/Y _08764_/Y VDD VSS sg13g2_a21oi_1
XFILLER_122_14 VDD VSS sg13g2_decap_8
XFILLER_26_601 VDD VSS sg13g2_decap_8
X_07716_ _08049_/A _15102_/Q _15094_/Q VDD VSS sg13g2_nor2_1
XFILLER_122_58 VDD VSS sg13g2_decap_8
X_08696_ _08696_/Y _15019_/Q _08673_/B _08698_/B VDD VSS sg13g2_a21oi_1
XFILLER_81_751 VDD VSS sg13g2_decap_4
X_14453__2111 _14453_/RESET_B VDD VSS sg13g2_tiehi
XFILLER_0_1151 VDD VSS sg13g2_decap_8
X_07647_ _07647_/Y _14806_/Q VDD VSS sg13g2_inv_1
XFILLER_53_464 VDD VSS sg13g2_decap_8
XFILLER_0_1162 VDD VSS sg13g2_fill_1
XFILLER_40_103 VDD VSS sg13g2_decap_4
XFILLER_15_56 VDD VSS sg13g2_decap_8
XFILLER_90_1022 VDD VSS sg13g2_decap_4
XFILLER_94_1191 VDD VSS sg13g2_decap_8
XFILLER_16_1104 VDD VSS sg13g2_decap_8
XFILLER_90_1033 VDD VSS sg13g2_fill_1
XFILLER_40_147 VDD VSS sg13g2_decap_4
XFILLER_107_1221 VDD VSS sg13g2_decap_8
X_09317_ _13924_/D _09915_/A1 _13924_/Q _09337_/S VDD VSS sg13g2_mux2_1
XFILLER_22_862 VDD VSS sg13g2_decap_8
XFILLER_22_873 VDD VSS sg13g2_fill_1
XFILLER_51_1039 VDD VSS sg13g2_decap_8
X_09248_ _13857_/D _13857_/Q _09747_/A1 _09271_/S VDD VSS sg13g2_mux2_1
XFILLER_21_394 VDD VSS sg13g2_decap_4
X_14486__2078 _14486_/RESET_B VDD VSS sg13g2_tiehi
XFILLER_154_517 VDD VSS sg13g2_decap_8
XFILLER_31_44 VDD VSS sg13g2_fill_1
XFILLER_126_208 VDD VSS sg13g2_decap_8
X_09179_ _13795_/D _13795_/Q _10146_/A1 _09199_/S VDD VSS sg13g2_mux2_1
X_11210_ _11210_/X _13947_/Q _13979_/Q _14011_/Q _14043_/Q _11212_/S _11226_/S1 VDD
+ VSS sg13g2_mux4_1
X_12190_ _12190_/Y _12190_/A _12253_/B VDD VSS sg13g2_nand2_1
XFILLER_108_978 VDD VSS sg13g2_decap_8
XFILLER_147_77 VDD VSS sg13g2_decap_8
XFILLER_123_904 VDD VSS sg13g2_fill_2
XFILLER_107_477 VDD VSS sg13g2_decap_4
X_11141_ _11141_/X _11163_/A _11192_/B1 _11168_/B1 VDD VSS sg13g2_a21o_1
Xoutput44 mem_axi_araddr[15] _16868_/A VDD VSS sg13g2_buf_1
Xoutput55 mem_axi_araddr[26] output55/A VDD VSS sg13g2_buf_1
Xoutput66 mem_axi_araddr[7] _16860_/A VDD VSS sg13g2_buf_1
XFILLER_27_1222 VDD VSS sg13g2_decap_8
Xoutput77 mem_axi_awaddr[16] _16869_/X VDD VSS sg13g2_buf_1
X_11072_ _11072_/Y _11029_/C _11070_/Y _11071_/Y VDD VSS sg13g2_a21oi_1
XFILLER_89_862 VDD VSS sg13g2_decap_8
Xoutput88 mem_axi_awaddr[27] _16880_/X VDD VSS sg13g2_buf_1
XFILLER_62_1124 VDD VSS sg13g2_decap_8
Xoutput99 mem_axi_awaddr[8] _16861_/X VDD VSS sg13g2_buf_1
X_10023_ _14605_/D _10089_/A0 _14605_/Q wire601/X VDD VSS sg13g2_mux2_1
XFILLER_49_726 VDD VSS sg13g2_decap_8
X_14900_ _14900_/Q clkload39/A _14900_/D _14900_/RESET_B VDD VSS sg13g2_dfrbpq_1
XFILLER_103_683 VDD VSS sg13g2_fill_2
XFILLER_23_1119 VDD VSS sg13g2_decap_8
XFILLER_0_287 VDD VSS sg13g2_decap_8
X_14663__1901 _14663_/RESET_B VDD VSS sg13g2_tiehi
XFILLER_62_1168 VDD VSS sg13g2_fill_1
XFILLER_114_1236 VDD VSS sg13g2_fill_1
XFILLER_0_298 VDD VSS sg13g2_fill_1
XFILLER_76_545 VDD VSS sg13g2_decap_8
XFILLER_130_491 VDD VSS sg13g2_decap_8
X_14831_ _14831_/Q _14873_/CLK _14831_/D _14831_/RESET_B VDD VSS sg13g2_dfrbpq_1
XFILLER_5_1073 VDD VSS sg13g2_decap_8
XFILLER_56_74 VDD VSS sg13g2_decap_8
XFILLER_63_228 VDD VSS sg13g2_decap_8
X_14092__2472 _14092_/RESET_B VDD VSS sg13g2_tiehi
XFILLER_17_623 VDD VSS sg13g2_fill_1
X_14762_ _14762_/Q clkload21/A _14762_/D _14762_/RESET_B VDD VSS sg13g2_dfrbpq_1
XFILLER_45_932 VDD VSS sg13g2_decap_8
XFILLER_17_634 VDD VSS sg13g2_decap_8
XFILLER_45_943 VDD VSS sg13g2_decap_4
X_11974_ _11975_/B _11971_/Y _11973_/Y _12048_/A1 VDD VSS sg13g2_a21oi_1
X_13713_ _13713_/Q clkload19/A _13713_/D _13713_/RESET_B VDD VSS sg13g2_dfrbpq_1
XFILLER_60_902 VDD VSS sg13g2_decap_8
X_10925_ _10926_/B wire582/X _10954_/D _10924_/Y VDD VSS sg13g2_o21ai_1
XFILLER_32_604 VDD VSS sg13g2_fill_2
X_14693_ _14693_/Q _14725_/CLK _14693_/D _14693_/RESET_B VDD VSS sg13g2_dfrbpq_1
XFILLER_72_773 VDD VSS sg13g2_fill_1
XFILLER_60_924 VDD VSS sg13g2_decap_4
X_13936__2628 _13936_/RESET_B VDD VSS sg13g2_tiehi
X_14696__1868 _14696_/RESET_B VDD VSS sg13g2_tiehi
XFILLER_147_1067 VDD VSS sg13g2_decap_4
XFILLER_16_188 VDD VSS sg13g2_fill_1
X_13644_ _13752_/D _13644_/A VDD VSS sg13g2_buf_1
XFILLER_73_1220 VDD VSS sg13g2_decap_8
X_10856_ _10857_/B _14752_/Q _10870_/A VDD VSS sg13g2_xnor2_1
XFILLER_108_1029 VDD VSS sg13g2_fill_1
XFILLER_31_136 VDD VSS sg13g2_decap_8
X_15031__2941 _15031_/RESET_B VDD VSS sg13g2_tiehi
XFILLER_31_169 VDD VSS sg13g2_decap_8
X_13575_ _13575_/Y _13575_/A _13593_/B VDD VSS sg13g2_nor2_1
X_10787_ _14923_/D _10787_/A VDD VSS sg13g2_inv_1
X_14893__3143 _14893_/RESET_B VDD VSS sg13g2_tiehi
XFILLER_121_1207 VDD VSS sg13g2_decap_8
X_12526_ _12527_/B _13681_/Q _12749_/A2 _12525_/X _12749_/B2 _12763_/C1 VDD VSS sg13g2_a221oi_1
XFILLER_75_7 VDD VSS sg13g2_fill_2
XFILLER_117_208 VDD VSS sg13g2_decap_8
XFILLER_117_219 VDD VSS sg13g2_fill_2
X_14316__2248 _14316_/RESET_B VDD VSS sg13g2_tiehi
X_15245_ _15245_/Q clkload31/A _15245_/D _15245_/RESET_B VDD VSS sg13g2_dfrbpq_1
X_12457_ _14996_/D _12457_/A _12457_/B VDD VSS sg13g2_nor2_1
X_11408_ _11408_/Y _11418_/A _14399_/Q _11391_/B VDD VSS sg13g2_a21oi_1
X_15176_ _15176_/Q _15178_/CLK _15176_/D _15176_/RESET_B VDD VSS sg13g2_dfrbpq_1
X_12388_ _14991_/D _08511_/S _12638_/A2 _12387_/Y _12386_/Y VDD VSS sg13g2_a22oi_1
XFILLER_153_583 VDD VSS sg13g2_decap_4
X_14127_ _14127_/Q clkload13/A _14127_/D _14127_/RESET_B VDD VSS sg13g2_dfrbpq_1
XFILLER_153_594 VDD VSS sg13g2_fill_1
X_11339_ _11339_/Y _11339_/A _11339_/B VDD VSS sg13g2_xnor2_1
XFILLER_140_211 VDD VSS sg13g2_fill_1
XFILLER_4_593 VDD VSS sg13g2_decap_8
XFILLER_67_1079 VDD VSS sg13g2_decap_8
XFILLER_98_136 VDD VSS sg13g2_fill_2
XFILLER_125_296 VDD VSS sg13g2_decap_8
XFILLER_140_244 VDD VSS sg13g2_decap_8
X_14531__2033 _14531_/RESET_B VDD VSS sg13g2_tiehi
X_14058_ _14058_/Q clkload25/A _14058_/D _14058_/RESET_B VDD VSS sg13g2_dfrbpq_1
XFILLER_101_609 VDD VSS sg13g2_decap_8
XFILLER_97_81 VDD VSS sg13g2_fill_1
X_13009_ _13009_/Y _13009_/A _13010_/A _13010_/B VDD VSS sg13g2_nand3_1
XFILLER_67_523 VDD VSS sg13g2_decap_8
XFILLER_121_491 VDD VSS sg13g2_fill_2
X_14785__3313 _14785_/RESET_B VDD VSS sg13g2_tiehi
XFILLER_55_707 VDD VSS sg13g2_decap_8
XFILLER_82_515 VDD VSS sg13g2_decap_8
XFILLER_94_386 VDD VSS sg13g2_fill_2
X_08550_ _08550_/Y _08567_/B _08531_/B _07956_/Y VDD VSS sg13g2_a21oi_1
XFILLER_39_1115 VDD VSS sg13g2_decap_8
XFILLER_51_902 VDD VSS sg13g2_decap_8
XFILLER_39_1126 VDD VSS sg13g2_fill_1
X_08481_ _08481_/X _08481_/A _08481_/B VDD VSS sg13g2_xor2_1
XFILLER_90_581 VDD VSS sg13g2_decap_8
XFILLER_22_114 VDD VSS sg13g2_decap_4
XFILLER_23_648 VDD VSS sg13g2_decap_8
XFILLER_51_968 VDD VSS sg13g2_decap_8
XFILLER_51_979 VDD VSS sg13g2_fill_1
XFILLER_149_834 VDD VSS sg13g2_decap_8
XFILLER_50_478 VDD VSS sg13g2_decap_8
X_09102_ _09102_/Y _13142_/A _09136_/B _09090_/A VDD VSS sg13g2_o21ai_1
X_13790__2774 _13790_/RESET_B VDD VSS sg13g2_tiehi
XFILLER_31_692 VDD VSS sg13g2_decap_8
XFILLER_148_355 VDD VSS sg13g2_decap_4
XFILLER_148_377 VDD VSS sg13g2_fill_1
X_09033_ _13766_/D _13766_/Q _10082_/A0 _09038_/S VDD VSS sg13g2_mux2_1
X_14741__1823 _14741_/RESET_B VDD VSS sg13g2_tiehi
XFILLER_15_1192 VDD VSS sg13g2_decap_8
XFILLER_11_1023 VDD VSS sg13g2_fill_1
XFILLER_129_580 VDD VSS sg13g2_decap_4
XFILLER_102_1151 VDD VSS sg13g2_decap_4
XFILLER_11_1056 VDD VSS sg13g2_decap_8
XFILLER_102_1184 VDD VSS sg13g2_decap_8
XFILLER_132_701 VDD VSS sg13g2_fill_2
XFILLER_2_508 VDD VSS sg13g2_decap_8
XFILLER_117_14 VDD VSS sg13g2_decap_8
XFILLER_104_414 VDD VSS sg13g2_decap_8
XFILLER_105_937 VDD VSS sg13g2_fill_2
X_14170__2394 _14170_/RESET_B VDD VSS sg13g2_tiehi
XFILLER_46_1108 VDD VSS sg13g2_decap_4
XFILLER_132_756 VDD VSS sg13g2_fill_1
XFILLER_85_1179 VDD VSS sg13g2_fill_2
XFILLER_104_447 VDD VSS sg13g2_decap_8
XFILLER_132_767 VDD VSS sg13g2_fill_1
Xfanout801 _08110_/D _08034_/Y VDD VSS sg13g2_buf_1
XFILLER_120_907 VDD VSS sg13g2_decap_8
X_09935_ _14520_/D _14520_/Q _09935_/A1 wire423/X VDD VSS sg13g2_mux2_1
XFILLER_89_158 VDD VSS sg13g2_fill_2
Xfanout812 _13252_/B1 _13049_/X VDD VSS sg13g2_buf_1
Xfanout823 _13569_/S _13561_/S VDD VSS sg13g2_buf_1
Xfanout834 _11170_/B _10959_/B VDD VSS sg13g2_buf_1
XFILLER_131_277 VDD VSS sg13g2_decap_8
X_13674__2909 _13674_/RESET_B VDD VSS sg13g2_tiehi
Xfanout856 _10757_/A _08954_/S VDD VSS sg13g2_buf_1
Xfanout867 _10788_/S _08837_/X VDD VSS sg13g2_buf_1
X_09866_ _14453_/D _14453_/Q _10064_/A0 _09870_/S VDD VSS sg13g2_mux2_1
Xfanout878 _08825_/C1 _08724_/Y VDD VSS sg13g2_buf_1
XFILLER_133_46 VDD VSS sg13g2_decap_8
Xfanout889 _08654_/B _07997_/Y VDD VSS sg13g2_buf_1
X_08817_ _08817_/Y _13279_/B _15122_/Q _13482_/A _15192_/Q _08825_/C1 VDD VSS sg13g2_a221oi_1
Xclkbuf_4_6_0_clk_i clkbuf_4_6_0_clk_i/X clkbuf_0_clk_i/X VDD VSS sg13g2_buf_8
XFILLER_86_887 VDD VSS sg13g2_decap_4
XFILLER_73_515 VDD VSS sg13g2_decap_8
X_09797_ _14386_/D _09830_/A0 _14386_/Q _09805_/S VDD VSS sg13g2_mux2_1
XFILLER_2_1213 VDD VSS sg13g2_decap_8
XFILLER_93_28 VDD VSS sg13g2_decap_8
XFILLER_93_39 VDD VSS sg13g2_fill_1
XFILLER_22_1163 VDD VSS sg13g2_decap_8
X_08748_ _08748_/Y _08751_/A1 _08751_/A2 _15194_/Q VDD VSS sg13g2_o21ai_1
XFILLER_96_1231 VDD VSS sg13g2_decap_4
XFILLER_26_431 VDD VSS sg13g2_decap_8
XFILLER_27_976 VDD VSS sg13g2_fill_1
X_08679_ _08679_/Y _08642_/Y _08645_/X _08678_/Y VDD VSS sg13g2_a21oi_1
XFILLER_57_1226 VDD VSS sg13g2_decap_8
XFILLER_26_77 VDD VSS sg13g2_decap_8
XFILLER_54_784 VDD VSS sg13g2_decap_8
XFILLER_81_570 VDD VSS sg13g2_decap_8
XFILLER_42_935 VDD VSS sg13g2_fill_1
XFILLER_42_946 VDD VSS sg13g2_fill_1
X_10710_ _10936_/C _09027_/X _08877_/A _08873_/Y VDD VSS sg13g2_a21o_1
X_11690_ _11694_/A _11689_/X _11690_/B VDD VSS sg13g2_nand2b_1
XFILLER_42_21 VDD VSS sg13g2_decap_8
X_10641_ _10643_/B _14887_/Q _10642_/C _14888_/Q VDD VSS sg13g2_a21oi_1
XFILLER_22_670 VDD VSS sg13g2_fill_1
XFILLER_139_344 VDD VSS sg13g2_decap_8
XFILLER_42_54 VDD VSS sg13g2_fill_2
XFILLER_10_832 VDD VSS sg13g2_decap_8
X_13360_ _13494_/B _13389_/B _13381_/A VDD VSS sg13g2_nand2b_1
XFILLER_139_355 VDD VSS sg13g2_fill_2
XFILLER_10_843 VDD VSS sg13g2_fill_2
X_10572_ _14869_/D _10572_/A _10595_/B _10572_/C VDD VSS sg13g2_nor3_1
X_12311_ _12311_/Y _12303_/S _14586_/Q VDD VSS sg13g2_nand2b_1
X_13291_ _15054_/D _13291_/A _13291_/B _13291_/C VDD VSS sg13g2_nand3_1
XFILLER_154_336 VDD VSS sg13g2_decap_8
X_15030_ _15030_/Q _15229_/CLK _15030_/D _15030_/RESET_B VDD VSS sg13g2_dfrbpq_1
X_12242_ _12242_/Y _12255_/A1 _14648_/Q VDD VSS sg13g2_nand2b_1
XFILLER_101_0 VDD VSS sg13g2_decap_8
X_12173_ _12174_/B _12170_/Y _12172_/Y _12173_/B1 VDD VSS sg13g2_a21oi_1
X_14000__2564 _14000_/RESET_B VDD VSS sg13g2_tiehi
XFILLER_1_530 VDD VSS sg13g2_decap_8
X_11124_ _11128_/A _11127_/A _11127_/B VDD VSS sg13g2_nand2_1
XFILLER_110_417 VDD VSS sg13g2_fill_1
XFILLER_7_1124 VDD VSS sg13g2_decap_8
X_15049__2912 _15049_/RESET_B VDD VSS sg13g2_tiehi
XFILLER_104_992 VDD VSS sg13g2_decap_8
X_11055_ _11055_/Y _11191_/A _11051_/Y _11054_/Y VDD VSS sg13g2_a21oi_1
XFILLER_95_139 VDD VSS sg13g2_decap_8
XFILLER_110_439 VDD VSS sg13g2_decap_8
XFILLER_153_1093 VDD VSS sg13g2_decap_8
XFILLER_27_1096 VDD VSS sg13g2_decap_8
XFILLER_77_865 VDD VSS sg13g2_fill_2
X_10006_ _14588_/D _10039_/A0 _14588_/Q wire601/A VDD VSS sg13g2_mux2_1
XFILLER_77_887 VDD VSS sg13g2_decap_8
XFILLER_37_729 VDD VSS sg13g2_decap_8
XFILLER_49_589 VDD VSS sg13g2_decap_4
XFILLER_77_898 VDD VSS sg13g2_fill_2
XFILLER_97_1017 VDD VSS sg13g2_fill_1
XFILLER_36_217 VDD VSS sg13g2_decap_8
X_14814_ _14814_/Q clkload78/A _14814_/D _14814_/RESET_B VDD VSS sg13g2_dfrbpq_1
XFILLER_97_1039 VDD VSS sg13g2_fill_2
X_14745_ _14745_/Q _14745_/CLK _14745_/D _14745_/RESET_B VDD VSS sg13g2_dfrbpq_1
X_11957_ _11957_/Y _12291_/A _11957_/B VDD VSS sg13g2_nor2_1
XFILLER_83_72 VDD VSS sg13g2_fill_1
XFILLER_45_795 VDD VSS sg13g2_decap_8
XFILLER_32_423 VDD VSS sg13g2_fill_2
X_10908_ _10908_/Y _10923_/A _10923_/D _10923_/B VDD VSS sg13g2_o21ai_1
XFILLER_44_294 VDD VSS sg13g2_decap_8
X_14676_ _14676_/Q clkload16/A _14676_/D _14676_/RESET_B VDD VSS sg13g2_dfrbpq_1
X_11888_ _11888_/Y _11890_/S0 _14510_/Q _11894_/B VDD VSS sg13g2_a21oi_1
XFILLER_149_119 VDD VSS sg13g2_decap_8
XFILLER_20_607 VDD VSS sg13g2_decap_4
X_13627_ _13735_/D _13627_/A VDD VSS sg13g2_buf_1
XFILLER_34_1012 VDD VSS sg13g2_fill_1
X_10839_ _10841_/B _14751_/Q _10876_/A VDD VSS sg13g2_xor2_1
XFILLER_125_1140 VDD VSS sg13g2_decap_8
XFILLER_41_990 VDD VSS sg13g2_decap_8
X_14549__2015 _14549_/RESET_B VDD VSS sg13g2_tiehi
XFILLER_34_1056 VDD VSS sg13g2_decap_4
X_13558_ _13558_/Y _15008_/Q _13566_/B _13563_/C VDD VSS sg13g2_nor3_1
XFILLER_121_1004 VDD VSS sg13g2_decap_8
XFILLER_125_1184 VDD VSS sg13g2_decap_8
XFILLER_8_140 VDD VSS sg13g2_decap_8
X_12509_ _12509_/X _12508_/X _12507_/X _12501_/X _12502_/X wire1081/A _12636_/S VDD
+ VSS sg13g2_mux4_1
XFILLER_145_325 VDD VSS sg13g2_decap_8
XFILLER_121_1048 VDD VSS sg13g2_decap_8
X_13489_ _15124_/D _15124_/Q _13656_/S _13488_/Y VDD VSS sg13g2_a21o_1
X_15228_ _15228_/Q _15229_/CLK _15228_/D _15228_/RESET_B VDD VSS sg13g2_dfrbpq_1
Xmax_cap1674 _12067_/S0 _11648_/S0 VDD VSS sg13g2_buf_4
XFILLER_114_723 VDD VSS sg13g2_decap_4
X_15159_ _15159_/Q clkload29/A _15159_/D _15159_/RESET_B VDD VSS sg13g2_dfrbpq_1
XFILLER_113_222 VDD VSS sg13g2_fill_2
XFILLER_114_756 VDD VSS sg13g2_decap_8
XFILLER_102_918 VDD VSS sg13g2_fill_2
X_07981_ _07985_/A _07980_/Y _15075_/Q _07981_/C VDD VSS sg13g2_nand3b_1
XFILLER_102_929 VDD VSS sg13g2_decap_8
XFILLER_113_266 VDD VSS sg13g2_decap_4
XFILLER_86_117 VDD VSS sg13g2_decap_8
XFILLER_45_1152 VDD VSS sg13g2_decap_4
X_09720_ _14311_/D _09918_/A1 _14311_/Q wire449/X VDD VSS sg13g2_mux2_1
XFILLER_80_1043 VDD VSS sg13g2_decap_8
X_09651_ _14244_/D _10147_/A1 _14244_/Q wire639/X VDD VSS sg13g2_mux2_1
XFILLER_94_161 VDD VSS sg13g2_decap_8
X_08602_ _08615_/A _15015_/Q _07853_/B _08674_/B1 VDD VSS sg13g2_o21ai_1
XFILLER_94_172 VDD VSS sg13g2_fill_1
XFILLER_95_695 VDD VSS sg13g2_decap_8
X_09582_ _14179_/D _14179_/Q _09650_/A0 wire329/X VDD VSS sg13g2_mux2_1
XFILLER_36_740 VDD VSS sg13g2_decap_8
XFILLER_36_751 VDD VSS sg13g2_fill_1
X_08533_ _08533_/Y _08567_/B _08532_/Y _08039_/A VDD VSS sg13g2_a21oi_1
XFILLER_24_913 VDD VSS sg13g2_fill_1
XFILLER_24_924 VDD VSS sg13g2_decap_8
XFILLER_51_710 VDD VSS sg13g2_decap_4
XFILLER_23_412 VDD VSS sg13g2_decap_4
X_08464_ _08475_/D _08027_/Y _08050_/Y _08463_/Y VDD VSS sg13g2_a21oi_1
X_14188__2376 _14188_/RESET_B VDD VSS sg13g2_tiehi
XFILLER_51_787 VDD VSS sg13g2_fill_2
XFILLER_17_1232 VDD VSS sg13g2_decap_4
X_08395_ _08395_/Y _08395_/A _08395_/B VDD VSS sg13g2_nor2_1
XFILLER_52_1123 VDD VSS sg13g2_decap_8
XFILLER_50_297 VDD VSS sg13g2_fill_1
XFILLER_91_1194 VDD VSS sg13g2_fill_1
XFILLER_13_1118 VDD VSS sg13g2_decap_8
XFILLER_148_163 VDD VSS sg13g2_decap_8
XFILLER_137_826 VDD VSS sg13g2_fill_1
XFILLER_12_35 VDD VSS sg13g2_decap_8
XFILLER_109_528 VDD VSS sg13g2_decap_4
XFILLER_128_35 VDD VSS sg13g2_decap_8
X_09016_ _09019_/A _09141_/A _09016_/B _10697_/B VDD VSS sg13g2_nand3_1
XFILLER_3_817 VDD VSS sg13g2_fill_1
XFILLER_105_701 VDD VSS sg13g2_decap_4
XFILLER_88_28 VDD VSS sg13g2_fill_2
XFILLER_128_79 VDD VSS sg13g2_fill_1
XFILLER_105_734 VDD VSS sg13g2_decap_8
XFILLER_137_1011 VDD VSS sg13g2_fill_2
XFILLER_104_211 VDD VSS sg13g2_decap_8
XFILLER_117_594 VDD VSS sg13g2_decap_4
XFILLER_5_7 VDD VSS sg13g2_decap_8
XFILLER_137_1044 VDD VSS sg13g2_decap_8
XFILLER_137_1055 VDD VSS sg13g2_fill_2
XFILLER_137_1066 VDD VSS sg13g2_decap_8
Xfanout1618 _12067_/S1 _12207_/S1 VDD VSS sg13g2_buf_1
XFILLER_144_56 VDD VSS sg13g2_decap_8
Xfanout1629 _11693_/C _11555_/S1 VDD VSS sg13g2_buf_1
X_14995__2977 _14995_/RESET_B VDD VSS sg13g2_tiehi
X_09918_ _14503_/D _14503_/Q _09918_/A1 _09930_/S VDD VSS sg13g2_mux2_1
Xfanout642 _09673_/S _09661_/S VDD VSS sg13g2_buf_1
XFILLER_77_139 VDD VSS sg13g2_decap_8
XFILLER_24_1225 VDD VSS sg13g2_decap_8
XFILLER_144_89 VDD VSS sg13g2_decap_8
Xfanout664 _09454_/S _09467_/S VDD VSS sg13g2_buf_1
Xfanout675 _09391_/S _09407_/S VDD VSS sg13g2_buf_1
XFILLER_24_1236 VDD VSS sg13g2_fill_1
Xfanout686 _09347_/S wire689/X VDD VSS sg13g2_buf_1
XFILLER_59_876 VDD VSS sg13g2_decap_4
Xfanout697 _09227_/S wire700/A VDD VSS sg13g2_buf_1
X_09849_ _14436_/D _14436_/Q _10080_/A0 _09855_/S VDD VSS sg13g2_mux2_1
XFILLER_37_21 VDD VSS sg13g2_decap_8
XFILLER_59_887 VDD VSS sg13g2_decap_8
XFILLER_92_109 VDD VSS sg13g2_fill_1
XFILLER_100_450 VDD VSS sg13g2_decap_8
XFILLER_111_1228 VDD VSS sg13g2_decap_8
XFILLER_18_228 VDD VSS sg13g2_decap_8
XFILLER_58_397 VDD VSS sg13g2_fill_2
XFILLER_85_183 VDD VSS sg13g2_fill_2
X_12860_ _12876_/A _12861_/B _12861_/A VDD VSS sg13g2_nor2_1
XFILLER_100_494 VDD VSS sg13g2_decap_4
XFILLER_74_879 VDD VSS sg13g2_decap_8
X_11811_ _11811_/Y _11814_/S0 _14636_/Q VDD VSS sg13g2_nand2b_1
XFILLER_15_913 VDD VSS sg13g2_decap_8
X_12791_ wire366/A _13662_/Q _12791_/A2 _12790_/X _12415_/A _12791_/C1 VDD VSS sg13g2_a221oi_1
XFILLER_2_1087 VDD VSS sg13g2_decap_8
X_14530_ _14530_/Q _14722_/CLK _14530_/D _14530_/RESET_B VDD VSS sg13g2_dfrbpq_1
X_11742_ _11743_/B _11742_/A _11742_/B _11760_/C VDD VSS sg13g2_nand3_1
XFILLER_53_53 VDD VSS sg13g2_decap_4
X_14018__2546 _14018_/RESET_B VDD VSS sg13g2_tiehi
XFILLER_149_0 VDD VSS sg13g2_decap_8
X_13853__2711 _13853_/RESET_B VDD VSS sg13g2_tiehi
X_14461_ _14461_/Q clkload54/A _14461_/D _14461_/RESET_B VDD VSS sg13g2_dfrbpq_1
X_11673_ _11673_/Y _11692_/A _14568_/Q VDD VSS sg13g2_nand2b_1
XFILLER_30_949 VDD VSS sg13g2_decap_8
XFILLER_41_286 VDD VSS sg13g2_fill_1
XFILLER_70_1234 VDD VSS sg13g2_fill_2
X_13412_ _13448_/C _15198_/Q _13412_/B _13412_/C VDD VSS sg13g2_nor3_1
X_10624_ _10626_/C _14883_/Q _10636_/A VDD VSS sg13g2_nand2b_1
X_14392_ _14392_/Q _14506_/CLK _14392_/D _14392_/RESET_B VDD VSS sg13g2_dfrbpq_1
X_13343_ _13343_/Y _13654_/S _13343_/B VDD VSS sg13g2_nand2_1
X_10555_ _10557_/A _14867_/Q _10555_/B VDD VSS sg13g2_nand2b_1
XFILLER_154_133 VDD VSS sg13g2_decap_8
X_14233__2331 _14233_/RESET_B VDD VSS sg13g2_tiehi
X_13274_ _13274_/Y _14830_/Q _13206_/B _13249_/B _14894_/Q _13274_/C1 VDD VSS sg13g2_a221oi_1
X_10486_ _10512_/B _14849_/Q _13084_/A _14847_/Q _10504_/C VDD VSS sg13g2_nand4_1
XFILLER_120_1070 VDD VSS sg13g2_fill_1
X_13886__2678 _13886_/RESET_B VDD VSS sg13g2_tiehi
X_15013_ _15013_/Q clkload29/A _15013_/D _15013_/RESET_B VDD VSS sg13g2_dfrbpq_1
XFILLER_120_1081 VDD VSS sg13g2_decap_8
X_12225_ _12225_/Y _12224_/Y _12223_/X _12204_/Y _12156_/A _12126_/A VDD VSS sg13g2_a221oi_1
XFILLER_151_840 VDD VSS sg13g2_decap_4
XFILLER_123_531 VDD VSS sg13g2_decap_4
XFILLER_29_1125 VDD VSS sg13g2_decap_8
XFILLER_29_1158 VDD VSS sg13g2_decap_8
X_12156_ _12156_/Y _12156_/A _12156_/B _12156_/C VDD VSS sg13g2_nand3_1
XFILLER_38_7 VDD VSS sg13g2_decap_8
XFILLER_78_61 VDD VSS sg13g2_decap_8
XFILLER_155_1177 VDD VSS sg13g2_decap_8
X_11107_ _11107_/Y _11097_/Y _10764_/X _11179_/B VDD VSS sg13g2_a21oi_1
X_12087_ _12087_/X _14132_/Q _14164_/Q _12090_/A VDD VSS sg13g2_mux2_1
X_14266__2298 _14266_/RESET_B VDD VSS sg13g2_tiehi
X_11038_ _11044_/A _11064_/C _11036_/Y _11037_/Y VDD VSS sg13g2_o21ai_1
XFILLER_18_773 VDD VSS sg13g2_decap_8
X_12989_ _12993_/B _12943_/A _12989_/B _12989_/C VDD VSS sg13g2_nand3b_1
XFILLER_64_389 VDD VSS sg13g2_decap_4
XFILLER_33_721 VDD VSS sg13g2_fill_2
XFILLER_17_272 VDD VSS sg13g2_decap_8
XFILLER_75_1134 VDD VSS sg13g2_fill_1
X_14481__2083 _14481_/RESET_B VDD VSS sg13g2_tiehi
XFILLER_91_197 VDD VSS sg13g2_decap_8
X_14728_ _14728_/Q _15148_/CLK _14728_/D _14728_/RESET_B VDD VSS sg13g2_dfrbpq_1
XFILLER_33_754 VDD VSS sg13g2_decap_8
XFILLER_127_1235 VDD VSS sg13g2_fill_2
XFILLER_36_1129 VDD VSS sg13g2_decap_4
X_14659_ _14659_/Q clkload1/A _14659_/D _14659_/RESET_B VDD VSS sg13g2_dfrbpq_1
XFILLER_21_949 VDD VSS sg13g2_decap_8
X_08180_ _08187_/B _08381_/A _08170_/X _08026_/Y _08179_/Y VDD VSS sg13g2_a22oi_1
XFILLER_64_0 VDD VSS sg13g2_decap_8
XFILLER_146_678 VDD VSS sg13g2_fill_1
XFILLER_145_155 VDD VSS sg13g2_decap_8
XFILLER_12_1151 VDD VSS sg13g2_decap_8
XFILLER_127_870 VDD VSS sg13g2_decap_8
X_13716__2848 _13716_/RESET_B VDD VSS sg13g2_tiehi
XFILLER_142_851 VDD VSS sg13g2_decap_8
XFILLER_114_553 VDD VSS sg13g2_decap_4
XFILLER_82_1127 VDD VSS sg13g2_decap_8
XFILLER_87_404 VDD VSS sg13g2_decap_8
XFILLER_82_1149 VDD VSS sg13g2_decap_8
X_07964_ _07964_/Y _08641_/C _07963_/Y _07962_/Y VDD VSS sg13g2_a21oi_1
XFILLER_4_91 VDD VSS sg13g2_decap_8
XFILLER_59_139 VDD VSS sg13g2_fill_2
X_09703_ _14295_/D _10166_/A1 _14295_/Q wire458/A VDD VSS sg13g2_mux2_1
XFILLER_96_971 VDD VSS sg13g2_fill_2
X_13931__2633 _13931_/RESET_B VDD VSS sg13g2_tiehi
X_14691__1873 _14691_/RESET_B VDD VSS sg13g2_tiehi
XFILLER_56_824 VDD VSS sg13g2_decap_4
X_07895_ _08037_/A _08023_/A _07903_/B VDD VSS sg13g2_or2_1
XFILLER_28_526 VDD VSS sg13g2_decap_8
XFILLER_28_537 VDD VSS sg13g2_fill_2
XFILLER_74_19 VDD VSS sg13g2_decap_8
XFILLER_110_792 VDD VSS sg13g2_decap_8
X_09634_ _14230_/D _09900_/A0 _14230_/Q _09636_/S VDD VSS sg13g2_mux2_1
XFILLER_83_654 VDD VSS sg13g2_decap_8
XFILLER_71_805 VDD VSS sg13g2_decap_8
X_09565_ _14163_/D _10062_/A0 _14163_/Q _09566_/S VDD VSS sg13g2_mux2_1
XFILLER_70_315 VDD VSS sg13g2_fill_2
XFILLER_130_14 VDD VSS sg13g2_decap_8
XFILLER_64_890 VDD VSS sg13g2_decap_8
X_08516_ _08517_/D _07816_/X _08541_/A _08515_/Y _07815_/X _08514_/Y VDD VSS sg13g2_a221oi_1
X_14311__2253 _14311_/RESET_B VDD VSS sg13g2_tiehi
X_09496_ _14096_/D _10092_/A0 _14096_/Q _09505_/S VDD VSS sg13g2_mux2_1
XFILLER_130_58 VDD VSS sg13g2_decap_8
XFILLER_24_765 VDD VSS sg13g2_decap_8
XFILLER_51_562 VDD VSS sg13g2_decap_8
X_08447_ _08447_/X _08548_/A _08447_/B VDD VSS sg13g2_and2_1
XFILLER_142_7 VDD VSS sg13g2_decap_8
XFILLER_12_938 VDD VSS sg13g2_decap_8
XFILLER_12_949 VDD VSS sg13g2_fill_1
XFILLER_23_56 VDD VSS sg13g2_decap_8
XFILLER_11_459 VDD VSS sg13g2_fill_2
X_08378_ _08378_/Y _08621_/B _08376_/X _08377_/Y VDD VSS sg13g2_o21ai_1
XFILLER_20_960 VDD VSS sg13g2_decap_8
XFILLER_143_1081 VDD VSS sg13g2_fill_2
XFILLER_136_100 VDD VSS sg13g2_fill_2
XFILLER_139_56 VDD VSS sg13g2_decap_8
X_14938__3053 _14938_/RESET_B VDD VSS sg13g2_tiehi
XFILLER_109_358 VDD VSS sg13g2_decap_4
XFILLER_87_1027 VDD VSS sg13g2_decap_8
X_10340_ _14806_/D _10405_/C _10357_/D _10337_/B _07647_/Y _10347_/B VDD VSS sg13g2_a221oi_1
XFILLER_87_1038 VDD VSS sg13g2_fill_1
XFILLER_139_1139 VDD VSS sg13g2_decap_8
X_10271_ _10271_/Y _10305_/A _10271_/B VDD VSS sg13g2_nand2b_1
XFILLER_133_840 VDD VSS sg13g2_decap_8
XFILLER_151_147 VDD VSS sg13g2_decap_8
XFILLER_133_851 VDD VSS sg13g2_fill_2
XFILLER_105_542 VDD VSS sg13g2_fill_1
X_12010_ _12055_/D _12008_/Y _12010_/B VDD VSS sg13g2_nand2b_1
XFILLER_155_77 VDD VSS sg13g2_decap_8
XFILLER_105_564 VDD VSS sg13g2_decap_8
XFILLER_2_168 VDD VSS sg13g2_fill_2
Xfanout1404 _12300_/A _14988_/Q VDD VSS sg13g2_buf_1
Xfanout1415 _07849_/B _12152_/A VDD VSS sg13g2_buf_1
XFILLER_8_1230 VDD VSS sg13g2_decap_8
Xfanout1426 _08541_/B _12009_/A VDD VSS sg13g2_buf_1
Xfanout1437 _07819_/B _11914_/A VDD VSS sg13g2_buf_1
Xfanout450 _09737_/S _09707_/X VDD VSS sg13g2_buf_1
Xfanout1448 _11798_/A _14974_/Q VDD VSS sg13g2_buf_1
XFILLER_24_1022 VDD VSS sg13g2_decap_8
Xfanout1459 _08405_/A1 _11661_/A VDD VSS sg13g2_buf_1
Xfanout461 _09706_/S _09694_/S VDD VSS sg13g2_buf_1
XFILLER_150_1030 VDD VSS sg13g2_decap_8
XFILLER_93_407 VDD VSS sg13g2_decap_4
X_13961_ _13961_/Q _14633_/CLK _13961_/D _13961_/RESET_B VDD VSS sg13g2_dfrbpq_1
XFILLER_19_515 VDD VSS sg13g2_fill_2
Xfanout483 _09335_/S fanout486/X VDD VSS sg13g2_buf_1
XFILLER_101_770 VDD VSS sg13g2_decap_8
X_15116__3112 _15116_/RESET_B VDD VSS sg13g2_tiehi
Xfanout494 _09299_/S wire496/A VDD VSS sg13g2_buf_1
XFILLER_87_993 VDD VSS sg13g2_fill_2
XFILLER_111_1003 VDD VSS sg13g2_decap_4
Xwire1565 _16860_/A _13698_/Q VDD VSS sg13g2_buf_8
X_12912_ _12914_/B _12911_/Y _12799_/X input19/X _12801_/Y VDD VSS sg13g2_a22oi_1
XFILLER_19_548 VDD VSS sg13g2_fill_2
XFILLER_47_857 VDD VSS sg13g2_decap_8
X_13892_ _13892_/Q clkload30/A _13892_/D _13892_/RESET_B VDD VSS sg13g2_dfrbpq_1
XFILLER_24_1099 VDD VSS sg13g2_decap_8
XFILLER_46_345 VDD VSS sg13g2_fill_2
XFILLER_104_70 VDD VSS sg13g2_decap_8
XFILLER_74_676 VDD VSS sg13g2_decap_8
X_12843_ _12845_/C _13609_/A _12844_/C input6/X _12899_/A VDD VSS sg13g2_nand4_1
XFILLER_62_849 VDD VSS sg13g2_fill_2
XFILLER_64_52 VDD VSS sg13g2_fill_1
XFILLER_64_74 VDD VSS sg13g2_fill_2
X_12774_ _12774_/X _12767_/X _12771_/X _12766_/X _12770_/X _12581_/S _12775_/S1 VDD
+ VSS sg13g2_mux4_1
XFILLER_9_14 VDD VSS sg13g2_decap_8
X_14513_ _14513_/Q clkload51/A _14513_/D _14513_/RESET_B VDD VSS sg13g2_dfrbpq_1
X_11725_ _11725_/Y _11726_/A _13678_/Q VDD VSS sg13g2_nor2_1
X_14444_ _14444_/Q clkload51/A _14444_/D _14444_/RESET_B VDD VSS sg13g2_dfrbpq_1
XFILLER_35_1151 VDD VSS sg13g2_decap_8
X_11656_ _11656_/Y _11234_/Y _11654_/X _12269_/A2 VDD VSS sg13g2_a21oi_1
XFILLER_35_1173 VDD VSS sg13g2_decap_8
X_10607_ _10614_/A _14878_/Q _14877_/Q _10607_/C _10607_/D VDD VSS sg13g2_nand4_1
X_14375_ _14375_/Q clkload4/A _14375_/D _14375_/RESET_B VDD VSS sg13g2_dfrbpq_1
XFILLER_31_1037 VDD VSS sg13g2_fill_1
XFILLER_11_993 VDD VSS sg13g2_decap_8
X_11587_ _11587_/Y _11586_/Y wire303/X _11572_/X _11631_/A2 _11701_/C1 VDD VSS sg13g2_a221oi_1
XFILLER_156_965 VDD VSS sg13g2_fill_1
XFILLER_70_1097 VDD VSS sg13g2_decap_8
XFILLER_122_1176 VDD VSS sg13g2_decap_4
XFILLER_156_987 VDD VSS sg13g2_fill_1
XFILLER_155_453 VDD VSS sg13g2_decap_8
X_13326_ _15066_/D _13328_/A _13326_/B VDD VSS sg13g2_nor2_1
X_10538_ _10538_/Y _10538_/A _10538_/B _10567_/A _10567_/B VDD VSS sg13g2_nor4_1
XFILLER_143_615 VDD VSS sg13g2_decap_4
XFILLER_109_881 VDD VSS sg13g2_decap_8
XFILLER_6_474 VDD VSS sg13g2_decap_8
XFILLER_143_648 VDD VSS sg13g2_fill_2
X_13257_ _13270_/A _14924_/Q _13663_/Q VDD VSS sg13g2_nand2_1
X_10469_ _10472_/C _10511_/C _10473_/D _14845_/Q VDD VSS sg13g2_a21oi_1
X_12208_ _12208_/Y _12207_/X _12219_/S VDD VSS sg13g2_nand2b_1
X_13188_ _13202_/A wire182/X _13225_/B _13225_/A VDD VSS sg13g2_nand3_1
XFILLER_151_670 VDD VSS sg13g2_decap_4
X_14499__2065 _14499_/RESET_B VDD VSS sg13g2_tiehi
X_12139_ _12139_/X _14133_/Q _14165_/Q _14197_/Q _14229_/Q _12139_/S0 _12285_/S1 VDD
+ VSS sg13g2_mux4_1
XFILLER_2_691 VDD VSS sg13g2_decap_8
XFILLER_111_545 VDD VSS sg13g2_decap_8
XFILLER_111_556 VDD VSS sg13g2_fill_1
XFILLER_78_960 VDD VSS sg13g2_decap_8
XFILLER_81_1160 VDD VSS sg13g2_decap_8
XFILLER_78_971 VDD VSS sg13g2_fill_2
XFILLER_37_301 VDD VSS sg13g2_decap_8
XFILLER_96_289 VDD VSS sg13g2_fill_2
XFILLER_37_312 VDD VSS sg13g2_fill_1
XFILLER_77_481 VDD VSS sg13g2_decap_8
XFILLER_49_183 VDD VSS sg13g2_decap_8
XFILLER_93_952 VDD VSS sg13g2_decap_8
X_07680_ _07680_/Y _13296_/A1 _13289_/C _07679_/Y VDD VSS sg13g2_a21oi_1
X_16878_ _16878_/X _16878_/A VDD VSS sg13g2_buf_1
XFILLER_38_879 VDD VSS sg13g2_fill_1
XFILLER_64_153 VDD VSS sg13g2_decap_4
XFILLER_92_462 VDD VSS sg13g2_decap_8
XFILLER_53_849 VDD VSS sg13g2_fill_1
X_09350_ _13954_/D _09649_/A0 _13954_/Q _09370_/S VDD VSS sg13g2_mux2_1
XFILLER_33_540 VDD VSS sg13g2_fill_2
X_08301_ _08301_/X _08215_/X _08300_/X _08538_/S VDD VSS sg13g2_mux2_1
X_09281_ _13889_/D _13889_/Q _09747_/A1 wire496/X VDD VSS sg13g2_mux2_1
XFILLER_33_584 VDD VSS sg13g2_decap_8
XFILLER_33_595 VDD VSS sg13g2_fill_1
X_08232_ _08232_/Y _07924_/C _08230_/Y _08231_/Y VDD VSS sg13g2_a21oi_1
XFILLER_60_392 VDD VSS sg13g2_decap_8
XFILLER_127_1087 VDD VSS sg13g2_decap_8
X_08163_ _08163_/Y _08649_/S _08162_/Y _08160_/Y VDD VSS sg13g2_a21oi_1
XFILLER_101_1205 VDD VSS sg13g2_decap_8
X_13949__2615 _13949_/RESET_B VDD VSS sg13g2_tiehi
XFILLER_107_818 VDD VSS sg13g2_decap_4
X_08094_ _08094_/X _08383_/A _07798_/B _07790_/A _07825_/B _08598_/S1 _08048_/A VDD
+ VSS sg13g2_mux4_1
Xclkload60 clkload60/Y clkload60/A VDD VSS sg13g2_inv_2
XFILLER_134_648 VDD VSS sg13g2_decap_8
Xclkload71 clkload71/Y clkload71/A VDD VSS sg13g2_inv_1
Xclkload82 clkload82/Y clkload82/A VDD VSS sg13g2_inv_1
Xhold3501 _10914_/A _14936_/Q VDD VSS sg13g2_dlygate4sd3_1
Xhold3512 _10850_/A _14931_/Q VDD VSS sg13g2_dlygate4sd3_1
Xhold3523 _13423_/C _15095_/Q VDD VSS sg13g2_dlygate4sd3_1
XFILLER_125_14 VDD VSS sg13g2_decap_8
Xhold3534 hold3534/X _14929_/Q VDD VSS sg13g2_dlygate4sd3_1
XFILLER_115_895 VDD VSS sg13g2_fill_1
XFILLER_0_639 VDD VSS sg13g2_decap_8
X_14329__2235 _14329_/RESET_B VDD VSS sg13g2_tiehi
XFILLER_47_1099 VDD VSS sg13g2_decap_8
XFILLER_60_1200 VDD VSS sg13g2_decap_8
X_08996_ wire537/A _08993_/X _08995_/Y _08992_/Y VDD VSS sg13g2_o21ai_1
XFILLER_76_919 VDD VSS sg13g2_decap_8
XFILLER_87_256 VDD VSS sg13g2_fill_1
XFILLER_130_865 VDD VSS sg13g2_fill_1
XFILLER_69_982 VDD VSS sg13g2_decap_8
X_07947_ _08443_/A _08435_/A _08574_/A _07945_/Y VDD VSS sg13g2_o21ai_1
XFILLER_28_334 VDD VSS sg13g2_fill_2
XFILLER_18_56 VDD VSS sg13g2_decap_8
X_07878_ _07878_/Y _08105_/A _08200_/B VDD VSS sg13g2_nand2_1
XFILLER_141_35 VDD VSS sg13g2_decap_8
XFILLER_44_816 VDD VSS sg13g2_fill_1
XFILLER_83_451 VDD VSS sg13g2_decap_8
X_09617_ _14213_/D _09850_/A1 _14213_/Q _09632_/S VDD VSS sg13g2_mux2_1
XFILLER_3_1160 VDD VSS sg13g2_decap_8
XFILLER_43_304 VDD VSS sg13g2_fill_2
X_14544__2020 _14544_/RESET_B VDD VSS sg13g2_tiehi
XFILLER_71_624 VDD VSS sg13g2_decap_8
X_09548_ _14146_/D _09649_/A0 _14146_/Q _09569_/S VDD VSS sg13g2_mux2_1
XFILLER_58_1162 VDD VSS sg13g2_fill_2
X_14798__3300 _14798_/RESET_B VDD VSS sg13g2_tiehi
XFILLER_93_1064 VDD VSS sg13g2_decap_4
XFILLER_24_573 VDD VSS sg13g2_fill_1
XFILLER_19_1135 VDD VSS sg13g2_decap_8
XFILLER_58_1184 VDD VSS sg13g2_decap_4
X_09479_ _14079_/D _10075_/A0 _14079_/Q _09479_/S VDD VSS sg13g2_mux2_1
XFILLER_70_189 VDD VSS sg13g2_decap_4
XFILLER_93_1075 VDD VSS sg13g2_fill_2
XFILLER_106_1105 VDD VSS sg13g2_fill_1
XFILLER_24_595 VDD VSS sg13g2_fill_2
X_11510_ _11510_/X _14243_/Q _14275_/Q _14307_/Q _14339_/Q _11580_/S0 _11580_/S1 VDD
+ VSS sg13g2_mux4_1
XFILLER_11_223 VDD VSS sg13g2_fill_2
X_12490_ _12490_/X _14245_/Q _14277_/Q _14309_/Q _14341_/Q _12494_/S0 _12494_/S1 VDD
+ VSS sg13g2_mux4_1
X_15145__3052 _15145_/RESET_B VDD VSS sg13g2_tiehi
XFILLER_7_205 VDD VSS sg13g2_decap_8
XFILLER_156_239 VDD VSS sg13g2_decap_8
X_11441_ _11441_/X _13728_/Q _14080_/Q _14432_/Q _14528_/Q _12213_/S0 _12169_/C VDD
+ VSS sg13g2_mux4_1
Xwire147 wire147/X wire147/A VDD VSS sg13g2_buf_2
XFILLER_50_43 VDD VSS sg13g2_decap_4
Xwire158 wire158/X wire158/A VDD VSS sg13g2_buf_2
XFILLER_153_902 VDD VSS sg13g2_decap_8
X_14160_ _14160_/Q clkload49/A _14160_/D _14160_/RESET_B VDD VSS sg13g2_dfrbpq_1
X_11372_ _11374_/A _11373_/A _14174_/Q VDD VSS sg13g2_nand2b_1
XFILLER_137_486 VDD VSS sg13g2_fill_2
XFILLER_3_400 VDD VSS sg13g2_decap_8
XFILLER_4_923 VDD VSS sg13g2_fill_1
X_13111_ _15040_/D _13155_/A _13111_/B VDD VSS sg13g2_nor2_1
XFILLER_152_434 VDD VSS sg13g2_decap_4
X_10323_ _10325_/A _14801_/Q _10323_/B VDD VSS sg13g2_nand2b_1
X_14091_ _14091_/Q _14667_/CLK _14091_/D _14091_/RESET_B VDD VSS sg13g2_dfrbpq_1
XFILLER_124_158 VDD VSS sg13g2_decap_4
X_13042_ _13043_/B _13042_/A _13042_/B _13042_/C VDD VSS sg13g2_nand3_1
XFILLER_140_629 VDD VSS sg13g2_decap_8
X_10254_ _10256_/A _14779_/Q _10258_/D _14780_/Q VDD VSS sg13g2_a21o_1
XFILLER_106_873 VDD VSS sg13g2_decap_8
XFILLER_117_1223 VDD VSS sg13g2_decap_8
XFILLER_26_1128 VDD VSS sg13g2_decap_8
XFILLER_121_843 VDD VSS sg13g2_fill_1
X_10185_ _10185_/Y _10185_/A _10185_/B _10185_/C VDD VSS sg13g2_nand3_1
Xfanout1223 _11236_/B _15208_/Q VDD VSS sg13g2_buf_1
XFILLER_152_1147 VDD VSS sg13g2_decap_8
Xfanout1234 _13293_/C _12403_/A2 VDD VSS sg13g2_buf_1
XFILLER_121_876 VDD VSS sg13g2_decap_8
Xfanout1245 _13563_/C _15202_/Q VDD VSS sg13g2_buf_1
XFILLER_78_267 VDD VSS sg13g2_fill_2
Xfanout1256 _13381_/A _10199_/A1 VDD VSS sg13g2_buf_1
XFILLER_93_215 VDD VSS sg13g2_fill_2
Xfanout1267 _13180_/B1 _13162_/B1 VDD VSS sg13g2_buf_1
X_14993_ _14993_/Q clkload62/A _14993_/D _14993_/RESET_B VDD VSS sg13g2_dfrbpq_1
Xfanout280 _12298_/B _11724_/B VDD VSS sg13g2_buf_1
Xfanout1278 _07728_/A _13180_/A2 VDD VSS sg13g2_buf_1
Xfanout291 _10117_/A0 _09037_/X VDD VSS sg13g2_buf_1
XFILLER_19_323 VDD VSS sg13g2_decap_4
Xfanout1289 _11191_/A _11099_/B2 VDD VSS sg13g2_buf_1
X_14183__2381 _14183_/RESET_B VDD VSS sg13g2_tiehi
X_13944_ _13944_/Q _15001_/CLK _13944_/D _13944_/RESET_B VDD VSS sg13g2_dfrbpq_1
XFILLER_75_51 VDD VSS sg13g2_decap_4
XFILLER_47_654 VDD VSS sg13g2_decap_8
XFILLER_74_462 VDD VSS sg13g2_decap_8
XFILLER_35_838 VDD VSS sg13g2_fill_2
X_13875_ _13875_/Q clkload12/A _13875_/D _13875_/RESET_B VDD VSS sg13g2_dfrbpq_1
XFILLER_28_890 VDD VSS sg13g2_decap_4
XFILLER_34_348 VDD VSS sg13g2_decap_8
X_12826_ _12826_/X _12900_/A _12900_/B _12900_/C input13/X VDD VSS sg13g2_and4_1
XFILLER_37_1202 VDD VSS sg13g2_decap_8
X_12757_ _12757_/X _13752_/Q _14104_/Q _14456_/Q _14552_/Q _12757_/S0 _12757_/S1 VDD
+ VSS sg13g2_mux4_1
XFILLER_43_882 VDD VSS sg13g2_fill_1
X_11708_ _11708_/X _14569_/Q _14601_/Q _14633_/Q _14665_/Q _11714_/S0 _11714_/S1 VDD
+ VSS sg13g2_mux4_1
XFILLER_124_1227 VDD VSS sg13g2_decap_8
XFILLER_30_554 VDD VSS sg13g2_fill_1
X_12688_ _12688_/X _14387_/Q _14419_/Q _14483_/Q _14515_/Q _12740_/S0 _12740_/S1 VDD
+ VSS sg13g2_mux4_1
XFILLER_129_910 VDD VSS sg13g2_decap_8
XFILLER_147_228 VDD VSS sg13g2_fill_1
X_14407__2157 _14407_/RESET_B VDD VSS sg13g2_tiehi
X_14427_ _14427_/Q _14670_/CLK _14427_/D _14427_/RESET_B VDD VSS sg13g2_dfrbpq_1
XFILLER_147_239 VDD VSS sg13g2_decap_8
X_11639_ _11639_/Y _11570_/A _13683_/Q _13682_/Q _11591_/A VDD VSS sg13g2_a22oi_1
X_14358_ _14358_/Q clkload33/A _14358_/D _14358_/RESET_B VDD VSS sg13g2_dfrbpq_1
X_14990__2982 _14990_/RESET_B VDD VSS sg13g2_tiehi
XFILLER_116_604 VDD VSS sg13g2_fill_2
XFILLER_143_401 VDD VSS sg13g2_decap_8
Xmax_cap414 _09969_/S _09943_/S VDD VSS sg13g2_buf_4
Xmax_cap425 _09936_/S _09910_/S VDD VSS sg13g2_buf_4
XFILLER_115_114 VDD VSS sg13g2_fill_2
X_13309_ _13309_/Y _13499_/C _13309_/A2 wire810/X VDD VSS sg13g2_a21oi_1
XFILLER_155_294 VDD VSS sg13g2_decap_8
X_14289_ _14289_/Q _14737_/CLK _14289_/D _14289_/RESET_B VDD VSS sg13g2_dfrbpq_1
XFILLER_69_201 VDD VSS sg13g2_fill_2
X_08850_ _08850_/X _08849_/X _11428_/A _08871_/S VDD VSS sg13g2_mux2_1
XFILLER_123_180 VDD VSS sg13g2_decap_4
XFILLER_44_1228 VDD VSS sg13g2_decap_8
X_14922__3085 _14922_/RESET_B VDD VSS sg13g2_tiehi
XFILLER_97_554 VDD VSS sg13g2_fill_1
XFILLER_27_0 VDD VSS sg13g2_decap_8
X_07801_ _07950_/A _15008_/Q _07801_/B VDD VSS sg13g2_nand2b_1
XFILLER_111_353 VDD VSS sg13g2_fill_2
XFILLER_97_587 VDD VSS sg13g2_decap_4
XFILLER_112_887 VDD VSS sg13g2_fill_2
X_08781_ _08781_/Y _13679_/Q _08787_/B VDD VSS sg13g2_nor2_1
XFILLER_38_610 VDD VSS sg13g2_decap_8
XFILLER_78_790 VDD VSS sg13g2_decap_8
XFILLER_84_226 VDD VSS sg13g2_fill_1
X_07732_ _08400_/A _15097_/Q _15092_/Q VDD VSS sg13g2_nor2_1
X_14013__2551 _14013_/RESET_B VDD VSS sg13g2_tiehi
Xfanout1790 _10557_/C fanout1794/X VDD VSS sg13g2_buf_1
XFILLER_38_676 VDD VSS sg13g2_decap_4
XFILLER_1_70 VDD VSS sg13g2_decap_8
X_07663_ _07663_/Y input36/X _10184_/B _14749_/Q VDD VSS sg13g2_o21ai_1
XFILLER_26_849 VDD VSS sg13g2_decap_8
X_09402_ _14005_/D _10064_/A0 _14005_/Q _09406_/S VDD VSS sg13g2_mux2_1
Xclkbuf_leaf_123_clk_i clkload9/A clkbuf_5_3__f_clk_i/X VDD VSS sg13g2_buf_8
X_14617__1947 _14617_/RESET_B VDD VSS sg13g2_tiehi
X_09333_ _13940_/D _10030_/A0 _13940_/Q _09333_/S VDD VSS sg13g2_mux2_1
X_13881__2683 _13881_/RESET_B VDD VSS sg13g2_tiehi
X_09264_ _13873_/D _13873_/Q _09730_/A0 _09264_/S VDD VSS sg13g2_mux2_1
X_08215_ _08215_/X _11483_/A _11461_/A _11454_/A _11428_/A _08215_/S0 _08686_/S1 VDD
+ VSS sg13g2_mux4_1
X_09195_ _13811_/D _13811_/Q _09332_/A0 _09196_/S VDD VSS sg13g2_mux2_1
XFILLER_14_1043 VDD VSS sg13g2_decap_8
XFILLER_135_902 VDD VSS sg13g2_decap_4
X_08146_ _08146_/X _08146_/A _08167_/A VDD VSS sg13g2_and2_1
XFILLER_146_261 VDD VSS sg13g2_decap_8
XFILLER_135_946 VDD VSS sg13g2_decap_8
XFILLER_20_35 VDD VSS sg13g2_decap_8
XFILLER_49_1117 VDD VSS sg13g2_fill_1
X_08077_ _08078_/C _08588_/B _08076_/Y _08381_/A _08058_/X VDD VSS sg13g2_a22oi_1
XFILLER_101_1068 VDD VSS sg13g2_fill_2
XFILLER_106_136 VDD VSS sg13g2_decap_8
XFILLER_107_659 VDD VSS sg13g2_decap_8
XFILLER_150_905 VDD VSS sg13g2_decap_4
XFILLER_105_7 VDD VSS sg13g2_decap_8
XFILLER_136_35 VDD VSS sg13g2_decap_8
XFILLER_134_478 VDD VSS sg13g2_decap_8
XFILLER_122_629 VDD VSS sg13g2_decap_8
XFILLER_150_949 VDD VSS sg13g2_decap_8
XFILLER_1_937 VDD VSS sg13g2_fill_2
XFILLER_88_543 VDD VSS sg13g2_fill_1
XFILLER_103_854 VDD VSS sg13g2_decap_8
XFILLER_0_447 VDD VSS sg13g2_decap_8
XFILLER_0_458 VDD VSS sg13g2_fill_1
XFILLER_76_705 VDD VSS sg13g2_decap_8
XFILLER_76_716 VDD VSS sg13g2_fill_2
XFILLER_103_876 VDD VSS sg13g2_fill_1
XFILLER_29_44 VDD VSS sg13g2_fill_1
XFILLER_48_418 VDD VSS sg13g2_decap_8
XFILLER_29_55 VDD VSS sg13g2_fill_1
X_08979_ _13757_/D _13757_/Q _10140_/A1 _09167_/S VDD VSS sg13g2_mux2_1
XFILLER_76_738 VDD VSS sg13g2_decap_8
XFILLER_76_749 VDD VSS sg13g2_fill_2
XFILLER_60_1041 VDD VSS sg13g2_decap_8
XFILLER_152_56 VDD VSS sg13g2_decap_8
XFILLER_25_1172 VDD VSS sg13g2_decap_8
XFILLER_60_1052 VDD VSS sg13g2_fill_1
XFILLER_112_1120 VDD VSS sg13g2_decap_8
XFILLER_112_1131 VDD VSS sg13g2_decap_8
X_11990_ _11990_/X _14129_/Q _14161_/Q _14193_/Q _14225_/Q _11997_/S0 _11997_/S1 VDD
+ VSS sg13g2_mux4_1
XFILLER_60_1085 VDD VSS sg13g2_fill_2
XFILLER_84_760 VDD VSS sg13g2_decap_8
XFILLER_21_1047 VDD VSS sg13g2_decap_8
XFILLER_60_1096 VDD VSS sg13g2_fill_2
XFILLER_84_771 VDD VSS sg13g2_fill_1
XFILLER_90_207 VDD VSS sg13g2_fill_2
XFILLER_45_21 VDD VSS sg13g2_decap_4
X_10941_ _10941_/X _14938_/Q _10959_/B VDD VSS sg13g2_and2_1
XFILLER_84_782 VDD VSS sg13g2_decap_8
XFILLER_72_933 VDD VSS sg13g2_fill_1
XFILLER_84_793 VDD VSS sg13g2_fill_2
XFILLER_147_1216 VDD VSS sg13g2_decap_8
X_13660_ _13660_/Q _15188_/CLK _13660_/D _13660_/RESET_B VDD VSS sg13g2_dfrbpq_1
XFILLER_32_808 VDD VSS sg13g2_decap_8
XFILLER_44_668 VDD VSS sg13g2_decap_8
XFILLER_71_454 VDD VSS sg13g2_decap_8
X_10872_ _10872_/Y _10871_/Y _10935_/A _10869_/Y _10867_/Y _11207_/A2 VDD VSS sg13g2_a221oi_1
X_12611_ _15007_/D _12611_/A wire376/X VDD VSS sg13g2_nor2_1
X_13591_ _15162_/D _13590_/B _13589_/Y _13590_/Y VDD VSS sg13g2_a21oi_1
XFILLER_12_510 VDD VSS sg13g2_decap_8
XFILLER_12_532 VDD VSS sg13g2_decap_8
X_12542_ _12555_/A _07625_/A _12751_/A2 _15003_/Q VDD VSS sg13g2_a21oi_1
X_13711__2853 _13711_/RESET_B VDD VSS sg13g2_tiehi
XFILLER_8_525 VDD VSS sg13g2_decap_8
XFILLER_61_64 VDD VSS sg13g2_decap_8
XFILLER_131_0 VDD VSS sg13g2_decap_8
X_12473_ _12473_/X _14116_/Q _14148_/Q _14180_/Q _14212_/Q _12759_/S0 _12759_/S1 VDD
+ VSS sg13g2_mux4_1
XFILLER_8_547 VDD VSS sg13g2_decap_4
XFILLER_32_1143 VDD VSS sg13g2_fill_1
XFILLER_32_1154 VDD VSS sg13g2_decap_8
X_14212_ _14212_/Q clkload31/A _14212_/D _14212_/RESET_B VDD VSS sg13g2_dfrbpq_1
X_11424_ _11425_/A _11423_/Y _11424_/B _11424_/C VDD VSS sg13g2_nand3b_1
X_15192_ _15192_/Q clkload72/A _15192_/D _15192_/RESET_B VDD VSS sg13g2_dfrbpq_1
XFILLER_32_1176 VDD VSS sg13g2_decap_8
X_14055__2509 _14055_/RESET_B VDD VSS sg13g2_tiehi
XFILLER_153_732 VDD VSS sg13g2_fill_1
XANTENNA_8 _13427_/C VDD VSS sg13g2_antennanp
X_14143_ _14143_/Q _14509_/CLK _14143_/D _14143_/RESET_B VDD VSS sg13g2_dfrbpq_1
X_11355_ _11355_/Y _11353_/S _14654_/Q _12304_/B VDD VSS sg13g2_a21oi_1
XFILLER_126_968 VDD VSS sg13g2_fill_1
XFILLER_152_242 VDD VSS sg13g2_decap_8
XFILLER_141_927 VDD VSS sg13g2_decap_8
X_10306_ _14795_/D _10327_/B _10468_/A _10306_/C VDD VSS sg13g2_nor3_1
X_14074_ _14074_/Q _15040_/CLK _14074_/D _14074_/RESET_B VDD VSS sg13g2_dfrbpq_1
XFILLER_152_275 VDD VSS sg13g2_decap_8
X_11286_ _11287_/B _11378_/S _11276_/Y _11285_/Y VDD VSS sg13g2_o21ai_1
XFILLER_79_521 VDD VSS sg13g2_decap_8
X_13025_ _13042_/B _13026_/A _13026_/C _13057_/A VDD VSS sg13g2_o21ai_1
XFILLER_79_532 VDD VSS sg13g2_fill_2
X_10237_ wire763/A _10237_/A _10237_/B _10237_/C _10237_/D VDD VSS sg13g2_nor4_1
XFILLER_121_640 VDD VSS sg13g2_fill_2
Xfanout1020 _08125_/S _08110_/B VDD VSS sg13g2_buf_1
Xfanout1031 _08079_/S _13553_/A1 VDD VSS sg13g2_buf_1
XFILLER_20_7 VDD VSS sg13g2_decap_8
Xfanout1042 _11109_/B _11044_/C VDD VSS sg13g2_buf_1
X_10168_ _14745_/D _14745_/Q wire158/X _10168_/S VDD VSS sg13g2_mux2_1
XFILLER_86_72 VDD VSS sg13g2_decap_8
Xfanout1064 _12636_/S _12706_/S VDD VSS sg13g2_buf_1
Xfanout1086 _12760_/S0 wire1096/X VDD VSS sg13g2_buf_1
Xfanout1097 _12494_/S1 fanout1104/X VDD VSS sg13g2_buf_1
X_10099_ _14679_/D _10099_/A0 _14679_/Q _10099_/S VDD VSS sg13g2_mux2_1
X_14976_ _14976_/Q clkload64/A _14976_/D _14976_/RESET_B VDD VSS sg13g2_dfrbpq_1
Xclkbuf_leaf_40_clk_i _14525_/CLK clkbuf_leaf_48_clk_i/A VDD VSS sg13g2_buf_8
XFILLER_35_602 VDD VSS sg13g2_fill_1
XFILLER_35_613 VDD VSS sg13g2_fill_1
XFILLER_48_996 VDD VSS sg13g2_decap_8
XFILLER_35_624 VDD VSS sg13g2_decap_8
X_13927_ _13927_/Q clkload7/A _13927_/D _13927_/RESET_B VDD VSS sg13g2_dfrbpq_1
XFILLER_63_944 VDD VSS sg13g2_decap_8
X_13858_ _13858_/Q clkload22/A _13858_/D _13858_/RESET_B VDD VSS sg13g2_dfrbpq_1
XFILLER_16_871 VDD VSS sg13g2_decap_8
XFILLER_63_999 VDD VSS sg13g2_decap_8
XFILLER_90_785 VDD VSS sg13g2_decap_4
XFILLER_37_1021 VDD VSS sg13g2_fill_1
XFILLER_76_1070 VDD VSS sg13g2_fill_2
X_12809_ _12809_/Y _14767_/Q _12918_/A2 _13297_/A0 VDD VSS sg13g2_o21ai_1
X_13789_ _13789_/Q clkload53/A _13789_/D _13789_/RESET_B VDD VSS sg13g2_dfrbpq_1
Xclkbuf_leaf_55_clk_i clkload65/A clkbuf_leaf_84_clk_i/A VDD VSS sg13g2_buf_8
XFILLER_128_1193 VDD VSS sg13g2_decap_8
XFILLER_37_1098 VDD VSS sg13g2_fill_1
XFILLER_50_1232 VDD VSS sg13g2_decap_4
X_08000_ _08000_/X _08001_/A _08001_/B _08001_/C _08001_/D VDD VSS sg13g2_and4_1
XFILLER_129_773 VDD VSS sg13g2_decap_8
XFILLER_156_570 VDD VSS sg13g2_fill_1
XFILLER_144_721 VDD VSS sg13g2_decap_8
XFILLER_117_946 VDD VSS sg13g2_decap_8
XFILLER_117_957 VDD VSS sg13g2_fill_2
XFILLER_144_743 VDD VSS sg13g2_decap_8
XFILLER_143_220 VDD VSS sg13g2_fill_2
XFILLER_128_294 VDD VSS sg13g2_fill_1
XFILLER_116_456 VDD VSS sg13g2_decap_8
XFILLER_132_927 VDD VSS sg13g2_decap_8
X_09951_ _14535_/D _14535_/Q _10017_/A0 _09951_/S VDD VSS sg13g2_mux2_1
XFILLER_103_128 VDD VSS sg13g2_decap_8
X_08902_ _13708_/D _08926_/S _08900_/Y _08901_/Y VDD VSS sg13g2_a21oi_1
X_09882_ _14468_/D _09915_/A1 _14468_/Q wire321/X VDD VSS sg13g2_mux2_1
XFILLER_131_459 VDD VSS sg13g2_decap_8
XFILLER_44_1025 VDD VSS sg13g2_decap_8
XFILLER_58_705 VDD VSS sg13g2_decap_8
XFILLER_112_662 VDD VSS sg13g2_decap_4
X_08833_ _08833_/Y _14747_/Q _13613_/C _08833_/C VDD VSS sg13g2_nor3_1
XFILLER_85_535 VDD VSS sg13g2_fill_1
XFILLER_111_172 VDD VSS sg13g2_decap_8
X_13899__2665 _13899_/RESET_B VDD VSS sg13g2_tiehi
X_08764_ _08764_/Y _13673_/Q _08787_/B VDD VSS sg13g2_nor2_1
XFILLER_39_963 VDD VSS sg13g2_decap_8
XFILLER_85_579 VDD VSS sg13g2_decap_8
XFILLER_72_207 VDD VSS sg13g2_decap_8
X_07715_ _07721_/B _15099_/Q _15098_/Q _15088_/Q _15087_/Q VDD VSS sg13g2_nor4_1
XFILLER_66_782 VDD VSS sg13g2_fill_2
X_08695_ _08695_/Y _08681_/B _08679_/Y _08673_/X VDD VSS sg13g2_o21ai_1
XFILLER_53_410 VDD VSS sg13g2_decap_4
XFILLER_65_270 VDD VSS sg13g2_decap_8
XFILLER_25_123 VDD VSS sg13g2_decap_4
XFILLER_0_1130 VDD VSS sg13g2_fill_1
X_07646_ _07646_/Y _14802_/Q VDD VSS sg13g2_inv_1
XFILLER_81_774 VDD VSS sg13g2_decap_4
X_14279__2285 _14279_/RESET_B VDD VSS sg13g2_tiehi
XFILLER_0_1174 VDD VSS sg13g2_decap_4
XFILLER_80_262 VDD VSS sg13g2_decap_8
XFILLER_15_35 VDD VSS sg13g2_decap_8
XFILLER_94_1170 VDD VSS sg13g2_decap_8
XFILLER_41_649 VDD VSS sg13g2_fill_1
X_09316_ _13923_/D wire524/X _13923_/Q _09336_/S VDD VSS sg13g2_mux2_1
XFILLER_51_1007 VDD VSS sg13g2_decap_4
X_15236__3389 _15236_/RESET_B VDD VSS sg13g2_tiehi
XFILLER_55_1187 VDD VSS sg13g2_decap_8
XFILLER_90_1078 VDD VSS sg13g2_decap_8
XFILLER_21_373 VDD VSS sg13g2_decap_8
X_09247_ _13856_/D _13856_/Q _09911_/A1 _09266_/S VDD VSS sg13g2_mux2_1
Xclkbuf_4_2_0_clk_i clkbuf_4_2_0_clk_i/X clkbuf_0_clk_i/X VDD VSS sg13g2_buf_8
XFILLER_119_250 VDD VSS sg13g2_decap_8
X_14494__2070 _14494_/RESET_B VDD VSS sg13g2_tiehi
X_09178_ _13794_/D _13794_/Q _10145_/A1 _09198_/S VDD VSS sg13g2_mux2_1
Xclkbuf_5_9__f_clk_i clkbuf_5_9__f_clk_i/X clkbuf_4_4_0_clk_i/X VDD VSS sg13g2_buf_16
XFILLER_108_935 VDD VSS sg13g2_decap_4
XFILLER_147_592 VDD VSS sg13g2_fill_1
XFILLER_107_423 VDD VSS sg13g2_fill_2
XFILLER_147_56 VDD VSS sg13g2_decap_8
XFILLER_31_89 VDD VSS sg13g2_decap_4
X_08129_ _08129_/X _08306_/C _07786_/A _08405_/A1 _07790_/A wire1387/X _13521_/A VDD
+ VSS sg13g2_mux4_1
XFILLER_150_713 VDD VSS sg13g2_fill_2
XFILLER_135_787 VDD VSS sg13g2_fill_2
X_11140_ _11140_/Y _11139_/Y _11138_/Y _11136_/Y _11179_/B _11192_/B1 VDD VSS sg13g2_a221oi_1
Xoutput45 mem_axi_araddr[16] _16869_/A VDD VSS sg13g2_buf_1
XFILLER_27_1201 VDD VSS sg13g2_decap_8
XFILLER_1_723 VDD VSS sg13g2_decap_8
Xoutput56 mem_axi_araddr[27] output56/A VDD VSS sg13g2_buf_1
Xoutput67 mem_axi_araddr[8] _16861_/A VDD VSS sg13g2_buf_1
Xoutput78 mem_axi_awaddr[17] _16870_/X VDD VSS sg13g2_buf_1
XFILLER_62_1103 VDD VSS sg13g2_decap_8
X_11071_ _11071_/Y _11029_/C _11068_/B _11082_/B1 VDD VSS sg13g2_o21ai_1
Xoutput89 mem_axi_awaddr[28] _16881_/X VDD VSS sg13g2_buf_1
XFILLER_49_705 VDD VSS sg13g2_decap_8
XFILLER_0_255 VDD VSS sg13g2_decap_8
XFILLER_62_1147 VDD VSS sg13g2_fill_1
X_10022_ _14604_/D _10155_/A1 _14604_/Q _10035_/S VDD VSS sg13g2_mux2_1
XFILLER_0_266 VDD VSS sg13g2_fill_1
X_13729__2835 _13729_/RESET_B VDD VSS sg13g2_tiehi
X_14830_ _14830_/Q clkload70/A _14830_/D _14830_/RESET_B VDD VSS sg13g2_dfrbpq_1
XFILLER_76_568 VDD VSS sg13g2_fill_1
XFILLER_5_1052 VDD VSS sg13g2_decap_8
XFILLER_45_900 VDD VSS sg13g2_decap_4
XFILLER_56_42 VDD VSS sg13g2_decap_8
XFILLER_17_613 VDD VSS sg13g2_fill_2
XFILLER_63_218 VDD VSS sg13g2_fill_1
XFILLER_91_527 VDD VSS sg13g2_decap_8
X_14761_ _14761_/Q _15200_/CLK _14761_/D _14761_/RESET_B VDD VSS sg13g2_dfrbpq_1
X_11973_ _11973_/Y _11973_/A _11973_/B VDD VSS sg13g2_nand2_1
X_10924_ _10924_/Y _10954_/D wire582/X _10924_/B1 VDD VSS sg13g2_a21oi_1
X_13712_ _13712_/Q clkload19/A _13712_/D _13712_/RESET_B VDD VSS sg13g2_dfrbpq_1
X_14692_ _14692_/Q _15001_/CLK _14692_/D _14692_/RESET_B VDD VSS sg13g2_dfrbpq_1
XFILLER_147_1046 VDD VSS sg13g2_decap_8
X_14109__2455 _14109_/RESET_B VDD VSS sg13g2_tiehi
X_13944__2620 _13944_/RESET_B VDD VSS sg13g2_tiehi
X_13643_ _13751_/D _13643_/A VDD VSS sg13g2_buf_1
X_10855_ _10890_/A _14752_/Q _10870_/A VDD VSS sg13g2_nor2_1
XFILLER_60_969 VDD VSS sg13g2_fill_2
XFILLER_72_74 VDD VSS sg13g2_fill_2
X_13574_ _13574_/Y _14998_/Q _13589_/A2 _13569_/S _15014_/Q _13521_/X VDD VSS sg13g2_a221oi_1
XFILLER_34_1227 VDD VSS sg13g2_decap_8
X_10786_ _10787_/A _14923_/Q _10973_/B _11183_/B1 _11181_/A VDD VSS sg13g2_a22oi_1
X_12525_ _12525_/X _12524_/X _12523_/X _12692_/S VDD VSS sg13g2_mux2_1
X_12456_ _12457_/B _13686_/Q _12763_/A2 _12455_/X _12763_/B2 _12749_/C1 VDD VSS sg13g2_a221oi_1
X_15244_ _15244_/Q clkload32/A _15244_/D _15244_/RESET_B VDD VSS sg13g2_dfrbpq_1
X_14324__2240 _14324_/RESET_B VDD VSS sg13g2_tiehi
XFILLER_68_7 VDD VSS sg13g2_decap_8
X_13977__2587 _13977_/RESET_B VDD VSS sg13g2_tiehi
X_11407_ _11407_/Y _11814_/S0 _14367_/Q VDD VSS sg13g2_nand2b_1
X_15175_ _15175_/Q _15178_/CLK _15175_/D _15175_/RESET_B VDD VSS sg13g2_dfrbpq_1
XFILLER_67_1014 VDD VSS sg13g2_fill_1
X_12387_ _12387_/Y _15121_/Q _12348_/A _12416_/B1 _13691_/Q _13282_/A1 VDD VSS sg13g2_a221oi_1
XFILLER_99_605 VDD VSS sg13g2_decap_4
XFILLER_153_562 VDD VSS sg13g2_decap_8
X_14126_ _14126_/Q _14763_/CLK _14126_/D _14126_/RESET_B VDD VSS sg13g2_dfrbpq_1
X_11338_ _11339_/B _11338_/A _11338_/B VDD VSS sg13g2_nor2_1
XFILLER_126_798 VDD VSS sg13g2_fill_1
XFILLER_140_201 VDD VSS sg13g2_decap_4
XFILLER_119_1126 VDD VSS sg13g2_decap_4
XFILLER_141_746 VDD VSS sg13g2_fill_2
XFILLER_140_223 VDD VSS sg13g2_decap_8
X_14057_ _14057_/Q clkload6/A _14057_/D _14057_/RESET_B VDD VSS sg13g2_dfrbpq_1
X_11269_ _11287_/A _11224_/A _11258_/Y _11268_/Y VDD VSS sg13g2_o21ai_1
X_13008_ _13010_/B _13058_/A _13058_/C VDD VSS sg13g2_nand2_1
XFILLER_80_1236 VDD VSS sg13g2_fill_1
XFILLER_79_373 VDD VSS sg13g2_fill_2
XFILLER_122_982 VDD VSS sg13g2_decap_8
XFILLER_41_1209 VDD VSS sg13g2_decap_8
XFILLER_121_470 VDD VSS sg13g2_decap_8
XFILLER_94_321 VDD VSS sg13g2_decap_8
XFILLER_82_505 VDD VSS sg13g2_decap_4
XFILLER_94_365 VDD VSS sg13g2_decap_8
XFILLER_48_771 VDD VSS sg13g2_decap_8
X_14959_ _14959_/Q clkload62/A _14959_/D _14959_/RESET_B VDD VSS sg13g2_dfrbpq_1
XFILLER_36_944 VDD VSS sg13g2_decap_8
XFILLER_78_1154 VDD VSS sg13g2_decap_4
X_08480_ _08481_/B _08478_/Y _08479_/Y _08477_/Y VDD VSS sg13g2_a21oi_1
XFILLER_63_763 VDD VSS sg13g2_decap_4
XFILLER_90_560 VDD VSS sg13g2_fill_1
XFILLER_36_999 VDD VSS sg13g2_decap_8
XFILLER_50_413 VDD VSS sg13g2_fill_2
XFILLER_94_0 VDD VSS sg13g2_decap_8
X_09101_ _10752_/B _09100_/B _15043_/Q _09100_/Y VDD VSS sg13g2_o21ai_1
XFILLER_50_1040 VDD VSS sg13g2_fill_2
X_09032_ _09032_/X _09044_/A _09027_/X _09031_/Y VDD VSS sg13g2_a21o_1
XFILLER_15_1171 VDD VSS sg13g2_decap_8
XFILLER_102_1130 VDD VSS sg13g2_decap_8
X_13807__2757 _13807_/RESET_B VDD VSS sg13g2_tiehi
X_14567__1997 _14567_/RESET_B VDD VSS sg13g2_tiehi
XFILLER_7_91 VDD VSS sg13g2_decap_8
XFILLER_137_1226 VDD VSS sg13g2_decap_8
XFILLER_89_126 VDD VSS sg13g2_fill_2
XFILLER_131_223 VDD VSS sg13g2_decap_8
Xfanout802 _08637_/B _08034_/Y VDD VSS sg13g2_buf_1
XFILLER_131_234 VDD VSS sg13g2_fill_2
X_09934_ _14519_/D _14519_/Q _09934_/A1 _09934_/S VDD VSS sg13g2_mux2_1
Xfanout813 _13546_/B2 _12936_/Y VDD VSS sg13g2_buf_1
Xfanout824 _12914_/A _13272_/A2 VDD VSS sg13g2_buf_1
Xfanout835 _11196_/B _10959_/B VDD VSS sg13g2_buf_1
XFILLER_98_671 VDD VSS sg13g2_decap_4
Xfanout846 _10521_/C _10453_/C VDD VSS sg13g2_buf_1
X_14963__3009 _14963_/RESET_B VDD VSS sg13g2_tiehi
X_09865_ _14452_/D _14452_/Q _10063_/A0 _09865_/S VDD VSS sg13g2_mux2_1
Xfanout857 _08954_/S _10675_/A VDD VSS sg13g2_buf_1
XFILLER_133_25 VDD VSS sg13g2_decap_8
Xfanout868 _08940_/S _08945_/A2 VDD VSS sg13g2_buf_1
Xfanout879 _13440_/A _13427_/A VDD VSS sg13g2_buf_1
XFILLER_46_708 VDD VSS sg13g2_decap_8
XFILLER_86_877 VDD VSS sg13g2_decap_4
X_08816_ _08816_/Y _13499_/C _13481_/A _15179_/Q VDD VSS sg13g2_o21ai_1
XFILLER_100_665 VDD VSS sg13g2_fill_1
X_09796_ _14385_/D _09928_/A1 _14385_/Q wire633/X VDD VSS sg13g2_mux2_1
XFILLER_22_1142 VDD VSS sg13g2_decap_8
X_08747_ _13667_/D _08753_/A1 _08745_/Y _08746_/Y VDD VSS sg13g2_a21oi_1
XFILLER_2_1236 VDD VSS sg13g2_fill_1
XFILLER_85_398 VDD VSS sg13g2_fill_1
XFILLER_54_730 VDD VSS sg13g2_decap_4
X_14402__2162 _14402_/RESET_B VDD VSS sg13g2_tiehi
X_08678_ _08678_/Y _08678_/A _08678_/B _08678_/C VDD VSS sg13g2_nand3_1
XFILLER_26_56 VDD VSS sg13g2_decap_8
XFILLER_54_774 VDD VSS sg13g2_fill_2
XFILLER_92_1107 VDD VSS sg13g2_decap_8
XFILLER_26_476 VDD VSS sg13g2_fill_1
XFILLER_53_262 VDD VSS sg13g2_decap_4
X_07629_ _07629_/Y _08200_/A VDD VSS sg13g2_inv_1
XFILLER_144_1219 VDD VSS sg13g2_decap_8
XFILLER_13_137 VDD VSS sg13g2_fill_1
X_10640_ _14887_/D _10640_/A _10639_/Y VDD VSS sg13g2_nor2b_1
XFILLER_42_33 VDD VSS sg13g2_fill_2
XFILLER_139_323 VDD VSS sg13g2_decap_8
XFILLER_50_991 VDD VSS sg13g2_decap_4
X_10571_ _10572_/A _12895_/A _10579_/B _10571_/C VDD VSS sg13g2_and3_1
XFILLER_155_805 VDD VSS sg13g2_decap_8
XFILLER_21_170 VDD VSS sg13g2_fill_1
XFILLER_127_507 VDD VSS sg13g2_fill_2
XFILLER_42_88 VDD VSS sg13g2_decap_8
X_12310_ _12310_/Y _12310_/A _12324_/B VDD VSS sg13g2_nand2_1
XFILLER_154_315 VDD VSS sg13g2_decap_8
X_13290_ _13291_/C _13290_/A wire145/X _13294_/B _13290_/D VDD VSS sg13g2_nand4_1
X_14863__3203 _14863_/RESET_B VDD VSS sg13g2_tiehi
XFILLER_108_721 VDD VSS sg13g2_fill_2
X_12241_ _12241_/Y _12255_/A1 _14616_/Q _12259_/S1 VDD VSS sg13g2_a21oi_1
XFILLER_107_264 VDD VSS sg13g2_fill_2
XFILLER_135_584 VDD VSS sg13g2_decap_8
X_12172_ _12172_/Y _12172_/A _12172_/B VDD VSS sg13g2_nand2_1
XFILLER_123_735 VDD VSS sg13g2_fill_2
XFILLER_135_595 VDD VSS sg13g2_fill_2
XFILLER_107_297 VDD VSS sg13g2_decap_8
X_11123_ _11127_/B _11123_/A _11123_/B VDD VSS sg13g2_nor2_1
X_14896__3137 _14896_/RESET_B VDD VSS sg13g2_tiehi
XFILLER_7_1103 VDD VSS sg13g2_decap_8
XFILLER_3_49 VDD VSS sg13g2_decap_8
XFILLER_77_811 VDD VSS sg13g2_decap_8
XFILLER_122_278 VDD VSS sg13g2_decap_8
X_11054_ _11054_/Y _11069_/B _11053_/Y _11029_/C VDD VSS sg13g2_o21ai_1
X_14612__1952 _14612_/RESET_B VDD VSS sg13g2_tiehi
XFILLER_27_1075 VDD VSS sg13g2_decap_8
XFILLER_67_52 VDD VSS sg13g2_decap_4
X_10005_ _14587_/D _10071_/A0 _14587_/Q wire601/A VDD VSS sg13g2_mux2_1
XFILLER_49_557 VDD VSS sg13g2_fill_2
XFILLER_67_85 VDD VSS sg13g2_decap_8
XFILLER_64_505 VDD VSS sg13g2_fill_2
XFILLER_76_365 VDD VSS sg13g2_decap_4
XFILLER_40_1231 VDD VSS sg13g2_decap_4
XFILLER_92_825 VDD VSS sg13g2_decap_8
X_14813_ _14813_/Q _14854_/CLK _14813_/D _14813_/RESET_B VDD VSS sg13g2_dfrbpq_1
XFILLER_114_1089 VDD VSS sg13g2_decap_8
XFILLER_149_1108 VDD VSS sg13g2_fill_2
X_14744_ _14744_/Q clkload38/A _14744_/D _14744_/RESET_B VDD VSS sg13g2_dfrbpq_1
XFILLER_18_988 VDD VSS sg13g2_decap_8
X_11956_ _11957_/B _11953_/Y _11955_/Y _12290_/S1 VDD VSS sg13g2_a21oi_1
XFILLER_17_465 VDD VSS sg13g2_decap_8
XFILLER_45_774 VDD VSS sg13g2_decap_8
XFILLER_32_402 VDD VSS sg13g2_decap_8
XFILLER_17_476 VDD VSS sg13g2_fill_2
X_10907_ _10907_/Y _10907_/A _10948_/B VDD VSS sg13g2_xnor2_1
X_14675_ _14675_/Q clkload11/A _14675_/D _14675_/RESET_B VDD VSS sg13g2_dfrbpq_1
X_11887_ _11887_/Y _11890_/S0 _14478_/Q VDD VSS sg13g2_nand2b_1
XFILLER_32_446 VDD VSS sg13g2_decap_8
XFILLER_60_766 VDD VSS sg13g2_decap_8
X_13626_ _13734_/D _13626_/A VDD VSS sg13g2_buf_1
X_10838_ _10865_/A _10851_/C _14751_/Q VDD VSS sg13g2_nand2_1
XFILLER_32_479 VDD VSS sg13g2_fill_2
XFILLER_38_1171 VDD VSS sg13g2_fill_1
XFILLER_34_1024 VDD VSS sg13g2_fill_1
XFILLER_34_1035 VDD VSS sg13g2_decap_8
XFILLER_73_1095 VDD VSS sg13g2_decap_8
X_13557_ _15150_/D _15150_/Q wire730/X _13560_/S VDD VSS sg13g2_mux2_1
X_10769_ _10769_/X _14950_/Q _10769_/A2 _10767_/Y VDD VSS sg13g2_a21o_1
XFILLER_12_181 VDD VSS sg13g2_fill_2
XFILLER_34_1079 VDD VSS sg13g2_fill_1
X_12508_ _12508_/X _13958_/Q _13990_/Q _14022_/Q _14054_/Q _12508_/S0 _12508_/S1 VDD
+ VSS sg13g2_mux4_1
XFILLER_121_1038 VDD VSS sg13g2_decap_4
X_13488_ _13488_/Y _15174_/D _13487_/Y VDD VSS sg13g2_nor2b_1
X_12439_ _12439_/X _12432_/X _12436_/X _12431_/X _12435_/X _12567_/S _12566_/S0 VDD
+ VSS sg13g2_mux4_1
X_15227_ _15227_/Q _15229_/CLK _15227_/D _15227_/RESET_B VDD VSS sg13g2_dfrbpq_1
XFILLER_154_882 VDD VSS sg13g2_decap_8
XFILLER_126_573 VDD VSS sg13g2_fill_2
X_15158_ _15158_/Q clkload29/A _15158_/D _15158_/RESET_B VDD VSS sg13g2_dfrbpq_1
XFILLER_99_424 VDD VSS sg13g2_decap_8
XFILLER_5_892 VDD VSS sg13g2_decap_4
X_14109_ _14109_/Q clkload52/A _14109_/D _14109_/RESET_B VDD VSS sg13g2_dfrbpq_1
X_07980_ _07980_/Y _08577_/B _07866_/Y _07979_/Y VDD VSS sg13g2_a21oi_1
X_15089_ _15089_/Q clkload71/A _15089_/D _15089_/RESET_B VDD VSS sg13g2_dfrbpq_1
XFILLER_113_245 VDD VSS sg13g2_decap_8
XFILLER_45_1164 VDD VSS sg13g2_decap_8
XFILLER_132_1123 VDD VSS sg13g2_fill_1
X_15235__3388 _15235_/RESET_B VDD VSS sg13g2_tiehi
X_09650_ _14243_/D _09650_/A0 _14243_/Q _09666_/S VDD VSS sg13g2_mux2_1
XFILLER_80_1077 VDD VSS sg13g2_fill_1
XFILLER_95_652 VDD VSS sg13g2_decap_8
XFILLER_83_803 VDD VSS sg13g2_decap_8
XFILLER_83_814 VDD VSS sg13g2_fill_1
X_08601_ _08605_/A _08329_/B _08458_/X _08600_/Y VDD VSS sg13g2_o21ai_1
XFILLER_55_516 VDD VSS sg13g2_decap_8
XFILLER_55_527 VDD VSS sg13g2_fill_2
X_09581_ _14178_/D _14178_/Q _09649_/A0 wire329/X VDD VSS sg13g2_mux2_1
XFILLER_103_28 VDD VSS sg13g2_decap_8
X_08532_ _08532_/Y _08548_/A _08529_/Y _08531_/Y VDD VSS sg13g2_a21oi_1
XFILLER_36_763 VDD VSS sg13g2_decap_4
XFILLER_36_774 VDD VSS sg13g2_decap_4
XFILLER_63_571 VDD VSS sg13g2_fill_2
XFILLER_63_582 VDD VSS sg13g2_decap_8
X_08463_ _08463_/Y _08463_/A _08463_/B VDD VSS sg13g2_nor2_1
X_15181__3228 _15181_/RESET_B VDD VSS sg13g2_tiehi
XFILLER_51_744 VDD VSS sg13g2_fill_2
X_14050__2514 _14050_/RESET_B VDD VSS sg13g2_tiehi
XFILLER_17_1211 VDD VSS sg13g2_decap_8
X_08394_ _08395_/B _08414_/C _08394_/B _08394_/C VDD VSS sg13g2_nor3_1
XFILLER_91_1151 VDD VSS sg13g2_decap_8
XFILLER_52_1157 VDD VSS sg13g2_fill_2
XFILLER_137_816 VDD VSS sg13g2_fill_1
XFILLER_31_490 VDD VSS sg13g2_decap_8
XFILLER_12_14 VDD VSS sg13g2_decap_8
Xclkbuf_5_27__f_clk_i clkbuf_leaf_83_clk_i/A clkbuf_4_13_0_clk_i/X VDD VSS sg13g2_buf_16
XFILLER_128_14 VDD VSS sg13g2_decap_8
X_09015_ _09016_/B _15030_/Q _15227_/Q _09034_/S VDD VSS sg13g2_mux2_1
XFILLER_136_359 VDD VSS sg13g2_decap_8
XFILLER_151_307 VDD VSS sg13g2_fill_1
XFILLER_3_829 VDD VSS sg13g2_fill_1
XFILLER_88_18 VDD VSS sg13g2_fill_1
XFILLER_89_1091 VDD VSS sg13g2_fill_2
XFILLER_2_317 VDD VSS sg13g2_decap_4
XFILLER_132_521 VDD VSS sg13g2_decap_4
XFILLER_137_1023 VDD VSS sg13g2_decap_8
XFILLER_132_554 VDD VSS sg13g2_fill_2
Xfanout610 _09991_/S wire613/A VDD VSS sg13g2_buf_1
Xfanout1608 _11898_/C _13659_/Q VDD VSS sg13g2_buf_1
XFILLER_144_35 VDD VSS sg13g2_decap_8
XFILLER_63_1231 VDD VSS sg13g2_decap_4
XFILLER_99_980 VDD VSS sg13g2_fill_2
Xfanout621 _09829_/S _09826_/S VDD VSS sg13g2_buf_1
XFILLER_59_822 VDD VSS sg13g2_decap_8
Xfanout1619 _12073_/S1 _12207_/S1 VDD VSS sg13g2_buf_1
XFILLER_120_727 VDD VSS sg13g2_decap_8
X_09917_ _14502_/D _14502_/Q _09917_/A1 _09930_/S VDD VSS sg13g2_mux2_1
Xfanout632 wire633/A wire635/A VDD VSS sg13g2_buf_1
XFILLER_24_1204 VDD VSS sg13g2_decap_8
Xfanout643 _09661_/S _09641_/X VDD VSS sg13g2_buf_1
Xfanout654 _09520_/S _09533_/S VDD VSS sg13g2_buf_1
XFILLER_59_855 VDD VSS sg13g2_decap_8
XFILLER_150_1234 VDD VSS sg13g2_fill_2
X_09848_ _14435_/D _14435_/Q _10079_/A0 _09868_/S VDD VSS sg13g2_mux2_1
XFILLER_111_1207 VDD VSS sg13g2_decap_8
XFILLER_74_825 VDD VSS sg13g2_fill_1
XFILLER_101_985 VDD VSS sg13g2_fill_2
XFILLER_100_473 VDD VSS sg13g2_decap_8
XFILLER_74_847 VDD VSS sg13g2_decap_4
XFILLER_6_1180 VDD VSS sg13g2_decap_8
X_09779_ _14368_/D _09911_/A1 _14368_/Q _09798_/S VDD VSS sg13g2_mux2_1
XFILLER_37_77 VDD VSS sg13g2_decap_8
XFILLER_37_88 VDD VSS sg13g2_fill_2
X_11810_ _11810_/Y _11814_/S0 _14604_/Q _11828_/S1 VDD VSS sg13g2_a21oi_1
X_12790_ _12790_/X _12789_/X _12788_/X _12790_/S VDD VSS sg13g2_mux2_1
XFILLER_2_1066 VDD VSS sg13g2_decap_8
XFILLER_57_1013 VDD VSS sg13g2_decap_8
XFILLER_148_1141 VDD VSS sg13g2_fill_1
XFILLER_15_936 VDD VSS sg13g2_decap_8
X_11741_ _11742_/B _11741_/A _14666_/Q VDD VSS sg13g2_nand2_1
XFILLER_53_21 VDD VSS sg13g2_decap_4
XFILLER_144_1005 VDD VSS sg13g2_decap_4
XFILLER_109_1125 VDD VSS sg13g2_decap_8
X_14460_ _14460_/Q _14776_/CLK _14460_/D _14460_/RESET_B VDD VSS sg13g2_dfrbpq_1
X_11672_ _11672_/Y _11669_/Y _11671_/X _11747_/A VDD VSS sg13g2_o21ai_1
XFILLER_70_1202 VDD VSS sg13g2_fill_2
XFILLER_42_799 VDD VSS sg13g2_fill_1
X_10623_ _14882_/D _10623_/A _10623_/B _10632_/D VDD VSS sg13g2_nor3_1
X_13411_ _13490_/C _13448_/B wire809/X VDD VSS sg13g2_nand2b_1
X_14391_ _14391_/Q clkload4/A _14391_/D _14391_/RESET_B VDD VSS sg13g2_dfrbpq_1
X_13342_ _15068_/D _11288_/A _13654_/S _13341_/Y VDD VSS sg13g2_a21o_1
XFILLER_155_624 VDD VSS sg13g2_fill_1
XFILLER_139_175 VDD VSS sg13g2_decap_8
X_10554_ _14866_/D _10554_/A _10555_/B _10557_/C VDD VSS sg13g2_and3_1
XFILLER_154_112 VDD VSS sg13g2_decap_8
X_14812__3286 _14812_/RESET_B VDD VSS sg13g2_tiehi
XFILLER_6_645 VDD VSS sg13g2_decap_4
X_13273_ _13273_/Y _13273_/A _13273_/B VDD VSS sg13g2_nand2_1
XFILLER_155_679 VDD VSS sg13g2_decap_8
X_10485_ _10508_/C _14849_/Q _13084_/A _14847_/Q _14846_/Q VDD VSS sg13g2_and4_1
XFILLER_5_133 VDD VSS sg13g2_decap_8
XFILLER_108_551 VDD VSS sg13g2_fill_2
XFILLER_68_1131 VDD VSS sg13g2_fill_2
X_12224_ _12224_/Y _13245_/A _12267_/A2 _12156_/A VDD VSS sg13g2_a21oi_1
X_15012_ _15012_/Q _15200_/CLK _15012_/D _15012_/RESET_B VDD VSS sg13g2_dfrbpq_1
XFILLER_154_189 VDD VSS sg13g2_decap_8
X_13894__2670 _13894_/RESET_B VDD VSS sg13g2_tiehi
XFILLER_29_1104 VDD VSS sg13g2_decap_8
XFILLER_29_1137 VDD VSS sg13g2_decap_8
XFILLER_64_1017 VDD VSS sg13g2_decap_8
X_12155_ _12156_/C _12155_/A _12155_/B _12198_/D VDD VSS sg13g2_nand3_1
XFILLER_68_1197 VDD VSS sg13g2_decap_8
XFILLER_155_1156 VDD VSS sg13g2_decap_8
XFILLER_150_351 VDD VSS sg13g2_decap_8
XFILLER_150_373 VDD VSS sg13g2_decap_8
X_11106_ _11106_/Y _11093_/Y _11105_/Y _11151_/A VDD VSS sg13g2_a21oi_1
X_12086_ _12086_/X _12197_/B _12086_/B VDD VSS sg13g2_xor2_1
XFILLER_111_749 VDD VSS sg13g2_decap_4
XFILLER_96_449 VDD VSS sg13g2_fill_1
XFILLER_110_226 VDD VSS sg13g2_fill_1
X_14274__2290 _14274_/RESET_B VDD VSS sg13g2_tiehi
X_11037_ _11037_/Y _11036_/Y _11064_/C _11043_/A VDD VSS sg13g2_a21oi_1
XFILLER_49_376 VDD VSS sg13g2_decap_8
XFILLER_37_527 VDD VSS sg13g2_decap_8
XFILLER_64_313 VDD VSS sg13g2_decap_8
XFILLER_77_696 VDD VSS sg13g2_decap_8
XFILLER_18_730 VDD VSS sg13g2_decap_8
XFILLER_94_94 VDD VSS sg13g2_decap_8
X_12988_ _12989_/C _12988_/A _12988_/B _12988_/C _12988_/D VDD VSS sg13g2_nor4_1
XFILLER_91_165 VDD VSS sg13g2_fill_1
XFILLER_33_733 VDD VSS sg13g2_decap_8
X_14727_ _14727_/Q clkload10/A _14727_/D _14727_/RESET_B VDD VSS sg13g2_dfrbpq_1
XFILLER_127_1203 VDD VSS sg13g2_fill_1
X_11939_ _11939_/Y _12055_/B _11937_/Y _11938_/Y VDD VSS sg13g2_o21ai_1
XFILLER_60_530 VDD VSS sg13g2_decap_8
XFILLER_75_1157 VDD VSS sg13g2_fill_2
XFILLER_21_906 VDD VSS sg13g2_fill_2
X_14658_ _14658_/Q clkload22/A _14658_/D _14658_/RESET_B VDD VSS sg13g2_dfrbpq_1
XFILLER_60_574 VDD VSS sg13g2_decap_8
XFILLER_20_427 VDD VSS sg13g2_decap_8
X_13609_ _13609_/Y _13609_/A _13609_/B VDD VSS sg13g2_nor2_1
X_14589_ _14589_/Q clkload52/A _14589_/D _14589_/RESET_B VDD VSS sg13g2_dfrbpq_1
XFILLER_145_123 VDD VSS sg13g2_decap_4
XFILLER_12_1130 VDD VSS sg13g2_decap_8
XFILLER_145_167 VDD VSS sg13g2_decap_8
XFILLER_57_0 VDD VSS sg13g2_decap_8
X_13724__2840 _13724_/RESET_B VDD VSS sg13g2_tiehi
XFILLER_126_392 VDD VSS sg13g2_decap_4
XFILLER_47_1226 VDD VSS sg13g2_decap_8
XFILLER_82_1106 VDD VSS sg13g2_decap_8
XFILLER_88_939 VDD VSS sg13g2_fill_1
XFILLER_141_373 VDD VSS sg13g2_decap_4
XFILLER_4_70 VDD VSS sg13g2_decap_8
XFILLER_87_427 VDD VSS sg13g2_fill_1
XFILLER_141_384 VDD VSS sg13g2_decap_4
X_07963_ _07963_/Y _15013_/Q _07861_/B VDD VSS sg13g2_nor2b_1
XFILLER_114_598 VDD VSS sg13g2_fill_1
XFILLER_101_237 VDD VSS sg13g2_fill_2
X_09702_ _14294_/D _09900_/A0 _14294_/Q wire458/X VDD VSS sg13g2_mux2_1
X_14104__2460 _14104_/RESET_B VDD VSS sg13g2_tiehi
X_07894_ _07904_/B _07917_/B _08160_/B VDD VSS sg13g2_nor2_1
XFILLER_68_685 VDD VSS sg13g2_decap_8
X_09633_ _14229_/D _10097_/A0 _14229_/Q _09637_/S VDD VSS sg13g2_mux2_1
XFILLER_56_858 VDD VSS sg13g2_decap_8
XFILLER_67_184 VDD VSS sg13g2_fill_1
XFILLER_82_143 VDD VSS sg13g2_fill_2
X_14708__1856 _14708_/RESET_B VDD VSS sg13g2_tiehi
X_09564_ _14162_/D _09830_/A0 _14162_/Q _09564_/S VDD VSS sg13g2_mux2_1
X_14880__3169 _14880_/RESET_B VDD VSS sg13g2_tiehi
XFILLER_55_379 VDD VSS sg13g2_decap_4
X_08515_ _08515_/Y _07816_/X _08001_/A _08542_/A2 VDD VSS sg13g2_o21ai_1
X_09495_ _14095_/D _09992_/A0 _14095_/Q _09495_/S VDD VSS sg13g2_mux2_1
XFILLER_82_198 VDD VSS sg13g2_decap_8
X_13972__2592 _13972_/RESET_B VDD VSS sg13g2_tiehi
X_08446_ _08447_/B wire232/X _08444_/Y _08445_/Y VDD VSS sg13g2_o21ai_1
XFILLER_23_276 VDD VSS sg13g2_decap_8
XFILLER_51_596 VDD VSS sg13g2_decap_8
XFILLER_23_35 VDD VSS sg13g2_decap_8
XFILLER_11_438 VDD VSS sg13g2_fill_1
X_08377_ _08377_/Y _08300_/X _08621_/B VDD VSS sg13g2_nand2b_1
XFILLER_135_7 VDD VSS sg13g2_decap_8
XFILLER_137_602 VDD VSS sg13g2_decap_8
XFILLER_139_35 VDD VSS sg13g2_decap_8
XFILLER_137_613 VDD VSS sg13g2_fill_2
Xwire329 wire329/X wire329/A VDD VSS sg13g2_buf_8
XFILLER_17_1085 VDD VSS sg13g2_decap_8
XFILLER_137_668 VDD VSS sg13g2_decap_8
XFILLER_152_616 VDD VSS sg13g2_fill_2
XFILLER_139_1118 VDD VSS sg13g2_decap_8
X_10270_ _10305_/A _14784_/Q _14785_/Q _10278_/C VDD VSS sg13g2_and3_1
XFILLER_118_893 VDD VSS sg13g2_decap_8
XFILLER_151_126 VDD VSS sg13g2_decap_8
XFILLER_105_521 VDD VSS sg13g2_decap_8
XFILLER_3_648 VDD VSS sg13g2_fill_1
X_15186__3192 _15186_/RESET_B VDD VSS sg13g2_tiehi
XFILLER_155_56 VDD VSS sg13g2_decap_8
XFILLER_3_659 VDD VSS sg13g2_decap_8
XFILLER_79_906 VDD VSS sg13g2_fill_1
XFILLER_2_147 VDD VSS sg13g2_decap_8
XFILLER_78_405 VDD VSS sg13g2_decap_8
XFILLER_78_416 VDD VSS sg13g2_fill_2
Xfanout1405 _08673_/B _08686_/A1 VDD VSS sg13g2_buf_1
Xfanout1416 _12152_/A _14984_/Q VDD VSS sg13g2_buf_1
Xfanout1427 _08598_/A3 _12009_/A VDD VSS sg13g2_buf_1
XFILLER_48_21 VDD VSS sg13g2_decap_8
XFILLER_24_1001 VDD VSS sg13g2_decap_8
XFILLER_63_1050 VDD VSS sg13g2_decap_4
Xfanout1438 _11914_/A _14977_/Q VDD VSS sg13g2_buf_1
Xfanout1449 _07825_/B _14973_/Q VDD VSS sg13g2_buf_1
Xfanout451 _09729_/S _09739_/S VDD VSS sg13g2_buf_1
Xfanout462 _09694_/S _09674_/X VDD VSS sg13g2_buf_1
XFILLER_28_1192 VDD VSS sg13g2_decap_8
X_13960_ _13960_/Q clkload27/A _13960_/D _13960_/RESET_B VDD VSS sg13g2_dfrbpq_1
XFILLER_48_65 VDD VSS sg13g2_decap_8
XFILLER_47_803 VDD VSS sg13g2_decap_4
Xfanout473 _09495_/S _09500_/S VDD VSS sg13g2_buf_1
XFILLER_58_140 VDD VSS sg13g2_fill_2
Xwire1533 _10177_/B _14766_/Q VDD VSS sg13g2_buf_8
XFILLER_115_1162 VDD VSS sg13g2_decap_8
Xfanout495 wire496/A fanout495/A VDD VSS sg13g2_buf_1
XFILLER_115_1173 VDD VSS sg13g2_fill_1
XFILLER_47_836 VDD VSS sg13g2_decap_8
XFILLER_111_1015 VDD VSS sg13g2_decap_4
XFILLER_4_1139 VDD VSS sg13g2_decap_8
XFILLER_47_847 VDD VSS sg13g2_fill_2
X_12911_ _12911_/Y input28/X _12911_/B VDD VSS sg13g2_nand2b_1
XFILLER_115_1184 VDD VSS sg13g2_decap_8
XFILLER_24_1078 VDD VSS sg13g2_decap_8
Xwire1566 _16859_/A _13697_/Q VDD VSS sg13g2_buf_8
XFILLER_73_110 VDD VSS sg13g2_fill_2
XFILLER_74_633 VDD VSS sg13g2_fill_1
X_13891_ _13891_/Q _14505_/CLK _13891_/D _13891_/RESET_B VDD VSS sg13g2_dfrbpq_1
XFILLER_58_195 VDD VSS sg13g2_fill_1
XFILLER_74_655 VDD VSS sg13g2_decap_8
XFILLER_62_806 VDD VSS sg13g2_fill_2
XFILLER_73_154 VDD VSS sg13g2_fill_2
XFILLER_98_1179 VDD VSS sg13g2_decap_8
X_12842_ _12845_/B _12900_/A _12900_/B _12884_/C input14/X VDD VSS sg13g2_nand4_1
XFILLER_15_700 VDD VSS sg13g2_decap_4
XFILLER_73_198 VDD VSS sg13g2_decap_4
XFILLER_61_349 VDD VSS sg13g2_decap_8
X_12773_ _12773_/X _14265_/Q _14297_/Q _14329_/Q _14361_/Q _12773_/S0 _12773_/S1 VDD
+ VSS sg13g2_mux4_1
X_14512_ _14512_/Q clkload46/A _14512_/D _14512_/RESET_B VDD VSS sg13g2_dfrbpq_1
X_13802__2762 _13802_/RESET_B VDD VSS sg13g2_tiehi
X_11724_ _11724_/Y _11726_/A _11724_/B VDD VSS sg13g2_nor2_1
XFILLER_14_276 VDD VSS sg13g2_decap_8
X_11655_ _11655_/Y _14906_/Q _11655_/B VDD VSS sg13g2_nand2_1
X_14443_ _14443_/Q _14667_/CLK _14443_/D _14443_/RESET_B VDD VSS sg13g2_dfrbpq_1
XFILLER_80_63 VDD VSS sg13g2_decap_8
XFILLER_128_602 VDD VSS sg13g2_decap_8
X_15234__3387 _15234_/RESET_B VDD VSS sg13g2_tiehi
XFILLER_156_933 VDD VSS sg13g2_fill_2
X_10606_ _10629_/C _10606_/A _10606_/B _10652_/A VDD VSS sg13g2_nor3_1
XFILLER_11_972 VDD VSS sg13g2_decap_8
XFILLER_7_921 VDD VSS sg13g2_decap_8
X_11586_ _11586_/Y _12957_/A _11655_/B _11631_/A2 VDD VSS sg13g2_a21oi_1
X_14374_ _14374_/Q clkload17/A _14374_/D _14374_/RESET_B VDD VSS sg13g2_dfrbpq_1
X_14146__2418 _14146_/RESET_B VDD VSS sg13g2_tiehi
XFILLER_7_932 VDD VSS sg13g2_fill_2
XFILLER_128_646 VDD VSS sg13g2_decap_8
XFILLER_155_432 VDD VSS sg13g2_decap_8
XFILLER_7_943 VDD VSS sg13g2_fill_1
XFILLER_128_657 VDD VSS sg13g2_fill_1
X_10537_ _10567_/B _14861_/Q _14860_/Q _14859_/Q _10558_/B VDD VSS sg13g2_nand4_1
X_13325_ _13326_/B _15113_/Q wire810/X _13309_/Y _10105_/C VDD VSS sg13g2_a22oi_1
Xmax_cap607 _09996_/S _09987_/S VDD VSS sg13g2_buf_4
XFILLER_109_860 VDD VSS sg13g2_fill_2
XFILLER_115_307 VDD VSS sg13g2_decap_8
XFILLER_7_998 VDD VSS sg13g2_decap_8
XFILLER_50_7 VDD VSS sg13g2_fill_2
XFILLER_109_893 VDD VSS sg13g2_decap_4
X_10468_ _14844_/D _10468_/A _10468_/B _10468_/C VDD VSS sg13g2_nor3_1
X_13256_ _13259_/A _13243_/Y _13232_/A _13255_/Y VDD VSS sg13g2_o21ai_1
XFILLER_89_72 VDD VSS sg13g2_decap_4
XFILLER_142_159 VDD VSS sg13g2_fill_1
X_12207_ _12207_/X _13847_/Q _13879_/Q _13911_/Q _13943_/Q _12207_/S0 _12207_/S1 VDD
+ VSS sg13g2_mux4_1
XFILLER_89_94 VDD VSS sg13g2_decap_8
XFILLER_9_1006 VDD VSS sg13g2_decap_4
X_13187_ _13191_/A wire182/X _13225_/A _13186_/X VDD VSS sg13g2_a21o_1
XFILLER_97_703 VDD VSS sg13g2_fill_1
X_10399_ _10414_/C _10400_/B _10400_/C _10400_/D VDD VSS sg13g2_nor3_1
X_14361__2203 _14361_/RESET_B VDD VSS sg13g2_tiehi
XFILLER_2_670 VDD VSS sg13g2_decap_8
X_12138_ _12138_/X _14389_/Q _14421_/Q _14485_/Q _14517_/Q _12287_/S0 _12287_/S1 VDD
+ VSS sg13g2_mux4_1
XFILLER_69_449 VDD VSS sg13g2_fill_1
XFILLER_38_803 VDD VSS sg13g2_decap_8
X_12069_ _12069_/X _14259_/Q _14291_/Q _14323_/Q _14355_/Q _12072_/S0 _12072_/S1 VDD
+ VSS sg13g2_mux4_1
XFILLER_96_268 VDD VSS sg13g2_decap_8
XFILLER_38_814 VDD VSS sg13g2_fill_1
XFILLER_78_983 VDD VSS sg13g2_fill_2
XFILLER_42_1167 VDD VSS sg13g2_decap_8
X_16877_ _16877_/X _16877_/A VDD VSS sg13g2_buf_1
XFILLER_92_430 VDD VSS sg13g2_fill_1
XFILLER_77_1208 VDD VSS sg13g2_fill_1
XFILLER_65_666 VDD VSS sg13g2_fill_1
XFILLER_77_1219 VDD VSS sg13g2_decap_8
XFILLER_93_997 VDD VSS sg13g2_decap_8
XFILLER_80_625 VDD VSS sg13g2_decap_8
XFILLER_45_390 VDD VSS sg13g2_fill_2
XFILLER_80_669 VDD VSS sg13g2_fill_1
X_08300_ _08300_/X _07775_/A _08337_/A3 _08327_/A3 _08300_/A3 _08686_/S0 _08686_/S1
+ VDD VSS sg13g2_mux4_1
X_09280_ _13888_/D _13888_/Q _09911_/A1 _09302_/S VDD VSS sg13g2_mux2_1
XFILLER_21_736 VDD VSS sg13g2_fill_1
X_08231_ _08231_/Y _07924_/C _08230_/Y _08000_/X VDD VSS sg13g2_o21ai_1
XFILLER_14_1225 VDD VSS sg13g2_decap_8
X_08162_ _08162_/Y _08182_/B _08115_/B _08140_/Y VDD VSS sg13g2_o21ai_1
XFILLER_14_1236 VDD VSS sg13g2_fill_1
XFILLER_146_421 VDD VSS sg13g2_fill_1
XFILLER_118_112 VDD VSS sg13g2_decap_8
X_08093_ _08093_/Y _07879_/Y _08091_/Y _08092_/Y VDD VSS sg13g2_a21oi_1
XFILLER_147_999 VDD VSS sg13g2_fill_1
X_14908__3113 _14908_/RESET_B VDD VSS sg13g2_tiehi
XFILLER_106_318 VDD VSS sg13g2_decap_8
Xclkload50 clkload50/Y clkload50/A VDD VSS sg13g2_inv_1
Xclkload61 clkload61/Y clkload61/A VDD VSS sg13g2_inv_1
Xclkload72 clkload72/Y clkload72/A VDD VSS sg13g2_inv_1
Xclkload83 clkload83/Y clkload83/A VDD VSS sg13g2_inv_1
XFILLER_138_1140 VDD VSS sg13g2_decap_8
Xhold3502 _13622_/A _13730_/Q VDD VSS sg13g2_dlygate4sd3_1
XFILLER_138_1151 VDD VSS sg13g2_fill_2
XFILLER_47_1034 VDD VSS sg13g2_fill_2
Xhold3513 _11196_/A _14956_/Q VDD VSS sg13g2_dlygate4sd3_1
Xhold3524 hold3524/X _14827_/Q VDD VSS sg13g2_dlygate4sd3_1
XFILLER_0_629 VDD VSS sg13g2_decap_4
Xhold3535 _13547_/A _15147_/Q VDD VSS sg13g2_dlygate4sd3_1
XFILLER_138_1184 VDD VSS sg13g2_fill_1
X_08995_ _08995_/Y _14899_/Q _08988_/C _08995_/B1 VDD VSS sg13g2_o21ai_1
XFILLER_69_961 VDD VSS sg13g2_decap_8
XFILLER_60_1223 VDD VSS sg13g2_decap_8
XFILLER_87_268 VDD VSS sg13g2_decap_8
X_07946_ _08435_/A _15005_/Q _07946_/B VDD VSS sg13g2_nand2b_1
XFILLER_18_35 VDD VSS sg13g2_decap_8
XFILLER_141_14 VDD VSS sg13g2_decap_8
XFILLER_21_1229 VDD VSS sg13g2_decap_8
X_07877_ _07917_/A _07879_/A _08452_/D VDD VSS sg13g2_nor2_1
XFILLER_56_655 VDD VSS sg13g2_decap_8
X_15189__3174 _15189_/RESET_B VDD VSS sg13g2_tiehi
X_09616_ _14212_/D _09616_/A0 _14212_/Q _09631_/S VDD VSS sg13g2_mux2_1
XFILLER_16_508 VDD VSS sg13g2_decap_4
XFILLER_71_603 VDD VSS sg13g2_decap_8
X_09547_ _14145_/D _09613_/A0 _14145_/Q _09556_/S VDD VSS sg13g2_mux2_1
XFILLER_97_1190 VDD VSS sg13g2_decap_8
XFILLER_110_1092 VDD VSS sg13g2_decap_4
XFILLER_19_1114 VDD VSS sg13g2_decap_8
XFILLER_12_703 VDD VSS sg13g2_decap_8
X_09478_ _14078_/D _10141_/A1 _14078_/Q wire480/X VDD VSS sg13g2_mux2_1
X_15119__3106 _15119_/RESET_B VDD VSS sg13g2_tiehi
X_08429_ _08429_/Y _08429_/A _08659_/B _08429_/C VDD VSS sg13g2_nor3_1
XFILLER_156_207 VDD VSS sg13g2_decap_8
XFILLER_156_218 VDD VSS sg13g2_fill_1
XFILLER_133_4 VDD VSS sg13g2_decap_8
Xclkload0 clkload0/Y clkload0/A VDD VSS sg13g2_inv_1
X_11440_ _11440_/X _14560_/Q _14592_/Q _14624_/Q _14656_/Q _12213_/S0 _12169_/C VDD
+ VSS sg13g2_mux4_1
XFILLER_109_123 VDD VSS sg13g2_fill_2
X_11371_ _11371_/Y _11373_/A _14142_/Q _11374_/C VDD VSS sg13g2_a21oi_1
XFILLER_109_167 VDD VSS sg13g2_fill_1
X_13110_ _13111_/B _13265_/A1 _13105_/X _13104_/Y _13309_/A2 _13109_/Y VDD VSS sg13g2_a221oi_1
X_10322_ _14800_/D _10322_/A _10323_/B _10444_/C VDD VSS sg13g2_and3_1
X_14090_ _14090_/Q clkload21/A _14090_/D _14090_/RESET_B VDD VSS sg13g2_dfrbpq_1
XFILLER_109_189 VDD VSS sg13g2_fill_1
XFILLER_106_830 VDD VSS sg13g2_fill_1
XFILLER_124_137 VDD VSS sg13g2_decap_8
X_13041_ _13041_/Y _13042_/A _13042_/B _13042_/C VDD VSS sg13g2_a21oi_1
X_10253_ _14779_/D _14779_/Q _10258_/D _10252_/Y VDD VSS sg13g2_a21oi_1
XFILLER_4_979 VDD VSS sg13g2_decap_8
XFILLER_117_1202 VDD VSS sg13g2_decap_8
XFILLER_26_1107 VDD VSS sg13g2_decap_8
XFILLER_133_693 VDD VSS sg13g2_decap_4
XFILLER_152_1126 VDD VSS sg13g2_decap_8
X_10184_ _10184_/X input36/X _10184_/B _10184_/C VDD VSS sg13g2_or3_1
Xfanout1202 _12588_/S0 fanout1205/X VDD VSS sg13g2_buf_1
Xfanout1213 _12368_/S0 _12351_/S0 VDD VSS sg13g2_buf_1
XFILLER_78_235 VDD VSS sg13g2_fill_1
XFILLER_121_855 VDD VSS sg13g2_decap_8
XFILLER_59_97 VDD VSS sg13g2_fill_1
XFILLER_79_769 VDD VSS sg13g2_fill_2
Xfanout1224 _13247_/D _13271_/C VDD VSS sg13g2_buf_1
Xfanout1235 _12779_/A2 _12403_/A2 VDD VSS sg13g2_buf_1
Xfanout1246 _12899_/C _12844_/C VDD VSS sg13g2_buf_1
XFILLER_94_728 VDD VSS sg13g2_fill_1
X_14992_ _14992_/Q clkload41/A _14992_/D _14992_/RESET_B VDD VSS sg13g2_dfrbpq_1
Xfanout1257 _10199_/A1 _15181_/Q VDD VSS sg13g2_buf_1
XFILLER_59_471 VDD VSS sg13g2_decap_4
Xfanout1268 _13162_/B1 _15108_/Q VDD VSS sg13g2_buf_1
Xfanout1279 _13068_/B _13180_/A2 VDD VSS sg13g2_buf_1
XFILLER_8_1083 VDD VSS sg13g2_decap_8
Xfanout281 _11724_/B _11246_/Y VDD VSS sg13g2_buf_1
Xfanout292 _10149_/A1 _09917_/A1 VDD VSS sg13g2_buf_1
XFILLER_93_238 VDD VSS sg13g2_decap_8
X_13943_ _13943_/Q clkload4/A _13943_/D _13943_/RESET_B VDD VSS sg13g2_dfrbpq_1
XFILLER_46_110 VDD VSS sg13g2_decap_8
XFILLER_75_986 VDD VSS sg13g2_decap_4
XFILLER_90_912 VDD VSS sg13g2_fill_2
XFILLER_35_828 VDD VSS sg13g2_decap_4
X_13874_ _13874_/Q _14738_/CLK _13874_/D _13874_/RESET_B VDD VSS sg13g2_dfrbpq_1
XFILLER_34_316 VDD VSS sg13g2_fill_1
XFILLER_62_647 VDD VSS sg13g2_fill_1
X_12825_ _12828_/B _12866_/A _12825_/B _12899_/C input22/X VDD VSS sg13g2_nand4_1
XFILLER_90_978 VDD VSS sg13g2_decap_8
XFILLER_90_989 VDD VSS sg13g2_fill_1
X_12756_ _12756_/X _14584_/Q _14616_/Q _14648_/Q _14680_/Q _12757_/S0 _12757_/S1 VDD
+ VSS sg13g2_mux4_1
XFILLER_72_1116 VDD VSS sg13g2_decap_8
XFILLER_98_7 VDD VSS sg13g2_decap_8
X_11707_ _11707_/Y _11707_/A _11773_/C VDD VSS sg13g2_xnor2_1
X_12687_ _12687_/X _14707_/Q _14739_/Q _13779_/Q _13811_/Q _12689_/S0 _12689_/S1 VDD
+ VSS sg13g2_mux4_1
X_14426_ _14426_/Q clkload47/A _14426_/D _14426_/RESET_B VDD VSS sg13g2_dfrbpq_1
X_11638_ _11638_/X _11638_/A _11638_/B _11638_/C VDD VSS sg13g2_or3_1
XFILLER_156_730 VDD VSS sg13g2_fill_2
XFILLER_129_955 VDD VSS sg13g2_fill_2
XFILLER_129_966 VDD VSS sg13g2_fill_1
XFILLER_156_763 VDD VSS sg13g2_fill_1
X_14357_ _14357_/Q clkload14/A _14357_/D _14357_/RESET_B VDD VSS sg13g2_dfrbpq_1
Xwire671 wire671/X wire671/A VDD VSS sg13g2_buf_4
X_11569_ _11572_/A _11638_/A _11571_/C VDD VSS sg13g2_nor2_1
Xmax_cap404 _10101_/S _10094_/S VDD VSS sg13g2_buf_4
XFILLER_116_616 VDD VSS sg13g2_decap_8
XFILLER_155_273 VDD VSS sg13g2_decap_8
X_13308_ _13308_/Y _13308_/A _13308_/B VDD VSS sg13g2_nor2_1
Xmax_cap437 _09869_/S fanout436/X VDD VSS sg13g2_buf_8
X_14288_ _14288_/Q _14714_/CLK _14288_/D _14288_/RESET_B VDD VSS sg13g2_dfrbpq_1
XFILLER_131_608 VDD VSS sg13g2_fill_1
X_13239_ _15049_/D _13239_/A wire146/X VDD VSS sg13g2_nor2_1
XFILLER_97_500 VDD VSS sg13g2_fill_1
XFILLER_152_980 VDD VSS sg13g2_decap_8
XFILLER_130_129 VDD VSS sg13g2_fill_2
XFILLER_69_257 VDD VSS sg13g2_decap_4
X_07800_ _08574_/A _15006_/Q _07800_/B VDD VSS sg13g2_xor2_1
X_08780_ _13678_/D _08780_/A1 _08779_/Y _08778_/Y VDD VSS sg13g2_a21oi_1
XFILLER_111_365 VDD VSS sg13g2_decap_4
X_07731_ _07907_/D _15077_/Q _15075_/Q VDD VSS sg13g2_or2_1
Xfanout1780 _13440_/B _13600_/C VDD VSS sg13g2_buf_1
Xfanout1791 _10630_/C fanout1794/X VDD VSS sg13g2_buf_1
XFILLER_26_806 VDD VSS sg13g2_fill_1
XFILLER_66_975 VDD VSS sg13g2_decap_4
X_07662_ _07662_/Y _14764_/Q wire807/X VDD VSS sg13g2_nor2_1
XFILLER_66_986 VDD VSS sg13g2_fill_1
X_09401_ _14004_/D _10063_/A0 _14004_/Q _09403_/S VDD VSS sg13g2_mux2_1
XFILLER_65_496 VDD VSS sg13g2_fill_1
X_14771__3327 _14771_/RESET_B VDD VSS sg13g2_tiehi
XFILLER_80_455 VDD VSS sg13g2_fill_1
XFILLER_52_157 VDD VSS sg13g2_decap_8
XFILLER_34_872 VDD VSS sg13g2_decap_8
X_09332_ _13939_/D _09332_/A0 _13939_/Q _09333_/S VDD VSS sg13g2_mux2_1
XFILLER_34_883 VDD VSS sg13g2_fill_1
XFILLER_33_371 VDD VSS sg13g2_decap_8
XFILLER_21_511 VDD VSS sg13g2_fill_2
X_15100__3156 _15100_/RESET_B VDD VSS sg13g2_tiehi
X_09263_ _13872_/D _13872_/Q _10159_/A1 _09272_/S VDD VSS sg13g2_mux2_1
XFILLER_14_1000 VDD VSS sg13g2_decap_8
X_08214_ _08214_/X _08374_/B _08363_/S0 _08212_/X VDD VSS sg13g2_a21o_1
XFILLER_18_1191 VDD VSS sg13g2_decap_8
XFILLER_53_1071 VDD VSS sg13g2_fill_1
X_09194_ _13810_/D _13810_/Q _10161_/A1 _09201_/S VDD VSS sg13g2_mux2_1
XFILLER_140_1030 VDD VSS sg13g2_fill_1
XFILLER_21_599 VDD VSS sg13g2_decap_8
XFILLER_105_1150 VDD VSS sg13g2_decap_8
X_08145_ _15221_/D _08145_/A _08145_/B _08145_/C VDD VSS sg13g2_nand3_1
XFILLER_119_454 VDD VSS sg13g2_decap_8
XFILLER_146_240 VDD VSS sg13g2_decap_8
XFILLER_135_914 VDD VSS sg13g2_fill_1
XFILLER_101_1025 VDD VSS sg13g2_decap_4
XFILLER_105_1194 VDD VSS sg13g2_decap_8
XFILLER_20_14 VDD VSS sg13g2_decap_8
XFILLER_14_1099 VDD VSS sg13g2_decap_8
X_08076_ _08076_/Y _07626_/A _08074_/X _08075_/Y VDD VSS sg13g2_a21oi_1
XFILLER_136_14 VDD VSS sg13g2_decap_8
XFILLER_150_917 VDD VSS sg13g2_fill_2
XFILLER_150_928 VDD VSS sg13g2_fill_2
Xmax_cap960 _11975_/A _11313_/A1 VDD VSS sg13g2_buf_4
XFILLER_121_107 VDD VSS sg13g2_fill_2
XFILLER_143_991 VDD VSS sg13g2_fill_2
XFILLER_0_415 VDD VSS sg13g2_decap_8
X_15148__3046 _15148_/RESET_B VDD VSS sg13g2_tiehi
XFILLER_88_522 VDD VSS sg13g2_decap_8
XFILLER_0_426 VDD VSS sg13g2_fill_1
XFILLER_114_181 VDD VSS sg13g2_decap_8
XFILLER_130_641 VDD VSS sg13g2_decap_8
XFILLER_88_555 VDD VSS sg13g2_decap_8
XFILLER_102_365 VDD VSS sg13g2_decap_4
X_08978_ wire543/A _10674_/A _08988_/A _08977_/Y VDD VSS sg13g2_o21ai_1
XFILLER_152_35 VDD VSS sg13g2_decap_8
XFILLER_29_611 VDD VSS sg13g2_fill_1
XFILLER_29_67 VDD VSS sg13g2_fill_2
XFILLER_25_1151 VDD VSS sg13g2_decap_8
XFILLER_57_920 VDD VSS sg13g2_fill_2
XFILLER_29_633 VDD VSS sg13g2_decap_8
XFILLER_5_1234 VDD VSS sg13g2_fill_2
X_15233__3386 _15233_/RESET_B VDD VSS sg13g2_tiehi
X_07929_ _07930_/A _08263_/B _11502_/A VDD VSS sg13g2_nand2b_1
XFILLER_57_953 VDD VSS sg13g2_decap_8
X_14457__2107 _14457_/RESET_B VDD VSS sg13g2_tiehi
XFILLER_21_1026 VDD VSS sg13g2_decap_8
XFILLER_57_964 VDD VSS sg13g2_fill_2
XFILLER_60_1075 VDD VSS sg13g2_fill_2
XFILLER_29_677 VDD VSS sg13g2_decap_4
X_10940_ _14937_/D _10939_/Y _10938_/Y _10929_/Y VDD VSS sg13g2_o21ai_1
XFILLER_95_1105 VDD VSS sg13g2_decap_8
XFILLER_95_1116 VDD VSS sg13g2_fill_1
XFILLER_28_176 VDD VSS sg13g2_fill_2
XFILLER_112_1187 VDD VSS sg13g2_decap_8
X_10871_ _10871_/Y _10871_/A _10871_/B VDD VSS sg13g2_xnor2_1
XFILLER_71_466 VDD VSS sg13g2_decap_8
XFILLER_72_989 VDD VSS sg13g2_decap_4
X_12610_ wire376/A _13675_/Q _12679_/A2 _12609_/X _12679_/B2 _12791_/C1 VDD VSS sg13g2_a221oi_1
X_13590_ _13590_/Y _15162_/Q _13590_/B VDD VSS sg13g2_nor2_1
XFILLER_43_179 VDD VSS sg13g2_decap_4
XFILLER_52_680 VDD VSS sg13g2_decap_4
XFILLER_52_691 VDD VSS sg13g2_fill_1
X_12541_ _15002_/D _12541_/A _12541_/B VDD VSS sg13g2_nor2_1
XFILLER_61_21 VDD VSS sg13g2_decap_8
XFILLER_101_72 VDD VSS sg13g2_decap_4
XFILLER_61_32 VDD VSS sg13g2_fill_1
XFILLER_8_504 VDD VSS sg13g2_decap_8
XFILLER_61_43 VDD VSS sg13g2_decap_8
XFILLER_40_875 VDD VSS sg13g2_fill_1
X_12472_ _12485_/A _07625_/A _12751_/A2 _14998_/Q VDD VSS sg13g2_a21oi_1
XFILLER_12_599 VDD VSS sg13g2_fill_2
XFILLER_138_752 VDD VSS sg13g2_fill_1
X_14211_ _14211_/Q clkload2/A _14211_/D _14211_/RESET_B VDD VSS sg13g2_dfrbpq_1
XFILLER_71_1193 VDD VSS sg13g2_decap_8
XFILLER_124_0 VDD VSS sg13g2_decap_8
X_11423_ _11423_/Y _11420_/Y _11422_/Y _12000_/A VDD VSS sg13g2_a21oi_1
X_15191_ _15191_/Q _15212_/CLK _15191_/D _15191_/RESET_B VDD VSS sg13g2_dfrbpq_1
XFILLER_6_49 VDD VSS sg13g2_decap_8
XANTENNA_9 _11983_/A VDD VSS sg13g2_antennanp
X_14063__2501 _14063_/RESET_B VDD VSS sg13g2_tiehi
X_11354_ _11354_/Y _11353_/S _14622_/Q VDD VSS sg13g2_nand2b_1
X_14142_ _14142_/Q _14494_/CLK _14142_/D _14142_/RESET_B VDD VSS sg13g2_dfrbpq_1
XFILLER_152_221 VDD VSS sg13g2_decap_8
XFILLER_4_732 VDD VSS sg13g2_decap_8
XFILLER_67_1218 VDD VSS sg13g2_fill_2
XFILLER_99_809 VDD VSS sg13g2_fill_2
X_10305_ _10327_/B _10305_/A _10305_/B _10311_/B _10311_/C VDD VSS sg13g2_and4_1
X_11285_ _11285_/Y _11285_/A _12336_/B1 VDD VSS sg13g2_nor2b_1
X_14073_ _14073_/Q _14745_/CLK _14073_/D _14073_/RESET_B VDD VSS sg13g2_dfrbpq_1
XFILLER_4_798 VDD VSS sg13g2_decap_8
X_13024_ _13026_/A _13009_/A _13010_/B _13058_/C VDD VSS sg13g2_o21ai_1
X_10236_ _14773_/D _07638_/Y _10232_/B _10235_/Y VDD VSS sg13g2_a21oi_1
XFILLER_10_91 VDD VSS sg13g2_decap_8
X_14703__1861 _14703_/RESET_B VDD VSS sg13g2_tiehi
Xfanout1010 _10935_/A _11070_/A1 VDD VSS sg13g2_buf_1
XFILLER_105_192 VDD VSS sg13g2_decap_8
Xfanout1021 _08452_/D _08110_/B VDD VSS sg13g2_buf_1
XFILLER_39_419 VDD VSS sg13g2_decap_8
X_10167_ _14744_/D _14744_/Q _10167_/A1 _10167_/S VDD VSS sg13g2_mux2_1
Xfanout1032 _13553_/A1 _07627_/Y VDD VSS sg13g2_buf_1
XFILLER_120_140 VDD VSS sg13g2_fill_2
Xfanout1043 _11044_/C _10647_/D VDD VSS sg13g2_buf_1
X_14096__2468 _14096_/RESET_B VDD VSS sg13g2_tiehi
Xfanout1054 _12732_/S1 _12762_/S VDD VSS sg13g2_buf_1
XFILLER_67_739 VDD VSS sg13g2_decap_8
XFILLER_48_931 VDD VSS sg13g2_fill_2
XFILLER_94_536 VDD VSS sg13g2_decap_4
XFILLER_13_7 VDD VSS sg13g2_decap_8
Xfanout1076 wire1077/A _15213_/Q VDD VSS sg13g2_buf_1
X_10098_ _14678_/D _10098_/A0 _14678_/Q _10099_/S VDD VSS sg13g2_mux2_1
XFILLER_59_290 VDD VSS sg13g2_decap_8
X_14975_ _14975_/Q _15040_/CLK _14975_/D _14975_/RESET_B VDD VSS sg13g2_dfrbpq_1
Xfanout1087 _12719_/S0 _12788_/S0 VDD VSS sg13g2_buf_1
Xfanout1098 _12743_/S1 fanout1104/X VDD VSS sg13g2_buf_1
X_13926_ _13926_/Q clkload17/A _13926_/D _13926_/RESET_B VDD VSS sg13g2_dfrbpq_1
XFILLER_74_260 VDD VSS sg13g2_decap_8
XFILLER_63_934 VDD VSS sg13g2_fill_2
XFILLER_142_90 VDD VSS sg13g2_decap_4
X_15035__2937 _15035_/RESET_B VDD VSS sg13g2_tiehi
XFILLER_74_271 VDD VSS sg13g2_fill_2
X_13857_ _13857_/Q clkload26/A _13857_/D _13857_/RESET_B VDD VSS sg13g2_dfrbpq_1
XFILLER_90_764 VDD VSS sg13g2_decap_8
X_14925__3079 _14925_/RESET_B VDD VSS sg13g2_tiehi
XFILLER_62_477 VDD VSS sg13g2_decap_8
X_12808_ _12808_/Y _12808_/A _13312_/A VDD VSS sg13g2_nor2_1
XFILLER_22_319 VDD VSS sg13g2_decap_8
XFILLER_90_797 VDD VSS sg13g2_fill_1
X_13788_ _13788_/Q clkload77/A _13788_/D _13788_/RESET_B VDD VSS sg13g2_dfrbpq_1
XFILLER_62_499 VDD VSS sg13g2_fill_2
XFILLER_96_4 VDD VSS sg13g2_fill_2
X_12739_ _12739_/X _13751_/Q _14103_/Q _14455_/Q _14551_/Q _12743_/S0 _12743_/S1 VDD
+ VSS sg13g2_mux4_1
XFILLER_37_1077 VDD VSS sg13g2_decap_8
XFILLER_148_538 VDD VSS sg13g2_fill_2
XFILLER_148_549 VDD VSS sg13g2_fill_1
X_14409_ _14409_/Q _14505_/CLK _14409_/D _14409_/RESET_B VDD VSS sg13g2_dfrbpq_1
XFILLER_11_1217 VDD VSS sg13g2_decap_8
XFILLER_156_582 VDD VSS sg13g2_decap_4
Xmax_cap212 _10413_/B _10404_/A2 VDD VSS sg13g2_buf_1
X_15188__3184 _15188_/RESET_B VDD VSS sg13g2_tiehi
X_14535__2029 _14535_/RESET_B VDD VSS sg13g2_tiehi
XFILLER_89_308 VDD VSS sg13g2_decap_8
X_09950_ _14534_/D _14534_/Q _10149_/A1 _09951_/S VDD VSS sg13g2_mux2_1
XFILLER_89_319 VDD VSS sg13g2_fill_2
XFILLER_135_1110 VDD VSS sg13g2_fill_2
X_08901_ _08901_/Y _08835_/A _08835_/B hold3522/X VDD VSS sg13g2_a21oi_1
X_14789__3309 _14789_/RESET_B VDD VSS sg13g2_tiehi
X_09881_ _14467_/D _09914_/A1 _14467_/Q _09901_/S VDD VSS sg13g2_mux2_1
XFILLER_106_28 VDD VSS sg13g2_decap_8
XFILLER_97_352 VDD VSS sg13g2_decap_8
X_14825__3273 _14825_/RESET_B VDD VSS sg13g2_tiehi
X_08832_ _08833_/C _13613_/A _15055_/Q _13283_/A _08832_/D VDD VSS sg13g2_nor4_1
XFILLER_98_886 VDD VSS sg13g2_decap_8
XFILLER_131_1007 VDD VSS sg13g2_fill_1
XFILLER_140_994 VDD VSS sg13g2_decap_8
X_13761__2803 _13761_/RESET_B VDD VSS sg13g2_tiehi
XFILLER_100_847 VDD VSS sg13g2_decap_8
X_08763_ _08763_/Y _13343_/B _11288_/A _15189_/Q VDD VSS sg13g2_o21ai_1
XFILLER_39_986 VDD VSS sg13g2_decap_8
X_07714_ _07714_/Y _07740_/A _13312_/A VDD VSS sg13g2_nand2_1
X_08694_ _08694_/Y _08380_/Y _08452_/B _08687_/X _08637_/B _08693_/Y VDD VSS sg13g2_a221oi_1
XFILLER_81_731 VDD VSS sg13g2_decap_8
XFILLER_53_433 VDD VSS sg13g2_decap_8
X_07645_ _10297_/B _14793_/Q VDD VSS sg13g2_inv_1
XFILLER_0_1142 VDD VSS sg13g2_decap_4
X_14141__2423 _14141_/RESET_B VDD VSS sg13g2_tiehi
XFILLER_15_14 VDD VSS sg13g2_decap_8
XFILLER_53_488 VDD VSS sg13g2_fill_2
X_09315_ _13922_/D _10145_/A1 _13922_/Q _09335_/S VDD VSS sg13g2_mux2_1
XFILLER_139_505 VDD VSS sg13g2_decap_8
XFILLER_55_1166 VDD VSS sg13g2_decap_8
XFILLER_90_1057 VDD VSS sg13g2_decap_8
X_14745__1819 _14745_/RESET_B VDD VSS sg13g2_tiehi
XFILLER_16_1139 VDD VSS sg13g2_decap_8
X_09246_ _13855_/D _13855_/Q _10142_/A1 _09272_/S VDD VSS sg13g2_mux2_1
XFILLER_103_1109 VDD VSS sg13g2_decap_4
XFILLER_31_35 VDD VSS sg13g2_decap_8
X_09177_ _13793_/D _13793_/Q _10144_/A1 _09200_/S VDD VSS sg13g2_mux2_1
XFILLER_108_914 VDD VSS sg13g2_decap_8
XFILLER_5_507 VDD VSS sg13g2_fill_1
XFILLER_147_35 VDD VSS sg13g2_decap_8
X_08128_ _08128_/X _08383_/A _07798_/B _07825_/B _07949_/C _08559_/S1 wire1387/X VDD
+ VSS sg13g2_mux4_1
XFILLER_135_744 VDD VSS sg13g2_decap_4
XFILLER_123_917 VDD VSS sg13g2_decap_4
X_08059_ _08059_/X _08427_/A1 _07825_/B _07782_/A _08383_/A _08099_/S0 _08048_/A VDD
+ VSS sg13g2_mux4_1
XFILLER_1_702 VDD VSS sg13g2_decap_8
Xoutput46 mem_axi_araddr[17] _16870_/A VDD VSS sg13g2_buf_1
XFILLER_150_747 VDD VSS sg13g2_fill_2
Xoutput57 mem_axi_araddr[28] output57/A VDD VSS sg13g2_buf_1
X_11070_ _11070_/Y _11070_/A1 _11069_/Y _11067_/Y VDD VSS sg13g2_a21oi_1
Xoutput68 mem_axi_araddr[9] _16862_/A VDD VSS sg13g2_buf_1
XFILLER_0_223 VDD VSS sg13g2_decap_8
Xoutput79 mem_axi_awaddr[18] _16871_/X VDD VSS sg13g2_buf_1
XFILLER_0_234 VDD VSS sg13g2_fill_1
XFILLER_88_352 VDD VSS sg13g2_decap_8
XFILLER_103_652 VDD VSS sg13g2_decap_8
X_10021_ _14603_/D _10021_/A0 _14603_/Q _10035_/S VDD VSS sg13g2_mux2_1
XFILLER_0_278 VDD VSS sg13g2_decap_4
XFILLER_62_1159 VDD VSS sg13g2_decap_8
XFILLER_103_685 VDD VSS sg13g2_fill_1
XFILLER_114_1227 VDD VSS sg13g2_decap_8
XFILLER_130_471 VDD VSS sg13g2_decap_4
XFILLER_5_1031 VDD VSS sg13g2_decap_8
XFILLER_48_249 VDD VSS sg13g2_decap_8
XFILLER_56_21 VDD VSS sg13g2_decap_8
X_14760_ _14760_/Q _15188_/CLK _14760_/D _14760_/RESET_B VDD VSS sg13g2_dfrbpq_1
XFILLER_57_783 VDD VSS sg13g2_decap_8
X_11972_ _11973_/A _14704_/Q _14736_/Q _13776_/Q _13808_/Q _11969_/A _11970_/C VDD
+ VSS sg13g2_mux4_1
XFILLER_57_794 VDD VSS sg13g2_decap_8
XFILLER_99_1082 VDD VSS sg13g2_decap_8
X_13711_ _13711_/Q _14916_/CLK _13711_/D _13711_/RESET_B VDD VSS sg13g2_dfrbpq_1
X_10923_ _10937_/B _10923_/A _10923_/B wire582/A _10923_/D VDD VSS sg13g2_nor4_1
XFILLER_16_135 VDD VSS sg13g2_fill_2
X_14691_ _14691_/Q clkload2/A _14691_/D _14691_/RESET_B VDD VSS sg13g2_dfrbpq_1
XFILLER_72_753 VDD VSS sg13g2_fill_2
XFILLER_45_978 VDD VSS sg13g2_fill_2
XFILLER_112_60 VDD VSS sg13g2_fill_1
XFILLER_32_606 VDD VSS sg13g2_fill_1
XFILLER_44_466 VDD VSS sg13g2_fill_2
X_13642_ _13750_/D _13642_/A VDD VSS sg13g2_buf_1
XFILLER_71_263 VDD VSS sg13g2_fill_2
XFILLER_112_82 VDD VSS sg13g2_decap_8
XFILLER_16_179 VDD VSS sg13g2_decap_8
XFILLER_72_797 VDD VSS sg13g2_decap_8
X_10854_ _10865_/B _10870_/A _14752_/Q VDD VSS sg13g2_nand2_1
XFILLER_34_1206 VDD VSS sg13g2_decap_8
XFILLER_13_853 VDD VSS sg13g2_decap_8
XFILLER_9_802 VDD VSS sg13g2_decap_8
X_13573_ _15156_/D _13570_/S _13571_/Y _13572_/Y VDD VSS sg13g2_a21oi_1
X_10785_ _10785_/Y _08943_/A _09148_/Y _08943_/Y VDD VSS sg13g2_o21ai_1
XFILLER_40_672 VDD VSS sg13g2_fill_2
X_12524_ _12524_/X _12520_/X _12519_/X _12516_/X _12515_/X wire1081/X _12691_/S0 VDD
+ VSS sg13g2_mux4_1
XFILLER_145_508 VDD VSS sg13g2_decap_8
XFILLER_12_396 VDD VSS sg13g2_decap_8
XFILLER_8_345 VDD VSS sg13g2_decap_8
XFILLER_75_9 VDD VSS sg13g2_fill_1
X_15243_ _15243_/Q clkload33/A wire142/X _15243_/RESET_B VDD VSS sg13g2_dfrbpq_1
X_12455_ _12455_/X _12454_/X _12453_/X _12455_/S VDD VSS sg13g2_mux2_1
XFILLER_8_378 VDD VSS sg13g2_decap_4
X_11406_ _11425_/C _12000_/A _11404_/Y _11405_/Y VDD VSS sg13g2_o21ai_1
X_15174_ _15174_/Q _15178_/CLK _15174_/D _15174_/RESET_B VDD VSS sg13g2_dfrbpq_1
X_12386_ _12386_/Y _12415_/A _12386_/B VDD VSS sg13g2_nand2_1
XFILLER_153_541 VDD VSS sg13g2_decap_8
XFILLER_114_906 VDD VSS sg13g2_decap_4
XFILLER_114_917 VDD VSS sg13g2_fill_1
X_14125_ _14125_/Q _14669_/CLK _14125_/D _14125_/RESET_B VDD VSS sg13g2_dfrbpq_1
X_11337_ _11338_/B _12799_/A _15123_/Q _12836_/B _12844_/B VDD VSS sg13g2_a22oi_1
Xclkbuf_leaf_122_clk_i _14678_/CLK clkbuf_5_2__f_clk_i/X VDD VSS sg13g2_buf_8
XFILLER_107_980 VDD VSS sg13g2_decap_4
X_14056_ _14056_/Q clkload27/A _14056_/D _14056_/RESET_B VDD VSS sg13g2_dfrbpq_1
X_11268_ _11268_/Y _11267_/Y _11224_/A _12336_/B1 VDD VSS sg13g2_a21oi_1
XFILLER_79_352 VDD VSS sg13g2_decap_8
X_13007_ _13058_/C _14907_/Q _13680_/Q VDD VSS sg13g2_nand2_1
XFILLER_67_503 VDD VSS sg13g2_fill_1
XFILLER_140_279 VDD VSS sg13g2_decap_8
X_10219_ _10219_/X _14767_/Q _14768_/Q VDD VSS sg13g2_and2_1
X_11199_ _11199_/Y _11181_/A _11199_/B VDD VSS sg13g2_nand2b_1
X_15071__3248 _15071_/RESET_B VDD VSS sg13g2_tiehi
XFILLER_67_558 VDD VSS sg13g2_decap_4
XFILLER_78_1111 VDD VSS sg13g2_fill_2
X_14958_ _14958_/Q clkload72/A _14958_/D _14958_/RESET_B VDD VSS sg13g2_dfrbpq_1
XFILLER_75_591 VDD VSS sg13g2_decap_4
X_15132__3078 _15132_/RESET_B VDD VSS sg13g2_tiehi
XFILLER_63_742 VDD VSS sg13g2_decap_8
X_13909_ _13909_/Q clkload14/A _13909_/D _13909_/RESET_B VDD VSS sg13g2_dfrbpq_1
XFILLER_130_1095 VDD VSS sg13g2_decap_8
X_14889_ _14889_/Q clkload79/A _14889_/D _14889_/RESET_B VDD VSS sg13g2_dfrbpq_1
XFILLER_23_606 VDD VSS sg13g2_decap_8
XFILLER_62_241 VDD VSS sg13g2_fill_2
XFILLER_39_1139 VDD VSS sg13g2_decap_8
XFILLER_22_138 VDD VSS sg13g2_fill_1
XFILLER_149_825 VDD VSS sg13g2_fill_1
X_09100_ _09100_/Y _15240_/Q _09100_/B VDD VSS sg13g2_nand2b_1
XFILLER_87_0 VDD VSS sg13g2_decap_8
X_09031_ _09031_/Y _09044_/A _09031_/B _09031_/C VDD VSS sg13g2_nor3_1
XFILLER_15_1150 VDD VSS sg13g2_decap_8
X_14869__3191 _14869_/RESET_B VDD VSS sg13g2_tiehi
X_15232__3385 _15232_/RESET_B VDD VSS sg13g2_tiehi
XFILLER_11_1014 VDD VSS sg13g2_decap_8
XFILLER_7_70 VDD VSS sg13g2_decap_8
XFILLER_50_1096 VDD VSS sg13g2_fill_2
XFILLER_102_1175 VDD VSS sg13g2_fill_1
XFILLER_132_703 VDD VSS sg13g2_fill_1
XFILLER_105_928 VDD VSS sg13g2_fill_1
XFILLER_131_202 VDD VSS sg13g2_decap_8
XFILLER_117_49 VDD VSS sg13g2_decap_4
X_09933_ _14518_/D _14518_/Q _10132_/A0 _09933_/S VDD VSS sg13g2_mux2_1
XFILLER_89_138 VDD VSS sg13g2_fill_2
X_14159__2405 _14159_/RESET_B VDD VSS sg13g2_tiehi
Xfanout814 _12978_/B1 _13236_/B1 VDD VSS sg13g2_buf_1
Xfanout825 _13272_/A2 _13149_/A2 VDD VSS sg13g2_buf_1
Xfanout836 _10973_/B _10959_/B VDD VSS sg13g2_buf_1
XFILLER_86_812 VDD VSS sg13g2_fill_2
X_09864_ _14451_/D _14451_/Q _09963_/A1 _09865_/S VDD VSS sg13g2_mux2_1
Xfanout858 _10725_/A _08862_/S VDD VSS sg13g2_buf_1
X_14971__3001 _14971_/RESET_B VDD VSS sg13g2_tiehi
XFILLER_58_536 VDD VSS sg13g2_decap_8
Xfanout869 _08925_/S _08955_/S VDD VSS sg13g2_buf_1
XFILLER_86_856 VDD VSS sg13g2_fill_2
X_08815_ _13689_/D _08813_/Y _08812_/Y _08814_/Y VDD VSS sg13g2_a21oi_1
X_09795_ _14384_/D _09927_/A1 _14384_/Q _09805_/S VDD VSS sg13g2_mux2_1
XFILLER_22_1121 VDD VSS sg13g2_decap_8
XFILLER_27_923 VDD VSS sg13g2_decap_4
X_08746_ _08746_/Y _13667_/Q _08752_/B VDD VSS sg13g2_nor2_1
XFILLER_26_400 VDD VSS sg13g2_fill_2
XFILLER_27_967 VDD VSS sg13g2_decap_8
XFILLER_26_35 VDD VSS sg13g2_decap_8
XFILLER_22_1198 VDD VSS sg13g2_decap_8
X_08677_ _08697_/A _08662_/B _07847_/Y _07974_/C VDD VSS sg13g2_a21oi_1
XFILLER_14_606 VDD VSS sg13g2_fill_2
XFILLER_92_1119 VDD VSS sg13g2_decap_8
XFILLER_26_488 VDD VSS sg13g2_decap_8
XFILLER_13_105 VDD VSS sg13g2_decap_8
XFILLER_41_414 VDD VSS sg13g2_decap_8
X_07628_ _13609_/A _08023_/B VDD VSS sg13g2_inv_1
XFILLER_139_302 VDD VSS sg13g2_decap_8
XFILLER_50_981 VDD VSS sg13g2_decap_4
X_10570_ _10572_/C _10579_/B _10579_/C _12895_/A VDD VSS sg13g2_a21oi_1
XFILLER_42_67 VDD VSS sg13g2_decap_8
X_09229_ _13840_/D _10159_/A1 _13840_/Q _09239_/S VDD VSS sg13g2_mux2_1
XFILLER_148_891 VDD VSS sg13g2_decap_8
XFILLER_120_1231 VDD VSS sg13g2_decap_4
X_12240_ _12240_/Y _12255_/A1 _14584_/Q VDD VSS sg13g2_nand2b_1
XFILLER_108_755 VDD VSS sg13g2_decap_8
XFILLER_107_243 VDD VSS sg13g2_decap_8
X_12171_ _12172_/A _13750_/Q _14102_/Q _14454_/Q _14550_/Q _12168_/A _12171_/S1 VDD
+ VSS sg13g2_mux4_1
XFILLER_107_276 VDD VSS sg13g2_decap_8
X_11122_ _11123_/B _11119_/B _11063_/Y _11091_/B VDD VSS sg13g2_o21ai_1
XFILLER_3_28 VDD VSS sg13g2_decap_8
XFILLER_77_801 VDD VSS sg13g2_fill_1
XFILLER_110_408 VDD VSS sg13g2_decap_8
X_11053_ _11053_/Y wire577/X _11068_/A _11070_/A1 VDD VSS sg13g2_o21ai_1
Xclkbuf_leaf_54_clk_i clkload64/A clkbuf_leaf_84_clk_i/A VDD VSS sg13g2_buf_8
XFILLER_27_1054 VDD VSS sg13g2_decap_8
XFILLER_76_300 VDD VSS sg13g2_fill_1
XFILLER_49_536 VDD VSS sg13g2_fill_2
XFILLER_118_1193 VDD VSS sg13g2_decap_8
X_10004_ _10004_/Y _10070_/A _10004_/B _10004_/C _10070_/C VDD VSS sg13g2_nand4_1
XFILLER_7_1159 VDD VSS sg13g2_decap_8
XFILLER_77_867 VDD VSS sg13g2_fill_1
XFILLER_40_1210 VDD VSS sg13g2_decap_8
XFILLER_114_1068 VDD VSS sg13g2_decap_8
X_14812_ _14812_/Q _14854_/CLK _14812_/D _14812_/RESET_B VDD VSS sg13g2_dfrbpq_1
XFILLER_64_539 VDD VSS sg13g2_decap_8
Xclkbuf_leaf_69_clk_i clkload82/A clkbuf_leaf_71_clk_i/A VDD VSS sg13g2_buf_8
XFILLER_45_731 VDD VSS sg13g2_fill_1
XFILLER_92_859 VDD VSS sg13g2_fill_1
XFILLER_18_967 VDD VSS sg13g2_decap_8
X_14743_ _14743_/Q clkload3/A _14743_/D _14743_/RESET_B VDD VSS sg13g2_dfrbpq_1
XFILLER_123_92 VDD VSS sg13g2_decap_8
XFILLER_17_444 VDD VSS sg13g2_decap_8
X_11955_ _11955_/Y _11955_/A _11955_/B VDD VSS sg13g2_nand2_1
XFILLER_33_904 VDD VSS sg13g2_fill_2
XFILLER_17_455 VDD VSS sg13g2_fill_2
X_13857__2707 _13857_/RESET_B VDD VSS sg13g2_tiehi
XFILLER_45_764 VDD VSS sg13g2_fill_2
X_10906_ _10948_/B _14756_/Q _10923_/B VDD VSS sg13g2_xor2_1
XFILLER_17_488 VDD VSS sg13g2_decap_8
XFILLER_44_274 VDD VSS sg13g2_decap_4
X_14674_ _14674_/Q _14706_/CLK _14674_/D _14674_/RESET_B VDD VSS sg13g2_dfrbpq_1
X_15102__3148 _15102_/RESET_B VDD VSS sg13g2_tiehi
X_11886_ _11886_/Y _11890_/S0 _14414_/Q _12307_/C VDD VSS sg13g2_a21oi_1
X_13625_ _13733_/D _13625_/A VDD VSS sg13g2_buf_1
XFILLER_32_458 VDD VSS sg13g2_decap_8
X_10837_ _10849_/A _10837_/A _10929_/B VDD VSS sg13g2_nand2_1
XFILLER_12_160 VDD VSS sg13g2_decap_8
X_13556_ wire730/A _08511_/S _13600_/B _13555_/Y VDD VSS sg13g2_a21oi_1
XFILLER_80_7 VDD VSS sg13g2_decap_8
X_14237__2327 _14237_/RESET_B VDD VSS sg13g2_tiehi
X_10768_ _10768_/Y _14950_/Q _10769_/A2 _10767_/Y VDD VSS sg13g2_a21oi_1
X_12507_ _12507_/X _14118_/Q _14150_/Q _14182_/Q _14214_/Q _12508_/S0 _12508_/S1 VDD
+ VSS sg13g2_mux4_1
XFILLER_145_305 VDD VSS sg13g2_decap_8
XFILLER_146_839 VDD VSS sg13g2_decap_8
X_13487_ _13487_/Y _13654_/S _15173_/D _15175_/D _13502_/D VDD VSS sg13g2_nor4_1
X_10699_ _10699_/Y _14902_/Q _10903_/B VDD VSS sg13g2_nand2_1
XFILLER_8_175 VDD VSS sg13g2_fill_1
X_15226_ _15226_/Q clkload40/A _15226_/D _15226_/RESET_B VDD VSS sg13g2_dfrbpq_1
X_12438_ _12438_/X _14241_/Q _14273_/Q _14305_/Q _14337_/Q _12536_/S0 _12536_/S1 VDD
+ VSS sg13g2_mux4_1
Xmax_cap1676 _12073_/S0 _11925_/S0 VDD VSS sg13g2_buf_4
XFILLER_154_861 VDD VSS sg13g2_decap_8
X_15157_ _15157_/Q clkload29/A _15157_/D _15157_/RESET_B VDD VSS sg13g2_dfrbpq_1
X_12369_ _12369_/X _12368_/X _12367_/X _12361_/X _12362_/X _12369_/S0 _12355_/S VDD
+ VSS sg13g2_mux4_1
XFILLER_114_736 VDD VSS sg13g2_fill_1
X_14452__2112 _14452_/RESET_B VDD VSS sg13g2_tiehi
X_14108_ _14108_/Q clkload75/A _14108_/D _14108_/RESET_B VDD VSS sg13g2_dfrbpq_1
XFILLER_141_533 VDD VSS sg13g2_fill_2
XFILLER_10_1080 VDD VSS sg13g2_decap_8
X_15088_ _15088_/Q clkload66/A _15088_/D _15088_/RESET_B VDD VSS sg13g2_dfrbpq_1
XFILLER_99_469 VDD VSS sg13g2_decap_8
X_14039_ _14039_/Q _14505_/CLK _14039_/D _14039_/RESET_B VDD VSS sg13g2_dfrbpq_1
XFILLER_68_823 VDD VSS sg13g2_decap_8
XFILLER_68_856 VDD VSS sg13g2_decap_4
XFILLER_110_953 VDD VSS sg13g2_fill_1
XFILLER_45_1198 VDD VSS sg13g2_decap_8
XFILLER_94_141 VDD VSS sg13g2_decap_8
X_08600_ _08600_/Y _13533_/A _08659_/B _08600_/C _08600_/D VDD VSS sg13g2_nor4_1
XFILLER_110_986 VDD VSS sg13g2_fill_1
X_09580_ _14177_/D _14177_/Q _09613_/A0 _09587_/S VDD VSS sg13g2_mux2_1
X_14485__2079 _14485_/RESET_B VDD VSS sg13g2_tiehi
XFILLER_36_720 VDD VSS sg13g2_fill_1
X_13670__2917 _13670_/RESET_B VDD VSS sg13g2_tiehi
X_08531_ _08531_/Y _08548_/A _08531_/B VDD VSS sg13g2_nor2_1
XFILLER_24_904 VDD VSS sg13g2_decap_8
XFILLER_63_550 VDD VSS sg13g2_decap_8
XFILLER_36_797 VDD VSS sg13g2_decap_8
XFILLER_51_723 VDD VSS sg13g2_decap_8
X_08462_ _15236_/D _08462_/A _08462_/B _08462_/C VDD VSS sg13g2_nand3_1
XFILLER_91_892 VDD VSS sg13g2_fill_2
XFILLER_24_959 VDD VSS sg13g2_decap_8
XFILLER_50_222 VDD VSS sg13g2_decap_8
XFILLER_50_233 VDD VSS sg13g2_fill_2
XFILLER_23_458 VDD VSS sg13g2_decap_8
X_08393_ _08393_/Y _08394_/B _08394_/C _08414_/C VDD VSS sg13g2_o21ai_1
XFILLER_91_1130 VDD VSS sg13g2_decap_8
XFILLER_143_1220 VDD VSS sg13g2_decap_8
XFILLER_51_789 VDD VSS sg13g2_fill_1
XFILLER_91_1174 VDD VSS sg13g2_decap_8
XFILLER_50_288 VDD VSS sg13g2_fill_1
XFILLER_104_1226 VDD VSS sg13g2_decap_8
X_14662__1902 _14662_/RESET_B VDD VSS sg13g2_tiehi
X_09014_ _13763_/D _13763_/Q _10146_/A1 _09146_/S VDD VSS sg13g2_mux2_1
X_14091__2473 _14091_/RESET_B VDD VSS sg13g2_tiehi
XFILLER_117_563 VDD VSS sg13g2_decap_8
XFILLER_144_14 VDD VSS sg13g2_decap_8
X_13935__2629 _13935_/RESET_B VDD VSS sg13g2_tiehi
Xfanout600 wire601/A wire603/A VDD VSS sg13g2_buf_1
X_14695__1869 _14695_/RESET_B VDD VSS sg13g2_tiehi
XFILLER_120_706 VDD VSS sg13g2_decap_8
XFILLER_99_970 VDD VSS sg13g2_decap_4
X_09916_ _14501_/D _14501_/Q _09916_/A1 _09934_/S VDD VSS sg13g2_mux2_1
X_15030__2942 _15030_/RESET_B VDD VSS sg13g2_tiehi
Xfanout622 _09826_/S wire624/A VDD VSS sg13g2_buf_1
Xfanout644 _09553_/S _09566_/S VDD VSS sg13g2_buf_1
XFILLER_150_1213 VDD VSS sg13g2_decap_8
Xfanout666 _09457_/S _09473_/S VDD VSS sg13g2_buf_1
X_09847_ _14434_/D _14434_/Q _10078_/A0 _09868_/S VDD VSS sg13g2_mux2_1
Xfanout677 _09380_/S _09398_/S VDD VSS sg13g2_buf_1
Xfanout688 wire689/A _09374_/S VDD VSS sg13g2_buf_1
Xfanout699 wire700/A _09206_/X VDD VSS sg13g2_buf_1
XFILLER_46_517 VDD VSS sg13g2_fill_1
XFILLER_37_45 VDD VSS sg13g2_fill_1
X_09778_ _14367_/D _09877_/A0 _14367_/Q _09778_/S VDD VSS sg13g2_mux2_1
XFILLER_58_399 VDD VSS sg13g2_fill_1
X_15045__2920 _15045_/RESET_B VDD VSS sg13g2_tiehi
X_14315__2249 _14315_/RESET_B VDD VSS sg13g2_tiehi
XFILLER_2_1045 VDD VSS sg13g2_decap_8
X_08729_ _08729_/Y _10924_/B1 _10206_/A1 _08727_/X _13448_/B _08809_/C1 VDD VSS sg13g2_a221oi_1
XFILLER_61_509 VDD VSS sg13g2_fill_2
XFILLER_82_870 VDD VSS sg13g2_fill_2
XFILLER_27_786 VDD VSS sg13g2_decap_8
XFILLER_26_263 VDD VSS sg13g2_decap_8
XFILLER_42_712 VDD VSS sg13g2_decap_8
X_11740_ _11742_/A _11741_/A _14634_/Q VDD VSS sg13g2_nand2b_1
XFILLER_96_1074 VDD VSS sg13g2_fill_2
XFILLER_26_274 VDD VSS sg13g2_fill_1
XFILLER_26_285 VDD VSS sg13g2_decap_4
XFILLER_14_425 VDD VSS sg13g2_fill_2
XFILLER_41_211 VDD VSS sg13g2_decap_8
XFILLER_18_1009 VDD VSS sg13g2_decap_8
X_11671_ _11671_/X _11671_/A _11696_/B VDD VSS sg13g2_and2_1
XFILLER_42_778 VDD VSS sg13g2_decap_8
X_14530__2034 _14530_/RESET_B VDD VSS sg13g2_tiehi
XFILLER_41_277 VDD VSS sg13g2_decap_4
X_13410_ wire809/A _15194_/Q _15195_/Q _15196_/Q _15197_/Q VDD VSS sg13g2_nor4_1
X_10622_ _10636_/A _14882_/Q _10651_/D _10622_/C VDD VSS sg13g2_nand3_1
X_14390_ _14390_/Q clkload24/A _14390_/D _14390_/RESET_B VDD VSS sg13g2_dfrbpq_1
XFILLER_70_1236 VDD VSS sg13g2_fill_1
XFILLER_139_132 VDD VSS sg13g2_fill_2
XFILLER_41_299 VDD VSS sg13g2_decap_8
XFILLER_22_491 VDD VSS sg13g2_decap_8
XFILLER_155_603 VDD VSS sg13g2_fill_1
XFILLER_31_1209 VDD VSS sg13g2_decap_8
X_13341_ _13341_/Y _13341_/A _15174_/D VDD VSS sg13g2_nor2b_1
X_10553_ _10555_/B _14866_/Q _14865_/Q _10556_/D VDD VSS sg13g2_nand3_1
X_14784__3314 _14784_/RESET_B VDD VSS sg13g2_tiehi
XFILLER_127_338 VDD VSS sg13g2_fill_1
XFILLER_5_112 VDD VSS sg13g2_decap_8
X_13272_ _13272_/X input28/X _13272_/A2 _13049_/X VDD VSS sg13g2_a21o_1
X_10484_ _10495_/D _14849_/Q _13084_/A _14847_/Q _10484_/D VDD VSS sg13g2_and4_1
XFILLER_108_541 VDD VSS sg13g2_decap_4
XFILLER_154_168 VDD VSS sg13g2_decap_8
X_15011_ _15011_/Q _15200_/CLK _15011_/D _15011_/RESET_B VDD VSS sg13g2_dfrbpq_1
X_12223_ _12223_/X _12223_/A _12223_/B _12223_/C VDD VSS sg13g2_or3_1
XFILLER_108_574 VDD VSS sg13g2_fill_1
XFILLER_68_1154 VDD VSS sg13g2_decap_8
XFILLER_118_70 VDD VSS sg13g2_decap_8
XFILLER_155_1124 VDD VSS sg13g2_decap_8
XFILLER_155_1135 VDD VSS sg13g2_decap_8
XFILLER_150_330 VDD VSS sg13g2_decap_8
X_12154_ _12156_/B _12155_/A _12155_/B _12198_/D VDD VSS sg13g2_a21o_1
XFILLER_151_875 VDD VSS sg13g2_decap_8
XFILLER_116_1108 VDD VSS sg13g2_fill_2
XFILLER_123_566 VDD VSS sg13g2_fill_2
X_11105_ _11105_/Y _11086_/A _10759_/X _11118_/D VDD VSS sg13g2_a21oi_1
XFILLER_111_728 VDD VSS sg13g2_decap_8
X_12085_ _12086_/B _12061_/A _13189_/B _12063_/Y VDD VSS sg13g2_a21oi_1
XFILLER_89_491 VDD VSS sg13g2_fill_2
X_11036_ _11036_/Y _11023_/A _11052_/A _11034_/Y _11022_/B VDD VSS sg13g2_a22oi_1
XFILLER_49_344 VDD VSS sg13g2_fill_2
XFILLER_49_355 VDD VSS sg13g2_decap_8
XFILLER_76_141 VDD VSS sg13g2_fill_2
XFILLER_77_675 VDD VSS sg13g2_decap_8
XFILLER_92_601 VDD VSS sg13g2_fill_2
XFILLER_64_303 VDD VSS sg13g2_decap_4
XFILLER_92_612 VDD VSS sg13g2_decap_8
XFILLER_91_100 VDD VSS sg13g2_decap_8
X_15231__3384 _15231_/RESET_B VDD VSS sg13g2_tiehi
X_14740__1824 _14740_/RESET_B VDD VSS sg13g2_tiehi
XFILLER_92_656 VDD VSS sg13g2_fill_2
XFILLER_64_358 VDD VSS sg13g2_decap_8
XFILLER_40_1084 VDD VSS sg13g2_fill_2
X_12987_ _12987_/Y _12988_/C _12988_/D VDD VSS sg13g2_nor2_1
XFILLER_33_712 VDD VSS sg13g2_decap_4
X_14726_ _14726_/Q _14726_/CLK _14726_/D _14726_/RESET_B VDD VSS sg13g2_dfrbpq_1
XFILLER_73_881 VDD VSS sg13g2_decap_8
XFILLER_33_723 VDD VSS sg13g2_fill_1
XFILLER_73_892 VDD VSS sg13g2_fill_1
X_11938_ _11938_/Y _11937_/Y _12055_/B _12301_/B1 VDD VSS sg13g2_a21oi_1
XFILLER_17_296 VDD VSS sg13g2_decap_8
XFILLER_32_244 VDD VSS sg13g2_decap_8
X_14657_ _14657_/Q clkload28/A _14657_/D _14657_/RESET_B VDD VSS sg13g2_dfrbpq_1
X_11869_ _11869_/Y _11896_/A _13838_/Q VDD VSS sg13g2_nand2b_1
XFILLER_60_564 VDD VSS sg13g2_decap_4
XFILLER_33_789 VDD VSS sg13g2_decap_8
X_13608_ _13608_/Y _13600_/A _10173_/B _15167_/Q VDD VSS sg13g2_a21oi_1
X_14588_ _14588_/Q clkload76/A _14588_/D _14588_/RESET_B VDD VSS sg13g2_dfrbpq_1
X_13539_ _13539_/Y _13539_/A _13539_/B VDD VSS sg13g2_nor2_1
XFILLER_118_338 VDD VSS sg13g2_decap_8
X_15209_ _15209_/Q _15209_/CLK _15209_/D _15209_/RESET_B VDD VSS sg13g2_dfrbpq_1
XFILLER_12_1186 VDD VSS sg13g2_decap_8
XFILLER_154_691 VDD VSS sg13g2_decap_8
XFILLER_88_918 VDD VSS sg13g2_decap_8
XFILLER_142_886 VDD VSS sg13g2_decap_8
X_07962_ _07962_/Y _15014_/Q _07859_/B VDD VSS sg13g2_nor2b_1
XFILLER_68_631 VDD VSS sg13g2_decap_8
X_09701_ _14293_/D _09899_/A0 _14293_/Q _09705_/S VDD VSS sg13g2_mux2_1
XFILLER_68_642 VDD VSS sg13g2_fill_2
XFILLER_101_249 VDD VSS sg13g2_decap_8
XFILLER_114_28 VDD VSS sg13g2_decap_8
X_07893_ _07893_/Y _08110_/C _07893_/B VDD VSS sg13g2_nand2_1
XFILLER_96_973 VDD VSS sg13g2_fill_1
XFILLER_28_506 VDD VSS sg13g2_fill_2
XFILLER_110_772 VDD VSS sg13g2_decap_8
X_09632_ _14228_/D _10163_/A1 _14228_/Q _09632_/S VDD VSS sg13g2_mux2_1
XFILLER_82_122 VDD VSS sg13g2_decap_8
X_09563_ _14161_/D _10093_/A0 _14161_/Q wire651/X VDD VSS sg13g2_mux2_1
XFILLER_93_1203 VDD VSS sg13g2_decap_8
X_08514_ _08514_/Y _08514_/A _08514_/B VDD VSS sg13g2_nor2_1
XFILLER_70_317 VDD VSS sg13g2_fill_1
XFILLER_82_177 VDD VSS sg13g2_decap_8
XFILLER_93_1225 VDD VSS sg13g2_decap_8
X_09494_ _14094_/D _09991_/A0 _14094_/Q wire480/A VDD VSS sg13g2_mux2_1
XFILLER_93_1236 VDD VSS sg13g2_fill_1
XFILLER_130_49 VDD VSS sg13g2_decap_4
X_08445_ _08445_/Y _07798_/X _07826_/X _07799_/X VDD VSS sg13g2_a21oi_1
XFILLER_23_255 VDD VSS sg13g2_decap_8
XFILLER_24_789 VDD VSS sg13g2_fill_2
XFILLER_23_14 VDD VSS sg13g2_decap_8
X_08376_ _08376_/X _07794_/A _08427_/A1 _07782_/A _08376_/A3 _08686_/S0 _08686_/S1
+ VDD VSS sg13g2_mux4_1
XFILLER_139_14 VDD VSS sg13g2_decap_8
XFILLER_17_1064 VDD VSS sg13g2_decap_8
XFILLER_143_1083 VDD VSS sg13g2_fill_1
XFILLER_128_7 VDD VSS sg13g2_decap_8
XFILLER_149_496 VDD VSS sg13g2_decap_8
XFILLER_20_995 VDD VSS sg13g2_decap_8
XFILLER_104_1078 VDD VSS sg13g2_fill_2
XFILLER_136_146 VDD VSS sg13g2_decap_8
XFILLER_3_605 VDD VSS sg13g2_fill_1
XFILLER_151_105 VDD VSS sg13g2_decap_8
XFILLER_3_627 VDD VSS sg13g2_decap_8
XFILLER_155_35 VDD VSS sg13g2_decap_8
XFILLER_2_126 VDD VSS sg13g2_decap_8
XFILLER_144_190 VDD VSS sg13g2_fill_1
Xfanout1406 _08686_/A1 _12278_/A VDD VSS sg13g2_buf_1
Xfanout1417 _07853_/B _08635_/A2 VDD VSS sg13g2_buf_1
Xfanout430 _09855_/S _09869_/S VDD VSS sg13g2_buf_1
Xfanout1428 _12009_/A _14980_/Q VDD VSS sg13g2_buf_1
XFILLER_28_1171 VDD VSS sg13g2_decap_8
Xfanout441 _09769_/S wire447/X VDD VSS sg13g2_buf_1
Xfanout1439 _07801_/B _11865_/A VDD VSS sg13g2_buf_1
XFILLER_154_1190 VDD VSS sg13g2_decap_8
Xfanout463 _09632_/S _09631_/S VDD VSS sg13g2_buf_1
XFILLER_115_1141 VDD VSS sg13g2_decap_8
XFILLER_59_664 VDD VSS sg13g2_fill_2
X_14548__2016 _14548_/RESET_B VDD VSS sg13g2_tiehi
XFILLER_63_1084 VDD VSS sg13g2_decap_8
XFILLER_86_450 VDD VSS sg13g2_fill_1
XFILLER_4_1118 VDD VSS sg13g2_decap_8
Xfanout485 _09333_/S fanout486/X VDD VSS sg13g2_buf_1
XFILLER_24_1057 VDD VSS sg13g2_decap_8
X_12910_ _12910_/Y _12910_/A _12909_/Y VDD VSS sg13g2_nor2b_1
XFILLER_87_995 VDD VSS sg13g2_fill_1
X_13890_ _13890_/Q clkload22/A _13890_/D _13890_/RESET_B VDD VSS sg13g2_dfrbpq_1
Xwire1567 _16858_/A _13696_/Q VDD VSS sg13g2_buf_8
XFILLER_111_1038 VDD VSS sg13g2_fill_2
X_12841_ _12845_/A input29/X _12841_/B VDD VSS sg13g2_nand2_1
XFILLER_27_550 VDD VSS sg13g2_decap_8
XFILLER_73_177 VDD VSS sg13g2_decap_8
XFILLER_27_583 VDD VSS sg13g2_decap_8
XFILLER_64_76 VDD VSS sg13g2_fill_1
X_12772_ _12772_/X _14393_/Q _14425_/Q _14489_/Q _14521_/Q _12772_/S0 _12772_/S1 VDD
+ VSS sg13g2_mux4_1
XFILLER_42_520 VDD VSS sg13g2_decap_8
XFILLER_154_0 VDD VSS sg13g2_decap_8
X_14511_ _14511_/Q clkload12/A _14511_/D _14511_/RESET_B VDD VSS sg13g2_dfrbpq_1
X_11723_ _14971_/D _11706_/A _12126_/A _11722_/Y VDD VSS sg13g2_a21o_1
XFILLER_9_49 VDD VSS sg13g2_decap_8
X_14442_ _14442_/Q clkload21/A _14442_/D _14442_/RESET_B VDD VSS sg13g2_dfrbpq_1
X_11654_ _11654_/X _11652_/X _11653_/X _12192_/A VDD VSS sg13g2_mux2_1
XFILLER_80_42 VDD VSS sg13g2_decap_8
XFILLER_70_1022 VDD VSS sg13g2_decap_8
XFILLER_156_901 VDD VSS sg13g2_fill_2
XFILLER_35_1164 VDD VSS sg13g2_decap_4
X_10605_ _10652_/A _14878_/Q _14877_/Q _14876_/Q _14875_/Q VDD VSS sg13g2_nand4_1
XFILLER_7_900 VDD VSS sg13g2_decap_4
XFILLER_70_1055 VDD VSS sg13g2_decap_8
X_14373_ _14373_/Q _14405_/CLK _14373_/D _14373_/RESET_B VDD VSS sg13g2_dfrbpq_1
XFILLER_155_411 VDD VSS sg13g2_decap_8
X_11585_ wire303/A _12217_/A _11583_/X _11584_/Y VDD VSS sg13g2_o21ai_1
X_14154__2410 _14154_/RESET_B VDD VSS sg13g2_tiehi
X_13324_ _15065_/D _13328_/A _13324_/B VDD VSS sg13g2_nor2_1
X_10536_ _10543_/D _14861_/Q _14860_/Q _14859_/Q _10558_/B VDD VSS sg13g2_and4_1
XFILLER_13_91 VDD VSS sg13g2_decap_8
XFILLER_7_977 VDD VSS sg13g2_decap_8
XFILLER_155_488 VDD VSS sg13g2_decap_8
XFILLER_142_105 VDD VSS sg13g2_decap_8
X_13255_ _13255_/Y _14923_/Q _13664_/Q _13245_/X VDD VSS sg13g2_a21oi_1
X_10467_ _10468_/C _10511_/C _14843_/Q _10471_/D VDD VSS sg13g2_and3_1
XFILLER_89_51 VDD VSS sg13g2_decap_8
X_12206_ _12206_/X _14391_/Q _14423_/Q _14487_/Q _14519_/Q _12206_/S0 _12091_/C VDD
+ VSS sg13g2_mux4_1
XFILLER_108_393 VDD VSS sg13g2_fill_1
XFILLER_43_7 VDD VSS sg13g2_decap_8
X_13186_ _13186_/X _13168_/A _13189_/B _13225_/B VDD VSS sg13g2_a21o_1
XFILLER_124_864 VDD VSS sg13g2_fill_1
X_10398_ _10400_/D _14820_/Q _14821_/Q _14822_/Q _10398_/D VDD VSS sg13g2_nand4_1
XFILLER_124_875 VDD VSS sg13g2_decap_8
X_12137_ _12137_/X _14261_/Q _14293_/Q _14325_/Q _14357_/Q _12287_/S0 _12287_/S1 VDD
+ VSS sg13g2_mux4_1
X_14187__2377 _14187_/RESET_B VDD VSS sg13g2_tiehi
XFILLER_1_181 VDD VSS sg13g2_decap_8
XFILLER_96_247 VDD VSS sg13g2_fill_2
X_12068_ _12068_/X _14387_/Q _14419_/Q _14483_/Q _14515_/Q _12072_/S0 _12072_/S1 VDD
+ VSS sg13g2_mux4_1
XFILLER_77_461 VDD VSS sg13g2_fill_1
X_11019_ _11019_/Y _11044_/C _11002_/A _11082_/B1 VDD VSS sg13g2_o21ai_1
X_16876_ _16876_/X _16876_/A VDD VSS sg13g2_buf_1
XFILLER_65_645 VDD VSS sg13g2_fill_1
XFILLER_80_604 VDD VSS sg13g2_decap_4
XFILLER_65_689 VDD VSS sg13g2_fill_1
XFILLER_92_486 VDD VSS sg13g2_decap_8
XFILLER_64_199 VDD VSS sg13g2_decap_8
X_14850__3229 _14850_/RESET_B VDD VSS sg13g2_tiehi
XFILLER_33_542 VDD VSS sg13g2_fill_1
X_14709_ _14709_/Q clkload15/A _14709_/D _14709_/RESET_B VDD VSS sg13g2_dfrbpq_1
XFILLER_127_1023 VDD VSS sg13g2_decap_8
XFILLER_21_715 VDD VSS sg13g2_fill_2
X_08230_ _08230_/Y _08229_/B _08227_/Y _08229_/Y VDD VSS sg13g2_o21ai_1
XFILLER_147_901 VDD VSS sg13g2_decap_8
X_14994__2978 _14994_/RESET_B VDD VSS sg13g2_tiehi
XFILLER_14_1204 VDD VSS sg13g2_decap_8
X_08161_ _08182_/C _08142_/C _08142_/B _07879_/A _08200_/B _08113_/Y VDD VSS sg13g2_a221oi_1
XFILLER_119_614 VDD VSS sg13g2_fill_1
XFILLER_147_934 VDD VSS sg13g2_fill_2
X_08092_ _08092_/Y _07879_/Y _08091_/Y _08588_/B VDD VSS sg13g2_o21ai_1
XFILLER_9_292 VDD VSS sg13g2_decap_4
Xclkload40 clkload40/Y clkload40/A VDD VSS sg13g2_inv_1
XFILLER_134_628 VDD VSS sg13g2_decap_4
XFILLER_133_105 VDD VSS sg13g2_decap_8
Xclkload51 clkload51/Y clkload51/A VDD VSS sg13g2_inv_1
XFILLER_133_116 VDD VSS sg13g2_fill_1
Xclkload62 clkload62/X clkload62/A VDD VSS sg13g2_buf_8
Xclkload73 clkload73/Y clkload73/A VDD VSS sg13g2_inv_2
XFILLER_86_1040 VDD VSS sg13g2_decap_8
XFILLER_115_831 VDD VSS sg13g2_decap_8
XFILLER_47_1002 VDD VSS sg13g2_fill_1
X_14934__3061 _14934_/RESET_B VDD VSS sg13g2_tiehi
XFILLER_114_330 VDD VSS sg13g2_decap_4
Xhold3503 _11170_/A _14954_/Q VDD VSS sg13g2_dlygate4sd3_1
Xhold3514 _10875_/A _14933_/Q VDD VSS sg13g2_dlygate4sd3_1
Xhold3525 hold3525/X _14894_/Q VDD VSS sg13g2_dlygate4sd3_1
XFILLER_114_363 VDD VSS sg13g2_decap_8
XFILLER_114_374 VDD VSS sg13g2_fill_2
XFILLER_138_1196 VDD VSS sg13g2_fill_2
X_08994_ _09011_/D _14899_/Q _12859_/A _10681_/A _10674_/A VDD VSS sg13g2_nand4_1
X_14017__2547 _14017_/RESET_B VDD VSS sg13g2_tiehi
XFILLER_69_940 VDD VSS sg13g2_fill_2
X_13852__2712 _13852_/RESET_B VDD VSS sg13g2_tiehi
X_07945_ _07945_/Y _15006_/Q _11798_/A VDD VSS sg13g2_nand2b_1
XFILLER_102_569 VDD VSS sg13g2_decap_8
XFILLER_75_409 VDD VSS sg13g2_fill_2
XFILLER_84_910 VDD VSS sg13g2_fill_2
XFILLER_21_1208 VDD VSS sg13g2_decap_8
XFILLER_18_14 VDD VSS sg13g2_decap_8
XFILLER_96_781 VDD VSS sg13g2_decap_8
XFILLER_55_100 VDD VSS sg13g2_decap_8
XFILLER_29_848 VDD VSS sg13g2_fill_2
XFILLER_56_634 VDD VSS sg13g2_decap_8
X_07876_ _07876_/Y _07876_/A _07876_/B VDD VSS sg13g2_nand2_1
XFILLER_28_336 VDD VSS sg13g2_fill_1
XFILLER_28_347 VDD VSS sg13g2_fill_2
XFILLER_55_122 VDD VSS sg13g2_fill_2
X_09615_ _14211_/D _09650_/A0 _14211_/Q _09632_/S VDD VSS sg13g2_mux2_1
XFILLER_84_976 VDD VSS sg13g2_decap_8
X_14232__2332 _14232_/RESET_B VDD VSS sg13g2_tiehi
XFILLER_83_486 VDD VSS sg13g2_decap_8
X_15112__3120 _15112_/RESET_B VDD VSS sg13g2_tiehi
X_09546_ _14144_/D _09977_/A0 _14144_/Q _09569_/S VDD VSS sg13g2_mux2_1
XFILLER_70_114 VDD VSS sg13g2_decap_4
XFILLER_83_497 VDD VSS sg13g2_fill_2
XFILLER_110_1071 VDD VSS sg13g2_decap_8
X_13885__2679 _13885_/RESET_B VDD VSS sg13g2_tiehi
XFILLER_3_1195 VDD VSS sg13g2_decap_8
XFILLER_55_199 VDD VSS sg13g2_fill_1
XFILLER_93_1011 VDD VSS sg13g2_decap_8
XFILLER_36_391 VDD VSS sg13g2_fill_2
XFILLER_93_1044 VDD VSS sg13g2_fill_1
X_09477_ _14077_/D _10107_/A0 _14077_/Q _09479_/S VDD VSS sg13g2_mux2_1
XFILLER_58_1175 VDD VSS sg13g2_decap_4
XFILLER_93_1077 VDD VSS sg13g2_fill_1
XFILLER_145_1156 VDD VSS sg13g2_decap_8
XFILLER_145_1167 VDD VSS sg13g2_fill_1
X_08428_ _08428_/X _08337_/X _08427_/X _08538_/S VDD VSS sg13g2_mux2_1
XFILLER_141_1009 VDD VSS sg13g2_decap_8
XFILLER_11_225 VDD VSS sg13g2_fill_1
XFILLER_12_759 VDD VSS sg13g2_decap_4
XFILLER_11_247 VDD VSS sg13g2_fill_2
Xclkload1 clkload1/X clkload1/A VDD VSS sg13g2_buf_8
X_08359_ _08373_/C _08415_/A _08565_/A2 _08668_/B _08359_/B2 _08358_/Y VDD VSS sg13g2_a221oi_1
XFILLER_138_945 VDD VSS sg13g2_decap_8
X_14265__2299 _14265_/RESET_B VDD VSS sg13g2_tiehi
XFILLER_109_102 VDD VSS sg13g2_decap_8
XFILLER_149_293 VDD VSS sg13g2_decap_4
XFILLER_138_956 VDD VSS sg13g2_decap_8
XFILLER_20_781 VDD VSS sg13g2_decap_4
XFILLER_138_967 VDD VSS sg13g2_fill_2
Xclkbuf_5_11__f_clk_i clkbuf_leaf_97_clk_i/A clkbuf_4_5_0_clk_i/X VDD VSS sg13g2_buf_16
XFILLER_138_978 VDD VSS sg13g2_fill_2
X_11370_ _11370_/Y _11373_/A _14110_/Q VDD VSS sg13g2_nand2b_1
XFILLER_125_606 VDD VSS sg13g2_decap_8
XFILLER_109_157 VDD VSS sg13g2_decap_4
XFILLER_152_403 VDD VSS sg13g2_decap_8
XFILLER_153_937 VDD VSS sg13g2_decap_8
XFILLER_152_414 VDD VSS sg13g2_fill_2
X_15230__3383 _15230_/RESET_B VDD VSS sg13g2_tiehi
XFILLER_50_89 VDD VSS sg13g2_fill_2
X_10321_ _10323_/B _10330_/A _14799_/Q _14800_/Q _10342_/C VDD VSS sg13g2_nand4_1
XFILLER_3_435 VDD VSS sg13g2_decap_4
XFILLER_4_958 VDD VSS sg13g2_decap_8
X_13040_ _13042_/C _13057_/B _13057_/C VDD VSS sg13g2_nand2_1
X_10252_ _10252_/Y _14779_/Q _10258_/D _10271_/B VDD VSS sg13g2_o21ai_1
XFILLER_59_21 VDD VSS sg13g2_decap_8
XFILLER_59_32 VDD VSS sg13g2_fill_2
XFILLER_65_1135 VDD VSS sg13g2_decap_8
X_14480__2084 _14480_/RESET_B VDD VSS sg13g2_tiehi
XFILLER_152_1105 VDD VSS sg13g2_decap_8
X_10183_ _14748_/D _10173_/Y _10181_/Y _10182_/Y VDD VSS sg13g2_o21ai_1
XFILLER_120_311 VDD VSS sg13g2_fill_1
XFILLER_65_1179 VDD VSS sg13g2_fill_1
Xfanout1214 _12351_/S0 _12782_/S0 VDD VSS sg13g2_buf_1
XFILLER_120_333 VDD VSS sg13g2_decap_8
Xfanout1225 _13271_/C _12962_/C VDD VSS sg13g2_buf_1
Xfanout1236 _12403_/A2 _15206_/Q VDD VSS sg13g2_buf_1
XFILLER_66_409 VDD VSS sg13g2_fill_2
X_14991_ _14991_/Q clkload63/A _14991_/D _14991_/RESET_B VDD VSS sg13g2_dfrbpq_1
Xfanout1247 _12844_/C _15202_/Q VDD VSS sg13g2_buf_1
Xfanout260 _09789_/A0 _09888_/A0 VDD VSS sg13g2_buf_1
XFILLER_8_1062 VDD VSS sg13g2_decap_8
Xfanout1258 _13499_/C _15128_/Q VDD VSS sg13g2_buf_1
Xfanout1269 _13260_/B _13234_/B VDD VSS sg13g2_buf_1
Xfanout282 _10084_/A0 _10151_/A1 VDD VSS sg13g2_buf_1
X_13942_ _13942_/Q _14506_/CLK _13942_/D _13942_/RESET_B VDD VSS sg13g2_dfrbpq_1
XFILLER_47_623 VDD VSS sg13g2_decap_8
XFILLER_87_792 VDD VSS sg13g2_decap_8
Xfanout293 _10082_/A0 _09917_/A1 VDD VSS sg13g2_buf_1
XFILLER_75_943 VDD VSS sg13g2_decap_4
X_13873_ _13873_/Q _14737_/CLK _13873_/D _13873_/RESET_B VDD VSS sg13g2_dfrbpq_1
XFILLER_62_626 VDD VSS sg13g2_decap_8
XFILLER_74_497 VDD VSS sg13g2_fill_1
X_12824_ _15022_/D _13306_/A _12824_/B VDD VSS sg13g2_nor2_1
XFILLER_27_380 VDD VSS sg13g2_decap_4
X_13715__2849 _13715_/RESET_B VDD VSS sg13g2_tiehi
XFILLER_76_1231 VDD VSS sg13g2_decap_4
XFILLER_131_70 VDD VSS sg13g2_decap_8
XFILLER_43_851 VDD VSS sg13g2_fill_1
XFILLER_131_92 VDD VSS sg13g2_decap_8
X_12755_ _12755_/X _14264_/Q _14296_/Q _14328_/Q _14360_/Q _12755_/S0 _12759_/S1 VDD
+ VSS sg13g2_mux4_1
X_11706_ _11773_/C _11706_/A _13679_/Q VDD VSS sg13g2_xnor2_1
XFILLER_91_85 VDD VSS sg13g2_decap_4
X_12686_ _12686_/X _13843_/Q _13875_/Q _13907_/Q _13939_/Q _12686_/S0 _12686_/S1 VDD
+ VSS sg13g2_mux4_1
X_14425_ _14425_/Q _14706_/CLK _14425_/D _14425_/RESET_B VDD VSS sg13g2_dfrbpq_1
X_11637_ _11776_/A _11638_/C _11637_/B VDD VSS sg13g2_nor2_1
XFILLER_128_422 VDD VSS sg13g2_fill_1
X_13930__2634 _13930_/RESET_B VDD VSS sg13g2_tiehi
X_14690__1874 _14690_/RESET_B VDD VSS sg13g2_tiehi
X_14356_ _14356_/Q _14726_/CLK _14356_/D _14356_/RESET_B VDD VSS sg13g2_dfrbpq_1
X_11568_ _11571_/C _11502_/A _13685_/Q _12942_/B _11526_/A _11505_/X VDD VSS sg13g2_a221oi_1
XFILLER_155_252 VDD VSS sg13g2_decap_8
XFILLER_144_926 VDD VSS sg13g2_fill_2
Xmax_cap416 _09961_/S _09970_/S VDD VSS sg13g2_buf_4
X_13307_ _13307_/Y _13308_/A _13307_/B VDD VSS sg13g2_nor2_1
X_10519_ _14855_/D _10595_/B _10519_/B _10519_/C VDD VSS sg13g2_nor3_1
Xmax_cap427 _09937_/S _09907_/S VDD VSS sg13g2_buf_4
X_14287_ _14287_/Q clkload14/A _14287_/D _14287_/RESET_B VDD VSS sg13g2_dfrbpq_1
X_11499_ _11499_/Y _14901_/Q _11655_/B _11631_/A2 VDD VSS sg13g2_a21oi_1
X_13238_ wire146/A _13265_/A1 _13233_/X _13232_/Y _13271_/C _13237_/Y VDD VSS sg13g2_a221oi_1
XFILLER_83_1224 VDD VSS sg13g2_decap_8
XFILLER_83_1235 VDD VSS sg13g2_fill_2
X_14310__2254 _14310_/RESET_B VDD VSS sg13g2_tiehi
XFILLER_112_823 VDD VSS sg13g2_decap_8
X_13169_ _13169_/Y _13170_/C _13170_/D VDD VSS sg13g2_nor2_1
XFILLER_112_834 VDD VSS sg13g2_fill_1
XFILLER_123_171 VDD VSS sg13g2_decap_4
X_07730_ _07734_/B _15078_/Q _15084_/Q _15085_/Q _15081_/Q VDD VSS sg13g2_nor4_1
Xfanout1770 _13328_/A fanout1770/A VDD VSS sg13g2_buf_1
XFILLER_111_399 VDD VSS sg13g2_fill_1
XFILLER_65_420 VDD VSS sg13g2_fill_1
XFILLER_77_280 VDD VSS sg13g2_fill_1
Xfanout1781 _13425_/A _13600_/C VDD VSS sg13g2_buf_1
Xfanout1792 _10496_/B _10626_/B VDD VSS sg13g2_buf_1
XFILLER_133_1082 VDD VSS sg13g2_decap_8
X_07661_ _07661_/Y wire807/X VDD VSS sg13g2_inv_1
XFILLER_77_1006 VDD VSS sg13g2_decap_8
X_16859_ _16859_/X _16859_/A VDD VSS sg13g2_buf_1
XFILLER_65_475 VDD VSS sg13g2_decap_8
XFILLER_81_924 VDD VSS sg13g2_decap_8
XFILLER_53_626 VDD VSS sg13g2_decap_8
X_09400_ _14003_/D _09963_/A1 _14003_/Q _09403_/S VDD VSS sg13g2_mux2_1
XFILLER_93_795 VDD VSS sg13g2_decap_4
XFILLER_52_114 VDD VSS sg13g2_decap_8
XFILLER_129_1118 VDD VSS sg13g2_decap_8
XFILLER_92_294 VDD VSS sg13g2_decap_4
X_09331_ _13938_/D _09830_/A0 _13938_/Q _09339_/S VDD VSS sg13g2_mux2_1
XFILLER_90_1228 VDD VSS sg13g2_decap_8
X_09262_ _13871_/D _13871_/Q _10091_/A0 _09266_/S VDD VSS sg13g2_mux2_1
XFILLER_21_534 VDD VSS sg13g2_fill_1
X_08213_ _08374_/B _08121_/X _08124_/X _08213_/S VDD VSS sg13g2_mux2_1
XFILLER_18_1170 VDD VSS sg13g2_decap_8
X_09193_ _13809_/D _13809_/Q _09730_/A0 _09193_/S VDD VSS sg13g2_mux2_1
XFILLER_14_1023 VDD VSS sg13g2_decap_8
XFILLER_53_1083 VDD VSS sg13g2_decap_8
XFILLER_105_1162 VDD VSS sg13g2_decap_8
XFILLER_119_433 VDD VSS sg13g2_decap_8
X_08144_ _08145_/C _08110_/D _08138_/X _08463_/B _08381_/A _08143_/Y VDD VSS sg13g2_a221oi_1
XFILLER_88_1102 VDD VSS sg13g2_fill_2
XFILLER_14_1078 VDD VSS sg13g2_decap_8
X_15141__3060 _15141_/RESET_B VDD VSS sg13g2_tiehi
XFILLER_146_285 VDD VSS sg13g2_decap_8
X_08075_ _08075_/Y _08023_/A _08548_/A _08074_/C _08074_/B VDD VSS sg13g2_a22oi_1
XFILLER_103_823 VDD VSS sg13g2_decap_4
XFILLER_0_438 VDD VSS sg13g2_decap_4
XFILLER_130_631 VDD VSS sg13g2_fill_1
XFILLER_102_333 VDD VSS sg13g2_decap_8
XFILLER_29_35 VDD VSS sg13g2_decap_8
XFILLER_152_14 VDD VSS sg13g2_decap_8
XFILLER_25_1130 VDD VSS sg13g2_decap_8
X_08977_ _08977_/Y _08977_/A _08977_/B _08977_/C VDD VSS sg13g2_nand3_1
XFILLER_5_1213 VDD VSS sg13g2_decap_8
XFILLER_102_388 VDD VSS sg13g2_fill_2
X_07928_ _07928_/Y _07923_/Y _07925_/Y _07797_/X VDD VSS sg13g2_a21oi_1
XFILLER_28_111 VDD VSS sg13g2_decap_8
XFILLER_21_1005 VDD VSS sg13g2_decap_8
XFILLER_151_1182 VDD VSS sg13g2_decap_8
XFILLER_99_1231 VDD VSS sg13g2_decap_4
XFILLER_60_1087 VDD VSS sg13g2_fill_1
X_07859_ _08641_/C _15014_/Q _07859_/B VDD VSS sg13g2_xnor2_1
XFILLER_72_913 VDD VSS sg13g2_decap_8
XFILLER_90_209 VDD VSS sg13g2_fill_1
XFILLER_56_475 VDD VSS sg13g2_decap_8
XFILLER_72_924 VDD VSS sg13g2_fill_1
XFILLER_44_637 VDD VSS sg13g2_fill_2
XFILLER_16_339 VDD VSS sg13g2_decap_4
X_10870_ _10897_/B _10870_/A _10871_/A VDD VSS sg13g2_nand2_1
X_09529_ _14128_/D _09562_/A0 _14128_/Q _09538_/S VDD VSS sg13g2_mux2_1
X_12540_ _12541_/B _13680_/Q _12763_/A2 _12539_/X _12763_/B2 _12763_/C1 VDD VSS sg13g2_a221oi_1
XFILLER_40_832 VDD VSS sg13g2_decap_8
XFILLER_40_843 VDD VSS sg13g2_fill_2
XFILLER_24_394 VDD VSS sg13g2_fill_2
X_14498__2066 _14498_/RESET_B VDD VSS sg13g2_tiehi
X_12471_ _14997_/D _12471_/A _12471_/B VDD VSS sg13g2_nor2_1
X_14210_ _14210_/Q clkload6/A _14210_/D _14210_/RESET_B VDD VSS sg13g2_dfrbpq_1
X_11422_ _11422_/Y _11422_/A _11422_/B VDD VSS sg13g2_nand2_1
XFILLER_61_99 VDD VSS sg13g2_decap_8
X_15190_ _15190_/Q _15212_/CLK _15190_/D _15190_/RESET_B VDD VSS sg13g2_dfrbpq_1
XFILLER_6_28 VDD VSS sg13g2_decap_8
XFILLER_4_700 VDD VSS sg13g2_fill_2
X_14141_ _14141_/Q _14525_/CLK _14141_/D _14141_/RESET_B VDD VSS sg13g2_dfrbpq_1
XFILLER_117_0 VDD VSS sg13g2_decap_8
X_11353_ _11353_/X _14558_/Q _14590_/Q _11353_/S VDD VSS sg13g2_mux2_1
X_10304_ _10311_/C _14794_/Q _14795_/Q VDD VSS sg13g2_and2_1
X_14072_ _14072_/Q _14506_/CLK _14072_/D _14072_/RESET_B VDD VSS sg13g2_dfrbpq_1
XFILLER_113_609 VDD VSS sg13g2_fill_2
X_11284_ _11285_/A _11281_/Y _11283_/Y _11284_/B1 VDD VSS sg13g2_a21oi_1
XFILLER_3_254 VDD VSS sg13g2_decap_8
XFILLER_4_777 VDD VSS sg13g2_decap_8
XFILLER_10_70 VDD VSS sg13g2_decap_8
X_13023_ _13057_/A _14908_/Q _13679_/Q VDD VSS sg13g2_xor2_1
X_10235_ _10235_/Y _07638_/Y _10232_/B _13499_/B VDD VSS sg13g2_o21ai_1
XFILLER_79_545 VDD VSS sg13g2_fill_1
Xfanout1000 _11207_/A2 _11045_/A2 VDD VSS sg13g2_buf_1
Xfanout1011 _11070_/A1 _07649_/Y VDD VSS sg13g2_buf_1
XFILLER_126_81 VDD VSS sg13g2_decap_8
Xfanout1022 _08110_/B _07631_/Y VDD VSS sg13g2_buf_1
X_10166_ _14743_/D _14743_/Q _10166_/A1 _10166_/S VDD VSS sg13g2_mux2_1
Xfanout1033 _08048_/A _13550_/A1 VDD VSS sg13g2_buf_1
XFILLER_67_718 VDD VSS sg13g2_decap_8
XFILLER_120_152 VDD VSS sg13g2_decap_8
Xfanout1044 _10969_/B _10647_/D VDD VSS sg13g2_buf_1
XFILLER_121_686 VDD VSS sg13g2_decap_8
XFILLER_120_163 VDD VSS sg13g2_decap_8
Xfanout1066 _12455_/S _12706_/S VDD VSS sg13g2_buf_1
XFILLER_66_239 VDD VSS sg13g2_fill_1
XFILLER_86_96 VDD VSS sg13g2_decap_8
X_10097_ _14677_/D _10097_/A0 _14677_/Q _10101_/S VDD VSS sg13g2_mux2_1
X_14974_ _14974_/Q _15040_/CLK _14974_/D _14974_/RESET_B VDD VSS sg13g2_dfrbpq_1
Xfanout1099 _12546_/S1 fanout1104/X VDD VSS sg13g2_buf_1
XFILLER_47_453 VDD VSS sg13g2_decap_8
XFILLER_48_976 VDD VSS sg13g2_fill_2
XFILLER_63_902 VDD VSS sg13g2_decap_4
X_13925_ _13925_/Q clkload3/A _13925_/D _13925_/RESET_B VDD VSS sg13g2_dfrbpq_1
XFILLER_47_464 VDD VSS sg13g2_fill_1
X_13948__2616 _13948_/RESET_B VDD VSS sg13g2_tiehi
XFILLER_47_475 VDD VSS sg13g2_decap_8
X_13856_ _13856_/Q clkload17/A _13856_/D _13856_/RESET_B VDD VSS sg13g2_dfrbpq_1
XFILLER_90_743 VDD VSS sg13g2_decap_8
X_15061__2874 _15061_/RESET_B VDD VSS sg13g2_tiehi
X_12807_ _12807_/Y _14799_/Q _12851_/B _13260_/B _14831_/Q _13180_/C1 VDD VSS sg13g2_a221oi_1
X_13787_ _13787_/Q clkload76/A _13787_/D _13787_/RESET_B VDD VSS sg13g2_dfrbpq_1
XFILLER_76_1061 VDD VSS sg13g2_decap_4
X_10999_ _10999_/X _10995_/B _11045_/A2 _10999_/B1 VDD VSS sg13g2_a21o_1
XFILLER_76_1094 VDD VSS sg13g2_decap_8
X_12738_ _12738_/X _14583_/Q _14615_/Q _14647_/Q _14679_/Q _12743_/S0 _12743_/S1 VDD
+ VSS sg13g2_mux4_1
XFILLER_148_506 VDD VSS sg13g2_decap_8
X_14328__2236 _14328_/RESET_B VDD VSS sg13g2_tiehi
XFILLER_31_865 VDD VSS sg13g2_decap_8
XFILLER_30_342 VDD VSS sg13g2_fill_2
X_12669_ _12669_/X _14386_/Q _14418_/Q _14482_/Q _14514_/Q _12674_/S0 _12675_/S1 VDD
+ VSS sg13g2_mux4_1
XFILLER_124_1059 VDD VSS sg13g2_decap_4
X_14408_ _14408_/Q _15160_/CLK _14408_/D _14408_/RESET_B VDD VSS sg13g2_dfrbpq_1
Xwire480 wire480/X wire480/A VDD VSS sg13g2_buf_8
X_14339_ _14339_/Q _14405_/CLK _14339_/D _14339_/RESET_B VDD VSS sg13g2_dfrbpq_1
XFILLER_128_274 VDD VSS sg13g2_decap_4
Xmax_cap213 _10404_/A2 _10401_/A VDD VSS sg13g2_buf_2
X_14543__2021 _14543_/RESET_B VDD VSS sg13g2_tiehi
Xmax_cap257 _11015_/A _10952_/Y VDD VSS sg13g2_buf_1
X_08900_ _08900_/Y _11798_/A _08955_/S _08899_/Y VDD VSS sg13g2_a21oi_1
XFILLER_98_832 VDD VSS sg13g2_decap_8
X_15083__3212 _15083_/RESET_B VDD VSS sg13g2_tiehi
X_09880_ _14466_/D _09880_/A0 _14466_/Q _09900_/S VDD VSS sg13g2_mux2_1
XFILLER_131_439 VDD VSS sg13g2_fill_2
X_14797__3301 _14797_/RESET_B VDD VSS sg13g2_tiehi
XFILLER_44_1005 VDD VSS sg13g2_decap_4
XFILLER_83_1054 VDD VSS sg13g2_fill_1
XFILLER_32_0 VDD VSS sg13g2_decap_8
XFILLER_48_1185 VDD VSS sg13g2_decap_8
X_08831_ _08831_/Y _13283_/A _11241_/C VDD VSS sg13g2_nor2_1
XFILLER_135_1155 VDD VSS sg13g2_fill_2
XFILLER_83_1098 VDD VSS sg13g2_decap_8
XFILLER_112_675 VDD VSS sg13g2_decap_8
XFILLER_85_515 VDD VSS sg13g2_decap_8
XFILLER_100_826 VDD VSS sg13g2_decap_8
XFILLER_57_228 VDD VSS sg13g2_fill_1
X_08762_ _13672_/D _08765_/A1 _08760_/Y _08761_/Y VDD VSS sg13g2_a21oi_1
XFILLER_85_559 VDD VSS sg13g2_fill_2
X_07713_ _07740_/A _07713_/A _07748_/B VDD VSS sg13g2_nor2b_1
X_08693_ _08693_/Y _08693_/A _08693_/B _08693_/C VDD VSS sg13g2_nand3_1
XFILLER_122_28 VDD VSS sg13g2_decap_8
XFILLER_26_615 VDD VSS sg13g2_fill_1
XFILLER_66_784 VDD VSS sg13g2_fill_1
XFILLER_26_626 VDD VSS sg13g2_decap_8
XFILLER_0_1110 VDD VSS sg13g2_decap_4
X_07644_ _10297_/A _14790_/Q VDD VSS sg13g2_inv_1
XFILLER_41_607 VDD VSS sg13g2_fill_2
XFILLER_20_1093 VDD VSS sg13g2_decap_8
XFILLER_80_275 VDD VSS sg13g2_decap_8
X_09314_ _13921_/D _09747_/A1 _13921_/Q _09337_/S VDD VSS sg13g2_mux2_1
XFILLER_55_1145 VDD VSS sg13g2_fill_2
XFILLER_16_1118 VDD VSS sg13g2_decap_8
XFILLER_107_1235 VDD VSS sg13g2_fill_2
X_09245_ _13854_/D _13854_/Q _10074_/A0 _09264_/S VDD VSS sg13g2_mux2_1
XFILLER_22_898 VDD VSS sg13g2_fill_1
XFILLER_31_14 VDD VSS sg13g2_decap_8
X_09176_ _13792_/D _13792_/Q _10143_/A1 _09201_/S VDD VSS sg13g2_mux2_1
XFILLER_147_14 VDD VSS sg13g2_decap_8
XFILLER_135_701 VDD VSS sg13g2_decap_8
X_14182__2382 _14182_/RESET_B VDD VSS sg13g2_tiehi
X_08127_ _08463_/B _08270_/B _08122_/Y _08126_/Y VDD VSS sg13g2_o21ai_1
XFILLER_119_274 VDD VSS sg13g2_fill_2
XFILLER_110_7 VDD VSS sg13g2_decap_8
XFILLER_107_447 VDD VSS sg13g2_fill_2
X_08058_ _08058_/X _08044_/X _08052_/Y _08042_/X _08167_/B _08244_/B _08167_/A VDD
+ VSS sg13g2_mux4_1
XFILLER_150_715 VDD VSS sg13g2_fill_1
XFILLER_134_277 VDD VSS sg13g2_decap_8
XFILLER_122_417 VDD VSS sg13g2_decap_8
Xoutput47 mem_axi_araddr[18] _16871_/A VDD VSS sg13g2_buf_1
Xoutput58 mem_axi_araddr[29] output58/A VDD VSS sg13g2_buf_1
XFILLER_0_202 VDD VSS sg13g2_fill_1
Xoutput69 mem_axi_arprot[2] _16854_/X VDD VSS sg13g2_buf_1
XFILLER_88_320 VDD VSS sg13g2_fill_2
XFILLER_153_1233 VDD VSS sg13g2_decap_4
XFILLER_27_1236 VDD VSS sg13g2_fill_1
XFILLER_62_1116 VDD VSS sg13g2_fill_2
X_10020_ _14602_/D _10086_/A0 _14602_/Q _10020_/S VDD VSS sg13g2_mux2_1
XFILLER_0_246 VDD VSS sg13g2_decap_4
XFILLER_89_876 VDD VSS sg13g2_decap_8
XFILLER_88_364 VDD VSS sg13g2_decap_8
XFILLER_130_450 VDD VSS sg13g2_decap_8
XFILLER_76_526 VDD VSS sg13g2_decap_8
XFILLER_5_1010 VDD VSS sg13g2_decap_8
XFILLER_9_1190 VDD VSS sg13g2_decap_8
X_14406__2158 _14406_/RESET_B VDD VSS sg13g2_tiehi
X_11971_ _11971_/Y _11971_/A _11971_/B _12027_/C VDD VSS sg13g2_nand3_1
XFILLER_17_615 VDD VSS sg13g2_fill_1
XFILLER_5_1087 VDD VSS sg13g2_decap_8
X_13710_ _13710_/Q _14916_/CLK _13710_/D _13710_/RESET_B VDD VSS sg13g2_dfrbpq_1
XFILLER_56_99 VDD VSS sg13g2_fill_2
X_10922_ _10926_/A _10920_/A _10920_/B _10921_/Y VDD VSS sg13g2_a21o_1
XFILLER_17_648 VDD VSS sg13g2_decap_8
X_14690_ _14690_/Q _14722_/CLK _14690_/D _14690_/RESET_B VDD VSS sg13g2_dfrbpq_1
XFILLER_45_957 VDD VSS sg13g2_decap_8
XFILLER_56_294 VDD VSS sg13g2_decap_8
XFILLER_72_765 VDD VSS sg13g2_fill_1
XFILLER_16_158 VDD VSS sg13g2_decap_8
XFILLER_60_916 VDD VSS sg13g2_fill_2
XFILLER_72_21 VDD VSS sg13g2_decap_8
X_13641_ _13749_/D _13641_/A VDD VSS sg13g2_buf_1
X_10853_ _10857_/A _14751_/Q _10851_/C _10841_/Y VDD VSS sg13g2_a21o_1
XFILLER_13_832 VDD VSS sg13g2_decap_8
XFILLER_73_1234 VDD VSS sg13g2_fill_2
X_13572_ _13572_/Y _15156_/Q _13593_/B VDD VSS sg13g2_nor2_1
X_10784_ _14922_/D _11168_/B1 _11164_/C _10783_/Y VDD VSS sg13g2_o21ai_1
XFILLER_40_651 VDD VSS sg13g2_decap_8
XFILLER_12_353 VDD VSS sg13g2_decap_8
X_12523_ _12523_/X _12522_/X _12521_/X _12518_/X _12517_/X wire1081/X _12691_/S0 VDD
+ VSS sg13g2_mux4_1
XFILLER_12_364 VDD VSS sg13g2_fill_1
XFILLER_8_313 VDD VSS sg13g2_decap_8
X_15242_ _15242_/Q clkload32/A wire143/X _15242_/RESET_B VDD VSS sg13g2_dfrbpq_1
X_12454_ _12454_/X _12446_/X _12450_/X _12445_/X _12449_/X _12553_/S _12747_/S1 VDD
+ VSS sg13g2_mux4_1
XFILLER_126_712 VDD VSS sg13g2_decap_4
X_11405_ _11405_/Y _11396_/Y _12000_/A _11424_/B VDD VSS sg13g2_a21oi_1
X_14012__2552 _14012_/RESET_B VDD VSS sg13g2_tiehi
X_15173_ _15173_/Q clkload72/A _15173_/D _15173_/RESET_B VDD VSS sg13g2_dfrbpq_1
XFILLER_123_1092 VDD VSS sg13g2_decap_8
XFILLER_153_520 VDD VSS sg13g2_decap_8
X_12385_ _12386_/B _12383_/X _12384_/X _12720_/S VDD VSS sg13g2_mux2_1
XFILLER_125_211 VDD VSS sg13g2_fill_2
XFILLER_126_756 VDD VSS sg13g2_fill_2
XFILLER_67_1027 VDD VSS sg13g2_decap_8
X_14124_ _14124_/Q _14714_/CLK _14124_/D _14124_/RESET_B VDD VSS sg13g2_dfrbpq_1
XFILLER_141_704 VDD VSS sg13g2_decap_8
X_11336_ _11339_/A _11336_/A _11335_/X VDD VSS sg13g2_nor2b_1
XFILLER_67_1038 VDD VSS sg13g2_fill_2
XFILLER_114_929 VDD VSS sg13g2_decap_8
XFILLER_119_1106 VDD VSS sg13g2_fill_1
XFILLER_4_563 VDD VSS sg13g2_decap_8
X_14616__1948 _14616_/RESET_B VDD VSS sg13g2_tiehi
XFILLER_125_277 VDD VSS sg13g2_decap_8
X_14055_ _14055_/Q clkload5/A _14055_/D _14055_/RESET_B VDD VSS sg13g2_dfrbpq_1
X_11267_ _11267_/Y _11263_/Y _11264_/X _11266_/Y VDD VSS sg13g2_o21ai_1
X_13006_ _13058_/A _14907_/Q _13680_/Q VDD VSS sg13g2_or2_1
XFILLER_79_342 VDD VSS sg13g2_decap_4
X_10218_ _14767_/D _14767_/Q _10347_/B VDD VSS sg13g2_nor2_1
XFILLER_39_206 VDD VSS sg13g2_decap_8
X_11198_ _11201_/A _11177_/B _11177_/C _11197_/X VDD VSS sg13g2_o21ai_1
X_13880__2684 _13880_/RESET_B VDD VSS sg13g2_tiehi
XFILLER_39_239 VDD VSS sg13g2_decap_4
X_10149_ _14726_/D _14726_/Q _10149_/A1 _10150_/S VDD VSS sg13g2_mux2_1
XFILLER_95_879 VDD VSS sg13g2_decap_4
XFILLER_82_529 VDD VSS sg13g2_decap_8
X_14957_ _14957_/Q _15178_/CLK _14957_/D _14957_/RESET_B VDD VSS sg13g2_dfrbpq_1
XFILLER_75_570 VDD VSS sg13g2_decap_8
XFILLER_63_721 VDD VSS sg13g2_decap_8
X_13908_ _13908_/Q clkload33/A _13908_/D _13908_/RESET_B VDD VSS sg13g2_dfrbpq_1
X_14888_ _14888_/Q clkload79/A _14888_/D _14888_/RESET_B VDD VSS sg13g2_dfrbpq_1
XFILLER_51_916 VDD VSS sg13g2_decap_8
XFILLER_78_1189 VDD VSS sg13g2_decap_8
X_13839_ _13839_/Q clkload13/A _13839_/D _13839_/RESET_B VDD VSS sg13g2_dfrbpq_1
XFILLER_90_573 VDD VSS sg13g2_decap_4
XFILLER_50_415 VDD VSS sg13g2_fill_1
XFILLER_90_595 VDD VSS sg13g2_fill_1
XFILLER_149_848 VDD VSS sg13g2_decap_8
XFILLER_31_662 VDD VSS sg13g2_fill_2
X_09030_ _09043_/A _14905_/Q _12957_/A _12942_/A _09030_/D VDD VSS sg13g2_nand4_1
XFILLER_136_509 VDD VSS sg13g2_fill_1
XFILLER_30_194 VDD VSS sg13g2_fill_2
XFILLER_50_1042 VDD VSS sg13g2_fill_1
XFILLER_50_1053 VDD VSS sg13g2_fill_1
XFILLER_144_542 VDD VSS sg13g2_decap_4
XFILLER_144_553 VDD VSS sg13g2_decap_8
XFILLER_116_244 VDD VSS sg13g2_fill_2
XFILLER_102_1198 VDD VSS sg13g2_decap_8
XFILLER_116_266 VDD VSS sg13g2_fill_1
XFILLER_117_28 VDD VSS sg13g2_decap_8
XFILLER_116_277 VDD VSS sg13g2_fill_1
X_09932_ _14517_/D _14517_/Q _10131_/A0 _09936_/S VDD VSS sg13g2_mux2_1
XFILLER_116_288 VDD VSS sg13g2_decap_8
Xfanout804 _08359_/B2 _08381_/A VDD VSS sg13g2_buf_1
Xfanout815 _13123_/B1 _13236_/B1 VDD VSS sg13g2_buf_1
Xfanout826 _13149_/A2 _13264_/A2 VDD VSS sg13g2_buf_1
Xfanout837 _10959_/B wire844/X VDD VSS sg13g2_buf_1
X_09863_ _14450_/D _14450_/Q _09962_/A1 _09870_/S VDD VSS sg13g2_mux2_1
Xfanout848 _09137_/A _08988_/A VDD VSS sg13g2_buf_1
XFILLER_85_301 VDD VSS sg13g2_fill_2
XFILLER_113_995 VDD VSS sg13g2_decap_8
Xfanout859 _08862_/S _10675_/A VDD VSS sg13g2_buf_1
X_13710__2854 _13710_/RESET_B VDD VSS sg13g2_tiehi
XFILLER_86_835 VDD VSS sg13g2_decap_8
XFILLER_100_612 VDD VSS sg13g2_decap_8
X_08814_ _08814_/Y _13689_/Q _13481_/C VDD VSS sg13g2_nor2_1
XFILLER_22_1100 VDD VSS sg13g2_decap_8
XFILLER_58_559 VDD VSS sg13g2_decap_8
X_09794_ _14383_/D _09893_/A0 _14383_/Q _09798_/S VDD VSS sg13g2_mux2_1
XFILLER_85_356 VDD VSS sg13g2_fill_1
XFILLER_45_209 VDD VSS sg13g2_decap_8
X_08745_ _08745_/Y _08751_/A1 _08751_/A2 _15195_/Q VDD VSS sg13g2_o21ai_1
XFILLER_100_689 VDD VSS sg13g2_decap_8
XFILLER_2_1227 VDD VSS sg13g2_decap_8
XFILLER_26_14 VDD VSS sg13g2_decap_8
XFILLER_22_1177 VDD VSS sg13g2_decap_8
X_08676_ _08676_/Y _08363_/X _08452_/B _08668_/X _08688_/C _08675_/Y VDD VSS sg13g2_a221oi_1
XFILLER_26_445 VDD VSS sg13g2_decap_4
XFILLER_54_776 VDD VSS sg13g2_fill_1
X_07627_ _07627_/Y _07884_/A VDD VSS sg13g2_inv_1
XFILLER_54_798 VDD VSS sg13g2_decap_4
XFILLER_81_584 VDD VSS sg13g2_decap_8
XFILLER_42_35 VDD VSS sg13g2_fill_1
XFILLER_21_161 VDD VSS sg13g2_decap_8
X_09228_ _13839_/D _10091_/A0 _13839_/Q _09232_/S VDD VSS sg13g2_mux2_1
XFILLER_10_857 VDD VSS sg13g2_fill_2
XFILLER_127_509 VDD VSS sg13g2_fill_1
XFILLER_107_1098 VDD VSS sg13g2_decap_8
XFILLER_120_1210 VDD VSS sg13g2_decap_8
XFILLER_108_723 VDD VSS sg13g2_fill_1
X_09159_ wire158/A _09159_/A1 _09155_/Y _09158_/Y VDD VSS sg13g2_o21ai_1
X_12170_ _12170_/Y _12170_/A _12170_/B _12219_/S VDD VSS sg13g2_nand3_1
X_11121_ _11123_/A _11115_/A _11115_/B _11172_/A VDD VSS sg13g2_a21oi_1
XFILLER_123_737 VDD VSS sg13g2_fill_1
XFILLER_27_1000 VDD VSS sg13g2_fill_1
XFILLER_122_236 VDD VSS sg13g2_decap_4
XFILLER_1_555 VDD VSS sg13g2_decap_8
XFILLER_107_61 VDD VSS sg13g2_decap_8
XFILLER_150_578 VDD VSS sg13g2_decap_8
X_11052_ _11069_/B _11052_/A _11052_/B _11078_/A wire239/X VDD VSS sg13g2_nor4_1
XFILLER_67_21 VDD VSS sg13g2_decap_4
XFILLER_49_515 VDD VSS sg13g2_decap_8
XFILLER_77_824 VDD VSS sg13g2_decap_4
XFILLER_77_835 VDD VSS sg13g2_decap_8
XFILLER_7_1138 VDD VSS sg13g2_decap_8
X_10003_ _14586_/D _10069_/A0 _14586_/Q _10003_/S VDD VSS sg13g2_mux2_1
XFILLER_114_1047 VDD VSS sg13g2_fill_2
XFILLER_92_805 VDD VSS sg13g2_fill_1
X_14811_ _14811_/Q _14854_/CLK _14811_/D _14811_/RESET_B VDD VSS sg13g2_dfrbpq_1
XFILLER_64_518 VDD VSS sg13g2_decap_8
XFILLER_17_401 VDD VSS sg13g2_fill_1
XFILLER_18_946 VDD VSS sg13g2_decap_8
XFILLER_57_581 VDD VSS sg13g2_decap_8
XFILLER_123_71 VDD VSS sg13g2_decap_8
XFILLER_17_423 VDD VSS sg13g2_decap_8
X_14742_ _14742_/Q clkload24/A _14742_/D _14742_/RESET_B VDD VSS sg13g2_dfrbpq_1
X_11954_ _11955_/A _13744_/Q _14096_/Q _14448_/Q _14544_/Q _11951_/A _11970_/C VDD
+ VSS sg13g2_mux4_1
XFILLER_44_253 VDD VSS sg13g2_decap_8
X_10905_ _10945_/A _14756_/Q _10936_/D VDD VSS sg13g2_nor2_1
X_14673_ _14673_/Q clkload45/A _14673_/D _14673_/RESET_B VDD VSS sg13g2_dfrbpq_1
XFILLER_60_724 VDD VSS sg13g2_decap_8
X_11885_ _11885_/Y _11890_/S0 _14382_/Q VDD VSS sg13g2_nand2b_1
XFILLER_33_949 VDD VSS sg13g2_fill_2
XFILLER_72_584 VDD VSS sg13g2_decap_8
XFILLER_60_735 VDD VSS sg13g2_fill_2
X_13624_ _13732_/D _13624_/A VDD VSS sg13g2_buf_1
X_10836_ _14929_/D hold3534/X _10800_/B _10835_/Y VDD VSS sg13g2_a21o_1
XFILLER_16_91 VDD VSS sg13g2_fill_2
XFILLER_9_611 VDD VSS sg13g2_fill_1
XFILLER_38_1184 VDD VSS sg13g2_decap_8
X_13555_ _13555_/Y _13555_/A _13566_/B _13563_/C VDD VSS sg13g2_nor3_1
X_10767_ _10767_/Y _10767_/A _10767_/B VDD VSS sg13g2_nor2_1
XFILLER_40_470 VDD VSS sg13g2_fill_1
XFILLER_125_1154 VDD VSS sg13g2_decap_8
XFILLER_12_183 VDD VSS sg13g2_fill_1
X_12506_ _12506_/X _13734_/Q _14086_/Q _14438_/Q _14534_/Q _12745_/S0 _12745_/S1 VDD
+ VSS sg13g2_mux4_1
Xmax_cap1600 _12092_/C _11439_/A VDD VSS sg13g2_buf_4
XFILLER_121_1018 VDD VSS sg13g2_decap_4
XFILLER_73_7 VDD VSS sg13g2_decap_8
X_13486_ _13502_/D _13486_/A _15170_/D _15169_/D VDD VSS sg13g2_nand3_1
X_13898__2666 _13898_/RESET_B VDD VSS sg13g2_tiehi
XFILLER_8_154 VDD VSS sg13g2_fill_1
X_10698_ wire584/A _14933_/Q _08862_/S _10697_/X VDD VSS sg13g2_a21oi_1
XFILLER_139_881 VDD VSS sg13g2_decap_8
XFILLER_139_892 VDD VSS sg13g2_fill_1
X_15225_ _15225_/Q clkload40/A _15225_/D _15225_/RESET_B VDD VSS sg13g2_dfrbpq_1
XFILLER_145_339 VDD VSS sg13g2_decap_4
X_12437_ _12437_/X _14369_/Q _14401_/Q _14465_/Q _14497_/Q _12535_/S0 _12536_/S1 VDD
+ VSS sg13g2_mux4_1
XFILLER_154_840 VDD VSS sg13g2_decap_8
Xmax_cap1666 _11714_/S0 _11711_/S0 VDD VSS sg13g2_buf_4
X_14839__3251 _14839_/RESET_B VDD VSS sg13g2_tiehi
XFILLER_5_850 VDD VSS sg13g2_decap_8
X_15156_ _15156_/Q clkload29/A _15156_/D _15156_/RESET_B VDD VSS sg13g2_dfrbpq_1
X_12368_ _12368_/X _14684_/Q _14716_/Q _13756_/Q _13788_/Q _12368_/S0 _12368_/S1 VDD
+ VSS sg13g2_mux4_1
XFILLER_99_404 VDD VSS sg13g2_fill_1
XFILLER_99_415 VDD VSS sg13g2_decap_4
XFILLER_126_575 VDD VSS sg13g2_fill_1
X_14107_ _14107_/Q clkload73/A _14107_/D _14107_/RESET_B VDD VSS sg13g2_dfrbpq_1
X_11319_ _11319_/Y _11314_/Y _11315_/Y _11395_/B VDD VSS sg13g2_a21oi_1
X_15087_ _15087_/Q clkload70/A _15087_/D _15087_/RESET_B VDD VSS sg13g2_dfrbpq_1
XFILLER_141_545 VDD VSS sg13g2_fill_1
X_14278__2286 _14278_/RESET_B VDD VSS sg13g2_tiehi
X_12299_ _12299_/Y wire147/X _12279_/B _12277_/X VDD VSS sg13g2_a21oi_1
X_14038_ _14038_/Q _14710_/CLK _14038_/D _14038_/RESET_B VDD VSS sg13g2_dfrbpq_1
XFILLER_68_802 VDD VSS sg13g2_decap_8
XFILLER_45_1133 VDD VSS sg13g2_decap_4
XFILLER_95_621 VDD VSS sg13g2_decap_8
XFILLER_45_1177 VDD VSS sg13g2_decap_8
XFILLER_67_323 VDD VSS sg13g2_decap_8
XFILLER_41_1019 VDD VSS sg13g2_decap_8
XFILLER_67_345 VDD VSS sg13g2_decap_8
XFILLER_80_1068 VDD VSS sg13g2_decap_8
XFILLER_132_1158 VDD VSS sg13g2_decap_8
XFILLER_67_356 VDD VSS sg13g2_fill_2
XFILLER_132_1169 VDD VSS sg13g2_fill_2
X_14493__2071 _14493_/RESET_B VDD VSS sg13g2_tiehi
X_08530_ _08531_/B _07823_/Y _08497_/B _07954_/C VDD VSS sg13g2_o21ai_1
X_08461_ _08462_/C _08461_/A _08461_/B _08461_/C _08461_/D VDD VSS sg13g2_and4_1
XFILLER_24_938 VDD VSS sg13g2_decap_8
XFILLER_63_573 VDD VSS sg13g2_fill_1
XFILLER_35_275 VDD VSS sg13g2_decap_8
XFILLER_51_746 VDD VSS sg13g2_fill_1
X_08392_ _08394_/C _08367_/Y _08391_/Y _08390_/Y VDD VSS sg13g2_a21oi_1
XFILLER_50_245 VDD VSS sg13g2_decap_4
XFILLER_52_1137 VDD VSS sg13g2_decap_8
XFILLER_104_1205 VDD VSS sg13g2_decap_8
XFILLER_136_317 VDD VSS sg13g2_decap_4
X_13728__2836 _13728_/RESET_B VDD VSS sg13g2_tiehi
XFILLER_12_49 VDD VSS sg13g2_decap_8
X_09013_ wire525/A _09011_/Y _09012_/Y _09010_/Y VDD VSS sg13g2_o21ai_1
XFILLER_117_542 VDD VSS sg13g2_decap_8
XFILLER_128_49 VDD VSS sg13g2_decap_4
XFILLER_105_748 VDD VSS sg13g2_decap_8
XFILLER_105_759 VDD VSS sg13g2_fill_2
X_14108__2456 _14108_/RESET_B VDD VSS sg13g2_tiehi
XFILLER_63_1200 VDD VSS sg13g2_fill_2
X_13943__2621 _13943_/RESET_B VDD VSS sg13g2_tiehi
Xfanout612 wire613/A _09971_/Y VDD VSS sg13g2_buf_1
XFILLER_132_578 VDD VSS sg13g2_decap_4
X_09915_ _14500_/D _14500_/Q _09915_/A1 wire423/X VDD VSS sg13g2_mux2_1
XFILLER_99_982 VDD VSS sg13g2_fill_1
Xfanout656 _09523_/S _09537_/S VDD VSS sg13g2_buf_1
XFILLER_86_632 VDD VSS sg13g2_fill_2
X_09846_ _14433_/D _14433_/Q _10077_/A0 _09855_/S VDD VSS sg13g2_mux2_1
XFILLER_98_492 VDD VSS sg13g2_fill_2
XFILLER_112_280 VDD VSS sg13g2_decap_8
XFILLER_150_1236 VDD VSS sg13g2_fill_1
X_14892__3145 _14892_/RESET_B VDD VSS sg13g2_tiehi
XFILLER_86_676 VDD VSS sg13g2_decap_8
XFILLER_100_464 VDD VSS sg13g2_fill_1
X_09777_ _14366_/D _09909_/A1 _14366_/Q wire633/X VDD VSS sg13g2_mux2_1
X_14323__2241 _14323_/RESET_B VDD VSS sg13g2_tiehi
XFILLER_73_337 VDD VSS sg13g2_fill_2
X_08728_ _08728_/Y _08727_/X _13448_/B _08809_/C1 VDD VSS sg13g2_a21oi_1
X_13976__2588 _13976_/RESET_B VDD VSS sg13g2_tiehi
XFILLER_54_540 VDD VSS sg13g2_decap_4
XFILLER_148_1110 VDD VSS sg13g2_decap_4
XFILLER_15_927 VDD VSS sg13g2_fill_1
X_08659_ _08661_/C _08668_/A _08659_/B _08659_/C VDD VSS sg13g2_or3_1
XFILLER_82_882 VDD VSS sg13g2_decap_8
XFILLER_54_584 VDD VSS sg13g2_decap_8
XFILLER_148_1165 VDD VSS sg13g2_fill_1
Xclkbuf_leaf_121_clk_i clkload6/A clkbuf_5_2__f_clk_i/X VDD VSS sg13g2_buf_8
X_11670_ _11671_/A _14696_/Q _14728_/Q _13768_/Q _13800_/Q _11670_/S0 _11686_/S1 VDD
+ VSS sg13g2_mux4_1
XFILLER_42_757 VDD VSS sg13g2_fill_1
XFILLER_41_256 VDD VSS sg13g2_decap_8
X_10621_ _10632_/D _14882_/Q _10651_/D _10625_/D VDD VSS sg13g2_and3_1
XFILLER_23_993 VDD VSS sg13g2_decap_8
XFILLER_22_470 VDD VSS sg13g2_decap_8
X_13340_ _15174_/D input31/X _15174_/Q _13340_/S VDD VSS sg13g2_mux2_1
X_10552_ _10554_/A _14865_/Q _10556_/D _14866_/Q VDD VSS sg13g2_a21o_1
XFILLER_128_829 VDD VSS sg13g2_decap_8
XFILLER_6_614 VDD VSS sg13g2_fill_2
X_13271_ _13271_/Y _13269_/Y _13271_/B _13271_/C VDD VSS sg13g2_nand3b_1
XFILLER_108_520 VDD VSS sg13g2_decap_8
X_10483_ _10487_/B _13084_/A _10489_/D _14849_/Q VDD VSS sg13g2_a21oi_1
XFILLER_154_147 VDD VSS sg13g2_decap_8
X_15010_ _15010_/Q clkload41/A _15010_/D _15010_/RESET_B VDD VSS sg13g2_dfrbpq_1
X_12222_ _12223_/C _12174_/A _12219_/X _12221_/Y VDD VSS sg13g2_a21oi_1
XFILLER_108_553 VDD VSS sg13g2_fill_1
XFILLER_108_564 VDD VSS sg13g2_decap_4
XFILLER_120_1095 VDD VSS sg13g2_fill_2
X_12153_ _12198_/D _12151_/Y _12153_/B VDD VSS sg13g2_nand2b_1
X_11104_ _11104_/Y _11085_/Y _11095_/A _11118_/D VDD VSS sg13g2_o21ai_1
XFILLER_111_707 VDD VSS sg13g2_fill_2
XFILLER_151_887 VDD VSS sg13g2_decap_8
XFILLER_1_352 VDD VSS sg13g2_fill_1
X_12084_ _12197_/B _12084_/A _13668_/Q VDD VSS sg13g2_xnor2_1
XFILLER_1_374 VDD VSS sg13g2_fill_2
X_11035_ _11035_/Y _11023_/A _11052_/A _11034_/Y VDD VSS sg13g2_a21oi_1
XFILLER_134_70 VDD VSS sg13g2_decap_8
XFILLER_134_81 VDD VSS sg13g2_fill_2
XFILLER_40_1041 VDD VSS sg13g2_decap_8
XFILLER_92_635 VDD VSS sg13g2_decap_8
XFILLER_131_1180 VDD VSS sg13g2_decap_8
XFILLER_18_754 VDD VSS sg13g2_decap_8
X_12986_ _13058_/D _14906_/Q _13681_/Q VDD VSS sg13g2_xor2_1
X_13806__2758 _13806_/RESET_B VDD VSS sg13g2_tiehi
X_14566__1998 _14566_/RESET_B VDD VSS sg13g2_tiehi
XFILLER_17_253 VDD VSS sg13g2_decap_8
XFILLER_73_871 VDD VSS sg13g2_decap_4
XFILLER_18_787 VDD VSS sg13g2_fill_2
X_14725_ _14725_/Q _14725_/CLK _14725_/D _14725_/RESET_B VDD VSS sg13g2_dfrbpq_1
X_11937_ _11937_/Y _11914_/A _13673_/Q _11916_/Y VDD VSS sg13g2_a21oi_1
XFILLER_32_201 VDD VSS sg13g2_decap_8
XFILLER_17_286 VDD VSS sg13g2_decap_4
XFILLER_150_91 VDD VSS sg13g2_decap_8
XFILLER_32_223 VDD VSS sg13g2_decap_8
X_14656_ _14656_/Q _14710_/CLK _14656_/D _14656_/RESET_B VDD VSS sg13g2_dfrbpq_1
XFILLER_33_768 VDD VSS sg13g2_fill_1
X_11868_ _11868_/Y _11868_/A _11868_/B _11868_/C VDD VSS sg13g2_nand3_1
XFILLER_60_554 VDD VSS sg13g2_decap_4
X_13607_ _15166_/D _13606_/Y _10173_/B _13605_/Y VDD VSS sg13g2_a21oi_1
X_10819_ _10821_/B _10844_/B _15122_/Q VDD VSS sg13g2_nand2_1
XFILLER_32_289 VDD VSS sg13g2_decap_8
X_14587_ _14587_/Q clkload75/A _14587_/D _14587_/RESET_B VDD VSS sg13g2_dfrbpq_1
XFILLER_14_993 VDD VSS sg13g2_decap_8
X_11799_ _11800_/B _11770_/A _13064_/B _11779_/Y VDD VSS sg13g2_a21oi_1
XFILLER_119_818 VDD VSS sg13g2_fill_1
X_13538_ _13538_/Y _14994_/Q _12936_/B _15002_/Q _13546_/B2 VDD VSS sg13g2_a22oi_1
XFILLER_146_637 VDD VSS sg13g2_fill_2
XFILLER_51_1181 VDD VSS sg13g2_decap_8
X_13469_ _13469_/X _13600_/C _13507_/B _13469_/C wire741/X VDD VSS sg13g2_and4_1
XFILLER_12_1165 VDD VSS sg13g2_decap_8
X_15208_ _15208_/Q _15209_/CLK _15208_/D _15208_/RESET_B VDD VSS sg13g2_dfrbpq_1
XFILLER_154_670 VDD VSS sg13g2_decap_8
XFILLER_127_884 VDD VSS sg13g2_decap_4
XFILLER_114_512 VDD VSS sg13g2_decap_8
X_14401__2163 _14401_/RESET_B VDD VSS sg13g2_tiehi
X_15139_ _15139_/Q clkload27/A _15139_/D _15139_/RESET_B VDD VSS sg13g2_dfrbpq_1
XFILLER_142_865 VDD VSS sg13g2_decap_8
X_07961_ _08577_/B _07961_/A _07961_/B VDD VSS sg13g2_nand2_1
XFILLER_87_418 VDD VSS sg13g2_decap_8
X_09700_ _14292_/D _09898_/A0 _14292_/Q wire456/A VDD VSS sg13g2_mux2_1
XFILLER_96_930 VDD VSS sg13g2_fill_2
XFILLER_136_1091 VDD VSS sg13g2_fill_1
X_07892_ _08160_/B _08200_/A _07893_/B VDD VSS sg13g2_nor2b_1
X_09631_ _14227_/D _10062_/A0 _14227_/Q _09631_/S VDD VSS sg13g2_mux2_1
XFILLER_95_473 VDD VSS sg13g2_fill_2
XFILLER_68_698 VDD VSS sg13g2_fill_2
XFILLER_55_337 VDD VSS sg13g2_decap_8
XFILLER_110_1220 VDD VSS sg13g2_decap_8
X_09562_ _14160_/D _09562_/A0 _14160_/Q _09564_/S VDD VSS sg13g2_mux2_1
XFILLER_82_145 VDD VSS sg13g2_fill_1
XFILLER_82_156 VDD VSS sg13g2_decap_8
X_08513_ _08517_/C _08560_/A _08511_/X _08512_/Y VDD VSS sg13g2_o21ai_1
X_09493_ _14093_/D _10089_/A0 _14093_/Q wire480/X VDD VSS sg13g2_mux2_1
XFILLER_36_573 VDD VSS sg13g2_decap_8
XFILLER_130_28 VDD VSS sg13g2_decap_8
XFILLER_23_212 VDD VSS sg13g2_decap_8
XFILLER_1_1090 VDD VSS sg13g2_decap_8
X_08444_ _08444_/Y _08574_/A _08574_/B VDD VSS sg13g2_nand2_1
XFILLER_23_234 VDD VSS sg13g2_decap_8
XFILLER_56_1070 VDD VSS sg13g2_decap_8
XFILLER_11_429 VDD VSS sg13g2_decap_8
X_08375_ _08375_/Y _08599_/A _08223_/X _08397_/A VDD VSS sg13g2_o21ai_1
Xclkbuf_leaf_53_clk_i clkload61/A clkbuf_leaf_87_clk_i/A VDD VSS sg13g2_buf_8
XFILLER_143_1040 VDD VSS sg13g2_fill_1
XFILLER_17_1043 VDD VSS sg13g2_decap_8
X_15048__2914 _15048_/RESET_B VDD VSS sg13g2_tiehi
X_14611__1953 _14611_/RESET_B VDD VSS sg13g2_tiehi
XFILLER_104_1013 VDD VSS sg13g2_decap_8
XFILLER_143_1073 VDD VSS sg13g2_fill_2
XFILLER_20_974 VDD VSS sg13g2_decap_8
XFILLER_30_1221 VDD VSS sg13g2_decap_8
XFILLER_118_840 VDD VSS sg13g2_decap_8
Xclkbuf_leaf_68_clk_i clkload81/A clkbuf_leaf_71_clk_i/A VDD VSS sg13g2_buf_8
XFILLER_155_14 VDD VSS sg13g2_decap_8
XFILLER_2_105 VDD VSS sg13g2_decap_8
XFILLER_3_7 VDD VSS sg13g2_decap_8
XFILLER_132_353 VDD VSS sg13g2_decap_4
Xfanout1407 _12278_/A _14987_/Q VDD VSS sg13g2_buf_1
XFILLER_132_386 VDD VSS sg13g2_decap_8
XFILLER_28_1150 VDD VSS sg13g2_decap_8
Xfanout1418 _08635_/A2 _12128_/A VDD VSS sg13g2_buf_1
XFILLER_59_610 VDD VSS sg13g2_fill_1
XFILLER_63_1041 VDD VSS sg13g2_fill_1
Xfanout1429 _07812_/B _11983_/A VDD VSS sg13g2_buf_1
XFILLER_63_1063 VDD VSS sg13g2_fill_2
Xfanout453 _09739_/S _09727_/S VDD VSS sg13g2_buf_1
Xfanout475 _09490_/S wire482/X VDD VSS sg13g2_buf_1
XFILLER_24_1036 VDD VSS sg13g2_decap_8
XFILLER_58_142 VDD VSS sg13g2_fill_1
XFILLER_150_1044 VDD VSS sg13g2_fill_1
Xfanout486 fanout486/X _09307_/X VDD VSS sg13g2_buf_1
XFILLER_58_153 VDD VSS sg13g2_decap_8
XFILLER_100_250 VDD VSS sg13g2_fill_1
XFILLER_101_784 VDD VSS sg13g2_decap_4
Xfanout497 _09279_/S _09297_/S VDD VSS sg13g2_buf_1
X_09829_ _14417_/D _09928_/A1 _14417_/Q _09829_/S VDD VSS sg13g2_mux2_1
Xwire1557 _16868_/A _13706_/Q VDD VSS sg13g2_buf_8
XFILLER_74_624 VDD VSS sg13g2_decap_8
XFILLER_46_326 VDD VSS sg13g2_fill_2
XFILLER_58_186 VDD VSS sg13g2_decap_8
XFILLER_73_112 VDD VSS sg13g2_fill_1
Xwire1568 _16857_/A _13695_/Q VDD VSS sg13g2_buf_8
XFILLER_111_1028 VDD VSS sg13g2_fill_1
X_12840_ _15023_/D _13319_/A _12840_/B VDD VSS sg13g2_nor2_1
XFILLER_104_84 VDD VSS sg13g2_decap_8
XFILLER_61_307 VDD VSS sg13g2_decap_8
X_12771_ _12771_/X _13977_/Q _14009_/Q _14041_/Q _14073_/Q _12771_/S0 _12771_/S1 VDD
+ VSS sg13g2_mux4_1
XFILLER_70_830 VDD VSS sg13g2_decap_8
X_11722_ _11722_/Y _11721_/Y wire302/X _11707_/Y _12269_/A2 _12126_/A VDD VSS sg13g2_a221oi_1
X_14510_ _14510_/Q _15188_/CLK _14510_/D _14510_/RESET_B VDD VSS sg13g2_dfrbpq_1
XFILLER_14_234 VDD VSS sg13g2_decap_8
XFILLER_9_28 VDD VSS sg13g2_decap_8
XFILLER_147_0 VDD VSS sg13g2_decap_8
X_14441_ _14441_/Q _14633_/CLK _14441_/D _14441_/RESET_B VDD VSS sg13g2_dfrbpq_1
XFILLER_35_1121 VDD VSS sg13g2_decap_8
X_11653_ _11653_/X _11646_/X _11647_/X _11650_/X _11651_/X _11928_/S0 _12076_/S1 VDD
+ VSS sg13g2_mux4_1
XFILLER_80_21 VDD VSS sg13g2_decap_8
X_10604_ _10613_/A _14878_/Q _14877_/Q _10610_/D VDD VSS sg13g2_nand3_1
X_14372_ _14372_/Q _15001_/CLK _14372_/D _14372_/RESET_B VDD VSS sg13g2_dfrbpq_1
Xwire810 wire810/X wire810/A VDD VSS sg13g2_buf_2
X_11584_ _11584_/Y _12223_/A _11584_/B VDD VSS sg13g2_nor2_1
XFILLER_156_935 VDD VSS sg13g2_fill_1
XFILLER_10_440 VDD VSS sg13g2_decap_4
XFILLER_35_1187 VDD VSS sg13g2_decap_8
X_13323_ _13324_/B _15112_/Q wire810/X _13309_/Y _09806_/A VDD VSS sg13g2_a22oi_1
XFILLER_13_70 VDD VSS sg13g2_decap_8
X_10535_ _14860_/D _10535_/A _10535_/B _13363_/B VDD VSS sg13g2_and3_1
XFILLER_6_433 VDD VSS sg13g2_decap_8
Xmax_cap609 _10002_/S _09976_/S VDD VSS sg13g2_buf_4
XFILLER_155_467 VDD VSS sg13g2_decap_8
X_13254_ _15050_/D _13247_/Y wire206/X _13239_/A VDD VSS sg13g2_a21oi_1
X_10466_ _10509_/B _10511_/C _10511_/D VDD VSS sg13g2_nand2_1
XFILLER_124_810 VDD VSS sg13g2_fill_2
XFILLER_108_361 VDD VSS sg13g2_fill_1
XFILLER_6_488 VDD VSS sg13g2_decap_8
XFILLER_108_372 VDD VSS sg13g2_decap_8
X_12205_ _12205_/X _14263_/Q _14295_/Q _14327_/Q _14359_/Q _12206_/S0 _12091_/C VDD
+ VSS sg13g2_mux4_1
X_13185_ _13225_/B _14919_/Q _13668_/Q VDD VSS sg13g2_xor2_1
X_10397_ _10401_/A _10400_/A _10397_/B _10397_/C VDD VSS sg13g2_nor3_1
X_12136_ _12136_/X _14709_/Q _14741_/Q _13781_/Q _13813_/Q _12287_/S0 _12287_/S1 VDD
+ VSS sg13g2_mux4_1
XFILLER_36_7 VDD VSS sg13g2_decap_8
XFILLER_123_375 VDD VSS sg13g2_decap_8
XFILLER_97_749 VDD VSS sg13g2_fill_2
XFILLER_123_386 VDD VSS sg13g2_fill_2
X_12067_ _12067_/X _13971_/Q _14003_/Q _14035_/Q _14067_/Q _12067_/S0 _12067_/S1 VDD
+ VSS sg13g2_mux4_1
XFILLER_42_1125 VDD VSS sg13g2_decap_8
XFILLER_42_1147 VDD VSS sg13g2_decap_8
X_11018_ _11018_/Y _11022_/B _11014_/Y _11017_/Y VDD VSS sg13g2_a21oi_1
X_16875_ _16875_/X _16875_/A VDD VSS sg13g2_buf_1
XFILLER_65_624 VDD VSS sg13g2_decap_8
XFILLER_64_112 VDD VSS sg13g2_decap_8
XFILLER_49_197 VDD VSS sg13g2_decap_4
XFILLER_53_819 VDD VSS sg13g2_decap_8
XFILLER_46_871 VDD VSS sg13g2_decap_8
XFILLER_92_476 VDD VSS sg13g2_decap_4
XFILLER_18_573 VDD VSS sg13g2_decap_8
XFILLER_64_178 VDD VSS sg13g2_decap_8
XFILLER_79_1081 VDD VSS sg13g2_fill_2
X_12969_ _12969_/Y _12967_/Y _12968_/Y _12933_/Y VDD VSS sg13g2_o21ai_1
XFILLER_73_690 VDD VSS sg13g2_decap_8
XFILLER_127_1002 VDD VSS sg13g2_decap_8
X_14708_ _14708_/Q clkload8/A _14708_/D _14708_/RESET_B VDD VSS sg13g2_dfrbpq_1
X_14419__2145 _14419_/RESET_B VDD VSS sg13g2_tiehi
X_14639_ _14639_/Q _14671_/CLK _14639_/D _14639_/RESET_B VDD VSS sg13g2_dfrbpq_1
X_08160_ _08160_/Y _08649_/S _08160_/B _08160_/C VDD VSS sg13g2_nor3_1
XFILLER_119_626 VDD VSS sg13g2_fill_1
XFILLER_146_412 VDD VSS sg13g2_decap_8
X_08091_ _08091_/Y _08074_/B _08088_/Y _08090_/Y VDD VSS sg13g2_a21oi_1
XFILLER_101_1219 VDD VSS sg13g2_decap_8
XFILLER_109_18 VDD VSS sg13g2_fill_1
Xclkload30 clkload30/Y clkload30/A VDD VSS sg13g2_inv_1
XFILLER_62_0 VDD VSS sg13g2_decap_8
Xclkload41 clkload41/Y clkload41/A VDD VSS sg13g2_inv_8
XFILLER_118_169 VDD VSS sg13g2_decap_8
Xclkload52 clkload52/Y clkload52/A VDD VSS sg13g2_inv_1
XFILLER_155_990 VDD VSS sg13g2_fill_1
Xclkload63 clkload63/Y clkload63/A VDD VSS sg13g2_inv_2
XFILLER_127_692 VDD VSS sg13g2_fill_1
Xclkload74 clkload74/Y clkload74/A VDD VSS sg13g2_inv_1
XFILLER_115_854 VDD VSS sg13g2_decap_8
Xhold3504 _11001_/A _14942_/Q VDD VSS sg13g2_dlygate4sd3_1
XFILLER_88_705 VDD VSS sg13g2_decap_4
XFILLER_47_1036 VDD VSS sg13g2_fill_1
XFILLER_86_1085 VDD VSS sg13g2_decap_4
Xhold3515 _11048_/A _14945_/Q VDD VSS sg13g2_dlygate4sd3_1
XFILLER_142_673 VDD VSS sg13g2_decap_8
Xhold3526 _13575_/A _15157_/Q VDD VSS sg13g2_dlygate4sd3_1
X_08993_ _08993_/X _14899_/Q _12859_/A _10681_/A _10674_/A VDD VSS sg13g2_and4_1
XFILLER_47_1069 VDD VSS sg13g2_decap_8
XFILLER_141_172 VDD VSS sg13g2_decap_8
XFILLER_102_548 VDD VSS sg13g2_decap_8
X_07944_ _07961_/A _07942_/A _07928_/Y _07906_/B VDD VSS sg13g2_o21ai_1
XFILLER_68_451 VDD VSS sg13g2_fill_1
XFILLER_84_900 VDD VSS sg13g2_fill_2
XFILLER_28_315 VDD VSS sg13g2_fill_2
X_07875_ _07905_/A _07876_/A _07876_/B VDD VSS sg13g2_and2_1
XFILLER_84_944 VDD VSS sg13g2_decap_8
X_14629__1935 _14629_/RESET_B VDD VSS sg13g2_tiehi
XFILLER_83_432 VDD VSS sg13g2_decap_8
X_09614_ _14210_/D _09880_/A0 _14210_/Q _09635_/S VDD VSS sg13g2_mux2_1
XFILLER_141_49 VDD VSS sg13g2_decap_8
X_14811__3287 _14811_/RESET_B VDD VSS sg13g2_tiehi
XFILLER_23_1091 VDD VSS sg13g2_decap_8
XFILLER_83_465 VDD VSS sg13g2_decap_8
XFILLER_55_167 VDD VSS sg13g2_decap_4
X_09545_ _14143_/D _09646_/A0 _14143_/Q _09571_/S VDD VSS sg13g2_mux2_1
XFILLER_3_1174 VDD VSS sg13g2_decap_8
XFILLER_58_1110 VDD VSS sg13g2_fill_1
XFILLER_36_370 VDD VSS sg13g2_decap_8
XFILLER_34_14 VDD VSS sg13g2_decap_8
X_13893__2671 _13893_/RESET_B VDD VSS sg13g2_tiehi
XFILLER_58_1143 VDD VSS sg13g2_fill_1
X_09476_ _14076_/D _10039_/A0 _14076_/Q wire480/A VDD VSS sg13g2_mux2_1
XFILLER_54_1007 VDD VSS sg13g2_fill_1
XFILLER_34_69 VDD VSS sg13g2_decap_8
XFILLER_19_1149 VDD VSS sg13g2_decap_8
X_08427_ _08427_/X _07794_/A _08427_/A1 _07798_/B _07825_/B _08427_/S0 _13553_/A1
+ VDD VSS sg13g2_mux4_1
XFILLER_58_1198 VDD VSS sg13g2_decap_8
XFILLER_140_7 VDD VSS sg13g2_decap_8
XFILLER_93_1089 VDD VSS sg13g2_decap_8
XFILLER_145_1179 VDD VSS sg13g2_fill_2
XFILLER_8_709 VDD VSS sg13g2_decap_8
X_08358_ _08358_/Y _08412_/A _08275_/B _08357_/Y VDD VSS sg13g2_o21ai_1
Xclkload2 clkload2/Y clkload2/A VDD VSS sg13g2_inv_1
XFILLER_149_272 VDD VSS sg13g2_decap_8
X_14273__2291 _14273_/RESET_B VDD VSS sg13g2_tiehi
XFILLER_137_434 VDD VSS sg13g2_fill_1
XFILLER_109_125 VDD VSS sg13g2_fill_1
X_08289_ _08289_/Y _08265_/X _08315_/C _08315_/A VDD VSS sg13g2_a21oi_1
XFILLER_153_916 VDD VSS sg13g2_decap_8
XFILLER_50_68 VDD VSS sg13g2_decap_8
X_10320_ _10322_/A _14799_/Q _10405_/C _14800_/Q VDD VSS sg13g2_a21o_1
XFILLER_30_1051 VDD VSS sg13g2_decap_8
XFILLER_30_1073 VDD VSS sg13g2_fill_2
XFILLER_106_821 VDD VSS sg13g2_decap_8
XFILLER_3_414 VDD VSS sg13g2_decap_8
X_10251_ _14778_/D _10251_/A _10258_/D VDD VSS sg13g2_nor2_1
XFILLER_30_1095 VDD VSS sg13g2_fill_2
XFILLER_117_180 VDD VSS sg13g2_decap_8
XFILLER_133_640 VDD VSS sg13g2_decap_8
XFILLER_156_1231 VDD VSS sg13g2_decap_4
XFILLER_117_191 VDD VSS sg13g2_fill_2
XFILLER_133_673 VDD VSS sg13g2_decap_8
XFILLER_78_204 VDD VSS sg13g2_decap_8
X_10182_ _10182_/Y _10182_/A _13613_/C VDD VSS sg13g2_nand2_1
Xfanout1204 _12381_/S0 fanout1205/X VDD VSS sg13g2_buf_1
Xfanout1215 _12782_/S0 _15210_/Q VDD VSS sg13g2_buf_1
Xfanout1226 _13160_/B _13309_/A2 VDD VSS sg13g2_buf_1
Xfanout1237 _13308_/B _10670_/A VDD VSS sg13g2_buf_1
XFILLER_120_345 VDD VSS sg13g2_decap_4
XFILLER_8_1041 VDD VSS sg13g2_decap_8
X_14990_ _14990_/Q _15200_/CLK _14990_/D _14990_/RESET_B VDD VSS sg13g2_dfrbpq_1
Xfanout250 _09922_/A1 _09691_/A0 VDD VSS sg13g2_buf_1
Xfanout1248 _13448_/B _15200_/Q VDD VSS sg13g2_buf_1
Xfanout261 _09888_/A0 _09921_/A1 VDD VSS sg13g2_buf_1
Xfanout1259 _13506_/A _15128_/Q VDD VSS sg13g2_buf_1
Xfanout272 _12126_/A _12147_/B1 VDD VSS sg13g2_buf_1
Xfanout283 _09655_/A0 _10151_/A1 VDD VSS sg13g2_buf_1
X_13941_ _13941_/Q clkload14/A _13941_/D _13941_/RESET_B VDD VSS sg13g2_dfrbpq_1
XFILLER_59_484 VDD VSS sg13g2_fill_2
Xfanout294 _09653_/A0 _09884_/A0 VDD VSS sg13g2_buf_1
XFILLER_47_668 VDD VSS sg13g2_decap_8
Xwire1387 wire1387/X wire1387/A VDD VSS sg13g2_buf_4
XFILLER_75_76 VDD VSS sg13g2_decap_8
X_13872_ _13872_/Q clkload42/A _13872_/D _13872_/RESET_B VDD VSS sg13g2_dfrbpq_1
XFILLER_28_860 VDD VSS sg13g2_decap_8
XFILLER_74_476 VDD VSS sg13g2_decap_8
XFILLER_90_925 VDD VSS sg13g2_decap_8
XFILLER_90_936 VDD VSS sg13g2_fill_1
XFILLER_76_1210 VDD VSS sg13g2_decap_8
X_12823_ _12824_/B _12808_/A _12822_/X _12816_/Y _13048_/B _12820_/Y VDD VSS sg13g2_a221oi_1
XFILLER_61_137 VDD VSS sg13g2_fill_1
X_13723__2841 _13723_/RESET_B VDD VSS sg13g2_tiehi
XFILLER_91_20 VDD VSS sg13g2_fill_1
X_12754_ _12754_/X _14392_/Q _14424_/Q _14488_/Q _14520_/Q _12754_/S0 _12754_/S1 VDD
+ VSS sg13g2_mux4_1
XFILLER_37_1216 VDD VSS sg13g2_decap_8
X_15173__3334 _15173_/RESET_B VDD VSS sg13g2_tiehi
XFILLER_72_1107 VDD VSS sg13g2_fill_1
XFILLER_70_660 VDD VSS sg13g2_decap_8
XFILLER_42_373 VDD VSS sg13g2_fill_2
X_11705_ _11705_/Y _11706_/A _13679_/Q VDD VSS sg13g2_nand2_1
X_12685_ _12685_/X _13971_/Q _14003_/Q _14035_/Q _14067_/Q _12685_/S0 _12685_/S1 VDD
+ VSS sg13g2_mux4_1
X_14424_ _14424_/Q _14506_/CLK _14424_/D _14424_/RESET_B VDD VSS sg13g2_dfrbpq_1
X_11636_ _11637_/B _11636_/A _11636_/B _11636_/C VDD VSS sg13g2_nand3_1
XFILLER_156_710 VDD VSS sg13g2_fill_2
XFILLER_24_91 VDD VSS sg13g2_decap_8
XFILLER_126_1090 VDD VSS sg13g2_decap_4
XFILLER_156_732 VDD VSS sg13g2_fill_1
X_14103__2461 _14103_/RESET_B VDD VSS sg13g2_tiehi
XFILLER_129_957 VDD VSS sg13g2_fill_1
X_11567_ _11638_/B _11502_/A _13685_/Q _12942_/B _11526_/A VDD VSS sg13g2_a22oi_1
X_14355_ _14355_/Q clkload12/A _14355_/D _14355_/RESET_B VDD VSS sg13g2_dfrbpq_1
Xwire651 wire651/X wire651/A VDD VSS sg13g2_buf_8
XFILLER_10_292 VDD VSS sg13g2_fill_2
Xmax_cap406 _10093_/S _10090_/S VDD VSS sg13g2_buf_4
X_13306_ _15059_/D _13306_/A wire810/A _13306_/C VDD VSS sg13g2_nor3_1
X_10518_ _10519_/C _14855_/Q _10579_/B VDD VSS sg13g2_and2_1
XFILLER_7_786 VDD VSS sg13g2_decap_8
X_14286_ _14286_/Q clkload57/A _14286_/D _14286_/RESET_B VDD VSS sg13g2_dfrbpq_1
XFILLER_128_489 VDD VSS sg13g2_decap_8
X_11498_ wire305/A _12191_/B1 _11496_/X _11497_/Y VDD VSS sg13g2_o21ai_1
X_14707__1857 _14707_/RESET_B VDD VSS sg13g2_tiehi
X_13237_ _13237_/Y _13234_/Y _13235_/Y _13236_/Y VDD VSS sg13g2_a21oi_1
X_10449_ _10450_/C _10670_/A _14839_/Q _10510_/B wire760/X VDD VSS sg13g2_and4_1
X_13168_ _13225_/A _13168_/A _13189_/B VDD VSS sg13g2_xor2_1
XFILLER_123_150 VDD VSS sg13g2_fill_2
X_14904__3121 _14904_/RESET_B VDD VSS sg13g2_tiehi
XFILLER_124_684 VDD VSS sg13g2_decap_4
XFILLER_3_992 VDD VSS sg13g2_fill_2
X_13971__2593 _13971_/RESET_B VDD VSS sg13g2_tiehi
X_12119_ _12119_/Y _12099_/Y _12101_/X _12192_/A VDD VSS sg13g2_o21ai_1
X_13099_ _13099_/Y _13222_/A1 _13098_/X _13097_/Y VDD VSS sg13g2_a21oi_1
XFILLER_46_1080 VDD VSS sg13g2_decap_8
Xfanout1760 _13306_/A _13353_/A VDD VSS sg13g2_buf_1
XFILLER_65_410 VDD VSS sg13g2_decap_4
Xfanout1782 _13600_/C fanout1795/X VDD VSS sg13g2_buf_1
XFILLER_38_646 VDD VSS sg13g2_decap_8
Xfanout1793 _10626_/B fanout1794/X VDD VSS sg13g2_buf_1
XFILLER_65_443 VDD VSS sg13g2_decap_4
X_07660_ wire807/A wire955/X _14749_/Q VDD VSS sg13g2_nand2b_1
X_16858_ _16858_/X _16858_/A VDD VSS sg13g2_buf_1
X_14937__3055 _14937_/RESET_B VDD VSS sg13g2_tiehi
XFILLER_81_903 VDD VSS sg13g2_decap_8
XFILLER_66_999 VDD VSS sg13g2_decap_4
XFILLER_1_84 VDD VSS sg13g2_decap_8
XFILLER_19_882 VDD VSS sg13g2_decap_8
XFILLER_92_273 VDD VSS sg13g2_decap_8
XFILLER_129_1108 VDD VSS sg13g2_fill_2
X_09330_ _13937_/D _09928_/A1 _13937_/Q _09330_/S VDD VSS sg13g2_mux2_1
XFILLER_80_479 VDD VSS sg13g2_fill_1
X_09261_ _13870_/D _13870_/Q _10157_/A1 _09261_/S VDD VSS sg13g2_mux2_1
XFILLER_21_513 VDD VSS sg13g2_fill_1
XFILLER_21_524 VDD VSS sg13g2_fill_2
X_08212_ _08212_/X _08270_/B _08688_/D _08688_/A VDD VSS sg13g2_and3_1
XFILLER_53_1040 VDD VSS sg13g2_decap_8
X_09192_ _13808_/D _13808_/Q _10159_/A1 _09201_/S VDD VSS sg13g2_mux2_1
XFILLER_53_1062 VDD VSS sg13g2_decap_8
X_08143_ _08143_/Y _08182_/B _08141_/Y _08142_/Y VDD VSS sg13g2_o21ai_1
XFILLER_14_1057 VDD VSS sg13g2_decap_8
X_15115__3114 _15115_/RESET_B VDD VSS sg13g2_tiehi
X_08074_ _08074_/X _08548_/A _08074_/B _08074_/C VDD VSS sg13g2_and3_1
XFILLER_88_1147 VDD VSS sg13g2_decap_8
XFILLER_88_1158 VDD VSS sg13g2_fill_1
XFILLER_20_49 VDD VSS sg13g2_decap_8
X_14829__3269 _14829_/RESET_B VDD VSS sg13g2_tiehi
XFILLER_143_960 VDD VSS sg13g2_decap_8
XFILLER_136_49 VDD VSS sg13g2_decap_8
XFILLER_0_406 VDD VSS sg13g2_decap_4
XFILLER_102_312 VDD VSS sg13g2_decap_8
XFILLER_29_14 VDD VSS sg13g2_decap_8
X_13801__2763 _13801_/RESET_B VDD VSS sg13g2_tiehi
X_08976_ _08977_/B _10675_/B _10675_/C VDD VSS sg13g2_nor2_1
XFILLER_69_771 VDD VSS sg13g2_fill_2
X_07927_ _07927_/Y _07922_/Y _07904_/A _07926_/X VDD VSS sg13g2_a21oi_1
XFILLER_151_1161 VDD VSS sg13g2_decap_8
XFILLER_5_1236 VDD VSS sg13g2_fill_1
XFILLER_69_793 VDD VSS sg13g2_decap_8
XFILLER_84_730 VDD VSS sg13g2_decap_8
XFILLER_111_890 VDD VSS sg13g2_decap_4
XFILLER_25_1186 VDD VSS sg13g2_decap_8
X_07858_ _07858_/X _15014_/Q _07859_/B VDD VSS sg13g2_and2_1
X_14145__2419 _14145_/RESET_B VDD VSS sg13g2_tiehi
XFILLER_57_977 VDD VSS sg13g2_decap_4
XFILLER_112_1167 VDD VSS sg13g2_decap_4
XFILLER_43_104 VDD VSS sg13g2_decap_8
X_07789_ _08391_/B _07790_/A _15003_/Q VDD VSS sg13g2_nor2_1
XFILLER_72_958 VDD VSS sg13g2_decap_8
XFILLER_83_284 VDD VSS sg13g2_decap_8
XFILLER_25_841 VDD VSS sg13g2_fill_2
XFILLER_71_446 VDD VSS sg13g2_fill_1
X_09528_ _14127_/D _09992_/A0 _14127_/Q _09533_/S VDD VSS sg13g2_mux2_1
XFILLER_24_362 VDD VSS sg13g2_fill_1
XFILLER_80_980 VDD VSS sg13g2_fill_1
X_09459_ _14060_/D _09956_/A1 _14060_/Q _09472_/S VDD VSS sg13g2_mux2_1
X_14360__2204 _14360_/RESET_B VDD VSS sg13g2_tiehi
XFILLER_12_546 VDD VSS sg13g2_fill_1
XFILLER_12_557 VDD VSS sg13g2_fill_2
X_12470_ _12471_/B _13685_/Q _12763_/A2 _12469_/X _12763_/B2 _12498_/C1 VDD VSS sg13g2_a221oi_1
XFILLER_71_1162 VDD VSS sg13g2_fill_2
XFILLER_61_78 VDD VSS sg13g2_decap_8
X_11421_ _11422_/A _13951_/Q _13983_/Q _14015_/Q _14047_/Q _11992_/S0 _11997_/S1 VDD
+ VSS sg13g2_mux4_1
XFILLER_153_702 VDD VSS sg13g2_decap_8
X_14140_ _14140_/Q clkload75/A _14140_/D _14140_/RESET_B VDD VSS sg13g2_dfrbpq_1
XFILLER_153_713 VDD VSS sg13g2_fill_2
X_11352_ _11361_/B _11346_/Y _11351_/Y _11224_/A VDD VSS sg13g2_o21ai_1
XFILLER_125_426 VDD VSS sg13g2_fill_2
X_10303_ _10306_/C _14794_/Q _10299_/Y hold3517/X VDD VSS sg13g2_a21oi_1
X_14071_ _14071_/Q _14505_/CLK _14071_/D _14071_/RESET_B VDD VSS sg13g2_dfrbpq_1
X_11283_ _11283_/Y _11283_/A _11283_/B VDD VSS sg13g2_nand2_1
XFILLER_3_233 VDD VSS sg13g2_decap_8
XFILLER_152_267 VDD VSS sg13g2_decap_4
X_13022_ _13042_/A _14908_/Q _13679_/Q VDD VSS sg13g2_nand2_1
XFILLER_106_662 VDD VSS sg13g2_decap_8
XFILLER_106_673 VDD VSS sg13g2_fill_1
X_10234_ _10234_/Y _14771_/Q _14772_/Q _14773_/Q _10234_/D VDD VSS sg13g2_nand4_1
XFILLER_156_1050 VDD VSS sg13g2_fill_2
XFILLER_152_289 VDD VSS sg13g2_decap_8
XFILLER_134_993 VDD VSS sg13g2_decap_8
Xfanout1001 _11045_/A2 _10886_/A2 VDD VSS sg13g2_buf_1
Xfanout1012 _08538_/S _08511_/S VDD VSS sg13g2_buf_1
X_10165_ _14742_/D _14742_/Q _10165_/A1 _10166_/S VDD VSS sg13g2_mux2_1
Xfanout1023 _08617_/A _08544_/C VDD VSS sg13g2_buf_1
Xfanout1034 _08063_/A _13550_/A1 VDD VSS sg13g2_buf_1
Xfanout1045 _10797_/C _08724_/B VDD VSS sg13g2_buf_1
XFILLER_117_1078 VDD VSS sg13g2_decap_8
Xfanout1056 _12762_/S _15214_/Q VDD VSS sg13g2_buf_1
XFILLER_48_933 VDD VSS sg13g2_fill_1
X_10096_ _14676_/D _10096_/A0 _14676_/Q _10096_/S VDD VSS sg13g2_mux2_1
X_14973_ _14973_/Q _15040_/CLK _14973_/D _14973_/RESET_B VDD VSS sg13g2_dfrbpq_1
Xfanout1078 _12747_/S1 _12733_/S0 VDD VSS sg13g2_buf_1
XFILLER_75_730 VDD VSS sg13g2_decap_8
Xfanout1089 wire1090/A _12593_/S0 VDD VSS sg13g2_buf_1
XFILLER_48_955 VDD VSS sg13g2_decap_8
X_13924_ _13924_/Q _15160_/CLK _13924_/D _13924_/RESET_B VDD VSS sg13g2_dfrbpq_1
XFILLER_19_134 VDD VSS sg13g2_decap_8
XFILLER_47_443 VDD VSS sg13g2_decap_4
XFILLER_19_91 VDD VSS sg13g2_decap_4
XFILLER_63_914 VDD VSS sg13g2_decap_8
XFILLER_142_70 VDD VSS sg13g2_decap_8
XFILLER_75_785 VDD VSS sg13g2_decap_4
XFILLER_90_722 VDD VSS sg13g2_fill_2
X_13855_ _13855_/Q clkload52/A _13855_/D _13855_/RESET_B VDD VSS sg13g2_dfrbpq_1
XFILLER_62_435 VDD VSS sg13g2_fill_1
XFILLER_34_137 VDD VSS sg13g2_decap_8
XFILLER_62_457 VDD VSS sg13g2_fill_2
X_12806_ _12806_/Y _14863_/Q _12862_/B VDD VSS sg13g2_nand2_1
X_10998_ _10998_/Y _11099_/B2 _10992_/X _10997_/Y VDD VSS sg13g2_a21oi_1
X_13786_ _13786_/Q _14714_/CLK _13786_/D _13786_/RESET_B VDD VSS sg13g2_dfrbpq_1
XFILLER_16_885 VDD VSS sg13g2_fill_1
X_12737_ _12750_/A _07625_/A _12751_/A2 _15017_/Q VDD VSS sg13g2_a21oi_1
XFILLER_31_844 VDD VSS sg13g2_decap_8
XFILLER_124_1038 VDD VSS sg13g2_fill_1
X_13989__2575 _13989_/RESET_B VDD VSS sg13g2_tiehi
X_12668_ _12668_/X _14258_/Q _14290_/Q _14322_/Q _14354_/Q _12674_/S0 _12675_/S1 VDD
+ VSS sg13g2_mux4_1
X_14407_ _14407_/Q clkload4/A _14407_/D _14407_/RESET_B VDD VSS sg13g2_dfrbpq_1
X_11619_ _11619_/Y _11621_/S0 _13926_/Q _12088_/B VDD VSS sg13g2_a21oi_1
XFILLER_156_551 VDD VSS sg13g2_decap_4
X_12599_ _12599_/X _14573_/Q _14605_/Q _14637_/Q _14669_/Q _12603_/S0 _12604_/S1 VDD
+ VSS sg13g2_mux4_1
XFILLER_117_927 VDD VSS sg13g2_fill_2
Xwire470 wire470/X wire470/A VDD VSS sg13g2_buf_4
X_14338_ _14338_/Q clkload22/A _14338_/D _14338_/RESET_B VDD VSS sg13g2_dfrbpq_1
XFILLER_129_798 VDD VSS sg13g2_decap_8
XFILLER_13_1090 VDD VSS sg13g2_decap_8
X_14269_ _14269_/Q _14525_/CLK _14269_/D _14269_/RESET_B VDD VSS sg13g2_dfrbpq_1
X_14369__2195 _14369_/RESET_B VDD VSS sg13g2_tiehi
XFILLER_87_1191 VDD VSS sg13g2_fill_1
XFILLER_100_1082 VDD VSS sg13g2_decap_8
XFILLER_131_418 VDD VSS sg13g2_decap_8
XFILLER_140_930 VDD VSS sg13g2_fill_2
XFILLER_112_643 VDD VSS sg13g2_decap_8
X_08830_ _08830_/X _13613_/B _13613_/C _08830_/C VDD VSS sg13g2_or3_1
XFILLER_112_654 VDD VSS sg13g2_fill_2
XFILLER_44_1039 VDD VSS sg13g2_decap_8
XFILLER_58_719 VDD VSS sg13g2_decap_8
XFILLER_100_805 VDD VSS sg13g2_decap_8
XFILLER_111_142 VDD VSS sg13g2_decap_8
XFILLER_135_1178 VDD VSS sg13g2_decap_8
XFILLER_25_0 VDD VSS sg13g2_decap_8
XFILLER_135_1189 VDD VSS sg13g2_fill_1
X_08761_ _08761_/Y _13130_/B _08787_/B VDD VSS sg13g2_nor2_1
X_15144__3054 _15144_/RESET_B VDD VSS sg13g2_tiehi
X_07712_ _07713_/A _11241_/C _11241_/A VDD VSS sg13g2_nor2_1
Xfanout1590 _12075_/A _12174_/A VDD VSS sg13g2_buf_1
X_08692_ _08693_/C _08692_/A _08692_/B _08692_/C VDD VSS sg13g2_nand3_1
XFILLER_38_465 VDD VSS sg13g2_fill_2
XFILLER_93_571 VDD VSS sg13g2_decap_4
X_07643_ _10299_/A _14785_/Q VDD VSS sg13g2_inv_1
XFILLER_81_744 VDD VSS sg13g2_fill_2
XFILLER_80_221 VDD VSS sg13g2_decap_8
XFILLER_20_1072 VDD VSS sg13g2_decap_8
XFILLER_81_755 VDD VSS sg13g2_fill_2
XFILLER_53_457 VDD VSS sg13g2_decap_8
XFILLER_22_800 VDD VSS sg13g2_decap_8
XFILLER_40_107 VDD VSS sg13g2_fill_2
X_09313_ _13920_/D _09911_/A1 _13920_/Q _09336_/S VDD VSS sg13g2_mux2_1
XFILLER_15_49 VDD VSS sg13g2_decap_8
XFILLER_62_991 VDD VSS sg13g2_decap_4
XFILLER_0_1199 VDD VSS sg13g2_decap_8
XFILLER_94_1184 VDD VSS sg13g2_decap_8
XFILLER_21_310 VDD VSS sg13g2_decap_8
XFILLER_107_1214 VDD VSS sg13g2_decap_8
XFILLER_22_855 VDD VSS sg13g2_decap_8
X_09244_ _13853_/D _13853_/Q _10140_/A1 _09272_/S VDD VSS sg13g2_mux2_1
XFILLER_139_529 VDD VSS sg13g2_decap_4
X_13819__2745 _13819_/RESET_B VDD VSS sg13g2_tiehi
X_14579__1985 _14579_/RESET_B VDD VSS sg13g2_tiehi
XFILLER_21_387 VDD VSS sg13g2_decap_8
X_09175_ _13791_/D _13791_/Q _10142_/A1 _09193_/S VDD VSS sg13g2_mux2_1
X_08126_ _08126_/Y _08270_/B _08126_/B VDD VSS sg13g2_nand2_1
X_08057_ _08057_/Y _08198_/S _08052_/Y _08056_/Y VDD VSS sg13g2_o21ai_1
XFILLER_103_7 VDD VSS sg13g2_decap_8
XFILLER_66_1220 VDD VSS sg13g2_decap_8
Xoutput48 mem_axi_araddr[19] _16872_/A VDD VSS sg13g2_buf_1
Xoutput59 mem_axi_araddr[2] _16855_/A VDD VSS sg13g2_buf_1
XFILLER_153_1212 VDD VSS sg13g2_decap_8
XFILLER_27_1215 VDD VSS sg13g2_decap_8
XFILLER_0_214 VDD VSS sg13g2_decap_4
XFILLER_103_621 VDD VSS sg13g2_decap_4
XFILLER_131_930 VDD VSS sg13g2_fill_1
XFILLER_89_855 VDD VSS sg13g2_decap_8
XFILLER_131_952 VDD VSS sg13g2_fill_1
XFILLER_49_719 VDD VSS sg13g2_decap_8
XFILLER_62_1139 VDD VSS sg13g2_fill_1
XFILLER_102_142 VDD VSS sg13g2_decap_8
XFILLER_103_665 VDD VSS sg13g2_fill_2
XFILLER_103_676 VDD VSS sg13g2_decap_8
XFILLER_102_153 VDD VSS sg13g2_decap_8
XFILLER_131_996 VDD VSS sg13g2_decap_8
X_08959_ _09204_/D _15060_/Q _08959_/B VDD VSS sg13g2_nor2_1
XFILLER_69_590 VDD VSS sg13g2_fill_1
X_14414__2150 _14414_/RESET_B VDD VSS sg13g2_tiehi
XFILLER_5_1066 VDD VSS sg13g2_decap_8
XFILLER_56_56 VDD VSS sg13g2_decap_8
X_11970_ _11971_/B _11970_/A _11970_/B _11970_/C VDD VSS sg13g2_nand3_1
XFILLER_56_67 VDD VSS sg13g2_decap_8
XFILLER_99_1062 VDD VSS sg13g2_decap_4
XFILLER_45_947 VDD VSS sg13g2_fill_2
X_10921_ _10921_/Y _10920_/A _10920_/B _10924_/B1 VDD VSS sg13g2_o21ai_1
XFILLER_72_755 VDD VSS sg13g2_fill_1
XFILLER_44_468 VDD VSS sg13g2_fill_1
X_13640_ _13748_/D _13640_/A VDD VSS sg13g2_buf_1
X_10852_ _10852_/X _10870_/A _10897_/D VDD VSS sg13g2_xor2_1
XFILLER_73_1202 VDD VSS sg13g2_fill_1
XFILLER_31_107 VDD VSS sg13g2_decap_4
XFILLER_13_811 VDD VSS sg13g2_decap_8
XFILLER_60_939 VDD VSS sg13g2_fill_2
XFILLER_31_129 VDD VSS sg13g2_decap_8
X_13571_ _13571_/Y _08263_/B _13589_/A2 _13569_/S _15013_/Q _13517_/X VDD VSS sg13g2_a221oi_1
X_10783_ _10783_/Y _13245_/A _11170_/B VDD VSS sg13g2_nand2_1
X_12522_ _12522_/X _13959_/Q _13991_/Q _14023_/Q _14055_/Q _12685_/S0 _12685_/S1 VDD
+ VSS sg13g2_mux4_1
X_14921__3087 _14921_/RESET_B VDD VSS sg13g2_tiehi
X_15241_ _15241_/Q clkload18/A _15241_/D _15241_/RESET_B VDD VSS sg13g2_dfrbpq_1
X_12453_ _12453_/X _12448_/X _12452_/X _12447_/X _12451_/X _12553_/S _12566_/S0 VDD
+ VSS sg13g2_mux4_1
XFILLER_138_551 VDD VSS sg13g2_decap_8
XFILLER_138_562 VDD VSS sg13g2_fill_1
X_11404_ _11404_/Y _11402_/Y _11401_/Y _11422_/B _11403_/X VDD VSS sg13g2_a22oi_1
XFILLER_123_1082 VDD VSS sg13g2_fill_2
X_12384_ _12384_/X _12378_/X _12382_/X _12377_/X _12381_/X _12609_/S wire1090/A VDD
+ VSS sg13g2_mux4_1
X_15172_ _15172_/Q clkload73/A _15172_/D _15172_/RESET_B VDD VSS sg13g2_dfrbpq_1
XFILLER_21_70 VDD VSS sg13g2_decap_8
X_11335_ _11335_/X _11335_/A _13691_/Q VDD VSS sg13g2_or2_1
X_14123_ _14123_/Q _14667_/CLK _14123_/D _14123_/RESET_B VDD VSS sg13g2_dfrbpq_1
XFILLER_125_234 VDD VSS sg13g2_fill_2
XFILLER_4_542 VDD VSS sg13g2_decap_8
XFILLER_99_619 VDD VSS sg13g2_fill_1
XFILLER_153_576 VDD VSS sg13g2_decap_8
XFILLER_137_70 VDD VSS sg13g2_decap_8
X_14770__3328 _14770_/RESET_B VDD VSS sg13g2_tiehi
X_11266_ _11266_/Y _11266_/A _11283_/B VDD VSS sg13g2_nand2_1
X_14624__1940 _14624_/RESET_B VDD VSS sg13g2_tiehi
X_14054_ _14054_/Q _14662_/CLK _14054_/D _14054_/RESET_B VDD VSS sg13g2_dfrbpq_1
XFILLER_140_237 VDD VSS sg13g2_decap_8
XFILLER_106_492 VDD VSS sg13g2_fill_2
X_13005_ _15033_/D _13005_/A wire238/X _13005_/C VDD VSS sg13g2_nand3_1
X_10217_ _14765_/D _13333_/S _13499_/B _10216_/Y VDD VSS sg13g2_a21oi_1
X_11197_ _11197_/X _11197_/A _11197_/B VDD VSS sg13g2_and2_1
XFILLER_95_814 VDD VSS sg13g2_decap_4
XFILLER_67_516 VDD VSS sg13g2_decap_8
XFILLER_122_996 VDD VSS sg13g2_decap_8
X_10148_ _14725_/D _14725_/Q _10148_/A1 _10150_/S VDD VSS sg13g2_mux2_1
XFILLER_121_484 VDD VSS sg13g2_decap_8
XFILLER_94_335 VDD VSS sg13g2_fill_2
XFILLER_153_91 VDD VSS sg13g2_decap_8
X_10079_ _14659_/D _10079_/A0 _14659_/Q _10099_/S VDD VSS sg13g2_mux2_1
XFILLER_36_903 VDD VSS sg13g2_fill_2
X_14956_ _14956_/Q clkload35/A _14956_/D _14956_/RESET_B VDD VSS sg13g2_dfrbpq_1
XFILLER_63_700 VDD VSS sg13g2_decap_8
XFILLER_94_379 VDD VSS sg13g2_decap_8
XFILLER_35_402 VDD VSS sg13g2_fill_1
X_13907_ _13907_/Q clkload12/A _13907_/D _13907_/RESET_B VDD VSS sg13g2_dfrbpq_1
XFILLER_90_530 VDD VSS sg13g2_fill_1
X_15086__3206 _15086_/RESET_B VDD VSS sg13g2_tiehi
X_14887_ _14887_/Q clkload79/A _14887_/D _14887_/RESET_B VDD VSS sg13g2_dfrbpq_1
XFILLER_36_969 VDD VSS sg13g2_decap_4
XFILLER_39_1108 VDD VSS sg13g2_decap_8
XFILLER_62_243 VDD VSS sg13g2_fill_1
X_13838_ _13838_/Q _14670_/CLK _13838_/D _13838_/RESET_B VDD VSS sg13g2_dfrbpq_1
XFILLER_22_107 VDD VSS sg13g2_decap_8
XFILLER_22_118 VDD VSS sg13g2_fill_2
XFILLER_62_298 VDD VSS sg13g2_fill_1
X_13769_ _13769_/Q _14633_/CLK _13769_/D _13769_/RESET_B VDD VSS sg13g2_dfrbpq_1
XFILLER_30_140 VDD VSS sg13g2_fill_1
XFILLER_30_162 VDD VSS sg13g2_decap_8
XFILLER_148_359 VDD VSS sg13g2_fill_2
XFILLER_50_1021 VDD VSS sg13g2_decap_8
XFILLER_89_1231 VDD VSS sg13g2_decap_4
XFILLER_129_573 VDD VSS sg13g2_decap_8
XFILLER_144_510 VDD VSS sg13g2_fill_2
XFILLER_141_1182 VDD VSS sg13g2_decap_8
XFILLER_15_1185 VDD VSS sg13g2_decap_8
X_14456__2108 _14456_/RESET_B VDD VSS sg13g2_tiehi
XFILLER_129_584 VDD VSS sg13g2_fill_2
XFILLER_141_1193 VDD VSS sg13g2_fill_1
XFILLER_102_1155 VDD VSS sg13g2_fill_2
XFILLER_156_392 VDD VSS sg13g2_fill_2
XFILLER_104_407 VDD VSS sg13g2_decap_8
XFILLER_144_598 VDD VSS sg13g2_fill_1
X_09931_ _14516_/D _14516_/Q _10096_/A0 _09933_/S VDD VSS sg13g2_mux2_1
Xfanout805 _08381_/A _08004_/Y VDD VSS sg13g2_buf_1
Xfanout816 _13262_/B1 _13236_/B1 VDD VSS sg13g2_buf_1
XFILLER_113_963 VDD VSS sg13g2_decap_4
Xfanout827 _13264_/A2 _13561_/S VDD VSS sg13g2_buf_1
X_09862_ _14449_/D _14449_/Q _09994_/A0 wire435/X VDD VSS sg13g2_mux2_1
XFILLER_86_814 VDD VSS sg13g2_fill_1
Xfanout838 _11084_/B _11074_/B VDD VSS sg13g2_buf_1
Xfanout849 _09044_/A _08988_/A VDD VSS sg13g2_buf_1
X_08813_ _08813_/Y _13279_/B _12347_/B _08727_/D _15180_/Q _08825_/C1 VDD VSS sg13g2_a221oi_1
XFILLER_100_624 VDD VSS sg13g2_decap_8
X_09793_ _14382_/D _09925_/A1 _14382_/Q wire633/X VDD VSS sg13g2_mux2_1
XFILLER_133_39 VDD VSS sg13g2_decap_8
XFILLER_86_858 VDD VSS sg13g2_fill_1
XFILLER_97_195 VDD VSS sg13g2_fill_1
XFILLER_86_869 VDD VSS sg13g2_decap_4
XFILLER_61_1161 VDD VSS sg13g2_decap_8
XFILLER_61_1172 VDD VSS sg13g2_fill_1
XFILLER_73_508 VDD VSS sg13g2_decap_8
X_08744_ _13666_/D _08753_/A1 _08742_/Y _08743_/Y VDD VSS sg13g2_a21oi_1
XFILLER_2_1206 VDD VSS sg13g2_decap_8
XFILLER_61_1194 VDD VSS sg13g2_decap_8
XFILLER_22_1156 VDD VSS sg13g2_decap_8
XFILLER_39_785 VDD VSS sg13g2_decap_4
XFILLER_66_571 VDD VSS sg13g2_fill_2
XFILLER_96_1213 VDD VSS sg13g2_fill_2
XFILLER_26_413 VDD VSS sg13g2_decap_8
XFILLER_66_582 VDD VSS sg13g2_decap_8
XFILLER_96_1224 VDD VSS sg13g2_decap_8
XFILLER_26_424 VDD VSS sg13g2_decap_8
X_08675_ _08675_/Y _08035_/X _08671_/Y _08674_/Y VDD VSS sg13g2_o21ai_1
XFILLER_96_1235 VDD VSS sg13g2_fill_2
X_14062__2502 _14062_/RESET_B VDD VSS sg13g2_tiehi
XFILLER_54_755 VDD VSS sg13g2_decap_4
XFILLER_57_1219 VDD VSS sg13g2_decap_8
XFILLER_14_608 VDD VSS sg13g2_fill_1
X_07626_ _07626_/Y _07626_/A VDD VSS sg13g2_inv_1
XFILLER_42_928 VDD VSS sg13g2_decap_8
XFILLER_42_14 VDD VSS sg13g2_decap_8
X_14702__1862 _14702_/RESET_B VDD VSS sg13g2_tiehi
XFILLER_107_1055 VDD VSS sg13g2_decap_4
XFILLER_139_337 VDD VSS sg13g2_decap_8
XFILLER_10_825 VDD VSS sg13g2_decap_8
X_09227_ _13838_/D _10157_/A1 _13838_/Q _09227_/S VDD VSS sg13g2_mux2_1
X_14095__2469 _14095_/RESET_B VDD VSS sg13g2_tiehi
XFILLER_154_329 VDD VSS sg13g2_decap_8
X_09158_ _09158_/Y _09158_/A _09158_/B _09158_/C VDD VSS sg13g2_nand3_1
XFILLER_147_392 VDD VSS sg13g2_decap_8
X_08109_ _08110_/A _08109_/A1 _08402_/B _08023_/Y _08101_/Y VDD VSS sg13g2_a22oi_1
X_09089_ _09090_/C _14911_/Q _13064_/A _09089_/C _09103_/D VDD VSS sg13g2_nand4_1
X_15034__2938 _15034_/RESET_B VDD VSS sg13g2_tiehi
XFILLER_150_502 VDD VSS sg13g2_decap_4
X_11120_ _11127_/A _11012_/B _11012_/C _11119_/Y VDD VSS sg13g2_o21ai_1
XFILLER_1_523 VDD VSS sg13g2_decap_8
XFILLER_66_1061 VDD VSS sg13g2_decap_8
XFILLER_89_641 VDD VSS sg13g2_decap_8
XFILLER_122_248 VDD VSS sg13g2_fill_2
XFILLER_153_1020 VDD VSS sg13g2_decap_8
X_11051_ _11051_/Y _11064_/D _11051_/B VDD VSS sg13g2_xnor2_1
XFILLER_7_1117 VDD VSS sg13g2_decap_8
XFILLER_104_985 VDD VSS sg13g2_decap_8
XFILLER_118_1162 VDD VSS sg13g2_decap_8
XFILLER_153_1053 VDD VSS sg13g2_fill_2
X_10002_ _14585_/D _10068_/A0 _14585_/Q _10002_/S VDD VSS sg13g2_mux2_1
XFILLER_1_589 VDD VSS sg13g2_fill_1
XFILLER_153_1086 VDD VSS sg13g2_decap_8
XFILLER_27_1089 VDD VSS sg13g2_decap_8
X_14810_ _14810_/Q clkload78/A _14810_/D _14810_/RESET_B VDD VSS sg13g2_dfrbpq_1
XFILLER_67_99 VDD VSS sg13g2_decap_4
XFILLER_92_839 VDD VSS sg13g2_fill_2
XFILLER_83_21 VDD VSS sg13g2_decap_8
X_14741_ _14741_/Q clkload15/A _14741_/D _14741_/RESET_B VDD VSS sg13g2_dfrbpq_1
X_11953_ _11953_/Y _11953_/A _11953_/B _11953_/C VDD VSS sg13g2_nand3_1
XFILLER_33_906 VDD VSS sg13g2_fill_1
X_10904_ _10907_/A _10888_/Y _10904_/B VDD VSS sg13g2_nand2b_1
X_14672_ _14672_/Q clkload50/A _14672_/D _14672_/RESET_B VDD VSS sg13g2_dfrbpq_1
X_11884_ _11884_/Y _11378_/S _11883_/X _12334_/C VDD VSS sg13g2_a21oi_1
XFILLER_45_788 VDD VSS sg13g2_decap_8
XFILLER_32_416 VDD VSS sg13g2_decap_8
XFILLER_16_70 VDD VSS sg13g2_decap_8
X_13623_ _13731_/D _13623_/A VDD VSS sg13g2_buf_1
XFILLER_77_1190 VDD VSS sg13g2_decap_8
X_10835_ _10835_/Y _10827_/B _10816_/Y _10834_/Y _10835_/B2 _13279_/D VDD VSS sg13g2_a221oi_1
XFILLER_73_1032 VDD VSS sg13g2_decap_8
XFILLER_125_1100 VDD VSS sg13g2_decap_4
XFILLER_73_1054 VDD VSS sg13g2_fill_2
X_13554_ _15149_/D _15149_/Q wire731/X _13560_/S VDD VSS sg13g2_mux2_1
XFILLER_125_1133 VDD VSS sg13g2_decap_8
X_10766_ _14918_/D _11168_/B1 _11115_/B _10765_/Y VDD VSS sg13g2_o21ai_1
X_14824__3274 _14824_/RESET_B VDD VSS sg13g2_tiehi
XFILLER_34_1049 VDD VSS sg13g2_decap_8
X_12505_ _12505_/X _14566_/Q _14598_/Q _14630_/Q _14662_/Q _12508_/S0 _12508_/S1 VDD
+ VSS sg13g2_mux4_1
XFILLER_8_133 VDD VSS sg13g2_decap_8
X_10697_ _10697_/X _10697_/A _10697_/B _10793_/A VDD VSS sg13g2_and3_1
X_13760__2804 _13760_/RESET_B VDD VSS sg13g2_tiehi
X_13485_ _13486_/A _15171_/D _15172_/D VDD VSS sg13g2_nor2_1
X_15224_ _15224_/Q clkload40/A _15224_/D _15224_/RESET_B VDD VSS sg13g2_dfrbpq_1
X_12436_ _12436_/X _13953_/Q _13985_/Q _14017_/Q _14049_/Q _12561_/S0 _12564_/S1 VDD
+ VSS sg13g2_mux4_1
XFILLER_66_7 VDD VSS sg13g2_decap_8
XFILLER_126_521 VDD VSS sg13g2_decap_8
Xmax_cap1678 _12072_/S0 _11922_/S0 VDD VSS sg13g2_buf_4
XFILLER_153_340 VDD VSS sg13g2_fill_2
X_15155_ _15155_/Q clkload29/A _15155_/D _15155_/RESET_B VDD VSS sg13g2_dfrbpq_1
X_12367_ _12367_/X _13820_/Q _13852_/Q _13884_/Q _13916_/Q _12368_/S0 _12368_/S1 VDD
+ VSS sg13g2_mux4_1
XFILLER_114_716 VDD VSS sg13g2_decap_8
XFILLER_114_727 VDD VSS sg13g2_fill_2
XFILLER_154_896 VDD VSS sg13g2_decap_8
XFILLER_153_373 VDD VSS sg13g2_fill_2
X_14106_ _14106_/Q clkload58/A _14106_/D _14106_/RESET_B VDD VSS sg13g2_dfrbpq_1
X_11318_ _11318_/Y _11318_/A _11318_/B VDD VSS sg13g2_nand2_1
XFILLER_99_438 VDD VSS sg13g2_fill_2
X_12298_ _12298_/Y _12300_/A _12298_/B VDD VSS sg13g2_nor2_1
X_15086_ _15086_/Q clkload71/A _15086_/D _15086_/RESET_B VDD VSS sg13g2_dfrbpq_1
XFILLER_114_749 VDD VSS sg13g2_decap_8
X_14140__2424 _14140_/RESET_B VDD VSS sg13g2_tiehi
XFILLER_4_383 VDD VSS sg13g2_fill_1
XFILLER_107_790 VDD VSS sg13g2_fill_1
X_14037_ _14037_/Q clkload15/A _14037_/D _14037_/RESET_B VDD VSS sg13g2_dfrbpq_1
XFILLER_113_259 VDD VSS sg13g2_decap_8
X_11249_ _11249_/Y _12866_/A _11724_/B VDD VSS sg13g2_nor2_1
XFILLER_45_1145 VDD VSS sg13g2_decap_8
XFILLER_84_1194 VDD VSS sg13g2_fill_2
XFILLER_122_760 VDD VSS sg13g2_fill_2
XFILLER_80_1036 VDD VSS sg13g2_decap_8
XFILLER_132_1115 VDD VSS sg13g2_fill_2
XFILLER_110_944 VDD VSS sg13g2_fill_2
XFILLER_95_666 VDD VSS sg13g2_fill_2
XFILLER_110_966 VDD VSS sg13g2_fill_2
XFILLER_94_154 VDD VSS sg13g2_decap_8
XFILLER_36_711 VDD VSS sg13g2_decap_8
X_14939_ _14939_/Q clkload34/A _14939_/D _14939_/RESET_B VDD VSS sg13g2_dfrbpq_1
XFILLER_94_198 VDD VSS sg13g2_decap_8
X_08460_ _08461_/D _08597_/A _08458_/X _08459_/Y VDD VSS sg13g2_o21ai_1
XFILLER_51_703 VDD VSS sg13g2_decap_8
XFILLER_51_714 VDD VSS sg13g2_fill_1
XFILLER_91_894 VDD VSS sg13g2_fill_1
XFILLER_90_382 VDD VSS sg13g2_decap_8
XFILLER_91_1110 VDD VSS sg13g2_fill_1
X_08391_ _08391_/Y _08584_/A _08391_/B VDD VSS sg13g2_nor2_1
XFILLER_16_490 VDD VSS sg13g2_fill_1
XFILLER_92_0 VDD VSS sg13g2_decap_8
XFILLER_32_961 VDD VSS sg13g2_decap_8
XFILLER_17_1225 VDD VSS sg13g2_decap_8
XFILLER_149_624 VDD VSS sg13g2_fill_2
XFILLER_52_1116 VDD VSS sg13g2_decap_8
XFILLER_148_112 VDD VSS sg13g2_decap_8
XFILLER_17_1236 VDD VSS sg13g2_fill_1
XFILLER_148_156 VDD VSS sg13g2_decap_8
XFILLER_12_28 VDD VSS sg13g2_decap_8
X_09012_ _09012_/Y _14902_/Q _09022_/D _09024_/A VDD VSS sg13g2_o21ai_1
XFILLER_128_28 VDD VSS sg13g2_decap_8
XFILLER_105_705 VDD VSS sg13g2_fill_2
XFILLER_137_1004 VDD VSS sg13g2_decap_8
XFILLER_104_204 VDD VSS sg13g2_decap_8
XFILLER_117_598 VDD VSS sg13g2_fill_2
XFILLER_137_1037 VDD VSS sg13g2_decap_8
Xfanout602 wire603/A _10004_/Y VDD VSS sg13g2_buf_1
X_09914_ _14499_/D _14499_/Q _09914_/A1 _09934_/S VDD VSS sg13g2_mux2_1
XFILLER_144_49 VDD VSS sg13g2_decap_8
X_13769__2795 _13769_/RESET_B VDD VSS sg13g2_tiehi
XFILLER_113_771 VDD VSS sg13g2_decap_8
XFILLER_58_302 VDD VSS sg13g2_decap_4
XFILLER_113_782 VDD VSS sg13g2_fill_1
Xfanout646 _09556_/S wire653/X VDD VSS sg13g2_buf_1
X_09845_ _14432_/D _14432_/Q _09977_/A0 _09868_/S VDD VSS sg13g2_mux2_1
XFILLER_24_1218 VDD VSS sg13g2_decap_8
XFILLER_140_590 VDD VSS sg13g2_fill_2
Xfanout668 _09446_/S wire671/X VDD VSS sg13g2_buf_1
XFILLER_100_432 VDD VSS sg13g2_decap_8
Xfanout679 _09377_/S _09407_/S VDD VSS sg13g2_buf_1
XFILLER_37_14 VDD VSS sg13g2_decap_8
X_09776_ _14365_/D _09908_/A1 _14365_/Q _09778_/S VDD VSS sg13g2_mux2_1
XFILLER_85_176 VDD VSS sg13g2_decap_8
XFILLER_100_487 VDD VSS sg13g2_decap_8
XFILLER_27_722 VDD VSS sg13g2_decap_4
XFILLER_100_498 VDD VSS sg13g2_fill_1
XFILLER_2_1025 VDD VSS sg13g2_fill_2
XFILLER_6_1194 VDD VSS sg13g2_decap_8
X_08727_ _08727_/X _15129_/Q _15124_/Q _15071_/Q _08727_/D VDD VSS sg13g2_or4_1
XFILLER_27_744 VDD VSS sg13g2_fill_2
XFILLER_54_530 VDD VSS sg13g2_decap_4
XFILLER_113_1092 VDD VSS sg13g2_decap_8
X_13984__2580 _13984_/RESET_B VDD VSS sg13g2_tiehi
XFILLER_15_906 VDD VSS sg13g2_decap_8
XFILLER_82_872 VDD VSS sg13g2_fill_1
X_08658_ _08659_/C _08029_/Y _08591_/X _08511_/X _08597_/A _08657_/Y VDD VSS sg13g2_a221oi_1
XFILLER_82_894 VDD VSS sg13g2_decap_8
XFILLER_109_1106 VDD VSS sg13g2_fill_1
XFILLER_42_769 VDD VSS sg13g2_fill_1
X_08589_ _08596_/B _08429_/A _08252_/Y _08688_/C VDD VSS sg13g2_o21ai_1
XFILLER_53_57 VDD VSS sg13g2_fill_2
XFILLER_109_1139 VDD VSS sg13g2_decap_4
X_10620_ _10623_/B _10651_/D _10622_/C _14882_/Q VDD VSS sg13g2_a21oi_1
XFILLER_23_972 VDD VSS sg13g2_decap_8
XFILLER_139_112 VDD VSS sg13g2_fill_2
XFILLER_70_1227 VDD VSS sg13g2_decap_8
X_13679__2899 _13679_/RESET_B VDD VSS sg13g2_tiehi
XFILLER_139_134 VDD VSS sg13g2_fill_1
X_10551_ _14865_/D _14865_/Q _10556_/D _10550_/Y VDD VSS sg13g2_a21oi_1
XFILLER_139_189 VDD VSS sg13g2_decap_8
X_10482_ _14848_/D _10482_/A _10481_/Y VDD VSS sg13g2_nor2b_1
X_13270_ _13271_/B _13270_/A _13270_/B _13270_/C VDD VSS sg13g2_nand3_1
XFILLER_154_126 VDD VSS sg13g2_decap_8
XFILLER_33_1082 VDD VSS sg13g2_decap_8
XFILLER_68_1101 VDD VSS sg13g2_decap_8
X_12221_ _12221_/Y _12174_/A _12220_/Y _12221_/B1 VDD VSS sg13g2_o21ai_1
XFILLER_5_147 VDD VSS sg13g2_decap_8
XFILLER_120_1063 VDD VSS sg13g2_fill_2
XFILLER_120_1074 VDD VSS sg13g2_decap_8
XFILLER_151_811 VDD VSS sg13g2_fill_1
XFILLER_123_502 VDD VSS sg13g2_fill_2
X_12152_ _12153_/B _12152_/A _13666_/Q VDD VSS sg13g2_nand2_1
XFILLER_108_598 VDD VSS sg13g2_decap_4
XFILLER_151_833 VDD VSS sg13g2_decap_8
XFILLER_29_1118 VDD VSS sg13g2_decap_8
XFILLER_78_21 VDD VSS sg13g2_fill_2
X_11103_ _11118_/D _11171_/B _11115_/B VDD VSS sg13g2_xnor2_1
X_12083_ _12198_/A _12084_/A _13668_/Q VDD VSS sg13g2_nor2_1
XFILLER_150_365 VDD VSS sg13g2_decap_4
XFILLER_150_387 VDD VSS sg13g2_decap_8
XFILLER_1_364 VDD VSS sg13g2_decap_4
XFILLER_2_898 VDD VSS sg13g2_decap_8
XFILLER_77_622 VDD VSS sg13g2_decap_8
X_11034_ _11034_/Y _15117_/Q _11002_/A _11023_/Y VDD VSS sg13g2_a21oi_1
XFILLER_49_346 VDD VSS sg13g2_fill_1
XFILLER_103_292 VDD VSS sg13g2_fill_2
XFILLER_76_143 VDD VSS sg13g2_fill_1
XFILLER_94_42 VDD VSS sg13g2_decap_8
Xclkbuf_5_2__f_clk_i clkbuf_5_2__f_clk_i/X clkbuf_4_1_0_clk_i/X VDD VSS sg13g2_buf_16
XFILLER_64_338 VDD VSS sg13g2_fill_2
X_12985_ _13009_/A _14906_/Q _13681_/Q VDD VSS sg13g2_nand2_1
X_13814__2750 _13814_/RESET_B VDD VSS sg13g2_tiehi
XFILLER_18_766 VDD VSS sg13g2_decap_8
X_14574__1990 _14574_/RESET_B VDD VSS sg13g2_tiehi
XFILLER_33_703 VDD VSS sg13g2_fill_1
X_14724_ _14724_/Q _15001_/CLK _14724_/D _14724_/RESET_B VDD VSS sg13g2_dfrbpq_1
XFILLER_40_1097 VDD VSS sg13g2_decap_4
XFILLER_75_1105 VDD VSS sg13g2_decap_4
X_11936_ _12055_/B _11936_/A _13130_/B VDD VSS sg13g2_xnor2_1
XFILLER_17_265 VDD VSS sg13g2_decap_8
XFILLER_72_360 VDD VSS sg13g2_decap_8
XFILLER_150_70 VDD VSS sg13g2_decap_8
XFILLER_18_799 VDD VSS sg13g2_decap_8
XFILLER_33_747 VDD VSS sg13g2_decap_8
X_14655_ _14655_/Q clkload56/A _14655_/D _14655_/RESET_B VDD VSS sg13g2_dfrbpq_1
XFILLER_127_1228 VDD VSS sg13g2_decap_8
X_11867_ _11868_/C _11867_/A _11867_/B _11910_/C VDD VSS sg13g2_nand3_1
X_13606_ _13606_/Y _12801_/Y _13600_/Y _08830_/X VDD VSS sg13g2_o21ai_1
X_14158__2406 _14158_/RESET_B VDD VSS sg13g2_tiehi
XFILLER_14_972 VDD VSS sg13g2_decap_8
X_10818_ _10818_/Y _10818_/A _10818_/B VDD VSS sg13g2_nor2_1
X_14586_ _14586_/Q clkload58/A _14586_/D _14586_/RESET_B VDD VSS sg13g2_dfrbpq_1
X_11798_ _12056_/A _11798_/A _13676_/Q VDD VSS sg13g2_xor2_1
XFILLER_9_420 VDD VSS sg13g2_fill_1
X_13537_ _13537_/X _14994_/Q _13537_/B VDD VSS sg13g2_and2_1
XFILLER_13_493 VDD VSS sg13g2_decap_8
XFILLER_9_442 VDD VSS sg13g2_fill_1
X_14970__3002 _14970_/RESET_B VDD VSS sg13g2_tiehi
X_10749_ _11068_/B _14946_/Q _10752_/A _10747_/Y VDD VSS sg13g2_a21o_1
X_13468_ wire742/A _15173_/Q _15174_/Q _15175_/Q _13468_/D VDD VSS sg13g2_nor4_1
XFILLER_12_1144 VDD VSS sg13g2_decap_8
X_15207_ _15207_/Q _15209_/CLK _15207_/D _15207_/RESET_B VDD VSS sg13g2_dfrbpq_1
X_12419_ _12419_/X _13952_/Q _13984_/Q _14016_/Q _14048_/Q _12742_/S0 _12742_/S1 VDD
+ VSS sg13g2_mux4_1
XFILLER_127_863 VDD VSS sg13g2_decap_8
XFILLER_86_1234 VDD VSS sg13g2_fill_2
X_13399_ _15087_/D _13431_/A _13396_/D _13398_/Y VDD VSS sg13g2_o21ai_1
X_15138_ _15138_/Q _15148_/CLK _15138_/D _15138_/RESET_B VDD VSS sg13g2_dfrbpq_1
XFILLER_142_844 VDD VSS sg13g2_decap_8
X_07960_ _07960_/Y wire233/A _07906_/B _07959_/Y VDD VSS sg13g2_a21oi_1
X_15069_ _15069_/Q clkload65/A _15069_/D _15069_/RESET_B VDD VSS sg13g2_dfrbpq_1
XFILLER_142_899 VDD VSS sg13g2_decap_4
XFILLER_4_84 VDD VSS sg13g2_decap_8
X_07891_ _07917_/B _07893_/B _08452_/C VDD VSS sg13g2_nor2_1
XFILLER_96_964 VDD VSS sg13g2_decap_8
XFILLER_28_508 VDD VSS sg13g2_fill_1
X_09630_ _14226_/D _09830_/A0 _14226_/Q _09637_/S VDD VSS sg13g2_mux2_1
XFILLER_28_519 VDD VSS sg13g2_decap_8
XFILLER_67_165 VDD VSS sg13g2_decap_4
XFILLER_110_785 VDD VSS sg13g2_decap_8
X_09561_ _14159_/D _09992_/A0 _14159_/Q _09566_/S VDD VSS sg13g2_mux2_1
XFILLER_83_647 VDD VSS sg13g2_decap_8
X_14862__3205 _14862_/RESET_B VDD VSS sg13g2_tiehi
XFILLER_36_552 VDD VSS sg13g2_decap_8
X_08512_ _08512_/Y _08560_/A _08339_/Y _08539_/B1 VDD VSS sg13g2_a21oi_1
XFILLER_70_308 VDD VSS sg13g2_decap_8
XFILLER_51_500 VDD VSS sg13g2_decap_8
XFILLER_64_883 VDD VSS sg13g2_decap_8
X_09492_ _14092_/D _09956_/A1 _14092_/Q _09505_/S VDD VSS sg13g2_mux2_1
XFILLER_24_736 VDD VSS sg13g2_decap_8
X_08443_ _08443_/Y _08443_/A _08443_/B VDD VSS sg13g2_nor2_1
XFILLER_51_555 VDD VSS sg13g2_decap_8
X_14895__3139 _14895_/RESET_B VDD VSS sg13g2_tiehi
X_08374_ _08374_/Y _08374_/A _08374_/B VDD VSS sg13g2_nor2_1
XFILLER_149_421 VDD VSS sg13g2_decap_8
XFILLER_17_1022 VDD VSS sg13g2_decap_8
XFILLER_32_780 VDD VSS sg13g2_decap_8
XFILLER_23_49 VDD VSS sg13g2_decap_8
XFILLER_149_465 VDD VSS sg13g2_decap_8
XFILLER_20_953 VDD VSS sg13g2_decap_8
XFILLER_31_290 VDD VSS sg13g2_decap_8
XFILLER_139_49 VDD VSS sg13g2_decap_8
XFILLER_30_1200 VDD VSS sg13g2_decap_8
XFILLER_17_1099 VDD VSS sg13g2_decap_8
XFILLER_104_1047 VDD VSS sg13g2_fill_2
XFILLER_117_340 VDD VSS sg13g2_decap_8
XFILLER_105_502 VDD VSS sg13g2_fill_1
XFILLER_133_833 VDD VSS sg13g2_decap_8
X_13856__2708 _13856_/RESET_B VDD VSS sg13g2_tiehi
XFILLER_105_535 VDD VSS sg13g2_decap_8
XFILLER_132_365 VDD VSS sg13g2_decap_8
Xfanout1408 _08653_/B _08686_/A2 VDD VSS sg13g2_buf_1
XFILLER_8_1223 VDD VSS sg13g2_decap_8
Xfanout1419 _12128_/A _14983_/Q VDD VSS sg13g2_buf_1
Xfanout421 _09930_/S wire423/A VDD VSS sg13g2_buf_1
XFILLER_99_791 VDD VSS sg13g2_decap_8
Xfanout432 _09844_/S wire435/X VDD VSS sg13g2_buf_1
XFILLER_87_942 VDD VSS sg13g2_decap_8
Xfanout443 wire444/A _09760_/S VDD VSS sg13g2_buf_1
XFILLER_24_1015 VDD VSS sg13g2_decap_8
XFILLER_87_953 VDD VSS sg13g2_fill_2
XFILLER_113_590 VDD VSS sg13g2_decap_8
Xfanout454 _09727_/S _09707_/X VDD VSS sg13g2_buf_1
XFILLER_150_1023 VDD VSS sg13g2_decap_8
Xfanout465 _09622_/S _09636_/S VDD VSS sg13g2_buf_1
XFILLER_59_666 VDD VSS sg13g2_fill_1
X_14236__2328 _14236_/RESET_B VDD VSS sg13g2_tiehi
X_09828_ _14416_/D _09927_/A1 _14416_/Q _09838_/S VDD VSS sg13g2_mux2_1
Xwire1569 _16856_/A _13694_/Q VDD VSS sg13g2_buf_8
XFILLER_86_496 VDD VSS sg13g2_fill_2
XFILLER_115_1198 VDD VSS sg13g2_decap_8
XFILLER_46_338 VDD VSS sg13g2_decap_8
XFILLER_104_63 VDD VSS sg13g2_decap_8
X_09759_ _14349_/D _14349_/Q _09924_/A1 _09772_/S VDD VSS sg13g2_mux2_1
XFILLER_39_390 VDD VSS sg13g2_decap_8
XFILLER_74_669 VDD VSS sg13g2_decap_8
X_12770_ _12770_/X _14137_/Q _14169_/Q _14201_/Q _14233_/Q _12770_/S0 _12770_/S1 VDD
+ VSS sg13g2_mux4_1
XFILLER_55_894 VDD VSS sg13g2_decap_8
X_11721_ _11721_/Y _14908_/Q _12267_/A2 _12269_/A2 VDD VSS sg13g2_a21oi_1
XFILLER_54_393 VDD VSS sg13g2_decap_8
X_14451__2113 _14451_/RESET_B VDD VSS sg13g2_tiehi
XFILLER_81_190 VDD VSS sg13g2_fill_2
XFILLER_70_864 VDD VSS sg13g2_fill_1
XFILLER_30_717 VDD VSS sg13g2_decap_4
X_14440_ _14440_/Q clkload28/A _14440_/D _14440_/RESET_B VDD VSS sg13g2_dfrbpq_1
XFILLER_70_886 VDD VSS sg13g2_decap_8
X_11652_ _11652_/X _11644_/X _11645_/X _11648_/X _11649_/X _12092_/C _12076_/S1 VDD
+ VSS sg13g2_mux4_1
XFILLER_74_1193 VDD VSS sg13g2_decap_8
XFILLER_156_903 VDD VSS sg13g2_fill_1
X_10603_ _10608_/C _14877_/Q _10610_/D _14878_/Q VDD VSS sg13g2_a21oi_1
X_14371_ _14371_/Q clkload2/A _14371_/D _14371_/RESET_B VDD VSS sg13g2_dfrbpq_1
X_11583_ _11583_/X _11575_/X _11576_/X _11579_/X _11580_/X wire964/A _12221_/B1 VDD
+ VSS sg13g2_mux4_1
XFILLER_128_616 VDD VSS sg13g2_decap_8
XFILLER_11_986 VDD VSS sg13g2_decap_8
X_13322_ _15064_/D _13322_/A _13322_/B VDD VSS sg13g2_nand2_1
Xwire844 wire844/X wire844/A VDD VSS sg13g2_buf_2
X_10534_ _10535_/B _14860_/Q _14859_/Q _10558_/B _10543_/C VDD VSS sg13g2_nand4_1
XFILLER_155_446 VDD VSS sg13g2_decap_8
XFILLER_143_608 VDD VSS sg13g2_decap_8
X_10465_ _10468_/B _10511_/D _10471_/D _10511_/C VDD VSS sg13g2_a21oi_1
XFILLER_143_619 VDD VSS sg13g2_fill_2
X_13253_ wire206/A _13297_/A0 _13251_/Y _13252_/X _13048_/X VDD VSS sg13g2_a22oi_1
XFILLER_109_874 VDD VSS sg13g2_decap_8
XFILLER_89_42 VDD VSS sg13g2_decap_4
X_12204_ _12204_/Y _12204_/A _12272_/A VDD VSS sg13g2_xnor2_1
X_10396_ _10397_/C _14818_/Q _14819_/Q _10396_/C _10396_/D VDD VSS sg13g2_nand4_1
X_13184_ _15045_/D _13266_/A _13184_/B VDD VSS sg13g2_nor2_1
XFILLER_151_663 VDD VSS sg13g2_decap_8
XFILLER_2_651 VDD VSS sg13g2_decap_8
X_12135_ _12135_/X _13845_/Q _13877_/Q _13909_/Q _13941_/Q _12139_/S0 _12285_/S1 VDD
+ VSS sg13g2_mux4_1
XFILLER_151_674 VDD VSS sg13g2_fill_1
XFILLER_145_70 VDD VSS sg13g2_decap_8
XFILLER_1_150 VDD VSS sg13g2_decap_8
XFILLER_1_161 VDD VSS sg13g2_fill_2
XFILLER_2_684 VDD VSS sg13g2_fill_2
XFILLER_111_538 VDD VSS sg13g2_decap_8
XFILLER_123_398 VDD VSS sg13g2_decap_8
X_12066_ _12066_/X _14131_/Q _14163_/Q _14195_/Q _14227_/Q _12073_/S0 _12073_/S1 VDD
+ VSS sg13g2_mux4_1
XFILLER_78_953 VDD VSS sg13g2_decap_8
XFILLER_29_7 VDD VSS sg13g2_decap_8
XFILLER_42_1137 VDD VSS sg13g2_fill_1
XFILLER_77_452 VDD VSS sg13g2_decap_8
X_11017_ _11017_/Y _11099_/B2 _11016_/Y _11029_/C VDD VSS sg13g2_o21ai_1
X_16874_ _16874_/X _16874_/A VDD VSS sg13g2_buf_1
XFILLER_81_1197 VDD VSS sg13g2_decap_8
XFILLER_77_474 VDD VSS sg13g2_decap_8
X_14661__1903 _14661_/RESET_B VDD VSS sg13g2_tiehi
XFILLER_49_176 VDD VSS sg13g2_decap_8
XFILLER_93_945 VDD VSS sg13g2_decap_8
XFILLER_18_530 VDD VSS sg13g2_decap_4
XFILLER_46_850 VDD VSS sg13g2_decap_8
XFILLER_64_146 VDD VSS sg13g2_decap_8
XFILLER_18_552 VDD VSS sg13g2_decap_4
XFILLER_52_308 VDD VSS sg13g2_fill_2
XFILLER_79_1060 VDD VSS sg13g2_decap_8
X_14090__2474 _14090_/RESET_B VDD VSS sg13g2_tiehi
X_12968_ _12968_/Y input22/X _12795_/Y _12937_/Y VDD VSS sg13g2_o21ai_1
XFILLER_61_831 VDD VSS sg13g2_fill_1
X_14707_ _14707_/Q clkload13/A _14707_/D _14707_/RESET_B VDD VSS sg13g2_dfrbpq_1
XFILLER_33_533 VDD VSS sg13g2_decap_8
XFILLER_61_842 VDD VSS sg13g2_fill_1
X_11919_ _11919_/X _13743_/Q _14095_/Q _14447_/Q _14543_/Q _11925_/S0 _12073_/S1 VDD
+ VSS sg13g2_mux4_1
XFILLER_60_330 VDD VSS sg13g2_fill_1
X_12899_ _12902_/C _12899_/A _12900_/C _12899_/C input27/X VDD VSS sg13g2_nand4_1
XFILLER_21_717 VDD VSS sg13g2_fill_1
X_14638_ _14638_/Q _14670_/CLK _14638_/D _14638_/RESET_B VDD VSS sg13g2_dfrbpq_1
XFILLER_60_385 VDD VSS sg13g2_decap_8
XFILLER_53_1233 VDD VSS sg13g2_decap_4
XFILLER_140_1203 VDD VSS sg13g2_decap_8
X_14569_ _14569_/Q _14633_/CLK _14569_/D _14569_/RESET_B VDD VSS sg13g2_dfrbpq_1
XFILLER_147_936 VDD VSS sg13g2_fill_1
XFILLER_9_250 VDD VSS sg13g2_fill_1
X_08090_ _08090_/Y _08183_/A _08090_/B _08090_/C VDD VSS sg13g2_nor3_1
Xclkload20 clkload20/Y clkload20/A VDD VSS sg13g2_inv_2
Xclkload31 clkload31/Y clkload31/A VDD VSS sg13g2_inv_1
Xclkload42 clkload42/Y clkload42/A VDD VSS sg13g2_inv_1
Xclkload53 clkload53/X clkload53/A VDD VSS sg13g2_buf_8
Xclkload64 clkload64/X clkload64/A VDD VSS sg13g2_buf_8
XFILLER_55_0 VDD VSS sg13g2_decap_8
Xclkload75 clkload75/Y clkload75/A VDD VSS sg13g2_inv_2
XFILLER_138_1110 VDD VSS sg13g2_fill_1
XFILLER_138_1132 VDD VSS sg13g2_decap_4
Xhold3505 _10862_/A _14932_/Q VDD VSS sg13g2_dlygate4sd3_1
Xhold3516 _13535_/A _15144_/Q VDD VSS sg13g2_dlygate4sd3_1
Xhold3527 _11133_/A _14951_/Q VDD VSS sg13g2_dlygate4sd3_1
Xclkbuf_leaf_120_clk_i _14722_/CLK clkbuf_5_8__f_clk_i/X VDD VSS sg13g2_buf_8
X_08992_ _08992_/Y _09141_/A _08992_/B _10697_/B VDD VSS sg13g2_nand3_1
XFILLER_138_1198 VDD VSS sg13g2_fill_1
X_07943_ wire233/A _07797_/X _07927_/Y _07942_/Y VDD VSS sg13g2_o21ai_1
XFILLER_87_249 VDD VSS sg13g2_fill_1
XFILLER_69_975 VDD VSS sg13g2_decap_8
X_07874_ _07876_/B _07910_/B _14994_/Q VDD VSS sg13g2_nand2_1
XFILLER_110_560 VDD VSS sg13g2_decap_8
XFILLER_28_327 VDD VSS sg13g2_decap_8
X_09613_ _14209_/D _09613_/A0 _14209_/Q _09622_/S VDD VSS sg13g2_mux2_1
XFILLER_18_49 VDD VSS sg13g2_decap_8
XFILLER_110_593 VDD VSS sg13g2_decap_4
X_14783__3315 _14783_/RESET_B VDD VSS sg13g2_tiehi
XFILLER_141_28 VDD VSS sg13g2_decap_8
XFILLER_55_124 VDD VSS sg13g2_fill_1
XFILLER_28_349 VDD VSS sg13g2_fill_1
XFILLER_23_1070 VDD VSS sg13g2_decap_8
XFILLER_3_1153 VDD VSS sg13g2_decap_8
XFILLER_71_617 VDD VSS sg13g2_decap_8
X_09544_ _14142_/D _10141_/A1 _14142_/Q wire651/X VDD VSS sg13g2_mux2_1
XFILLER_97_1160 VDD VSS sg13g2_decap_4
XFILLER_97_1182 VDD VSS sg13g2_decap_4
XFILLER_52_831 VDD VSS sg13g2_decap_4
X_09475_ _14075_/D _10071_/A0 _14075_/Q wire480/A VDD VSS sg13g2_mux2_1
XFILLER_19_1128 VDD VSS sg13g2_decap_8
XFILLER_93_1057 VDD VSS sg13g2_decap_8
XFILLER_58_1188 VDD VSS sg13g2_fill_1
XFILLER_93_1068 VDD VSS sg13g2_fill_2
XFILLER_12_717 VDD VSS sg13g2_fill_1
X_08426_ _08429_/C _08617_/A _08426_/B VDD VSS sg13g2_nor2_1
XFILLER_11_216 VDD VSS sg13g2_decap_8
XFILLER_51_396 VDD VSS sg13g2_decap_4
X_08357_ _08357_/Y _07790_/A _15003_/Q _08674_/B1 VDD VSS sg13g2_o21ai_1
Xclkload3 clkload3/Y clkload3/A VDD VSS sg13g2_inv_1
XFILLER_50_36 VDD VSS sg13g2_decap_8
XFILLER_137_446 VDD VSS sg13g2_fill_2
X_08288_ _08315_/C _08258_/C _14998_/Q _07768_/A _08263_/B VDD VSS sg13g2_a22oi_1
XFILLER_152_427 VDD VSS sg13g2_decap_8
XFILLER_152_438 VDD VSS sg13g2_fill_1
X_10250_ _10258_/D _14776_/Q _14777_/Q _14778_/Q _10250_/D VDD VSS sg13g2_and4_1
XFILLER_156_1210 VDD VSS sg13g2_decap_8
XFILLER_79_706 VDD VSS sg13g2_fill_2
X_10181_ _10181_/Y _13613_/A _13508_/B _10174_/Y _13613_/B VDD VSS sg13g2_a22oi_1
XFILLER_65_1148 VDD VSS sg13g2_fill_2
XFILLER_117_1216 VDD VSS sg13g2_decap_8
XFILLER_79_739 VDD VSS sg13g2_fill_2
XFILLER_78_227 VDD VSS sg13g2_fill_2
Xfanout1205 fanout1205/X _15210_/Q VDD VSS sg13g2_buf_1
XFILLER_121_836 VDD VSS sg13g2_decap_8
Xfanout1216 _13048_/B _11243_/B VDD VSS sg13g2_buf_1
Xfanout1227 _13308_/A _13309_/A2 VDD VSS sg13g2_buf_1
XFILLER_121_869 VDD VSS sg13g2_decap_8
Xfanout1238 _10670_/A _15205_/Q VDD VSS sg13g2_buf_1
Xfanout1249 _13438_/B _13381_/B VDD VSS sg13g2_buf_1
Xfanout251 _09691_/A0 _09063_/X VDD VSS sg13g2_buf_1
Xfanout262 _09921_/A1 _09058_/Y VDD VSS sg13g2_buf_1
Xfanout273 _11701_/C1 _11522_/A2 VDD VSS sg13g2_buf_1
X_13940_ _13940_/Q clkload33/A _13940_/D _13940_/RESET_B VDD VSS sg13g2_dfrbpq_1
XFILLER_59_463 VDD VSS sg13g2_decap_4
Xclkbuf_5_20__f_clk_i clkbuf_leaf_48_clk_i/A clkbuf_4_10_0_clk_i/X VDD VSS sg13g2_buf_16
Xfanout284 _10151_/A1 _09919_/A1 VDD VSS sg13g2_buf_1
XFILLER_75_934 VDD VSS sg13g2_decap_4
XFILLER_8_1097 VDD VSS sg13g2_decap_8
Xfanout295 _09884_/A0 _09917_/A1 VDD VSS sg13g2_buf_1
XFILLER_75_44 VDD VSS sg13g2_decap_8
XFILLER_46_124 VDD VSS sg13g2_fill_2
XFILLER_47_647 VDD VSS sg13g2_decap_8
X_13871_ _13871_/Q clkload13/A _13871_/D _13871_/RESET_B VDD VSS sg13g2_dfrbpq_1
X_12822_ _12822_/X _14895_/Q _12836_/B VDD VSS sg13g2_xor2_1
XFILLER_28_883 VDD VSS sg13g2_decap_8
XFILLER_15_522 VDD VSS sg13g2_fill_2
X_12753_ _12753_/X _14712_/Q _14744_/Q _13784_/Q _13816_/Q _12757_/S0 _12757_/S1 VDD
+ VSS sg13g2_mux4_1
XFILLER_42_341 VDD VSS sg13g2_fill_1
X_11704_ _11707_/A _11663_/B _11771_/B _11771_/A VDD VSS sg13g2_a21o_1
X_12684_ _12684_/X _14131_/Q _14163_/Q _14195_/Q _14227_/Q _12689_/S0 _12689_/S1 VDD
+ VSS sg13g2_mux4_1
XFILLER_30_536 VDD VSS sg13g2_decap_4
X_14423_ _14423_/Q _14726_/CLK _14423_/D _14423_/RESET_B VDD VSS sg13g2_dfrbpq_1
XFILLER_129_903 VDD VSS sg13g2_decap_8
XFILLER_24_70 VDD VSS sg13g2_decap_8
X_11635_ _11773_/A _11635_/A _13681_/Q VDD VSS sg13g2_xnor2_1
XFILLER_128_402 VDD VSS sg13g2_fill_2
X_14354_ _14354_/Q clkload46/A _14354_/D _14354_/RESET_B VDD VSS sg13g2_dfrbpq_1
XFILLER_155_221 VDD VSS sg13g2_decap_8
X_11566_ _14966_/D _11566_/A _11566_/B VDD VSS sg13g2_nor2_1
Xwire641 wire641/X wire641/A VDD VSS sg13g2_buf_4
XFILLER_7_743 VDD VSS sg13g2_decap_4
XFILLER_156_777 VDD VSS sg13g2_fill_2
X_13305_ _13306_/C _13305_/A _13305_/B VDD VSS sg13g2_nor2_1
XFILLER_144_928 VDD VSS sg13g2_fill_1
X_10517_ _10519_/B _10521_/C wire388/X _14855_/Q VDD VSS sg13g2_a21oi_1
X_14285_ _14285_/Q clkload45/A _14285_/D _14285_/RESET_B VDD VSS sg13g2_dfrbpq_1
X_11497_ _11497_/Y _12191_/B1 _11495_/Y _12223_/A VDD VSS sg13g2_a21oi_1
XFILLER_6_264 VDD VSS sg13g2_fill_1
XFILLER_155_287 VDD VSS sg13g2_decap_8
Xmax_cap429 _09868_/S _09852_/S VDD VSS sg13g2_buf_4
X_13236_ _13236_/Y _14795_/Q _13236_/A2 _13236_/B1 VDD VSS sg13g2_o21ai_1
X_10448_ _10450_/B _10521_/C wire760/X _14839_/Q VDD VSS sg13g2_a21oi_1
XFILLER_124_641 VDD VSS sg13g2_decap_8
XFILLER_152_972 VDD VSS sg13g2_decap_4
XFILLER_3_971 VDD VSS sg13g2_decap_8
X_13167_ _15044_/D _13160_/Y _13166_/Y _13155_/A VDD VSS sg13g2_a21oi_1
XFILLER_152_994 VDD VSS sg13g2_decap_8
X_10379_ _14817_/D _10379_/A _10602_/A _10379_/C VDD VSS sg13g2_nor3_1
X_12118_ _12118_/Y _12116_/Y _12118_/B _12118_/C VDD VSS sg13g2_nand3b_1
XFILLER_97_547 VDD VSS sg13g2_decap_8
XFILLER_123_184 VDD VSS sg13g2_fill_1
XFILLER_111_346 VDD VSS sg13g2_decap_8
X_13098_ _13098_/X input13/X _12914_/A _13252_/B1 VDD VSS sg13g2_a21o_1
Xclkbuf_leaf_52_clk_i clkload48/A clkbuf_leaf_52_clk_i/A VDD VSS sg13g2_buf_8
Xfanout1750 fanout1750/X _11212_/S VDD VSS sg13g2_buf_1
XFILLER_38_603 VDD VSS sg13g2_decap_8
X_12049_ _12049_/Y _12048_/Y _11975_/A _12292_/A VDD VSS sg13g2_a21oi_1
XFILLER_78_783 VDD VSS sg13g2_decap_8
Xfanout1761 _13507_/A _13353_/A VDD VSS sg13g2_buf_1
Xfanout1772 _10213_/A _13005_/C VDD VSS sg13g2_buf_1
Xfanout1783 _13356_/B _13363_/B VDD VSS sg13g2_buf_1
Xfanout1794 fanout1794/X fanout1795/X VDD VSS sg13g2_buf_1
X_16857_ _16857_/X _16857_/A VDD VSS sg13g2_buf_1
XFILLER_1_63 VDD VSS sg13g2_decap_8
XFILLER_92_252 VDD VSS sg13g2_fill_2
XFILLER_80_425 VDD VSS sg13g2_fill_1
Xclkbuf_leaf_67_clk_i clkload74/A clkbuf_leaf_67_clk_i/A VDD VSS sg13g2_buf_8
XFILLER_45_190 VDD VSS sg13g2_fill_2
X_09260_ _13869_/D _13869_/Q _10156_/A1 _09264_/S VDD VSS sg13g2_mux2_1
X_08211_ _15224_/D _08211_/A _08211_/B _08211_/C _08211_/D VDD VSS sg13g2_nand4_1
X_09191_ _13807_/D _13807_/Q _09893_/A0 _09201_/S VDD VSS sg13g2_mux2_1
XFILLER_14_1014 VDD VSS sg13g2_decap_4
XFILLER_119_413 VDD VSS sg13g2_fill_2
XFILLER_144_1191 VDD VSS sg13g2_decap_8
X_14547__2017 _14547_/RESET_B VDD VSS sg13g2_tiehi
X_08142_ _08142_/Y _08456_/A _08142_/B _08142_/C VDD VSS sg13g2_nand3_1
XFILLER_146_221 VDD VSS sg13g2_decap_8
XFILLER_88_1104 VDD VSS sg13g2_fill_1
XFILLER_135_906 VDD VSS sg13g2_fill_2
XFILLER_147_777 VDD VSS sg13g2_decap_8
XFILLER_146_254 VDD VSS sg13g2_decap_8
X_08073_ _08074_/C _08073_/A _08073_/B _08073_/C VDD VSS sg13g2_nand3_1
XFILLER_101_1039 VDD VSS sg13g2_fill_2
XFILLER_135_939 VDD VSS sg13g2_decap_8
XFILLER_20_28 VDD VSS sg13g2_decap_8
XFILLER_136_28 VDD VSS sg13g2_decap_8
XFILLER_143_972 VDD VSS sg13g2_fill_2
XFILLER_88_503 VDD VSS sg13g2_fill_2
XFILLER_88_536 VDD VSS sg13g2_decap_8
X_08975_ _10675_/C _15220_/Q _09085_/B VDD VSS sg13g2_nor2b_1
XFILLER_69_750 VDD VSS sg13g2_fill_1
XFILLER_88_569 VDD VSS sg13g2_fill_2
XFILLER_64_1181 VDD VSS sg13g2_decap_8
XFILLER_151_1140 VDD VSS sg13g2_decap_8
X_07926_ _07926_/X _07926_/A _07926_/B VDD VSS sg13g2_or2_1
XFILLER_60_1034 VDD VSS sg13g2_decap_8
XFILLER_152_49 VDD VSS sg13g2_decap_8
XFILLER_25_1165 VDD VSS sg13g2_decap_8
X_07857_ _07857_/X _15014_/Q _07859_/B VDD VSS sg13g2_or2_1
X_14153__2411 _14153_/RESET_B VDD VSS sg13g2_tiehi
XFILLER_44_606 VDD VSS sg13g2_decap_4
XFILLER_45_14 VDD VSS sg13g2_decap_8
XFILLER_45_25 VDD VSS sg13g2_fill_2
XFILLER_147_1209 VDD VSS sg13g2_decap_8
X_07788_ _07797_/C _08414_/A _08414_/B _08414_/D VDD VSS sg13g2_o21ai_1
X_09527_ _14126_/D _10157_/A1 _14126_/Q _09527_/S VDD VSS sg13g2_mux2_1
XFILLER_45_69 VDD VSS sg13g2_decap_4
XFILLER_24_330 VDD VSS sg13g2_fill_1
XFILLER_101_20 VDD VSS sg13g2_fill_1
XFILLER_12_503 VDD VSS sg13g2_decap_8
XFILLER_80_992 VDD VSS sg13g2_decap_8
X_09458_ _14059_/D _10087_/A0 _14059_/Q _09472_/S VDD VSS sg13g2_mux2_1
XFILLER_24_396 VDD VSS sg13g2_fill_1
X_08409_ _08410_/B _08452_/C _08407_/Y _08408_/Y VDD VSS sg13g2_a21o_1
X_14186__2378 _14186_/RESET_B VDD VSS sg13g2_tiehi
X_09389_ _13992_/D _09655_/A0 _13992_/Q _09391_/S VDD VSS sg13g2_mux2_1
XFILLER_8_518 VDD VSS sg13g2_decap_8
XFILLER_123_1220 VDD VSS sg13g2_decap_8
X_11420_ _11420_/Y _11420_/A _11420_/B _11420_/C VDD VSS sg13g2_nand3_1
X_11351_ _11351_/Y _11347_/Y _11348_/Y _11350_/Y _11349_/Y _11230_/S VDD VSS sg13g2_a221oi_1
XFILLER_152_202 VDD VSS sg13g2_decap_4
XFILLER_119_991 VDD VSS sg13g2_fill_1
X_10302_ _14794_/D _14794_/Q _10299_/Y _10301_/Y VDD VSS sg13g2_a21oi_1
XFILLER_137_298 VDD VSS sg13g2_decap_8
XFILLER_152_235 VDD VSS sg13g2_decap_8
XFILLER_3_212 VDD VSS sg13g2_decap_8
X_14070_ _14070_/Q _14710_/CLK _14070_/D _14070_/RESET_B VDD VSS sg13g2_dfrbpq_1
X_11282_ _11283_/A _13948_/Q _13980_/Q _14012_/Q _14044_/Q _11277_/S _11282_/S1 VDD
+ VSS sg13g2_mux4_1
X_13021_ _15034_/D _13239_/A _13021_/B VDD VSS sg13g2_nor2_1
X_10233_ _10237_/D _14772_/Q _14773_/Q VDD VSS sg13g2_nand2_1
XFILLER_79_514 VDD VSS sg13g2_decap_8
XFILLER_117_1002 VDD VSS sg13g2_decap_8
XFILLER_133_493 VDD VSS sg13g2_fill_1
X_10164_ _14741_/D _14741_/Q _09131_/X _10168_/S VDD VSS sg13g2_mux2_1
Xfanout1002 _08723_/B _13412_/C VDD VSS sg13g2_buf_1
XFILLER_117_1035 VDD VSS sg13g2_decap_4
XFILLER_156_1095 VDD VSS sg13g2_fill_1
Xfanout1013 _08511_/S _07631_/Y VDD VSS sg13g2_buf_1
Xfanout1024 _08544_/C _08173_/B VDD VSS sg13g2_buf_1
Xfanout1035 _13550_/A1 _07626_/Y VDD VSS sg13g2_buf_1
Xfanout1046 _10835_/B2 _08724_/B VDD VSS sg13g2_buf_1
X_14972_ _14972_/Q clkload38/A _14972_/D _14972_/RESET_B VDD VSS sg13g2_dfrbpq_1
X_10095_ _14675_/D _10162_/A1 _14675_/Q _10096_/S VDD VSS sg13g2_mux2_1
Xfanout1057 _12678_/S _12789_/S1 VDD VSS sg13g2_buf_1
X_14993__2979 _14993_/RESET_B VDD VSS sg13g2_tiehi
Xfanout1068 _12483_/S _12734_/S VDD VSS sg13g2_buf_1
XFILLER_47_422 VDD VSS sg13g2_decap_8
XFILLER_120_198 VDD VSS sg13g2_fill_1
X_13923_ _13923_/Q _14633_/CLK _13923_/D _13923_/RESET_B VDD VSS sg13g2_dfrbpq_1
XFILLER_19_70 VDD VSS sg13g2_decap_8
XFILLER_48_978 VDD VSS sg13g2_fill_1
XFILLER_90_701 VDD VSS sg13g2_decap_8
X_13854_ _13854_/Q clkload59/A _13854_/D _13854_/RESET_B VDD VSS sg13g2_dfrbpq_1
XFILLER_28_680 VDD VSS sg13g2_fill_2
X_14907__3115 _14907_/RESET_B VDD VSS sg13g2_tiehi
X_12805_ _12805_/Y _13149_/A2 _12802_/Y _12804_/Y VDD VSS sg13g2_o21ai_1
XFILLER_90_778 VDD VSS sg13g2_decap_8
X_13785_ _13785_/Q clkload42/A _13785_/D _13785_/RESET_B VDD VSS sg13g2_dfrbpq_1
X_10997_ _10997_/Y _10995_/Y _10996_/Y _10969_/B VDD VSS sg13g2_o21ai_1
XFILLER_43_661 VDD VSS sg13g2_decap_8
XFILLER_90_789 VDD VSS sg13g2_fill_2
XFILLER_31_812 VDD VSS sg13g2_fill_2
XFILLER_71_981 VDD VSS sg13g2_fill_2
X_12736_ _15016_/D _12736_/A wire368/X VDD VSS sg13g2_nor2_1
XFILLER_128_1186 VDD VSS sg13g2_decap_8
X_14016__2548 _14016_/RESET_B VDD VSS sg13g2_tiehi
X_12667_ _12680_/A _12709_/A1 _12779_/A2 _15012_/Q VDD VSS sg13g2_a21oi_1
X_13851__2713 _13851_/RESET_B VDD VSS sg13g2_tiehi
XFILLER_50_1203 VDD VSS sg13g2_decap_4
X_14406_ _14406_/Q clkload17/A _14406_/D _14406_/RESET_B VDD VSS sg13g2_dfrbpq_1
XFILLER_50_1225 VDD VSS sg13g2_decap_8
X_11618_ _11618_/Y _12206_/S0 _13894_/Q VDD VSS sg13g2_nand2b_1
XFILLER_50_1236 VDD VSS sg13g2_fill_1
X_12598_ _12611_/A _10671_/B _12779_/A2 _13555_/A VDD VSS sg13g2_a21oi_1
XFILLER_117_917 VDD VSS sg13g2_decap_4
X_14337_ _14337_/Q _14465_/CLK _14337_/D _14337_/RESET_B VDD VSS sg13g2_dfrbpq_1
X_11549_ _11549_/X _11549_/A _12246_/B VDD VSS sg13g2_and2_1
XFILLER_7_573 VDD VSS sg13g2_fill_1
Xmax_cap215 _10385_/C _10391_/C VDD VSS sg13g2_buf_1
XFILLER_144_736 VDD VSS sg13g2_decap_8
Xwire482 wire482/X wire482/A VDD VSS sg13g2_buf_8
X_13661__1809 _13661_/RESET_B VDD VSS sg13g2_tiehi
X_14268_ _14268_/Q _14776_/CLK _14268_/D _14268_/RESET_B VDD VSS sg13g2_dfrbpq_1
X_14231__2333 _14231_/RESET_B VDD VSS sg13g2_tiehi
XFILLER_83_1001 VDD VSS sg13g2_decap_8
X_13219_ _13219_/Y _14826_/Q _13206_/B _13249_/B _14890_/Q _13274_/C1 VDD VSS sg13g2_a221oi_1
XFILLER_124_460 VDD VSS sg13g2_fill_2
X_14199_ _14199_/Q clkload9/A _14199_/D _14199_/RESET_B VDD VSS sg13g2_dfrbpq_1
XFILLER_97_322 VDD VSS sg13g2_fill_2
XFILLER_135_1157 VDD VSS sg13g2_fill_1
XFILLER_97_366 VDD VSS sg13g2_decap_4
X_15118__3108 _15118_/RESET_B VDD VSS sg13g2_tiehi
XFILLER_97_388 VDD VSS sg13g2_fill_1
X_08760_ _08760_/Y _13343_/B _11288_/A _15190_/Q VDD VSS sg13g2_o21ai_1
XFILLER_66_731 VDD VSS sg13g2_decap_8
XFILLER_18_0 VDD VSS sg13g2_decap_8
XFILLER_39_956 VDD VSS sg13g2_decap_8
X_07711_ _07748_/B _13302_/C _07754_/B VDD VSS sg13g2_and2_1
Xfanout1580 _12173_/B1 _12265_/B1 VDD VSS sg13g2_buf_1
X_08691_ _08693_/B _08692_/C _08048_/B _08690_/X VDD VSS sg13g2_o21ai_1
Xfanout1591 _12174_/A _11284_/B1 VDD VSS sg13g2_buf_1
X_07642_ _10265_/C _14783_/Q VDD VSS sg13g2_inv_1
XFILLER_53_414 VDD VSS sg13g2_fill_2
XFILLER_93_583 VDD VSS sg13g2_decap_4
XFILLER_25_116 VDD VSS sg13g2_decap_8
XFILLER_20_1051 VDD VSS sg13g2_decap_8
XFILLER_25_127 VDD VSS sg13g2_fill_2
XFILLER_81_767 VDD VSS sg13g2_decap_8
XFILLER_81_778 VDD VSS sg13g2_fill_2
XFILLER_15_28 VDD VSS sg13g2_decap_8
XFILLER_0_1167 VDD VSS sg13g2_decap_8
X_09312_ _13919_/D _10142_/A1 _13919_/Q _09312_/S VDD VSS sg13g2_mux2_1
XFILLER_0_1178 VDD VSS sg13g2_fill_1
XFILLER_55_1147 VDD VSS sg13g2_fill_1
XFILLER_21_322 VDD VSS sg13g2_decap_8
X_09243_ _13852_/D _13852_/Q _10072_/A0 _09261_/S VDD VSS sg13g2_mux2_1
XFILLER_139_519 VDD VSS sg13g2_decap_4
XFILLER_33_193 VDD VSS sg13g2_decap_8
XFILLER_22_878 VDD VSS sg13g2_decap_8
XFILLER_21_366 VDD VSS sg13g2_decap_8
X_09174_ _13790_/D _13790_/Q _10074_/A0 _09190_/S VDD VSS sg13g2_mux2_1
X_08125_ _08126_/B _08688_/D _08124_/X _08125_/S VDD VSS sg13g2_mux2_1
XFILLER_108_928 VDD VSS sg13g2_decap_8
XFILLER_107_416 VDD VSS sg13g2_decap_8
XFILLER_147_49 VDD VSS sg13g2_decap_8
X_08056_ _08056_/Y _08167_/B _08198_/S VDD VSS sg13g2_nand2b_1
XFILLER_134_246 VDD VSS sg13g2_fill_2
XFILLER_116_950 VDD VSS sg13g2_decap_8
XFILLER_116_961 VDD VSS sg13g2_fill_2
XFILLER_116_972 VDD VSS sg13g2_fill_2
XFILLER_1_716 VDD VSS sg13g2_decap_8
Xoutput49 mem_axi_araddr[20] _16873_/A VDD VSS sg13g2_buf_1
XFILLER_89_823 VDD VSS sg13g2_fill_2
XFILLER_88_322 VDD VSS sg13g2_fill_1
X_08958_ _10105_/D _09905_/A _09806_/A VDD VSS sg13g2_nor2_1
XFILLER_102_198 VDD VSS sg13g2_fill_2
XFILLER_5_1045 VDD VSS sg13g2_decap_8
XFILLER_56_35 VDD VSS sg13g2_decap_8
X_07909_ _07909_/Y _14994_/Q _07909_/B VDD VSS sg13g2_nor2_1
XFILLER_57_753 VDD VSS sg13g2_fill_2
XFILLER_45_904 VDD VSS sg13g2_fill_1
X_08889_ _13705_/D _08935_/S _08887_/Y _08888_/Y VDD VSS sg13g2_a21oi_1
XFILLER_17_606 VDD VSS sg13g2_decap_8
X_10920_ _10934_/B _10920_/A _10920_/B VDD VSS sg13g2_nand2_1
XFILLER_72_734 VDD VSS sg13g2_decap_4
XFILLER_99_1096 VDD VSS sg13g2_fill_1
X_10851_ _10871_/B _10851_/A _10870_/A _10851_/C _10851_/D VDD VSS sg13g2_nand4_1
XFILLER_147_1039 VDD VSS sg13g2_decap_8
XFILLER_60_918 VDD VSS sg13g2_fill_1
XFILLER_53_970 VDD VSS sg13g2_fill_1
X_13570_ _15155_/D _15155_/Q _13569_/X _13570_/S VDD VSS sg13g2_mux2_1
X_10782_ _11164_/C _14953_/Q _08943_/A _10781_/X VDD VSS sg13g2_a21oi_1
XFILLER_73_1236 VDD VSS sg13g2_fill_1
XFILLER_72_67 VDD VSS sg13g2_decap_8
X_12521_ _12521_/X _14119_/Q _14151_/Q _14183_/Q _14215_/Q _12521_/S0 _12685_/S1 VDD
+ VSS sg13g2_mux4_1
XFILLER_9_816 VDD VSS sg13g2_fill_1
XFILLER_9_838 VDD VSS sg13g2_decap_4
XFILLER_9_849 VDD VSS sg13g2_decap_4
X_15240_ _15240_/Q clkload68/A _15240_/D _15240_/RESET_B VDD VSS sg13g2_dfrbpq_1
X_12452_ _12452_/X _14242_/Q _14274_/Q _14306_/Q _14338_/Q _12452_/S0 _12452_/S1 VDD
+ VSS sg13g2_mux4_1
XFILLER_8_359 VDD VSS sg13g2_decap_4
XFILLER_122_0 VDD VSS sg13g2_decap_8
X_11403_ _11403_/X _13727_/Q _14079_/Q _14431_/Q _14527_/Q _11415_/S _11419_/C VDD
+ VSS sg13g2_mux4_1
X_15171_ _15171_/Q clkload73/A _15171_/D _15171_/RESET_B VDD VSS sg13g2_dfrbpq_1
X_12383_ _12383_/X _12376_/X _12380_/X _12375_/X _12379_/X _12678_/S wire1090/X VDD
+ VSS sg13g2_mux4_1
X_14122_ _14122_/Q clkload25/A _14122_/D _14122_/RESET_B VDD VSS sg13g2_dfrbpq_1
XFILLER_10_1220 VDD VSS sg13g2_decap_8
XFILLER_67_1007 VDD VSS sg13g2_decap_8
XFILLER_4_521 VDD VSS sg13g2_decap_8
X_11334_ _11336_/A _11335_/A _13691_/Q VDD VSS sg13g2_and2_1
XFILLER_126_758 VDD VSS sg13g2_fill_1
XFILLER_153_555 VDD VSS sg13g2_decap_8
XFILLER_99_609 VDD VSS sg13g2_fill_2
XFILLER_107_950 VDD VSS sg13g2_fill_1
XFILLER_119_1119 VDD VSS sg13g2_decap_8
XFILLER_140_205 VDD VSS sg13g2_fill_2
X_14053_ _14053_/Q clkload0/A _14053_/D _14053_/RESET_B VDD VSS sg13g2_dfrbpq_1
X_11265_ _11266_/A _14684_/Q _14716_/Q _13756_/Q _13788_/Q _11275_/S0 _11262_/B VDD
+ VSS sg13g2_mux4_1
XFILLER_79_300 VDD VSS sg13g2_fill_1
XFILLER_140_216 VDD VSS sg13g2_decap_8
XFILLER_106_471 VDD VSS sg13g2_fill_1
X_13004_ wire238/A _12999_/Y _13048_/B _13003_/Y VDD VSS sg13g2_a21oi_1
X_10216_ _10216_/Y _13499_/B _10216_/B VDD VSS sg13g2_nor2_1
XFILLER_122_953 VDD VSS sg13g2_fill_1
X_11196_ _11209_/A _11196_/A _11196_/B VDD VSS sg13g2_nand2_1
X_13688__2881 _13688_/RESET_B VDD VSS sg13g2_tiehi
XFILLER_122_975 VDD VSS sg13g2_decap_8
XFILLER_79_366 VDD VSS sg13g2_decap_8
X_10147_ _14724_/D _14724_/Q _10147_/A1 _10167_/S VDD VSS sg13g2_mux2_1
XFILLER_153_70 VDD VSS sg13g2_decap_8
XFILLER_0_793 VDD VSS sg13g2_fill_2
XFILLER_48_731 VDD VSS sg13g2_decap_8
XFILLER_11_7 VDD VSS sg13g2_decap_8
XFILLER_43_1073 VDD VSS sg13g2_fill_2
X_14955_ _14955_/Q clkload19/A _14955_/D _14955_/RESET_B VDD VSS sg13g2_dfrbpq_1
XFILLER_94_358 VDD VSS sg13g2_decap_8
X_10078_ _14658_/D _10078_/A0 _14658_/Q _10096_/S VDD VSS sg13g2_mux2_1
XFILLER_130_1054 VDD VSS sg13g2_fill_2
XFILLER_36_937 VDD VSS sg13g2_decap_8
X_13906_ _13906_/Q _14916_/CLK _13906_/D _13906_/RESET_B VDD VSS sg13g2_dfrbpq_1
X_14886_ _14886_/Q clkload79/A _14886_/D _14886_/RESET_B VDD VSS sg13g2_dfrbpq_1
XFILLER_78_1147 VDD VSS sg13g2_decap_8
XFILLER_130_1087 VDD VSS sg13g2_fill_2
XFILLER_63_756 VDD VSS sg13g2_decap_8
XFILLER_78_1158 VDD VSS sg13g2_fill_1
X_13837_ _13837_/Q clkload55/A _13837_/D _13837_/RESET_B VDD VSS sg13g2_dfrbpq_1
XFILLER_50_406 VDD VSS sg13g2_fill_2
X_14249__2315 _14249_/RESET_B VDD VSS sg13g2_tiehi
X_13768_ _13768_/Q _15148_/CLK _13768_/D _13768_/RESET_B VDD VSS sg13g2_dfrbpq_1
XFILLER_15_182 VDD VSS sg13g2_decap_4
X_15147__3048 _15147_/RESET_B VDD VSS sg13g2_tiehi
X_12719_ _12719_/X _12710_/X _12711_/X _12717_/X _12716_/X _12719_/S0 _12581_/S VDD
+ VSS sg13g2_mux4_1
XFILLER_31_664 VDD VSS sg13g2_fill_1
X_13699_ _13699_/Q clkload33/A _13699_/D _13699_/RESET_B VDD VSS sg13g2_dfrbpq_1
XFILLER_50_1000 VDD VSS sg13g2_decap_8
XFILLER_89_1210 VDD VSS sg13g2_decap_8
XFILLER_15_1164 VDD VSS sg13g2_decap_8
X_14464__2100 _14464_/RESET_B VDD VSS sg13g2_tiehi
XFILLER_7_84 VDD VSS sg13g2_decap_8
XFILLER_117_758 VDD VSS sg13g2_decap_4
XFILLER_137_1219 VDD VSS sg13g2_decap_8
X_09930_ _14515_/D _14515_/Q _09930_/A1 _09930_/S VDD VSS sg13g2_mux2_1
XFILLER_125_780 VDD VSS sg13g2_decap_8
XFILLER_131_216 VDD VSS sg13g2_decap_8
X_09861_ _14448_/D _14448_/Q _10092_/A0 _09870_/S VDD VSS sg13g2_mux2_1
Xfanout817 _13236_/B1 _13140_/B2 VDD VSS sg13g2_buf_1
Xfanout828 _13561_/S _12793_/Y VDD VSS sg13g2_buf_1
XFILLER_98_664 VDD VSS sg13g2_decap_8
Xfanout839 _11074_/B wire844/X VDD VSS sg13g2_buf_1
XFILLER_98_675 VDD VSS sg13g2_fill_1
X_08812_ _08812_/Y _13482_/A _15193_/Q VDD VSS sg13g2_nand2_1
X_14497__2067 _14497_/RESET_B VDD VSS sg13g2_tiehi
X_09792_ _14381_/D _09924_/A1 _14381_/Q wire633/X VDD VSS sg13g2_mux2_1
XFILLER_133_18 VDD VSS sg13g2_decap_8
X_08743_ _08743_/Y _13666_/Q _08752_/B VDD VSS sg13g2_nor2_1
XFILLER_22_1135 VDD VSS sg13g2_decap_8
X_08674_ _08674_/Y _08684_/A _08674_/A2 _08674_/B1 _08673_/X _08672_/X VDD VSS sg13g2_a221oi_1
XFILLER_54_734 VDD VSS sg13g2_fill_2
XFILLER_26_49 VDD VSS sg13g2_decap_8
X_07625_ _07625_/Y _07625_/A VDD VSS sg13g2_inv_1
XFILLER_53_233 VDD VSS sg13g2_fill_2
XFILLER_54_767 VDD VSS sg13g2_decap_8
XFILLER_81_542 VDD VSS sg13g2_decap_8
XFILLER_53_266 VDD VSS sg13g2_fill_2
XFILLER_13_119 VDD VSS sg13g2_decap_4
XFILLER_41_439 VDD VSS sg13g2_decap_8
XFILLER_139_316 VDD VSS sg13g2_decap_8
XFILLER_146_1094 VDD VSS sg13g2_decap_8
X_09226_ _13837_/D _10156_/A1 _13837_/Q _09230_/S VDD VSS sg13g2_mux2_1
XFILLER_50_995 VDD VSS sg13g2_fill_1
XFILLER_10_859 VDD VSS sg13g2_fill_1
XFILLER_154_308 VDD VSS sg13g2_decap_8
XFILLER_21_196 VDD VSS sg13g2_decap_8
X_09157_ _09158_/C _14924_/Q _14923_/Q _09157_/C _09157_/D VDD VSS sg13g2_nand4_1
XFILLER_5_329 VDD VSS sg13g2_decap_8
X_08108_ _08112_/C _15104_/Q _15091_/Q _08105_/Y VDD VSS sg13g2_o21ai_1
X_13947__2617 _13947_/RESET_B VDD VSS sg13g2_tiehi
X_09088_ _09103_/D _14914_/Q _14913_/Q _13088_/A VDD VSS sg13g2_and3_1
XFILLER_107_257 VDD VSS sg13g2_decap_8
XFILLER_135_577 VDD VSS sg13g2_decap_8
X_08039_ _08039_/Y _08039_/A _08039_/B _08039_/C _08039_/D VDD VSS sg13g2_nand4_1
XFILLER_104_942 VDD VSS sg13g2_decap_8
Xmax_cap590 _10135_/S _10136_/S VDD VSS sg13g2_buf_4
X_11050_ _11051_/B _11036_/Y _11064_/C _11032_/Y VDD VSS sg13g2_a21oi_1
XFILLER_66_1084 VDD VSS sg13g2_decap_4
XFILLER_131_750 VDD VSS sg13g2_fill_1
X_10001_ _14584_/D _10167_/A1 _14584_/Q wire613/X VDD VSS sg13g2_mux2_1
XFILLER_27_1068 VDD VSS sg13g2_decap_8
X_14327__2237 _14327_/RESET_B VDD VSS sg13g2_tiehi
XFILLER_67_56 VDD VSS sg13g2_fill_2
XFILLER_130_282 VDD VSS sg13g2_decap_8
XFILLER_114_1049 VDD VSS sg13g2_fill_1
XFILLER_40_1224 VDD VSS sg13g2_decap_8
XFILLER_76_358 VDD VSS sg13g2_decap_8
XFILLER_40_1235 VDD VSS sg13g2_fill_2
XFILLER_57_561 VDD VSS sg13g2_fill_1
X_14740_ _14740_/Q clkload8/A _14740_/D _14740_/RESET_B VDD VSS sg13g2_dfrbpq_1
XFILLER_45_712 VDD VSS sg13g2_fill_2
X_11952_ _11953_/B _11952_/A _11952_/B _11970_/C VDD VSS sg13g2_nand3_1
XFILLER_44_222 VDD VSS sg13g2_decap_8
X_10903_ _10903_/Y _10903_/A _10903_/B VDD VSS sg13g2_nand2_1
X_14671_ _14671_/Q _14671_/CLK _14671_/D _14671_/RESET_B VDD VSS sg13g2_dfrbpq_1
X_11883_ _11883_/X _12324_/B _11882_/X _11881_/Y VDD VSS sg13g2_a21o_1
X_14542__2022 _14542_/RESET_B VDD VSS sg13g2_tiehi
X_13622_ _13730_/D _13622_/A VDD VSS sg13g2_buf_1
XFILLER_38_1120 VDD VSS sg13g2_fill_2
X_10834_ _10834_/Y _11070_/A1 _10876_/D _10830_/X _10832_/X VDD VSS sg13g2_a22oi_1
XFILLER_16_93 VDD VSS sg13g2_fill_1
XFILLER_13_642 VDD VSS sg13g2_fill_2
X_13553_ wire731/A _13553_/A1 _13600_/B _13552_/Y VDD VSS sg13g2_a21oi_1
X_14796__3302 _14796_/RESET_B VDD VSS sg13g2_tiehi
X_10765_ _10765_/Y _13168_/A _11196_/B VDD VSS sg13g2_nand2_1
XFILLER_8_112 VDD VSS sg13g2_fill_2
X_12504_ _12504_/X _14694_/Q _14726_/Q _13766_/Q _13798_/Q _12745_/S0 _12745_/S1 VDD
+ VSS sg13g2_mux4_1
XFILLER_73_1088 VDD VSS sg13g2_decap_8
XFILLER_12_174 VDD VSS sg13g2_decap_8
XFILLER_9_646 VDD VSS sg13g2_fill_2
X_13484_ _15123_/D _13484_/A _13484_/B _13484_/C VDD VSS sg13g2_nand3_1
X_10696_ _14901_/D _10696_/A VDD VSS sg13g2_inv_1
X_15223_ _15223_/Q clkload40/A _15223_/D _15223_/RESET_B VDD VSS sg13g2_dfrbpq_1
XFILLER_145_319 VDD VSS sg13g2_fill_2
X_12435_ _12435_/X _14113_/Q _14145_/Q _14177_/Q _14209_/Q _12529_/S0 _12534_/S1 VDD
+ VSS sg13g2_mux4_1
XFILLER_148_70 VDD VSS sg13g2_decap_8
Xmax_cap1668 _11493_/S0 _11489_/S0 VDD VSS sg13g2_buf_4
X_15154_ _15154_/Q _15160_/CLK _15154_/D _15154_/RESET_B VDD VSS sg13g2_dfrbpq_1
X_12366_ _12366_/X _13724_/Q _14076_/Q _14428_/Q _14524_/Q _12366_/S0 _12366_/S1 VDD
+ VSS sg13g2_mux4_1
XFILLER_154_875 VDD VSS sg13g2_decap_8
XFILLER_59_7 VDD VSS sg13g2_decap_8
X_14105_ _14105_/Q clkload43/A _14105_/D _14105_/RESET_B VDD VSS sg13g2_dfrbpq_1
X_11317_ _11318_/A _11317_/A1 _14493_/Q _12304_/B VDD VSS sg13g2_a21oi_1
XFILLER_4_362 VDD VSS sg13g2_decap_8
XFILLER_5_885 VDD VSS sg13g2_decap_8
X_15085_ _15085_/Q clkload71/A _15085_/D _15085_/RESET_B VDD VSS sg13g2_dfrbpq_1
XFILLER_5_896 VDD VSS sg13g2_fill_2
X_12297_ _14987_/D _12297_/A _12297_/B VDD VSS sg13g2_nand2_1
XFILLER_10_1094 VDD VSS sg13g2_decap_8
XFILLER_113_238 VDD VSS sg13g2_decap_8
XFILLER_141_558 VDD VSS sg13g2_decap_4
X_14036_ _14036_/Q clkload16/A _14036_/D _14036_/RESET_B VDD VSS sg13g2_dfrbpq_1
X_11248_ _11248_/Y _11248_/A _11248_/B VDD VSS sg13g2_nor2_1
XFILLER_68_837 VDD VSS sg13g2_decap_8
X_11179_ _11179_/X _11186_/B _11179_/B VDD VSS sg13g2_and2_1
XFILLER_68_848 VDD VSS sg13g2_decap_4
XFILLER_95_634 VDD VSS sg13g2_fill_1
XFILLER_95_645 VDD VSS sg13g2_decap_8
XFILLER_82_317 VDD VSS sg13g2_fill_1
X_14938_ _14938_/Q clkload34/A _14938_/D _14938_/RESET_B VDD VSS sg13g2_dfrbpq_1
X_14181__2383 _14181_/RESET_B VDD VSS sg13g2_tiehi
XFILLER_35_233 VDD VSS sg13g2_fill_1
XFILLER_36_756 VDD VSS sg13g2_decap_8
XFILLER_36_767 VDD VSS sg13g2_fill_2
XFILLER_36_778 VDD VSS sg13g2_fill_1
XFILLER_63_564 VDD VSS sg13g2_decap_8
X_14869_ _14869_/Q _14873_/CLK _14869_/D _14869_/RESET_B VDD VSS sg13g2_dfrbpq_1
XFILLER_51_737 VDD VSS sg13g2_decap_8
X_08390_ _08390_/Y _07790_/A _08612_/S _08412_/A VDD VSS sg13g2_o21ai_1
XFILLER_17_1204 VDD VSS sg13g2_decap_8
XFILLER_91_1144 VDD VSS sg13g2_decap_8
XFILLER_143_1234 VDD VSS sg13g2_fill_2
XFILLER_85_0 VDD VSS sg13g2_decap_8
XFILLER_31_483 VDD VSS sg13g2_decap_8
X_15250__3086 _15250_/RESET_B VDD VSS sg13g2_tiehi
X_09011_ _09011_/Y _09011_/A _09011_/B _09011_/C _09011_/D VDD VSS sg13g2_nor4_1
X_14405__2159 _14405_/RESET_B VDD VSS sg13g2_tiehi
XFILLER_145_820 VDD VSS sg13g2_decap_8
XFILLER_117_522 VDD VSS sg13g2_decap_8
XFILLER_145_842 VDD VSS sg13g2_fill_2
XFILLER_89_1062 VDD VSS sg13g2_decap_8
XFILLER_144_363 VDD VSS sg13g2_decap_4
XFILLER_132_525 VDD VSS sg13g2_fill_2
XFILLER_99_940 VDD VSS sg13g2_fill_2
X_09913_ _14498_/D _14498_/Q _09913_/A1 _09933_/S VDD VSS sg13g2_mux2_1
XFILLER_144_28 VDD VSS sg13g2_decap_8
XFILLER_63_1224 VDD VSS sg13g2_decap_8
Xfanout614 _09835_/S wire618/X VDD VSS sg13g2_buf_1
Xfanout625 _09802_/S wire629/X VDD VSS sg13g2_buf_1
XFILLER_59_815 VDD VSS sg13g2_decap_8
XFILLER_63_1235 VDD VSS sg13g2_fill_2
Xfanout636 _09667_/S wire639/A VDD VSS sg13g2_buf_1
XFILLER_98_472 VDD VSS sg13g2_fill_1
X_09844_ _14431_/D _14431_/Q _10075_/A0 _09844_/S VDD VSS sg13g2_mux2_1
XFILLER_59_848 VDD VSS sg13g2_decap_8
XFILLER_100_411 VDD VSS sg13g2_decap_8
Xfanout658 _09512_/S _09539_/S VDD VSS sg13g2_buf_1
XFILLER_150_1227 VDD VSS sg13g2_decap_8
X_09775_ _14364_/D _09907_/A1 _14364_/Q wire633/A VDD VSS sg13g2_mux2_1
XFILLER_101_978 VDD VSS sg13g2_decap_8
XFILLER_6_1173 VDD VSS sg13g2_decap_8
XFILLER_39_572 VDD VSS sg13g2_decap_8
X_08726_ _08727_/D _13499_/C _13481_/A VDD VSS sg13g2_or2_1
XFILLER_39_583 VDD VSS sg13g2_fill_1
XFILLER_66_380 VDD VSS sg13g2_fill_2
XFILLER_73_339 VDD VSS sg13g2_fill_1
X_14011__2553 _14011_/RESET_B VDD VSS sg13g2_tiehi
XFILLER_2_1059 VDD VSS sg13g2_decap_8
X_08657_ _08657_/Y _08079_/S _08655_/Y _08656_/X VDD VSS sg13g2_a21oi_1
XFILLER_57_1006 VDD VSS sg13g2_decap_8
XFILLER_42_726 VDD VSS sg13g2_decap_4
XFILLER_53_14 VDD VSS sg13g2_decap_8
XFILLER_53_25 VDD VSS sg13g2_fill_1
XFILLER_81_372 VDD VSS sg13g2_decap_4
XFILLER_109_1118 VDD VSS sg13g2_decap_8
XFILLER_144_1009 VDD VSS sg13g2_fill_1
X_14615__1949 _14615_/RESET_B VDD VSS sg13g2_tiehi
X_08588_ _08596_/A _08587_/Y _08588_/B _08588_/C VDD VSS sg13g2_nand3b_1
XFILLER_41_225 VDD VSS sg13g2_decap_4
XFILLER_81_394 VDD VSS sg13g2_fill_2
XFILLER_50_792 VDD VSS sg13g2_decap_4
X_10550_ _10550_/Y _14865_/Q _10556_/D _13356_/B VDD VSS sg13g2_o21ai_1
XFILLER_139_168 VDD VSS sg13g2_decap_8
X_09209_ _13820_/D _10072_/A0 _13820_/Q _09230_/S VDD VSS sg13g2_mux2_1
XFILLER_154_105 VDD VSS sg13g2_decap_8
XFILLER_6_616 VDD VSS sg13g2_fill_1
X_10481_ _10481_/Y _13084_/A _14847_/Q _14846_/Q _10492_/C VDD VSS sg13g2_nand4_1
XFILLER_10_678 VDD VSS sg13g2_fill_1
XFILLER_6_638 VDD VSS sg13g2_decap_8
X_12220_ _12220_/Y _12219_/S _12215_/X _12214_/Y VDD VSS sg13g2_o21ai_1
XFILLER_5_126 VDD VSS sg13g2_decap_8
XFILLER_6_649 VDD VSS sg13g2_fill_1
XFILLER_68_1124 VDD VSS sg13g2_decap_8
XFILLER_118_51 VDD VSS sg13g2_fill_1
XFILLER_155_1105 VDD VSS sg13g2_decap_4
XFILLER_150_300 VDD VSS sg13g2_decap_4
X_12151_ _12151_/Y _12152_/A _13666_/Q VDD VSS sg13g2_nor2_1
XFILLER_120_1097 VDD VSS sg13g2_fill_1
XFILLER_68_1168 VDD VSS sg13g2_decap_4
X_11102_ _11102_/Y _11102_/A _11196_/B VDD VSS sg13g2_nand2_1
XFILLER_155_1149 VDD VSS sg13g2_decap_8
XFILLER_150_344 VDD VSS sg13g2_decap_8
X_12082_ _12125_/A _12084_/A _12227_/B VDD VSS sg13g2_nor2_1
XFILLER_111_709 VDD VSS sg13g2_fill_1
XFILLER_89_450 VDD VSS sg13g2_decap_4
XFILLER_77_601 VDD VSS sg13g2_decap_8
X_11033_ _11064_/C _14760_/Q _11033_/B VDD VSS sg13g2_xor2_1
XFILLER_89_483 VDD VSS sg13g2_fill_1
XFILLER_1_387 VDD VSS sg13g2_fill_1
XFILLER_104_794 VDD VSS sg13g2_decap_8
XFILLER_94_21 VDD VSS sg13g2_decap_8
XFILLER_49_369 VDD VSS sg13g2_decap_8
XFILLER_92_626 VDD VSS sg13g2_decap_4
X_14868__3193 _14868_/RESET_B VDD VSS sg13g2_tiehi
XFILLER_91_114 VDD VSS sg13g2_fill_2
X_12984_ _15032_/D _12984_/A _12984_/B VDD VSS sg13g2_nor2_1
XFILLER_57_380 VDD VSS sg13g2_decap_8
XFILLER_94_87 VDD VSS sg13g2_decap_8
XFILLER_17_222 VDD VSS sg13g2_decap_8
XFILLER_45_542 VDD VSS sg13g2_fill_1
X_14723_ _14723_/Q clkload2/A _14723_/D _14723_/RESET_B VDD VSS sg13g2_dfrbpq_1
X_11935_ _11986_/A _11936_/A _13130_/B VDD VSS sg13g2_nor2_1
X_14654_ _14654_/Q clkload59/A _14654_/D _14654_/RESET_B VDD VSS sg13g2_dfrbpq_1
XFILLER_45_597 VDD VSS sg13g2_decap_8
XFILLER_60_523 VDD VSS sg13g2_decap_8
X_11866_ _11868_/B _11867_/A _11867_/B _11910_/C VDD VSS sg13g2_a21o_1
XFILLER_14_951 VDD VSS sg13g2_decap_4
X_13605_ _13605_/Y _13600_/A _10173_/B _15166_/Q VDD VSS sg13g2_a21oi_1
X_10817_ _10821_/A _10818_/B _10818_/A VDD VSS sg13g2_nand2_1
X_14585_ _14585_/Q _14745_/CLK _14585_/D _14585_/RESET_B VDD VSS sg13g2_dfrbpq_1
XFILLER_13_450 VDD VSS sg13g2_fill_1
X_11797_ _11907_/A _11798_/A _13676_/Q VDD VSS sg13g2_nor2_1
XFILLER_13_472 VDD VSS sg13g2_decap_8
X_13536_ _15144_/D _13547_/B _13534_/Y _13535_/Y VDD VSS sg13g2_a21oi_1
X_10748_ _11078_/B _14946_/Q _10752_/A _10747_/Y VDD VSS sg13g2_a21oi_1
X_13467_ _13468_/D _15169_/Q _15170_/Q _15171_/Q _15172_/Q VDD VSS sg13g2_nand4_1
XFILLER_12_1123 VDD VSS sg13g2_decap_8
X_10679_ _10818_/B _08980_/X _10669_/S _08844_/Y VDD VSS sg13g2_a21oi_1
XFILLER_145_127 VDD VSS sg13g2_fill_1
X_15206_ _15206_/Q _15209_/CLK _15206_/D _15206_/RESET_B VDD VSS sg13g2_dfrbpq_1
XFILLER_127_842 VDD VSS sg13g2_decap_8
X_12418_ _12418_/X _14112_/Q _14144_/Q _14176_/Q _14208_/Q _12727_/S0 _12742_/S1 VDD
+ VSS sg13g2_mux4_1
XFILLER_138_190 VDD VSS sg13g2_decap_8
X_13398_ _13398_/Y _13490_/B _13425_/A _15087_/Q VDD VSS sg13g2_nand3_1
X_15137_ _15137_/Q _15148_/CLK _15137_/D _15137_/RESET_B VDD VSS sg13g2_dfrbpq_1
X_12349_ _12349_/X _13819_/Q _13851_/Q _13883_/Q _13915_/Q _12365_/S0 _12366_/S1 VDD
+ VSS sg13g2_mux4_1
X_14199__2365 _14199_/RESET_B VDD VSS sg13g2_tiehi
XFILLER_126_385 VDD VSS sg13g2_decap_8
XFILLER_153_182 VDD VSS sg13g2_decap_8
X_15068_ _15068_/Q clkload65/A _15068_/D _15068_/RESET_B VDD VSS sg13g2_dfrbpq_1
XFILLER_141_366 VDD VSS sg13g2_decap_8
XFILLER_4_63 VDD VSS sg13g2_decap_8
XFILLER_141_377 VDD VSS sg13g2_fill_2
XFILLER_141_388 VDD VSS sg13g2_fill_2
X_14019_ _14019_/Q clkload2/A _14019_/D _14019_/RESET_B VDD VSS sg13g2_dfrbpq_1
X_07890_ _07904_/A _07924_/C _07890_/B VDD VSS sg13g2_nor2_1
XFILLER_110_753 VDD VSS sg13g2_fill_2
XFILLER_56_818 VDD VSS sg13g2_fill_1
XFILLER_68_678 VDD VSS sg13g2_decap_8
XFILLER_110_764 VDD VSS sg13g2_fill_2
XFILLER_96_998 VDD VSS sg13g2_fill_2
XFILLER_83_626 VDD VSS sg13g2_decap_4
XFILLER_95_486 VDD VSS sg13g2_fill_1
X_09560_ _14158_/D _09892_/A0 _14158_/Q wire651/X VDD VSS sg13g2_mux2_1
XFILLER_82_136 VDD VSS sg13g2_decap_8
X_08511_ _08511_/X _08427_/X _08510_/X _08511_/S VDD VSS sg13g2_mux2_1
X_09491_ _14091_/D _10021_/A0 _14091_/Q _09505_/S VDD VSS sg13g2_mux2_1
X_08442_ _08443_/B _08574_/A _08442_/B VDD VSS sg13g2_nor2_1
XFILLER_17_1001 VDD VSS sg13g2_decap_8
XFILLER_23_269 VDD VSS sg13g2_decap_8
XFILLER_11_409 VDD VSS sg13g2_fill_2
X_08373_ _15232_/D _08372_/Y _08373_/B _08373_/C VDD VSS sg13g2_nand3b_1
XFILLER_23_28 VDD VSS sg13g2_decap_8
XFILLER_51_589 VDD VSS sg13g2_decap_8
XFILLER_143_1064 VDD VSS sg13g2_fill_2
XFILLER_139_28 VDD VSS sg13g2_decap_8
XFILLER_31_280 VDD VSS sg13g2_decap_4
XFILLER_143_1075 VDD VSS sg13g2_fill_1
XFILLER_17_1078 VDD VSS sg13g2_decap_8
XFILLER_137_628 VDD VSS sg13g2_fill_1
XFILLER_143_1097 VDD VSS sg13g2_decap_4
XFILLER_152_609 VDD VSS sg13g2_decap_8
XFILLER_145_650 VDD VSS sg13g2_fill_2
XFILLER_145_661 VDD VSS sg13g2_decap_8
XFILLER_118_886 VDD VSS sg13g2_decap_8
XFILLER_151_119 VDD VSS sg13g2_decap_8
XFILLER_145_672 VDD VSS sg13g2_fill_1
XFILLER_105_514 VDD VSS sg13g2_decap_8
X_14029__2535 _14029_/RESET_B VDD VSS sg13g2_tiehi
XFILLER_117_385 VDD VSS sg13g2_fill_2
XFILLER_155_49 VDD VSS sg13g2_decap_8
X_13864__2700 _13864_/RESET_B VDD VSS sg13g2_tiehi
XFILLER_8_1202 VDD VSS sg13g2_decap_8
Xfanout1409 _08686_/A2 _12229_/A VDD VSS sg13g2_buf_1
XFILLER_63_1021 VDD VSS sg13g2_decap_8
Xfanout411 _09964_/S wire418/X VDD VSS sg13g2_buf_1
XFILLER_48_14 VDD VSS sg13g2_decap_8
Xfanout422 wire423/A _09905_/X VDD VSS sg13g2_buf_1
XFILLER_120_539 VDD VSS sg13g2_fill_2
XFILLER_115_1122 VDD VSS sg13g2_decap_8
XFILLER_28_1185 VDD VSS sg13g2_decap_8
XFILLER_48_47 VDD VSS sg13g2_fill_1
XFILLER_63_1065 VDD VSS sg13g2_fill_1
Xfanout455 wire456/A wire458/A VDD VSS sg13g2_buf_1
XFILLER_48_58 VDD VSS sg13g2_decap_8
XFILLER_58_133 VDD VSS sg13g2_decap_8
XFILLER_87_965 VDD VSS sg13g2_fill_1
XFILLER_47_807 VDD VSS sg13g2_fill_1
X_09827_ _14415_/D _09893_/A0 _14415_/Q _09831_/S VDD VSS sg13g2_mux2_1
XFILLER_115_1155 VDD VSS sg13g2_decap_8
Xfanout477 _09479_/S wire480/X VDD VSS sg13g2_buf_1
XFILLER_47_829 VDD VSS sg13g2_decap_8
Xfanout488 _09312_/S _09330_/S VDD VSS sg13g2_buf_1
Xfanout499 _09294_/S _09274_/Y VDD VSS sg13g2_buf_1
X_14244__2320 _14244_/RESET_B VDD VSS sg13g2_tiehi
Xwire1559 _16866_/A _13704_/Q VDD VSS sg13g2_buf_8
XFILLER_111_1019 VDD VSS sg13g2_fill_1
X_13897__2667 _13897_/RESET_B VDD VSS sg13g2_tiehi
XFILLER_104_42 VDD VSS sg13g2_decap_8
XFILLER_74_648 VDD VSS sg13g2_decap_8
X_09758_ _14348_/D _14348_/Q _09824_/A0 _09772_/S VDD VSS sg13g2_mux2_1
XFILLER_64_35 VDD VSS sg13g2_fill_2
X_08709_ _15187_/D input13/X _15187_/Q _13333_/S VDD VSS sg13g2_mux2_1
XFILLER_27_564 VDD VSS sg13g2_fill_2
XFILLER_15_704 VDD VSS sg13g2_fill_1
X_09689_ _14281_/D _09887_/A0 _14281_/Q wire456/X VDD VSS sg13g2_mux2_1
X_11720_ wire302/A _12217_/A _11718_/X _11719_/Y VDD VSS sg13g2_o21ai_1
XFILLER_54_372 VDD VSS sg13g2_decap_8
XFILLER_82_681 VDD VSS sg13g2_decap_8
XFILLER_27_597 VDD VSS sg13g2_decap_8
XFILLER_82_692 VDD VSS sg13g2_fill_1
XFILLER_70_854 VDD VSS sg13g2_fill_2
XFILLER_30_707 VDD VSS sg13g2_decap_4
X_14277__2287 _14277_/RESET_B VDD VSS sg13g2_tiehi
X_11651_ _11651_/X _13959_/Q _13991_/Q _14023_/Q _14055_/Q _12067_/S0 _12067_/S1 VDD
+ VSS sg13g2_mux4_1
XFILLER_74_1150 VDD VSS sg13g2_fill_1
XFILLER_14_269 VDD VSS sg13g2_decap_8
X_10602_ _14877_/D _10602_/A _10602_/B _10602_/C VDD VSS sg13g2_nor3_1
XFILLER_11_921 VDD VSS sg13g2_decap_8
X_14370_ _14370_/Q _14678_/CLK _14370_/D _14370_/RESET_B VDD VSS sg13g2_dfrbpq_1
X_11582_ _11584_/B _12174_/A _11582_/B VDD VSS sg13g2_nor2_1
XFILLER_70_1036 VDD VSS sg13g2_decap_4
XFILLER_80_56 VDD VSS sg13g2_decap_8
XFILLER_31_1009 VDD VSS sg13g2_fill_1
XFILLER_7_914 VDD VSS sg13g2_decap_8
X_13321_ _13322_/A _15111_/Q wire810/X _13319_/A VDD VSS sg13g2_a21oi_1
X_10533_ _10535_/A _14860_/Q _10533_/B VDD VSS sg13g2_nand2b_1
XFILLER_155_425 VDD VSS sg13g2_decap_8
X_13252_ _13252_/X input25/X _13272_/A2 _13252_/B1 VDD VSS sg13g2_a21o_1
X_10464_ _14843_/D _10511_/D _10471_/D _10463_/Y VDD VSS sg13g2_a21oi_1
XFILLER_89_21 VDD VSS sg13g2_decap_4
XFILLER_108_341 VDD VSS sg13g2_fill_2
X_14492__2072 _14492_/RESET_B VDD VSS sg13g2_tiehi
X_12203_ _12272_/A _12203_/A _13665_/Q VDD VSS sg13g2_xnor2_1
XFILLER_142_119 VDD VSS sg13g2_decap_4
XFILLER_109_897 VDD VSS sg13g2_fill_2
XFILLER_89_65 VDD VSS sg13g2_decap_8
X_13183_ _13184_/B _13265_/A1 _13178_/X _13177_/X _13160_/B wire561/X VDD VSS sg13g2_a221oi_1
X_10395_ _10396_/D _10395_/A _10400_/C _10395_/C VDD VSS sg13g2_nor3_1
XFILLER_151_631 VDD VSS sg13g2_decap_8
XFILLER_135_182 VDD VSS sg13g2_fill_1
XFILLER_151_642 VDD VSS sg13g2_fill_1
XFILLER_2_630 VDD VSS sg13g2_decap_8
X_12134_ _12134_/X _13749_/Q _14101_/Q _14453_/Q _14549_/Q _12285_/S0 _12285_/S1 VDD
+ VSS sg13g2_mux4_1
XFILLER_123_355 VDD VSS sg13g2_fill_1
X_12065_ _12065_/Y _12065_/A _12065_/B VDD VSS sg13g2_nand2_1
XFILLER_89_280 VDD VSS sg13g2_fill_1
X_11016_ _11016_/Y _11042_/D _10995_/Y wire239/A VDD VSS sg13g2_o21ai_1
X_16873_ _16873_/X _16873_/A VDD VSS sg13g2_buf_1
XFILLER_65_604 VDD VSS sg13g2_fill_2
X_13727__2837 _13727_/RESET_B VDD VSS sg13g2_tiehi
XFILLER_80_618 VDD VSS sg13g2_decap_8
X_12967_ _12967_/Y _12900_/A _12884_/C input5/X VDD VSS sg13g2_a21oi_1
XFILLER_46_884 VDD VSS sg13g2_fill_1
XFILLER_61_810 VDD VSS sg13g2_decap_4
X_11918_ _11918_/X _14575_/Q _14607_/Q _14639_/Q _14671_/Q _11925_/S0 _12073_/S1 VDD
+ VSS sg13g2_mux4_1
X_14706_ _14706_/Q _14706_/CLK _14706_/D _14706_/RESET_B VDD VSS sg13g2_dfrbpq_1
X_12898_ _12898_/Y _12895_/Y _12896_/Y _12897_/Y VDD VSS sg13g2_a21oi_1
X_11849_ _11849_/X _13837_/Q _13869_/Q _13901_/Q _13933_/Q _11852_/S0 _11995_/S1 VDD
+ VSS sg13g2_mux4_1
X_14637_ _14637_/Q _14669_/CLK _14637_/D _14637_/RESET_B VDD VSS sg13g2_dfrbpq_1
X_14107__2457 _14107_/RESET_B VDD VSS sg13g2_tiehi
X_13942__2622 _13942_/RESET_B VDD VSS sg13g2_tiehi
X_14568_ _14568_/Q clkload27/A _14568_/D _14568_/RESET_B VDD VSS sg13g2_dfrbpq_1
XFILLER_147_915 VDD VSS sg13g2_fill_1
XFILLER_14_1218 VDD VSS sg13g2_decap_8
XFILLER_118_105 VDD VSS sg13g2_decap_8
X_13519_ _13519_/Y _13519_/A _13547_/B VDD VSS sg13g2_nor2_1
X_14499_ _14499_/Q _14505_/CLK _14499_/D _14499_/RESET_B VDD VSS sg13g2_dfrbpq_1
Xclkload10 clkload10/Y clkload10/A VDD VSS sg13g2_inv_1
Xclkload21 clkload21/Y clkload21/A VDD VSS sg13g2_inv_1
Xclkload32 clkload32/Y clkload32/A VDD VSS sg13g2_inv_1
X_15044__2922 _15044_/RESET_B VDD VSS sg13g2_tiehi
Xclkload43 clkload43/Y clkload43/A VDD VSS sg13g2_inv_2
X_14322__2242 _14322_/RESET_B VDD VSS sg13g2_tiehi
Xclkload54 clkload54/Y clkload54/A VDD VSS sg13g2_inv_2
Xclkload65 clkload65/Y clkload65/A VDD VSS sg13g2_inv_1
Xclkload76 clkload76/Y clkload76/A VDD VSS sg13g2_inv_2
X_13975__2589 _13975_/RESET_B VDD VSS sg13g2_tiehi
XFILLER_154_480 VDD VSS sg13g2_decap_8
XFILLER_142_620 VDD VSS sg13g2_fill_2
XFILLER_154_491 VDD VSS sg13g2_fill_2
XFILLER_48_0 VDD VSS sg13g2_decap_8
Xhold3506 _13519_/A _15140_/Q VDD VSS sg13g2_dlygate4sd3_1
Xhold3517 hold3517/X _14795_/Q VDD VSS sg13g2_dlygate4sd3_1
X_08991_ _08992_/B _15026_/Q _15223_/Q _09034_/S VDD VSS sg13g2_mux2_1
Xhold3528 _11143_/A _14952_/Q VDD VSS sg13g2_dlygate4sd3_1
X_07942_ _07942_/Y _07942_/A VDD VSS sg13g2_inv_1
XFILLER_69_954 VDD VSS sg13g2_decap_8
X_14949__3031 _14949_/RESET_B VDD VSS sg13g2_tiehi
XFILLER_56_604 VDD VSS sg13g2_fill_2
X_07873_ _08188_/B _07909_/B _07910_/A VDD VSS sg13g2_nor2_1
X_09612_ _14208_/D _09977_/A0 _14208_/Q _09635_/S VDD VSS sg13g2_mux2_1
XFILLER_18_28 VDD VSS sg13g2_decap_8
XFILLER_68_486 VDD VSS sg13g2_fill_2
XFILLER_96_795 VDD VSS sg13g2_decap_8
XFILLER_55_114 VDD VSS sg13g2_decap_4
XFILLER_83_423 VDD VSS sg13g2_decap_4
XFILLER_56_648 VDD VSS sg13g2_decap_8
XFILLER_3_1132 VDD VSS sg13g2_decap_8
XFILLER_37_840 VDD VSS sg13g2_fill_2
X_09543_ _14141_/D _09609_/A0 _14141_/Q _09571_/S VDD VSS sg13g2_mux2_1
XFILLER_36_361 VDD VSS sg13g2_fill_1
XFILLER_110_1085 VDD VSS sg13g2_decap_8
X_09474_ _09474_/X _09938_/A _09938_/B _10137_/A _10137_/C VDD VSS sg13g2_or4_1
XFILLER_19_1107 VDD VSS sg13g2_decap_8
XFILLER_52_876 VDD VSS sg13g2_decap_8
X_08425_ _08441_/C _08034_/A _08058_/X _08518_/B1 VDD VSS sg13g2_o21ai_1
X_08356_ _08668_/B _08270_/B _08196_/Y _08241_/Y VDD VSS sg13g2_o21ai_1
Xclkload4 clkload4/Y clkload4/A VDD VSS sg13g2_inv_1
XFILLER_137_414 VDD VSS sg13g2_decap_4
X_08287_ _08287_/Y _07797_/A _07927_/Y _07932_/Y VDD VSS sg13g2_o21ai_1
XFILLER_109_116 VDD VSS sg13g2_decap_8
XFILLER_126_7 VDD VSS sg13g2_decap_8
XFILLER_146_981 VDD VSS sg13g2_decap_8
XFILLER_118_672 VDD VSS sg13g2_fill_2
XFILLER_30_1075 VDD VSS sg13g2_fill_1
X_13805__2759 _13805_/RESET_B VDD VSS sg13g2_tiehi
XFILLER_30_1086 VDD VSS sg13g2_fill_2
X_14565__1999 _14565_/RESET_B VDD VSS sg13g2_tiehi
X_10180_ _14747_/D _10173_/Y _10176_/Y _10179_/Y VDD VSS sg13g2_o21ai_1
XFILLER_105_355 VDD VSS sg13g2_fill_1
XFILLER_152_1119 VDD VSS sg13g2_decap_8
Xfanout1206 _12615_/S0 _12620_/S0 VDD VSS sg13g2_buf_1
Xfanout1217 _13035_/A2 _11243_/B VDD VSS sg13g2_buf_1
XFILLER_121_848 VDD VSS sg13g2_decap_8
Xfanout230 _10123_/A0 wire231/X VDD VSS sg13g2_buf_1
Xfanout1228 _12808_/A _13309_/A2 VDD VSS sg13g2_buf_1
Xfanout241 _10405_/C _10414_/B VDD VSS sg13g2_buf_1
Xfanout1239 _13589_/A2 _13566_/B VDD VSS sg13g2_buf_1
Xfanout263 _10152_/A1 _09920_/A1 VDD VSS sg13g2_buf_1
XFILLER_8_1076 VDD VSS sg13g2_decap_8
Xfanout274 _11522_/A2 _12147_/B1 VDD VSS sg13g2_buf_1
Xfanout285 _09787_/A0 _09919_/A1 VDD VSS sg13g2_buf_1
XFILLER_59_475 VDD VSS sg13g2_fill_1
Xfanout296 _09917_/A1 _09032_/X VDD VSS sg13g2_buf_1
XFILLER_59_486 VDD VSS sg13g2_fill_1
XFILLER_101_572 VDD VSS sg13g2_decap_8
X_13870_ _13870_/Q _14670_/CLK _13870_/D _13870_/RESET_B VDD VSS sg13g2_dfrbpq_1
XFILLER_75_979 VDD VSS sg13g2_decap_8
XFILLER_90_905 VDD VSS sg13g2_decap_8
X_12821_ _12821_/Y _14895_/Q _12836_/B VDD VSS sg13g2_nand2_1
XFILLER_62_618 VDD VSS sg13g2_decap_4
XFILLER_61_106 VDD VSS sg13g2_decap_4
X_12752_ _12752_/X _13848_/Q _13880_/Q _13912_/Q _13944_/Q _12752_/S0 _12757_/S1 VDD
+ VSS sg13g2_mux4_1
XFILLER_91_11 VDD VSS sg13g2_fill_1
X_14400__2164 _14400_/RESET_B VDD VSS sg13g2_tiehi
XFILLER_15_556 VDD VSS sg13g2_fill_1
XFILLER_54_191 VDD VSS sg13g2_fill_2
XFILLER_152_0 VDD VSS sg13g2_decap_8
X_11703_ _11771_/B _11635_/A _13681_/Q _13680_/Q _11661_/A VDD VSS sg13g2_a22oi_1
XFILLER_91_55 VDD VSS sg13g2_fill_2
XFILLER_15_578 VDD VSS sg13g2_decap_4
X_12683_ _12683_/X _13747_/Q _14099_/Q _14451_/Q _14547_/Q _12689_/S0 _12689_/S1 VDD
+ VSS sg13g2_mux4_1
X_14422_ _14422_/Q clkload24/A _14422_/D _14422_/RESET_B VDD VSS sg13g2_dfrbpq_1
X_11634_ _11643_/A _11635_/A _13681_/Q VDD VSS sg13g2_xor2_1
XFILLER_11_740 VDD VSS sg13g2_decap_8
XFILLER_155_200 VDD VSS sg13g2_decap_8
X_14353_ _14353_/Q _14737_/CLK _14353_/D _14353_/RESET_B VDD VSS sg13g2_dfrbpq_1
X_11565_ _11566_/B _11527_/Y _11631_/A2 _11564_/Y VDD VSS sg13g2_a21oi_1
X_13304_ _13320_/A _12808_/A _15205_/Q VDD VSS sg13g2_nand2b_1
Xwire653 wire653/X wire653/A VDD VSS sg13g2_buf_8
X_10516_ _14854_/D _10453_/C _10509_/Y _10499_/B _07623_/Y _10602_/A VDD VSS sg13g2_a221oi_1
XFILLER_6_232 VDD VSS sg13g2_fill_1
X_14284_ _14284_/Q _14525_/CLK _14284_/D _14284_/RESET_B VDD VSS sg13g2_dfrbpq_1
XFILLER_156_789 VDD VSS sg13g2_fill_2
XFILLER_155_266 VDD VSS sg13g2_decap_8
Xmax_cap408 _10102_/S fanout407/X VDD VSS sg13g2_buf_8
X_11496_ _11496_/X _11486_/X _11487_/X _11490_/X _11491_/X wire964/X _12217_/A VDD
+ VSS sg13g2_mux4_1
X_13235_ _13235_/Y _14827_/Q _13206_/B _13249_/B _14891_/Q _13274_/C1 VDD VSS sg13g2_a221oi_1
X_10447_ _14838_/D _10521_/C wire760/A _10444_/B _07624_/Y _10490_/A VDD VSS sg13g2_a221oi_1
XFILLER_156_70 VDD VSS sg13g2_fill_2
XFILLER_3_950 VDD VSS sg13g2_decap_8
XFILLER_41_7 VDD VSS sg13g2_decap_8
X_13166_ _13166_/Y _13222_/A1 _13161_/X _13165_/Y VDD VSS sg13g2_a21oi_1
X_10378_ _10379_/A _14815_/Q _14816_/Q _14817_/Q _10378_/D VDD VSS sg13g2_and4_1
XFILLER_123_152 VDD VSS sg13g2_fill_1
X_12117_ _12118_/B _12106_/Y _12108_/X _12174_/A VDD VSS sg13g2_o21ai_1
X_13097_ _13097_/Y _13094_/Y _13095_/Y _13096_/Y VDD VSS sg13g2_a21oi_1
XFILLER_123_196 VDD VSS sg13g2_decap_8
Xfanout1740 _11353_/S _11373_/A VDD VSS sg13g2_buf_1
X_12048_ _12048_/Y _12048_/A1 _12043_/X _12047_/Y VDD VSS sg13g2_a21oi_1
XFILLER_111_369 VDD VSS sg13g2_fill_1
Xfanout1751 _11212_/S _12328_/A1 VDD VSS sg13g2_buf_1
Xfanout1762 _13353_/A _13328_/A VDD VSS sg13g2_buf_1
Xfanout1773 _13005_/C fanout1797/X VDD VSS sg13g2_buf_1
X_14610__1954 _14610_/RESET_B VDD VSS sg13g2_tiehi
Xfanout1784 _13363_/B fanout1795/X VDD VSS sg13g2_buf_1
XFILLER_1_42 VDD VSS sg13g2_decap_8
X_16856_ _16856_/X _16856_/A VDD VSS sg13g2_buf_1
Xfanout1795 fanout1795/X _10256_/C VDD VSS sg13g2_buf_1
XFILLER_133_1096 VDD VSS sg13g2_decap_4
XFILLER_66_968 VDD VSS sg13g2_decap_8
XFILLER_93_754 VDD VSS sg13g2_fill_1
XFILLER_66_979 VDD VSS sg13g2_fill_2
XFILLER_93_765 VDD VSS sg13g2_fill_2
XFILLER_20_1233 VDD VSS sg13g2_decap_4
XFILLER_65_489 VDD VSS sg13g2_decap_8
XFILLER_81_938 VDD VSS sg13g2_decap_8
XFILLER_18_361 VDD VSS sg13g2_decap_8
X_13999_ _13999_/Q _14671_/CLK _13999_/D _13999_/RESET_B VDD VSS sg13g2_dfrbpq_1
XFILLER_52_128 VDD VSS sg13g2_fill_2
XFILLER_34_854 VDD VSS sg13g2_decap_4
XFILLER_61_662 VDD VSS sg13g2_decap_8
XFILLER_33_364 VDD VSS sg13g2_decap_8
XFILLER_21_504 VDD VSS sg13g2_decap_8
X_08210_ _08211_/A _08004_/Y _08197_/X _08209_/X _08110_/D _08193_/Y VDD VSS sg13g2_a221oi_1
X_09190_ _13806_/D _13806_/Q _09991_/A0 _09190_/S VDD VSS sg13g2_mux2_1
XFILLER_140_1001 VDD VSS sg13g2_fill_2
XFILLER_18_1184 VDD VSS sg13g2_decap_8
X_08141_ _08141_/Y _08522_/C _08140_/Y _08523_/B1 VDD VSS sg13g2_a21oi_1
XFILLER_140_1023 VDD VSS sg13g2_fill_1
XFILLER_105_1143 VDD VSS sg13g2_decap_8
XFILLER_14_1037 VDD VSS sg13g2_fill_2
XFILLER_146_233 VDD VSS sg13g2_decap_8
XFILLER_119_447 VDD VSS sg13g2_decap_8
XFILLER_105_1176 VDD VSS sg13g2_decap_8
X_08072_ _08078_/B _07882_/Y _08456_/A _08071_/Y _08073_/A _08070_/X VDD VSS sg13g2_a221oi_1
XFILLER_101_1018 VDD VSS sg13g2_decap_8
XFILLER_105_1187 VDD VSS sg13g2_decap_8
XFILLER_101_1029 VDD VSS sg13g2_fill_1
XFILLER_128_970 VDD VSS sg13g2_decap_8
Xmax_cap1092 _12788_/S0 _12593_/S0 VDD VSS sg13g2_buf_4
XFILLER_115_631 VDD VSS sg13g2_decap_8
XFILLER_88_515 VDD VSS sg13g2_decap_8
X_15156__3030 _15156_/RESET_B VDD VSS sg13g2_tiehi
XFILLER_88_548 VDD VSS sg13g2_decap_8
X_08974_ _10675_/B _09085_/B _15023_/Q VDD VSS sg13g2_nor2_1
XFILLER_102_347 VDD VSS sg13g2_fill_2
XFILLER_102_358 VDD VSS sg13g2_decap_8
X_07925_ _07925_/Y _07926_/A _07926_/B VDD VSS sg13g2_nor2_1
XFILLER_60_1013 VDD VSS sg13g2_decap_4
XFILLER_152_28 VDD VSS sg13g2_decap_8
XFILLER_29_604 VDD VSS sg13g2_decap_8
XFILLER_25_1144 VDD VSS sg13g2_decap_8
XFILLER_102_369 VDD VSS sg13g2_fill_1
XFILLER_111_870 VDD VSS sg13g2_fill_1
XFILLER_5_1227 VDD VSS sg13g2_decap_8
XFILLER_69_784 VDD VSS sg13g2_fill_2
XFILLER_29_626 VDD VSS sg13g2_decap_8
XFILLER_68_283 VDD VSS sg13g2_decap_4
XFILLER_96_592 VDD VSS sg13g2_decap_8
X_07856_ _07856_/Y _07855_/A _07855_/B _08641_/A VDD VSS sg13g2_o21ai_1
XFILLER_29_648 VDD VSS sg13g2_decap_8
XFILLER_21_1019 VDD VSS sg13g2_decap_8
XFILLER_151_1196 VDD VSS sg13g2_decap_8
XFILLER_28_147 VDD VSS sg13g2_fill_1
XFILLER_28_169 VDD VSS sg13g2_decap_8
X_07787_ _07796_/B _08414_/A _08414_/B VDD VSS sg13g2_nor2_1
XFILLER_72_938 VDD VSS sg13g2_fill_2
X_09526_ _14125_/D _09693_/A0 _14125_/Q _09539_/S VDD VSS sg13g2_mux2_1
X_09457_ _14058_/D _09888_/A0 _14058_/Q _09457_/S VDD VSS sg13g2_mux2_1
XFILLER_80_971 VDD VSS sg13g2_decap_8
XFILLER_40_813 VDD VSS sg13g2_decap_4
XFILLER_52_673 VDD VSS sg13g2_decap_8
XFILLER_52_684 VDD VSS sg13g2_fill_2
XFILLER_61_14 VDD VSS sg13g2_decap_8
XFILLER_101_65 VDD VSS sg13g2_decap_8
X_08408_ _08408_/Y _08452_/C _08236_/X _08034_/Y VDD VSS sg13g2_o21ai_1
XFILLER_51_183 VDD VSS sg13g2_fill_2
X_09388_ _13991_/D _10083_/A0 _13991_/Q _09388_/S VDD VSS sg13g2_mux2_1
XFILLER_12_559 VDD VSS sg13g2_fill_1
X_14194__2370 _14194_/RESET_B VDD VSS sg13g2_tiehi
X_08339_ _08339_/Y _08621_/B _08337_/X _08338_/Y VDD VSS sg13g2_o21ai_1
XFILLER_137_211 VDD VSS sg13g2_decap_8
XFILLER_138_745 VDD VSS sg13g2_fill_1
XFILLER_137_222 VDD VSS sg13g2_fill_1
XFILLER_71_1186 VDD VSS sg13g2_decap_8
XFILLER_126_907 VDD VSS sg13g2_decap_4
X_11350_ _11350_/Y _11373_/A _13790_/Q _12304_/B VDD VSS sg13g2_a21oi_1
XFILLER_153_737 VDD VSS sg13g2_fill_2
X_10301_ _10301_/Y _14794_/Q _10299_/Y _10271_/B VDD VSS sg13g2_o21ai_1
XFILLER_125_428 VDD VSS sg13g2_fill_1
XFILLER_152_214 VDD VSS sg13g2_decap_8
XFILLER_4_725 VDD VSS sg13g2_decap_8
X_11281_ _11281_/Y _11282_/S1 _11277_/X _11280_/Y VDD VSS sg13g2_o21ai_1
XFILLER_69_1060 VDD VSS sg13g2_decap_8
X_13020_ _13021_/B _07682_/A wire252/X _13012_/Y _13009_/Y wire565/X VDD VSS sg13g2_a221oi_1
X_10232_ _14772_/D _10232_/A _10232_/B _13499_/B VDD VSS sg13g2_and3_1
XFILLER_3_268 VDD VSS sg13g2_decap_4
XFILLER_10_84 VDD VSS sg13g2_decap_8
X_10163_ _14740_/D _14740_/Q _10163_/A1 _10163_/S VDD VSS sg13g2_mux2_1
X_14418__2146 _14418_/RESET_B VDD VSS sg13g2_tiehi
XFILLER_105_185 VDD VSS sg13g2_decap_8
Xfanout1003 _13412_/C _13307_/B VDD VSS sg13g2_buf_1
Xfanout1014 _08488_/A _08328_/S VDD VSS sg13g2_buf_1
Xfanout1025 _08173_/B _07629_/Y VDD VSS sg13g2_buf_1
Xfanout1036 _08969_/B _08977_/A VDD VSS sg13g2_buf_1
Xfanout1047 _08724_/B _10647_/D VDD VSS sg13g2_buf_1
X_14971_ _14971_/Q clkload38/A _14971_/D _14971_/RESET_B VDD VSS sg13g2_dfrbpq_1
X_10094_ _14674_/D _10161_/A1 _14674_/Q _10094_/S VDD VSS sg13g2_mux2_1
XFILLER_94_529 VDD VSS sg13g2_decap_8
XFILLER_48_924 VDD VSS sg13g2_decap_8
XFILLER_120_177 VDD VSS sg13g2_fill_1
XFILLER_120_188 VDD VSS sg13g2_decap_4
X_13922_ _13922_/Q clkload22/A _13922_/D _13922_/RESET_B VDD VSS sg13g2_dfrbpq_1
XFILLER_59_283 VDD VSS sg13g2_decap_8
XFILLER_75_776 VDD VSS sg13g2_decap_4
XFILLER_74_253 VDD VSS sg13g2_decap_8
X_13853_ _13853_/Q clkload53/A _13853_/D _13853_/RESET_B VDD VSS sg13g2_dfrbpq_1
XFILLER_142_94 VDD VSS sg13g2_fill_1
XFILLER_90_724 VDD VSS sg13g2_fill_1
X_12804_ _12804_/Y input4/X _12841_/B _12803_/X input34/X _12800_/X VDD VSS sg13g2_a221oi_1
XFILLER_90_757 VDD VSS sg13g2_decap_8
X_13784_ _13784_/Q clkload38/A _13784_/D _13784_/RESET_B VDD VSS sg13g2_dfrbpq_1
X_10996_ _10996_/Y _11043_/A _10996_/B VDD VSS sg13g2_nand2_1
X_14933__3063 _14933_/RESET_B VDD VSS sg13g2_tiehi
XFILLER_37_1015 VDD VSS sg13g2_fill_2
XFILLER_71_971 VDD VSS sg13g2_fill_1
X_12735_ wire368/A _13666_/Q _12749_/A2 _12734_/X _12749_/B2 _12749_/C1 VDD VSS sg13g2_a221oi_1
XFILLER_128_1154 VDD VSS sg13g2_fill_2
XFILLER_30_312 VDD VSS sg13g2_fill_2
X_12666_ _15011_/D _12666_/A wire373/X VDD VSS sg13g2_nor2_1
X_14024__2540 _14024_/RESET_B VDD VSS sg13g2_tiehi
XFILLER_89_7 VDD VSS sg13g2_decap_8
X_14405_ _14405_/Q _14405_/CLK _14405_/D _14405_/RESET_B VDD VSS sg13g2_dfrbpq_1
X_11617_ _11617_/Y _12206_/S0 _13862_/Q _12091_/C VDD VSS sg13g2_a21oi_1
XFILLER_129_723 VDD VSS sg13g2_fill_1
XFILLER_30_378 VDD VSS sg13g2_fill_2
X_12597_ _15006_/D _12597_/A wire377/X VDD VSS sg13g2_nor2_1
X_11548_ _11549_/A _14244_/Q _14276_/Q _14308_/Q _14340_/Q _11555_/S0 _12259_/S1 VDD
+ VSS sg13g2_mux4_1
X_14336_ _14336_/Q _14916_/CLK _14336_/D _14336_/RESET_B VDD VSS sg13g2_dfrbpq_1
XFILLER_156_575 VDD VSS sg13g2_decap_8
XFILLER_117_929 VDD VSS sg13g2_fill_1
X_14628__1936 _14628_/RESET_B VDD VSS sg13g2_tiehi
XFILLER_7_563 VDD VSS sg13g2_fill_2
XFILLER_156_586 VDD VSS sg13g2_fill_1
X_14810__3288 _14810_/RESET_B VDD VSS sg13g2_tiehi
X_14267_ _14267_/Q _15188_/CLK _14267_/D _14267_/RESET_B VDD VSS sg13g2_dfrbpq_1
X_11479_ _11479_/Y _14900_/Q _11655_/B _11631_/A2 VDD VSS sg13g2_a21oi_1
XFILLER_100_1040 VDD VSS sg13g2_decap_8
XFILLER_87_1160 VDD VSS sg13g2_decap_4
XFILLER_125_951 VDD VSS sg13g2_fill_2
X_13218_ _13218_/Y _14858_/Q _13234_/B VDD VSS sg13g2_nand2_1
X_15111__3122 _15111_/RESET_B VDD VSS sg13g2_tiehi
XFILLER_87_1182 VDD VSS sg13g2_decap_8
X_13892__2672 _13892_/RESET_B VDD VSS sg13g2_tiehi
X_14198_ _14198_/Q _14710_/CLK _14198_/D _14198_/RESET_B VDD VSS sg13g2_dfrbpq_1
XFILLER_83_1024 VDD VSS sg13g2_fill_2
XFILLER_97_301 VDD VSS sg13g2_decap_8
XFILLER_98_846 VDD VSS sg13g2_decap_4
XFILLER_135_1125 VDD VSS sg13g2_decap_4
X_13149_ _13149_/X input18/X _13149_/A2 _13252_/B1 VDD VSS sg13g2_a21o_1
XFILLER_48_1199 VDD VSS sg13g2_decap_8
XFILLER_97_345 VDD VSS sg13g2_decap_8
XFILLER_98_879 VDD VSS sg13g2_fill_2
XFILLER_140_987 VDD VSS sg13g2_decap_8
X_07710_ _07710_/Y _13281_/B _13281_/C VDD VSS sg13g2_nor2_1
Xfanout1581 _12191_/B1 _12263_/C VDD VSS sg13g2_buf_1
X_08690_ _08690_/X _15103_/Q _15090_/Q _08690_/C VDD VSS sg13g2_or3_1
Xfanout1592 _11747_/A _12265_/A2 VDD VSS sg13g2_buf_1
XFILLER_66_754 VDD VSS sg13g2_fill_1
X_14272__2292 _14272_/RESET_B VDD VSS sg13g2_tiehi
XFILLER_39_979 VDD VSS sg13g2_decap_8
X_07641_ _10265_/B _14782_/Q VDD VSS sg13g2_inv_1
XFILLER_38_467 VDD VSS sg13g2_fill_1
XFILLER_81_713 VDD VSS sg13g2_fill_2
XFILLER_20_1030 VDD VSS sg13g2_decap_8
XFILLER_81_724 VDD VSS sg13g2_decap_8
XFILLER_0_1135 VDD VSS sg13g2_decap_8
XFILLER_94_1120 VDD VSS sg13g2_fill_1
XFILLER_0_1146 VDD VSS sg13g2_fill_1
X_09311_ _13918_/D _08983_/X _13918_/Q _09311_/S VDD VSS sg13g2_mux2_1
XFILLER_146_1221 VDD VSS sg13g2_decap_8
XFILLER_34_662 VDD VSS sg13g2_decap_8
XFILLER_80_289 VDD VSS sg13g2_decap_4
XFILLER_61_481 VDD VSS sg13g2_decap_8
X_09242_ _13851_/D _13851_/Q _10138_/A1 _09261_/S VDD VSS sg13g2_mux2_1
XFILLER_55_1159 VDD VSS sg13g2_decap_8
X_09173_ _13789_/D _13789_/Q _10140_/A1 _09202_/S VDD VSS sg13g2_mux2_1
XFILLER_31_28 VDD VSS sg13g2_decap_8
X_08124_ _08124_/X _08012_/B _08686_/A3 _08653_/B _08673_/B _08046_/B _13521_/A VDD
+ VSS sg13g2_mux4_1
XFILLER_108_907 VDD VSS sg13g2_decap_8
XFILLER_147_28 VDD VSS sg13g2_decap_8
XFILLER_147_597 VDD VSS sg13g2_fill_2
XFILLER_135_748 VDD VSS sg13g2_fill_2
X_08055_ _08167_/B _07859_/B _07853_/B _08012_/B _07972_/B _08055_/S0 _08669_/B1 VDD
+ VSS sg13g2_mux4_1
XFILLER_31_1181 VDD VSS sg13g2_decap_8
XFILLER_66_1200 VDD VSS sg13g2_fill_1
XFILLER_66_1211 VDD VSS sg13g2_fill_1
Xmax_cap761 _10397_/B _10346_/B VDD VSS sg13g2_buf_1
XFILLER_115_450 VDD VSS sg13g2_decap_8
Xoutput39 mem_axi_araddr[10] output39/A VDD VSS sg13g2_buf_1
X_13722__2842 _13722_/RESET_B VDD VSS sg13g2_tiehi
XFILLER_115_472 VDD VSS sg13g2_decap_8
XFILLER_88_345 VDD VSS sg13g2_decap_8
XFILLER_103_645 VDD VSS sg13g2_decap_8
XFILLER_130_431 VDD VSS sg13g2_fill_2
XFILLER_103_667 VDD VSS sg13g2_fill_1
XFILLER_130_464 VDD VSS sg13g2_decap_8
X_08957_ _10137_/B _09938_/A _09938_/B VDD VSS sg13g2_nand2b_1
XFILLER_130_475 VDD VSS sg13g2_fill_2
XFILLER_69_570 VDD VSS sg13g2_fill_1
XFILLER_56_14 VDD VSS sg13g2_decap_8
XFILLER_5_1024 VDD VSS sg13g2_decap_8
XFILLER_57_732 VDD VSS sg13g2_fill_2
X_07908_ _13290_/A _07908_/A _07908_/B VDD VSS sg13g2_nand2_1
X_08888_ _08888_/Y _08835_/A _08835_/B output43/A VDD VSS sg13g2_a21oi_1
XFILLER_99_1031 VDD VSS sg13g2_decap_8
X_14102__2462 _14102_/RESET_B VDD VSS sg13g2_tiehi
XFILLER_29_445 VDD VSS sg13g2_fill_2
XFILLER_99_1042 VDD VSS sg13g2_fill_2
XFILLER_72_702 VDD VSS sg13g2_fill_2
X_07839_ _07969_/A _07979_/C _07981_/C _08697_/B _08698_/A VDD VSS sg13g2_nand4_1
XFILLER_99_1075 VDD VSS sg13g2_decap_8
XFILLER_38_990 VDD VSS sg13g2_decap_8
X_10850_ _10850_/Y _10850_/A _10929_/B VDD VSS sg13g2_nand2_1
XFILLER_112_42 VDD VSS sg13g2_fill_1
XFILLER_112_53 VDD VSS sg13g2_decap_8
X_14706__1858 _14706_/RESET_B VDD VSS sg13g2_tiehi
X_09509_ _14108_/D _10039_/A0 _14108_/Q _09527_/S VDD VSS sg13g2_mux2_1
X_10781_ _10781_/X _10781_/A _10793_/B _10793_/A VDD VSS sg13g2_and3_1
XFILLER_12_312 VDD VSS sg13g2_decap_8
XFILLER_13_846 VDD VSS sg13g2_decap_8
X_12520_ _12520_/X _13735_/Q _14087_/Q _14439_/Q _14535_/Q _12685_/S0 _12685_/S1 VDD
+ VSS sg13g2_mux4_1
XFILLER_12_323 VDD VSS sg13g2_fill_2
XFILLER_40_632 VDD VSS sg13g2_decap_8
X_13970__2594 _13970_/RESET_B VDD VSS sg13g2_tiehi
XFILLER_40_665 VDD VSS sg13g2_decap_8
X_12451_ _12451_/X _14370_/Q _14402_/Q _14466_/Q _14498_/Q _12452_/S0 _12452_/S1 VDD
+ VSS sg13g2_mux4_1
XFILLER_40_698 VDD VSS sg13g2_decap_8
Xclkbuf_leaf_51_clk_i _15040_/CLK clkbuf_leaf_52_clk_i/A VDD VSS sg13g2_buf_8
XFILLER_138_542 VDD VSS sg13g2_decap_4
X_11402_ _11402_/Y _11397_/Y _11398_/Y _11422_/B VDD VSS sg13g2_a21oi_1
X_15170_ _15170_/Q clkload73/A _15170_/D _15170_/RESET_B VDD VSS sg13g2_dfrbpq_1
X_12382_ _12382_/X _14237_/Q _14269_/Q _14301_/Q _14333_/Q _12588_/S0 _12592_/S1 VDD
+ VSS sg13g2_mux4_1
XFILLER_123_1073 VDD VSS sg13g2_fill_1
X_14121_ _14121_/Q _14678_/CLK _14121_/D _14121_/RESET_B VDD VSS sg13g2_dfrbpq_1
X_11333_ _11333_/Y _12835_/A _12338_/A2 _07684_/B VDD VSS sg13g2_a21oi_1
XFILLER_115_0 VDD VSS sg13g2_decap_8
XFILLER_153_534 VDD VSS sg13g2_decap_8
XFILLER_141_718 VDD VSS sg13g2_fill_1
X_14052_ _14052_/Q clkload31/A _14052_/D _14052_/RESET_B VDD VSS sg13g2_dfrbpq_1
X_11264_ _11264_/X _11259_/Y _11260_/Y _11283_/B VDD VSS sg13g2_a21o_1
Xclkbuf_leaf_66_clk_i _14776_/CLK clkbuf_leaf_66_clk_i/A VDD VSS sg13g2_buf_8
XFILLER_4_577 VDD VSS sg13g2_fill_2
XFILLER_106_461 VDD VSS sg13g2_fill_2
XFILLER_107_995 VDD VSS sg13g2_fill_2
X_13003_ _13003_/Y _13000_/Y _13001_/Y _13002_/Y VDD VSS sg13g2_a21oi_1
XFILLER_137_94 VDD VSS sg13g2_decap_8
XFILLER_134_781 VDD VSS sg13g2_decap_4
XFILLER_79_312 VDD VSS sg13g2_decap_4
X_10215_ _14764_/D _10213_/A wire847/X hold3404/X VDD VSS sg13g2_a21oi_1
X_11195_ _14955_/D _07614_/Y _10671_/Y _11194_/Y VDD VSS sg13g2_o21ai_1
XFILLER_122_965 VDD VSS sg13g2_decap_4
X_10146_ _14723_/D _14723_/Q _10146_/A1 _10166_/S VDD VSS sg13g2_mux2_1
XFILLER_95_827 VDD VSS sg13g2_decap_4
X_10077_ _14657_/D _10077_/A0 _14657_/Q _10084_/S VDD VSS sg13g2_mux2_1
X_14954_ _14954_/Q clkload35/A _14954_/D _14954_/RESET_B VDD VSS sg13g2_dfrbpq_1
XFILLER_134_1191 VDD VSS sg13g2_decap_4
XFILLER_78_1104 VDD VSS sg13g2_decap_8
X_13905_ _13905_/Q _14509_/CLK _13905_/D _13905_/RESET_B VDD VSS sg13g2_dfrbpq_1
XFILLER_47_264 VDD VSS sg13g2_decap_8
X_14885_ _14885_/Q clkload78/A _14885_/D _14885_/RESET_B VDD VSS sg13g2_dfrbpq_1
XFILLER_75_584 VDD VSS sg13g2_decap_8
XFILLER_63_735 VDD VSS sg13g2_decap_8
XFILLER_90_521 VDD VSS sg13g2_decap_8
X_15140__3062 _15140_/RESET_B VDD VSS sg13g2_tiehi
X_13836_ _13836_/Q _14714_/CLK _13836_/D _13836_/RESET_B VDD VSS sg13g2_dfrbpq_1
X_13767_ _13767_/Q _14725_/CLK _13767_/D _13767_/RESET_B VDD VSS sg13g2_dfrbpq_1
X_10979_ _10979_/Y _14759_/Q _11015_/C _11009_/D VDD VSS sg13g2_o21ai_1
X_12718_ _12718_/X _12713_/X _12715_/X _12712_/X _12714_/X _12581_/S _12775_/S1 VDD
+ VSS sg13g2_mux4_1
X_13800__2764 _13800_/RESET_B VDD VSS sg13g2_tiehi
X_13698_ _13698_/Q clkload18/A _13698_/D _13698_/RESET_B VDD VSS sg13g2_dfrbpq_1
Xclkbuf_leaf_19_clk_i _14738_/CLK clkbuf_5_7__f_clk_i/X VDD VSS sg13g2_buf_8
X_12649_ _12649_/X _12647_/X _12646_/X _12643_/X _12642_/X _12719_/S0 _12776_/S VDD
+ VSS sg13g2_mux4_1
XFILLER_15_1143 VDD VSS sg13g2_decap_8
XFILLER_11_1007 VDD VSS sg13g2_decap_8
XFILLER_102_1124 VDD VSS sg13g2_fill_1
XFILLER_7_63 VDD VSS sg13g2_decap_8
XFILLER_156_383 VDD VSS sg13g2_decap_4
XFILLER_156_394 VDD VSS sg13g2_fill_1
X_14319_ _14319_/Q _14662_/CLK _14319_/D _14319_/RESET_B VDD VSS sg13g2_dfrbpq_1
XFILLER_102_1168 VDD VSS sg13g2_decap_8
XFILLER_144_567 VDD VSS sg13g2_decap_4
XFILLER_98_610 VDD VSS sg13g2_fill_1
X_09860_ _14447_/D _14447_/Q _09992_/A0 _09865_/S VDD VSS sg13g2_mux2_1
Xfanout818 _13297_/A0 _13140_/B2 VDD VSS sg13g2_buf_1
XFILLER_30_0 VDD VSS sg13g2_decap_8
Xfanout829 _12267_/A2 _11433_/B VDD VSS sg13g2_buf_1
XFILLER_86_805 VDD VSS sg13g2_decap_8
X_08811_ _13688_/D _08811_/A _08811_/B VDD VSS sg13g2_nor2_1
XFILLER_86_827 VDD VSS sg13g2_fill_1
XFILLER_97_164 VDD VSS sg13g2_decap_4
X_09791_ _14380_/D _09824_/A0 _14380_/Q wire633/X VDD VSS sg13g2_mux2_1
XFILLER_58_529 VDD VSS sg13g2_decap_8
XFILLER_98_698 VDD VSS sg13g2_decap_8
XFILLER_86_849 VDD VSS sg13g2_fill_2
X_08742_ _08742_/Y _08751_/A1 _08751_/A2 _15196_/Q VDD VSS sg13g2_o21ai_1
XFILLER_22_1114 VDD VSS sg13g2_decap_8
XFILLER_66_540 VDD VSS sg13g2_fill_1
XFILLER_27_916 VDD VSS sg13g2_decap_8
X_08673_ _08673_/X _15019_/Q _08673_/B VDD VSS sg13g2_or2_1
XFILLER_27_927 VDD VSS sg13g2_fill_2
XFILLER_66_573 VDD VSS sg13g2_fill_1
XFILLER_96_1215 VDD VSS sg13g2_fill_1
XFILLER_26_28 VDD VSS sg13g2_decap_8
XFILLER_81_521 VDD VSS sg13g2_decap_8
X_07624_ _07624_/Y _14838_/Q VDD VSS sg13g2_inv_1
XFILLER_4_1090 VDD VSS sg13g2_decap_8
XFILLER_81_598 VDD VSS sg13g2_decap_4
XFILLER_22_632 VDD VSS sg13g2_decap_8
XFILLER_146_1062 VDD VSS sg13g2_decap_8
XFILLER_21_142 VDD VSS sg13g2_decap_8
XFILLER_50_985 VDD VSS sg13g2_fill_2
X_09225_ _13836_/D _09956_/A1 _13836_/Q _09227_/S VDD VSS sg13g2_mux2_1
XFILLER_33_1232 VDD VSS sg13g2_decap_4
XFILLER_148_851 VDD VSS sg13g2_fill_1
X_09156_ _09158_/B _14924_/Q _09156_/B VDD VSS sg13g2_nand2b_1
XFILLER_148_884 VDD VSS sg13g2_decap_8
XFILLER_120_1224 VDD VSS sg13g2_decap_8
XFILLER_135_512 VDD VSS sg13g2_decap_8
XFILLER_120_1235 VDD VSS sg13g2_fill_2
X_08107_ _08112_/D _07879_/A _08025_/B _08106_/Y VDD VSS sg13g2_o21ai_1
X_09087_ _09090_/B _14914_/Q _09087_/B VDD VSS sg13g2_nand2b_1
XFILLER_107_236 VDD VSS sg13g2_decap_8
X_08038_ _08039_/D _08541_/A _07896_/X _08037_/A _08523_/B1 VDD VSS sg13g2_a22oi_1
XFILLER_1_503 VDD VSS sg13g2_decap_8
XFILLER_1_514 VDD VSS sg13g2_decap_4
XFILLER_118_1120 VDD VSS sg13g2_decap_8
XFILLER_88_131 VDD VSS sg13g2_decap_4
XFILLER_118_1142 VDD VSS sg13g2_fill_2
X_10000_ _14583_/D _10033_/A0 _14583_/Q _10000_/S VDD VSS sg13g2_mux2_1
XFILLER_27_1047 VDD VSS sg13g2_decap_8
XFILLER_89_687 VDD VSS sg13g2_fill_2
XFILLER_49_529 VDD VSS sg13g2_decap_8
XFILLER_76_315 VDD VSS sg13g2_decap_8
XFILLER_89_698 VDD VSS sg13g2_decap_4
XFILLER_118_1186 VDD VSS sg13g2_decap_8
XFILLER_77_849 VDD VSS sg13g2_fill_2
X_09989_ _14572_/D _10155_/A1 _14572_/Q _10002_/S VDD VSS sg13g2_mux2_1
XFILLER_76_337 VDD VSS sg13g2_decap_4
X_13988__2576 _13988_/RESET_B VDD VSS sg13g2_tiehi
XFILLER_130_294 VDD VSS sg13g2_decap_8
XFILLER_57_540 VDD VSS sg13g2_decap_8
X_11951_ _11952_/B _11951_/A _14672_/Q VDD VSS sg13g2_nand2_1
XFILLER_57_595 VDD VSS sg13g2_fill_2
XFILLER_123_85 VDD VSS sg13g2_decap_8
XFILLER_17_437 VDD VSS sg13g2_decap_8
XFILLER_45_746 VDD VSS sg13g2_decap_4
X_10902_ _14934_/D hold3530/X _10903_/B _10901_/Y VDD VSS sg13g2_a21o_1
XFILLER_84_392 VDD VSS sg13g2_fill_2
X_14670_ _14670_/Q _14670_/CLK _14670_/D _14670_/RESET_B VDD VSS sg13g2_dfrbpq_1
X_11882_ _11882_/X _13742_/Q _14094_/Q _14446_/Q _14542_/Q _11882_/S0 _11897_/C VDD
+ VSS sg13g2_mux4_1
XFILLER_44_267 VDD VSS sg13g2_decap_8
X_13621_ _13729_/D _13621_/A VDD VSS sg13g2_buf_1
XFILLER_44_278 VDD VSS sg13g2_fill_2
X_10833_ _10876_/D _10844_/A _10844_/B _10851_/D VDD VSS sg13g2_nand3_1
X_14368__2196 _14368_/RESET_B VDD VSS sg13g2_tiehi
XFILLER_73_1012 VDD VSS sg13g2_decap_8
XFILLER_38_1143 VDD VSS sg13g2_decap_8
XFILLER_53_790 VDD VSS sg13g2_fill_1
X_15082__3214 _15082_/RESET_B VDD VSS sg13g2_tiehi
XFILLER_41_952 VDD VSS sg13g2_decap_8
X_13552_ _13552_/Y _15006_/Q _13566_/B _13563_/C VDD VSS sg13g2_nor3_1
X_10764_ _10764_/X _14949_/Q _10769_/A2 _10762_/Y VDD VSS sg13g2_a21o_1
XFILLER_73_1067 VDD VSS sg13g2_decap_4
XFILLER_12_153 VDD VSS sg13g2_decap_8
X_12503_ _12503_/X _13830_/Q _13862_/Q _13894_/Q _13926_/Q _12745_/S0 _12745_/S1 VDD
+ VSS sg13g2_mux4_1
XFILLER_13_687 VDD VSS sg13g2_fill_2
X_13483_ _13484_/C _15057_/Q _13307_/B _15123_/Q VDD VSS sg13g2_o21ai_1
X_10695_ _10696_/A _14901_/Q _10903_/B _10939_/B1 _10871_/A VDD VSS sg13g2_a22oi_1
XFILLER_125_1168 VDD VSS sg13g2_decap_4
Xmax_cap1603 _11761_/C _12237_/C VDD VSS sg13g2_buf_4
X_12434_ _12434_/X _14689_/Q _14721_/Q _13761_/Q _13793_/Q _12534_/S0 _12534_/S1 VDD
+ VSS sg13g2_mux4_1
X_15222_ _15222_/Q clkload29/A _15222_/D _15222_/RESET_B VDD VSS sg13g2_dfrbpq_1
X_12365_ _12365_/X _14556_/Q _14588_/Q _14620_/Q _14652_/Q _12365_/S0 _12366_/S1 VDD
+ VSS sg13g2_mux4_1
X_15153_ _15153_/Q clkload26/A _15153_/D _15153_/RESET_B VDD VSS sg13g2_dfrbpq_1
XFILLER_154_854 VDD VSS sg13g2_decap_8
X_11316_ _11318_/B _11328_/S0 _14461_/Q VDD VSS sg13g2_nand2b_1
XFILLER_5_864 VDD VSS sg13g2_decap_4
X_14104_ _14104_/Q clkload31/A _14104_/D _14104_/RESET_B VDD VSS sg13g2_dfrbpq_1
X_15084_ _15084_/Q clkload71/A _15084_/D _15084_/RESET_B VDD VSS sg13g2_dfrbpq_1
X_12296_ _12297_/B _12301_/B1 _12280_/Y _12295_/Y VDD VSS sg13g2_o21ai_1
XFILLER_10_1073 VDD VSS sg13g2_decap_8
XFILLER_153_397 VDD VSS sg13g2_decap_8
X_14035_ _14035_/Q clkload10/A _14035_/D _14035_/RESET_B VDD VSS sg13g2_dfrbpq_1
X_11247_ _11247_/X _11243_/B _07690_/X _11245_/Y VDD VSS sg13g2_a21o_1
XFILLER_68_816 VDD VSS sg13g2_decap_8
XFILLER_122_762 VDD VSS sg13g2_fill_1
XFILLER_132_1106 VDD VSS sg13g2_decap_4
X_11178_ _11186_/B _11177_/B _11177_/C _11197_/A VDD VSS sg13g2_o21ai_1
XFILLER_132_1117 VDD VSS sg13g2_fill_1
XFILLER_94_101 VDD VSS sg13g2_fill_1
XFILLER_67_337 VDD VSS sg13g2_decap_4
XFILLER_121_283 VDD VSS sg13g2_fill_1
X_10129_ _14707_/D _10162_/A1 _14707_/Q _10129_/S VDD VSS sg13g2_mux2_1
XFILLER_0_591 VDD VSS sg13g2_fill_1
X_13818__2746 _13818_/RESET_B VDD VSS sg13g2_tiehi
XFILLER_110_968 VDD VSS sg13g2_fill_1
X_14578__1986 _14578_/RESET_B VDD VSS sg13g2_tiehi
XFILLER_76_860 VDD VSS sg13g2_decap_8
X_14937_ _14937_/Q clkload34/A _14937_/D _14937_/RESET_B VDD VSS sg13g2_dfrbpq_1
XFILLER_63_543 VDD VSS sg13g2_decap_8
X_14868_ _14868_/Q _14873_/CLK _14868_/D _14868_/RESET_B VDD VSS sg13g2_dfrbpq_1
XFILLER_21_1180 VDD VSS sg13g2_decap_8
X_13819_ _13819_/Q clkload76/A _13819_/D _13819_/RESET_B VDD VSS sg13g2_dfrbpq_1
XFILLER_35_289 VDD VSS sg13g2_decap_4
X_14799_ _14799_/Q clkload74/A _14799_/D _14799_/RESET_B VDD VSS sg13g2_dfrbpq_1
XFILLER_143_1213 VDD VSS sg13g2_decap_8
XFILLER_50_259 VDD VSS sg13g2_fill_1
XFILLER_32_974 VDD VSS sg13g2_decap_4
XFILLER_31_462 VDD VSS sg13g2_decap_8
XFILLER_32_996 VDD VSS sg13g2_decap_8
XFILLER_104_1219 VDD VSS sg13g2_decap_8
X_09010_ _09010_/Y _09141_/A _10697_/A _10697_/B VDD VSS sg13g2_nand3_1
XFILLER_78_0 VDD VSS sg13g2_decap_8
XFILLER_129_350 VDD VSS sg13g2_decap_8
X_14413__2151 _14413_/RESET_B VDD VSS sg13g2_tiehi
XFILLER_156_191 VDD VSS sg13g2_decap_8
XFILLER_117_556 VDD VSS sg13g2_decap_8
XFILLER_144_342 VDD VSS sg13g2_decap_8
X_09912_ _14497_/D _14497_/Q _09912_/A1 wire423/X VDD VSS sg13g2_mux2_1
Xfanout604 _09999_/S _09996_/S VDD VSS sg13g2_buf_1
XFILLER_99_963 VDD VSS sg13g2_decap_8
XFILLER_99_974 VDD VSS sg13g2_fill_2
XFILLER_86_602 VDD VSS sg13g2_decap_8
X_09843_ _14430_/D _14430_/Q _10141_/A1 wire435/X VDD VSS sg13g2_mux2_1
XFILLER_150_1206 VDD VSS sg13g2_decap_8
Xfanout648 _09564_/S wire651/X VDD VSS sg13g2_buf_1
XFILLER_112_294 VDD VSS sg13g2_decap_8
XFILLER_58_359 VDD VSS sg13g2_fill_1
X_09774_ _14363_/D _09906_/A1 _14363_/Q wire633/A VDD VSS sg13g2_mux2_1
XFILLER_6_1152 VDD VSS sg13g2_decap_8
XFILLER_73_307 VDD VSS sg13g2_fill_2
XFILLER_67_882 VDD VSS sg13g2_fill_2
X_08725_ _13482_/A _15129_/Q _15124_/Q _15071_/Q VDD VSS sg13g2_or3_1
XFILLER_113_1072 VDD VSS sg13g2_decap_8
XFILLER_54_521 VDD VSS sg13g2_decap_4
X_08656_ _08656_/X _08669_/B1 _08619_/Y _08402_/C VDD VSS sg13g2_a21o_1
XFILLER_82_863 VDD VSS sg13g2_decap_8
XFILLER_27_779 VDD VSS sg13g2_decap_8
XFILLER_96_1067 VDD VSS sg13g2_decap_8
XFILLER_14_418 VDD VSS sg13g2_decap_8
XFILLER_41_204 VDD VSS sg13g2_decap_8
X_08587_ _08587_/Y _08586_/B _08586_/C _08641_/C VDD VSS sg13g2_a21oi_1
XFILLER_54_598 VDD VSS sg13g2_fill_2
XFILLER_156_7 VDD VSS sg13g2_decap_8
XFILLER_35_790 VDD VSS sg13g2_decap_4
X_14623__1941 _14623_/RESET_B VDD VSS sg13g2_tiehi
XFILLER_50_771 VDD VSS sg13g2_decap_8
XFILLER_139_125 VDD VSS sg13g2_decap_8
XFILLER_22_484 VDD VSS sg13g2_decap_8
XFILLER_10_646 VDD VSS sg13g2_fill_1
X_09208_ _10070_/C _09938_/A _09938_/B VDD VSS sg13g2_nor2_1
X_10480_ _10482_/A _13084_/A _10489_/D _10295_/C VDD VSS sg13g2_o21ai_1
XFILLER_33_1051 VDD VSS sg13g2_decap_8
XFILLER_5_105 VDD VSS sg13g2_decap_8
X_09139_ _13782_/D _13782_/Q _10132_/A0 _09146_/S VDD VSS sg13g2_mux2_1
XFILLER_108_534 VDD VSS sg13g2_decap_8
XFILLER_68_1114 VDD VSS sg13g2_decap_4
XFILLER_108_545 VDD VSS sg13g2_fill_2
Xclkbuf_5_14__f_clk_i clkbuf_5_14__f_clk_i/X clkbuf_4_7_0_clk_i/X VDD VSS sg13g2_buf_16
XFILLER_120_1065 VDD VSS sg13g2_fill_1
XFILLER_151_802 VDD VSS sg13g2_decap_8
X_12150_ _12150_/Y _12152_/A _12227_/B VDD VSS sg13g2_nor2_1
XFILLER_136_898 VDD VSS sg13g2_decap_8
XFILLER_68_1147 VDD VSS sg13g2_decap_8
XFILLER_2_812 VDD VSS sg13g2_fill_1
XFILLER_118_63 VDD VSS sg13g2_decap_8
XFILLER_155_1117 VDD VSS sg13g2_decap_8
XFILLER_150_323 VDD VSS sg13g2_decap_8
XFILLER_1_300 VDD VSS sg13g2_decap_4
X_11101_ _14948_/D _11100_/Y _11099_/Y _11084_/Y VDD VSS sg13g2_o21ai_1
XFILLER_78_23 VDD VSS sg13g2_fill_1
X_12081_ _14981_/D _12061_/A _12126_/A _12080_/Y VDD VSS sg13g2_a21o_1
X_11032_ _11032_/Y _11052_/B _14760_/Q VDD VSS sg13g2_nor2b_1
XFILLER_49_337 VDD VSS sg13g2_decap_8
XFILLER_103_283 VDD VSS sg13g2_decap_4
XFILLER_103_294 VDD VSS sg13g2_fill_1
XFILLER_77_668 VDD VSS sg13g2_decap_8
XFILLER_40_1022 VDD VSS sg13g2_decap_8
XFILLER_64_307 VDD VSS sg13g2_fill_2
XFILLER_18_713 VDD VSS sg13g2_decap_8
XFILLER_58_882 VDD VSS sg13g2_fill_1
XFILLER_40_1055 VDD VSS sg13g2_decap_4
X_12983_ _12984_/B _07682_/A wire253/X _12975_/X _12962_/C wire566/X VDD VSS sg13g2_a221oi_1
XFILLER_92_649 VDD VSS sg13g2_decap_8
XFILLER_45_521 VDD VSS sg13g2_decap_8
XFILLER_79_1232 VDD VSS sg13g2_decap_4
X_14455__2109 _14455_/RESET_B VDD VSS sg13g2_tiehi
XFILLER_131_1194 VDD VSS sg13g2_decap_8
X_14722_ _14722_/Q _14722_/CLK _14722_/D _14722_/RESET_B VDD VSS sg13g2_dfrbpq_1
X_11934_ _11934_/Y _11936_/A _12298_/B VDD VSS sg13g2_nor2_1
XFILLER_45_576 VDD VSS sg13g2_fill_1
X_14653_ _14653_/Q clkload53/A _14653_/D _14653_/RESET_B VDD VSS sg13g2_dfrbpq_1
XFILLER_32_215 VDD VSS sg13g2_decap_4
X_11865_ _11910_/C _11865_/A _13674_/Q VDD VSS sg13g2_xnor2_1
XFILLER_32_237 VDD VSS sg13g2_decap_8
X_13604_ _15165_/D _13603_/Y _10173_/B _13599_/Y VDD VSS sg13g2_a21oi_1
X_10816_ _10816_/Y _10843_/C _10851_/A _10835_/B2 VDD VSS sg13g2_o21ai_1
X_14584_ _14584_/Q clkload36/A _14584_/D _14584_/RESET_B VDD VSS sg13g2_dfrbpq_1
XFILLER_60_568 VDD VSS sg13g2_fill_1
X_11796_ _11839_/A _11798_/A _12298_/B VDD VSS sg13g2_nor2_1
X_15246__3399 _15246_/RESET_B VDD VSS sg13g2_tiehi
X_13535_ _13535_/Y _13535_/A _13547_/B VDD VSS sg13g2_nor2_1
X_10747_ _10747_/Y _10752_/A _10747_/B VDD VSS sg13g2_nor2_1
XFILLER_146_618 VDD VSS sg13g2_decap_4
XFILLER_12_1102 VDD VSS sg13g2_decap_8
XFILLER_71_7 VDD VSS sg13g2_decap_8
X_10678_ _14896_/D _13279_/D _10813_/A _10674_/Y VDD VSS sg13g2_o21ai_1
X_13466_ _15108_/D _13459_/Y _13463_/X _13465_/Y VDD VSS sg13g2_o21ai_1
XFILLER_127_821 VDD VSS sg13g2_decap_8
X_15205_ _15205_/Q _15209_/CLK _15205_/D _15205_/RESET_B VDD VSS sg13g2_dfrbpq_1
XFILLER_51_1195 VDD VSS sg13g2_fill_2
X_12417_ _14993_/D _12415_/Y _12416_/Y _12403_/Y VDD VSS sg13g2_a21oi_1
X_13397_ _15086_/D _15086_/Q _13353_/Y _13396_/Y VDD VSS sg13g2_a21o_1
XFILLER_12_1179 VDD VSS sg13g2_decap_8
XFILLER_86_1236 VDD VSS sg13g2_fill_1
X_15136_ _15136_/Q _15148_/CLK _15136_/D _15136_/RESET_B VDD VSS sg13g2_dfrbpq_1
XFILLER_154_684 VDD VSS sg13g2_decap_8
XFILLER_141_301 VDD VSS sg13g2_decap_4
X_14061__2503 _14061_/RESET_B VDD VSS sg13g2_tiehi
X_12348_ _12348_/Y _12348_/A _15217_/Q _15126_/Q _12348_/D VDD VSS sg13g2_nor4_1
XFILLER_153_161 VDD VSS sg13g2_decap_8
XFILLER_4_171 VDD VSS sg13g2_decap_8
XFILLER_4_42 VDD VSS sg13g2_decap_8
X_12279_ _12280_/B _12277_/X _12279_/B VDD VSS sg13g2_nand2b_1
X_15067_ _15067_/Q _15178_/CLK _15067_/D _15067_/RESET_B VDD VSS sg13g2_dfrbpq_1
XFILLER_142_879 VDD VSS sg13g2_decap_8
X_14018_ _14018_/Q clkload6/A _14018_/D _14018_/RESET_B VDD VSS sg13g2_dfrbpq_1
XFILLER_68_624 VDD VSS sg13g2_decap_8
X_14701__1863 _14701_/RESET_B VDD VSS sg13g2_tiehi
XFILLER_110_732 VDD VSS sg13g2_decap_8
XFILLER_23_1231 VDD VSS sg13g2_decap_4
XFILLER_49_871 VDD VSS sg13g2_fill_1
XFILLER_95_498 VDD VSS sg13g2_decap_8
X_08510_ _08510_/X _07815_/B _07820_/B _07801_/B _07949_/C wire1387/A _08559_/S1 VDD
+ VSS sg13g2_mux4_1
XFILLER_110_1234 VDD VSS sg13g2_fill_2
XFILLER_64_841 VDD VSS sg13g2_decap_8
X_09490_ _14090_/D _10153_/A1 _14090_/Q _09490_/S VDD VSS sg13g2_mux2_1
XFILLER_36_543 VDD VSS sg13g2_decap_4
XFILLER_63_351 VDD VSS sg13g2_decap_8
XFILLER_93_1218 VDD VSS sg13g2_decap_8
X_08441_ _15235_/D _08441_/A _08441_/B _08441_/C _08441_/D VDD VSS sg13g2_nand4_1
X_15033__2939 _15033_/RESET_B VDD VSS sg13g2_tiehi
X_08372_ _08372_/Y _07795_/A _08370_/Y _08371_/Y VDD VSS sg13g2_a21oi_1
XFILLER_108_1130 VDD VSS sg13g2_fill_1
XFILLER_143_1021 VDD VSS sg13g2_fill_1
Xclkbuf_4_15_0_clk_i clkbuf_4_15_0_clk_i/X clkbuf_0_clk_i/X VDD VSS sg13g2_buf_8
XFILLER_56_1084 VDD VSS sg13g2_decap_4
XFILLER_17_1057 VDD VSS sg13g2_decap_8
XFILLER_108_1185 VDD VSS sg13g2_fill_1
XFILLER_104_1027 VDD VSS sg13g2_fill_1
XFILLER_149_489 VDD VSS sg13g2_decap_8
XFILLER_20_988 VDD VSS sg13g2_decap_8
XFILLER_104_1049 VDD VSS sg13g2_fill_1
XFILLER_136_139 VDD VSS sg13g2_decap_8
XFILLER_30_1235 VDD VSS sg13g2_fill_2
XFILLER_118_854 VDD VSS sg13g2_fill_2
XFILLER_118_876 VDD VSS sg13g2_fill_2
XFILLER_155_28 VDD VSS sg13g2_decap_8
XFILLER_2_119 VDD VSS sg13g2_decap_8
Xfanout401 _10084_/S _10102_/S VDD VSS sg13g2_buf_1
XFILLER_115_1101 VDD VSS sg13g2_decap_8
Xfanout434 wire435/A fanout436/X VDD VSS sg13g2_buf_1
XFILLER_28_1164 VDD VSS sg13g2_decap_8
Xfanout445 _09772_/S _09760_/S VDD VSS sg13g2_buf_1
XFILLER_150_1014 VDD VSS sg13g2_decap_4
XFILLER_86_421 VDD VSS sg13g2_fill_2
XFILLER_154_1183 VDD VSS sg13g2_decap_8
XFILLER_59_657 VDD VSS sg13g2_decap_8
Xfanout467 _09611_/S wire470/X VDD VSS sg13g2_buf_1
X_09826_ _14414_/D _09925_/A1 _14414_/Q _09826_/S VDD VSS sg13g2_mux2_1
X_14823__3275 _14823_/RESET_B VDD VSS sg13g2_tiehi
XFILLER_104_21 VDD VSS sg13g2_decap_8
XFILLER_58_167 VDD VSS sg13g2_decap_4
X_09757_ _14347_/D _14347_/Q _10154_/A1 wire444/X VDD VSS sg13g2_mux2_1
XFILLER_27_521 VDD VSS sg13g2_decap_8
X_08708_ _13659_/D _15186_/D _15117_/Q _13651_/S VDD VSS sg13g2_mux2_1
X_09688_ _14280_/D _10151_/A1 _14280_/Q wire458/X VDD VSS sg13g2_mux2_1
XFILLER_104_98 VDD VSS sg13g2_decap_8
X_14838__3253 _14838_/RESET_B VDD VSS sg13g2_tiehi
XFILLER_70_800 VDD VSS sg13g2_fill_2
XFILLER_27_576 VDD VSS sg13g2_fill_2
XFILLER_55_885 VDD VSS sg13g2_decap_4
XFILLER_42_513 VDD VSS sg13g2_decap_8
X_08639_ _08640_/B _08678_/B _08674_/B1 _08674_/A2 _08650_/A VDD VSS sg13g2_a22oi_1
X_15009__2963 _15009_/RESET_B VDD VSS sg13g2_tiehi
X_11650_ _11650_/X _14119_/Q _14151_/Q _14183_/Q _14215_/Q _12067_/S0 _12067_/S1 VDD
+ VSS sg13g2_mux4_1
XFILLER_74_1140 VDD VSS sg13g2_fill_1
XFILLER_42_568 VDD VSS sg13g2_fill_1
XFILLER_11_900 VDD VSS sg13g2_decap_8
XFILLER_120_75 VDD VSS sg13g2_fill_2
X_10601_ _10602_/C _14877_/Q _14876_/Q _14875_/Q _10607_/C VDD VSS sg13g2_and4_1
XFILLER_23_782 VDD VSS sg13g2_decap_8
XFILLER_70_1015 VDD VSS sg13g2_decap_8
XFILLER_80_35 VDD VSS sg13g2_decap_8
X_11581_ _11582_/B _11573_/X _11574_/X _11577_/X _11578_/X wire964/A _12221_/B1 VDD
+ VSS sg13g2_mux4_1
XFILLER_155_404 VDD VSS sg13g2_decap_8
X_10532_ _14859_/D _10533_/B _10630_/C _10532_/C VDD VSS sg13g2_and3_1
X_13320_ _13322_/B _13320_/A _15064_/Q _13320_/C VDD VSS sg13g2_nand3_1
XFILLER_156_949 VDD VSS sg13g2_fill_2
XFILLER_109_821 VDD VSS sg13g2_decap_8
XFILLER_7_948 VDD VSS sg13g2_fill_2
XFILLER_13_84 VDD VSS sg13g2_decap_8
X_10463_ _10463_/Y _10511_/D _10471_/D _10295_/C VDD VSS sg13g2_o21ai_1
X_13251_ _13251_/Y _13251_/A _13251_/B _13251_/C VDD VSS sg13g2_nand3_1
X_12202_ _12274_/A _12203_/A _13665_/Q VDD VSS sg13g2_nand2_1
XFILLER_129_95 VDD VSS sg13g2_fill_1
X_13182_ wire561/A _13179_/Y _13180_/Y _13181_/Y VDD VSS sg13g2_a21oi_1
XFILLER_151_610 VDD VSS sg13g2_decap_8
X_10394_ _10395_/C _14820_/Q _14821_/Q _14822_/Q VDD VSS sg13g2_nand3_1
XFILLER_108_386 VDD VSS sg13g2_decap_8
X_12133_ _12133_/X _14581_/Q _14613_/Q _14645_/Q _14677_/Q _12285_/S0 _12285_/S1 VDD
+ VSS sg13g2_mux4_1
XFILLER_8_0 VDD VSS sg13g2_decap_8
X_14509__2055 _14509_/RESET_B VDD VSS sg13g2_tiehi
XFILLER_1_141 VDD VSS sg13g2_decap_4
XFILLER_81_1122 VDD VSS sg13g2_decap_8
X_12064_ _12065_/B _12062_/A wire379/X _12197_/A VDD VSS sg13g2_a21o_1
XFILLER_78_922 VDD VSS sg13g2_decap_4
XFILLER_2_686 VDD VSS sg13g2_fill_1
XFILLER_150_186 VDD VSS sg13g2_decap_4
XFILLER_132_890 VDD VSS sg13g2_decap_4
XFILLER_145_94 VDD VSS sg13g2_decap_4
XFILLER_1_174 VDD VSS sg13g2_fill_2
X_11015_ wire239/A _11015_/A _11042_/B _11015_/C _11042_/D VDD VSS sg13g2_nand4_1
X_16872_ _16872_/X _16872_/A VDD VSS sg13g2_buf_1
XFILLER_78_977 VDD VSS sg13g2_fill_2
XFILLER_38_819 VDD VSS sg13g2_fill_2
Xfanout990 _11739_/B fanout992/X VDD VSS sg13g2_buf_1
XFILLER_65_638 VDD VSS sg13g2_decap_8
XFILLER_64_126 VDD VSS sg13g2_decap_4
XFILLER_80_608 VDD VSS sg13g2_fill_2
X_12966_ _12966_/Y _12963_/Y _12964_/Y _12965_/Y VDD VSS sg13g2_a21oi_1
XFILLER_18_587 VDD VSS sg13g2_decap_8
XFILLER_46_896 VDD VSS sg13g2_decap_8
X_14705_ _14705_/Q clkload44/A _14705_/D _14705_/RESET_B VDD VSS sg13g2_dfrbpq_1
X_11917_ _11917_/Y _11917_/A _12055_/A VDD VSS sg13g2_xnor2_1
X_12897_ _12897_/Y _14773_/Q _12918_/A2 _12978_/B1 VDD VSS sg13g2_o21ai_1
XFILLER_127_1016 VDD VSS sg13g2_decap_8
XFILLER_21_708 VDD VSS sg13g2_decap_8
X_14636_ _14636_/Q clkload51/A _14636_/D _14636_/RESET_B VDD VSS sg13g2_dfrbpq_1
X_11848_ _11848_/X _13741_/Q _14093_/Q _14445_/Q _14541_/Q _11852_/S0 _11419_/C VDD
+ VSS sg13g2_mux4_1
XFILLER_61_877 VDD VSS sg13g2_fill_2
XFILLER_127_1049 VDD VSS sg13g2_decap_4
XFILLER_14_782 VDD VSS sg13g2_decap_8
X_13768__2796 _13768_/RESET_B VDD VSS sg13g2_tiehi
X_14567_ _14567_/Q clkload5/A _14567_/D _14567_/RESET_B VDD VSS sg13g2_dfrbpq_1
X_11779_ _11779_/Y _11910_/A wire210/X VDD VSS sg13g2_nor2_1
XFILLER_119_607 VDD VSS sg13g2_decap_8
XFILLER_147_927 VDD VSS sg13g2_decap_8
X_13518_ _13518_/Y _13517_/A _12936_/B _08263_/B _13546_/B2 VDD VSS sg13g2_a22oi_1
X_14719__1845 _14719_/RESET_B VDD VSS sg13g2_tiehi
X_14498_ _14498_/Q clkload25/A _14498_/D _14498_/RESET_B VDD VSS sg13g2_dfrbpq_1
X_14891__3147 _14891_/RESET_B VDD VSS sg13g2_tiehi
XFILLER_9_285 VDD VSS sg13g2_decap_8
XFILLER_16_1090 VDD VSS sg13g2_decap_8
XFILLER_9_296 VDD VSS sg13g2_fill_1
Xclkload11 clkload11/Y clkload11/A VDD VSS sg13g2_inv_1
Xclkload22 clkload22/Y clkload22/A VDD VSS sg13g2_inv_1
X_13449_ _13449_/X _15196_/Q _13449_/B VDD VSS sg13g2_or2_1
XFILLER_155_960 VDD VSS sg13g2_fill_1
Xclkload33 clkload33/Y clkload33/A VDD VSS sg13g2_inv_1
Xclkload44 clkload44/Y clkload44/A VDD VSS sg13g2_inv_1
Xclkload55 clkload55/Y clkload55/A VDD VSS sg13g2_inv_2
XFILLER_86_1033 VDD VSS sg13g2_decap_8
Xclkload66 clkload66/Y clkload66/A VDD VSS sg13g2_inv_2
XFILLER_115_824 VDD VSS sg13g2_decap_8
Xclkload77 clkload77/Y clkload77/A VDD VSS sg13g2_inv_2
X_13983__2581 _13983_/RESET_B VDD VSS sg13g2_tiehi
XFILLER_114_323 VDD VSS sg13g2_decap_8
X_15119_ _15119_/Q clkload64/A _15119_/D _15119_/RESET_B VDD VSS sg13g2_dfrbpq_1
XFILLER_114_334 VDD VSS sg13g2_fill_2
Xhold3507 _10216_/B _14765_/Q VDD VSS sg13g2_dlygate4sd3_1
X_08990_ _13759_/D _13759_/Q _10075_/A0 _09106_/S VDD VSS sg13g2_mux2_1
Xhold3518 _10959_/A _14939_/Q VDD VSS sg13g2_dlygate4sd3_1
Xhold3529 _13539_/A _15145_/Q VDD VSS sg13g2_dlygate4sd3_1
XFILLER_142_687 VDD VSS sg13g2_decap_4
XFILLER_69_922 VDD VSS sg13g2_decap_8
X_07941_ _07942_/A _07796_/Y _07940_/Y _07938_/Y VDD VSS sg13g2_a21o_1
X_07872_ _07876_/A _07909_/B _07910_/A VDD VSS sg13g2_nand2_1
XFILLER_95_251 VDD VSS sg13g2_fill_2
XFILLER_96_774 VDD VSS sg13g2_decap_8
X_09611_ _14207_/D _09877_/A0 _14207_/Q _09611_/S VDD VSS sg13g2_mux2_1
XFILLER_3_1111 VDD VSS sg13g2_decap_8
XFILLER_83_446 VDD VSS sg13g2_fill_1
XFILLER_84_969 VDD VSS sg13g2_decap_8
X_09542_ _14140_/D _10039_/A0 _14140_/Q wire651/A VDD VSS sg13g2_mux2_1
XFILLER_52_800 VDD VSS sg13g2_fill_2
XFILLER_83_479 VDD VSS sg13g2_decap_8
XFILLER_3_1188 VDD VSS sg13g2_decap_8
XFILLER_93_1004 VDD VSS sg13g2_decap_8
XFILLER_110_1064 VDD VSS sg13g2_decap_8
XFILLER_70_118 VDD VSS sg13g2_fill_2
XFILLER_36_384 VDD VSS sg13g2_decap_8
X_09473_ _14074_/D _10102_/A0 _14074_/Q _09473_/S VDD VSS sg13g2_mux2_1
XFILLER_52_844 VDD VSS sg13g2_fill_2
XFILLER_145_1105 VDD VSS sg13g2_decap_4
XFILLER_34_28 VDD VSS sg13g2_decap_8
XFILLER_34_39 VDD VSS sg13g2_decap_4
XFILLER_51_332 VDD VSS sg13g2_fill_2
XFILLER_58_1168 VDD VSS sg13g2_decap_8
XFILLER_58_1179 VDD VSS sg13g2_fill_1
X_08424_ _15234_/D _08685_/A1 _08423_/X _08410_/X VDD VSS sg13g2_o21ai_1
XFILLER_145_1149 VDD VSS sg13g2_decap_8
X_08355_ _15231_/D _08395_/A _08354_/Y _08347_/Y VDD VSS sg13g2_o21ai_1
XFILLER_138_927 VDD VSS sg13g2_decap_4
Xclkload5 clkload5/Y clkload5/A VDD VSS sg13g2_inv_1
XFILLER_138_938 VDD VSS sg13g2_decap_8
X_08286_ _08286_/Y _08286_/A _08286_/B _08286_/C VDD VSS sg13g2_nor3_1
XFILLER_149_286 VDD VSS sg13g2_decap_8
XFILLER_149_297 VDD VSS sg13g2_fill_2
XFILLER_20_785 VDD VSS sg13g2_fill_1
XFILLER_137_448 VDD VSS sg13g2_fill_1
XFILLER_30_1032 VDD VSS sg13g2_decap_4
XFILLER_118_651 VDD VSS sg13g2_decap_8
XFILLER_119_7 VDD VSS sg13g2_decap_8
XFILLER_121_1193 VDD VSS sg13g2_decap_8
XFILLER_133_621 VDD VSS sg13g2_decap_8
XFILLER_3_428 VDD VSS sg13g2_decap_8
X_13813__2751 _13813_/RESET_B VDD VSS sg13g2_tiehi
X_14573__1991 _14573_/RESET_B VDD VSS sg13g2_tiehi
XFILLER_3_439 VDD VSS sg13g2_fill_2
XFILLER_106_846 VDD VSS sg13g2_decap_4
XFILLER_59_14 VDD VSS sg13g2_decap_8
XFILLER_133_654 VDD VSS sg13g2_decap_4
XFILLER_106_868 VDD VSS sg13g2_fill_1
XFILLER_1_7 VDD VSS sg13g2_decap_8
XFILLER_78_229 VDD VSS sg13g2_fill_1
XFILLER_87_730 VDD VSS sg13g2_decap_8
Xfanout220 _09696_/A0 _09098_/Y VDD VSS sg13g2_buf_1
Xfanout1218 _11243_/B _13312_/A VDD VSS sg13g2_buf_1
Xfanout1229 _13309_/A2 _12962_/C VDD VSS sg13g2_buf_1
X_14157__2407 _14157_/RESET_B VDD VSS sg13g2_tiehi
X_15245__3398 _15245_/RESET_B VDD VSS sg13g2_tiehi
Xfanout242 _09956_/A1 wire246/X VDD VSS sg13g2_buf_1
XFILLER_120_359 VDD VSS sg13g2_decap_4
Xfanout264 _10085_/A0 _09920_/A1 VDD VSS sg13g2_buf_1
XFILLER_8_1055 VDD VSS sg13g2_decap_8
XFILLER_86_240 VDD VSS sg13g2_fill_2
XFILLER_19_307 VDD VSS sg13g2_decap_4
XFILLER_47_616 VDD VSS sg13g2_decap_8
Xfanout275 _12147_/B1 _11247_/X VDD VSS sg13g2_buf_1
Xfanout286 _09919_/A1 _09045_/Y VDD VSS sg13g2_buf_1
X_09809_ _14397_/D _09908_/A1 _14397_/Q _09810_/S VDD VSS sg13g2_mux2_1
XFILLER_86_273 VDD VSS sg13g2_fill_2
XFILLER_28_841 VDD VSS sg13g2_decap_8
XFILLER_28_852 VDD VSS sg13g2_fill_2
X_12820_ _12820_/Y _12817_/Y _12818_/Y _12819_/Y VDD VSS sg13g2_a21oi_1
XFILLER_27_373 VDD VSS sg13g2_decap_8
XFILLER_76_1224 VDD VSS sg13g2_decap_8
XFILLER_27_384 VDD VSS sg13g2_fill_2
XFILLER_15_524 VDD VSS sg13g2_fill_1
X_12751_ _12764_/A _07625_/A _12751_/A2 _15018_/Q VDD VSS sg13g2_a21oi_1
XFILLER_76_1235 VDD VSS sg13g2_fill_2
XFILLER_131_63 VDD VSS sg13g2_decap_8
XFILLER_42_310 VDD VSS sg13g2_fill_2
XFILLER_82_490 VDD VSS sg13g2_fill_1
X_11702_ _14970_/D _11702_/A _11702_/B VDD VSS sg13g2_nor2_1
XFILLER_43_866 VDD VSS sg13g2_fill_1
X_12682_ _12682_/X _14579_/Q _14611_/Q _14643_/Q _14675_/Q _12689_/S0 _12689_/S1 VDD
+ VSS sg13g2_mux4_1
XFILLER_70_674 VDD VSS sg13g2_decap_8
XFILLER_91_78 VDD VSS sg13g2_decap_8
XFILLER_145_0 VDD VSS sg13g2_decap_8
X_14421_ _14421_/Q clkload42/A _14421_/D _14421_/RESET_B VDD VSS sg13g2_dfrbpq_1
X_11633_ _11663_/A _11635_/A _13681_/Q VDD VSS sg13g2_nand2_1
XFILLER_126_1071 VDD VSS sg13g2_fill_2
XFILLER_128_404 VDD VSS sg13g2_fill_1
X_14352_ _14352_/Q _14714_/CLK _14352_/D _14352_/RESET_B VDD VSS sg13g2_dfrbpq_1
XFILLER_128_415 VDD VSS sg13g2_decap_8
X_11564_ _11564_/Y _11631_/A2 _11563_/Y _12227_/B VDD VSS sg13g2_o21ai_1
XFILLER_129_949 VDD VSS sg13g2_fill_2
XFILLER_156_746 VDD VSS sg13g2_fill_2
XFILLER_11_785 VDD VSS sg13g2_fill_2
XFILLER_13_1230 VDD VSS sg13g2_decap_8
XFILLER_6_211 VDD VSS sg13g2_decap_8
X_13303_ wire810/A _13308_/A _13308_/B VDD VSS sg13g2_nor2b_1
XFILLER_128_448 VDD VSS sg13g2_decap_4
X_10515_ _10579_/B _10538_/A _10538_/B VDD VSS sg13g2_nor2_1
XFILLER_156_779 VDD VSS sg13g2_fill_1
XFILLER_155_245 VDD VSS sg13g2_decap_8
X_11495_ _11495_/Y _11495_/A VDD VSS sg13g2_inv_1
X_14283_ _14283_/Q _14731_/CLK _14283_/D _14283_/RESET_B VDD VSS sg13g2_dfrbpq_1
XFILLER_137_971 VDD VSS sg13g2_decap_8
XFILLER_137_982 VDD VSS sg13g2_fill_2
XFILLER_100_1233 VDD VSS sg13g2_decap_4
X_13234_ _13234_/Y _14859_/Q _13234_/B VDD VSS sg13g2_nand2_1
X_10446_ wire760/A _10459_/B _10459_/C VDD VSS sg13g2_nor2_1
XFILLER_136_470 VDD VSS sg13g2_decap_8
XFILLER_136_481 VDD VSS sg13g2_fill_1
XFILLER_152_941 VDD VSS sg13g2_decap_8
XFILLER_6_299 VDD VSS sg13g2_decap_4
XFILLER_152_952 VDD VSS sg13g2_fill_1
XFILLER_83_1217 VDD VSS sg13g2_decap_8
X_10377_ _10396_/C _14815_/Q _14816_/Q _14817_/Q VDD VSS sg13g2_and3_1
X_13165_ _13165_/Y _13162_/Y _13163_/Y _13164_/Y VDD VSS sg13g2_a21oi_1
XFILLER_97_505 VDD VSS sg13g2_decap_4
X_12116_ _12116_/Y _12092_/Y _12094_/Y _12075_/A VDD VSS sg13g2_a21oi_1
XFILLER_123_164 VDD VSS sg13g2_decap_8
X_13096_ _13096_/Y _14785_/Q _13123_/A2 _13262_/B1 VDD VSS sg13g2_o21ai_1
XFILLER_34_7 VDD VSS sg13g2_decap_8
XFILLER_111_315 VDD VSS sg13g2_decap_4
XFILLER_123_175 VDD VSS sg13g2_fill_1
XFILLER_78_730 VDD VSS sg13g2_decap_8
XFILLER_2_494 VDD VSS sg13g2_decap_8
XFILLER_78_741 VDD VSS sg13g2_fill_1
Xfanout1730 _11418_/A _11400_/A VDD VSS sg13g2_buf_1
X_12047_ _12047_/Y _12027_/Y _12029_/Y _12048_/A1 VDD VSS sg13g2_a21oi_1
Xfanout1741 _11373_/A _11348_/A1 VDD VSS sg13g2_buf_1
XFILLER_46_1094 VDD VSS sg13g2_fill_2
Xfanout1752 _12328_/A1 fanout1753/X VDD VSS sg13g2_buf_1
X_15047__2916 _15047_/RESET_B VDD VSS sg13g2_tiehi
Xfanout1763 _10347_/B _10490_/A VDD VSS sg13g2_buf_1
XFILLER_1_21 VDD VSS sg13g2_decap_8
Xfanout1774 _07625_/A fanout1797/X VDD VSS sg13g2_buf_1
X_16855_ _16855_/X _16855_/A VDD VSS sg13g2_buf_1
Xfanout1785 _10444_/C _10350_/C VDD VSS sg13g2_buf_1
Xfanout1796 _10256_/C fanout1797/X VDD VSS sg13g2_buf_1
XFILLER_20_1212 VDD VSS sg13g2_decap_8
XFILLER_65_468 VDD VSS sg13g2_decap_8
XFILLER_81_917 VDD VSS sg13g2_decap_8
XFILLER_53_619 VDD VSS sg13g2_decap_8
XFILLER_92_254 VDD VSS sg13g2_fill_1
X_13998_ _13998_/Q _14494_/CLK _13998_/D _13998_/RESET_B VDD VSS sg13g2_dfrbpq_1
XFILLER_46_660 VDD VSS sg13g2_fill_2
XFILLER_52_107 VDD VSS sg13g2_decap_8
XFILLER_93_799 VDD VSS sg13g2_fill_1
XFILLER_92_287 VDD VSS sg13g2_decap_8
X_12949_ _12949_/Y _14776_/Q _13220_/A2 _12978_/B1 VDD VSS sg13g2_o21ai_1
XFILLER_34_844 VDD VSS sg13g2_fill_1
X_13855__2709 _13855_/RESET_B VDD VSS sg13g2_tiehi
X_15185__3196 _15185_/RESET_B VDD VSS sg13g2_tiehi
XFILLER_60_140 VDD VSS sg13g2_decap_8
XFILLER_60_151 VDD VSS sg13g2_decap_4
XFILLER_34_899 VDD VSS sg13g2_decap_8
X_14619_ _14619_/Q clkload75/A _14619_/D _14619_/RESET_B VDD VSS sg13g2_dfrbpq_1
XFILLER_21_549 VDD VSS sg13g2_fill_2
XFILLER_60_195 VDD VSS sg13g2_fill_1
XFILLER_18_1163 VDD VSS sg13g2_decap_8
XFILLER_144_1171 VDD VSS sg13g2_fill_1
X_08140_ _08140_/Y _08142_/C _08140_/B VDD VSS sg13g2_nand2_1
XFILLER_53_1076 VDD VSS sg13g2_decap_8
XFILLER_140_1046 VDD VSS sg13g2_decap_8
X_14235__2329 _14235_/RESET_B VDD VSS sg13g2_tiehi
X_08071_ _08071_/Y _07882_/Y _08453_/B1 _08001_/C VDD VSS sg13g2_o21ai_1
XFILLER_88_1117 VDD VSS sg13g2_fill_2
XFILLER_140_1068 VDD VSS sg13g2_decap_4
XFILLER_60_0 VDD VSS sg13g2_decap_8
Xmax_cap1060 _12609_/S _12664_/S VDD VSS sg13g2_buf_4
XFILLER_146_278 VDD VSS sg13g2_decap_8
Xmax_cap1071 _12720_/S _12776_/S VDD VSS sg13g2_buf_4
XFILLER_155_790 VDD VSS sg13g2_decap_8
Xmax_cap987 _12113_/C1 fanout986/X VDD VSS sg13g2_buf_8
XFILLER_114_142 VDD VSS sg13g2_decap_8
X_14450__2114 _14450_/RESET_B VDD VSS sg13g2_tiehi
X_08973_ _13756_/D _13756_/Q _10072_/A0 _09084_/S VDD VSS sg13g2_mux2_1
XFILLER_102_326 VDD VSS sg13g2_decap_8
XFILLER_29_28 VDD VSS sg13g2_decap_8
XFILLER_25_1123 VDD VSS sg13g2_decap_8
X_07924_ _07926_/B _08203_/A _14995_/Q _07924_/C VDD VSS sg13g2_nor3_1
XFILLER_5_1206 VDD VSS sg13g2_decap_8
XFILLER_96_571 VDD VSS sg13g2_decap_8
XFILLER_112_1115 VDD VSS sg13g2_fill_1
XFILLER_28_104 VDD VSS sg13g2_decap_8
XFILLER_56_413 VDD VSS sg13g2_fill_1
XFILLER_60_1058 VDD VSS sg13g2_fill_1
XFILLER_99_1224 VDD VSS sg13g2_decap_8
XFILLER_151_1175 VDD VSS sg13g2_decap_8
X_07855_ _08641_/B _07855_/A _07855_/B VDD VSS sg13g2_or2_1
XFILLER_99_1235 VDD VSS sg13g2_fill_2
XFILLER_56_446 VDD VSS sg13g2_decap_4
XFILLER_84_755 VDD VSS sg13g2_fill_1
XFILLER_72_906 VDD VSS sg13g2_decap_8
X_07786_ _08414_/B _07786_/A _08351_/B VDD VSS sg13g2_and2_1
XFILLER_43_118 VDD VSS sg13g2_decap_8
XFILLER_37_682 VDD VSS sg13g2_fill_2
X_09525_ _14124_/D _09923_/A1 _14124_/Q _09538_/S VDD VSS sg13g2_mux2_1
XFILLER_24_310 VDD VSS sg13g2_decap_4
XFILLER_36_192 VDD VSS sg13g2_decap_8
X_09456_ _14057_/D _09621_/A0 _14057_/Q _09470_/S VDD VSS sg13g2_mux2_1
XFILLER_51_140 VDD VSS sg13g2_fill_1
XFILLER_40_825 VDD VSS sg13g2_decap_8
X_08407_ _08407_/Y _08560_/B _08327_/X _08406_/X VDD VSS sg13g2_a21oi_1
X_09387_ _13990_/D _09653_/A0 _13990_/Q _09388_/S VDD VSS sg13g2_mux2_1
XFILLER_32_1105 VDD VSS sg13g2_decap_4
X_08338_ _08338_/Y _08253_/X _08621_/B VDD VSS sg13g2_nand2b_1
X_08269_ _15227_/D _08395_/A _08268_/Y _08262_/Y VDD VSS sg13g2_o21ai_1
X_14660__1904 _14660_/RESET_B VDD VSS sg13g2_tiehi
XFILLER_119_960 VDD VSS sg13g2_fill_2
X_10300_ _14793_/D _10311_/A _10311_/B _10295_/B _10297_/B _10468_/A VDD VSS sg13g2_a221oi_1
X_11280_ _11280_/Y _11279_/Y _11278_/Y _11283_/B VDD VSS sg13g2_a21oi_1
XFILLER_146_790 VDD VSS sg13g2_decap_8
XFILLER_106_643 VDD VSS sg13g2_decap_4
X_10231_ _10232_/B _14771_/Q _14772_/Q _10234_/D VDD VSS sg13g2_nand3_1
XFILLER_105_120 VDD VSS sg13g2_decap_4
XFILLER_3_247 VDD VSS sg13g2_decap_8
XFILLER_10_63 VDD VSS sg13g2_decap_8
XFILLER_126_41 VDD VSS sg13g2_fill_2
X_10162_ _14739_/D _14739_/Q _10162_/A1 _10163_/S VDD VSS sg13g2_mux2_1
XFILLER_79_538 VDD VSS sg13g2_decap_8
Xfanout1004 _13307_/B _10886_/A2 VDD VSS sg13g2_buf_1
Xfanout1015 _08597_/B _08328_/S VDD VSS sg13g2_buf_1
XFILLER_117_1048 VDD VSS sg13g2_decap_8
XFILLER_0_954 VDD VSS sg13g2_fill_1
Xfanout1026 _08329_/B _08363_/S0 VDD VSS sg13g2_buf_1
XFILLER_126_96 VDD VSS sg13g2_decap_8
X_14970_ _14970_/Q clkload37/A _14970_/D _14970_/RESET_B VDD VSS sg13g2_dfrbpq_1
XFILLER_121_679 VDD VSS sg13g2_decap_8
X_10093_ _14673_/D _10093_/A0 _14673_/Q _10093_/S VDD VSS sg13g2_mux2_1
Xfanout1048 _10510_/B _10647_/D VDD VSS sg13g2_buf_1
Xfanout1059 _12664_/S _12789_/S1 VDD VSS sg13g2_buf_1
XFILLER_0_998 VDD VSS sg13g2_decap_4
X_13921_ _13921_/Q clkload26/A _13921_/D _13921_/RESET_B VDD VSS sg13g2_dfrbpq_1
XFILLER_87_593 VDD VSS sg13g2_fill_1
XFILLER_48_969 VDD VSS sg13g2_decap_8
XFILLER_75_755 VDD VSS sg13g2_fill_2
XFILLER_19_148 VDD VSS sg13g2_fill_2
X_13852_ _13852_/Q clkload76/A _13852_/D _13852_/RESET_B VDD VSS sg13g2_dfrbpq_1
XFILLER_63_928 VDD VSS sg13g2_fill_2
XFILLER_90_736 VDD VSS sg13g2_decap_8
X_12803_ _12803_/X _13609_/A _12899_/C _12899_/A VDD VSS sg13g2_and3_1
XFILLER_76_1021 VDD VSS sg13g2_decap_8
X_13783_ _13783_/Q clkload4/A _13783_/D _13783_/RESET_B VDD VSS sg13g2_dfrbpq_1
XFILLER_76_1032 VDD VSS sg13g2_fill_1
X_10995_ _10995_/Y wire385/X _10995_/B _10995_/C VDD VSS sg13g2_nor3_1
XFILLER_76_1043 VDD VSS sg13g2_decap_4
XFILLER_37_1005 VDD VSS sg13g2_decap_4
XFILLER_76_1054 VDD VSS sg13g2_decap_8
X_12734_ _12734_/X _12733_/X _12732_/X _12734_/S VDD VSS sg13g2_mux2_1
XFILLER_42_140 VDD VSS sg13g2_decap_8
XFILLER_71_983 VDD VSS sg13g2_fill_1
XFILLER_37_1038 VDD VSS sg13g2_decap_4
XFILLER_37_1049 VDD VSS sg13g2_decap_8
XFILLER_31_858 VDD VSS sg13g2_decap_8
X_12665_ wire373/A _13671_/Q _12679_/A2 _12664_/X _12679_/B2 _12679_/C1 VDD VSS sg13g2_a221oi_1
XFILLER_30_335 VDD VSS sg13g2_decap_8
XFILLER_42_195 VDD VSS sg13g2_decap_8
XFILLER_129_702 VDD VSS sg13g2_decap_8
X_14404_ _14404_/Q _15160_/CLK _14404_/D _14404_/RESET_B VDD VSS sg13g2_dfrbpq_1
X_11616_ _11616_/Y _12206_/S0 _13830_/Q VDD VSS sg13g2_nand2b_1
X_12596_ wire377/A _13676_/Q _12679_/A2 _12595_/X _12679_/B2 _12791_/C1 VDD VSS sg13g2_a221oi_1
X_14335_ _14335_/Q clkload51/A _14335_/D _14335_/RESET_B VDD VSS sg13g2_dfrbpq_1
X_11547_ _11547_/Y _11543_/Y _11544_/Y _11546_/Y _11545_/Y _12246_/B VDD VSS sg13g2_a221oi_1
X_14782__3316 _14782_/RESET_B VDD VSS sg13g2_tiehi
XFILLER_128_278 VDD VSS sg13g2_fill_2
X_14266_ _14266_/Q _14714_/CLK _14266_/D _14266_/RESET_B VDD VSS sg13g2_dfrbpq_1
X_11478_ _11478_/Y _11765_/A _11476_/X _11477_/Y VDD VSS sg13g2_o21ai_1
XFILLER_125_930 VDD VSS sg13g2_decap_8
X_13217_ _13217_/X input23/X _13272_/A2 _13252_/B1 VDD VSS sg13g2_a21o_1
X_10429_ _10434_/C _10670_/A _14832_/Q _14831_/Q _10510_/B VDD VSS sg13g2_and4_1
XFILLER_125_963 VDD VSS sg13g2_fill_1
X_14197_ _14197_/Q _14671_/CLK _14197_/D _14197_/RESET_B VDD VSS sg13g2_dfrbpq_1
XFILLER_152_771 VDD VSS sg13g2_decap_8
XFILLER_124_462 VDD VSS sg13g2_fill_1
XFILLER_48_1156 VDD VSS sg13g2_fill_2
XFILLER_100_1096 VDD VSS sg13g2_fill_2
XFILLER_3_770 VDD VSS sg13g2_fill_2
XFILLER_44_1009 VDD VSS sg13g2_fill_2
XFILLER_97_324 VDD VSS sg13g2_fill_1
X_13148_ _13148_/Y _13170_/C _13148_/B VDD VSS sg13g2_xnor2_1
XFILLER_140_944 VDD VSS sg13g2_decap_8
XFILLER_124_495 VDD VSS sg13g2_decap_4
XFILLER_135_1148 VDD VSS sg13g2_decap_8
XFILLER_85_508 VDD VSS sg13g2_decap_8
X_13909__2655 _13909_/RESET_B VDD VSS sg13g2_tiehi
XFILLER_100_819 VDD VSS sg13g2_decap_8
X_13079_ _13079_/Y _13077_/X _13092_/A _13160_/B VDD VSS sg13g2_nand3b_1
X_14669__1895 _14669_/RESET_B VDD VSS sg13g2_tiehi
Xfanout1571 _12836_/B _13692_/Q VDD VSS sg13g2_buf_1
Xfanout1582 _12263_/C _12265_/B1 VDD VSS sg13g2_buf_1
Xfanout1593 _12265_/A2 _11284_/B1 VDD VSS sg13g2_buf_1
X_07640_ _10265_/A _14781_/Q VDD VSS sg13g2_inv_1
XFILLER_26_608 VDD VSS sg13g2_decap_8
XFILLER_0_1103 VDD VSS sg13g2_decap_8
XFILLER_0_1114 VDD VSS sg13g2_fill_1
X_15159__3024 _15159_/RESET_B VDD VSS sg13g2_tiehi
XFILLER_111_1170 VDD VSS sg13g2_fill_1
XFILLER_34_630 VDD VSS sg13g2_fill_1
XFILLER_80_235 VDD VSS sg13g2_fill_1
XFILLER_146_1200 VDD VSS sg13g2_decap_8
XFILLER_20_1086 VDD VSS sg13g2_decap_8
X_09310_ _13917_/D _10140_/A1 _13917_/Q _09312_/S VDD VSS sg13g2_mux2_1
XFILLER_0_1158 VDD VSS sg13g2_decap_4
XFILLER_33_151 VDD VSS sg13g2_decap_4
XFILLER_22_814 VDD VSS sg13g2_fill_2
X_09241_ wire510/A _09307_/B _10137_/C VDD VSS sg13g2_nor2_1
XFILLER_107_1228 VDD VSS sg13g2_decap_8
XFILLER_22_869 VDD VSS sg13g2_decap_4
X_09172_ _13788_/D _13788_/Q _10072_/A0 _09190_/S VDD VSS sg13g2_mux2_1
X_15244__3397 _15244_/RESET_B VDD VSS sg13g2_tiehi
XFILLER_147_510 VDD VSS sg13g2_fill_2
X_14504__2060 _14504_/RESET_B VDD VSS sg13g2_tiehi
X_08123_ _08688_/D _08669_/B1 _08048_/Y _08242_/A VDD VSS sg13g2_o21ai_1
XFILLER_147_576 VDD VSS sg13g2_fill_2
XFILLER_31_1160 VDD VSS sg13g2_decap_8
X_08054_ _08054_/Y _07972_/B _08054_/B VDD VSS sg13g2_nand2b_1
XFILLER_66_1234 VDD VSS sg13g2_fill_2
XFILLER_89_825 VDD VSS sg13g2_fill_1
XFILLER_143_782 VDD VSS sg13g2_decap_8
XFILLER_88_313 VDD VSS sg13g2_decap_8
XFILLER_116_996 VDD VSS sg13g2_decap_8
XFILLER_27_1229 VDD VSS sg13g2_decap_8
XFILLER_153_1226 VDD VSS sg13g2_decap_8
XFILLER_0_239 VDD VSS sg13g2_decap_8
XFILLER_89_869 VDD VSS sg13g2_decap_8
XFILLER_130_443 VDD VSS sg13g2_decap_8
XFILLER_76_519 VDD VSS sg13g2_decap_8
X_08956_ _13722_/D _13722_/Q _08955_/X _08956_/S VDD VSS sg13g2_mux2_1
XFILLER_5_1003 VDD VSS sg13g2_fill_2
XFILLER_9_1183 VDD VSS sg13g2_decap_8
X_07907_ _07908_/B _15073_/Q _15216_/Q _15215_/Q _07907_/D VDD VSS sg13g2_nor4_1
XFILLER_130_498 VDD VSS sg13g2_decap_8
XFILLER_56_210 VDD VSS sg13g2_decap_8
X_08887_ _08887_/Y _11706_/A _08940_/S _08886_/Y VDD VSS sg13g2_a21oi_1
XFILLER_57_755 VDD VSS sg13g2_fill_1
XFILLER_84_541 VDD VSS sg13g2_decap_8
X_07838_ _08684_/A _08697_/B _08698_/A VDD VSS sg13g2_nand2_1
XFILLER_44_405 VDD VSS sg13g2_fill_2
XFILLER_112_21 VDD VSS sg13g2_decap_8
XFILLER_56_287 VDD VSS sg13g2_decap_8
XFILLER_44_438 VDD VSS sg13g2_decap_8
X_07769_ _08318_/A _08265_/A _08265_/B VDD VSS sg13g2_nor2_1
XFILLER_60_909 VDD VSS sg13g2_decap_8
XFILLER_53_950 VDD VSS sg13g2_fill_2
XFILLER_72_14 VDD VSS sg13g2_decap_8
X_14714__1850 _14714_/RESET_B VDD VSS sg13g2_tiehi
X_09508_ _14107_/D _09741_/A1 _14107_/Q _09539_/S VDD VSS sg13g2_mux2_1
X_10780_ _14921_/D _11168_/B1 _10777_/Y _10779_/Y VDD VSS sg13g2_o21ai_1
XFILLER_13_825 VDD VSS sg13g2_decap_8
XFILLER_73_1227 VDD VSS sg13g2_decap_8
X_14903__3123 _14903_/RESET_B VDD VSS sg13g2_tiehi
X_09439_ _14041_/D _10101_/A0 _14041_/Q _09439_/S VDD VSS sg13g2_mux2_1
XFILLER_40_644 VDD VSS sg13g2_decap_8
XFILLER_12_346 VDD VSS sg13g2_decap_8
XFILLER_8_306 VDD VSS sg13g2_decap_8
X_12450_ _12450_/X _13954_/Q _13986_/Q _14018_/Q _14050_/Q _12450_/S0 _12452_/S1 VDD
+ VSS sg13g2_mux4_1
X_11401_ _11401_/Y _11401_/A _11401_/B _11419_/C VDD VSS sg13g2_nand3_1
XFILLER_123_1052 VDD VSS sg13g2_decap_8
X_12381_ _12381_/X _14365_/Q _14397_/Q _14461_/Q _14493_/Q _12381_/S0 _12381_/S1 VDD
+ VSS sg13g2_mux4_1
XFILLER_126_716 VDD VSS sg13g2_fill_1
XFILLER_153_502 VDD VSS sg13g2_decap_8
XFILLER_153_513 VDD VSS sg13g2_decap_8
X_14120_ _14120_/Q clkload23/A _14120_/D _14120_/RESET_B VDD VSS sg13g2_dfrbpq_1
XFILLER_125_204 VDD VSS sg13g2_decap_8
XFILLER_138_598 VDD VSS sg13g2_decap_8
X_11332_ wire256/A _11424_/B _11313_/Y _11331_/Y VDD VSS sg13g2_o21ai_1
X_14936__3057 _14936_/RESET_B VDD VSS sg13g2_tiehi
XFILLER_21_84 VDD VSS sg13g2_fill_1
X_14051_ _14051_/Q clkload2/A _14051_/D _14051_/RESET_B VDD VSS sg13g2_dfrbpq_1
XFILLER_4_556 VDD VSS sg13g2_decap_8
XFILLER_107_963 VDD VSS sg13g2_fill_1
XFILLER_108_0 VDD VSS sg13g2_decap_8
X_11263_ _11263_/Y _11263_/A1 _13916_/Q _11262_/Y VDD VSS sg13g2_a21oi_1
X_13002_ _13002_/Y _14779_/Q _13220_/A2 _13123_/B1 VDD VSS sg13g2_o21ai_1
X_10214_ _10214_/Y _07661_/Y _10213_/X _14764_/Q VDD VSS sg13g2_a21oi_1
X_11194_ _11194_/Y _11192_/X _11188_/Y _11193_/Y VDD VSS sg13g2_o21ai_1
XFILLER_79_346 VDD VSS sg13g2_fill_2
X_10145_ _14722_/D _14722_/Q _10145_/A1 _10166_/S VDD VSS sg13g2_mux2_1
XFILLER_0_751 VDD VSS sg13g2_decap_8
X_10076_ _14656_/D _10076_/A0 _14656_/Q _10099_/S VDD VSS sg13g2_mux2_1
X_14953_ _14953_/Q _15046_/CLK _14953_/D _14953_/RESET_B VDD VSS sg13g2_dfrbpq_1
XFILLER_130_1012 VDD VSS sg13g2_fill_1
XFILLER_43_1075 VDD VSS sg13g2_fill_1
XFILLER_87_390 VDD VSS sg13g2_decap_8
XFILLER_47_232 VDD VSS sg13g2_decap_4
X_14546__2018 _14546_/RESET_B VDD VSS sg13g2_tiehi
X_13904_ _13904_/Q clkload42/A _13904_/D _13904_/RESET_B VDD VSS sg13g2_dfrbpq_1
XFILLER_75_563 VDD VSS sg13g2_decap_8
X_14884_ _14884_/Q clkload78/A _14884_/D _14884_/RESET_B VDD VSS sg13g2_dfrbpq_1
XFILLER_63_714 VDD VSS sg13g2_decap_8
X_15114__3116 _15114_/RESET_B VDD VSS sg13g2_tiehi
XFILLER_130_1089 VDD VSS sg13g2_fill_1
X_13835_ _13835_/Q clkload50/A _13835_/D _13835_/RESET_B VDD VSS sg13g2_dfrbpq_1
XFILLER_51_909 VDD VSS sg13g2_decap_8
XFILLER_90_566 VDD VSS sg13g2_decap_8
XFILLER_44_972 VDD VSS sg13g2_fill_1
X_13766_ _13766_/Q _14726_/CLK _13766_/D _13766_/RESET_B VDD VSS sg13g2_dfrbpq_1
XFILLER_31_600 VDD VSS sg13g2_decap_8
X_10978_ _10978_/Y _10978_/A _10978_/B VDD VSS sg13g2_nor2_1
XFILLER_31_611 VDD VSS sg13g2_fill_2
XFILLER_71_791 VDD VSS sg13g2_decap_8
X_12717_ _12717_/X _14261_/Q _14293_/Q _14325_/Q _14357_/Q _12772_/S0 _12772_/S1 VDD
+ VSS sg13g2_mux4_1
X_13697_ _13697_/Q clkload18/A _13697_/D _13697_/RESET_B VDD VSS sg13g2_dfrbpq_1
XFILLER_62_80 VDD VSS sg13g2_decap_4
XFILLER_15_1122 VDD VSS sg13g2_decap_8
X_12648_ _12648_/X _12645_/X _12644_/X _12641_/X _12640_/X _12775_/S1 _12776_/S VDD
+ VSS sg13g2_mux4_1
XFILLER_30_176 VDD VSS sg13g2_decap_8
XFILLER_30_187 VDD VSS sg13g2_decap_8
XFILLER_141_1163 VDD VSS sg13g2_fill_1
XFILLER_156_351 VDD VSS sg13g2_decap_8
XFILLER_7_42 VDD VSS sg13g2_decap_8
X_12579_ _12579_/X _12574_/X _12578_/X _12573_/X _12577_/X _12776_/S _12775_/S1 VDD
+ VSS sg13g2_mux4_1
XFILLER_156_362 VDD VSS sg13g2_fill_1
XFILLER_50_1068 VDD VSS sg13g2_decap_8
Xwire270 wire270/X wire270/A VDD VSS sg13g2_buf_1
XFILLER_15_1199 VDD VSS sg13g2_decap_8
XFILLER_7_361 VDD VSS sg13g2_fill_1
X_14318_ _14318_/Q clkload57/A _14318_/D _14318_/RESET_B VDD VSS sg13g2_dfrbpq_1
X_14152__2412 _14152_/RESET_B VDD VSS sg13g2_tiehi
XFILLER_144_535 VDD VSS sg13g2_decap_8
XFILLER_144_546 VDD VSS sg13g2_fill_2
X_14249_ _14249_/Q _14505_/CLK _14249_/D _14249_/RESET_B VDD VSS sg13g2_dfrbpq_1
XFILLER_98_633 VDD VSS sg13g2_fill_1
XFILLER_113_933 VDD VSS sg13g2_fill_1
XFILLER_112_421 VDD VSS sg13g2_decap_8
XFILLER_113_944 VDD VSS sg13g2_fill_2
XFILLER_140_741 VDD VSS sg13g2_fill_1
XFILLER_113_955 VDD VSS sg13g2_fill_2
Xfanout819 _13140_/B2 _12808_/Y VDD VSS sg13g2_buf_1
X_08810_ _08811_/B _13688_/Q _13375_/B VDD VSS sg13g2_nor2_1
XFILLER_98_688 VDD VSS sg13g2_fill_2
XFILLER_100_605 VDD VSS sg13g2_decap_8
X_09790_ _14379_/D _10154_/A1 _14379_/Q _09805_/S VDD VSS sg13g2_mux2_1
XFILLER_113_988 VDD VSS sg13g2_decap_8
XFILLER_61_1120 VDD VSS sg13g2_fill_2
XFILLER_23_0 VDD VSS sg13g2_decap_8
XFILLER_79_880 VDD VSS sg13g2_decap_8
X_14185__2379 _14185_/RESET_B VDD VSS sg13g2_tiehi
XFILLER_79_891 VDD VSS sg13g2_fill_2
X_08741_ _13665_/D _08753_/A1 _08739_/Y _08740_/Y VDD VSS sg13g2_a21oi_1
XFILLER_78_390 VDD VSS sg13g2_decap_8
Xfanout1390 _08457_/S0 _13517_/A VDD VSS sg13g2_buf_1
X_08672_ _08672_/X _08692_/A _08673_/B _15019_/Q VDD VSS sg13g2_and3_1
XFILLER_93_360 VDD VSS sg13g2_fill_1
XFILLER_66_596 VDD VSS sg13g2_decap_8
X_07623_ _07623_/Y _14854_/Q VDD VSS sg13g2_inv_1
XFILLER_26_438 VDD VSS sg13g2_decap_8
XFILLER_81_577 VDD VSS sg13g2_decap_8
XFILLER_22_611 VDD VSS sg13g2_fill_2
XFILLER_146_1041 VDD VSS sg13g2_decap_8
XFILLER_62_791 VDD VSS sg13g2_fill_1
XFILLER_42_28 VDD VSS sg13g2_fill_1
XFILLER_22_666 VDD VSS sg13g2_decap_4
X_09224_ _13835_/D _10154_/A1 _13835_/Q _09239_/S VDD VSS sg13g2_mux2_1
XFILLER_33_1211 VDD VSS sg13g2_decap_8
XFILLER_21_154 VDD VSS sg13g2_decap_8
XFILLER_10_839 VDD VSS sg13g2_decap_4
X_09155_ _09155_/Y _09155_/A1 _15051_/Q _09154_/Y VDD VSS sg13g2_o21ai_1
XFILLER_120_1203 VDD VSS sg13g2_decap_8
X_08106_ _08106_/Y _08453_/B1 _08105_/Y _08001_/C VDD VSS sg13g2_o21ai_1
X_09086_ _09086_/Y _09155_/A1 _15041_/Q _09085_/Y VDD VSS sg13g2_o21ai_1
XFILLER_135_557 VDD VSS sg13g2_fill_2
X_08037_ _08039_/C _08037_/A _08037_/B _08522_/C VDD VSS sg13g2_nand3_1
XFILLER_101_7 VDD VSS sg13g2_decap_8
XFILLER_116_771 VDD VSS sg13g2_fill_1
XFILLER_89_622 VDD VSS sg13g2_decap_8
XFILLER_107_21 VDD VSS sg13g2_decap_8
Xmax_cap581 _10954_/B _10712_/Y VDD VSS sg13g2_buf_2
XFILLER_122_229 VDD VSS sg13g2_decap_8
XFILLER_1_537 VDD VSS sg13g2_decap_8
XFILLER_66_1053 VDD VSS sg13g2_fill_2
XFILLER_143_590 VDD VSS sg13g2_fill_1
XFILLER_153_1034 VDD VSS sg13g2_fill_2
XFILLER_67_14 VDD VSS sg13g2_decap_8
XFILLER_77_828 VDD VSS sg13g2_fill_1
XFILLER_104_999 VDD VSS sg13g2_decap_8
XFILLER_114_1007 VDD VSS sg13g2_fill_1
X_09988_ _14571_/D _10021_/A0 _14571_/Q _10002_/S VDD VSS sg13g2_mux2_1
XFILLER_118_1176 VDD VSS sg13g2_fill_2
XFILLER_130_262 VDD VSS sg13g2_fill_2
XFILLER_131_785 VDD VSS sg13g2_fill_2
X_14015__2549 _14015_/RESET_B VDD VSS sg13g2_tiehi
X_13850__2714 _13850_/RESET_B VDD VSS sg13g2_tiehi
X_08939_ _08939_/X _15049_/Q _14953_/Q _08943_/A VDD VSS sg13g2_mux2_1
XFILLER_69_390 VDD VSS sg13g2_fill_1
XFILLER_123_42 VDD VSS sg13g2_fill_2
X_11950_ _11952_/A _11951_/A _14640_/Q VDD VSS sg13g2_nand2b_1
XFILLER_45_714 VDD VSS sg13g2_fill_1
XFILLER_18_939 VDD VSS sg13g2_decap_8
X_10901_ _10901_/Y _11207_/A2 _10701_/Y _10900_/Y VDD VSS sg13g2_a21oi_1
XFILLER_83_35 VDD VSS sg13g2_decap_4
X_11881_ _11881_/Y _11877_/Y _11878_/Y _11880_/Y _11879_/Y _11875_/B VDD VSS sg13g2_a221oi_1
X_15187__3188 _15187_/RESET_B VDD VSS sg13g2_tiehi
X_13620_ _13728_/D _13620_/A VDD VSS sg13g2_buf_1
X_14230__2334 _14230_/RESET_B VDD VSS sg13g2_tiehi
X_10832_ _10832_/X _10832_/A _10843_/C VDD VSS sg13g2_and2_1
XFILLER_26_983 VDD VSS sg13g2_fill_2
XFILLER_73_1002 VDD VSS sg13g2_fill_1
XFILLER_16_84 VDD VSS sg13g2_decap_8
XFILLER_41_931 VDD VSS sg13g2_decap_8
X_13551_ _15148_/D _15148_/Q wire732/X _13551_/S VDD VSS sg13g2_mux2_1
XFILLER_38_1155 VDD VSS sg13g2_decap_4
XFILLER_13_644 VDD VSS sg13g2_fill_1
X_10763_ _11115_/B _14949_/Q _10769_/A2 _10762_/Y VDD VSS sg13g2_a21oi_1
XFILLER_73_1046 VDD VSS sg13g2_decap_4
XFILLER_38_1177 VDD VSS sg13g2_decap_8
XFILLER_9_604 VDD VSS sg13g2_decap_8
X_12502_ _12502_/X _14374_/Q _14406_/Q _14470_/Q _14502_/Q _12508_/S0 _12508_/S1 VDD
+ VSS sg13g2_mux4_1
XFILLER_125_1147 VDD VSS sg13g2_decap_8
XFILLER_41_997 VDD VSS sg13g2_decap_8
X_13482_ _13484_/B _13482_/A _13482_/B _15189_/Q VDD VSS sg13g2_nand3_1
X_15064__3336 _15064_/RESET_B VDD VSS sg13g2_tiehi
XFILLER_9_648 VDD VSS sg13g2_fill_1
XFILLER_8_114 VDD VSS sg13g2_fill_1
X_10694_ _10871_/A _14932_/Q _09003_/X _10694_/S VDD VSS sg13g2_mux2_1
XFILLER_40_485 VDD VSS sg13g2_fill_2
X_15221_ _15221_/Q clkload67/A _15221_/D _15221_/RESET_B VDD VSS sg13g2_dfrbpq_1
X_12433_ _12433_/X _13825_/Q _13857_/Q _13889_/Q _13921_/Q _12534_/S0 _12534_/S1 VDD
+ VSS sg13g2_mux4_1
XFILLER_8_147 VDD VSS sg13g2_decap_8
XFILLER_139_874 VDD VSS sg13g2_decap_8
X_15143__3056 _15143_/RESET_B VDD VSS sg13g2_tiehi
XFILLER_126_502 VDD VSS sg13g2_fill_2
XFILLER_138_373 VDD VSS sg13g2_decap_4
XFILLER_154_833 VDD VSS sg13g2_decap_8
X_15152_ _15152_/Q _15160_/CLK _15152_/D _15152_/RESET_B VDD VSS sg13g2_dfrbpq_1
X_12364_ _12364_/X _13948_/Q _13980_/Q _14012_/Q _14044_/Q _12366_/S0 _12366_/S1 VDD
+ VSS sg13g2_mux4_1
XFILLER_126_535 VDD VSS sg13g2_fill_2
X_14103_ _14103_/Q clkload3/A _14103_/D _14103_/RESET_B VDD VSS sg13g2_dfrbpq_1
X_11315_ _11315_/Y _11328_/S0 _14397_/Q _11328_/S1 VDD VSS sg13g2_a21oi_1
XFILLER_141_505 VDD VSS sg13g2_fill_1
XFILLER_10_1052 VDD VSS sg13g2_decap_8
X_15083_ _15083_/Q clkload71/A _15083_/D _15083_/RESET_B VDD VSS sg13g2_dfrbpq_1
X_12295_ _12295_/Y wire297/X _12294_/Y _12271_/A VDD VSS sg13g2_a21oi_1
XFILLER_99_419 VDD VSS sg13g2_fill_1
XFILLER_101_1191 VDD VSS sg13g2_fill_2
X_14034_ _14034_/Q _14738_/CLK _14034_/D _14034_/RESET_B VDD VSS sg13g2_dfrbpq_1
X_11246_ _11246_/Y _11243_/B _07690_/X _11245_/Y VDD VSS sg13g2_a21oi_1
XFILLER_122_730 VDD VSS sg13g2_fill_2
XFILLER_106_292 VDD VSS sg13g2_decap_8
XFILLER_45_1126 VDD VSS sg13g2_decap_8
XFILLER_80_1006 VDD VSS sg13g2_fill_2
XFILLER_45_1137 VDD VSS sg13g2_fill_1
X_11177_ _11177_/X _11197_/A _11177_/B _11177_/C VDD VSS sg13g2_or3_1
XFILLER_95_614 VDD VSS sg13g2_decap_8
XFILLER_67_316 VDD VSS sg13g2_decap_8
XFILLER_121_262 VDD VSS sg13g2_decap_8
XFILLER_132_1129 VDD VSS sg13g2_fill_2
XFILLER_0_570 VDD VSS sg13g2_fill_1
X_10128_ _14706_/D _10161_/A1 _14706_/Q _10135_/S VDD VSS sg13g2_mux2_1
X_15243__3396 _15243_/RESET_B VDD VSS sg13g2_tiehi
XFILLER_48_530 VDD VSS sg13g2_decap_4
X_14936_ _14936_/Q clkload34/A _14936_/D _14936_/RESET_B VDD VSS sg13g2_dfrbpq_1
XFILLER_94_168 VDD VSS sg13g2_decap_4
X_10059_ _14640_/D _10092_/A0 _14640_/Q _10060_/S VDD VSS sg13g2_mux2_1
XFILLER_36_747 VDD VSS sg13g2_decap_4
X_14867_ _14867_/Q _14873_/CLK _14867_/D _14867_/RESET_B VDD VSS sg13g2_dfrbpq_1
X_13818_ _13818_/Q clkload47/A _13818_/D _13818_/RESET_B VDD VSS sg13g2_dfrbpq_1
X_14798_ _14798_/Q clkload81/A _14798_/D _14798_/RESET_B VDD VSS sg13g2_dfrbpq_1
XFILLER_56_1222 VDD VSS sg13g2_decap_8
XFILLER_17_994 VDD VSS sg13g2_decap_8
XFILLER_44_791 VDD VSS sg13g2_decap_8
XFILLER_90_396 VDD VSS sg13g2_decap_8
X_13749_ _13749_/Q _14671_/CLK _13749_/D _13749_/RESET_B VDD VSS sg13g2_dfrbpq_1
XFILLER_143_1236 VDD VSS sg13g2_fill_1
XFILLER_148_126 VDD VSS sg13g2_fill_2
XFILLER_156_170 VDD VSS sg13g2_fill_1
XFILLER_117_535 VDD VSS sg13g2_decap_8
XFILLER_145_855 VDD VSS sg13g2_fill_1
XFILLER_104_218 VDD VSS sg13g2_decap_4
X_09911_ _14496_/D _14496_/Q _09911_/A1 _09933_/S VDD VSS sg13g2_mux2_1
XFILLER_99_942 VDD VSS sg13g2_fill_1
Xfanout616 _09831_/S wire618/A VDD VSS sg13g2_buf_1
X_09842_ _14429_/D _14429_/Q _10107_/A0 _09844_/S VDD VSS sg13g2_mux2_1
Xclkbuf_4_11_0_clk_i clkbuf_4_11_0_clk_i/X clkbuf_0_clk_i/X VDD VSS sg13g2_buf_8
Xfanout627 _09798_/S wire629/A VDD VSS sg13g2_buf_1
XFILLER_101_903 VDD VSS sg13g2_fill_2
Xfanout638 wire639/A _09641_/X VDD VSS sg13g2_buf_1
XFILLER_98_485 VDD VSS sg13g2_fill_2
XFILLER_112_273 VDD VSS sg13g2_decap_8
XFILLER_6_1131 VDD VSS sg13g2_decap_8
X_14920__3089 _14920_/RESET_B VDD VSS sg13g2_tiehi
X_09773_ wire635/A _09905_/A _10105_/C _09806_/A wire765/X VDD VSS sg13g2_nand4_1
XFILLER_85_135 VDD VSS sg13g2_decap_4
XFILLER_37_28 VDD VSS sg13g2_fill_2
XFILLER_100_457 VDD VSS sg13g2_decap_8
Xclkbuf_leaf_50_clk_i clkload47/A clkbuf_leaf_52_clk_i/A VDD VSS sg13g2_buf_8
X_08724_ _08724_/Y _13412_/B _08724_/B VDD VSS sg13g2_nand2b_1
XFILLER_113_1051 VDD VSS sg13g2_decap_8
XFILLER_82_820 VDD VSS sg13g2_decap_8
XFILLER_94_680 VDD VSS sg13g2_decap_8
XFILLER_148_1103 VDD VSS sg13g2_decap_8
X_08655_ _08655_/Y _08054_/B _08686_/A2 _08054_/Y VDD VSS sg13g2_o21ai_1
XFILLER_82_842 VDD VSS sg13g2_fill_2
XFILLER_148_1114 VDD VSS sg13g2_fill_1
XFILLER_26_235 VDD VSS sg13g2_decap_8
XFILLER_54_544 VDD VSS sg13g2_fill_1
XFILLER_54_577 VDD VSS sg13g2_decap_8
X_08586_ _08588_/C _08641_/C _08586_/B _08586_/C VDD VSS sg13g2_nand3_1
Xclkbuf_leaf_65_clk_i clkload77/A clkbuf_leaf_66_clk_i/A VDD VSS sg13g2_buf_8
XFILLER_81_396 VDD VSS sg13g2_fill_1
XFILLER_23_942 VDD VSS sg13g2_decap_8
XFILLER_22_430 VDD VSS sg13g2_fill_1
XFILLER_149_7 VDD VSS sg13g2_decap_8
XFILLER_23_986 VDD VSS sg13g2_decap_8
XFILLER_22_463 VDD VSS sg13g2_decap_8
XFILLER_10_603 VDD VSS sg13g2_fill_2
X_09207_ _13819_/D _10138_/A1 _13819_/Q _09230_/S VDD VSS sg13g2_mux2_1
XFILLER_72_1090 VDD VSS sg13g2_fill_1
XFILLER_148_671 VDD VSS sg13g2_fill_2
XFILLER_108_513 VDD VSS sg13g2_decap_8
XFILLER_147_170 VDD VSS sg13g2_decap_8
X_09138_ _09138_/X _09137_/A _10776_/A _09137_/Y VDD VSS sg13g2_a21o_1
XFILLER_33_1096 VDD VSS sg13g2_decap_8
XFILLER_147_192 VDD VSS sg13g2_decap_8
X_13904__2660 _13904_/RESET_B VDD VSS sg13g2_tiehi
XFILLER_135_343 VDD VSS sg13g2_fill_2
XFILLER_108_568 VDD VSS sg13g2_fill_1
XFILLER_118_42 VDD VSS sg13g2_decap_8
X_09069_ _09069_/X _09097_/A _09069_/B _09103_/C VDD VSS sg13g2_or3_1
XFILLER_120_1088 VDD VSS sg13g2_decap_8
X_15085__3208 _15085_/RESET_B VDD VSS sg13g2_tiehi
X_11100_ _11100_/Y _11109_/B _10759_/X _11183_/B1 VDD VSS sg13g2_o21ai_1
X_12080_ _12080_/Y _12079_/Y _12078_/Y _12065_/Y _12156_/A _12126_/A VDD VSS sg13g2_a221oi_1
XFILLER_104_741 VDD VSS sg13g2_decap_8
XFILLER_78_68 VDD VSS sg13g2_fill_2
XFILLER_104_752 VDD VSS sg13g2_fill_1
X_14248__2316 _14248_/RESET_B VDD VSS sg13g2_tiehi
X_11031_ _14943_/D _11029_/Y _11030_/Y _11021_/X VDD VSS sg13g2_a21o_1
XFILLER_134_63 VDD VSS sg13g2_decap_8
XFILLER_40_1001 VDD VSS sg13g2_decap_8
XFILLER_44_1170 VDD VSS sg13g2_fill_1
Xclkbuf_leaf_18_clk_i _14916_/CLK clkbuf_5_7__f_clk_i/X VDD VSS sg13g2_buf_8
XFILLER_44_1192 VDD VSS sg13g2_decap_8
XFILLER_79_1211 VDD VSS sg13g2_decap_8
XFILLER_94_56 VDD VSS sg13g2_decap_8
X_12982_ wire253/A _12980_/Y _12981_/Y _12933_/Y VDD VSS sg13g2_o21ai_1
XFILLER_100_980 VDD VSS sg13g2_fill_1
XFILLER_131_1173 VDD VSS sg13g2_decap_8
XFILLER_100_991 VDD VSS sg13g2_fill_2
X_14721_ _14721_/Q clkload27/A _14721_/D _14721_/RESET_B VDD VSS sg13g2_dfrbpq_1
XFILLER_85_691 VDD VSS sg13g2_fill_1
X_14463__2101 _14463_/RESET_B VDD VSS sg13g2_tiehi
X_11933_ _14977_/D _11914_/A _11980_/A _11932_/Y VDD VSS sg13g2_a21o_1
XFILLER_73_853 VDD VSS sg13g2_fill_2
XFILLER_17_246 VDD VSS sg13g2_decap_8
XFILLER_72_341 VDD VSS sg13g2_fill_2
XFILLER_73_875 VDD VSS sg13g2_fill_2
X_14652_ _14652_/Q clkload76/A _14652_/D _14652_/RESET_B VDD VSS sg13g2_dfrbpq_1
XFILLER_17_279 VDD VSS sg13g2_decap_8
X_11864_ _11864_/Y _11865_/A _13674_/Q VDD VSS sg13g2_nor2_1
XFILLER_150_84 VDD VSS sg13g2_decap_8
XFILLER_127_1209 VDD VSS sg13g2_fill_1
X_13603_ _13603_/Y _13602_/Y _13600_/Y _08830_/X VDD VSS sg13g2_o21ai_1
X_10815_ _10815_/Y _11070_/A1 _10814_/Y _13307_/B VDD VSS sg13g2_a21oi_1
X_14583_ _14583_/Q clkload3/A _14583_/D _14583_/RESET_B VDD VSS sg13g2_dfrbpq_1
XFILLER_60_558 VDD VSS sg13g2_fill_1
XFILLER_25_290 VDD VSS sg13g2_decap_8
X_11795_ _14973_/D _11770_/A _11980_/A _11794_/Y VDD VSS sg13g2_a21o_1
XFILLER_129_1091 VDD VSS sg13g2_fill_1
X_13534_ _13534_/Y _13534_/A1 _12936_/B _08351_/B _13546_/B2 VDD VSS sg13g2_a22oi_1
XFILLER_14_986 VDD VSS sg13g2_decap_8
X_10746_ _14914_/D _09204_/C _11078_/A _10745_/Y VDD VSS sg13g2_o21ai_1
XFILLER_43_82 VDD VSS sg13g2_fill_1
XFILLER_41_794 VDD VSS sg13g2_fill_1
X_14496__2068 _14496_/RESET_B VDD VSS sg13g2_tiehi
X_13465_ _13465_/Y _13465_/A1 _08723_/B _12862_/B VDD VSS sg13g2_o21ai_1
X_10677_ _10844_/A _08977_/B _10669_/S _10805_/B VDD VSS sg13g2_a21o_1
X_15204_ _15204_/Q _15209_/CLK _15204_/D _15204_/RESET_B VDD VSS sg13g2_dfrbpq_1
XFILLER_51_1174 VDD VSS sg13g2_decap_8
X_12416_ _12416_/Y _12347_/B _12348_/A _12416_/B1 _13689_/Q _13282_/A1 VDD VSS sg13g2_a221oi_1
XFILLER_64_7 VDD VSS sg13g2_fill_1
X_13396_ _13396_/Y _13401_/C _13401_/B _13429_/A _13396_/D VDD VSS sg13g2_nor4_1
XFILLER_12_1158 VDD VSS sg13g2_decap_8
X_15135_ _15135_/Q clkload26/A _15135_/D _15135_/RESET_B VDD VSS sg13g2_dfrbpq_1
XFILLER_127_877 VDD VSS sg13g2_decap_8
XFILLER_153_140 VDD VSS sg13g2_decap_8
X_12347_ _12348_/D _15122_/Q _12347_/B _15119_/Q _12347_/D VDD VSS sg13g2_nor4_1
XFILLER_114_505 VDD VSS sg13g2_decap_8
XFILLER_127_888 VDD VSS sg13g2_fill_1
XFILLER_99_216 VDD VSS sg13g2_fill_2
XFILLER_142_858 VDD VSS sg13g2_decap_8
XFILLER_4_21 VDD VSS sg13g2_decap_8
X_15066_ _15066_/Q _15178_/CLK _15066_/D _15066_/RESET_B VDD VSS sg13g2_dfrbpq_1
X_12278_ _12279_/B _12278_/A _13663_/Q VDD VSS sg13g2_or2_1
XFILLER_49_1070 VDD VSS sg13g2_decap_8
X_14017_ _14017_/Q clkload20/A _14017_/D _14017_/RESET_B VDD VSS sg13g2_dfrbpq_1
X_11229_ _11229_/X _13819_/Q _13851_/Q _13883_/Q _13915_/Q _11275_/S0 _11282_/S1 VDD
+ VSS sg13g2_mux4_1
XFILLER_136_1040 VDD VSS sg13g2_decap_8
XFILLER_136_1062 VDD VSS sg13g2_fill_2
XFILLER_4_98 VDD VSS sg13g2_decap_8
XFILLER_136_1084 VDD VSS sg13g2_decap_8
XFILLER_23_1210 VDD VSS sg13g2_decap_8
XFILLER_96_978 VDD VSS sg13g2_fill_1
XFILLER_110_755 VDD VSS sg13g2_fill_1
XFILLER_110_799 VDD VSS sg13g2_fill_2
XFILLER_64_820 VDD VSS sg13g2_fill_2
XFILLER_36_522 VDD VSS sg13g2_decap_8
X_14919_ _14919_/Q clkload18/A _14919_/D _14919_/RESET_B VDD VSS sg13g2_dfrbpq_1
XFILLER_36_566 VDD VSS sg13g2_decap_8
X_13946__2618 _13946_/RESET_B VDD VSS sg13g2_tiehi
X_08440_ _08441_/B _08574_/A _08438_/Y _08439_/Y VDD VSS sg13g2_o21ai_1
XFILLER_23_205 VDD VSS sg13g2_decap_8
XFILLER_51_514 VDD VSS sg13g2_decap_4
XFILLER_64_897 VDD VSS sg13g2_decap_8
XFILLER_51_525 VDD VSS sg13g2_fill_2
XFILLER_91_694 VDD VSS sg13g2_decap_8
XFILLER_23_227 VDD VSS sg13g2_decap_8
XFILLER_17_791 VDD VSS sg13g2_decap_4
XFILLER_1_1083 VDD VSS sg13g2_decap_8
X_08371_ _08371_/Y _07795_/A _08370_/Y _08588_/B VDD VSS sg13g2_o21ai_1
XFILLER_90_193 VDD VSS sg13g2_decap_8
XFILLER_143_1000 VDD VSS sg13g2_fill_1
XFILLER_51_569 VDD VSS sg13g2_fill_2
XFILLER_32_761 VDD VSS sg13g2_decap_4
XFILLER_56_1063 VDD VSS sg13g2_decap_8
XFILLER_90_0 VDD VSS sg13g2_decap_8
XFILLER_108_1142 VDD VSS sg13g2_decap_8
XFILLER_17_1036 VDD VSS sg13g2_decap_8
XFILLER_20_923 VDD VSS sg13g2_fill_2
XFILLER_32_794 VDD VSS sg13g2_decap_8
XFILLER_104_1006 VDD VSS sg13g2_decap_8
XFILLER_143_1066 VDD VSS sg13g2_fill_1
X_14326__2238 _14326_/RESET_B VDD VSS sg13g2_tiehi
XFILLER_20_967 VDD VSS sg13g2_decap_8
XFILLER_30_1214 VDD VSS sg13g2_decap_8
XFILLER_132_302 VDD VSS sg13g2_decap_8
XFILLER_133_847 VDD VSS sg13g2_decap_4
X_14541__2023 _14541_/RESET_B VDD VSS sg13g2_tiehi
XFILLER_132_335 VDD VSS sg13g2_fill_2
XFILLER_132_346 VDD VSS sg13g2_decap_8
XFILLER_120_508 VDD VSS sg13g2_fill_2
XFILLER_28_1143 VDD VSS sg13g2_decap_8
XFILLER_59_603 VDD VSS sg13g2_decap_8
XFILLER_67_1192 VDD VSS sg13g2_decap_8
XFILLER_87_912 VDD VSS sg13g2_fill_2
Xfanout413 _09943_/S _09970_/S VDD VSS sg13g2_buf_1
XFILLER_101_700 VDD VSS sg13g2_fill_1
XFILLER_113_560 VDD VSS sg13g2_decap_8
Xfanout424 _09910_/S _09937_/S VDD VSS sg13g2_buf_1
XFILLER_154_1162 VDD VSS sg13g2_decap_8
XFILLER_113_571 VDD VSS sg13g2_fill_2
X_14795__3303 _14795_/RESET_B VDD VSS sg13g2_tiehi
XFILLER_101_722 VDD VSS sg13g2_fill_2
Xfanout446 _09760_/S wire447/A VDD VSS sg13g2_buf_1
X_09825_ _14413_/D _09924_/A1 _14413_/Q _09829_/S VDD VSS sg13g2_mux2_1
Xfanout457 wire458/A _09674_/X VDD VSS sg13g2_buf_1
XFILLER_100_210 VDD VSS sg13g2_decap_8
XFILLER_101_733 VDD VSS sg13g2_decap_8
XFILLER_115_1135 VDD VSS sg13g2_fill_1
XFILLER_24_1029 VDD VSS sg13g2_decap_8
XFILLER_100_221 VDD VSS sg13g2_fill_2
XFILLER_150_1037 VDD VSS sg13g2_decap_8
XFILLER_101_755 VDD VSS sg13g2_fill_2
Xfanout479 wire480/A wire482/A VDD VSS sg13g2_buf_1
XFILLER_101_777 VDD VSS sg13g2_decap_8
XFILLER_115_1179 VDD VSS sg13g2_fill_1
X_09756_ _14346_/D _14346_/Q _09789_/A0 _09770_/S VDD VSS sg13g2_mux2_1
XFILLER_101_788 VDD VSS sg13g2_fill_1
XFILLER_27_511 VDD VSS sg13g2_fill_1
XFILLER_67_680 VDD VSS sg13g2_decap_8
X_08707_ _15186_/D hold3449/X _15186_/Q _13333_/S VDD VSS sg13g2_mux2_1
XFILLER_104_77 VDD VSS sg13g2_decap_8
X_09687_ _14279_/D _09918_/A1 _14279_/Q wire456/X VDD VSS sg13g2_mux2_1
XFILLER_54_341 VDD VSS sg13g2_decap_8
XFILLER_64_37 VDD VSS sg13g2_fill_1
XFILLER_64_48 VDD VSS sg13g2_decap_4
X_08638_ _08640_/A _07844_/X _08692_/A _08452_/B _08330_/Y VDD VSS sg13g2_a22oi_1
XFILLER_70_845 VDD VSS sg13g2_fill_1
XFILLER_120_21 VDD VSS sg13g2_decap_8
XFILLER_70_856 VDD VSS sg13g2_fill_1
X_08569_ _08569_/Y _07808_/Y _08568_/Y _08567_/X VDD VSS sg13g2_o21ai_1
XFILLER_35_1114 VDD VSS sg13g2_decap_8
XFILLER_80_14 VDD VSS sg13g2_decap_8
X_10600_ _10602_/B _10607_/C _10607_/D _14877_/Q VDD VSS sg13g2_a21oi_1
X_11580_ _11580_/X _14245_/Q _14277_/Q _14309_/Q _14341_/Q _11580_/S0 _11580_/S1 VDD
+ VSS sg13g2_mux4_1
XFILLER_35_1158 VDD VSS sg13g2_fill_2
XFILLER_156_917 VDD VSS sg13g2_fill_2
X_10531_ _10533_/B _14859_/Q _10558_/B _10564_/D _10531_/D VDD VSS sg13g2_nand4_1
XFILLER_13_63 VDD VSS sg13g2_decap_8
X_15242__3395 _15242_/RESET_B VDD VSS sg13g2_tiehi
Xwire847 wire847/X wire847/A VDD VSS sg13g2_buf_4
XFILLER_127_118 VDD VSS sg13g2_decap_4
XFILLER_6_426 VDD VSS sg13g2_decap_8
X_13250_ _13251_/C _14828_/Q _13206_/B _13273_/B _14860_/Q VDD VSS sg13g2_a22oi_1
X_10462_ _10473_/D _10511_/D _14842_/Q _14841_/Q _10462_/D VDD VSS sg13g2_and4_1
X_12201_ _12204_/A _12060_/Y _12197_/Y _12200_/X VDD VSS sg13g2_a21oi_1
XFILLER_108_354 VDD VSS sg13g2_decap_8
X_13181_ _13181_/Y _14791_/Q _13236_/A2 _13262_/B1 VDD VSS sg13g2_o21ai_1
X_14180__2384 _14180_/RESET_B VDD VSS sg13g2_tiehi
X_10393_ _10401_/C _14822_/Q _10392_/A VDD VSS sg13g2_nor2b_1
XFILLER_135_151 VDD VSS sg13g2_decap_4
X_12132_ _12132_/Y _12198_/B _12132_/B VDD VSS sg13g2_xnor2_1
XFILLER_108_398 VDD VSS sg13g2_decap_8
XFILLER_2_665 VDD VSS sg13g2_fill_1
XFILLER_123_368 VDD VSS sg13g2_decap_8
X_12063_ _12063_/Y _12062_/A wire379/X _12197_/A VDD VSS sg13g2_a21oi_1
XFILLER_2_698 VDD VSS sg13g2_decap_8
X_11014_ _11014_/Y _11043_/A _11014_/B VDD VSS sg13g2_nor2_1
XFILLER_133_1235 VDD VSS sg13g2_fill_2
XFILLER_42_1118 VDD VSS sg13g2_decap_8
XFILLER_81_1167 VDD VSS sg13g2_fill_2
X_16871_ _16871_/X _16871_/A VDD VSS sg13g2_buf_1
XFILLER_78_967 VDD VSS sg13g2_decap_4
XFILLER_65_606 VDD VSS sg13g2_fill_1
Xfanout980 _11422_/B _12113_/C1 VDD VSS sg13g2_buf_1
XFILLER_37_308 VDD VSS sg13g2_decap_4
Xfanout991 _11690_/B fanout992/X VDD VSS sg13g2_buf_1
XFILLER_77_488 VDD VSS sg13g2_fill_1
XFILLER_58_691 VDD VSS sg13g2_decap_8
X_12965_ _12965_/Y _14777_/Q _13220_/A2 _12978_/B1 VDD VSS sg13g2_o21ai_1
XFILLER_79_1041 VDD VSS sg13g2_fill_2
XFILLER_46_864 VDD VSS sg13g2_decap_8
XFILLER_92_469 VDD VSS sg13g2_decap_8
XFILLER_18_566 VDD VSS sg13g2_decap_8
XFILLER_45_352 VDD VSS sg13g2_fill_1
XFILLER_79_1074 VDD VSS sg13g2_decap_8
X_11916_ _11916_/Y _12055_/A _11917_/A VDD VSS sg13g2_nor2_1
X_14704_ _14704_/Q clkload42/A _14704_/D _14704_/RESET_B VDD VSS sg13g2_dfrbpq_1
X_12896_ _12896_/Y _14805_/Q _07728_/A _12930_/B1 _14837_/Q _13180_/C1 VDD VSS sg13g2_a221oi_1
X_14635_ _14635_/Q _14667_/CLK _14635_/D _14635_/RESET_B VDD VSS sg13g2_dfrbpq_1
X_11847_ _11847_/X _14573_/Q _14605_/Q _14637_/Q _14669_/Q _11852_/S0 _11419_/C VDD
+ VSS sg13g2_mux4_1
X_14566_ _14566_/Q _14662_/CLK _14566_/D _14566_/RESET_B VDD VSS sg13g2_dfrbpq_1
X_11778_ wire210/A _11778_/A _11778_/B VDD VSS sg13g2_nor2_1
XFILLER_60_399 VDD VSS sg13g2_decap_8
X_13517_ _13517_/X _13517_/A _13537_/B VDD VSS sg13g2_and2_1
XFILLER_146_405 VDD VSS sg13g2_decap_8
X_10729_ _10729_/Y _09060_/X _10788_/S _08893_/Y VDD VSS sg13g2_a21oi_1
XFILLER_119_619 VDD VSS sg13g2_decap_8
X_14497_ _14497_/Q _15160_/CLK _14497_/D _14497_/RESET_B VDD VSS sg13g2_dfrbpq_1
Xclkload12 clkload12/Y clkload12/A VDD VSS sg13g2_inv_2
X_13448_ _13449_/B _15199_/Q _13448_/B _13448_/C wire808/X VDD VSS sg13g2_nand4_1
Xclkload23 clkload23/Y clkload23/A VDD VSS sg13g2_inv_1
XFILLER_103_1050 VDD VSS sg13g2_decap_8
XFILLER_127_630 VDD VSS sg13g2_fill_1
Xclkload34 clkload34/Y clkload34/A VDD VSS sg13g2_inv_2
Xclkload45 clkload45/Y clkload45/A VDD VSS sg13g2_inv_2
Xclkload56 clkload56/Y clkload56/A VDD VSS sg13g2_inv_1
XFILLER_142_600 VDD VSS sg13g2_decap_4
Xclkload67 clkload67/Y clkload67/A VDD VSS sg13g2_inv_2
X_13379_ _15079_/D _15079_/Q _13427_/A _13378_/Y VDD VSS sg13g2_a21o_1
X_14010__2554 _14010_/RESET_B VDD VSS sg13g2_tiehi
Xclkload78 clkload78/Y clkload78/A VDD VSS sg13g2_inv_2
XFILLER_6_982 VDD VSS sg13g2_decap_8
XFILLER_127_685 VDD VSS sg13g2_decap_8
XFILLER_115_847 VDD VSS sg13g2_decap_8
X_15118_ _15118_/Q _15188_/CLK _15118_/D _15118_/RESET_B VDD VSS sg13g2_dfrbpq_1
Xhold3508 hold3508/X _15000_/Q VDD VSS sg13g2_dlygate4sd3_1
XFILLER_86_1089 VDD VSS sg13g2_fill_2
Xhold3519 hold3519/X _14890_/Q VDD VSS sg13g2_dlygate4sd3_1
X_07940_ _07940_/Y _07797_/B _07932_/Y _07939_/Y VDD VSS sg13g2_o21ai_1
X_15049_ _15049_/Q _15248_/CLK _15049_/D _15049_/RESET_B VDD VSS sg13g2_dfrbpq_1
XFILLER_130_828 VDD VSS sg13g2_decap_4
XFILLER_96_742 VDD VSS sg13g2_decap_8
X_07871_ _07871_/X _08183_/B _08188_/A VDD VSS sg13g2_or2_1
XFILLER_56_606 VDD VSS sg13g2_fill_1
XFILLER_69_989 VDD VSS sg13g2_fill_2
X_09610_ _14206_/D _09909_/A1 _14206_/Q wire470/X VDD VSS sg13g2_mux2_1
XFILLER_28_308 VDD VSS sg13g2_decap_8
XFILLER_68_488 VDD VSS sg13g2_fill_1
XFILLER_95_285 VDD VSS sg13g2_fill_2
XFILLER_37_831 VDD VSS sg13g2_fill_1
XFILLER_49_691 VDD VSS sg13g2_decap_8
XFILLER_110_1021 VDD VSS sg13g2_fill_1
X_09541_ _14139_/D _09574_/A1 _14139_/Q wire651/A VDD VSS sg13g2_mux2_1
XFILLER_83_458 VDD VSS sg13g2_fill_2
XFILLER_23_1084 VDD VSS sg13g2_decap_8
XFILLER_3_1167 VDD VSS sg13g2_decap_8
XFILLER_92_970 VDD VSS sg13g2_fill_1
X_09472_ _14073_/D _10101_/A0 _14073_/Q _09472_/S VDD VSS sg13g2_mux2_1
XFILLER_51_300 VDD VSS sg13g2_fill_1
XFILLER_58_1136 VDD VSS sg13g2_decap_8
XFILLER_58_1158 VDD VSS sg13g2_decap_4
XFILLER_91_491 VDD VSS sg13g2_decap_8
X_08423_ _08423_/X _08574_/B _08423_/B VDD VSS sg13g2_xor2_1
XFILLER_63_193 VDD VSS sg13g2_fill_2
X_14559__2005 _14559_/RESET_B VDD VSS sg13g2_tiehi
X_08354_ _08354_/Y _08414_/D _08354_/B VDD VSS sg13g2_xnor2_1
XFILLER_32_591 VDD VSS sg13g2_fill_2
XFILLER_149_265 VDD VSS sg13g2_decap_8
Xclkload6 clkload6/Y clkload6/A VDD VSS sg13g2_inv_1
X_08285_ _08286_/C _07923_/Y _07925_/Y _07797_/A VDD VSS sg13g2_a21oi_1
XFILLER_153_909 VDD VSS sg13g2_decap_8
XFILLER_121_1150 VDD VSS sg13g2_fill_2
XFILLER_146_961 VDD VSS sg13g2_fill_1
XFILLER_69_1221 VDD VSS sg13g2_decap_8
XFILLER_3_407 VDD VSS sg13g2_decap_8
XFILLER_118_674 VDD VSS sg13g2_fill_1
XFILLER_145_471 VDD VSS sg13g2_fill_2
XFILLER_105_302 VDD VSS sg13g2_fill_1
XFILLER_30_1088 VDD VSS sg13g2_fill_1
XFILLER_156_1224 VDD VSS sg13g2_decap_8
XFILLER_133_633 VDD VSS sg13g2_decap_8
XFILLER_156_1235 VDD VSS sg13g2_fill_2
XFILLER_133_688 VDD VSS sg13g2_fill_1
XFILLER_8_1001 VDD VSS sg13g2_decap_8
XFILLER_78_219 VDD VSS sg13g2_decap_4
Xfanout1208 _12617_/S0 _12620_/S0 VDD VSS sg13g2_buf_1
Xfanout1219 _13312_/A _11236_/A VDD VSS sg13g2_buf_1
Xfanout221 _09925_/A1 _10090_/A0 VDD VSS sg13g2_buf_1
XFILLER_114_891 VDD VSS sg13g2_decap_4
XFILLER_115_21 VDD VSS sg13g2_decap_8
XFILLER_8_1034 VDD VSS sg13g2_decap_8
XFILLER_120_349 VDD VSS sg13g2_fill_1
Xfanout243 _10155_/A1 wire246/X VDD VSS sg13g2_buf_1
Xfanout265 _09621_/A0 _09887_/A0 VDD VSS sg13g2_buf_1
Xfanout276 _11980_/A _12271_/A VDD VSS sg13g2_buf_1
X_09808_ _14396_/D _09907_/A1 _14396_/Q _09826_/S VDD VSS sg13g2_mux2_1
Xfanout287 _10083_/A0 _10017_/A0 VDD VSS sg13g2_buf_1
XFILLER_101_563 VDD VSS sg13g2_fill_1
XFILLER_41_1162 VDD VSS sg13g2_decap_4
X_09739_ _14330_/D _10069_/A0 _14330_/Q _09739_/S VDD VSS sg13g2_mux2_1
XFILLER_90_918 VDD VSS sg13g2_decap_8
X_14759__3342 _14759_/RESET_B VDD VSS sg13g2_tiehi
XFILLER_74_469 VDD VSS sg13g2_decap_8
XFILLER_41_1195 VDD VSS sg13g2_fill_2
XFILLER_131_42 VDD VSS sg13g2_decap_8
X_12750_ _15017_/D _12750_/A _12750_/B VDD VSS sg13g2_nor2_1
XFILLER_55_672 VDD VSS sg13g2_fill_2
XFILLER_82_480 VDD VSS sg13g2_fill_2
XFILLER_27_396 VDD VSS sg13g2_decap_8
XFILLER_37_1209 VDD VSS sg13g2_decap_8
X_14198__2366 _14198_/RESET_B VDD VSS sg13g2_tiehi
X_11701_ _11702_/B _11664_/A _11700_/X _11664_/Y _11663_/Y _11701_/C1 VDD VSS sg13g2_a221oi_1
X_12681_ _12694_/A _12709_/A1 _12751_/A2 _15013_/Q VDD VSS sg13g2_a21oi_1
XFILLER_70_653 VDD VSS sg13g2_decap_8
X_14420_ _14420_/Q clkload8/A _14420_/D _14420_/RESET_B VDD VSS sg13g2_dfrbpq_1
X_11632_ _14968_/D _11632_/A _11632_/B VDD VSS sg13g2_nor2_1
XFILLER_129_917 VDD VSS sg13g2_fill_1
XFILLER_138_0 VDD VSS sg13g2_decap_8
XFILLER_24_84 VDD VSS sg13g2_decap_8
X_14351_ _14351_/Q _14662_/CLK _14351_/D _14351_/RESET_B VDD VSS sg13g2_dfrbpq_1
X_11563_ _11563_/Y _12959_/A1 _11655_/B _11559_/Y _11562_/Y VDD VSS sg13g2_a22oi_1
XFILLER_126_1094 VDD VSS sg13g2_fill_1
X_13302_ _15058_/D _13299_/Y _13302_/B _13302_/C VDD VSS sg13g2_nand3b_1
Xwire633 wire633/X wire633/A VDD VSS sg13g2_buf_4
X_10514_ _10538_/B wire760/X _10514_/B _10514_/C VDD VSS sg13g2_nand3_1
X_14282_ _14282_/Q clkload25/A _14282_/D _14282_/RESET_B VDD VSS sg13g2_dfrbpq_1
X_11494_ _11495_/A _11488_/X _11489_/X _11493_/X _11492_/X _12237_/C _12217_/A VDD
+ VSS sg13g2_mux4_1
XFILLER_109_641 VDD VSS sg13g2_fill_2
XFILLER_143_408 VDD VSS sg13g2_fill_2
XFILLER_100_1212 VDD VSS sg13g2_decap_8
X_13233_ _13233_/X _12866_/D _13264_/A2 _13264_/B1 VDD VSS sg13g2_a21o_1
X_14861__3207 _14861_/RESET_B VDD VSS sg13g2_tiehi
X_10445_ _10459_/C _14838_/Q _14837_/Q _14832_/Q _14831_/Q VDD VSS sg13g2_nand4_1
XFILLER_152_920 VDD VSS sg13g2_decap_8
X_13164_ _13164_/Y _14790_/Q _13236_/A2 _13262_/B1 VDD VSS sg13g2_o21ai_1
XFILLER_152_964 VDD VSS sg13g2_fill_2
X_10376_ _10379_/C _14817_/Q _10375_/B VDD VSS sg13g2_nor2b_1
XFILLER_123_121 VDD VSS sg13g2_fill_2
XFILLER_124_655 VDD VSS sg13g2_fill_2
X_15040__2930 _15040_/RESET_B VDD VSS sg13g2_tiehi
X_12115_ _12115_/X _11615_/B _12114_/X _12113_/Y VDD VSS sg13g2_a21o_1
XFILLER_3_985 VDD VSS sg13g2_decap_8
XFILLER_124_688 VDD VSS sg13g2_fill_2
X_13095_ _13095_/Y _10651_/D _13028_/B _13193_/B VDD VSS sg13g2_a21oi_1
XFILLER_78_720 VDD VSS sg13g2_fill_1
XFILLER_46_1073 VDD VSS sg13g2_decap_8
XFILLER_49_70 VDD VSS sg13g2_decap_4
X_12046_ _12046_/Y _12044_/Y _12046_/B _12291_/A VDD VSS sg13g2_nand3b_1
Xfanout1720 _11804_/A fanout1721/X VDD VSS sg13g2_buf_1
XFILLER_137_1190 VDD VSS sg13g2_decap_8
Xfanout1731 _11328_/S0 _11317_/A1 VDD VSS sg13g2_buf_1
XFILLER_27_7 VDD VSS sg13g2_decap_8
Xfanout1742 _11896_/A _11348_/A1 VDD VSS sg13g2_buf_1
Xfanout1753 fanout1753/X _13657_/Q VDD VSS sg13g2_buf_1
Xfanout1764 _10468_/A _10490_/A VDD VSS sg13g2_buf_1
XFILLER_38_617 VDD VSS sg13g2_fill_2
X_16854_ _16854_/X _16854_/A VDD VSS sg13g2_buf_1
XFILLER_37_105 VDD VSS sg13g2_decap_4
Xfanout1775 _12709_/A1 fanout1797/X VDD VSS sg13g2_buf_1
XFILLER_78_797 VDD VSS sg13g2_decap_8
XFILLER_19_820 VDD VSS sg13g2_fill_2
Xfanout1786 _10337_/C _10350_/C VDD VSS sg13g2_buf_1
Xfanout1797 fanout1797/X input38/X VDD VSS sg13g2_buf_1
XFILLER_65_436 VDD VSS sg13g2_decap_8
XFILLER_93_767 VDD VSS sg13g2_fill_1
X_13997_ _13997_/Q clkload45/A _13997_/D _13997_/RESET_B VDD VSS sg13g2_dfrbpq_1
XFILLER_1_77 VDD VSS sg13g2_decap_8
XFILLER_19_875 VDD VSS sg13g2_decap_8
XFILLER_92_266 VDD VSS sg13g2_decap_8
XFILLER_74_981 VDD VSS sg13g2_decap_8
X_12948_ _12948_/Y _14808_/Q _07728_/A _13150_/B _14840_/Q _13082_/B VDD VSS sg13g2_a221oi_1
XFILLER_18_396 VDD VSS sg13g2_decap_4
XFILLER_45_182 VDD VSS sg13g2_decap_4
X_14028__2536 _14028_/RESET_B VDD VSS sg13g2_tiehi
X_13863__2701 _13863_/RESET_B VDD VSS sg13g2_tiehi
X_12879_ _12879_/Y _14836_/Q _13234_/B VDD VSS sg13g2_nand2_1
X_14618_ _14618_/Q _15040_/CLK _14618_/D _14618_/RESET_B VDD VSS sg13g2_dfrbpq_1
XFILLER_18_1142 VDD VSS sg13g2_decap_8
XFILLER_14_580 VDD VSS sg13g2_decap_8
XFILLER_105_1112 VDD VSS sg13g2_decap_8
XFILLER_140_1003 VDD VSS sg13g2_fill_1
XFILLER_53_1055 VDD VSS sg13g2_decap_8
X_14549_ _14549_/Q _14671_/CLK _14549_/D _14549_/RESET_B VDD VSS sg13g2_dfrbpq_1
X_08070_ _08070_/X _08431_/A _08452_/D _08110_/C _08110_/D VDD VSS sg13g2_and4_1
X_14243__2321 _14243_/RESET_B VDD VSS sg13g2_tiehi
X_13896__2668 _13896_/RESET_B VDD VSS sg13g2_tiehi
XFILLER_115_600 VDD VSS sg13g2_decap_4
Xmax_cap1083 _12733_/S0 _12705_/S0 VDD VSS sg13g2_buf_4
XFILLER_143_931 VDD VSS sg13g2_decap_4
XFILLER_53_0 VDD VSS sg13g2_decap_8
Xmax_cap1094 _12789_/S0 _12369_/S0 VDD VSS sg13g2_buf_4
XFILLER_127_493 VDD VSS sg13g2_decap_8
XFILLER_142_430 VDD VSS sg13g2_fill_1
Xmax_cap977 _12290_/S0 _11955_/B VDD VSS sg13g2_buf_4
XFILLER_114_154 VDD VSS sg13g2_decap_4
XFILLER_102_305 VDD VSS sg13g2_decap_8
X_08972_ _08972_/X _14895_/Q _08971_/X _08988_/A VDD VSS sg13g2_mux2_1
XFILLER_69_720 VDD VSS sg13g2_fill_2
X_14276__2288 _14276_/RESET_B VDD VSS sg13g2_tiehi
XFILLER_25_1102 VDD VSS sg13g2_decap_8
X_07923_ _07923_/Y _07909_/Y _07921_/Y _07904_/A VDD VSS sg13g2_o21ai_1
XFILLER_102_349 VDD VSS sg13g2_fill_1
XFILLER_151_1121 VDD VSS sg13g2_decap_8
XFILLER_64_1173 VDD VSS sg13g2_fill_2
XFILLER_68_230 VDD VSS sg13g2_fill_1
XFILLER_69_764 VDD VSS sg13g2_decap_8
XFILLER_64_1195 VDD VSS sg13g2_decap_8
XFILLER_151_1154 VDD VSS sg13g2_decap_8
XFILLER_68_263 VDD VSS sg13g2_fill_1
X_07854_ _08643_/D _07855_/A _07855_/B VDD VSS sg13g2_nor2_1
XFILLER_60_1048 VDD VSS sg13g2_decap_4
XFILLER_25_1179 VDD VSS sg13g2_decap_8
XFILLER_112_1138 VDD VSS sg13g2_fill_2
X_15241__3394 _15241_/RESET_B VDD VSS sg13g2_tiehi
XFILLER_84_767 VDD VSS sg13g2_decap_4
X_07785_ _08414_/A _07786_/A _08351_/B VDD VSS sg13g2_nor2_1
XFILLER_72_929 VDD VSS sg13g2_decap_4
XFILLER_84_789 VDD VSS sg13g2_decap_4
XFILLER_83_277 VDD VSS sg13g2_decap_8
X_09524_ _14123_/D _10087_/A0 _14123_/Q _09538_/S VDD VSS sg13g2_mux2_1
X_14491__2073 _14491_/RESET_B VDD VSS sg13g2_tiehi
XFILLER_65_992 VDD VSS sg13g2_fill_1
XFILLER_83_299 VDD VSS sg13g2_decap_8
XFILLER_64_491 VDD VSS sg13g2_decap_4
XFILLER_52_642 VDD VSS sg13g2_decap_4
X_09455_ _14056_/D _09655_/A0 _14056_/Q _09457_/S VDD VSS sg13g2_mux2_1
XFILLER_149_1094 VDD VSS sg13g2_decap_8
XFILLER_40_804 VDD VSS sg13g2_decap_4
XFILLER_12_517 VDD VSS sg13g2_fill_1
X_08406_ _08406_/X _08406_/A _08488_/A VDD VSS sg13g2_and2_1
XFILLER_52_697 VDD VSS sg13g2_decap_8
X_09386_ _13989_/D _09850_/A1 _13989_/Q _09388_/S VDD VSS sg13g2_mux2_1
XFILLER_12_539 VDD VSS sg13g2_decap_8
X_08337_ _08337_/X _08405_/A1 _08376_/A3 _07775_/A _08337_/A3 _08427_/S0 _08337_/S1
+ VDD VSS sg13g2_mux4_1
XFILLER_71_1155 VDD VSS sg13g2_decap_8
XFILLER_131_7 VDD VSS sg13g2_decap_8
XFILLER_123_1234 VDD VSS sg13g2_fill_2
X_08268_ _08268_/Y _08318_/B _08268_/B VDD VSS sg13g2_xnor2_1
XFILLER_20_594 VDD VSS sg13g2_fill_2
X_13726__2838 _13726_/RESET_B VDD VSS sg13g2_tiehi
XFILLER_137_268 VDD VSS sg13g2_fill_2
XFILLER_118_460 VDD VSS sg13g2_decap_4
XFILLER_119_983 VDD VSS sg13g2_fill_1
X_08199_ _08201_/C _08200_/A _08199_/B _08199_/C VDD VSS sg13g2_nor3_1
XFILLER_3_226 VDD VSS sg13g2_decap_8
XFILLER_118_493 VDD VSS sg13g2_decap_4
X_10230_ _10232_/A _14771_/Q _10234_/D _14772_/Q VDD VSS sg13g2_a21o_1
XFILLER_152_249 VDD VSS sg13g2_decap_4
XFILLER_10_42 VDD VSS sg13g2_decap_8
XFILLER_156_1065 VDD VSS sg13g2_fill_2
XFILLER_0_911 VDD VSS sg13g2_fill_2
XFILLER_79_528 VDD VSS sg13g2_decap_4
X_10161_ _14738_/D _14738_/Q _10161_/A1 _10168_/S VDD VSS sg13g2_mux2_1
XFILLER_0_922 VDD VSS sg13g2_fill_1
XFILLER_121_625 VDD VSS sg13g2_decap_8
XFILLER_121_636 VDD VSS sg13g2_decap_4
Xfanout1005 _10886_/A2 _07653_/Y VDD VSS sg13g2_buf_1
Xfanout1016 _08328_/S _08110_/B VDD VSS sg13g2_buf_1
X_14106__2458 _14106_/RESET_B VDD VSS sg13g2_tiehi
Xfanout1027 _08363_/S0 _08374_/A VDD VSS sg13g2_buf_1
X_13941__2623 _13941_/RESET_B VDD VSS sg13g2_tiehi
Xfanout1038 _08612_/S _08649_/S VDD VSS sg13g2_buf_1
XFILLER_94_509 VDD VSS sg13g2_fill_2
X_10092_ _14672_/D _10092_/A0 _14672_/Q _10094_/S VDD VSS sg13g2_mux2_1
XFILLER_59_252 VDD VSS sg13g2_decap_4
XFILLER_87_561 VDD VSS sg13g2_decap_8
Xfanout1049 _10647_/D _15250_/Q VDD VSS sg13g2_buf_1
XFILLER_86_79 VDD VSS sg13g2_fill_2
X_13920_ _13920_/Q _14917_/CLK _13920_/D _13920_/RESET_B VDD VSS sg13g2_dfrbpq_1
XFILLER_101_360 VDD VSS sg13g2_fill_2
XFILLER_75_723 VDD VSS sg13g2_decap_8
XFILLER_47_436 VDD VSS sg13g2_decap_8
XFILLER_47_447 VDD VSS sg13g2_fill_2
X_13851_ _13851_/Q clkload76/A _13851_/D _13851_/RESET_B VDD VSS sg13g2_dfrbpq_1
XFILLER_19_84 VDD VSS sg13g2_decap_8
XFILLER_142_63 VDD VSS sg13g2_decap_8
XFILLER_19_95 VDD VSS sg13g2_fill_1
XFILLER_28_650 VDD VSS sg13g2_decap_8
XFILLER_90_715 VDD VSS sg13g2_decap_8
XFILLER_74_277 VDD VSS sg13g2_decap_8
X_12802_ _12802_/Y _12900_/B input11/X _12825_/B VDD VSS sg13g2_nand3_1
X_13782_ _13782_/Q clkload24/A _13782_/D _13782_/RESET_B VDD VSS sg13g2_dfrbpq_1
X_14321__2243 _14321_/RESET_B VDD VSS sg13g2_tiehi
X_10994_ _11042_/B wire385/X _10995_/B VDD VSS sg13g2_nor2_1
X_12733_ _12733_/X _12729_/X _12728_/X _12727_/X _12726_/X _12733_/S0 _12692_/S VDD
+ VSS sg13g2_mux4_1
XFILLER_71_962 VDD VSS sg13g2_decap_8
XFILLER_16_878 VDD VSS sg13g2_decap_8
XFILLER_43_675 VDD VSS sg13g2_decap_4
XFILLER_35_83 VDD VSS sg13g2_fill_2
XFILLER_128_1156 VDD VSS sg13g2_fill_1
X_12664_ _12664_/X _12662_/X _12663_/X _12664_/S VDD VSS sg13g2_mux2_1
XFILLER_128_1167 VDD VSS sg13g2_decap_8
X_14403_ _14403_/Q _14505_/CLK _14403_/D _14403_/RESET_B VDD VSS sg13g2_dfrbpq_1
X_11615_ _11615_/X _11615_/A _11615_/B VDD VSS sg13g2_and2_1
XFILLER_156_511 VDD VSS sg13g2_decap_8
X_12595_ _12595_/X _12594_/X _12593_/X _12595_/S VDD VSS sg13g2_mux2_1
XFILLER_156_522 VDD VSS sg13g2_fill_1
X_14334_ _14334_/Q clkload57/A _14334_/D _14334_/RESET_B VDD VSS sg13g2_dfrbpq_1
XFILLER_156_544 VDD VSS sg13g2_decap_8
X_11546_ _11546_/Y _11555_/S0 _14500_/Q _11739_/B VDD VSS sg13g2_a21oi_1
XFILLER_156_566 VDD VSS sg13g2_decap_4
XFILLER_144_728 VDD VSS sg13g2_decap_4
X_14265_ _14265_/Q _14731_/CLK _14265_/D _14265_/RESET_B VDD VSS sg13g2_dfrbpq_1
XFILLER_143_216 VDD VSS sg13g2_decap_4
X_11477_ _11477_/Y _11477_/A _11477_/B VDD VSS sg13g2_nor2_1
XFILLER_13_1083 VDD VSS sg13g2_decap_8
Xwire496 wire496/X wire496/A VDD VSS sg13g2_buf_4
XFILLER_100_1031 VDD VSS sg13g2_decap_4
X_13216_ _13216_/Y _13247_/D _13216_/B VDD VSS sg13g2_nand2_1
X_10428_ _10430_/C _14831_/Q _10521_/C _14832_/Q VDD VSS sg13g2_a21oi_1
XFILLER_125_953 VDD VSS sg13g2_fill_1
X_14196_ _14196_/Q clkload8/A _14196_/D _14196_/RESET_B VDD VSS sg13g2_dfrbpq_1
XFILLER_83_1026 VDD VSS sg13g2_fill_1
X_13147_ _13158_/B _13146_/B _13145_/Y _13170_/C VDD VSS sg13g2_a21o_1
XFILLER_125_997 VDD VSS sg13g2_decap_4
X_10359_ _10359_/Y _10359_/A _10400_/B VDD VSS sg13g2_nor2_1
XFILLER_151_282 VDD VSS sg13g2_decap_8
X_13078_ _13092_/A _13078_/A _13172_/A _13172_/B VDD VSS sg13g2_nand3_1
X_12029_ _12029_/Y _12029_/A _12036_/B VDD VSS sg13g2_nand2_1
XFILLER_111_179 VDD VSS sg13g2_fill_1
Xfanout1572 _12942_/B _13684_/Q VDD VSS sg13g2_buf_1
Xfanout1583 _12290_/S1 _11832_/C VDD VSS sg13g2_buf_1
Xfanout1594 _12000_/A _12291_/A VDD VSS sg13g2_buf_1
XFILLER_38_458 VDD VSS sg13g2_decap_8
XFILLER_76_90 VDD VSS sg13g2_decap_8
XFILLER_81_704 VDD VSS sg13g2_fill_1
XFILLER_24_1190 VDD VSS sg13g2_decap_8
XFILLER_93_575 VDD VSS sg13g2_fill_1
XFILLER_47_970 VDD VSS sg13g2_decap_8
XFILLER_65_277 VDD VSS sg13g2_decap_8
XFILLER_94_1100 VDD VSS sg13g2_decap_8
XFILLER_59_1220 VDD VSS sg13g2_decap_8
XFILLER_80_214 VDD VSS sg13g2_decap_8
XFILLER_20_1065 VDD VSS sg13g2_decap_8
XFILLER_0_1126 VDD VSS sg13g2_decap_4
XFILLER_111_1193 VDD VSS sg13g2_decap_8
XFILLER_34_653 VDD VSS sg13g2_fill_1
XFILLER_80_269 VDD VSS sg13g2_fill_2
XFILLER_55_1128 VDD VSS sg13g2_fill_2
XFILLER_62_984 VDD VSS sg13g2_decap_8
XFILLER_94_1177 VDD VSS sg13g2_decap_8
XFILLER_21_303 VDD VSS sg13g2_decap_8
XFILLER_107_1207 VDD VSS sg13g2_decap_8
X_09240_ _10137_/C _10004_/B _10004_/C VDD VSS sg13g2_nand2_1
XFILLER_22_848 VDD VSS sg13g2_fill_2
X_09171_ _13787_/D _13787_/Q _10138_/A1 _09190_/S VDD VSS sg13g2_mux2_1
X_08122_ _08122_/Y _08198_/S _08121_/X _08120_/Y VDD VSS sg13g2_o21ai_1
XFILLER_119_257 VDD VSS sg13g2_fill_2
X_08053_ _08053_/Y _07853_/B _08054_/B VDD VSS sg13g2_nand2b_1
XFILLER_116_931 VDD VSS sg13g2_fill_1
Xmax_cap752 _12223_/A _12077_/A VDD VSS sg13g2_buf_4
XFILLER_153_1205 VDD VSS sg13g2_decap_8
XFILLER_27_1208 VDD VSS sg13g2_decap_8
XFILLER_0_207 VDD VSS sg13g2_decap_8
XFILLER_142_271 VDD VSS sg13g2_decap_8
XFILLER_0_218 VDD VSS sg13g2_fill_1
XFILLER_89_848 VDD VSS sg13g2_decap_8
XFILLER_142_282 VDD VSS sg13g2_fill_1
XFILLER_131_945 VDD VSS sg13g2_decap_8
X_08955_ _08955_/X _08954_/X _12300_/A _08955_/S VDD VSS sg13g2_mux2_1
XFILLER_102_135 VDD VSS sg13g2_decap_8
XFILLER_9_1162 VDD VSS sg13g2_decap_8
XFILLER_131_989 VDD VSS sg13g2_decap_8
X_07906_ _07908_/A _07797_/X _07906_/B _07906_/C VDD VSS sg13g2_nand3b_1
XFILLER_69_583 VDD VSS sg13g2_decap_8
XFILLER_57_734 VDD VSS sg13g2_fill_1
X_08886_ _08886_/Y _08884_/Y _08885_/Y _08940_/S VDD VSS sg13g2_a21oi_1
XFILLER_5_1059 VDD VSS sg13g2_decap_8
XFILLER_56_49 VDD VSS sg13g2_fill_2
X_07837_ _08698_/A _08673_/B _15019_/Q VDD VSS sg13g2_nand2b_1
XFILLER_110_190 VDD VSS sg13g2_fill_2
XFILLER_99_1055 VDD VSS sg13g2_decap_8
XFILLER_38_981 VDD VSS sg13g2_fill_2
XFILLER_84_586 VDD VSS sg13g2_decap_8
X_07768_ _08265_/B _07768_/A _08263_/B VDD VSS sg13g2_and2_1
XFILLER_71_225 VDD VSS sg13g2_fill_2
X_09507_ _09507_/Y _10037_/A _09971_/B _09606_/C VDD VSS sg13g2_nand3_1
XFILLER_13_804 VDD VSS sg13g2_decap_8
X_07699_ _07700_/C _15078_/Q _15081_/Q _07694_/Y VDD VSS sg13g2_o21ai_1
XFILLER_25_675 VDD VSS sg13g2_fill_2
XFILLER_40_601 VDD VSS sg13g2_decap_8
XFILLER_40_612 VDD VSS sg13g2_fill_2
X_09438_ _14040_/D _09836_/A0 _14040_/Q _09440_/S VDD VSS sg13g2_mux2_1
X_09369_ _13973_/D _10097_/A0 _13973_/Q _09373_/S VDD VSS sg13g2_mux2_1
XFILLER_40_678 VDD VSS sg13g2_fill_2
X_11400_ _11401_/B _11400_/A _14655_/Q VDD VSS sg13g2_nand2_1
X_13959__2605 _13959_/RESET_B VDD VSS sg13g2_tiehi
X_12380_ _12380_/X _13949_/Q _13981_/Q _14013_/Q _14045_/Q _12381_/S0 _12381_/S1 VDD
+ VSS sg13g2_mux4_1
XFILLER_20_391 VDD VSS sg13g2_fill_1
X_11331_ _11331_/Y _11424_/B _11330_/X _12292_/A VDD VSS sg13g2_a21oi_1
XFILLER_126_739 VDD VSS sg13g2_fill_2
XFILLER_107_920 VDD VSS sg13g2_decap_8
XFILLER_21_63 VDD VSS sg13g2_decap_8
XFILLER_10_1234 VDD VSS sg13g2_fill_2
X_14050_ _14050_/Q clkload6/A _14050_/D _14050_/RESET_B VDD VSS sg13g2_dfrbpq_1
XFILLER_4_535 VDD VSS sg13g2_decap_8
X_11262_ _11262_/Y _11262_/A _11262_/B VDD VSS sg13g2_nand2_1
XFILLER_153_569 VDD VSS sg13g2_decap_8
XFILLER_137_63 VDD VSS sg13g2_decap_8
X_13001_ _13001_/Y _14875_/Q _13028_/B _13193_/B VDD VSS sg13g2_a21oi_1
X_14339__2225 _14339_/RESET_B VDD VSS sg13g2_tiehi
X_10213_ _10213_/X _10213_/A _10213_/B VDD VSS sg13g2_and2_1
XFILLER_4_579 VDD VSS sg13g2_fill_1
XFILLER_107_997 VDD VSS sg13g2_fill_1
X_11193_ _11193_/Y _11199_/B _11207_/A2 _11207_/B1 VDD VSS sg13g2_a21oi_1
XFILLER_0_730 VDD VSS sg13g2_fill_1
X_10144_ _14721_/D _14721_/Q _10144_/A1 _10167_/S VDD VSS sg13g2_mux2_1
XFILLER_67_509 VDD VSS sg13g2_decap_8
XFILLER_122_989 VDD VSS sg13g2_decap_8
XFILLER_48_712 VDD VSS sg13g2_fill_2
XFILLER_121_477 VDD VSS sg13g2_decap_8
XFILLER_82_1092 VDD VSS sg13g2_decap_8
XFILLER_94_328 VDD VSS sg13g2_decap_8
X_10075_ _14655_/D _10075_/A0 _14655_/Q _10094_/S VDD VSS sg13g2_mux2_1
X_14952_ _14952_/Q _15046_/CLK _14952_/D _14952_/RESET_B VDD VSS sg13g2_dfrbpq_1
XFILLER_153_84 VDD VSS sg13g2_decap_8
X_13903_ _13903_/Q clkload12/A _13903_/D _13903_/RESET_B VDD VSS sg13g2_dfrbpq_1
X_14554__2010 _14554_/RESET_B VDD VSS sg13g2_tiehi
X_14883_ _14883_/Q clkload83/A _14883_/D _14883_/RESET_B VDD VSS sg13g2_dfrbpq_1
X_13834_ _13834_/Q clkload22/A _13834_/D _13834_/RESET_B VDD VSS sg13g2_dfrbpq_1
Xclkbuf_5_5__f_clk_i clkbuf_leaf_8_clk_i/A clkbuf_4_2_0_clk_i/X VDD VSS sg13g2_buf_16
XFILLER_16_631 VDD VSS sg13g2_decap_8
X_13765_ _13765_/Q _14405_/CLK _13765_/D _13765_/RESET_B VDD VSS sg13g2_dfrbpq_1
X_10977_ _10978_/B _10949_/Y _11004_/A _11009_/B VDD VSS sg13g2_a21oi_1
X_12716_ _12716_/X _14389_/Q _14421_/Q _14485_/Q _14517_/Q _12772_/S0 _12772_/S1 VDD
+ VSS sg13g2_mux4_1
XFILLER_43_494 VDD VSS sg13g2_fill_1
X_13696_ _13696_/Q clkload17/A _13696_/D _13696_/RESET_B VDD VSS sg13g2_dfrbpq_1
XFILLER_94_7 VDD VSS sg13g2_decap_8
XFILLER_15_1101 VDD VSS sg13g2_decap_8
X_12647_ _12647_/X _13968_/Q _14000_/Q _14032_/Q _14064_/Q _12647_/S0 _12647_/S1 VDD
+ VSS sg13g2_mux4_1
XFILLER_141_1131 VDD VSS sg13g2_decap_4
XFILLER_50_1014 VDD VSS sg13g2_decap_8
XFILLER_54_1183 VDD VSS sg13g2_decap_8
XFILLER_129_533 VDD VSS sg13g2_fill_1
XFILLER_156_330 VDD VSS sg13g2_fill_1
XFILLER_7_21 VDD VSS sg13g2_decap_8
X_12578_ _12578_/X _14251_/Q _14283_/Q _14315_/Q _14347_/Q _12578_/S0 _12771_/S1 VDD
+ VSS sg13g2_mux4_1
XFILLER_89_1224 VDD VSS sg13g2_decap_8
XFILLER_129_566 VDD VSS sg13g2_decap_8
XFILLER_141_1175 VDD VSS sg13g2_decap_8
XFILLER_15_1178 VDD VSS sg13g2_decap_8
XFILLER_89_1235 VDD VSS sg13g2_fill_2
XFILLER_102_1137 VDD VSS sg13g2_decap_4
XFILLER_156_374 VDD VSS sg13g2_fill_1
X_11529_ _11533_/A _11528_/X _11739_/B VDD VSS sg13g2_nand2b_1
X_15240__3393 _15240_/RESET_B VDD VSS sg13g2_tiehi
X_14317_ _14317_/Q _14737_/CLK _14317_/D _14317_/RESET_B VDD VSS sg13g2_dfrbpq_1
Xwire271 wire271/X wire271/A VDD VSS sg13g2_buf_2
XFILLER_7_98 VDD VSS sg13g2_decap_8
X_14248_ _14248_/Q _14465_/CLK _14248_/D _14248_/RESET_B VDD VSS sg13g2_dfrbpq_1
XFILLER_113_912 VDD VSS sg13g2_decap_8
X_14179_ _14179_/Q clkload0/A _14179_/D _14179_/RESET_B VDD VSS sg13g2_dfrbpq_1
XFILLER_125_794 VDD VSS sg13g2_fill_2
XFILLER_113_967 VDD VSS sg13g2_fill_1
XFILLER_61_1132 VDD VSS sg13g2_decap_8
X_08740_ _08740_/Y _13665_/Q _08752_/B VDD VSS sg13g2_nor2_1
X_14193__2371 _14193_/RESET_B VDD VSS sg13g2_tiehi
XFILLER_61_1154 VDD VSS sg13g2_decap_8
XFILLER_16_0 VDD VSS sg13g2_decap_8
Xfanout1380 _08044_/S1 _08337_/S1 VDD VSS sg13g2_buf_1
Xfanout1391 _08046_/B _08598_/S0 VDD VSS sg13g2_buf_1
X_08671_ _08671_/Y _08599_/C _08029_/Y _08520_/X _08597_/A _08670_/Y VDD VSS sg13g2_a221oi_1
XFILLER_22_1149 VDD VSS sg13g2_decap_8
XFILLER_26_406 VDD VSS sg13g2_decap_8
XFILLER_39_789 VDD VSS sg13g2_fill_1
XFILLER_54_715 VDD VSS sg13g2_fill_1
XFILLER_93_372 VDD VSS sg13g2_fill_2
X_07622_ _07622_/Y _14861_/Q VDD VSS sg13g2_inv_1
XFILLER_54_748 VDD VSS sg13g2_decap_8
XFILLER_54_759 VDD VSS sg13g2_fill_1
XFILLER_81_556 VDD VSS sg13g2_decap_4
XFILLER_62_781 VDD VSS sg13g2_fill_1
X_09223_ _13834_/D _10153_/A1 _13834_/Q _09223_/S VDD VSS sg13g2_mux2_1
X_14417__2147 _14417_/RESET_B VDD VSS sg13g2_tiehi
XFILLER_107_1059 VDD VSS sg13g2_fill_1
X_09154_ _09154_/Y _15248_/Q _09161_/S VDD VSS sg13g2_nand2b_1
X_08105_ _08105_/Y _08105_/A _08110_/B VDD VSS sg13g2_nor2_1
X_09085_ _09085_/Y _15238_/Q _09085_/B VDD VSS sg13g2_nand2b_1
X_08036_ _08039_/B _08036_/A _08110_/D _08452_/C _08452_/D VDD VSS sg13g2_nand4_1
XFILLER_150_506 VDD VSS sg13g2_fill_1
X_14906__3117 _14906_/RESET_B VDD VSS sg13g2_tiehi
XFILLER_150_517 VDD VSS sg13g2_fill_1
X_15060__2878 _15060_/RESET_B VDD VSS sg13g2_tiehi
XFILLER_153_1013 VDD VSS sg13g2_decap_8
XFILLER_104_978 VDD VSS sg13g2_decap_8
XFILLER_118_1155 VDD VSS sg13g2_decap_8
X_09987_ _14570_/D _10086_/A0 _14570_/Q _09987_/S VDD VSS sg13g2_mux2_1
XFILLER_77_818 VDD VSS sg13g2_fill_2
XFILLER_130_241 VDD VSS sg13g2_fill_2
XFILLER_89_689 VDD VSS sg13g2_fill_1
XFILLER_88_166 VDD VSS sg13g2_fill_1
X_08938_ _13718_/D _16880_/A _08937_/X _08941_/S VDD VSS sg13g2_mux2_1
X_14023__2541 _14023_/RESET_B VDD VSS sg13g2_tiehi
XFILLER_57_531 VDD VSS sg13g2_fill_1
XFILLER_123_21 VDD VSS sg13g2_decap_8
XFILLER_85_851 VDD VSS sg13g2_decap_8
X_08869_ _08869_/Y _10694_/S _14935_/Q VDD VSS sg13g2_nor2b_1
XFILLER_83_14 VDD VSS sg13g2_decap_8
X_10900_ _10900_/Y _10899_/Y _10896_/Y _10939_/B1 VDD VSS sg13g2_o21ai_1
X_11880_ _11880_/Y _11882_/S0 _14670_/Q _11894_/B VDD VSS sg13g2_a21oi_1
X_14627__1937 _14627_/RESET_B VDD VSS sg13g2_tiehi
XFILLER_72_556 VDD VSS sg13g2_fill_2
XFILLER_26_962 VDD VSS sg13g2_decap_8
X_10831_ _10832_/A _10831_/A _10831_/B _10831_/C VDD VSS sg13g2_nand3_1
XFILLER_32_409 VDD VSS sg13g2_decap_8
XFILLER_13_601 VDD VSS sg13g2_decap_8
XFILLER_41_910 VDD VSS sg13g2_fill_1
XFILLER_16_63 VDD VSS sg13g2_decap_8
XFILLER_41_921 VDD VSS sg13g2_decap_4
XFILLER_77_1183 VDD VSS sg13g2_decap_8
X_13891__2673 _13891_/RESET_B VDD VSS sg13g2_tiehi
X_13550_ wire732/A _13550_/A1 _13600_/B _13549_/Y VDD VSS sg13g2_a21oi_1
X_10762_ _10762_/Y _10767_/A _10762_/B VDD VSS sg13g2_nor2_1
XFILLER_125_1104 VDD VSS sg13g2_fill_1
X_12501_ _12501_/X _14246_/Q _14278_/Q _14310_/Q _14342_/Q _12508_/S0 _12508_/S1 VDD
+ VSS sg13g2_mux4_1
XFILLER_125_1126 VDD VSS sg13g2_fill_2
X_13481_ _13484_/A _13481_/A _15176_/Q _13481_/C VDD VSS sg13g2_nand3_1
X_10693_ _14900_/D _10693_/A VDD VSS sg13g2_inv_1
XFILLER_13_689 VDD VSS sg13g2_fill_1
X_15220_ _15220_/Q clkload67/A _15220_/D _15220_/RESET_B VDD VSS sg13g2_dfrbpq_1
X_12432_ _12432_/X _13729_/Q _14081_/Q _14433_/Q _14529_/Q _12561_/S0 _12564_/S1 VDD
+ VSS sg13g2_mux4_1
Xmax_cap1605 _12027_/C _11420_/C VDD VSS sg13g2_buf_4
XFILLER_8_159 VDD VSS sg13g2_fill_2
XFILLER_120_0 VDD VSS sg13g2_decap_8
XFILLER_139_897 VDD VSS sg13g2_decap_8
X_15151_ _15151_/Q clkload26/A _15151_/D _15151_/RESET_B VDD VSS sg13g2_dfrbpq_1
X_12363_ _12363_/X _14108_/Q _14140_/Q _14172_/Q _14204_/Q _12366_/S0 _12366_/S1 VDD
+ VSS sg13g2_mux4_1
XFILLER_126_514 VDD VSS sg13g2_decap_8
X_14271__2293 _14271_/RESET_B VDD VSS sg13g2_tiehi
XFILLER_153_322 VDD VSS sg13g2_decap_8
XFILLER_148_84 VDD VSS sg13g2_decap_8
X_14102_ _14102_/Q _14710_/CLK _14102_/D _14102_/RESET_B VDD VSS sg13g2_dfrbpq_1
X_11314_ _11314_/Y _11328_/S0 _14365_/Q VDD VSS sg13g2_nand2b_1
X_15082_ _15082_/Q clkload71/A _15082_/D _15082_/RESET_B VDD VSS sg13g2_dfrbpq_1
XFILLER_114_709 VDD VSS sg13g2_decap_8
X_12294_ _12294_/Y _14924_/Q _12338_/A2 _12294_/B1 VDD VSS sg13g2_a21oi_1
XFILLER_154_889 VDD VSS sg13g2_decap_8
X_14033_ _14033_/Q clkload44/A _14033_/D _14033_/RESET_B VDD VSS sg13g2_dfrbpq_1
XFILLER_4_376 VDD VSS sg13g2_decap_8
X_11245_ _11245_/Y _11245_/A _11245_/B _11245_/C VDD VSS sg13g2_nand3_1
XFILLER_79_111 VDD VSS sg13g2_fill_2
XFILLER_136_1233 VDD VSS sg13g2_decap_4
XFILLER_122_753 VDD VSS sg13g2_decap_8
X_11176_ _11177_/B _11171_/B _11147_/Y _11175_/Y VDD VSS sg13g2_a21o_1
X_10127_ _14705_/D _10160_/A1 _14705_/Q _10127_/S VDD VSS sg13g2_mux2_1
XFILLER_0_582 VDD VSS sg13g2_decap_4
XFILLER_110_959 VDD VSS sg13g2_decap_8
XFILLER_95_659 VDD VSS sg13g2_fill_2
XFILLER_48_542 VDD VSS sg13g2_fill_1
X_14935_ _14935_/Q clkload34/A _14935_/D _14935_/RESET_B VDD VSS sg13g2_dfrbpq_1
X_10058_ _14639_/D _10091_/A0 _14639_/Q _10068_/S VDD VSS sg13g2_mux2_1
XFILLER_36_704 VDD VSS sg13g2_decap_8
XFILLER_76_884 VDD VSS sg13g2_decap_8
XFILLER_76_895 VDD VSS sg13g2_decap_8
XFILLER_91_832 VDD VSS sg13g2_decap_8
X_14866_ _14866_/Q clkload69/A _14866_/D _14866_/RESET_B VDD VSS sg13g2_dfrbpq_1
XFILLER_90_342 VDD VSS sg13g2_decap_8
XFILLER_90_353 VDD VSS sg13g2_fill_2
X_13817_ _13817_/Q _14731_/CLK _13817_/D _13817_/RESET_B VDD VSS sg13g2_dfrbpq_1
X_14797_ _14797_/Q _14873_/CLK _14797_/D _14797_/RESET_B VDD VSS sg13g2_dfrbpq_1
XFILLER_91_1103 VDD VSS sg13g2_decap_8
XFILLER_73_80 VDD VSS sg13g2_fill_2
X_13721__2843 _13721_/RESET_B VDD VSS sg13g2_tiehi
X_13748_ _13748_/Q clkload16/A _13748_/D _13748_/RESET_B VDD VSS sg13g2_dfrbpq_1
XFILLER_17_1218 VDD VSS sg13g2_decap_8
XFILLER_52_1109 VDD VSS sg13g2_decap_8
XFILLER_91_1158 VDD VSS sg13g2_decap_4
XFILLER_148_105 VDD VSS sg13g2_decap_8
XFILLER_32_987 VDD VSS sg13g2_fill_2
X_13679_ _13679_/Q clkload61/A _13679_/D _13679_/RESET_B VDD VSS sg13g2_dfrbpq_1
XFILLER_148_149 VDD VSS sg13g2_decap_8
XFILLER_31_497 VDD VSS sg13g2_fill_2
XFILLER_89_1010 VDD VSS sg13g2_fill_1
XFILLER_8_671 VDD VSS sg13g2_fill_2
X_14101__2463 _14101_/RESET_B VDD VSS sg13g2_tiehi
XFILLER_156_182 VDD VSS sg13g2_decap_4
XFILLER_89_1076 VDD VSS sg13g2_fill_1
XFILLER_89_1087 VDD VSS sg13g2_decap_4
X_09910_ _14495_/D _14495_/Q _09910_/A1 _09910_/S VDD VSS sg13g2_mux2_1
X_14705__1859 _14705_/RESET_B VDD VSS sg13g2_tiehi
Xfanout606 _09987_/S wire613/X VDD VSS sg13g2_buf_1
X_09841_ _14428_/D _14428_/Q _10039_/A0 wire435/A VDD VSS sg13g2_mux2_1
Xfanout617 wire618/A wire623/X VDD VSS sg13g2_buf_1
XFILLER_98_442 VDD VSS sg13g2_fill_2
Xfanout628 wire629/A wire634/X VDD VSS sg13g2_buf_1
XFILLER_99_987 VDD VSS sg13g2_fill_1
XFILLER_59_829 VDD VSS sg13g2_fill_2
XFILLER_113_797 VDD VSS sg13g2_decap_4
XFILLER_6_1110 VDD VSS sg13g2_decap_8
XFILLER_100_425 VDD VSS sg13g2_decap_8
X_09772_ _14362_/D _14362_/Q _10069_/A0 _09772_/S VDD VSS sg13g2_mux2_1
X_08723_ _08723_/Y _13412_/B _08723_/B VDD VSS sg13g2_nor2_1
XFILLER_26_1093 VDD VSS sg13g2_decap_8
XFILLER_27_715 VDD VSS sg13g2_decap_8
XFILLER_66_350 VDD VSS sg13g2_fill_2
XFILLER_67_884 VDD VSS sg13g2_fill_1
XFILLER_27_726 VDD VSS sg13g2_fill_1
XFILLER_6_1187 VDD VSS sg13g2_decap_8
X_08654_ _08654_/Y _08654_/A _08654_/B VDD VSS sg13g2_nor2_1
XFILLER_27_737 VDD VSS sg13g2_decap_8
XFILLER_54_534 VDD VSS sg13g2_fill_2
XFILLER_148_1137 VDD VSS sg13g2_decap_4
XFILLER_42_707 VDD VSS sg13g2_fill_1
X_08585_ _08586_/C _08608_/B _08576_/Y _08584_/Y VDD VSS sg13g2_o21ai_1
XFILLER_22_442 VDD VSS sg13g2_decap_8
XFILLER_139_105 VDD VSS sg13g2_decap_8
X_13687__2883 _13687_/RESET_B VDD VSS sg13g2_tiehi
XFILLER_10_615 VDD VSS sg13g2_fill_2
X_09206_ _09206_/X _09641_/A _09307_/B _09707_/B _09641_/D VDD VSS sg13g2_or4_1
XFILLER_155_609 VDD VSS sg13g2_decap_8
XFILLER_154_119 VDD VSS sg13g2_decap_8
X_09137_ _09137_/Y _09137_/A _09137_/B _09137_/C VDD VSS sg13g2_nor3_1
XFILLER_120_1056 VDD VSS sg13g2_decap_8
XFILLER_118_21 VDD VSS sg13g2_decap_8
X_09068_ _09103_/C _14911_/Q _13064_/A _09089_/C VDD VSS sg13g2_and3_1
XFILLER_68_1138 VDD VSS sg13g2_fill_2
X_08019_ _08019_/X _08199_/B _08019_/B VDD VSS sg13g2_and2_1
XFILLER_78_14 VDD VSS sg13g2_decap_8
XFILLER_150_358 VDD VSS sg13g2_decap_8
X_11030_ _11030_/Y _11040_/A _11045_/A2 _09204_/C VDD VSS sg13g2_a21oi_1
XFILLER_1_357 VDD VSS sg13g2_decap_8
XFILLER_1_368 VDD VSS sg13g2_fill_2
XFILLER_77_615 VDD VSS sg13g2_decap_8
XFILLER_131_572 VDD VSS sg13g2_decap_8
XFILLER_134_42 VDD VSS sg13g2_decap_8
XFILLER_94_35 VDD VSS sg13g2_decap_8
X_12981_ _12981_/Y input23/X _12795_/Y _12937_/Y VDD VSS sg13g2_o21ai_1
Xclkbuf_5_23__f_clk_i clkbuf_leaf_62_clk_i/A clkbuf_4_11_0_clk_i/X VDD VSS sg13g2_buf_16
XFILLER_18_737 VDD VSS sg13g2_fill_1
XFILLER_73_832 VDD VSS sg13g2_decap_8
X_14720_ _14720_/Q _14916_/CLK _14720_/D _14720_/RESET_B VDD VSS sg13g2_dfrbpq_1
XFILLER_27_51 VDD VSS sg13g2_fill_1
XFILLER_18_748 VDD VSS sg13g2_fill_2
X_11932_ _11932_/Y _11931_/Y wire300/X _11917_/Y _12051_/A1 _11980_/A VDD VSS sg13g2_a221oi_1
XFILLER_27_62 VDD VSS sg13g2_decap_8
X_14289__2275 _14289_/RESET_B VDD VSS sg13g2_tiehi
XFILLER_150_63 VDD VSS sg13g2_decap_8
X_14651_ _14651_/Q clkload75/A _14651_/D _14651_/RESET_B VDD VSS sg13g2_dfrbpq_1
XFILLER_72_353 VDD VSS sg13g2_decap_8
X_11863_ _11863_/Y _11865_/A _12298_/B VDD VSS sg13g2_nor2_1
XFILLER_26_781 VDD VSS sg13g2_decap_4
X_13602_ _13602_/Y _13602_/A _13609_/B VDD VSS sg13g2_nor2_1
X_10814_ _10814_/Y _10805_/B _10805_/C _10844_/B VDD VSS sg13g2_o21ai_1
X_14582_ _14582_/Q _14678_/CLK _14582_/D _14582_/RESET_B VDD VSS sg13g2_dfrbpq_1
X_11794_ _11794_/Y _11793_/Y _11792_/Y _11780_/Y _12051_/A1 _11980_/A VDD VSS sg13g2_a221oi_1
XFILLER_13_431 VDD VSS sg13g2_fill_1
XFILLER_14_965 VDD VSS sg13g2_decap_8
X_13533_ _13533_/X _13533_/A _13537_/B VDD VSS sg13g2_and2_1
X_10745_ _10745_/Y _14914_/Q _11084_/B VDD VSS sg13g2_nand2_1
XFILLER_13_486 VDD VSS sg13g2_decap_8
X_13464_ _15107_/D _13449_/X _13463_/X _13461_/Y VDD VSS sg13g2_o21ai_1
X_10676_ _10813_/A _08977_/B _10669_/S _10805_/B VDD VSS sg13g2_a21oi_1
XFILLER_103_1221 VDD VSS sg13g2_decap_8
X_12415_ _12415_/Y _12415_/A _12415_/B VDD VSS sg13g2_nand2_1
X_15203_ _15203_/Q clkload69/A _15203_/D _15203_/RESET_B VDD VSS sg13g2_dfrbpq_1
XFILLER_138_160 VDD VSS sg13g2_decap_8
XFILLER_126_300 VDD VSS sg13g2_decap_8
XFILLER_12_1137 VDD VSS sg13g2_decap_8
X_13395_ _13395_/Y _13600_/C _15129_/Q _13507_/B VDD VSS sg13g2_nand3_1
XFILLER_126_322 VDD VSS sg13g2_fill_1
XFILLER_154_642 VDD VSS sg13g2_decap_4
XFILLER_126_333 VDD VSS sg13g2_decap_8
XFILLER_127_856 VDD VSS sg13g2_decap_8
X_15134_ _15134_/Q _15148_/CLK _15134_/D _15134_/RESET_B VDD VSS sg13g2_dfrbpq_1
XFILLER_86_1227 VDD VSS sg13g2_decap_8
X_12346_ _12347_/D _12346_/A _15121_/Q VDD VSS sg13g2_or2_1
XFILLER_57_7 VDD VSS sg13g2_decap_8
XFILLER_4_140 VDD VSS sg13g2_decap_8
XFILLER_4_151 VDD VSS sg13g2_fill_2
X_15065_ _15065_/Q _15178_/CLK _15065_/D _15065_/RESET_B VDD VSS sg13g2_dfrbpq_1
X_12277_ _12277_/X _12278_/A _13663_/Q VDD VSS sg13g2_and2_1
XFILLER_153_196 VDD VSS sg13g2_decap_8
XFILLER_141_336 VDD VSS sg13g2_fill_2
X_14016_ _14016_/Q _14726_/CLK _14016_/D _14016_/RESET_B VDD VSS sg13g2_dfrbpq_1
X_11228_ _11228_/X _14683_/Q _14715_/Q _13755_/Q _13787_/Q _11275_/S0 _11282_/S1 VDD
+ VSS sg13g2_mux4_1
XFILLER_96_913 VDD VSS sg13g2_decap_8
XFILLER_4_77 VDD VSS sg13g2_decap_8
XFILLER_67_103 VDD VSS sg13g2_fill_2
X_13739__2825 _13739_/RESET_B VDD VSS sg13g2_tiehi
X_11159_ _11159_/Y _11171_/B _11180_/C _11173_/C VDD VSS sg13g2_a21oi_1
XFILLER_95_434 VDD VSS sg13g2_fill_1
XFILLER_49_840 VDD VSS sg13g2_decap_8
XFILLER_0_390 VDD VSS sg13g2_decap_4
XFILLER_49_862 VDD VSS sg13g2_decap_8
XFILLER_67_169 VDD VSS sg13g2_fill_1
XFILLER_49_884 VDD VSS sg13g2_fill_2
XFILLER_76_670 VDD VSS sg13g2_fill_2
X_14918_ _14918_/Q clkload18/A _14918_/D _14918_/RESET_B VDD VSS sg13g2_dfrbpq_1
XFILLER_110_1236 VDD VSS sg13g2_fill_1
XFILLER_64_854 VDD VSS sg13g2_fill_2
X_13954__2610 _13954_/RESET_B VDD VSS sg13g2_tiehi
X_14119__2445 _14119_/RESET_B VDD VSS sg13g2_tiehi
X_14849_ _14849_/Q _14854_/CLK _14849_/D _14849_/RESET_B VDD VSS sg13g2_dfrbpq_1
XFILLER_90_150 VDD VSS sg13g2_fill_2
XFILLER_17_770 VDD VSS sg13g2_decap_8
XFILLER_1_1062 VDD VSS sg13g2_decap_8
XFILLER_90_172 VDD VSS sg13g2_decap_8
X_08370_ _08370_/Y _08369_/B _08367_/Y _08389_/B VDD VSS sg13g2_o21ai_1
XFILLER_95_1080 VDD VSS sg13g2_decap_4
XFILLER_147_1170 VDD VSS sg13g2_decap_4
XFILLER_32_740 VDD VSS sg13g2_decap_8
XFILLER_17_1015 VDD VSS sg13g2_decap_8
XFILLER_108_1154 VDD VSS sg13g2_decap_4
XFILLER_83_0 VDD VSS sg13g2_decap_8
XFILLER_137_609 VDD VSS sg13g2_decap_4
X_14334__2230 _14334_/RESET_B VDD VSS sg13g2_tiehi
X_13987__2577 _13987_/RESET_B VDD VSS sg13g2_tiehi
XFILLER_118_823 VDD VSS sg13g2_decap_8
XFILLER_117_333 VDD VSS sg13g2_decap_8
XFILLER_129_193 VDD VSS sg13g2_fill_1
XFILLER_105_528 VDD VSS sg13g2_decap_8
XFILLER_117_399 VDD VSS sg13g2_decap_8
X_14367__2197 _14367_/RESET_B VDD VSS sg13g2_tiehi
XFILLER_28_1122 VDD VSS sg13g2_decap_8
Xfanout403 _10094_/S _10093_/S VDD VSS sg13g2_buf_1
XFILLER_154_1141 VDD VSS sg13g2_decap_8
XFILLER_8_1216 VDD VSS sg13g2_decap_8
XFILLER_99_784 VDD VSS sg13g2_decap_8
Xfanout436 fanout436/X wire438/X VDD VSS sg13g2_buf_1
XFILLER_141_881 VDD VSS sg13g2_fill_2
XFILLER_48_28 VDD VSS sg13g2_fill_2
XFILLER_150_1005 VDD VSS sg13g2_decap_4
XFILLER_24_1008 VDD VSS sg13g2_decap_8
XFILLER_113_583 VDD VSS sg13g2_decap_8
X_09824_ _14412_/D _09824_/A0 _14412_/Q _09829_/S VDD VSS sg13g2_mux2_1
Xfanout469 wire470/A fanout471/X VDD VSS sg13g2_buf_1
XFILLER_28_1199 VDD VSS sg13g2_decap_8
XFILLER_101_745 VDD VSS sg13g2_fill_2
XFILLER_115_1169 VDD VSS sg13g2_decap_4
X_09755_ _14345_/D _14345_/Q _09887_/A0 _09765_/S VDD VSS sg13g2_mux2_1
XFILLER_100_255 VDD VSS sg13g2_decap_4
XFILLER_55_821 VDD VSS sg13g2_decap_8
XFILLER_104_56 VDD VSS sg13g2_decap_8
XFILLER_55_832 VDD VSS sg13g2_fill_2
X_08706_ _13658_/D _15185_/D _15116_/Q _13651_/S VDD VSS sg13g2_mux2_1
X_09686_ _14278_/D _09884_/A0 _14278_/Q wire456/A VDD VSS sg13g2_mux2_1
Xclkbuf_4_9_0_clk_i clkbuf_4_9_0_clk_i/X clkbuf_0_clk_i/X VDD VSS sg13g2_buf_8
X_08637_ _08640_/D _08637_/A _08637_/B VDD VSS sg13g2_nand2_1
XFILLER_82_662 VDD VSS sg13g2_decap_8
XFILLER_27_578 VDD VSS sg13g2_fill_1
X_08568_ _08568_/Y _15012_/Q _08541_/B _13566_/A _07812_/B VDD VSS sg13g2_a22oi_1
XFILLER_74_1131 VDD VSS sg13g2_decap_8
XFILLER_70_879 VDD VSS sg13g2_decap_8
XFILLER_74_1164 VDD VSS sg13g2_fill_2
XFILLER_74_1175 VDD VSS sg13g2_decap_8
X_08499_ _08499_/Y _08527_/B _08498_/Y _08000_/X VDD VSS sg13g2_o21ai_1
XFILLER_74_1186 VDD VSS sg13g2_decap_8
XFILLER_50_581 VDD VSS sg13g2_decap_8
X_10530_ _10532_/C _10558_/B _10543_/C _14859_/Q VDD VSS sg13g2_a21o_1
XFILLER_128_609 VDD VSS sg13g2_decap_8
XFILLER_13_42 VDD VSS sg13g2_decap_8
XFILLER_11_979 VDD VSS sg13g2_decap_8
XFILLER_7_928 VDD VSS sg13g2_decap_4
X_13817__2747 _13817_/RESET_B VDD VSS sg13g2_tiehi
XFILLER_155_439 VDD VSS sg13g2_decap_8
X_10461_ _10502_/A _10511_/D _14842_/Q _14841_/Q VDD VSS sg13g2_nand3_1
X_14577__1987 _14577_/RESET_B VDD VSS sg13g2_tiehi
X_12200_ _12200_/X _12200_/A _12200_/B VDD VSS sg13g2_or2_1
XFILLER_136_653 VDD VSS sg13g2_fill_1
XFILLER_109_867 VDD VSS sg13g2_decap_8
XFILLER_135_130 VDD VSS sg13g2_decap_8
XFILLER_89_35 VDD VSS sg13g2_decap_8
X_13180_ _13180_/Y _14823_/Q _13180_/A2 _13180_/B1 _14887_/Q _13180_/C1 VDD VSS sg13g2_a221oi_1
X_10392_ _14821_/D _10392_/A _10626_/B _10392_/C VDD VSS sg13g2_and3_1
XFILLER_89_46 VDD VSS sg13g2_fill_1
X_12131_ _12155_/B _12198_/B _12132_/B VDD VSS sg13g2_nand2b_1
XFILLER_123_336 VDD VSS sg13g2_fill_2
XFILLER_151_656 VDD VSS sg13g2_decap_8
XFILLER_2_644 VDD VSS sg13g2_decap_8
XFILLER_81_1102 VDD VSS sg13g2_decap_8
XFILLER_150_144 VDD VSS sg13g2_decap_4
X_12062_ _12065_/A _12062_/A wire379/X _12197_/A VDD VSS sg13g2_nand3_1
XFILLER_145_63 VDD VSS sg13g2_decap_8
XFILLER_78_913 VDD VSS sg13g2_fill_2
XFILLER_2_677 VDD VSS sg13g2_decap_8
X_11013_ _11022_/B _11012_/B _11012_/C _11064_/A VDD VSS sg13g2_o21ai_1
XFILLER_1_176 VDD VSS sg13g2_fill_1
X_16870_ _16870_/X _16870_/A VDD VSS sg13g2_buf_1
XFILLER_77_445 VDD VSS sg13g2_decap_8
Xfanout970 _12253_/B _12260_/A1 VDD VSS sg13g2_buf_1
Xfanout981 _11875_/B _12317_/B VDD VSS sg13g2_buf_1
XFILLER_77_467 VDD VSS sg13g2_decap_8
XFILLER_49_169 VDD VSS sg13g2_decap_8
Xfanout992 fanout992/X _11279_/B1 VDD VSS sg13g2_buf_1
XFILLER_92_426 VDD VSS sg13g2_decap_4
XFILLER_38_94 VDD VSS sg13g2_fill_2
XFILLER_18_534 VDD VSS sg13g2_fill_2
XFILLER_46_843 VDD VSS sg13g2_decap_8
X_14412__2152 _14412_/RESET_B VDD VSS sg13g2_tiehi
X_12964_ _12964_/Y _14809_/Q _07728_/A _13094_/B1 _14841_/Q _13082_/B VDD VSS sg13g2_a221oi_1
XFILLER_79_1053 VDD VSS sg13g2_fill_2
X_14703_ _14703_/Q clkload15/A _14703_/D _14703_/RESET_B VDD VSS sg13g2_dfrbpq_1
X_11915_ _12055_/A _11915_/A VDD VSS sg13g2_inv_1
X_12895_ _12895_/Y _12895_/A _12963_/B VDD VSS sg13g2_nand2_1
XFILLER_45_386 VDD VSS sg13g2_decap_4
XFILLER_60_312 VDD VSS sg13g2_decap_8
XFILLER_72_172 VDD VSS sg13g2_decap_8
X_14634_ _14634_/Q clkload20/A _14634_/D _14634_/RESET_B VDD VSS sg13g2_dfrbpq_1
XFILLER_54_60 VDD VSS sg13g2_fill_2
X_11846_ _11846_/Y _11846_/A _11867_/B VDD VSS sg13g2_nand2_1
X_14565_ _14565_/Q clkload5/A _14565_/D _14565_/RESET_B VDD VSS sg13g2_dfrbpq_1
X_11777_ _11778_/B _11777_/A _11777_/B _11777_/C VDD VSS sg13g2_nor3_1
XFILLER_53_1226 VDD VSS sg13g2_decap_8
XFILLER_60_378 VDD VSS sg13g2_decap_8
X_13516_ _15139_/D _15139_/Q _13545_/A _13547_/B VDD VSS sg13g2_mux2_1
X_10728_ _14909_/D _10985_/B1 wire385/A _10727_/Y VDD VSS sg13g2_o21ai_1
X_14496_ _14496_/Q _14917_/CLK _14496_/D _14496_/RESET_B VDD VSS sg13g2_dfrbpq_1
XFILLER_118_119 VDD VSS sg13g2_fill_2
XFILLER_70_81 VDD VSS sg13g2_decap_8
X_13447_ wire808/A _15193_/Q _15194_/Q _15195_/Q _15197_/Q VDD VSS sg13g2_nor4_1
X_10659_ _10661_/B _14891_/Q _10663_/D _14892_/Q VDD VSS sg13g2_a21oi_1
XFILLER_139_491 VDD VSS sg13g2_decap_8
Xclkload13 clkload13/Y clkload13/A VDD VSS sg13g2_inv_2
Xclkload24 clkload24/Y clkload24/A VDD VSS sg13g2_inv_1
Xclkload35 clkload35/Y clkload35/A VDD VSS sg13g2_inv_1
Xclkload46 clkload46/Y clkload46/A VDD VSS sg13g2_inv_2
XFILLER_6_961 VDD VSS sg13g2_decap_8
X_13378_ _13378_/Y _13381_/B _13494_/B _13378_/C VDD VSS sg13g2_nor3_1
XFILLER_103_1084 VDD VSS sg13g2_fill_2
Xclkload57 clkload57/Y clkload57/A VDD VSS sg13g2_inv_2
Xclkload68 clkload68/Y clkload68/A VDD VSS sg13g2_inv_4
XFILLER_103_1095 VDD VSS sg13g2_decap_8
Xclkload79 clkload79/Y clkload79/A VDD VSS sg13g2_inv_1
XFILLER_47_1008 VDD VSS sg13g2_fill_2
X_15117_ _15117_/Q clkload65/A _15117_/D _15117_/RESET_B VDD VSS sg13g2_dfrbpq_1
X_12329_ _12329_/Y _12325_/Y _12326_/Y _12328_/Y _12327_/Y _11973_/B VDD VSS sg13g2_a221oi_1
XFILLER_138_1147 VDD VSS sg13g2_decap_4
XFILLER_5_493 VDD VSS sg13g2_decap_8
Xhold3509 hold3509/X _15011_/Q VDD VSS sg13g2_dlygate4sd3_1
XFILLER_130_807 VDD VSS sg13g2_fill_1
Xclkbuf_leaf_64_clk_i clkload76/A clkbuf_leaf_66_clk_i/A VDD VSS sg13g2_buf_8
X_15048_ _15048_/Q _15248_/CLK _15048_/D _15048_/RESET_B VDD VSS sg13g2_dfrbpq_1
X_14622__1942 _14622_/RESET_B VDD VSS sg13g2_tiehi
XFILLER_96_710 VDD VSS sg13g2_fill_2
XFILLER_96_721 VDD VSS sg13g2_fill_2
X_07870_ _08188_/A _07870_/A _08201_/A VDD VSS sg13g2_and2_1
XFILLER_69_968 VDD VSS sg13g2_decap_8
XFILLER_110_553 VDD VSS sg13g2_decap_8
XFILLER_95_253 VDD VSS sg13g2_fill_1
Xclkbuf_leaf_79_clk_i clkload66/A clkbuf_leaf_82_clk_i/A VDD VSS sg13g2_buf_8
XFILLER_110_597 VDD VSS sg13g2_fill_1
X_09540_ _09540_/Y _10037_/A _10004_/B _10004_/C _09606_/C VDD VSS sg13g2_nand4_1
XFILLER_23_1063 VDD VSS sg13g2_decap_8
XFILLER_3_1146 VDD VSS sg13g2_decap_8
XFILLER_110_1033 VDD VSS sg13g2_decap_4
XFILLER_149_1221 VDD VSS sg13g2_decap_8
X_13660__3352 _13660_/RESET_B VDD VSS sg13g2_tiehi
X_09471_ _14072_/D _09836_/A0 _14072_/Q _09473_/S VDD VSS sg13g2_mux2_1
XFILLER_52_802 VDD VSS sg13g2_fill_1
XFILLER_97_1175 VDD VSS sg13g2_decap_8
XFILLER_52_835 VDD VSS sg13g2_fill_2
XFILLER_52_846 VDD VSS sg13g2_fill_1
X_08422_ _08423_/B wire233/X wire232/X _08548_/A VDD VSS sg13g2_mux2_1
XFILLER_97_1197 VDD VSS sg13g2_decap_8
X_08353_ _08354_/B _08353_/A _08353_/B VDD VSS sg13g2_nand2_1
X_14834__3261 _14834_/RESET_B VDD VSS sg13g2_tiehi
XFILLER_51_389 VDD VSS sg13g2_decap_8
XFILLER_32_570 VDD VSS sg13g2_decap_8
XFILLER_60_890 VDD VSS sg13g2_fill_1
X_08284_ _08293_/B _08270_/Y _08271_/Y _08273_/Y _08359_/B2 _08283_/Y VDD VSS sg13g2_a221oi_1
XFILLER_137_406 VDD VSS sg13g2_decap_4
Xclkload7 clkload7/Y clkload7/A VDD VSS sg13g2_inv_1
Xclkbuf_leaf_17_clk_i clkload19/A clkbuf_5_7__f_clk_i/X VDD VSS sg13g2_buf_8
XFILLER_34_1192 VDD VSS sg13g2_decap_8
X_14867__3195 _14867_/RESET_B VDD VSS sg13g2_tiehi
XFILLER_156_1203 VDD VSS sg13g2_decap_8
XFILLER_146_995 VDD VSS sg13g2_decap_8
XFILLER_145_494 VDD VSS sg13g2_decap_8
XFILLER_117_1209 VDD VSS sg13g2_decap_8
Xfanout200 _10091_/A0 fanout204/X VDD VSS sg13g2_buf_1
XFILLER_121_829 VDD VSS sg13g2_decap_8
XFILLER_132_177 VDD VSS sg13g2_fill_1
Xfanout222 _09892_/A0 _10090_/A0 VDD VSS sg13g2_buf_1
XFILLER_59_434 VDD VSS sg13g2_fill_2
XFILLER_113_380 VDD VSS sg13g2_decap_4
Xfanout244 _09824_/A0 _09923_/A1 VDD VSS sg13g2_buf_1
XFILLER_87_754 VDD VSS sg13g2_decap_8
XFILLER_59_456 VDD VSS sg13g2_decap_8
Xfanout266 _09887_/A0 _09920_/A1 VDD VSS sg13g2_buf_1
XFILLER_101_553 VDD VSS sg13g2_fill_2
Xfanout277 _12271_/A _11248_/B VDD VSS sg13g2_buf_1
X_09807_ _14395_/D _09906_/A1 _14395_/Q _09826_/S VDD VSS sg13g2_mux2_1
Xfanout288 _10017_/A0 _10117_/A0 VDD VSS sg13g2_buf_1
XFILLER_75_37 VDD VSS sg13g2_decap_8
XFILLER_75_938 VDD VSS sg13g2_fill_1
X_07999_ _08001_/D _15097_/Q _15092_/Q _15131_/Q _08027_/B VDD VSS sg13g2_nor4_1
XFILLER_46_117 VDD VSS sg13g2_decap_8
XFILLER_101_586 VDD VSS sg13g2_fill_1
X_09738_ _14329_/D _10135_/A0 _14329_/Q _09738_/S VDD VSS sg13g2_mux2_1
XFILLER_27_342 VDD VSS sg13g2_fill_2
XFILLER_131_21 VDD VSS sg13g2_decap_8
XFILLER_28_876 VDD VSS sg13g2_decap_8
X_09669_ _14262_/D _09900_/A0 _14262_/Q wire639/X VDD VSS sg13g2_mux2_1
XFILLER_54_161 VDD VSS sg13g2_decap_8
XFILLER_54_172 VDD VSS sg13g2_fill_1
X_14060__2504 _14060_/RESET_B VDD VSS sg13g2_tiehi
X_11700_ _11700_/X _14907_/Q _11655_/B _11699_/Y VDD VSS sg13g2_a21o_1
XFILLER_54_183 VDD VSS sg13g2_decap_4
X_12680_ _15012_/D _12680_/A wire372/X VDD VSS sg13g2_nor2_1
XFILLER_39_1070 VDD VSS sg13g2_fill_2
XFILLER_42_367 VDD VSS sg13g2_fill_2
X_11631_ _11632_/B _11593_/Y _11631_/A2 _11630_/Y VDD VSS sg13g2_a21oi_1
XFILLER_30_529 VDD VSS sg13g2_decap_8
XFILLER_70_698 VDD VSS sg13g2_decap_8
XFILLER_24_63 VDD VSS sg13g2_decap_8
X_11562_ _11562_/Y _11560_/Y _11561_/Y _11477_/A VDD VSS sg13g2_a21oi_1
X_14350_ _14350_/Q _15188_/CLK _14350_/D _14350_/RESET_B VDD VSS sg13g2_dfrbpq_1
Xwire601 wire601/X wire601/A VDD VSS sg13g2_buf_8
X_14700__1864 _14700_/RESET_B VDD VSS sg13g2_tiehi
XFILLER_7_714 VDD VSS sg13g2_fill_1
Xwire623 wire623/X wire624/X VDD VSS sg13g2_buf_2
XFILLER_155_214 VDD VSS sg13g2_decap_8
X_10513_ _10514_/C _14854_/Q _14853_/Q _14852_/Q _10513_/D VDD VSS sg13g2_and4_1
Xwire634 wire634/X wire635/X VDD VSS sg13g2_buf_2
X_13301_ _13302_/B _07744_/C _13300_/Y _08977_/C VDD VSS sg13g2_o21ai_1
X_14281_ _14281_/Q _14633_/CLK _14281_/D _14281_/RESET_B VDD VSS sg13g2_dfrbpq_1
XFILLER_11_787 VDD VSS sg13g2_fill_1
XFILLER_7_736 VDD VSS sg13g2_decap_8
X_11493_ _11493_/X _13954_/Q _13986_/Q _14018_/Q _14050_/Q _11493_/S0 _11493_/S1 VDD
+ VSS sg13g2_mux4_1
XFILLER_7_747 VDD VSS sg13g2_fill_2
X_13232_ _13232_/Y _13232_/A _13244_/B VDD VSS sg13g2_xnor2_1
Xwire689 wire689/X wire689/A VDD VSS sg13g2_buf_4
X_10444_ _14837_/D _10444_/A _10444_/B _10444_/C VDD VSS sg13g2_and3_1
XFILLER_40_62 VDD VSS sg13g2_decap_4
XFILLER_124_623 VDD VSS sg13g2_decap_8
X_13163_ _13163_/Y _14822_/Q _13180_/A2 _13248_/B VDD VSS sg13g2_a21oi_1
X_10375_ _14816_/D _10375_/A _10375_/B _10496_/B VDD VSS sg13g2_and3_1
XFILLER_124_634 VDD VSS sg13g2_decap_8
XFILLER_156_95 VDD VSS sg13g2_decap_8
XFILLER_152_976 VDD VSS sg13g2_fill_1
X_12114_ _12114_/X _14708_/Q _14740_/Q _13780_/Q _13812_/Q _12090_/A _12114_/S1 VDD
+ VSS sg13g2_mux4_1
XFILLER_152_987 VDD VSS sg13g2_decap_8
XFILLER_3_964 VDD VSS sg13g2_decap_8
XFILLER_112_818 VDD VSS sg13g2_fill_1
X_13094_ _13094_/Y _14817_/Q _13180_/A2 _13094_/B1 _14849_/Q VDD VSS sg13g2_a22oi_1
XFILLER_46_1030 VDD VSS sg13g2_decap_8
XFILLER_46_1052 VDD VSS sg13g2_decap_8
X_12045_ _12046_/B _12034_/Y _12036_/X _12048_/A1 VDD VSS sg13g2_o21ai_1
Xfanout1710 _11787_/S0 fanout1713/X VDD VSS sg13g2_buf_1
Xfanout1721 fanout1721/X fanout1736/X VDD VSS sg13g2_buf_1
Xfanout1732 _11310_/A1 _11317_/A1 VDD VSS sg13g2_buf_1
XFILLER_77_231 VDD VSS sg13g2_decap_4
Xfanout1743 _11882_/S0 _11348_/A1 VDD VSS sg13g2_buf_1
XFILLER_46_1096 VDD VSS sg13g2_fill_1
Xfanout1754 _13239_/A _07625_/Y VDD VSS sg13g2_buf_1
XFILLER_78_776 VDD VSS sg13g2_decap_8
Xfanout1765 _10490_/A _13328_/A VDD VSS sg13g2_buf_1
XFILLER_120_873 VDD VSS sg13g2_fill_2
XFILLER_66_938 VDD VSS sg13g2_fill_2
Xfanout1776 _13499_/B _10256_/C VDD VSS sg13g2_buf_1
Xfanout1787 _10271_/B _10295_/C VDD VSS sg13g2_buf_1
XFILLER_1_56 VDD VSS sg13g2_decap_8
XFILLER_92_245 VDD VSS sg13g2_decap_8
X_13996_ _13996_/Q _14714_/CLK _13996_/D _13996_/RESET_B VDD VSS sg13g2_dfrbpq_1
XFILLER_46_662 VDD VSS sg13g2_fill_1
XFILLER_74_971 VDD VSS sg13g2_fill_2
X_12947_ _12947_/Y _14872_/Q _12963_/B VDD VSS sg13g2_nand2_1
XFILLER_19_898 VDD VSS sg13g2_decap_8
XFILLER_45_161 VDD VSS sg13g2_decap_8
XFILLER_73_470 VDD VSS sg13g2_decap_8
XFILLER_73_481 VDD VSS sg13g2_fill_2
XFILLER_73_492 VDD VSS sg13g2_fill_2
XFILLER_61_643 VDD VSS sg13g2_fill_1
X_12878_ _12878_/Y _12878_/A _12878_/B _12878_/C _13271_/C VDD VSS sg13g2_nand4_1
XFILLER_34_879 VDD VSS sg13g2_decap_4
XFILLER_33_378 VDD VSS sg13g2_fill_2
XFILLER_18_1121 VDD VSS sg13g2_decap_8
X_14617_ _14617_/Q _14745_/CLK _14617_/D _14617_/RESET_B VDD VSS sg13g2_dfrbpq_1
XFILLER_53_1012 VDD VSS sg13g2_decap_8
X_11829_ _11829_/X _11822_/B _11828_/X _11827_/Y VDD VSS sg13g2_a21o_1
XFILLER_92_1072 VDD VSS sg13g2_fill_1
XFILLER_42_890 VDD VSS sg13g2_decap_8
XFILLER_14_1007 VDD VSS sg13g2_decap_8
X_14548_ _14548_/Q clkload18/A _14548_/D _14548_/RESET_B VDD VSS sg13g2_dfrbpq_1
XFILLER_147_715 VDD VSS sg13g2_decap_4
XFILLER_14_1018 VDD VSS sg13g2_fill_1
XFILLER_146_214 VDD VSS sg13g2_decap_8
X_14822__3276 _14822_/RESET_B VDD VSS sg13g2_tiehi
XFILLER_18_1198 VDD VSS sg13g2_decap_8
XFILLER_105_1157 VDD VSS sg13g2_fill_1
X_14479_ _14479_/Q clkload12/A _14479_/D _14479_/RESET_B VDD VSS sg13g2_dfrbpq_1
XFILLER_146_247 VDD VSS sg13g2_decap_8
XFILLER_88_1119 VDD VSS sg13g2_fill_1
Xmax_cap1051 _12553_/S _12497_/S VDD VSS sg13g2_buf_4
X_14069__2495 _14069_/RESET_B VDD VSS sg13g2_tiehi
Xmax_cap1062 _12788_/S1 _12355_/S VDD VSS sg13g2_buf_4
Xmax_cap912 _07734_/A wire911/A VDD VSS sg13g2_buf_1
Xmax_cap923 _08201_/B _08032_/B VDD VSS sg13g2_buf_2
XFILLER_154_280 VDD VSS sg13g2_decap_8
XFILLER_114_111 VDD VSS sg13g2_fill_2
XFILLER_143_954 VDD VSS sg13g2_fill_1
XFILLER_115_667 VDD VSS sg13g2_fill_2
XFILLER_142_453 VDD VSS sg13g2_fill_2
XFILLER_46_0 VDD VSS sg13g2_decap_8
XFILLER_143_998 VDD VSS sg13g2_fill_2
X_15008__2964 _15008_/RESET_B VDD VSS sg13g2_tiehi
XFILLER_88_529 VDD VSS sg13g2_decap_8
X_08971_ _08971_/X _15022_/Q _15219_/Q _09085_/B VDD VSS sg13g2_mux2_1
XFILLER_142_497 VDD VSS sg13g2_decap_8
XFILLER_64_1152 VDD VSS sg13g2_decap_8
XFILLER_114_188 VDD VSS sg13g2_fill_1
X_07922_ _07922_/Y _07905_/A _07920_/Y _07910_/Y VDD VSS sg13g2_o21ai_1
XFILLER_114_199 VDD VSS sg13g2_fill_2
XFILLER_130_648 VDD VSS sg13g2_fill_2
X_14284__2280 _14284_/RESET_B VDD VSS sg13g2_tiehi
XFILLER_151_1133 VDD VSS sg13g2_decap_8
XFILLER_60_1027 VDD VSS sg13g2_decap_8
XFILLER_84_702 VDD VSS sg13g2_fill_1
X_07853_ _07855_/B _15015_/Q _07853_/B VDD VSS sg13g2_and2_1
XFILLER_25_1158 VDD VSS sg13g2_decap_8
X_07784_ _08414_/D _08411_/A _07784_/B VDD VSS sg13g2_or2_1
X_09523_ _14122_/D _09888_/A0 _14122_/Q _09523_/S VDD VSS sg13g2_mux2_1
XFILLER_65_971 VDD VSS sg13g2_decap_8
XFILLER_65_982 VDD VSS sg13g2_fill_2
XFILLER_37_684 VDD VSS sg13g2_fill_1
XFILLER_52_621 VDD VSS sg13g2_decap_8
X_09454_ _14055_/D _10083_/A0 _14055_/Q _09454_/S VDD VSS sg13g2_mux2_1
XFILLER_80_963 VDD VSS sg13g2_decap_4
X_08405_ _08406_/A _07794_/A _08405_/A1 _07825_/B _08427_/A1 _08559_/S1 _13550_/A1
+ VDD VSS sg13g2_mux4_1
XFILLER_80_985 VDD VSS sg13g2_decap_8
X_14508__2056 _14508_/RESET_B VDD VSS sg13g2_tiehi
X_09385_ _13988_/D _09616_/A0 _13988_/Q _09391_/S VDD VSS sg13g2_mux2_1
XFILLER_40_849 VDD VSS sg13g2_fill_2
XFILLER_61_28 VDD VSS sg13g2_decap_4
XFILLER_33_890 VDD VSS sg13g2_decap_8
X_08336_ _08336_/Y _08270_/B _08169_/Y _08241_/Y VDD VSS sg13g2_o21ai_1
XFILLER_71_1145 VDD VSS sg13g2_decap_4
XFILLER_123_1213 VDD VSS sg13g2_decap_8
XFILLER_71_1178 VDD VSS sg13g2_fill_2
X_08267_ _08268_/B _08266_/Y _08265_/X _08263_/Y _08264_/Y VDD VSS sg13g2_a22oi_1
XFILLER_124_7 VDD VSS sg13g2_decap_8
X_08198_ _08198_/X _08086_/B _08094_/X _08198_/S VDD VSS sg13g2_mux2_1
X_13734__2830 _13734_/RESET_B VDD VSS sg13g2_tiehi
XFILLER_3_205 VDD VSS sg13g2_decap_8
XFILLER_152_228 VDD VSS sg13g2_decap_8
XFILLER_4_739 VDD VSS sg13g2_fill_2
XFILLER_106_623 VDD VSS sg13g2_decap_8
XFILLER_10_21 VDD VSS sg13g2_decap_8
X_15089__3194 _15089_/RESET_B VDD VSS sg13g2_tiehi
XFILLER_79_507 VDD VSS sg13g2_decap_8
XFILLER_126_21 VDD VSS sg13g2_decap_8
XFILLER_121_604 VDD VSS sg13g2_fill_2
X_10160_ _14737_/D _14737_/Q _10160_/A1 _10160_/S VDD VSS sg13g2_mux2_1
XFILLER_126_32 VDD VSS sg13g2_fill_1
XFILLER_156_1077 VDD VSS sg13g2_fill_1
XFILLER_10_98 VDD VSS sg13g2_decap_4
Xfanout1006 _11172_/A _11185_/A VDD VSS sg13g2_buf_1
XFILLER_117_1039 VDD VSS sg13g2_fill_1
XFILLER_120_114 VDD VSS sg13g2_decap_4
XFILLER_105_199 VDD VSS sg13g2_fill_2
Xfanout1017 _08198_/S _08125_/S VDD VSS sg13g2_buf_1
X_10091_ _14671_/D _10091_/A0 _14671_/Q _10101_/S VDD VSS sg13g2_mux2_1
X_14114__2450 _14114_/RESET_B VDD VSS sg13g2_tiehi
Xfanout1028 _08452_/C _08374_/A VDD VSS sg13g2_buf_1
XFILLER_87_540 VDD VSS sg13g2_decap_4
XFILLER_102_840 VDD VSS sg13g2_decap_4
XFILLER_120_136 VDD VSS sg13g2_decap_4
Xfanout1039 _08548_/A _08649_/S VDD VSS sg13g2_buf_1
XFILLER_43_1236 VDD VSS sg13g2_fill_1
X_13767__2797 _13767_/RESET_B VDD VSS sg13g2_tiehi
X_15209__3362 _15209_/RESET_B VDD VSS sg13g2_tiehi
XFILLER_19_106 VDD VSS sg13g2_decap_8
XFILLER_47_415 VDD VSS sg13g2_decap_8
XFILLER_19_63 VDD VSS sg13g2_decap_8
XFILLER_142_42 VDD VSS sg13g2_decap_8
XFILLER_59_297 VDD VSS sg13g2_decap_8
X_14718__1846 _14718_/RESET_B VDD VSS sg13g2_tiehi
X_13850_ _13850_/Q clkload47/A _13850_/D _13850_/RESET_B VDD VSS sg13g2_dfrbpq_1
XFILLER_28_662 VDD VSS sg13g2_fill_2
XFILLER_74_267 VDD VSS sg13g2_decap_4
X_12801_ _12801_/Y _13609_/A _12801_/B VDD VSS sg13g2_nor2_1
XFILLER_28_673 VDD VSS sg13g2_decap_8
X_15043__2924 _15043_/RESET_B VDD VSS sg13g2_tiehi
X_10993_ _10996_/B wire385/X _10995_/C _10995_/B VDD VSS sg13g2_o21ai_1
X_13781_ _13781_/Q clkload14/A _13781_/D _13781_/RESET_B VDD VSS sg13g2_dfrbpq_1
XFILLER_16_835 VDD VSS sg13g2_decap_4
X_12732_ _12732_/X _12731_/X _12730_/X _12724_/X _12725_/X _12761_/S0 _12732_/S1 VDD
+ VSS sg13g2_mux4_1
X_13982__2582 _13982_/RESET_B VDD VSS sg13g2_tiehi
XFILLER_43_654 VDD VSS sg13g2_decap_8
XFILLER_150_0 VDD VSS sg13g2_decap_8
XFILLER_71_996 VDD VSS sg13g2_fill_2
XFILLER_70_473 VDD VSS sg13g2_decap_4
X_12663_ _12663_/X _12657_/X _12661_/X _12656_/X _12660_/X wire1073/X wire1090/X VDD
+ VSS sg13g2_mux4_1
XFILLER_128_1179 VDD VSS sg13g2_decap_8
X_14402_ _14402_/Q _14678_/CLK _14402_/D _14402_/RESET_B VDD VSS sg13g2_dfrbpq_1
XFILLER_30_348 VDD VSS sg13g2_fill_2
X_11614_ _11615_/A _14246_/Q _14278_/Q _14310_/Q _14342_/Q _11614_/S0 _11598_/C VDD
+ VSS sg13g2_mux4_1
XFILLER_50_1207 VDD VSS sg13g2_fill_2
X_14948__3033 _14948_/RESET_B VDD VSS sg13g2_tiehi
X_12594_ _12594_/X _12590_/X _12589_/X _12586_/X _12585_/X _12788_/S0 _12664_/S VDD
+ VSS sg13g2_mux4_1
XFILLER_156_534 VDD VSS sg13g2_fill_2
X_14333_ _14333_/Q clkload54/A _14333_/D _14333_/RESET_B VDD VSS sg13g2_dfrbpq_1
X_11545_ _11545_/Y _11555_/S0 _14468_/Q VDD VSS sg13g2_nand2b_1
XFILLER_51_83 VDD VSS sg13g2_decap_4
X_11476_ _11476_/X _11473_/X _11472_/X _11468_/X _11469_/X _11761_/C _12263_/C VDD
+ VSS sg13g2_mux4_1
XFILLER_13_1062 VDD VSS sg13g2_decap_8
X_14264_ _14264_/Q _14506_/CLK _14264_/D _14264_/RESET_B VDD VSS sg13g2_dfrbpq_1
XFILLER_7_599 VDD VSS sg13g2_decap_8
X_13215_ _13216_/B _13215_/A _13215_/B VDD VSS sg13g2_xnor2_1
X_10427_ _14831_/D _14831_/Q _10521_/C _10426_/Y VDD VSS sg13g2_a21oi_1
XFILLER_139_1220 VDD VSS sg13g2_decap_8
XFILLER_100_1054 VDD VSS sg13g2_fill_2
X_14195_ _14195_/Q clkload10/A _14195_/D _14195_/RESET_B VDD VSS sg13g2_dfrbpq_1
XFILLER_83_1016 VDD VSS sg13g2_fill_1
XFILLER_151_250 VDD VSS sg13g2_decap_4
XFILLER_135_1106 VDD VSS sg13g2_decap_4
X_10358_ _10400_/B _14809_/Q _14810_/Q _10358_/C VDD VSS sg13g2_nand3_1
XFILLER_48_1158 VDD VSS sg13g2_fill_1
X_13146_ _13148_/B _13146_/A _13146_/B _13146_/C VDD VSS sg13g2_nand3_1
XFILLER_97_315 VDD VSS sg13g2_decap_8
XFILLER_111_114 VDD VSS sg13g2_fill_1
XFILLER_2_282 VDD VSS sg13g2_decap_8
X_13077_ _13077_/X _14910_/Q _13677_/Q _13172_/B VDD VSS sg13g2_and3_1
X_10289_ _14790_/D _10281_/D _10298_/D _10284_/Y _10297_/A _10468_/A VDD VSS sg13g2_a221oi_1
XFILLER_97_359 VDD VSS sg13g2_decap_8
X_12028_ _12029_/A _13746_/Q _14098_/Q _14450_/Q _14546_/Q _12025_/A _12026_/C VDD
+ VSS sg13g2_mux4_1
Xfanout1540 _13613_/B _14747_/Q VDD VSS sg13g2_buf_1
XFILLER_39_949 VDD VSS sg13g2_decap_8
Xfanout1573 _13064_/B _13677_/Q VDD VSS sg13g2_buf_1
Xfanout1584 _12048_/A1 _11832_/C VDD VSS sg13g2_buf_1
XFILLER_4_1230 VDD VSS sg13g2_decap_8
Xfanout1595 _12333_/B1 _12291_/A VDD VSS sg13g2_buf_1
XFILLER_25_109 VDD VSS sg13g2_decap_8
XFILLER_20_1044 VDD VSS sg13g2_decap_8
XFILLER_81_738 VDD VSS sg13g2_fill_1
X_13979_ _13979_/Q clkload60/A _13979_/D _13979_/RESET_B VDD VSS sg13g2_dfrbpq_1
X_13812__2752 _13812_/RESET_B VDD VSS sg13g2_tiehi
XFILLER_62_952 VDD VSS sg13g2_decap_8
XFILLER_61_440 VDD VSS sg13g2_decap_8
X_14572__1992 _14572_/RESET_B VDD VSS sg13g2_tiehi
XFILLER_146_1235 VDD VSS sg13g2_fill_2
XFILLER_34_676 VDD VSS sg13g2_decap_4
XFILLER_61_495 VDD VSS sg13g2_decap_8
X_09170_ wire519/A _10137_/A _10137_/B _09938_/D VDD VSS sg13g2_nor3_2
X_14156__2408 _14156_/RESET_B VDD VSS sg13g2_tiehi
X_08121_ _08121_/X _08598_/A3 _08620_/A3 _07859_/B _08635_/A2 _08046_/B _08669_/B1
+ VDD VSS sg13g2_mux4_1
XFILLER_147_578 VDD VSS sg13g2_fill_1
X_08052_ _08052_/Y _08079_/S _08047_/Y _08048_/Y _08051_/Y VDD VSS sg13g2_a22oi_1
XFILLER_116_921 VDD VSS sg13g2_fill_1
XFILLER_128_781 VDD VSS sg13g2_decap_8
XFILLER_31_1195 VDD VSS sg13g2_decap_8
XFILLER_1_709 VDD VSS sg13g2_decap_8
Xmax_cap764 _09971_/B wire765/X VDD VSS sg13g2_buf_1
XFILLER_143_762 VDD VSS sg13g2_fill_1
XFILLER_66_1236 VDD VSS sg13g2_fill_1
X_15172__3338 _15172_/RESET_B VDD VSS sg13g2_tiehi
X_08954_ _08954_/X _15052_/Q _14956_/Q _08954_/S VDD VSS sg13g2_mux2_1
XFILLER_88_359 VDD VSS sg13g2_fill_1
XFILLER_103_659 VDD VSS sg13g2_fill_1
XFILLER_9_1141 VDD VSS sg13g2_decap_8
XFILLER_5_1005 VDD VSS sg13g2_fill_1
X_07905_ _07906_/C _07905_/A _07905_/B _07905_/C _07905_/D VDD VSS sg13g2_nor4_1
XFILLER_99_1001 VDD VSS sg13g2_decap_8
X_08885_ _08885_/Y _10725_/A _14939_/Q VDD VSS sg13g2_nand2_1
XFILLER_99_1012 VDD VSS sg13g2_fill_1
XFILLER_56_28 VDD VSS sg13g2_decap_8
XFILLER_69_595 VDD VSS sg13g2_fill_2
XFILLER_84_521 VDD VSS sg13g2_fill_2
XFILLER_5_1038 VDD VSS sg13g2_decap_8
XFILLER_57_746 VDD VSS sg13g2_decap_8
XFILLER_116_1094 VDD VSS sg13g2_decap_4
X_07836_ _08697_/B _15019_/Q _08673_/B VDD VSS sg13g2_nand2b_1
XFILLER_38_960 VDD VSS sg13g2_decap_8
XFILLER_99_1089 VDD VSS sg13g2_decap_8
X_07767_ _08265_/A _07768_/A _08263_/B VDD VSS sg13g2_nor2_1
XFILLER_72_738 VDD VSS sg13g2_fill_2
XFILLER_53_941 VDD VSS sg13g2_fill_1
X_09506_ _14106_/D _10102_/A0 _14106_/Q wire480/X VDD VSS sg13g2_mux2_1
XFILLER_71_259 VDD VSS sg13g2_decap_4
X_07698_ _07700_/B _15083_/Q _07701_/B VDD VSS sg13g2_nand2_1
XFILLER_112_89 VDD VSS sg13g2_fill_1
X_09437_ _14039_/D _09967_/A1 _14039_/Q _09437_/S VDD VSS sg13g2_mux2_1
XFILLER_9_809 VDD VSS sg13g2_decap_8
XFILLER_36_1051 VDD VSS sg13g2_fill_2
X_09368_ _13972_/D _10063_/A0 _13972_/Q _09368_/S VDD VSS sg13g2_mux2_1
XFILLER_36_1084 VDD VSS sg13g2_decap_4
XFILLER_123_1032 VDD VSS sg13g2_decap_8
X_08319_ _08420_/A _08319_/A _08319_/B _08319_/C VDD VSS sg13g2_nor3_1
X_09299_ _13907_/D _13907_/Q _09332_/A0 _09299_/S VDD VSS sg13g2_mux2_1
X_11330_ _11330_/X _11321_/Y _11329_/Y _11330_/S VDD VSS sg13g2_mux2_1
XFILLER_21_42 VDD VSS sg13g2_decap_8
XFILLER_10_1213 VDD VSS sg13g2_decap_8
XFILLER_153_548 VDD VSS sg13g2_decap_8
X_11261_ _11262_/A _11263_/A1 _13884_/Q VDD VSS sg13g2_nand2b_1
XFILLER_137_42 VDD VSS sg13g2_decap_8
X_10212_ _14763_/D _13499_/B wire847/A hold3425/X VDD VSS sg13g2_a21oi_1
X_13000_ _13000_/Y _14811_/Q _07728_/A _13150_/B _10511_/D VDD VSS sg13g2_a22oi_1
X_11192_ _11192_/X _11191_/Y _11189_/Y _11192_/B1 VDD VSS sg13g2_a21o_1
XFILLER_121_401 VDD VSS sg13g2_fill_2
XFILLER_122_946 VDD VSS sg13g2_decap_8
X_10143_ _14720_/D _14720_/Q _10143_/A1 _10168_/S VDD VSS sg13g2_mux2_1
XFILLER_121_434 VDD VSS sg13g2_decap_4
XFILLER_0_742 VDD VSS sg13g2_decap_4
XFILLER_79_359 VDD VSS sg13g2_decap_8
XFILLER_121_456 VDD VSS sg13g2_decap_4
XFILLER_88_871 VDD VSS sg13g2_decap_8
X_10074_ _14654_/D _10074_/A0 _14654_/Q _10093_/S VDD VSS sg13g2_mux2_1
XFILLER_0_775 VDD VSS sg13g2_fill_1
X_14951_ _14951_/Q _15046_/CLK _14951_/D _14951_/RESET_B VDD VSS sg13g2_dfrbpq_1
XFILLER_153_63 VDD VSS sg13g2_decap_8
XFILLER_48_724 VDD VSS sg13g2_decap_8
X_13902_ _13902_/Q _14670_/CLK _13902_/D _13902_/RESET_B VDD VSS sg13g2_dfrbpq_1
X_14882_ _14882_/Q clkload83/A _14882_/D _14882_/RESET_B VDD VSS sg13g2_dfrbpq_1
X_13833_ _13833_/Q clkload1/A _13833_/D _13833_/RESET_B VDD VSS sg13g2_dfrbpq_1
XFILLER_62_204 VDD VSS sg13g2_fill_2
XFILLER_28_470 VDD VSS sg13g2_fill_2
XFILLER_16_610 VDD VSS sg13g2_decap_8
XFILLER_46_72 VDD VSS sg13g2_fill_2
XFILLER_63_749 VDD VSS sg13g2_decap_8
X_13764_ _13764_/Q _14465_/CLK _13764_/D _13764_/RESET_B VDD VSS sg13g2_dfrbpq_1
XFILLER_15_131 VDD VSS sg13g2_fill_1
X_10976_ _11009_/B _14759_/Q _10967_/B _10942_/Y VDD VSS sg13g2_a21o_1
XFILLER_71_782 VDD VSS sg13g2_decap_4
X_12715_ _12715_/X _13973_/Q _14005_/Q _14037_/Q _14069_/Q _12715_/S0 _12770_/S1 VDD
+ VSS sg13g2_mux4_1
X_15155__3032 _15155_/RESET_B VDD VSS sg13g2_tiehi
X_13695_ _13695_/Q _14917_/CLK _13695_/D _13695_/RESET_B VDD VSS sg13g2_dfrbpq_1
XFILLER_30_112 VDD VSS sg13g2_decap_4
XFILLER_15_186 VDD VSS sg13g2_fill_1
X_12646_ _12646_/X _14128_/Q _14160_/Q _14192_/Q _14224_/Q _12646_/S0 _12647_/S1 VDD
+ VSS sg13g2_mux4_1
XFILLER_54_1162 VDD VSS sg13g2_decap_8
XFILLER_87_7 VDD VSS sg13g2_decap_4
XFILLER_15_1157 VDD VSS sg13g2_decap_8
X_12577_ _12577_/X _14379_/Q _14411_/Q _14475_/Q _14507_/Q _12773_/S0 _12773_/S1 VDD
+ VSS sg13g2_mux4_1
XFILLER_156_342 VDD VSS sg13g2_decap_4
XFILLER_11_381 VDD VSS sg13g2_decap_8
XFILLER_50_1059 VDD VSS sg13g2_decap_4
X_14316_ _14316_/Q clkload54/A _14316_/D _14316_/RESET_B VDD VSS sg13g2_dfrbpq_1
X_11528_ _11528_/X _14116_/Q _14148_/Q _11531_/A VDD VSS sg13g2_mux2_1
XFILLER_7_352 VDD VSS sg13g2_decap_8
XFILLER_7_77 VDD VSS sg13g2_decap_8
X_14247_ _14247_/Q _14725_/CLK _14247_/D _14247_/RESET_B VDD VSS sg13g2_dfrbpq_1
X_11459_ _11459_/Y _11457_/Y _11458_/Y _11451_/Y _11664_/A _11522_/A2 VDD VSS sg13g2_a221oi_1
XFILLER_131_209 VDD VSS sg13g2_decap_8
X_14178_ _14178_/Q clkload6/A _14178_/D _14178_/RESET_B VDD VSS sg13g2_dfrbpq_1
XFILLER_152_581 VDD VSS sg13g2_decap_8
XFILLER_113_946 VDD VSS sg13g2_fill_1
XFILLER_113_957 VDD VSS sg13g2_fill_1
XFILLER_124_283 VDD VSS sg13g2_decap_4
XFILLER_3_591 VDD VSS sg13g2_decap_4
XFILLER_97_134 VDD VSS sg13g2_fill_2
X_13129_ _13133_/C _14915_/Q _13130_/B VDD VSS sg13g2_xor2_1
XFILLER_98_657 VDD VSS sg13g2_decap_8
XFILLER_39_724 VDD VSS sg13g2_fill_2
XFILLER_78_370 VDD VSS sg13g2_fill_2
XFILLER_121_990 VDD VSS sg13g2_decap_8
Xfanout1370 _08200_/B _08025_/B VDD VSS sg13g2_buf_1
XFILLER_22_1128 VDD VSS sg13g2_decap_8
X_08670_ _08670_/Y _08080_/Y _08012_/Y _08010_/Y _08669_/Y _08402_/C VDD VSS sg13g2_a221oi_1
Xfanout1381 _08402_/A _08109_/A1 VDD VSS sg13g2_buf_1
Xfanout1392 _08054_/B _08598_/S0 VDD VSS sg13g2_buf_1
XFILLER_94_863 VDD VSS sg13g2_decap_8
XFILLER_38_256 VDD VSS sg13g2_fill_2
X_07621_ _07621_/Y _14868_/Q VDD VSS sg13g2_inv_1
XFILLER_93_384 VDD VSS sg13g2_fill_2
XFILLER_81_535 VDD VSS sg13g2_decap_8
XFILLER_50_900 VDD VSS sg13g2_decap_8
XFILLER_62_760 VDD VSS sg13g2_fill_1
XFILLER_50_911 VDD VSS sg13g2_decap_4
XFILLER_22_613 VDD VSS sg13g2_fill_1
XFILLER_22_624 VDD VSS sg13g2_decap_4
XFILLER_61_270 VDD VSS sg13g2_fill_1
XFILLER_21_112 VDD VSS sg13g2_fill_2
XFILLER_22_646 VDD VSS sg13g2_decap_4
XFILLER_146_1076 VDD VSS sg13g2_decap_8
XFILLER_139_309 VDD VSS sg13g2_decap_8
X_09222_ _13833_/D _10152_/A1 _13833_/Q _09236_/S VDD VSS sg13g2_mux2_1
XFILLER_146_1087 VDD VSS sg13g2_decap_8
XFILLER_148_810 VDD VSS sg13g2_decap_4
X_09153_ _13784_/D _13784_/Q _10100_/A0 _09153_/S VDD VSS sg13g2_mux2_1
X_15208__3361 _15208_/RESET_B VDD VSS sg13g2_tiehi
X_08104_ _08104_/Y _08463_/A _08201_/B _08104_/C _08104_/D VDD VSS sg13g2_nor4_1
XFILLER_147_353 VDD VSS sg13g2_fill_2
X_09084_ _13774_/D _13774_/Q _10157_/A1 _09084_/S VDD VSS sg13g2_mux2_1
XFILLER_148_898 VDD VSS sg13g2_decap_8
XFILLER_135_526 VDD VSS sg13g2_decap_4
X_08035_ _08035_/X _13533_/A _08659_/B VDD VSS sg13g2_or2_1
XFILLER_135_559 VDD VSS sg13g2_fill_1
XFILLER_104_902 VDD VSS sg13g2_fill_1
XFILLER_116_762 VDD VSS sg13g2_decap_8
Xmax_cap583 _10923_/A _10701_/Y VDD VSS sg13g2_buf_2
XFILLER_104_935 VDD VSS sg13g2_decap_8
X_14932__3065 _14932_/RESET_B VDD VSS sg13g2_tiehi
XFILLER_66_1055 VDD VSS sg13g2_fill_1
XFILLER_118_1134 VDD VSS sg13g2_fill_1
XFILLER_66_1077 VDD VSS sg13g2_decap_8
XFILLER_153_1036 VDD VSS sg13g2_fill_1
X_09986_ _14569_/D _10085_/A0 _14569_/Q _10000_/S VDD VSS sg13g2_mux2_1
XFILLER_130_264 VDD VSS sg13g2_fill_1
X_08937_ _08937_/X _08936_/X _12152_/A _08940_/S VDD VSS sg13g2_mux2_1
XFILLER_130_275 VDD VSS sg13g2_decap_8
XFILLER_40_1217 VDD VSS sg13g2_decap_8
X_08868_ _13700_/D _13700_/Q _08867_/X _08892_/S VDD VSS sg13g2_mux2_1
XFILLER_57_554 VDD VSS sg13g2_decap_8
XFILLER_84_340 VDD VSS sg13g2_decap_8
X_07819_ _07822_/A _15009_/Q _07819_/B VDD VSS sg13g2_nor2_1
X_14781__3317 _14781_/RESET_B VDD VSS sg13g2_tiehi
X_08799_ _13684_/D _08799_/A _08799_/B VDD VSS sg13g2_nor2_1
XFILLER_123_99 VDD VSS sg13g2_decap_8
X_10830_ _10830_/X _10831_/A _10831_/B _10831_/C VDD VSS sg13g2_a21o_1
XFILLER_16_42 VDD VSS sg13g2_decap_8
XFILLER_38_1113 VDD VSS sg13g2_decap_8
XFILLER_26_985 VDD VSS sg13g2_fill_1
X_15110__3124 _15110_/RESET_B VDD VSS sg13g2_tiehi
X_10761_ _14917_/D _11207_/B1 _11115_/A _10760_/Y VDD VSS sg13g2_o21ai_1
XFILLER_73_1026 VDD VSS sg13g2_fill_1
XFILLER_13_635 VDD VSS sg13g2_decap_8
XFILLER_12_112 VDD VSS sg13g2_decap_8
XFILLER_40_421 VDD VSS sg13g2_decap_8
XFILLER_80_590 VDD VSS sg13g2_decap_8
XFILLER_12_123 VDD VSS sg13g2_fill_2
X_12500_ _12513_/A _07625_/A _07737_/B hold3508/X VDD VSS sg13g2_a21oi_1
X_10692_ _10693_/A _14900_/Q _10929_/B _10939_/B1 _10870_/A VDD VSS sg13g2_a22oi_1
X_13480_ _15114_/D _15180_/D _15114_/Q _13499_/A VDD VSS sg13g2_mux2_1
XFILLER_8_105 VDD VSS sg13g2_decap_8
XFILLER_12_167 VDD VSS sg13g2_decap_8
XFILLER_139_843 VDD VSS sg13g2_decap_8
X_12431_ _12431_/X _14561_/Q _14593_/Q _14625_/Q _14657_/Q _12529_/S0 _12534_/S1 VDD
+ VSS sg13g2_mux4_1
XFILLER_40_487 VDD VSS sg13g2_fill_1
X_13908__2656 _13908_/RESET_B VDD VSS sg13g2_tiehi
X_14668__1896 _14668_/RESET_B VDD VSS sg13g2_tiehi
XFILLER_32_63 VDD VSS sg13g2_fill_1
X_15150_ _15150_/Q clkload26/A _15150_/D _15150_/RESET_B VDD VSS sg13g2_dfrbpq_1
X_12362_ _12362_/X _14364_/Q _14396_/Q _14460_/Q _14492_/Q _12368_/S0 _12368_/S1 VDD
+ VSS sg13g2_mux4_1
XFILLER_153_301 VDD VSS sg13g2_decap_8
XFILLER_148_63 VDD VSS sg13g2_decap_8
X_14101_ _14101_/Q _14671_/CLK _14101_/D _14101_/RESET_B VDD VSS sg13g2_dfrbpq_1
XFILLER_113_0 VDD VSS sg13g2_decap_8
XFILLER_126_537 VDD VSS sg13g2_fill_1
X_11313_ _11313_/Y _11313_/A1 _11301_/Y _11312_/Y VDD VSS sg13g2_o21ai_1
XFILLER_14_1190 VDD VSS sg13g2_decap_8
XFILLER_10_1021 VDD VSS sg13g2_decap_8
XFILLER_154_868 VDD VSS sg13g2_decap_8
X_12293_ wire297/A _11975_/A _12289_/X _12292_/Y VDD VSS sg13g2_o21ai_1
X_15081_ _15081_/Q clkload71/A _15081_/D _15081_/RESET_B VDD VSS sg13g2_dfrbpq_1
XFILLER_4_355 VDD VSS sg13g2_decap_8
XFILLER_5_878 VDD VSS sg13g2_decap_8
XFILLER_107_762 VDD VSS sg13g2_fill_2
X_11244_ _11245_/C _13296_/A1 _11236_/B _07687_/B VDD VSS sg13g2_a21oi_1
XFILLER_107_773 VDD VSS sg13g2_fill_2
X_14032_ _14032_/Q clkload49/A _14032_/D _14032_/RESET_B VDD VSS sg13g2_dfrbpq_1
XFILLER_136_1201 VDD VSS sg13g2_decap_8
XFILLER_10_1087 VDD VSS sg13g2_decap_8
XFILLER_106_261 VDD VSS sg13g2_decap_8
XFILLER_106_272 VDD VSS sg13g2_fill_2
XFILLER_122_721 VDD VSS sg13g2_decap_4
XFILLER_84_1166 VDD VSS sg13g2_fill_1
X_11175_ _11175_/Y _11164_/B _11164_/C _11172_/A VDD VSS sg13g2_a21oi_1
XFILLER_80_1008 VDD VSS sg13g2_fill_1
X_10126_ _14704_/D _10159_/A1 _14704_/Q _10135_/S VDD VSS sg13g2_mux2_1
XFILLER_95_638 VDD VSS sg13g2_decap_8
XFILLER_76_841 VDD VSS sg13g2_decap_8
X_10057_ _14638_/D _10090_/A0 _14638_/Q _10057_/S VDD VSS sg13g2_mux2_1
X_14934_ _14934_/Q _15229_/CLK _14934_/D _14934_/RESET_B VDD VSS sg13g2_dfrbpq_1
XFILLER_94_148 VDD VSS sg13g2_fill_2
X_14503__2061 _14503_/RESET_B VDD VSS sg13g2_tiehi
XFILLER_63_502 VDD VSS sg13g2_fill_2
XFILLER_75_362 VDD VSS sg13g2_decap_8
X_14865_ _14865_/Q clkload69/A _14865_/D _14865_/RESET_B VDD VSS sg13g2_dfrbpq_1
XFILLER_1_1233 VDD VSS sg13g2_decap_4
X_13816_ _13816_/Q clkload37/A _13816_/D _13816_/RESET_B VDD VSS sg13g2_dfrbpq_1
XFILLER_63_557 VDD VSS sg13g2_decap_8
XFILLER_91_877 VDD VSS sg13g2_decap_8
XFILLER_21_1194 VDD VSS sg13g2_decap_8
XFILLER_56_1202 VDD VSS sg13g2_fill_1
X_14796_ _14796_/Q _14873_/CLK _14796_/D _14796_/RESET_B VDD VSS sg13g2_dfrbpq_1
XFILLER_50_229 VDD VSS sg13g2_decap_4
X_13747_ _13747_/Q clkload11/A _13747_/D _13747_/RESET_B VDD VSS sg13g2_dfrbpq_1
X_10959_ _10959_/Y _10959_/A _10959_/B VDD VSS sg13g2_nand2_1
XFILLER_91_1137 VDD VSS sg13g2_decap_8
XFILLER_31_432 VDD VSS sg13g2_decap_4
XFILLER_143_1227 VDD VSS sg13g2_decap_8
X_13678_ _13678_/Q clkload65/A _13678_/D _13678_/RESET_B VDD VSS sg13g2_dfrbpq_1
XFILLER_148_128 VDD VSS sg13g2_fill_1
XFILLER_31_476 VDD VSS sg13g2_fill_2
XFILLER_148_139 VDD VSS sg13g2_fill_1
X_12629_ _12629_/X _14255_/Q _14287_/Q _14319_/Q _14351_/Q _12686_/S0 _12686_/S1 VDD
+ VSS sg13g2_mux4_1
XFILLER_129_331 VDD VSS sg13g2_decap_8
XFILLER_129_364 VDD VSS sg13g2_fill_2
XFILLER_156_150 VDD VSS sg13g2_decap_4
XFILLER_117_515 VDD VSS sg13g2_decap_8
XFILLER_144_312 VDD VSS sg13g2_fill_2
XFILLER_89_1055 VDD VSS sg13g2_decap_8
XFILLER_144_356 VDD VSS sg13g2_decap_8
XFILLER_144_367 VDD VSS sg13g2_fill_2
XFILLER_99_933 VDD VSS sg13g2_decap_8
X_14713__1851 _14713_/RESET_B VDD VSS sg13g2_tiehi
XFILLER_99_955 VDD VSS sg13g2_fill_2
X_09840_ _14427_/D _14427_/Q _10071_/A0 wire435/A VDD VSS sg13g2_mux2_1
XFILLER_63_1217 VDD VSS sg13g2_decap_8
XFILLER_140_540 VDD VSS sg13g2_decap_8
XFILLER_112_231 VDD VSS sg13g2_decap_8
XFILLER_98_487 VDD VSS sg13g2_fill_1
XFILLER_100_404 VDD VSS sg13g2_decap_8
X_09771_ _14361_/D _14361_/Q _10135_/A0 wire444/X VDD VSS sg13g2_mux2_1
XFILLER_26_1072 VDD VSS sg13g2_decap_8
X_08722_ _15214_/D _15193_/D _12347_/B _13653_/S VDD VSS sg13g2_mux2_1
XFILLER_6_1166 VDD VSS sg13g2_decap_8
XFILLER_39_565 VDD VSS sg13g2_decap_8
XFILLER_94_671 VDD VSS sg13g2_fill_1
XFILLER_67_896 VDD VSS sg13g2_decap_8
X_08653_ _08661_/B _08692_/A _08653_/B _15018_/Q VDD VSS sg13g2_nand3_1
XFILLER_82_844 VDD VSS sg13g2_fill_1
X_08584_ _08584_/Y _08584_/A _08608_/A VDD VSS sg13g2_nor2_1
XFILLER_42_719 VDD VSS sg13g2_decap_8
XFILLER_81_376 VDD VSS sg13g2_fill_1
XFILLER_41_218 VDD VSS sg13g2_decap_8
XFILLER_81_387 VDD VSS sg13g2_decap_8
XFILLER_50_730 VDD VSS sg13g2_decap_8
XFILLER_50_785 VDD VSS sg13g2_decap_8
XFILLER_139_139 VDD VSS sg13g2_fill_1
X_09205_ _09307_/B _09938_/A _09938_/B _10137_/A VDD VSS sg13g2_nand3b_1
XFILLER_33_1021 VDD VSS sg13g2_fill_2
XFILLER_22_498 VDD VSS sg13g2_decap_8
XFILLER_148_673 VDD VSS sg13g2_fill_1
XFILLER_33_1065 VDD VSS sg13g2_decap_4
X_09136_ _09137_/C _13142_/A _09136_/B _09150_/C _09164_/C VDD VSS sg13g2_and4_1
XFILLER_135_312 VDD VSS sg13g2_fill_1
XFILLER_5_119 VDD VSS sg13g2_decap_8
X_14545__2019 _14545_/RESET_B VDD VSS sg13g2_tiehi
XFILLER_136_846 VDD VSS sg13g2_decap_4
X_09067_ _09069_/B _13064_/A _09089_/C _14911_/Q VDD VSS sg13g2_a21oi_1
XFILLER_135_345 VDD VSS sg13g2_fill_1
Xclkbuf_4_5_0_clk_i clkbuf_4_5_0_clk_i/X clkbuf_0_clk_i/X VDD VSS sg13g2_buf_8
XFILLER_150_304 VDD VSS sg13g2_fill_2
X_08018_ _08018_/X _07786_/A _07782_/A _08427_/A1 _08383_/A _08327_/S0 _08099_/S0
+ VDD VSS sg13g2_mux4_1
XFILLER_104_710 VDD VSS sg13g2_fill_1
XFILLER_118_77 VDD VSS sg13g2_decap_8
XFILLER_150_337 VDD VSS sg13g2_decap_8
Xmax_cap391 _10166_/S _10150_/S VDD VSS sg13g2_buf_4
XFILLER_103_220 VDD VSS sg13g2_decap_8
XFILLER_89_454 VDD VSS sg13g2_fill_2
XFILLER_134_21 VDD VSS sg13g2_decap_8
X_09969_ _14553_/D _14553_/Q _10068_/A0 _09969_/S VDD VSS sg13g2_mux2_1
XFILLER_58_841 VDD VSS sg13g2_decap_8
XFILLER_94_14 VDD VSS sg13g2_decap_8
XFILLER_57_340 VDD VSS sg13g2_decap_8
X_12980_ _12980_/Y _13045_/A1 _12884_/C input6/X VDD VSS sg13g2_a21oi_1
XFILLER_92_619 VDD VSS sg13g2_decap_8
XFILLER_91_107 VDD VSS sg13g2_decap_8
XFILLER_85_671 VDD VSS sg13g2_fill_1
XFILLER_85_682 VDD VSS sg13g2_decap_8
X_11931_ _11931_/Y _14914_/Q _11792_/B _12051_/A1 VDD VSS sg13g2_a21oi_1
XFILLER_17_215 VDD VSS sg13g2_decap_8
XFILLER_45_535 VDD VSS sg13g2_decap_8
XFILLER_72_321 VDD VSS sg13g2_decap_8
XFILLER_73_855 VDD VSS sg13g2_fill_1
XFILLER_150_42 VDD VSS sg13g2_decap_8
X_14151__2413 _14151_/RESET_B VDD VSS sg13g2_tiehi
XFILLER_73_866 VDD VSS sg13g2_fill_1
X_14650_ _14650_/Q clkload58/A _14650_/D _14650_/RESET_B VDD VSS sg13g2_dfrbpq_1
X_11862_ _14975_/D _11843_/A _12271_/A _11861_/Y VDD VSS sg13g2_a21o_1
XFILLER_27_96 VDD VSS sg13g2_decap_8
XFILLER_73_888 VDD VSS sg13g2_decap_4
XFILLER_60_516 VDD VSS sg13g2_decap_8
XFILLER_14_911 VDD VSS sg13g2_fill_2
X_13601_ _13609_/B _13601_/A _13601_/B VDD VSS sg13g2_nor2_1
X_10813_ _10851_/A _10813_/A _10818_/B VDD VSS sg13g2_nor2_1
X_14581_ _14581_/Q clkload43/A _14581_/D _14581_/RESET_B VDD VSS sg13g2_dfrbpq_1
X_11793_ _11793_/Y _11425_/B _11791_/X _12051_/A1 VDD VSS sg13g2_a21oi_1
XFILLER_13_443 VDD VSS sg13g2_decap_8
X_13532_ _15143_/D _13568_/S _13530_/Y _13531_/Y VDD VSS sg13g2_a21oi_1
X_10744_ wire577/A _10735_/A _09086_/Y _08913_/Y VDD VSS sg13g2_o21ai_1
XFILLER_13_465 VDD VSS sg13g2_decap_8
X_13463_ _13463_/X _15191_/Q _13463_/B _15192_/Q _13463_/D VDD VSS sg13g2_or4_1
X_10675_ _10805_/C _10675_/A _10675_/B _10675_/C VDD VSS sg13g2_nor3_1
XFILLER_103_1200 VDD VSS sg13g2_decap_8
X_15202_ _15202_/Q clkload69/A _15202_/D _15202_/RESET_B VDD VSS sg13g2_dfrbpq_1
XFILLER_139_673 VDD VSS sg13g2_decap_4
X_12414_ _12415_/B _12413_/X _12412_/X _12595_/S VDD VSS sg13g2_mux2_1
XFILLER_154_610 VDD VSS sg13g2_fill_1
XFILLER_12_1116 VDD VSS sg13g2_decap_8
X_13394_ _15085_/D _13455_/A _13391_/C _13393_/Y VDD VSS sg13g2_o21ai_1
XFILLER_127_835 VDD VSS sg13g2_decap_8
XFILLER_154_621 VDD VSS sg13g2_fill_2
X_15133_ _15133_/Q clkload26/A _15133_/D _15133_/RESET_B VDD VSS sg13g2_dfrbpq_1
X_12345_ _12345_/X _13723_/Q _14075_/Q _14427_/Q _14523_/Q _12366_/S0 _12366_/S1 VDD
+ VSS sg13g2_mux4_1
XFILLER_142_805 VDD VSS sg13g2_decap_4
XFILLER_154_665 VDD VSS sg13g2_fill_1
XFILLER_99_218 VDD VSS sg13g2_fill_1
XFILLER_154_698 VDD VSS sg13g2_fill_2
X_15064_ _15064_/Q clkload74/A _15064_/D _15064_/RESET_B VDD VSS sg13g2_dfrbpq_1
XFILLER_153_175 VDD VSS sg13g2_decap_8
XFILLER_4_163 VDD VSS sg13g2_decap_4
X_12276_ wire147/A _12273_/Y _12204_/A _12275_/Y VDD VSS sg13g2_o21ai_1
XFILLER_135_890 VDD VSS sg13g2_fill_2
XFILLER_5_697 VDD VSS sg13g2_fill_1
XFILLER_4_185 VDD VSS sg13g2_decap_4
X_14015_ _14015_/Q _14509_/CLK _14015_/D _14015_/RESET_B VDD VSS sg13g2_dfrbpq_1
XFILLER_4_56 VDD VSS sg13g2_decap_8
X_11227_ _11227_/X _11225_/X _11226_/X _11227_/S VDD VSS sg13g2_mux2_1
XFILLER_122_551 VDD VSS sg13g2_decap_4
X_11158_ _11158_/Y _11144_/Y _11151_/B _11173_/C VDD VSS sg13g2_o21ai_1
XFILLER_67_115 VDD VSS sg13g2_fill_2
XFILLER_68_638 VDD VSS sg13g2_decap_4
XFILLER_136_1097 VDD VSS sg13g2_decap_8
XFILLER_110_746 VDD VSS sg13g2_decap_8
X_10109_ _14687_/D _10142_/A1 _14687_/Q _10127_/S VDD VSS sg13g2_mux2_1
X_11089_ _11091_/B _11086_/A _10754_/X _11058_/Y VDD VSS sg13g2_a21oi_1
XFILLER_95_479 VDD VSS sg13g2_decap_8
X_15207__3360 _15207_/RESET_B VDD VSS sg13g2_tiehi
XFILLER_110_779 VDD VSS sg13g2_fill_2
XFILLER_49_896 VDD VSS sg13g2_decap_4
X_14917_ _14917_/Q _14917_/CLK _14917_/D _14917_/RESET_B VDD VSS sg13g2_dfrbpq_1
XFILLER_82_129 VDD VSS sg13g2_decap_8
XFILLER_91_641 VDD VSS sg13g2_fill_1
XFILLER_1_1030 VDD VSS sg13g2_decap_4
X_14848_ _14848_/Q _14854_/CLK _14848_/D _14848_/RESET_B VDD VSS sg13g2_dfrbpq_1
XFILLER_51_527 VDD VSS sg13g2_fill_1
X_14779_ _14779_/Q clkload81/A _14779_/D _14779_/RESET_B VDD VSS sg13g2_dfrbpq_1
XFILLER_143_1013 VDD VSS sg13g2_decap_4
XFILLER_31_240 VDD VSS sg13g2_decap_4
XFILLER_143_1046 VDD VSS sg13g2_decap_4
XFILLER_20_925 VDD VSS sg13g2_fill_1
XFILLER_31_273 VDD VSS sg13g2_decap_8
XFILLER_31_284 VDD VSS sg13g2_fill_2
XFILLER_118_802 VDD VSS sg13g2_decap_8
XFILLER_76_0 VDD VSS sg13g2_decap_8
XFILLER_9_992 VDD VSS sg13g2_decap_8
XFILLER_129_172 VDD VSS sg13g2_decap_8
XFILLER_105_507 VDD VSS sg13g2_decap_8
XFILLER_132_337 VDD VSS sg13g2_fill_1
XFILLER_28_1101 VDD VSS sg13g2_decap_8
XFILLER_154_1120 VDD VSS sg13g2_decap_8
XFILLER_87_914 VDD VSS sg13g2_fill_1
Xfanout415 _09970_/S wire418/A VDD VSS sg13g2_buf_1
X_15081__3216 _15081_/RESET_B VDD VSS sg13g2_tiehi
Xfanout426 _09907_/S _09905_/X VDD VSS sg13g2_buf_1
XFILLER_98_273 VDD VSS sg13g2_fill_2
X_09823_ _14411_/D _09922_/A1 _14411_/Q _09838_/S VDD VSS sg13g2_mux2_1
XFILLER_115_1115 VDD VSS sg13g2_decap_8
XFILLER_140_370 VDD VSS sg13g2_decap_4
XFILLER_28_1178 VDD VSS sg13g2_decap_8
Xfanout448 wire449/A _09707_/X VDD VSS sg13g2_buf_1
XFILLER_101_724 VDD VSS sg13g2_fill_1
Xfanout459 _09679_/S _09694_/S VDD VSS sg13g2_buf_1
XFILLER_154_1197 VDD VSS sg13g2_decap_8
XFILLER_101_757 VDD VSS sg13g2_fill_1
XFILLER_115_1148 VDD VSS sg13g2_decap_8
X_09754_ _14344_/D _14344_/Q _09787_/A0 _09770_/S VDD VSS sg13g2_mux2_1
XFILLER_55_800 VDD VSS sg13g2_fill_2
XFILLER_104_35 VDD VSS sg13g2_decap_8
X_08705_ _15185_/D hold3445/X _15185_/Q _13333_/S VDD VSS sg13g2_mux2_1
X_09685_ _14277_/D _09916_/A1 _14277_/Q wire456/X VDD VSS sg13g2_mux2_1
XFILLER_27_535 VDD VSS sg13g2_decap_4
XFILLER_27_557 VDD VSS sg13g2_decap_8
X_08636_ _08637_/A _08406_/A _08488_/B _08560_/C _08635_/X _08488_/A _08329_/B VDD
+ VSS sg13g2_mux4_1
XFILLER_42_527 VDD VSS sg13g2_decap_8
X_08567_ _08567_/X _08567_/A _08567_/B _08567_/C VDD VSS sg13g2_or3_1
XFILLER_154_7 VDD VSS sg13g2_decap_8
XFILLER_35_1105 VDD VSS sg13g2_fill_1
XFILLER_126_1233 VDD VSS sg13g2_decap_4
XFILLER_11_914 VDD VSS sg13g2_decap_8
XFILLER_50_560 VDD VSS sg13g2_decap_8
XFILLER_70_1007 VDD VSS sg13g2_decap_4
X_08498_ _08498_/Y _08497_/A _08495_/Y _08497_/Y VDD VSS sg13g2_o21ai_1
XFILLER_10_402 VDD VSS sg13g2_fill_2
XFILLER_70_1029 VDD VSS sg13g2_decap_8
XFILLER_80_49 VDD VSS sg13g2_decap_8
XFILLER_23_796 VDD VSS sg13g2_decap_8
XFILLER_22_273 VDD VSS sg13g2_fill_2
XFILLER_156_919 VDD VSS sg13g2_fill_1
XFILLER_13_21 VDD VSS sg13g2_decap_8
XFILLER_155_418 VDD VSS sg13g2_decap_8
XFILLER_129_21 VDD VSS sg13g2_decap_8
X_10460_ _14842_/D _10460_/A _10468_/A _10460_/C VDD VSS sg13g2_nor3_1
XFILLER_109_835 VDD VSS sg13g2_decap_8
XFILLER_148_481 VDD VSS sg13g2_decap_8
XFILLER_109_846 VDD VSS sg13g2_decap_4
XFILLER_148_492 VDD VSS sg13g2_decap_8
XFILLER_13_98 VDD VSS sg13g2_decap_8
XFILLER_89_14 VDD VSS sg13g2_decap_8
X_09119_ _13779_/D _13779_/Q _10062_/A0 _09127_/S VDD VSS sg13g2_mux2_1
X_10391_ _10392_/A _14820_/Q _14821_/Q _10391_/C _10398_/D VDD VSS sg13g2_nand4_1
XFILLER_89_58 VDD VSS sg13g2_decap_8
X_12130_ _12132_/B _12065_/B _12198_/C _12198_/A VDD VSS sg13g2_a21oi_1
XFILLER_151_624 VDD VSS sg13g2_decap_8
XFILLER_11_1182 VDD VSS sg13g2_decap_8
XFILLER_150_112 VDD VSS sg13g2_decap_8
XFILLER_117_890 VDD VSS sg13g2_decap_8
XFILLER_145_42 VDD VSS sg13g2_decap_8
X_12061_ _12197_/A _12061_/A _13189_/B VDD VSS sg13g2_xnor2_1
XFILLER_81_1136 VDD VSS sg13g2_fill_2
XFILLER_89_262 VDD VSS sg13g2_decap_8
X_11012_ _11014_/B _11064_/A _11012_/B _11012_/C VDD VSS sg13g2_nor3_1
XFILLER_1_188 VDD VSS sg13g2_decap_8
XFILLER_81_1169 VDD VSS sg13g2_fill_1
XFILLER_1_199 VDD VSS sg13g2_decap_8
Xfanout971 _11696_/B _12246_/B VDD VSS sg13g2_buf_1
XFILLER_93_917 VDD VSS sg13g2_decap_8
Xfanout982 _12317_/B _12324_/B VDD VSS sg13g2_buf_1
XFILLER_46_800 VDD VSS sg13g2_fill_1
Xfanout993 _12023_/B _12328_/B1 VDD VSS sg13g2_buf_1
XFILLER_18_513 VDD VSS sg13g2_decap_8
XFILLER_46_822 VDD VSS sg13g2_decap_8
XFILLER_79_1010 VDD VSS sg13g2_decap_4
X_12963_ _12963_/Y _12963_/A _12963_/B VDD VSS sg13g2_nand2_1
XFILLER_79_1043 VDD VSS sg13g2_fill_1
X_14702_ _14702_/Q _14763_/CLK _14702_/D _14702_/RESET_B VDD VSS sg13g2_dfrbpq_1
XFILLER_57_192 VDD VSS sg13g2_decap_8
XFILLER_73_652 VDD VSS sg13g2_decap_8
X_11914_ _11915_/A _11914_/A _13673_/Q VDD VSS sg13g2_xor2_1
XFILLER_61_803 VDD VSS sg13g2_decap_8
X_12894_ _12894_/X _12894_/A _12894_/B VDD VSS sg13g2_xor2_1
XFILLER_72_151 VDD VSS sg13g2_decap_8
X_14633_ _14633_/Q _14633_/CLK _14633_/D _14633_/RESET_B VDD VSS sg13g2_dfrbpq_1
X_11845_ _11867_/B _11907_/A _11910_/B _11845_/C VDD VSS sg13g2_or3_1
XFILLER_14_730 VDD VSS sg13g2_fill_1
XFILLER_54_83 VDD VSS sg13g2_fill_2
X_14564_ _14564_/Q clkload36/A _14564_/D _14564_/RESET_B VDD VSS sg13g2_dfrbpq_1
X_11776_ _11777_/B _11776_/A _11776_/B VDD VSS sg13g2_nand2_1
X_13515_ _15138_/D _15138_/Q _14995_/Q _13539_/B VDD VSS sg13g2_mux2_1
XFILLER_147_908 VDD VSS sg13g2_decap_8
XFILLER_13_284 VDD VSS sg13g2_fill_2
X_10727_ _10727_/Y _14909_/Q _10973_/B VDD VSS sg13g2_nand2_1
X_14495_ _14495_/Q clkload51/A _14495_/D _14495_/RESET_B VDD VSS sg13g2_dfrbpq_1
X_13446_ _13446_/Y _13465_/A1 _08723_/B hold3511/X VDD VSS sg13g2_o21ai_1
X_10658_ _14891_/D _13507_/A _10658_/B _10666_/D VDD VSS sg13g2_nor3_1
Xclkload14 clkload14/Y clkload14/A VDD VSS sg13g2_inv_1
Xclkload25 clkload25/Y clkload25/A VDD VSS sg13g2_inv_1
Xclkload36 clkload36/Y clkload36/A VDD VSS sg13g2_inv_1
X_13377_ _15078_/D _15078_/Q _13427_/A _13376_/Y VDD VSS sg13g2_a21o_1
Xclkload47 clkload47/Y clkload47/A VDD VSS sg13g2_inv_1
XFILLER_115_805 VDD VSS sg13g2_fill_2
X_10589_ _10592_/B _12963_/A _10594_/D _14874_/Q VDD VSS sg13g2_a21oi_1
Xclkload58 clkload58/Y clkload58/A VDD VSS sg13g2_inv_1
Xclkload69 clkload69/Y clkload69/A VDD VSS sg13g2_inv_1
XFILLER_154_473 VDD VSS sg13g2_decap_8
X_15116_ _15116_/Q _15188_/CLK _15116_/D _15116_/RESET_B VDD VSS sg13g2_dfrbpq_1
XFILLER_86_1047 VDD VSS sg13g2_fill_2
X_12328_ _12328_/Y _12328_/A1 _13946_/Q _12328_/B1 VDD VSS sg13g2_a21oi_1
XFILLER_115_838 VDD VSS sg13g2_fill_1
XFILLER_138_1126 VDD VSS sg13g2_fill_1
XFILLER_141_112 VDD VSS sg13g2_decap_8
X_15047_ _15047_/Q _15248_/CLK _15047_/D _15047_/RESET_B VDD VSS sg13g2_dfrbpq_1
X_12259_ _12259_/X _14712_/Q _14744_/Q _13784_/Q _13816_/Q _12259_/S0 _12259_/S1 VDD
+ VSS sg13g2_mux4_1
XFILLER_69_936 VDD VSS sg13g2_decap_4
XFILLER_123_893 VDD VSS sg13g2_decap_8
Xclkbuf_0_clk_i clkbuf_0_clk_i/X clk_i VDD VSS sg13g2_buf_16
XFILLER_84_906 VDD VSS sg13g2_decap_4
XFILLER_68_479 VDD VSS sg13g2_decap_8
XFILLER_96_788 VDD VSS sg13g2_decap_8
XFILLER_55_107 VDD VSS sg13g2_decap_8
XFILLER_83_416 VDD VSS sg13g2_decap_8
XFILLER_23_1042 VDD VSS sg13g2_decap_8
XFILLER_83_427 VDD VSS sg13g2_fill_1
XFILLER_95_287 VDD VSS sg13g2_fill_1
XFILLER_3_1125 VDD VSS sg13g2_decap_8
XFILLER_97_1110 VDD VSS sg13g2_decap_8
XFILLER_149_1200 VDD VSS sg13g2_decap_8
X_09470_ _14071_/D _09967_/A1 _14071_/Q _09470_/S VDD VSS sg13g2_mux2_1
X_13903__2661 _13903_/RESET_B VDD VSS sg13g2_tiehi
XFILLER_93_1018 VDD VSS sg13g2_decap_4
XFILLER_110_1078 VDD VSS sg13g2_decap_8
X_08421_ wire232/A _08419_/Y _08420_/A _08417_/Y VDD VSS sg13g2_o21ai_1
XFILLER_52_869 VDD VSS sg13g2_decap_8
X_08352_ _08353_/B _08352_/A _08352_/B _08369_/B VDD VSS sg13g2_nand3_1
X_14247__2317 _14247_/RESET_B VDD VSS sg13g2_tiehi
XFILLER_32_593 VDD VSS sg13g2_fill_1
X_08283_ _08283_/Y _08539_/B1 _08282_/Y _08277_/Y VDD VSS sg13g2_o21ai_1
Xclkload8 clkload8/Y clkload8/A VDD VSS sg13g2_inv_4
XFILLER_137_418 VDD VSS sg13g2_fill_1
XFILLER_109_109 VDD VSS sg13g2_decap_8
XFILLER_34_1160 VDD VSS sg13g2_fill_2
XFILLER_34_1171 VDD VSS sg13g2_decap_8
XFILLER_30_1002 VDD VSS sg13g2_decap_8
XFILLER_146_952 VDD VSS sg13g2_decap_8
XFILLER_121_1152 VDD VSS sg13g2_fill_1
XFILLER_118_665 VDD VSS sg13g2_decap_8
X_14462__2102 _14462_/RESET_B VDD VSS sg13g2_tiehi
XFILLER_145_473 VDD VSS sg13g2_fill_1
XFILLER_132_112 VDD VSS sg13g2_fill_2
XFILLER_117_197 VDD VSS sg13g2_decap_8
XFILLER_59_28 VDD VSS sg13g2_decap_4
Xfanout201 _10158_/A1 fanout204/X VDD VSS sg13g2_buf_1
Xfanout223 _10157_/A1 _09991_/A0 VDD VSS sg13g2_buf_1
XFILLER_8_1025 VDD VSS sg13g2_fill_1
XFILLER_86_210 VDD VSS sg13g2_fill_2
XFILLER_141_690 VDD VSS sg13g2_decap_4
Xfanout245 _09923_/A1 wire246/X VDD VSS sg13g2_buf_1
Xfanout267 _09920_/A1 wire268/X VDD VSS sg13g2_buf_1
X_09806_ wire624/A _09806_/A _09806_/B _10004_/C _09806_/D VDD VSS sg13g2_nand4_1
XFILLER_8_1069 VDD VSS sg13g2_decap_8
Xfanout278 _11248_/B _11247_/X VDD VSS sg13g2_buf_1
XFILLER_115_67 VDD VSS sg13g2_decap_4
Xfanout289 _09918_/A1 _10117_/A0 VDD VSS sg13g2_buf_1
X_07998_ _07998_/X _15103_/Q _15090_/Q VDD VSS sg13g2_or2_1
XFILLER_74_405 VDD VSS sg13g2_fill_2
X_14495__2069 _14495_/RESET_B VDD VSS sg13g2_tiehi
XFILLER_41_1131 VDD VSS sg13g2_decap_4
XFILLER_87_799 VDD VSS sg13g2_decap_8
XFILLER_28_822 VDD VSS sg13g2_fill_2
X_09737_ _14328_/D _09836_/A0 _14328_/Q _09737_/S VDD VSS sg13g2_mux2_1
XFILLER_27_321 VDD VSS sg13g2_decap_8
X_09668_ _14261_/D _09899_/A0 _14261_/Q wire641/X VDD VSS sg13g2_mux2_1
XFILLER_55_674 VDD VSS sg13g2_fill_1
XFILLER_28_899 VDD VSS sg13g2_fill_2
XFILLER_83_994 VDD VSS sg13g2_decap_8
X_08619_ _08619_/Y _08054_/B _07849_/B _08053_/Y VDD VSS sg13g2_o21ai_1
XFILLER_131_77 VDD VSS sg13g2_decap_8
XFILLER_70_633 VDD VSS sg13g2_decap_4
X_09599_ _14196_/D _14196_/Q _10163_/A1 _09599_/S VDD VSS sg13g2_mux2_1
XFILLER_91_48 VDD VSS sg13g2_decap_8
XFILLER_131_99 VDD VSS sg13g2_decap_8
X_11630_ _11630_/Y _12156_/A _11629_/Y _12227_/B VDD VSS sg13g2_o21ai_1
XFILLER_24_42 VDD VSS sg13g2_decap_8
XFILLER_42_379 VDD VSS sg13g2_fill_2
XFILLER_51_880 VDD VSS sg13g2_fill_1
X_11561_ _11561_/Y _11556_/X _11747_/A _12263_/C VDD VSS sg13g2_a21oi_1
XFILLER_11_733 VDD VSS sg13g2_decap_8
XFILLER_126_1063 VDD VSS sg13g2_decap_4
Xwire613 wire613/X wire613/A VDD VSS sg13g2_buf_8
X_13300_ _13300_/Y _13308_/A _13308_/B _13300_/C _13312_/A VDD VSS sg13g2_nor4_1
X_10512_ _10514_/B _10512_/A _10512_/B _10512_/C VDD VSS sg13g2_nor3_1
Xwire624 wire624/X wire624/A VDD VSS sg13g2_buf_2
X_14280_ _14280_/Q _14465_/CLK _14280_/D _14280_/RESET_B VDD VSS sg13g2_dfrbpq_1
Xwire635 wire635/X wire635/A VDD VSS sg13g2_buf_2
X_11492_ _11492_/X _14114_/Q _14146_/Q _14178_/Q _14210_/Q _11493_/S0 _11493_/S1 VDD
+ VSS sg13g2_mux4_1
XFILLER_6_225 VDD VSS sg13g2_decap_8
X_13231_ _13242_/A _13232_/A _13244_/B VDD VSS sg13g2_nand2b_1
XFILLER_155_259 VDD VSS sg13g2_decap_8
X_10443_ _10444_/B _14837_/Q _14836_/Q _14835_/Q _10443_/D VDD VSS sg13g2_nand4_1
XFILLER_136_451 VDD VSS sg13g2_fill_1
XFILLER_151_410 VDD VSS sg13g2_fill_1
X_13162_ _13162_/Y _14854_/Q _13162_/A2 _13162_/B1 _14886_/Q VDD VSS sg13g2_a22oi_1
XFILLER_3_921 VDD VSS sg13g2_decap_8
XFILLER_156_63 VDD VSS sg13g2_decap_8
X_10374_ _10375_/B _14815_/Q _14816_/Q _10385_/C VDD VSS sg13g2_nand3_1
X_13945__2619 _13945_/RESET_B VDD VSS sg13g2_tiehi
XFILLER_156_85 VDD VSS sg13g2_decap_4
XFILLER_3_943 VDD VSS sg13g2_decap_8
XFILLER_152_966 VDD VSS sg13g2_fill_1
X_12113_ _12113_/Y _12109_/Y _12110_/Y _12112_/Y _12111_/Y _12113_/C1 VDD VSS sg13g2_a221oi_1
XFILLER_6_0 VDD VSS sg13g2_decap_8
X_13093_ _13093_/Y _13091_/Y _13093_/B _13160_/B VDD VSS sg13g2_nand3b_1
XFILLER_2_453 VDD VSS sg13g2_decap_8
Xfanout1700 _11695_/S0 fanout1705/X VDD VSS sg13g2_buf_1
X_12044_ _12044_/Y _12019_/Y _12021_/Y _12048_/A1 VDD VSS sg13g2_a21oi_1
XFILLER_123_189 VDD VSS sg13g2_decap_8
XFILLER_104_370 VDD VSS sg13g2_fill_2
Xfanout1722 _11992_/S0 _11995_/S0 VDD VSS sg13g2_buf_1
Xfanout1733 _11300_/S0 _11317_/A1 VDD VSS sg13g2_buf_1
Xfanout1744 _11348_/A1 _12306_/A VDD VSS sg13g2_buf_1
Xfanout1755 _12984_/A fanout1770/A VDD VSS sg13g2_buf_1
Xfanout1766 _10595_/B _10623_/A VDD VSS sg13g2_buf_1
Xfanout1777 _10671_/B _13302_/C VDD VSS sg13g2_buf_1
X_14325__2239 _14325_/RESET_B VDD VSS sg13g2_tiehi
Xfanout1788 _10295_/C _10350_/C VDD VSS sg13g2_buf_1
XFILLER_1_35 VDD VSS sg13g2_decap_8
Xfanout790 _08787_/B _13481_/C VDD VSS sg13g2_buf_1
XFILLER_133_1089 VDD VSS sg13g2_decap_8
XFILLER_92_213 VDD VSS sg13g2_fill_1
X_13995_ _13995_/Q _14745_/CLK _13995_/D _13995_/RESET_B VDD VSS sg13g2_dfrbpq_1
XFILLER_20_1226 VDD VSS sg13g2_decap_8
XFILLER_18_332 VDD VSS sg13g2_fill_1
XFILLER_74_961 VDD VSS sg13g2_decap_8
XFILLER_18_354 VDD VSS sg13g2_decap_8
X_12946_ _12946_/Y _12946_/A _12962_/C _12961_/A VDD VSS sg13g2_nand3_1
XFILLER_46_674 VDD VSS sg13g2_decap_4
XFILLER_61_611 VDD VSS sg13g2_decap_8
XFILLER_46_696 VDD VSS sg13g2_fill_1
XFILLER_61_622 VDD VSS sg13g2_decap_8
XFILLER_34_858 VDD VSS sg13g2_fill_1
X_12877_ _12878_/C _14898_/Q _13689_/Q _12877_/C VDD VSS sg13g2_nand3_1
XFILLER_61_655 VDD VSS sg13g2_decap_8
XFILLER_18_1100 VDD VSS sg13g2_decap_8
X_14540__2024 _14540_/RESET_B VDD VSS sg13g2_tiehi
X_14616_ _14616_/Q clkload36/A _14616_/D _14616_/RESET_B VDD VSS sg13g2_dfrbpq_1
X_11828_ _11828_/X _14700_/Q _14732_/Q _13772_/Q _13804_/Q _11828_/S0 _11828_/S1 VDD
+ VSS sg13g2_mux4_1
XFILLER_92_1051 VDD VSS sg13g2_fill_2
X_14547_ _14547_/Q clkload11/A _14547_/D _14547_/RESET_B VDD VSS sg13g2_dfrbpq_1
X_11759_ _11760_/B _11759_/A _13930_/Q VDD VSS sg13g2_nand2_1
X_14794__3304 _14794_/RESET_B VDD VSS sg13g2_tiehi
XFILLER_18_1177 VDD VSS sg13g2_decap_8
XFILLER_140_1016 VDD VSS sg13g2_decap_8
X_14478_ _14478_/Q _14494_/CLK _14478_/D _14478_/RESET_B VDD VSS sg13g2_dfrbpq_1
XFILLER_105_1169 VDD VSS sg13g2_decap_8
X_13429_ _13429_/Y _13429_/A _13494_/B _13435_/B _13444_/C VDD VSS sg13g2_nor4_1
XFILLER_128_963 VDD VSS sg13g2_decap_8
Xmax_cap902 _08318_/D _07778_/X VDD VSS sg13g2_buf_2
Xmax_cap1085 _12566_/S0 _12761_/S0 VDD VSS sg13g2_buf_4
XFILLER_115_624 VDD VSS sg13g2_decap_8
X_14837__3255 _14837_/RESET_B VDD VSS sg13g2_tiehi
X_08970_ _13755_/D _13755_/Q _10071_/A0 _09084_/S VDD VSS sg13g2_mux2_1
XFILLER_64_1131 VDD VSS sg13g2_decap_8
XFILLER_39_0 VDD VSS sg13g2_decap_8
X_07921_ _07921_/Y _07876_/A _07876_/B _07912_/Y _07919_/Y VDD VSS sg13g2_a22oi_1
XFILLER_116_1221 VDD VSS sg13g2_decap_8
XFILLER_64_1175 VDD VSS sg13g2_fill_1
XFILLER_68_221 VDD VSS sg13g2_decap_8
XFILLER_60_1017 VDD VSS sg13g2_fill_1
XFILLER_25_1137 VDD VSS sg13g2_decap_8
XFILLER_68_243 VDD VSS sg13g2_decap_4
X_07852_ _07855_/A _15015_/Q _07853_/B VDD VSS sg13g2_nor2_1
XFILLER_68_276 VDD VSS sg13g2_decap_8
XFILLER_96_585 VDD VSS sg13g2_decap_8
XFILLER_28_118 VDD VSS sg13g2_fill_2
XFILLER_68_287 VDD VSS sg13g2_fill_1
Xinput1 input1/X input1/A VDD VSS sg13g2_buf_1
XFILLER_151_1189 VDD VSS sg13g2_decap_8
X_07783_ _07796_/A _08411_/A _07784_/B VDD VSS sg13g2_nor2_1
XFILLER_65_950 VDD VSS sg13g2_decap_8
X_09522_ _14121_/D _09621_/A0 _14121_/Q _09536_/S VDD VSS sg13g2_mux2_1
XFILLER_71_419 VDD VSS sg13g2_fill_2
XFILLER_149_1030 VDD VSS sg13g2_decap_4
X_09453_ _14054_/D _09653_/A0 _14054_/Q _09467_/S VDD VSS sg13g2_mux2_1
XFILLER_52_666 VDD VSS sg13g2_decap_8
X_08404_ _08410_/A _07826_/X _08456_/A _08523_/B1 _08436_/B _08402_/Y VDD VSS sg13g2_a221oi_1
XFILLER_40_817 VDD VSS sg13g2_fill_2
X_09384_ _13987_/D _09650_/A0 _13987_/Q _09404_/S VDD VSS sg13g2_mux2_1
XFILLER_101_58 VDD VSS sg13g2_decap_8
XFILLER_36_1222 VDD VSS sg13g2_decap_8
XFILLER_40_839 VDD VSS sg13g2_decap_4
XFILLER_51_176 VDD VSS sg13g2_decap_8
X_08335_ _15230_/D _08335_/A _08335_/B _08335_/C _08335_/D VDD VSS sg13g2_nand4_1
XFILLER_137_204 VDD VSS sg13g2_decap_8
XFILLER_71_1168 VDD VSS sg13g2_fill_1
XFILLER_123_1236 VDD VSS sg13g2_fill_1
XFILLER_138_738 VDD VSS sg13g2_decap_8
X_08266_ _08266_/Y _08300_/A3 _08263_/B _08584_/A VDD VSS sg13g2_a21oi_1
XFILLER_119_930 VDD VSS sg13g2_decap_8
XFILLER_20_596 VDD VSS sg13g2_fill_1
XFILLER_153_719 VDD VSS sg13g2_fill_1
X_08197_ _08197_/X _08241_/B _08079_/X _08081_/X _08085_/A _08125_/S _08363_/S0 VDD
+ VSS sg13g2_mux4_1
XFILLER_117_7 VDD VSS sg13g2_decap_8
XFILLER_119_974 VDD VSS sg13g2_decap_4
XFILLER_69_1053 VDD VSS sg13g2_decap_8
XFILLER_134_955 VDD VSS sg13g2_fill_1
XFILLER_10_77 VDD VSS sg13g2_decap_8
XFILLER_0_913 VDD VSS sg13g2_fill_1
XFILLER_156_1067 VDD VSS sg13g2_fill_1
XFILLER_105_178 VDD VSS sg13g2_decap_8
X_10090_ _14670_/D _10090_/A0 _14670_/Q _10090_/S VDD VSS sg13g2_mux2_1
Xfanout1007 _11185_/A _07652_/Y VDD VSS sg13g2_buf_1
Xfanout1018 _08199_/B _08125_/S VDD VSS sg13g2_buf_1
Xfanout1029 _08110_/C _08374_/A VDD VSS sg13g2_buf_1
XFILLER_126_88 VDD VSS sg13g2_decap_4
XFILLER_48_917 VDD VSS sg13g2_decap_8
XFILLER_19_42 VDD VSS sg13g2_decap_8
XFILLER_47_405 VDD VSS sg13g2_fill_2
XFILLER_87_574 VDD VSS sg13g2_fill_2
XFILLER_142_21 VDD VSS sg13g2_decap_8
XFILLER_59_276 VDD VSS sg13g2_decap_8
XFILLER_87_585 VDD VSS sg13g2_fill_2
XFILLER_101_362 VDD VSS sg13g2_fill_1
X_14890__3149 _14890_/RESET_B VDD VSS sg13g2_tiehi
XFILLER_75_769 VDD VSS sg13g2_decap_8
X_12800_ _12800_/X _12866_/A _12825_/B _12899_/C input20/X VDD VSS sg13g2_and4_1
X_13780_ _13780_/Q clkload8/A _13780_/D _13780_/RESET_B VDD VSS sg13g2_dfrbpq_1
XFILLER_76_1002 VDD VSS sg13g2_decap_8
X_10992_ _10992_/X _11009_/C _10992_/B VDD VSS sg13g2_xor2_1
X_12731_ _12731_/X _14710_/Q _14742_/Q _13782_/Q _13814_/Q _12755_/S0 _12759_/S1 VDD
+ VSS sg13g2_mux4_1
XFILLER_70_452 VDD VSS sg13g2_decap_4
XFILLER_128_1147 VDD VSS sg13g2_decap_8
XFILLER_42_154 VDD VSS sg13g2_decap_4
X_12662_ _12662_/X _12655_/X _12659_/X _12654_/X _12658_/X wire1073/X wire1090/X VDD
+ VSS sg13g2_mux4_1
Xclkbuf_leaf_63_clk_i clkload75/A clkbuf_leaf_66_clk_i/A VDD VSS sg13g2_buf_8
XFILLER_143_0 VDD VSS sg13g2_decap_8
X_14401_ _14401_/Q clkload26/A _14401_/D _14401_/RESET_B VDD VSS sg13g2_dfrbpq_1
XFILLER_24_891 VDD VSS sg13g2_fill_1
X_11613_ _11613_/Y _11609_/Y _11610_/Y _11612_/Y _11611_/Y _11615_/B VDD VSS sg13g2_a221oi_1
X_12593_ _12593_/X _12592_/X _12591_/X _12588_/X _12587_/X _12593_/S0 _12664_/S VDD
+ VSS sg13g2_mux4_1
XFILLER_129_716 VDD VSS sg13g2_decap_8
X_14332_ _14332_/Q _14776_/CLK _14332_/D _14332_/RESET_B VDD VSS sg13g2_dfrbpq_1
XFILLER_50_1219 VDD VSS sg13g2_fill_1
X_11544_ _11544_/Y _11555_/S0 _14404_/Q _12259_/S1 VDD VSS sg13g2_a21oi_1
XFILLER_13_1041 VDD VSS sg13g2_decap_8
X_14263_ _14263_/Q clkload7/A _14263_/D _14263_/RESET_B VDD VSS sg13g2_dfrbpq_1
X_11475_ _11477_/B _11747_/A _11475_/B VDD VSS sg13g2_nor2_1
Xclkbuf_leaf_78_clk_i clkload71/A clkbuf_leaf_83_clk_i/A VDD VSS sg13g2_buf_8
XFILLER_87_1120 VDD VSS sg13g2_decap_8
XFILLER_104_1180 VDD VSS sg13g2_fill_1
XFILLER_104_1191 VDD VSS sg13g2_decap_8
X_13214_ _13215_/B _14920_/Q _13667_/Q _13203_/Y VDD VSS sg13g2_a21oi_1
XFILLER_87_1131 VDD VSS sg13g2_fill_2
XFILLER_137_793 VDD VSS sg13g2_decap_8
X_10426_ _10426_/Y _14831_/Q _10521_/C _10444_/C VDD VSS sg13g2_o21ai_1
XFILLER_87_1153 VDD VSS sg13g2_decap_8
X_14194_ _14194_/Q _14738_/CLK _14194_/D _14194_/RESET_B VDD VSS sg13g2_dfrbpq_1
XFILLER_125_944 VDD VSS sg13g2_decap_8
XFILLER_48_1115 VDD VSS sg13g2_decap_4
XFILLER_87_1164 VDD VSS sg13g2_fill_2
XFILLER_87_1175 VDD VSS sg13g2_decap_8
XFILLER_124_432 VDD VSS sg13g2_fill_2
X_13145_ _13145_/Y _13145_/A VDD VSS sg13g2_inv_1
X_10357_ _10358_/C _14807_/Q _14808_/Q _14811_/Q _10357_/D VDD VSS sg13g2_and4_1
XFILLER_140_925 VDD VSS sg13g2_fill_1
XFILLER_152_785 VDD VSS sg13g2_decap_4
XFILLER_98_839 VDD VSS sg13g2_decap_8
XFILLER_135_1129 VDD VSS sg13g2_fill_1
XFILLER_2_261 VDD VSS sg13g2_decap_8
XFILLER_32_7 VDD VSS sg13g2_decap_8
X_13076_ _13076_/Y _14910_/Q _13064_/B _13172_/B VDD VSS sg13g2_a21oi_1
X_10288_ _10294_/C _10297_/A _10288_/B VDD VSS sg13g2_nor2_1
X_14558__2006 _14558_/RESET_B VDD VSS sg13g2_tiehi
Xfanout1530 _10511_/C _14844_/Q VDD VSS sg13g2_buf_1
XFILLER_78_552 VDD VSS sg13g2_fill_2
X_12027_ _12027_/Y _12027_/A _12027_/B _12027_/C VDD VSS sg13g2_nand3_1
XFILLER_78_574 VDD VSS sg13g2_fill_2
Xfanout1574 _13130_/B _13672_/Q VDD VSS sg13g2_buf_1
XFILLER_66_747 VDD VSS sg13g2_fill_2
Xfanout1585 _11424_/B _11832_/C VDD VSS sg13g2_buf_1
Xclkbuf_leaf_16_clk_i clkload18/A clkbuf_5_6__f_clk_i/X VDD VSS sg13g2_buf_8
Xfanout1596 _12291_/A _11284_/B1 VDD VSS sg13g2_buf_1
XFILLER_93_555 VDD VSS sg13g2_decap_4
XFILLER_47_950 VDD VSS sg13g2_fill_1
XFILLER_20_1023 VDD VSS sg13g2_decap_8
XFILLER_59_1200 VDD VSS sg13g2_decap_8
XFILLER_18_140 VDD VSS sg13g2_fill_1
XFILLER_34_600 VDD VSS sg13g2_fill_1
X_13978_ _13978_/Q _15040_/CLK _13978_/D _13978_/RESET_B VDD VSS sg13g2_dfrbpq_1
XFILLER_46_471 VDD VSS sg13g2_decap_4
XFILLER_74_780 VDD VSS sg13g2_decap_8
XFILLER_18_173 VDD VSS sg13g2_fill_2
XFILLER_46_482 VDD VSS sg13g2_decap_4
X_12929_ _12929_/Y _14871_/Q _12963_/B VDD VSS sg13g2_nand2_1
XFILLER_146_1214 VDD VSS sg13g2_decap_8
X_08120_ _08120_/Y _08119_/X _08198_/S VDD VSS sg13g2_nand2b_1
X_14164__2400 _14164_/RESET_B VDD VSS sg13g2_tiehi
X_08051_ _08051_/Y _08079_/S _08241_/B VDD VSS sg13g2_nor2_1
XFILLER_119_259 VDD VSS sg13g2_fill_1
XFILLER_128_760 VDD VSS sg13g2_decap_8
XFILLER_31_1174 VDD VSS sg13g2_decap_8
X_14758__3343 _14758_/RESET_B VDD VSS sg13g2_tiehi
XFILLER_143_741 VDD VSS sg13g2_decap_8
Xmax_cap743 _13455_/A _13431_/A VDD VSS sg13g2_buf_2
XFILLER_115_443 VDD VSS sg13g2_decap_8
Xmax_cap787 fanout785/A _08833_/Y VDD VSS sg13g2_buf_1
XFILLER_115_465 VDD VSS sg13g2_decap_8
X_14197__2367 _14197_/RESET_B VDD VSS sg13g2_tiehi
XFILLER_131_936 VDD VSS sg13g2_decap_4
XFILLER_9_1120 VDD VSS sg13g2_decap_8
X_08953_ _13721_/D _08956_/S _08951_/Y _08952_/Y VDD VSS sg13g2_a21oi_1
XFILLER_88_338 VDD VSS sg13g2_decap_8
XFILLER_130_457 VDD VSS sg13g2_decap_8
XFILLER_29_1092 VDD VSS sg13g2_fill_2
X_07904_ _07905_/C _07904_/A _07904_/B _07904_/C _08402_/B VDD VSS sg13g2_nand4_1
XFILLER_69_552 VDD VSS sg13g2_decap_8
XFILLER_57_703 VDD VSS sg13g2_decap_4
XFILLER_116_1051 VDD VSS sg13g2_fill_2
X_08884_ _08884_/Y _10793_/A _10793_/B _15035_/Q VDD VSS sg13g2_nand3_1
XFILLER_5_1017 VDD VSS sg13g2_decap_8
XFILLER_57_725 VDD VSS sg13g2_decap_8
XFILLER_84_500 VDD VSS sg13g2_decap_8
XFILLER_9_1197 VDD VSS sg13g2_decap_8
XFILLER_99_1024 VDD VSS sg13g2_decap_8
X_07835_ _07835_/Y _07979_/C _07981_/C VDD VSS sg13g2_nand2_1
XFILLER_56_224 VDD VSS sg13g2_fill_1
XFILLER_111_693 VDD VSS sg13g2_decap_4
XFILLER_38_950 VDD VSS sg13g2_fill_1
XFILLER_84_555 VDD VSS sg13g2_fill_2
XFILLER_110_192 VDD VSS sg13g2_fill_1
X_07766_ _07766_/Y _14762_/Q wire807/X VDD VSS sg13g2_nor2_1
XFILLER_38_983 VDD VSS sg13g2_fill_1
XFILLER_112_35 VDD VSS sg13g2_decap_8
XFILLER_65_791 VDD VSS sg13g2_fill_1
XFILLER_71_227 VDD VSS sg13g2_fill_1
X_09505_ _14105_/D _10068_/A0 _14105_/Q _09505_/S VDD VSS sg13g2_mux2_1
XFILLER_37_493 VDD VSS sg13g2_fill_1
X_07697_ _07700_/A _07697_/A _12844_/C VDD VSS sg13g2_nand2_1
XFILLER_72_28 VDD VSS sg13g2_decap_4
X_09436_ _14038_/D _10165_/A1 _14038_/Q _09436_/S VDD VSS sg13g2_mux2_1
XFILLER_13_839 VDD VSS sg13g2_decap_8
XFILLER_12_305 VDD VSS sg13g2_decap_8
XFILLER_40_625 VDD VSS sg13g2_decap_8
XFILLER_40_658 VDD VSS sg13g2_decap_8
X_09367_ _13971_/D _09963_/A1 _13971_/Q _09368_/S VDD VSS sg13g2_mux2_1
XFILLER_127_1180 VDD VSS sg13g2_fill_1
X_08318_ _08319_/B _08318_/A _08318_/B _08318_/C _08318_/D VDD VSS sg13g2_nand4_1
XFILLER_36_1096 VDD VSS sg13g2_decap_8
X_09298_ _13906_/D _13906_/Q _09830_/A0 _09306_/S VDD VSS sg13g2_mux2_1
X_15046__2918 _15046_/RESET_B VDD VSS sg13g2_tiehi
XFILLER_123_1066 VDD VSS sg13g2_decap_8
XFILLER_21_21 VDD VSS sg13g2_decap_8
X_08249_ _08250_/B _08584_/A _07927_/Y _08248_/Y VDD VSS sg13g2_a21oi_1
XFILLER_123_1099 VDD VSS sg13g2_decap_4
XFILLER_153_527 VDD VSS sg13g2_decap_8
XFILLER_137_21 VDD VSS sg13g2_decap_8
X_11260_ _11260_/Y _11263_/A1 _13852_/Q _11262_/B VDD VSS sg13g2_a21oi_1
XFILLER_10_1236 VDD VSS sg13g2_fill_1
X_10211_ _10211_/Y _14763_/Q _10210_/Y VDD VSS sg13g2_nor2b_1
Xclkbuf_5_17__f_clk_i clkbuf_leaf_34_clk_i/A clkbuf_4_8_0_clk_i/X VDD VSS sg13g2_buf_16
X_11191_ _11191_/Y _11191_/A _11205_/B VDD VSS sg13g2_nor2_1
XFILLER_79_305 VDD VSS sg13g2_decap_8
XFILLER_107_988 VDD VSS sg13g2_decap_8
XFILLER_134_785 VDD VSS sg13g2_fill_2
XFILLER_79_316 VDD VSS sg13g2_fill_1
X_14027__2537 _14027_/RESET_B VDD VSS sg13g2_tiehi
XFILLER_0_710 VDD VSS sg13g2_decap_4
X_13862__2702 _13862_/RESET_B VDD VSS sg13g2_tiehi
X_10142_ _14719_/D _14719_/Q _10142_/A1 _10160_/S VDD VSS sg13g2_mux2_1
XFILLER_122_958 VDD VSS sg13g2_decap_8
XFILLER_43_1001 VDD VSS sg13g2_fill_1
XFILLER_122_969 VDD VSS sg13g2_fill_1
X_10073_ _14653_/D _10107_/A0 _14653_/Q _10094_/S VDD VSS sg13g2_mux2_1
XFILLER_153_42 VDD VSS sg13g2_decap_8
XFILLER_43_1023 VDD VSS sg13g2_fill_2
X_14950_ _14950_/Q clkload18/A _14950_/D _14950_/RESET_B VDD VSS sg13g2_dfrbpq_1
XFILLER_48_714 VDD VSS sg13g2_fill_1
X_13901_ _13901_/Q clkload55/A _13901_/D _13901_/RESET_B VDD VSS sg13g2_dfrbpq_1
XFILLER_134_1184 VDD VSS sg13g2_decap_8
X_14881_ _14881_/Q clkload83/A _14881_/D _14881_/RESET_B VDD VSS sg13g2_dfrbpq_1
X_14242__2322 _14242_/RESET_B VDD VSS sg13g2_tiehi
X_13832_ _13832_/Q _14465_/CLK _13832_/D _13832_/RESET_B VDD VSS sg13g2_dfrbpq_1
XFILLER_75_577 VDD VSS sg13g2_decap_8
XFILLER_63_728 VDD VSS sg13g2_decap_8
X_13895__2669 _13895_/RESET_B VDD VSS sg13g2_tiehi
XFILLER_90_514 VDD VSS sg13g2_fill_2
XFILLER_29_994 VDD VSS sg13g2_decap_4
XFILLER_75_599 VDD VSS sg13g2_fill_1
XFILLER_28_493 VDD VSS sg13g2_fill_2
X_13763_ _13763_/Q clkload2/A _13763_/D _13763_/RESET_B VDD VSS sg13g2_dfrbpq_1
XFILLER_46_95 VDD VSS sg13g2_decap_4
X_10975_ _11009_/D _15115_/Q wire385/X VDD VSS sg13g2_xnor2_1
XFILLER_90_558 VDD VSS sg13g2_fill_2
XFILLER_16_666 VDD VSS sg13g2_fill_2
X_12714_ _12714_/X _14133_/Q _14165_/Q _14197_/Q _14229_/Q _12715_/S0 _12770_/S1 VDD
+ VSS sg13g2_mux4_1
X_13694_ _13694_/Q _14916_/CLK _13694_/D _13694_/RESET_B VDD VSS sg13g2_dfrbpq_1
X_12645_ _12645_/X _13744_/Q _14096_/Q _14448_/Q _14544_/Q _12646_/S0 _12647_/S1 VDD
+ VSS sg13g2_mux4_1
X_14275__2289 _14275_/RESET_B VDD VSS sg13g2_tiehi
XFILLER_156_310 VDD VSS sg13g2_decap_4
XFILLER_15_1136 VDD VSS sg13g2_decap_8
X_12576_ _12576_/X _14699_/Q _14731_/Q _13771_/Q _13803_/Q _12578_/S0 _12771_/S1 VDD
+ VSS sg13g2_mux4_1
XFILLER_141_1155 VDD VSS sg13g2_fill_2
XFILLER_7_331 VDD VSS sg13g2_decap_8
X_14315_ _14315_/Q _14731_/CLK _14315_/D _14315_/RESET_B VDD VSS sg13g2_dfrbpq_1
X_11527_ _11527_/Y _11527_/A _11636_/B VDD VSS sg13g2_xnor2_1
XFILLER_7_56 VDD VSS sg13g2_decap_8
XFILLER_156_387 VDD VSS sg13g2_fill_1
X_14246_ _14246_/Q _14662_/CLK _14246_/D _14246_/RESET_B VDD VSS sg13g2_dfrbpq_1
XFILLER_116_229 VDD VSS sg13g2_fill_2
X_11458_ _11458_/Y _11664_/A _11458_/B VDD VSS sg13g2_nor2_1
X_14490__2074 _14490_/RESET_B VDD VSS sg13g2_tiehi
XFILLER_98_603 VDD VSS sg13g2_decap_8
X_10409_ _14825_/D _14825_/Q _10406_/A _10408_/Y VDD VSS sg13g2_a21oi_1
X_14177_ _14177_/Q clkload23/A _14177_/D _14177_/RESET_B VDD VSS sg13g2_dfrbpq_1
XFILLER_125_774 VDD VSS sg13g2_fill_2
X_11389_ _11389_/Y _11418_/A _13855_/Q _11391_/B VDD VSS sg13g2_a21oi_1
XFILLER_140_711 VDD VSS sg13g2_fill_2
XFILLER_98_625 VDD VSS sg13g2_fill_1
XFILLER_98_647 VDD VSS sg13g2_fill_2
X_13128_ _13146_/A _14915_/Q _13130_/B VDD VSS sg13g2_nand2_1
XFILLER_112_457 VDD VSS sg13g2_fill_1
X_13059_ wire234/A _12993_/B _12993_/C _13058_/Y VDD VSS sg13g2_a21oi_1
XFILLER_112_479 VDD VSS sg13g2_decap_4
XFILLER_66_500 VDD VSS sg13g2_fill_1
XFILLER_87_91 VDD VSS sg13g2_decap_8
XFILLER_22_1107 VDD VSS sg13g2_decap_8
Xfanout1360 _08344_/A2 _13529_/A VDD VSS sg13g2_buf_1
XFILLER_66_522 VDD VSS sg13g2_decap_8
Xfanout1371 _08025_/B _08621_/B VDD VSS sg13g2_buf_1
Xfanout1382 _08109_/A1 _07884_/A VDD VSS sg13g2_buf_1
XFILLER_27_909 VDD VSS sg13g2_decap_8
Xfanout1393 _08598_/S0 _08055_/S0 VDD VSS sg13g2_buf_1
XFILLER_66_555 VDD VSS sg13g2_decap_4
X_07620_ _07620_/Y _14880_/Q VDD VSS sg13g2_inv_1
XFILLER_81_514 VDD VSS sg13g2_decap_4
X_13725__2839 _13725_/RESET_B VDD VSS sg13g2_tiehi
XFILLER_4_1083 VDD VSS sg13g2_decap_8
XFILLER_59_1041 VDD VSS sg13g2_decap_8
XFILLER_35_964 VDD VSS sg13g2_decap_4
XFILLER_35_986 VDD VSS sg13g2_decap_8
XFILLER_62_772 VDD VSS sg13g2_decap_8
XFILLER_35_997 VDD VSS sg13g2_fill_1
XFILLER_146_1055 VDD VSS sg13g2_decap_8
X_09221_ _13832_/D _09787_/A0 _13832_/Q _09223_/S VDD VSS sg13g2_mux2_1
XFILLER_107_1017 VDD VSS sg13g2_fill_2
XFILLER_22_658 VDD VSS sg13g2_decap_4
XFILLER_21_135 VDD VSS sg13g2_decap_8
X_14105__2459 _14105_/RESET_B VDD VSS sg13g2_tiehi
X_13940__2624 _13940_/RESET_B VDD VSS sg13g2_tiehi
XFILLER_33_1225 VDD VSS sg13g2_decap_8
XFILLER_21_168 VDD VSS sg13g2_fill_2
X_09152_ _09152_/Y _09158_/A _09148_/Y _09151_/Y VDD VSS sg13g2_o21ai_1
XFILLER_33_1236 VDD VSS sg13g2_fill_1
X_08103_ _08104_/D _08140_/B _08200_/B _08103_/C VDD VSS sg13g2_nor3_1
XFILLER_120_1217 VDD VSS sg13g2_decap_8
XFILLER_135_505 VDD VSS sg13g2_decap_8
X_09083_ _09083_/Y _09090_/A _09079_/Y _09082_/Y VDD VSS sg13g2_o21ai_1
X_08034_ _08034_/Y _08034_/A _08659_/B VDD VSS sg13g2_nor2_1
XFILLER_107_229 VDD VSS sg13g2_decap_8
X_14320__2244 _14320_/RESET_B VDD VSS sg13g2_tiehi
XFILLER_1_518 VDD VSS sg13g2_fill_1
XFILLER_103_413 VDD VSS sg13g2_fill_1
XFILLER_107_35 VDD VSS sg13g2_fill_2
Xmax_cap595 _10033_/S _10017_/S VDD VSS sg13g2_buf_4
X_09985_ _14568_/D _10084_/A0 _14568_/Q _09987_/S VDD VSS sg13g2_mux2_1
XFILLER_107_68 VDD VSS sg13g2_decap_4
XFILLER_103_457 VDD VSS sg13g2_fill_2
XFILLER_130_243 VDD VSS sg13g2_fill_1
X_08936_ _08936_/X _15048_/Q _14952_/Q _10767_/A VDD VSS sg13g2_mux2_1
X_08867_ _08867_/X _08866_/X _11526_/A _08882_/S VDD VSS sg13g2_mux2_1
XFILLER_96_190 VDD VSS sg13g2_decap_4
X_07818_ _07818_/Y _15010_/Q _07818_/B VDD VSS sg13g2_xnor2_1
XFILLER_57_588 VDD VSS sg13g2_decap_8
XFILLER_45_739 VDD VSS sg13g2_fill_1
X_08798_ _08799_/B _12942_/B _08807_/B VDD VSS sg13g2_nor2_1
XFILLER_123_78 VDD VSS sg13g2_decap_8
XFILLER_84_385 VDD VSS sg13g2_decap_8
Xclkbuf_4_1_0_clk_i clkbuf_4_1_0_clk_i/X clkbuf_0_clk_i/X VDD VSS sg13g2_buf_8
XFILLER_16_21 VDD VSS sg13g2_decap_8
X_07749_ _07750_/A _07738_/Y _07744_/D _07748_/Y VDD VSS sg13g2_o21ai_1
XFILLER_77_1141 VDD VSS sg13g2_decap_8
XFILLER_129_1231 VDD VSS sg13g2_decap_4
X_10760_ _10760_/Y _10760_/A _11196_/B VDD VSS sg13g2_nand2_1
XFILLER_53_783 VDD VSS sg13g2_decap_8
XFILLER_41_945 VDD VSS sg13g2_fill_2
X_09419_ _14021_/D _09850_/A1 _14021_/Q _09421_/S VDD VSS sg13g2_mux2_1
XFILLER_38_1169 VDD VSS sg13g2_fill_2
X_10691_ _10691_/X _14931_/Q _08998_/X _10691_/S VDD VSS sg13g2_mux2_1
XFILLER_12_146 VDD VSS sg13g2_decap_8
X_12430_ _14994_/D _07910_/A _12498_/C1 _12429_/Y VDD VSS sg13g2_a21oi_1
XFILLER_138_310 VDD VSS sg13g2_fill_1
Xmax_cap1607 _11230_/S _11953_/C VDD VSS sg13g2_buf_4
XFILLER_138_343 VDD VSS sg13g2_fill_2
XFILLER_148_42 VDD VSS sg13g2_decap_8
XFILLER_139_888 VDD VSS sg13g2_decap_4
X_12361_ _12361_/X _14236_/Q _14268_/Q _14300_/Q _14332_/Q _12368_/S0 _12368_/S1 VDD
+ VSS sg13g2_mux4_1
XFILLER_10_1000 VDD VSS sg13g2_decap_8
X_14100_ _14100_/Q clkload17/A _14100_/D _14100_/RESET_B VDD VSS sg13g2_dfrbpq_1
XFILLER_154_847 VDD VSS sg13g2_decap_8
X_11312_ _11312_/Y _11306_/Y _11311_/Y _11975_/A VDD VSS sg13g2_o21ai_1
X_15080_ _15080_/Q clkload69/A _15080_/D _15080_/RESET_B VDD VSS sg13g2_dfrbpq_1
X_12292_ _12292_/Y _12292_/A _12292_/B VDD VSS sg13g2_nor2_1
XFILLER_5_857 VDD VSS sg13g2_decap_8
XFILLER_5_868 VDD VSS sg13g2_fill_1
X_15158__3026 _15158_/RESET_B VDD VSS sg13g2_tiehi
X_14031_ _14031_/Q _14671_/CLK _14031_/D _14031_/RESET_B VDD VSS sg13g2_dfrbpq_1
XFILLER_106_0 VDD VSS sg13g2_decap_8
XFILLER_10_1066 VDD VSS sg13g2_decap_8
X_11243_ _11245_/B _13300_/C _11243_/B _13289_/C VDD VSS sg13g2_or3_1
XFILLER_106_240 VDD VSS sg13g2_decap_8
XFILLER_101_1183 VDD VSS sg13g2_fill_2
XFILLER_79_113 VDD VSS sg13g2_fill_1
X_11174_ _11177_/C _11127_/A _11127_/B _11173_/Y VDD VSS sg13g2_a21oi_1
XFILLER_68_809 VDD VSS sg13g2_decap_8
XFILLER_0_551 VDD VSS sg13g2_decap_4
XFILLER_79_168 VDD VSS sg13g2_fill_1
X_10125_ _14703_/D _10158_/A1 _14703_/Q _10135_/S VDD VSS sg13g2_mux2_1
XFILLER_95_628 VDD VSS sg13g2_fill_2
XFILLER_121_276 VDD VSS sg13g2_decap_8
Xhold3490 _13639_/A _13747_/Q VDD VSS sg13g2_dlygate4sd3_1
XFILLER_103_991 VDD VSS sg13g2_fill_1
X_10056_ _14637_/D _10089_/A0 _14637_/Q _10060_/S VDD VSS sg13g2_mux2_1
X_14933_ _14933_/Q _15229_/CLK _14933_/D _14933_/RESET_B VDD VSS sg13g2_dfrbpq_1
XFILLER_75_341 VDD VSS sg13g2_decap_8
X_14864_ _14864_/Q clkload69/A _14864_/D _14864_/RESET_B VDD VSS sg13g2_dfrbpq_1
XFILLER_1_1212 VDD VSS sg13g2_decap_8
XFILLER_21_1173 VDD VSS sg13g2_decap_8
X_13815_ _13815_/Q clkload4/A _13815_/D _13815_/RESET_B VDD VSS sg13g2_dfrbpq_1
X_14795_ _14795_/Q clkload81/A _14795_/D _14795_/RESET_B VDD VSS sg13g2_dfrbpq_1
XFILLER_44_750 VDD VSS sg13g2_decap_8
X_13746_ _13746_/Q _14706_/CLK _13746_/D _13746_/RESET_B VDD VSS sg13g2_dfrbpq_1
XFILLER_56_1236 VDD VSS sg13g2_fill_1
X_10958_ _14938_/D _10956_/Y _10957_/Y _10941_/X VDD VSS sg13g2_a21o_1
XFILLER_91_1116 VDD VSS sg13g2_decap_4
XFILLER_31_411 VDD VSS sg13g2_decap_8
XFILLER_73_82 VDD VSS sg13g2_fill_1
XFILLER_32_956 VDD VSS sg13g2_fill_1
X_13677_ _13677_/Q clkload64/A _13677_/D _13677_/RESET_B VDD VSS sg13g2_dfrbpq_1
XFILLER_31_455 VDD VSS sg13g2_decap_8
X_10889_ _10948_/A _14755_/Q _10923_/A VDD VSS sg13g2_xor2_1
XFILLER_32_989 VDD VSS sg13g2_fill_1
X_12628_ _12628_/X _14383_/Q _14415_/Q _14479_/Q _14511_/Q _12686_/S0 _12686_/S1 VDD
+ VSS sg13g2_mux4_1
X_12559_ _12559_/X _14378_/Q _14410_/Q _14474_/Q _14506_/Q _12754_/S0 _12754_/S1 VDD
+ VSS sg13g2_mux4_1
XFILLER_145_836 VDD VSS sg13g2_fill_1
XFILLER_8_673 VDD VSS sg13g2_fill_1
XFILLER_144_335 VDD VSS sg13g2_decap_8
XFILLER_117_549 VDD VSS sg13g2_decap_8
X_14229_ _14229_/Q clkload15/A _14229_/D _14229_/RESET_B VDD VSS sg13g2_dfrbpq_1
XFILLER_112_210 VDD VSS sg13g2_decap_8
Xfanout608 _09976_/S _10003_/S VDD VSS sg13g2_buf_1
XFILLER_98_444 VDD VSS sg13g2_fill_1
Xfanout619 _09810_/S _09826_/S VDD VSS sg13g2_buf_1
X_09770_ _14360_/D _14360_/Q _09836_/A0 _09770_/S VDD VSS sg13g2_mux2_1
X_14902__3125 _14902_/RESET_B VDD VSS sg13g2_tiehi
XFILLER_21_0 VDD VSS sg13g2_decap_8
XFILLER_26_1051 VDD VSS sg13g2_decap_8
XFILLER_112_287 VDD VSS sg13g2_decap_8
XFILLER_67_831 VDD VSS sg13g2_decap_4
X_08721_ _15193_/D input20/X _15193_/Q _13340_/S VDD VSS sg13g2_mux2_1
XFILLER_6_1145 VDD VSS sg13g2_decap_8
X_13958__2606 _13958_/RESET_B VDD VSS sg13g2_tiehi
XFILLER_66_352 VDD VSS sg13g2_fill_1
XFILLER_94_661 VDD VSS sg13g2_fill_1
X_08652_ _08661_/A _08668_/A _08336_/Y _08688_/C VDD VSS sg13g2_o21ai_1
XFILLER_54_503 VDD VSS sg13g2_fill_1
XFILLER_54_514 VDD VSS sg13g2_decap_8
XFILLER_54_525 VDD VSS sg13g2_fill_1
XFILLER_94_694 VDD VSS sg13g2_decap_8
X_14935__3059 _14935_/RESET_B VDD VSS sg13g2_tiehi
XFILLER_82_856 VDD VSS sg13g2_decap_8
X_08583_ _08586_/B _07963_/Y _08583_/B VDD VSS sg13g2_nand2b_1
XFILLER_82_889 VDD VSS sg13g2_fill_1
XFILLER_23_912 VDD VSS sg13g2_decap_8
XFILLER_35_794 VDD VSS sg13g2_fill_1
XFILLER_22_411 VDD VSS sg13g2_decap_8
X_14338__2226 _14338_/RESET_B VDD VSS sg13g2_tiehi
XFILLER_62_580 VDD VSS sg13g2_decap_8
XFILLER_34_282 VDD VSS sg13g2_fill_1
XFILLER_23_956 VDD VSS sg13g2_fill_2
XFILLER_139_118 VDD VSS sg13g2_decap_8
XFILLER_50_764 VDD VSS sg13g2_decap_8
XFILLER_33_1000 VDD VSS sg13g2_fill_1
X_09204_ wire765/A _09641_/A _09806_/B _09204_/C _09204_/D VDD VSS sg13g2_nor4_1
XFILLER_22_477 VDD VSS sg13g2_fill_2
XFILLER_10_617 VDD VSS sg13g2_fill_1
XFILLER_10_639 VDD VSS sg13g2_decap_8
XFILLER_72_1082 VDD VSS sg13g2_fill_1
XFILLER_33_1044 VDD VSS sg13g2_decap_8
X_09135_ _09164_/C _14921_/Q _13199_/A VDD VSS sg13g2_and2_1
XFILLER_120_1014 VDD VSS sg13g2_fill_2
XFILLER_147_151 VDD VSS sg13g2_fill_2
XFILLER_108_527 VDD VSS sg13g2_decap_8
XFILLER_147_184 VDD VSS sg13g2_decap_4
X_14553__2011 _14553_/RESET_B VDD VSS sg13g2_tiehi
X_09066_ _09066_/Y _09155_/A1 _15038_/Q _09065_/Y VDD VSS sg13g2_o21ai_1
X_15113__3118 _15113_/RESET_B VDD VSS sg13g2_tiehi
XFILLER_68_1118 VDD VSS sg13g2_fill_2
XFILLER_135_368 VDD VSS sg13g2_fill_2
X_08017_ _08019_/B _07768_/A _08258_/C _08276_/A _08306_/C _08327_/S0 _08099_/S0 VDD
+ VSS sg13g2_mux4_1
XFILLER_118_56 VDD VSS sg13g2_decap_8
XFILLER_150_316 VDD VSS sg13g2_decap_8
XFILLER_1_304 VDD VSS sg13g2_fill_1
XFILLER_116_571 VDD VSS sg13g2_fill_1
Xmax_cap381 _11147_/A _10768_/Y VDD VSS sg13g2_buf_2
XFILLER_116_593 VDD VSS sg13g2_decap_8
XFILLER_1_348 VDD VSS sg13g2_decap_4
X_09968_ _14552_/D _14552_/Q _10167_/A1 wire418/X VDD VSS sg13g2_mux2_1
XFILLER_44_1140 VDD VSS sg13g2_fill_1
XFILLER_58_820 VDD VSS sg13g2_fill_2
XFILLER_103_287 VDD VSS sg13g2_fill_1
X_08919_ _08919_/X _08918_/X _11936_/A _08955_/S VDD VSS sg13g2_mux2_1
XFILLER_134_77 VDD VSS sg13g2_decap_4
XFILLER_40_1015 VDD VSS sg13g2_decap_8
X_09899_ _14485_/D _09899_/A0 _14485_/Q _09903_/S VDD VSS sg13g2_mux2_1
XFILLER_18_706 VDD VSS sg13g2_decap_8
XFILLER_85_650 VDD VSS sg13g2_decap_8
XFILLER_58_875 VDD VSS sg13g2_fill_1
XFILLER_40_1048 VDD VSS sg13g2_decap_8
X_11930_ wire300/A _11975_/A _11928_/X _11929_/Y VDD VSS sg13g2_o21ai_1
XFILLER_79_1225 VDD VSS sg13g2_decap_8
XFILLER_27_42 VDD VSS sg13g2_decap_8
XFILLER_40_1059 VDD VSS sg13g2_fill_1
XFILLER_79_1236 VDD VSS sg13g2_fill_1
XFILLER_150_21 VDD VSS sg13g2_decap_8
XFILLER_131_1187 VDD VSS sg13g2_decap_8
XFILLER_45_547 VDD VSS sg13g2_decap_4
X_11861_ _11861_/Y _11860_/Y wire301/X _11846_/Y _11868_/A _11980_/A VDD VSS sg13g2_a221oi_1
X_13600_ _13600_/Y _13600_/A _13600_/B _13600_/C VDD VSS sg13g2_nand3_1
XFILLER_32_208 VDD VSS sg13g2_decap_8
X_10812_ _14927_/D _10811_/Y _10810_/Y _10800_/Y VDD VSS sg13g2_o21ai_1
XFILLER_32_219 VDD VSS sg13g2_fill_1
XFILLER_14_923 VDD VSS sg13g2_fill_1
X_14580_ _14580_/Q clkload16/A _14580_/D _14580_/RESET_B VDD VSS sg13g2_dfrbpq_1
XFILLER_150_98 VDD VSS sg13g2_decap_8
X_11792_ _11792_/Y _13064_/A _11792_/B VDD VSS sg13g2_nand2_1
X_13531_ _13531_/Y _15143_/Q _13568_/S VDD VSS sg13g2_nor2_1
X_10743_ _11078_/A _07615_/Y _09086_/Y _10788_/S VDD VSS sg13g2_mux2_1
XFILLER_129_1072 VDD VSS sg13g2_fill_1
XFILLER_43_63 VDD VSS sg13g2_fill_2
XFILLER_51_1100 VDD VSS sg13g2_decap_4
X_13462_ _13463_/B _15189_/Q _15190_/Q VDD VSS sg13g2_nand2b_1
X_10674_ _10674_/Y _10674_/A _10800_/B VDD VSS sg13g2_nand2_1
XFILLER_40_296 VDD VSS sg13g2_decap_8
X_15201_ _15201_/Q clkload69/A _15201_/D _15201_/RESET_B VDD VSS sg13g2_dfrbpq_1
X_12413_ _12413_/X _12409_/X _12408_/X _12405_/X _12404_/X wire1090/X _12609_/S VDD
+ VSS sg13g2_mux4_1
X_14192__2372 _14192_/RESET_B VDD VSS sg13g2_tiehi
X_13393_ _13393_/Y _13465_/A1 _13412_/C _15085_/Q VDD VSS sg13g2_o21ai_1
X_15132_ _15132_/Q clkload27/A _15132_/D _15132_/RESET_B VDD VSS sg13g2_dfrbpq_1
XFILLER_5_610 VDD VSS sg13g2_decap_8
XFILLER_51_1188 VDD VSS sg13g2_decap_8
X_12344_ _12344_/X _14555_/Q _14587_/Q _14619_/Q _14651_/Q _12365_/S0 _12366_/S1 VDD
+ VSS sg13g2_mux4_1
XFILLER_86_1207 VDD VSS sg13g2_fill_2
XFILLER_154_677 VDD VSS sg13g2_decap_8
XFILLER_153_154 VDD VSS sg13g2_decap_8
XFILLER_114_519 VDD VSS sg13g2_decap_8
X_15063_ _15063_/Q _15178_/CLK _15063_/D _15063_/RESET_B VDD VSS sg13g2_dfrbpq_1
X_12275_ _12275_/Y _12229_/A _13664_/Q _12274_/Y VDD VSS sg13g2_a21oi_1
XFILLER_141_338 VDD VSS sg13g2_fill_1
X_14014_ _14014_/Q clkload58/A _14014_/D _14014_/RESET_B VDD VSS sg13g2_dfrbpq_1
XFILLER_4_35 VDD VSS sg13g2_decap_8
X_11226_ _11226_/X _14235_/Q _14267_/Q _14299_/Q _14331_/Q _11890_/S0 _11226_/S1 VDD
+ VSS sg13g2_mux4_1
XFILLER_49_1084 VDD VSS sg13g2_decap_4
XFILLER_96_926 VDD VSS sg13g2_decap_4
X_11157_ _11173_/C _11171_/B _11164_/C VDD VSS sg13g2_xnor2_1
XFILLER_1_871 VDD VSS sg13g2_fill_2
XFILLER_95_425 VDD VSS sg13g2_decap_4
X_14416__2148 _14416_/RESET_B VDD VSS sg13g2_tiehi
X_10108_ _14686_/D _10141_/A1 _14686_/Q _10124_/S VDD VSS sg13g2_mux2_1
XFILLER_23_1224 VDD VSS sg13g2_decap_8
X_11088_ _11091_/A _11088_/A _11118_/B _11118_/A VDD VSS sg13g2_nand3_1
XFILLER_23_1235 VDD VSS sg13g2_fill_2
XFILLER_36_503 VDD VSS sg13g2_fill_2
XFILLER_49_886 VDD VSS sg13g2_fill_1
X_10039_ _14620_/D _10039_/A0 _14620_/Q _10057_/S VDD VSS sg13g2_mux2_1
X_14916_ _14916_/Q _14916_/CLK _14916_/D _14916_/RESET_B VDD VSS sg13g2_dfrbpq_1
XFILLER_64_834 VDD VSS sg13g2_decap_8
XFILLER_110_1227 VDD VSS sg13g2_decap_8
XFILLER_36_536 VDD VSS sg13g2_decap_8
XFILLER_36_547 VDD VSS sg13g2_fill_1
X_14847_ _14847_/Q _14854_/CLK _14847_/D _14847_/RESET_B VDD VSS sg13g2_dfrbpq_1
XFILLER_17_761 VDD VSS sg13g2_decap_4
XFILLER_56_1000 VDD VSS sg13g2_decap_8
XFILLER_23_219 VDD VSS sg13g2_decap_4
X_14778_ _14778_/Q clkload81/A _14778_/D _14778_/RESET_B VDD VSS sg13g2_dfrbpq_1
XFILLER_147_1150 VDD VSS sg13g2_decap_8
XFILLER_1_1097 VDD VSS sg13g2_decap_8
XFILLER_108_1123 VDD VSS sg13g2_decap_8
X_13729_ _13729_/Q clkload28/A _13729_/D _13729_/RESET_B VDD VSS sg13g2_dfrbpq_1
XFILLER_56_1077 VDD VSS sg13g2_decap_8
XFILLER_143_1036 VDD VSS sg13g2_decap_4
XFILLER_31_252 VDD VSS sg13g2_decap_8
XFILLER_56_1088 VDD VSS sg13g2_fill_1
X_14022__2542 _14022_/RESET_B VDD VSS sg13g2_tiehi
XFILLER_9_971 VDD VSS sg13g2_decap_8
XFILLER_129_151 VDD VSS sg13g2_decap_8
XFILLER_30_1228 VDD VSS sg13g2_decap_8
XFILLER_118_847 VDD VSS sg13g2_decap_8
X_13683__2891 _13683_/RESET_B VDD VSS sg13g2_tiehi
XFILLER_69_0 VDD VSS sg13g2_decap_8
XFILLER_144_143 VDD VSS sg13g2_fill_1
X_14626__1938 _14626_/RESET_B VDD VSS sg13g2_tiehi
XFILLER_144_165 VDD VSS sg13g2_fill_2
XFILLER_67_1173 VDD VSS sg13g2_decap_4
XFILLER_98_230 VDD VSS sg13g2_fill_1
XFILLER_125_390 VDD VSS sg13g2_decap_4
Xfanout405 _10090_/S fanout407/X VDD VSS sg13g2_buf_1
X_13890__2674 _13890_/RESET_B VDD VSS sg13g2_tiehi
XFILLER_28_1157 VDD VSS sg13g2_decap_8
X_09822_ _14410_/D _09888_/A0 _14410_/Q wire618/X VDD VSS sg13g2_mux2_1
XFILLER_86_414 VDD VSS sg13g2_decap_8
XFILLER_154_1176 VDD VSS sg13g2_decap_8
XFILLER_59_639 VDD VSS sg13g2_fill_1
X_09753_ _14343_/D _14343_/Q _09918_/A1 _09765_/S VDD VSS sg13g2_mux2_1
XFILLER_104_14 VDD VSS sg13g2_decap_8
XFILLER_95_970 VDD VSS sg13g2_decap_8
X_08704_ _13657_/D _15184_/D _15115_/Q _13651_/S VDD VSS sg13g2_mux2_1
X_15142__3058 _15142_/RESET_B VDD VSS sg13g2_tiehi
X_09684_ _14276_/D _10147_/A1 _14276_/Q wire458/X VDD VSS sg13g2_mux2_1
X_14270__2294 _14270_/RESET_B VDD VSS sg13g2_tiehi
X_08635_ _08635_/X _08686_/A3 _07849_/B _08635_/A2 _08635_/A3 wire1387/X _13521_/A
+ VDD VSS sg13g2_mux4_1
XFILLER_42_506 VDD VSS sg13g2_decap_8
XFILLER_70_837 VDD VSS sg13g2_decap_4
X_08566_ _08574_/D _08567_/A _08567_/B _08566_/C VDD VSS sg13g2_nor3_1
XFILLER_120_35 VDD VSS sg13g2_fill_2
XFILLER_81_196 VDD VSS sg13g2_decap_8
X_08497_ _08497_/Y _08497_/A _08497_/B VDD VSS sg13g2_nand2_1
XFILLER_147_7 VDD VSS sg13g2_decap_8
XFILLER_22_241 VDD VSS sg13g2_decap_8
XFILLER_35_1128 VDD VSS sg13g2_fill_1
XFILLER_80_28 VDD VSS sg13g2_decap_8
X_14879__3171 _14879_/RESET_B VDD VSS sg13g2_tiehi
XFILLER_136_600 VDD VSS sg13g2_fill_1
XFILLER_109_814 VDD VSS sg13g2_decap_8
XFILLER_148_460 VDD VSS sg13g2_decap_8
XFILLER_149_994 VDD VSS sg13g2_decap_8
XFILLER_13_77 VDD VSS sg13g2_decap_8
X_09118_ _09118_/Y _09158_/A _10762_/B _09117_/Y VDD VSS sg13g2_o21ai_1
X_10390_ _10392_/C _10369_/Y _10387_/X _14821_/Q VDD VSS sg13g2_a21o_1
XFILLER_11_1161 VDD VSS sg13g2_decap_8
X_09049_ _09049_/Y _14908_/Q _09056_/C _09024_/A VDD VSS sg13g2_o21ai_1
XFILLER_108_379 VDD VSS sg13g2_decap_8
XFILLER_145_21 VDD VSS sg13g2_decap_8
XFILLER_123_338 VDD VSS sg13g2_fill_1
X_12060_ _12060_/Y _12062_/A wire379/X VDD VSS sg13g2_nand2_1
XFILLER_123_349 VDD VSS sg13g2_fill_1
XFILLER_132_850 VDD VSS sg13g2_fill_1
XFILLER_1_134 VDD VSS sg13g2_decap_8
XFILLER_1_145 VDD VSS sg13g2_fill_1
XFILLER_46_1235 VDD VSS sg13g2_fill_2
XFILLER_78_915 VDD VSS sg13g2_fill_1
XFILLER_81_1115 VDD VSS sg13g2_decap_8
X_13720__2844 _13720_/RESET_B VDD VSS sg13g2_tiehi
X_11011_ _11011_/Y _11012_/B _11012_/C VDD VSS sg13g2_nor2_1
XFILLER_132_883 VDD VSS sg13g2_decap_8
XFILLER_1_167 VDD VSS sg13g2_decap_8
XFILLER_104_574 VDD VSS sg13g2_fill_2
XFILLER_145_98 VDD VSS sg13g2_fill_1
XFILLER_104_596 VDD VSS sg13g2_fill_2
Xfanout950 _13340_/S _13471_/S VDD VSS sg13g2_buf_1
Xfanout961 _11330_/S _11378_/S VDD VSS sg13g2_buf_1
XFILLER_131_393 VDD VSS sg13g2_decap_8
Xfanout972 _12246_/B _12260_/A1 VDD VSS sg13g2_buf_1
Xfanout983 _11283_/B _11227_/S VDD VSS sg13g2_buf_1
XFILLER_38_63 VDD VSS sg13g2_fill_2
XFILLER_86_970 VDD VSS sg13g2_fill_1
Xfanout994 _11416_/B _12328_/B1 VDD VSS sg13g2_buf_1
X_12962_ _12962_/Y _12960_/Y _12962_/B _12962_/C VDD VSS sg13g2_nand3b_1
XFILLER_64_119 VDD VSS sg13g2_decap_8
XFILLER_100_780 VDD VSS sg13g2_decap_8
XFILLER_45_311 VDD VSS sg13g2_decap_8
XFILLER_57_171 VDD VSS sg13g2_decap_8
X_14701_ _14701_/Q clkload55/A _14701_/D _14701_/RESET_B VDD VSS sg13g2_dfrbpq_1
X_14100__2464 _14100_/RESET_B VDD VSS sg13g2_tiehi
X_11913_ _11917_/A _11913_/A _11913_/B VDD VSS sg13g2_nor2_1
XFILLER_46_878 VDD VSS sg13g2_fill_2
X_12893_ _12925_/B _12894_/A _12894_/B VDD VSS sg13g2_nand2_1
XFILLER_72_130 VDD VSS sg13g2_decap_8
XFILLER_46_889 VDD VSS sg13g2_decap_8
X_14632_ _14632_/Q clkload28/A _14632_/D _14632_/RESET_B VDD VSS sg13g2_dfrbpq_1
XFILLER_73_697 VDD VSS sg13g2_decap_8
X_11844_ _11846_/A _11907_/A _11845_/C _11910_/B VDD VSS sg13g2_o21ai_1
XFILLER_127_1009 VDD VSS sg13g2_decap_8
XFILLER_54_62 VDD VSS sg13g2_fill_1
XFILLER_54_73 VDD VSS sg13g2_fill_1
X_14563_ _14563_/Q clkload2/A _14563_/D _14563_/RESET_B VDD VSS sg13g2_dfrbpq_1
X_11775_ _11778_/A _11725_/Y _11772_/Y _11774_/Y VDD VSS sg13g2_o21ai_1
XFILLER_13_241 VDD VSS sg13g2_decap_8
XFILLER_14_775 VDD VSS sg13g2_decap_8
X_13514_ _15137_/D _15137_/Q _14994_/Q _13539_/B VDD VSS sg13g2_mux2_1
X_10726_ wire385/A _14940_/Q _10725_/A _10725_/Y VDD VSS sg13g2_a21oi_1
X_14494_ _14494_/Q _14494_/CLK _14494_/D _14494_/RESET_B VDD VSS sg13g2_dfrbpq_1
XFILLER_110_90 VDD VSS sg13g2_fill_2
XFILLER_70_50 VDD VSS sg13g2_decap_8
XFILLER_146_419 VDD VSS sg13g2_fill_2
Xmax_cap1201 _12411_/S0 _12378_/S0 VDD VSS sg13g2_buf_4
X_13445_ _15104_/D _15104_/Q _13470_/A2 _13444_/Y VDD VSS sg13g2_a21o_1
Xmax_cap1212 _12365_/S0 _12366_/S0 VDD VSS sg13g2_buf_4
X_10657_ _10666_/D _14891_/Q _10663_/D VDD VSS sg13g2_and2_1
XFILLER_127_600 VDD VSS sg13g2_decap_8
XFILLER_9_278 VDD VSS sg13g2_decap_8
XFILLER_155_931 VDD VSS sg13g2_decap_8
XFILLER_16_1083 VDD VSS sg13g2_decap_8
XFILLER_103_1031 VDD VSS sg13g2_fill_1
Xclkload15 clkload15/Y clkload15/A VDD VSS sg13g2_inv_2
Xclkload26 clkload26/Y clkload26/A VDD VSS sg13g2_inv_1
XFILLER_126_110 VDD VSS sg13g2_decap_8
Xclkload37 clkload37/Y clkload37/A VDD VSS sg13g2_inv_2
XFILLER_62_7 VDD VSS sg13g2_decap_8
X_13376_ _13376_/Y _13381_/A _13389_/B _13381_/B _13378_/C VDD VSS sg13g2_nor4_1
XFILLER_103_1064 VDD VSS sg13g2_decap_8
X_10588_ _14873_/D _12963_/A _10594_/D _10587_/Y VDD VSS sg13g2_a21oi_1
XFILLER_154_452 VDD VSS sg13g2_decap_8
Xclkload48 clkload48/Y clkload48/A VDD VSS sg13g2_inv_2
Xclkload59 clkload59/Y clkload59/A VDD VSS sg13g2_inv_2
XFILLER_86_1026 VDD VSS sg13g2_decap_8
XFILLER_115_817 VDD VSS sg13g2_decap_8
X_12327_ _12327_/Y _11801_/S _13914_/Q VDD VSS sg13g2_nand2b_1
X_15115_ _15115_/Q clkload65/A _15115_/D _15115_/RESET_B VDD VSS sg13g2_dfrbpq_1
XFILLER_114_305 VDD VSS sg13g2_decap_4
XFILLER_108_891 VDD VSS sg13g2_decap_4
X_15046_ _15046_/Q _15046_/CLK _15046_/D _15046_/RESET_B VDD VSS sg13g2_dfrbpq_1
X_12258_ _12258_/Y _12254_/Y _12255_/Y _12257_/Y _12256_/Y _12260_/A1 VDD VSS sg13g2_a221oi_1
X_11209_ _14956_/D _11209_/A _11209_/B VDD VSS sg13g2_nand2_1
XFILLER_96_712 VDD VSS sg13g2_fill_1
X_12189_ _12190_/A _14710_/Q _14742_/Q _13782_/Q _13814_/Q _12186_/A _12187_/C VDD
+ VSS sg13g2_mux4_1
XFILLER_95_200 VDD VSS sg13g2_decap_8
XFILLER_122_382 VDD VSS sg13g2_decap_8
XFILLER_96_756 VDD VSS sg13g2_fill_2
XFILLER_122_393 VDD VSS sg13g2_fill_1
XFILLER_96_767 VDD VSS sg13g2_decap_8
XFILLER_23_1021 VDD VSS sg13g2_decap_8
XFILLER_3_1104 VDD VSS sg13g2_decap_8
XFILLER_83_439 VDD VSS sg13g2_decap_8
XFILLER_23_1098 VDD VSS sg13g2_decap_8
XFILLER_58_1106 VDD VSS sg13g2_decap_4
X_08420_ _08575_/C _08420_/A _08419_/A VDD VSS sg13g2_nor2b_1
XFILLER_36_377 VDD VSS sg13g2_decap_8
XFILLER_145_1109 VDD VSS sg13g2_fill_1
X_08351_ _08352_/B _07786_/A _08351_/B VDD VSS sg13g2_nand2b_1
XFILLER_149_213 VDD VSS sg13g2_decap_4
XFILLER_60_870 VDD VSS sg13g2_decap_8
X_08282_ _08282_/Y _08452_/A _08234_/Y _08329_/B _08280_/X VDD VSS sg13g2_a22oi_1
Xclkload9 clkload9/Y clkload9/A VDD VSS sg13g2_inv_1
XFILLER_149_279 VDD VSS sg13g2_decap_8
XFILLER_30_1025 VDD VSS sg13g2_decap_8
XFILLER_118_644 VDD VSS sg13g2_decap_8
XFILLER_121_1164 VDD VSS sg13g2_fill_2
XFILLER_69_1235 VDD VSS sg13g2_fill_2
XFILLER_133_614 VDD VSS sg13g2_decap_8
XFILLER_106_828 VDD VSS sg13g2_fill_2
XFILLER_106_839 VDD VSS sg13g2_decap_8
X_14288__2276 _14288_/RESET_B VDD VSS sg13g2_tiehi
XFILLER_117_187 VDD VSS sg13g2_decap_4
XFILLER_133_647 VDD VSS sg13g2_decap_8
XFILLER_133_658 VDD VSS sg13g2_fill_1
Xfanout202 _09893_/A0 fanout204/X VDD VSS sg13g2_buf_1
XFILLER_8_1015 VDD VSS sg13g2_decap_4
XFILLER_87_712 VDD VSS sg13g2_fill_2
Xfanout224 _09991_/A0 _10090_/A0 VDD VSS sg13g2_buf_1
XFILLER_87_723 VDD VSS sg13g2_decap_8
XFILLER_101_511 VDD VSS sg13g2_decap_4
Xfanout235 _13265_/A1 _13222_/A1 VDD VSS sg13g2_buf_1
XFILLER_8_1048 VDD VSS sg13g2_decap_8
XFILLER_113_393 VDD VSS sg13g2_decap_4
XFILLER_86_233 VDD VSS sg13g2_decap_8
X_09805_ _14394_/D _10169_/A1 _14394_/Q _09805_/S VDD VSS sg13g2_mux2_1
Xfanout279 _12227_/B _11724_/B VDD VSS sg13g2_buf_1
XFILLER_47_609 VDD VSS sg13g2_decap_8
X_07997_ _07997_/Y _15103_/Q _15090_/Q VDD VSS sg13g2_nor2_1
XFILLER_28_801 VDD VSS sg13g2_decap_8
X_09736_ _14327_/D _09934_/A1 _14327_/Q wire449/X VDD VSS sg13g2_mux2_1
XFILLER_28_834 VDD VSS sg13g2_decap_8
XFILLER_55_642 VDD VSS sg13g2_fill_2
XFILLER_28_867 VDD VSS sg13g2_fill_1
XFILLER_27_344 VDD VSS sg13g2_fill_1
X_09667_ _14260_/D _09898_/A0 _14260_/Q _09667_/S VDD VSS sg13g2_mux2_1
XFILLER_55_653 VDD VSS sg13g2_fill_1
XFILLER_76_1217 VDD VSS sg13g2_decap_8
XFILLER_27_366 VDD VSS sg13g2_decap_8
XFILLER_131_56 VDD VSS sg13g2_decap_8
X_08618_ _08622_/A _08030_/Y _08537_/X _08637_/B VDD VSS sg13g2_o21ai_1
XFILLER_91_16 VDD VSS sg13g2_decap_4
X_09598_ _14195_/D _14195_/Q _10062_/A0 _09599_/S VDD VSS sg13g2_mux2_1
XFILLER_43_859 VDD VSS sg13g2_decap_8
XFILLER_24_21 VDD VSS sg13g2_decap_8
XFILLER_70_667 VDD VSS sg13g2_decap_8
X_08549_ _08549_/Y _08522_/A _08529_/Y _08548_/Y VDD VSS sg13g2_a21oi_1
XFILLER_39_1072 VDD VSS sg13g2_fill_1
XFILLER_126_1020 VDD VSS sg13g2_fill_2
XFILLER_126_1031 VDD VSS sg13g2_fill_1
X_11560_ _11560_/Y _11540_/Y _11542_/X _11765_/A VDD VSS sg13g2_o21ai_1
Xwire603 wire603/X wire603/A VDD VSS sg13g2_buf_8
X_13738__2826 _13738_/RESET_B VDD VSS sg13g2_tiehi
X_10511_ _10512_/C _14850_/Q _14845_/Q _10511_/C _10511_/D VDD VSS sg13g2_nand4_1
X_11491_ _11491_/X _13730_/Q _14082_/Q _14434_/Q _14530_/Q _11493_/S0 _11493_/S1 VDD
+ VSS sg13g2_mux4_1
XFILLER_13_1223 VDD VSS sg13g2_decap_8
XFILLER_155_238 VDD VSS sg13g2_decap_8
X_13230_ _13244_/B _13245_/A _13665_/Q VDD VSS sg13g2_xor2_1
X_10442_ _10444_/A _14837_/Q _10442_/B VDD VSS sg13g2_nand2b_1
XFILLER_137_964 VDD VSS sg13g2_decap_8
XFILLER_108_132 VDD VSS sg13g2_decap_4
XFILLER_100_1226 VDD VSS sg13g2_decap_8
XFILLER_108_154 VDD VSS sg13g2_fill_1
XFILLER_156_42 VDD VSS sg13g2_decap_8
X_13161_ _13161_/X input19/X _12914_/A _13252_/B1 VDD VSS sg13g2_a21o_1
X_10373_ _10375_/A _14815_/Q _10378_/D _14816_/Q VDD VSS sg13g2_a21o_1
XFILLER_152_934 VDD VSS sg13g2_decap_8
XFILLER_123_113 VDD VSS sg13g2_decap_4
X_13953__2611 _13953_/RESET_B VDD VSS sg13g2_tiehi
X_12112_ _12112_/Y _12235_/A _13940_/Q _12088_/B VDD VSS sg13g2_a21oi_1
X_14118__2446 _14118_/RESET_B VDD VSS sg13g2_tiehi
XFILLER_2_432 VDD VSS sg13g2_decap_8
X_13092_ _13093_/B _13092_/A _13112_/A _13092_/C VDD VSS sg13g2_nand3_1
XFILLER_97_509 VDD VSS sg13g2_fill_2
XFILLER_123_157 VDD VSS sg13g2_decap_8
XFILLER_78_701 VDD VSS sg13g2_decap_8
X_12043_ _12043_/X _12036_/B _12042_/X _12041_/Y VDD VSS sg13g2_a21o_1
XFILLER_111_319 VDD VSS sg13g2_fill_2
Xfanout1701 _12255_/A1 _12259_/S0 VDD VSS sg13g2_buf_1
XFILLER_2_487 VDD VSS sg13g2_decap_8
Xfanout1712 _12288_/S0 fanout1713/X VDD VSS sg13g2_buf_1
XFILLER_132_691 VDD VSS sg13g2_decap_4
Xfanout1734 _11317_/A1 _11400_/A VDD VSS sg13g2_buf_1
XFILLER_46_1087 VDD VSS sg13g2_decap_8
XFILLER_104_393 VDD VSS sg13g2_decap_8
XFILLER_66_907 VDD VSS sg13g2_decap_4
Xfanout1745 _12306_/A fanout1753/X VDD VSS sg13g2_buf_1
XFILLER_133_1046 VDD VSS sg13g2_fill_2
Xfanout1756 _13266_/A _13319_/A VDD VSS sg13g2_buf_1
XFILLER_93_704 VDD VSS sg13g2_fill_2
XFILLER_1_14 VDD VSS sg13g2_decap_8
Xfanout1767 _10655_/B _10623_/A VDD VSS sg13g2_buf_1
XFILLER_120_875 VDD VSS sg13g2_fill_1
Xfanout1778 _10177_/A _13302_/C VDD VSS sg13g2_buf_1
Xfanout780 _09159_/A1 _09162_/A VDD VSS sg13g2_buf_1
Xfanout791 _08778_/B _13481_/C VDD VSS sg13g2_buf_1
X_14333__2231 _14333_/RESET_B VDD VSS sg13g2_tiehi
Xfanout1789 _10350_/C fanout1794/X VDD VSS sg13g2_buf_1
XFILLER_20_1205 VDD VSS sg13g2_decap_8
XFILLER_18_311 VDD VSS sg13g2_decap_8
X_13994_ _13994_/Q clkload25/A _13994_/D _13994_/RESET_B VDD VSS sg13g2_dfrbpq_1
X_13986__2578 _13986_/RESET_B VDD VSS sg13g2_tiehi
XFILLER_46_653 VDD VSS sg13g2_decap_8
X_12945_ _12945_/Y _12945_/A _12988_/B VDD VSS sg13g2_nor2_1
XFILLER_19_889 VDD VSS sg13g2_decap_4
XFILLER_74_973 VDD VSS sg13g2_fill_1
XFILLER_65_94 VDD VSS sg13g2_fill_2
XFILLER_60_100 VDD VSS sg13g2_fill_1
X_12876_ _12878_/B _12876_/A _12877_/C VDD VSS sg13g2_nand2_1
XFILLER_2_1192 VDD VSS sg13g2_decap_8
XFILLER_60_133 VDD VSS sg13g2_decap_8
X_14615_ _14615_/Q clkload3/A _14615_/D _14615_/RESET_B VDD VSS sg13g2_dfrbpq_1
XFILLER_92_1041 VDD VSS sg13g2_decap_4
X_11827_ _11827_/Y _11823_/Y _11824_/Y _11826_/Y _11825_/Y _11822_/B VDD VSS sg13g2_a221oi_1
XFILLER_60_155 VDD VSS sg13g2_fill_2
X_14366__2198 _14366_/RESET_B VDD VSS sg13g2_tiehi
XFILLER_144_1142 VDD VSS sg13g2_decap_8
XFILLER_18_1156 VDD VSS sg13g2_decap_8
X_11758_ _11760_/A _11759_/A _13898_/Q VDD VSS sg13g2_nand2b_1
XFILLER_60_188 VDD VSS sg13g2_decap_8
X_14546_ _14546_/Q _14738_/CLK _14546_/D _14546_/RESET_B VDD VSS sg13g2_dfrbpq_1
XFILLER_14_594 VDD VSS sg13g2_decap_8
XFILLER_81_93 VDD VSS sg13g2_decap_8
XFILLER_105_1126 VDD VSS sg13g2_fill_2
XFILLER_144_1186 VDD VSS sg13g2_fill_1
XFILLER_53_1069 VDD VSS sg13g2_fill_2
X_10709_ wire582/A _09027_/X _08877_/A _08873_/Y VDD VSS sg13g2_a21oi_1
XFILLER_140_1028 VDD VSS sg13g2_fill_2
XFILLER_140_1039 VDD VSS sg13g2_decap_8
X_14477_ _14477_/Q _14737_/CLK _14477_/D _14477_/RESET_B VDD VSS sg13g2_dfrbpq_1
X_11689_ _11689_/X _14120_/Q _14152_/Q _11692_/A VDD VSS sg13g2_mux2_1
X_13428_ _15096_/D _13421_/Y _13425_/Y _13427_/Y VDD VSS sg13g2_o21ai_1
Xmax_cap1053 _12692_/S _12635_/S1 VDD VSS sg13g2_buf_4
Xmax_cap1075 _12790_/S _12371_/S VDD VSS sg13g2_buf_4
XFILLER_6_760 VDD VSS sg13g2_decap_4
XFILLER_155_783 VDD VSS sg13g2_decap_8
X_13359_ _13438_/D _13401_/B _13401_/C VDD VSS sg13g2_nor2b_1
XFILLER_115_614 VDD VSS sg13g2_fill_2
XFILLER_114_113 VDD VSS sg13g2_fill_1
XFILLER_143_967 VDD VSS sg13g2_fill_1
XFILLER_114_135 VDD VSS sg13g2_decap_8
XFILLER_142_455 VDD VSS sg13g2_fill_1
XFILLER_64_1110 VDD VSS sg13g2_decap_8
X_07920_ _07920_/Y _07918_/Y _07871_/X _07911_/Y VDD VSS sg13g2_a21oi_1
XFILLER_116_1200 VDD VSS sg13g2_decap_8
X_15029_ _15029_/Q _15229_/CLK _15029_/D _15029_/RESET_B VDD VSS sg13g2_dfrbpq_1
XFILLER_102_319 VDD VSS sg13g2_decap_8
XFILLER_69_734 VDD VSS sg13g2_fill_1
XFILLER_25_1116 VDD VSS sg13g2_decap_8
X_07851_ _08641_/A _08643_/C _08646_/A VDD VSS sg13g2_nand2_1
XFILLER_96_564 VDD VSS sg13g2_decap_8
XFILLER_56_406 VDD VSS sg13g2_decap_8
XFILLER_99_1217 VDD VSS sg13g2_decap_8
XFILLER_151_1168 VDD VSS sg13g2_decap_8
XFILLER_84_737 VDD VSS sg13g2_decap_4
X_07782_ _07784_/B _07782_/A _15002_/Q VDD VSS sg13g2_and2_1
Xinput2 input2/X input2/A VDD VSS sg13g2_buf_1
XFILLER_56_439 VDD VSS sg13g2_decap_8
XFILLER_37_620 VDD VSS sg13g2_decap_4
XFILLER_49_480 VDD VSS sg13g2_fill_1
X_13816__2748 _13816_/RESET_B VDD VSS sg13g2_tiehi
X_09521_ _14120_/D _09655_/A0 _14120_/Q _09523_/S VDD VSS sg13g2_mux2_1
XFILLER_37_642 VDD VSS sg13g2_decap_8
X_14576__1988 _14576_/RESET_B VDD VSS sg13g2_tiehi
XFILLER_149_1020 VDD VSS sg13g2_decap_4
XFILLER_149_1042 VDD VSS sg13g2_fill_2
X_09452_ _14053_/D _09850_/A1 _14053_/Q _09470_/S VDD VSS sg13g2_mux2_1
XFILLER_25_837 VDD VSS sg13g2_decap_4
XFILLER_24_303 VDD VSS sg13g2_decap_8
XFILLER_64_472 VDD VSS sg13g2_fill_1
XFILLER_24_314 VDD VSS sg13g2_fill_2
XFILLER_36_185 VDD VSS sg13g2_decap_8
X_08403_ _08410_/D _15100_/Q _15089_/Q _08574_/B VDD VSS sg13g2_o21ai_1
XFILLER_51_133 VDD VSS sg13g2_decap_8
XFILLER_24_358 VDD VSS sg13g2_decap_4
X_09383_ _13986_/D _09649_/A0 _13986_/Q _09404_/S VDD VSS sg13g2_mux2_1
XFILLER_36_1201 VDD VSS sg13g2_decap_8
X_08334_ _08335_/D _08359_/B2 _08333_/Y _08637_/B _08330_/Y VDD VSS sg13g2_a22oi_1
XFILLER_32_1109 VDD VSS sg13g2_fill_2
X_08265_ _08265_/X _08265_/A _08265_/B _08319_/A _08319_/C VDD VSS sg13g2_or4_1
XFILLER_20_586 VDD VSS sg13g2_fill_2
XFILLER_119_953 VDD VSS sg13g2_decap_8
XFILLER_153_709 VDD VSS sg13g2_decap_4
X_08196_ _08196_/Y _08599_/B _08079_/X _08688_/A VDD VSS sg13g2_o21ai_1
XFILLER_69_1032 VDD VSS sg13g2_decap_8
X_14411__2153 _14411_/RESET_B VDD VSS sg13g2_tiehi
XFILLER_146_783 VDD VSS sg13g2_decap_8
XFILLER_145_282 VDD VSS sg13g2_fill_2
XFILLER_105_113 VDD VSS sg13g2_decap_8
XFILLER_10_56 VDD VSS sg13g2_decap_8
XFILLER_106_669 VDD VSS sg13g2_decap_4
XFILLER_121_606 VDD VSS sg13g2_fill_1
XFILLER_126_56 VDD VSS sg13g2_decap_4
Xfanout1008 _11151_/A _11043_/A VDD VSS sg13g2_buf_1
Xfanout1019 _08167_/A _08125_/S VDD VSS sg13g2_buf_1
XFILLER_19_21 VDD VSS sg13g2_decap_8
XFILLER_113_190 VDD VSS sg13g2_decap_8
XFILLER_74_203 VDD VSS sg13g2_fill_1
XFILLER_75_737 VDD VSS sg13g2_fill_1
XFILLER_74_225 VDD VSS sg13g2_fill_1
XFILLER_75_748 VDD VSS sg13g2_decap_8
XFILLER_142_77 VDD VSS sg13g2_fill_2
X_09719_ _14310_/D _09884_/A0 _14310_/Q _09739_/S VDD VSS sg13g2_mux2_1
X_10991_ _10992_/B _10979_/Y _10978_/B _10974_/Y VDD VSS sg13g2_o21ai_1
XFILLER_90_729 VDD VSS sg13g2_decap_8
XFILLER_28_686 VDD VSS sg13g2_fill_1
XFILLER_27_163 VDD VSS sg13g2_decap_4
XFILLER_28_697 VDD VSS sg13g2_decap_8
X_12730_ _12730_/X _13846_/Q _13878_/Q _13910_/Q _13942_/Q _12755_/S0 _12759_/S1 VDD
+ VSS sg13g2_mux4_1
XFILLER_76_1047 VDD VSS sg13g2_fill_1
XFILLER_35_53 VDD VSS sg13g2_fill_2
XFILLER_27_196 VDD VSS sg13g2_decap_8
XFILLER_37_1009 VDD VSS sg13g2_fill_1
XFILLER_42_133 VDD VSS sg13g2_decap_8
X_12661_ _12661_/X _14257_/Q _14289_/Q _14321_/Q _14353_/Q _12661_/S0 _12661_/S1 VDD
+ VSS sg13g2_mux4_1
XFILLER_71_998 VDD VSS sg13g2_fill_1
X_11612_ _11612_/Y _11614_/S0 _14502_/Q _12088_/B VDD VSS sg13g2_a21oi_1
X_14400_ _14400_/Q _14917_/CLK _14400_/D _14400_/RESET_B VDD VSS sg13g2_dfrbpq_1
XFILLER_30_328 VDD VSS sg13g2_decap_8
X_14621__1943 _14621_/RESET_B VDD VSS sg13g2_tiehi
X_12592_ _12592_/X _14700_/Q _14732_/Q _13772_/Q _13804_/Q _12592_/S0 _12592_/S1 VDD
+ VSS sg13g2_mux4_1
XFILLER_136_0 VDD VSS sg13g2_decap_8
X_11543_ _11543_/Y _11555_/S0 _14372_/Q VDD VSS sg13g2_nand2b_1
X_14331_ _14331_/Q _15188_/CLK _14331_/D _14331_/RESET_B VDD VSS sg13g2_dfrbpq_1
XFILLER_128_227 VDD VSS sg13g2_fill_2
XFILLER_13_1020 VDD VSS sg13g2_decap_8
Xwire444 wire444/X wire444/A VDD VSS sg13g2_buf_4
X_14262_ _14262_/Q clkload24/A _14262_/D _14262_/RESET_B VDD VSS sg13g2_dfrbpq_1
X_11474_ _11475_/B _11471_/X _11470_/X _11467_/X _11466_/X _11761_/C _12263_/C VDD
+ VSS sg13g2_mux4_1
XFILLER_137_772 VDD VSS sg13g2_decap_8
X_13213_ _13215_/A _14921_/Q _13666_/Q VDD VSS sg13g2_xor2_1
X_10425_ _10538_/A _10670_/A _10510_/B VDD VSS sg13g2_nand2_1
X_14193_ _14193_/Q clkload44/A _14193_/D _14193_/RESET_B VDD VSS sg13g2_dfrbpq_1
XFILLER_13_1097 VDD VSS sg13g2_decap_8
XFILLER_109_496 VDD VSS sg13g2_decap_4
XFILLER_136_293 VDD VSS sg13g2_decap_8
XFILLER_100_1056 VDD VSS sg13g2_fill_1
X_13144_ _13145_/A _13146_/A _13146_/C VDD VSS sg13g2_nand2_1
XFILLER_152_753 VDD VSS sg13g2_fill_1
X_10356_ _10364_/C _10359_/A _10397_/B _10395_/A VDD VSS sg13g2_nor3_1
XFILLER_152_764 VDD VSS sg13g2_decap_8
XFILLER_140_904 VDD VSS sg13g2_decap_8
XFILLER_100_1089 VDD VSS sg13g2_decap_8
XFILLER_2_240 VDD VSS sg13g2_decap_8
XFILLER_140_937 VDD VSS sg13g2_decap_8
XFILLER_124_488 VDD VSS sg13g2_decap_8
X_13075_ _13172_/B _14911_/Q _13676_/Q VDD VSS sg13g2_xor2_1
X_10287_ _10298_/D _14788_/Q _14789_/Q _14790_/Q _10305_/B VDD VSS sg13g2_and4_1
XFILLER_105_680 VDD VSS sg13g2_decap_8
XFILLER_151_296 VDD VSS sg13g2_decap_8
X_12026_ _12027_/B _12026_/A _12026_/B _12026_/C VDD VSS sg13g2_nand3_1
Xfanout1520 _12835_/A _14896_/Q VDD VSS sg13g2_buf_1
XFILLER_111_149 VDD VSS sg13g2_fill_2
Xfanout1531 _10511_/D _14843_/Q VDD VSS sg13g2_buf_1
XFILLER_104_190 VDD VSS sg13g2_decap_8
XFILLER_25_7 VDD VSS sg13g2_decap_8
XFILLER_78_564 VDD VSS sg13g2_decap_4
Xfanout1575 _13189_/B _13669_/Q VDD VSS sg13g2_buf_1
Xfanout1586 _11832_/C _12265_/B1 VDD VSS sg13g2_buf_1
Xfanout1597 _11224_/A _11284_/B1 VDD VSS sg13g2_buf_1
XFILLER_20_1002 VDD VSS sg13g2_decap_8
XFILLER_65_236 VDD VSS sg13g2_fill_2
X_13977_ _13977_/Q _14745_/CLK _13977_/D _13977_/RESET_B VDD VSS sg13g2_dfrbpq_1
XFILLER_18_152 VDD VSS sg13g2_decap_8
XFILLER_47_984 VDD VSS sg13g2_fill_1
XFILLER_111_1163 VDD VSS sg13g2_decap_8
XFILLER_47_995 VDD VSS sg13g2_decap_8
XFILLER_34_623 VDD VSS sg13g2_decap_8
XFILLER_59_1234 VDD VSS sg13g2_fill_2
XFILLER_80_228 VDD VSS sg13g2_decap_8
XFILLER_20_1079 VDD VSS sg13g2_decap_8
X_12928_ _12928_/X _12988_/A _12928_/B VDD VSS sg13g2_xor2_1
XFILLER_18_196 VDD VSS sg13g2_decap_4
XFILLER_22_807 VDD VSS sg13g2_decap_8
XFILLER_33_144 VDD VSS sg13g2_decap_8
XFILLER_33_155 VDD VSS sg13g2_fill_1
X_12859_ _12861_/B _12859_/A _13689_/Q VDD VSS sg13g2_xnor2_1
XFILLER_92_92 VDD VSS sg13g2_decap_4
XFILLER_21_317 VDD VSS sg13g2_fill_1
XFILLER_15_892 VDD VSS sg13g2_decap_8
XFILLER_109_1092 VDD VSS sg13g2_decap_8
XFILLER_30_862 VDD VSS sg13g2_decap_4
X_14529_ _14529_/Q clkload28/A _14529_/D _14529_/RESET_B VDD VSS sg13g2_dfrbpq_1
XFILLER_119_216 VDD VSS sg13g2_decap_8
X_08050_ _08050_/Y _15102_/Q _15094_/Q _08692_/B VDD VSS sg13g2_o21ai_1
XFILLER_31_1153 VDD VSS sg13g2_decap_8
XFILLER_155_580 VDD VSS sg13g2_decap_8
XFILLER_155_591 VDD VSS sg13g2_fill_2
XFILLER_51_0 VDD VSS sg13g2_decap_8
XFILLER_142_230 VDD VSS sg13g2_fill_1
XFILLER_66_1227 VDD VSS sg13g2_decap_8
Xmax_cap766 _10004_/C _09375_/B VDD VSS sg13g2_buf_1
XFILLER_143_775 VDD VSS sg13g2_decap_8
XFILLER_88_306 VDD VSS sg13g2_fill_2
XFILLER_131_926 VDD VSS sg13g2_decap_4
Xmax_cap799 _08241_/B _08397_/B VDD VSS sg13g2_buf_2
XFILLER_153_1219 VDD VSS sg13g2_decap_8
X_08952_ _08952_/Y _08835_/A _08835_/B _16883_/A VDD VSS sg13g2_a21oi_1
XFILLER_103_639 VDD VSS sg13g2_fill_1
X_07903_ _08402_/B _08063_/A _07903_/B VDD VSS sg13g2_nand2_1
X_08883_ _13704_/D _13704_/Q _08882_/X _08892_/S VDD VSS sg13g2_mux2_1
XFILLER_9_1176 VDD VSS sg13g2_decap_8
XFILLER_29_406 VDD VSS sg13g2_fill_2
XFILLER_56_203 VDD VSS sg13g2_decap_8
X_07834_ _07974_/D _07834_/A _07834_/B VDD VSS sg13g2_nor2_1
XFILLER_69_597 VDD VSS sg13g2_fill_1
X_07765_ _15215_/D _15099_/Q _15088_/Q _15076_/Q VDD VSS sg13g2_or3_1
XFILLER_112_14 VDD VSS sg13g2_decap_8
XFILLER_37_472 VDD VSS sg13g2_decap_8
X_09504_ _14104_/D _09935_/A1 _14104_/Q wire482/X VDD VSS sg13g2_mux2_1
X_14860__3209 _14860_/RESET_B VDD VSS sg13g2_tiehi
X_07696_ _15203_/D _07696_/A _07696_/B _07696_/C VDD VSS sg13g2_nand3_1
X_14429__2135 _14429_/RESET_B VDD VSS sg13g2_tiehi
XFILLER_64_291 VDD VSS sg13g2_fill_1
XFILLER_80_751 VDD VSS sg13g2_fill_1
X_09435_ _14037_/D _10097_/A0 _14037_/Q _09439_/S VDD VSS sg13g2_mux2_1
XFILLER_53_976 VDD VSS sg13g2_fill_1
XFILLER_80_762 VDD VSS sg13g2_decap_8
XFILLER_13_818 VDD VSS sg13g2_decap_8
XFILLER_53_987 VDD VSS sg13g2_fill_1
XFILLER_52_475 VDD VSS sg13g2_fill_2
XFILLER_53_998 VDD VSS sg13g2_decap_8
XFILLER_36_1020 VDD VSS sg13g2_decap_8
X_09366_ _13970_/D _09962_/A1 _13970_/Q _09373_/S VDD VSS sg13g2_mux2_1
XFILLER_75_1091 VDD VSS sg13g2_decap_4
XFILLER_36_1053 VDD VSS sg13g2_fill_1
XFILLER_127_1170 VDD VSS sg13g2_fill_2
X_08317_ _08418_/A _08315_/Y _08318_/D _08316_/Y VDD VSS sg13g2_a21oi_1
XFILLER_127_1192 VDD VSS sg13g2_decap_8
X_09297_ _13905_/D _13905_/Q _09730_/A0 _09297_/S VDD VSS sg13g2_mux2_1
XFILLER_138_558 VDD VSS sg13g2_decap_4
X_08248_ _08248_/Y _08584_/A _08319_/A _08319_/C VDD VSS sg13g2_nor3_1
XFILLER_123_1078 VDD VSS sg13g2_decap_4
X_14944__3041 _14944_/RESET_B VDD VSS sg13g2_tiehi
XFILLER_118_260 VDD VSS sg13g2_fill_1
X_08179_ _08179_/Y _08402_/C _08066_/Y _08178_/Y VDD VSS sg13g2_o21ai_1
XFILLER_107_934 VDD VSS sg13g2_decap_4
XFILLER_119_794 VDD VSS sg13g2_decap_8
XFILLER_21_77 VDD VSS sg13g2_decap_8
X_10210_ _10210_/Y _13499_/B _14749_/Q _10210_/C wire954/X VDD VSS sg13g2_nand4_1
XFILLER_4_549 VDD VSS sg13g2_decap_8
XFILLER_107_956 VDD VSS sg13g2_decap_8
XFILLER_134_753 VDD VSS sg13g2_fill_2
XFILLER_137_77 VDD VSS sg13g2_decap_8
X_11190_ _11205_/B _11190_/A _11199_/B _11190_/C VDD VSS sg13g2_nor3_1
XFILLER_97_37 VDD VSS sg13g2_fill_2
XFILLER_121_403 VDD VSS sg13g2_fill_1
X_10141_ _14718_/D _14718_/Q _10141_/A1 _10157_/S VDD VSS sg13g2_mux2_1
XFILLER_106_488 VDD VSS sg13g2_decap_4
XFILLER_121_425 VDD VSS sg13g2_decap_4
XFILLER_153_21 VDD VSS sg13g2_decap_8
X_10072_ _14652_/D _10072_/A0 _14652_/Q _10090_/S VDD VSS sg13g2_mux2_1
XFILLER_0_799 VDD VSS sg13g2_decap_8
X_14639__1925 _14639_/RESET_B VDD VSS sg13g2_tiehi
X_13900_ _13900_/Q clkload54/A _13900_/D _13900_/RESET_B VDD VSS sg13g2_dfrbpq_1
XFILLER_130_1005 VDD VSS sg13g2_decap_8
XFILLER_87_383 VDD VSS sg13g2_decap_8
XFILLER_153_98 VDD VSS sg13g2_decap_8
X_14880_ _14880_/Q clkload78/A _14880_/D _14880_/RESET_B VDD VSS sg13g2_dfrbpq_1
XFILLER_47_225 VDD VSS sg13g2_decap_8
X_14821__3277 _14821_/RESET_B VDD VSS sg13g2_tiehi
XFILLER_47_236 VDD VSS sg13g2_fill_1
X_13831_ _13831_/Q _14725_/CLK _13831_/D _13831_/RESET_B VDD VSS sg13g2_dfrbpq_1
XFILLER_63_707 VDD VSS sg13g2_decap_8
X_15122__3100 _15122_/RESET_B VDD VSS sg13g2_tiehi
X_14068__2496 _14068_/RESET_B VDD VSS sg13g2_tiehi
X_13762_ _13762_/Q clkload22/A _13762_/D _13762_/RESET_B VDD VSS sg13g2_dfrbpq_1
X_10974_ _10974_/Y wire385/X _15115_/Q VDD VSS sg13g2_nand2b_1
XFILLER_44_965 VDD VSS sg13g2_decap_8
X_12713_ _12713_/X _13749_/Q _14101_/Q _14453_/Q _14549_/Q _12770_/S0 _12770_/S1 VDD
+ VSS sg13g2_mux4_1
XFILLER_44_998 VDD VSS sg13g2_decap_8
X_13693_ _13693_/Q clkload61/A _13693_/D _13693_/RESET_B VDD VSS sg13g2_dfrbpq_1
X_15007__2965 _15007_/RESET_B VDD VSS sg13g2_tiehi
XFILLER_31_648 VDD VSS sg13g2_fill_1
XFILLER_62_51 VDD VSS sg13g2_fill_1
X_12644_ _12644_/X _14576_/Q _14608_/Q _14640_/Q _14672_/Q _12646_/S0 _12647_/S1 VDD
+ VSS sg13g2_mux4_1
XFILLER_30_136 VDD VSS sg13g2_decap_4
XFILLER_62_73 VDD VSS sg13g2_decap_8
XFILLER_62_84 VDD VSS sg13g2_fill_1
X_14283__2281 _14283_/RESET_B VDD VSS sg13g2_tiehi
XFILLER_15_1115 VDD VSS sg13g2_decap_8
XFILLER_106_1232 VDD VSS sg13g2_decap_4
XFILLER_30_169 VDD VSS sg13g2_decap_8
X_12575_ _12575_/X _13835_/Q _13867_/Q _13899_/Q _13931_/Q _12773_/S0 _12773_/S1 VDD
+ VSS sg13g2_mux4_1
XFILLER_7_310 VDD VSS sg13g2_decap_8
XFILLER_50_1028 VDD VSS sg13g2_decap_4
X_14314_ _14314_/Q clkload25/A _14314_/D _14314_/RESET_B VDD VSS sg13g2_dfrbpq_1
XFILLER_7_35 VDD VSS sg13g2_decap_8
X_11526_ _11636_/B _11526_/A _12942_/B VDD VSS sg13g2_xor2_1
XFILLER_102_1118 VDD VSS sg13g2_fill_1
Xwire252 wire252/X wire252/A VDD VSS sg13g2_buf_2
XFILLER_141_1189 VDD VSS sg13g2_decap_4
XFILLER_144_528 VDD VSS sg13g2_decap_8
XFILLER_156_399 VDD VSS sg13g2_decap_8
X_14245_ _14245_/Q _14405_/CLK _14245_/D _14245_/RESET_B VDD VSS sg13g2_dfrbpq_1
X_11457_ _11457_/Y _11457_/A _11457_/B _11457_/C VDD VSS sg13g2_nand3_1
X_10408_ _10408_/Y _14825_/Q _10406_/A _10557_/C VDD VSS sg13g2_o21ai_1
X_14176_ _14176_/Q clkload9/A _14176_/D _14176_/RESET_B VDD VSS sg13g2_dfrbpq_1
X_11388_ _11388_/Y _11418_/A _13823_/Q VDD VSS sg13g2_nand2b_1
XFILLER_125_764 VDD VSS sg13g2_decap_4
XFILLER_113_926 VDD VSS sg13g2_decap_8
XFILLER_112_414 VDD VSS sg13g2_decap_8
X_10339_ _10357_/D _10345_/C _10345_/D VDD VSS sg13g2_and2_1
X_13127_ _15041_/D _13155_/A _13127_/B VDD VSS sg13g2_nor2_1
XFILLER_97_136 VDD VSS sg13g2_fill_1
X_14507__2057 _14507_/RESET_B VDD VSS sg13g2_tiehi
XFILLER_26_1233 VDD VSS sg13g2_decap_4
X_13058_ _13058_/Y _13058_/A _13058_/B _13058_/C _13058_/D VDD VSS sg13g2_nand4_1
XFILLER_140_778 VDD VSS sg13g2_fill_1
Xfanout1350 _08201_/A _08429_/A VDD VSS sg13g2_buf_1
X_12009_ _12010_/B _12009_/A _13670_/Q VDD VSS sg13g2_nand2_1
Xfanout1361 _08200_/A _08142_/B VDD VSS sg13g2_buf_1
XFILLER_61_1168 VDD VSS sg13g2_decap_4
Xfanout1372 _08621_/B _13525_/A VDD VSS sg13g2_buf_1
Xfanout1383 _07884_/A _08337_/S1 VDD VSS sg13g2_buf_1
XFILLER_93_331 VDD VSS sg13g2_decap_4
Xfanout1394 _08005_/S0 _13517_/A VDD VSS sg13g2_buf_1
XFILLER_4_1040 VDD VSS sg13g2_decap_4
XFILLER_66_589 VDD VSS sg13g2_decap_8
XFILLER_4_1062 VDD VSS sg13g2_decap_8
X_13733__2831 _13733_/RESET_B VDD VSS sg13g2_tiehi
XFILLER_146_1034 VDD VSS sg13g2_decap_8
XFILLER_22_604 VDD VSS sg13g2_decap_8
X_09220_ _13831_/D _10150_/A1 _13831_/Q _09232_/S VDD VSS sg13g2_mux2_1
XFILLER_99_0 VDD VSS sg13g2_decap_8
XFILLER_33_1204 VDD VSS sg13g2_decap_8
X_09151_ _09151_/Y _09158_/A _09151_/B _09156_/B VDD VSS sg13g2_nand3_1
X_14113__2451 _14113_/RESET_B VDD VSS sg13g2_tiehi
X_13766__2798 _13766_/RESET_B VDD VSS sg13g2_tiehi
X_08102_ _08103_/C _07893_/B _07910_/B _08171_/A1 _07870_/A _08402_/A _08063_/A VDD
+ VSS sg13g2_mux4_1
XFILLER_147_344 VDD VSS sg13g2_decap_4
X_09082_ _09082_/Y _09090_/A _09082_/B _09087_/B VDD VSS sg13g2_nand3_1
XFILLER_147_355 VDD VSS sg13g2_fill_1
X_14717__1847 _14717_/RESET_B VDD VSS sg13g2_tiehi
X_08033_ _08036_/A _08402_/A _08402_/B VDD VSS sg13g2_nor2_1
XFILLER_147_399 VDD VSS sg13g2_fill_2
XFILLER_107_14 VDD VSS sg13g2_decap_8
XFILLER_89_615 VDD VSS sg13g2_decap_8
XFILLER_143_572 VDD VSS sg13g2_fill_1
XFILLER_103_403 VDD VSS sg13g2_fill_2
X_13981__2583 _13981_/RESET_B VDD VSS sg13g2_tiehi
XFILLER_143_583 VDD VSS sg13g2_decap_8
XFILLER_66_1068 VDD VSS sg13g2_decap_4
XFILLER_153_1027 VDD VSS sg13g2_decap_8
X_09984_ _14567_/D _10017_/A0 _14567_/Q _10000_/S VDD VSS sg13g2_mux2_1
XFILLER_104_959 VDD VSS sg13g2_fill_1
XFILLER_153_1049 VDD VSS sg13g2_decap_4
Xclkbuf_leaf_62_clk_i _14670_/CLK clkbuf_leaf_62_clk_i/A VDD VSS sg13g2_buf_8
XFILLER_118_1169 VDD VSS sg13g2_decap_8
X_08935_ _13717_/D _16879_/A _08934_/X _08935_/S VDD VSS sg13g2_mux2_1
XFILLER_130_255 VDD VSS sg13g2_decap_8
XFILLER_57_512 VDD VSS sg13g2_fill_2
X_08866_ _08866_/X _15030_/Q _10694_/S _08865_/Y VDD VSS sg13g2_a21o_1
XFILLER_123_35 VDD VSS sg13g2_decap_8
X_07817_ _08527_/A _15010_/Q _07818_/B VDD VSS sg13g2_xor2_1
X_08797_ _08799_/A _10885_/A1 _14755_/Q _08727_/X _15198_/Q _08809_/C1 VDD VSS sg13g2_a221oi_1
XFILLER_72_515 VDD VSS sg13g2_decap_8
XFILLER_83_28 VDD VSS sg13g2_decap_8
X_15195__3150 _15195_/RESET_B VDD VSS sg13g2_tiehi
Xclkbuf_leaf_77_clk_i clkload70/A clkbuf_leaf_83_clk_i/A VDD VSS sg13g2_buf_8
XFILLER_83_39 VDD VSS sg13g2_fill_2
XFILLER_77_1120 VDD VSS sg13g2_decap_4
X_07748_ _07748_/Y _11241_/A _07748_/B _13506_/A _13308_/A VDD VSS sg13g2_nand4_1
XFILLER_26_976 VDD VSS sg13g2_decap_8
X_07679_ _07679_/Y _15084_/Q _15085_/Q _15083_/Q _07679_/D VDD VSS sg13g2_nor4_1
XFILLER_25_486 VDD VSS sg13g2_fill_2
XFILLER_16_77 VDD VSS sg13g2_decap_8
XFILLER_52_261 VDD VSS sg13g2_decap_8
XFILLER_77_1197 VDD VSS sg13g2_decap_8
XFILLER_73_1039 VDD VSS sg13g2_decap_8
X_09418_ _14020_/D _09616_/A0 _14020_/Q _09424_/S VDD VSS sg13g2_mux2_1
X_10690_ _14899_/D _10886_/B1 _10876_/A _10689_/Y VDD VSS sg13g2_o21ai_1
XFILLER_32_21 VDD VSS sg13g2_decap_8
X_09349_ _13953_/D _10077_/A0 _13953_/Q _09358_/S VDD VSS sg13g2_mux2_1
XFILLER_138_322 VDD VSS sg13g2_decap_8
XFILLER_148_21 VDD VSS sg13g2_decap_8
X_15151__3040 _15151_/RESET_B VDD VSS sg13g2_tiehi
X_12360_ _14989_/D _13550_/A1 _12638_/A2 _12359_/Y _12356_/Y VDD VSS sg13g2_a22oi_1
X_11311_ _11311_/Y _11307_/Y _11308_/Y _11310_/Y _11309_/Y _11420_/C VDD VSS sg13g2_a221oi_1
XFILLER_138_377 VDD VSS sg13g2_fill_1
XFILLER_138_388 VDD VSS sg13g2_fill_1
Xclkbuf_leaf_15_clk_i _14917_/CLK clkbuf_5_6__f_clk_i/X VDD VSS sg13g2_buf_8
XFILLER_126_528 VDD VSS sg13g2_decap_8
X_12291_ _12292_/B _12291_/A _12291_/B VDD VSS sg13g2_nor2_1
XFILLER_153_336 VDD VSS sg13g2_decap_4
X_14030_ _14030_/Q _15188_/CLK _14030_/D _14030_/RESET_B VDD VSS sg13g2_dfrbpq_1
XFILLER_10_1045 VDD VSS sg13g2_decap_8
X_11242_ _13298_/B _13300_/C _13048_/B VDD VSS sg13g2_nor2_1
XFILLER_101_1173 VDD VSS sg13g2_decap_4
XFILLER_107_775 VDD VSS sg13g2_fill_1
XFILLER_84_1135 VDD VSS sg13g2_fill_2
XFILLER_122_701 VDD VSS sg13g2_fill_1
X_13811__2753 _13811_/RESET_B VDD VSS sg13g2_tiehi
X_11173_ _11173_/Y _11150_/B _11173_/B _11173_/C VDD VSS sg13g2_nand3b_1
X_14571__1993 _14571_/RESET_B VDD VSS sg13g2_tiehi
XFILLER_106_285 VDD VSS sg13g2_decap_8
X_15164__2902 _15164_/RESET_B VDD VSS sg13g2_tiehi
X_10124_ _14702_/D _10157_/A1 _14702_/Q _10124_/S VDD VSS sg13g2_mux2_1
XFILLER_95_607 VDD VSS sg13g2_decap_8
Xhold3480 _13623_/A _13731_/Q VDD VSS sg13g2_dlygate4sd3_1
XFILLER_48_523 VDD VSS sg13g2_decap_8
Xhold3491 _13626_/A _13734_/Q VDD VSS sg13g2_dlygate4sd3_1
X_14932_ _14932_/Q clkload39/A _14932_/D _14932_/RESET_B VDD VSS sg13g2_dfrbpq_1
X_10055_ _14636_/D _10155_/A1 _14636_/Q _10068_/S VDD VSS sg13g2_mux2_1
XFILLER_0_596 VDD VSS sg13g2_fill_2
X_14155__2409 _14155_/RESET_B VDD VSS sg13g2_tiehi
XFILLER_36_718 VDD VSS sg13g2_fill_2
XFILLER_57_95 VDD VSS sg13g2_fill_1
XFILLER_63_504 VDD VSS sg13g2_fill_1
X_14863_ _14863_/Q clkload69/A _14863_/D _14863_/RESET_B VDD VSS sg13g2_dfrbpq_1
XFILLER_21_1152 VDD VSS sg13g2_decap_8
X_13814_ _13814_/Q clkload24/A _13814_/D _13814_/RESET_B VDD VSS sg13g2_dfrbpq_1
X_14794_ _14794_/Q clkload81/A _14794_/D _14794_/RESET_B VDD VSS sg13g2_dfrbpq_1
XFILLER_16_420 VDD VSS sg13g2_fill_2
XFILLER_56_1215 VDD VSS sg13g2_decap_8
XFILLER_17_987 VDD VSS sg13g2_decap_8
X_13745_ _13745_/Q clkload45/A _13745_/D _13745_/RESET_B VDD VSS sg13g2_dfrbpq_1
X_10957_ _10957_/Y _10954_/C _11207_/A2 _10985_/B1 VDD VSS sg13g2_a21oi_1
XFILLER_90_389 VDD VSS sg13g2_decap_8
XFILLER_44_784 VDD VSS sg13g2_decap_8
XFILLER_43_272 VDD VSS sg13g2_fill_2
XFILLER_92_7 VDD VSS sg13g2_decap_8
XFILLER_32_968 VDD VSS sg13g2_fill_1
X_13676_ _13676_/Q clkload64/A _13676_/D _13676_/RESET_B VDD VSS sg13g2_dfrbpq_1
X_10888_ _10888_/Y _10923_/A _14755_/Q VDD VSS sg13g2_nor2b_1
XFILLER_148_119 VDD VSS sg13g2_decap_8
XFILLER_31_478 VDD VSS sg13g2_fill_1
X_12627_ _12627_/X _13967_/Q _13999_/Q _14031_/Q _14063_/Q _12630_/S0 _12689_/S1 VDD
+ VSS sg13g2_mux4_1
XFILLER_12_681 VDD VSS sg13g2_decap_8
XFILLER_106_1062 VDD VSS sg13g2_fill_1
X_12558_ _12558_/X _14698_/Q _14730_/Q _13770_/Q _13802_/Q _12564_/S0 _12564_/S1 VDD
+ VSS sg13g2_mux4_1
XFILLER_129_366 VDD VSS sg13g2_fill_1
XFILLER_145_848 VDD VSS sg13g2_decap_8
X_11509_ _11509_/X _14371_/Q _14403_/Q _14467_/Q _14499_/Q _11710_/S0 _11715_/S1 VDD
+ VSS sg13g2_mux4_1
X_12489_ _12489_/X _14373_/Q _14405_/Q _14469_/Q _14501_/Q _12743_/S0 _12743_/S1 VDD
+ VSS sg13g2_mux4_1
X_14228_ _14228_/Q clkload33/A _14228_/D _14228_/RESET_B VDD VSS sg13g2_dfrbpq_1
XFILLER_99_902 VDD VSS sg13g2_decap_4
XFILLER_153_881 VDD VSS sg13g2_decap_8
XFILLER_125_572 VDD VSS sg13g2_decap_8
X_14159_ _14159_/Q clkload13/A _14159_/D _14159_/RESET_B VDD VSS sg13g2_dfrbpq_1
XFILLER_99_957 VDD VSS sg13g2_fill_1
XFILLER_113_778 VDD VSS sg13g2_decap_4
XFILLER_98_478 VDD VSS sg13g2_decap_8
XFILLER_112_266 VDD VSS sg13g2_decap_8
XFILLER_65_1090 VDD VSS sg13g2_fill_1
XFILLER_6_1124 VDD VSS sg13g2_decap_8
XFILLER_79_692 VDD VSS sg13g2_decap_8
XFILLER_85_128 VDD VSS sg13g2_decap_8
X_08720_ _15213_/D _15192_/D _15122_/Q _13656_/S VDD VSS sg13g2_mux2_1
XFILLER_100_439 VDD VSS sg13g2_decap_8
XFILLER_14_0 VDD VSS sg13g2_decap_8
Xfanout1180 _12758_/S0 fanout1181/X VDD VSS sg13g2_buf_1
XFILLER_113_1044 VDD VSS sg13g2_decap_8
X_08651_ _15246_/D _08685_/A1 _08650_/X _08640_/X VDD VSS sg13g2_o21ai_1
Xfanout1191 _12787_/S0 fanout1194/X VDD VSS sg13g2_buf_1
XFILLER_82_813 VDD VSS sg13g2_decap_8
XFILLER_93_172 VDD VSS sg13g2_fill_2
XFILLER_113_1099 VDD VSS sg13g2_decap_4
X_08582_ _08583_/B _08641_/D _08577_/B _08612_/S VDD VSS sg13g2_a21oi_1
XFILLER_23_935 VDD VSS sg13g2_decap_8
XFILLER_50_721 VDD VSS sg13g2_decap_4
XFILLER_90_890 VDD VSS sg13g2_decap_8
XFILLER_22_423 VDD VSS sg13g2_decap_8
X_13999__2565 _13999_/RESET_B VDD VSS sg13g2_tiehi
XFILLER_23_979 VDD VSS sg13g2_decap_8
XFILLER_22_456 VDD VSS sg13g2_decap_8
X_09203_ _09375_/B _09641_/A _09204_/C _09204_/D VDD VSS sg13g2_nor3_1
XFILLER_37_1181 VDD VSS sg13g2_decap_8
XFILLER_72_1061 VDD VSS sg13g2_decap_8
XFILLER_33_1023 VDD VSS sg13g2_fill_1
X_09134_ _10776_/A _15048_/Q _15245_/Q _09147_/B VDD VSS sg13g2_mux2_1
XFILLER_124_1151 VDD VSS sg13g2_decap_8
XFILLER_148_653 VDD VSS sg13g2_decap_8
XFILLER_148_664 VDD VSS sg13g2_decap_8
XFILLER_147_163 VDD VSS sg13g2_decap_8
XFILLER_33_1089 VDD VSS sg13g2_decap_8
X_09065_ _09065_/Y _15235_/Q _13305_/A VDD VSS sg13g2_nand2b_1
XFILLER_68_1108 VDD VSS sg13g2_fill_2
X_14379__2185 _14379_/RESET_B VDD VSS sg13g2_tiehi
X_08016_ _08016_/Y _08332_/A1 _08015_/Y _08008_/Y VDD VSS sg13g2_a21oi_1
XFILLER_118_35 VDD VSS sg13g2_decap_8
XFILLER_104_701 VDD VSS sg13g2_decap_8
Xmax_cap382 _11115_/A _11086_/B VDD VSS sg13g2_buf_2
XFILLER_104_734 VDD VSS sg13g2_decap_8
XFILLER_131_520 VDD VSS sg13g2_decap_8
Xmax_cap393 _10167_/S _10163_/S VDD VSS sg13g2_buf_4
X_09967_ _14551_/D _14551_/Q _09967_/A1 _09967_/S VDD VSS sg13g2_mux2_1
XFILLER_77_629 VDD VSS sg13g2_fill_1
XFILLER_134_56 VDD VSS sg13g2_decap_8
X_08918_ _08918_/X _15042_/Q _14946_/Q _10752_/A VDD VSS sg13g2_mux2_1
XFILLER_131_1122 VDD VSS sg13g2_decap_8
X_09898_ _14484_/D _09898_/A0 _14484_/Q _09898_/S VDD VSS sg13g2_mux2_1
XFILLER_73_802 VDD VSS sg13g2_decap_4
XFILLER_94_49 VDD VSS sg13g2_decap_8
XFILLER_100_962 VDD VSS sg13g2_decap_8
XFILLER_131_1166 VDD VSS sg13g2_decap_8
XFILLER_27_21 VDD VSS sg13g2_decap_8
X_08849_ _08849_/X _15025_/Q _08848_/A _08848_/Y VDD VSS sg13g2_a21o_1
XFILLER_58_898 VDD VSS sg13g2_decap_8
XFILLER_73_846 VDD VSS sg13g2_decap_8
XFILLER_17_239 VDD VSS sg13g2_decap_8
XFILLER_84_194 VDD VSS sg13g2_fill_1
X_11860_ _11860_/Y _13088_/A _11792_/B _11868_/A VDD VSS sg13g2_a21oi_1
XFILLER_27_76 VDD VSS sg13g2_fill_2
XFILLER_150_77 VDD VSS sg13g2_decap_8
XFILLER_72_367 VDD VSS sg13g2_decap_4
X_10811_ _10811_/Y _10835_/B2 _10844_/A _07753_/B VDD VSS sg13g2_o21ai_1
X_11791_ _11791_/X _11789_/X _11790_/X _11975_/A VDD VSS sg13g2_mux2_1
XFILLER_53_570 VDD VSS sg13g2_fill_1
X_13530_ _13530_/Y _13529_/A _12936_/B _08306_/B _13546_/B2 VDD VSS sg13g2_a22oi_1
XFILLER_53_592 VDD VSS sg13g2_fill_2
X_10742_ _14913_/D _09204_/C _11052_/B _10741_/Y VDD VSS sg13g2_o21ai_1
XFILLER_43_42 VDD VSS sg13g2_decap_8
XFILLER_129_1084 VDD VSS sg13g2_decap_8
XFILLER_14_979 VDD VSS sg13g2_decap_8
X_13829__2735 _13829_/RESET_B VDD VSS sg13g2_tiehi
X_14589__1975 _14589_/RESET_B VDD VSS sg13g2_tiehi
XFILLER_41_787 VDD VSS sg13g2_decap_8
XFILLER_43_75 VDD VSS sg13g2_decap_8
X_10673_ _14895_/D _10673_/A VDD VSS sg13g2_inv_1
X_13461_ _13461_/Y _13465_/A1 _08723_/B _13260_/B VDD VSS sg13g2_o21ai_1
XFILLER_40_275 VDD VSS sg13g2_fill_1
XFILLER_43_97 VDD VSS sg13g2_decap_8
X_15200_ _15200_/Q _15200_/CLK _15200_/D _15200_/RESET_B VDD VSS sg13g2_dfrbpq_1
X_12412_ _12412_/X _12411_/X _12410_/X _12407_/X _12406_/X _12593_/S0 _12609_/S VDD
+ VSS sg13g2_mux4_1
X_13392_ _15084_/D _15084_/Q _13427_/A _13391_/Y VDD VSS sg13g2_a21o_1
XFILLER_51_1167 VDD VSS sg13g2_decap_8
XFILLER_103_1235 VDD VSS sg13g2_fill_2
XFILLER_154_623 VDD VSS sg13g2_fill_1
XFILLER_138_174 VDD VSS sg13g2_decap_4
X_15131_ _15131_/Q clkload71/A _15131_/D _15131_/RESET_B VDD VSS sg13g2_dfrbpq_1
X_12343_ _12343_/X _14107_/Q _14139_/Q _14171_/Q _14203_/Q _12351_/S0 _12351_/S1 VDD
+ VSS sg13g2_mux4_1
XFILLER_153_133 VDD VSS sg13g2_decap_8
X_14209__2355 _14209_/RESET_B VDD VSS sg13g2_tiehi
XFILLER_5_644 VDD VSS sg13g2_fill_1
X_12274_ _12274_/Y _12274_/A _12274_/B VDD VSS sg13g2_nor2_1
XFILLER_99_209 VDD VSS sg13g2_decap_8
X_15062_ _15062_/Q clkload69/A _15062_/D _15062_/RESET_B VDD VSS sg13g2_dfrbpq_1
XFILLER_4_14 VDD VSS sg13g2_decap_8
X_14013_ _14013_/Q _14525_/CLK _14013_/D _14013_/RESET_B VDD VSS sg13g2_dfrbpq_1
X_11225_ _11225_/X _14363_/Q _14395_/Q _14459_/Q _14491_/Q _11212_/S _11226_/S1 VDD
+ VSS sg13g2_mux4_1
XFILLER_107_594 VDD VSS sg13g2_decap_4
XFILLER_136_1033 VDD VSS sg13g2_decap_8
XFILLER_150_862 VDD VSS sg13g2_fill_1
X_11156_ _11156_/Y _14953_/Q _11170_/B VDD VSS sg13g2_nand2_1
XFILLER_110_704 VDD VSS sg13g2_fill_1
XFILLER_136_1077 VDD VSS sg13g2_decap_8
X_10107_ _14685_/D _10107_/A0 _14685_/Q _10136_/S VDD VSS sg13g2_mux2_1
XFILLER_89_990 VDD VSS sg13g2_decap_8
XFILLER_122_597 VDD VSS sg13g2_decap_4
X_14424__2140 _14424_/RESET_B VDD VSS sg13g2_tiehi
XFILLER_23_1203 VDD VSS sg13g2_decap_8
X_11087_ _11087_/X _11118_/A _11118_/B VDD VSS sg13g2_and2_1
X_10038_ _14619_/D _10071_/A0 _14619_/Q _10057_/S VDD VSS sg13g2_mux2_1
XFILLER_64_802 VDD VSS sg13g2_decap_8
X_14915_ _14915_/Q clkload48/A _14915_/D _14915_/RESET_B VDD VSS sg13g2_dfrbpq_1
XFILLER_36_515 VDD VSS sg13g2_fill_2
XFILLER_76_684 VDD VSS sg13g2_decap_4
XFILLER_48_386 VDD VSS sg13g2_fill_1
X_14846_ _14846_/Q clkload83/A _14846_/D _14846_/RESET_B VDD VSS sg13g2_dfrbpq_1
XFILLER_36_559 VDD VSS sg13g2_decap_8
XFILLER_17_740 VDD VSS sg13g2_decap_8
XFILLER_51_507 VDD VSS sg13g2_fill_2
XFILLER_51_518 VDD VSS sg13g2_fill_2
XFILLER_91_687 VDD VSS sg13g2_decap_8
X_14777_ _14777_/Q clkload74/A _14777_/D _14777_/RESET_B VDD VSS sg13g2_dfrbpq_1
XFILLER_1_1076 VDD VSS sg13g2_decap_8
XFILLER_17_784 VDD VSS sg13g2_decap_8
X_14905__3119 _14905_/RESET_B VDD VSS sg13g2_tiehi
X_11989_ _11989_/Y _11989_/A _11989_/B VDD VSS sg13g2_xnor2_1
XFILLER_90_186 VDD VSS sg13g2_decap_8
X_13728_ _13728_/Q clkload9/A _13728_/D _13728_/RESET_B VDD VSS sg13g2_dfrbpq_1
XFILLER_56_1045 VDD VSS sg13g2_decap_8
XFILLER_56_1056 VDD VSS sg13g2_decap_8
XFILLER_32_754 VDD VSS sg13g2_fill_2
XFILLER_108_1135 VDD VSS sg13g2_decap_8
XFILLER_32_765 VDD VSS sg13g2_fill_1
XFILLER_17_1029 VDD VSS sg13g2_decap_8
XFILLER_32_787 VDD VSS sg13g2_decap_8
X_13659_ _13659_/Q _15040_/CLK _13659_/D _13659_/RESET_B VDD VSS sg13g2_dfrbpq_1
XFILLER_31_297 VDD VSS sg13g2_decap_8
XFILLER_129_130 VDD VSS sg13g2_decap_8
XFILLER_30_1207 VDD VSS sg13g2_decap_8
XFILLER_8_460 VDD VSS sg13g2_decap_8
XFILLER_8_471 VDD VSS sg13g2_fill_1
XFILLER_145_645 VDD VSS sg13g2_fill_1
XFILLER_117_347 VDD VSS sg13g2_fill_1
X_14780__3318 _14780_/RESET_B VDD VSS sg13g2_tiehi
X_14634__1930 _14634_/RESET_B VDD VSS sg13g2_tiehi
XFILLER_126_881 VDD VSS sg13g2_decap_8
XFILLER_144_188 VDD VSS sg13g2_fill_2
XFILLER_132_328 VDD VSS sg13g2_fill_2
XFILLER_67_1152 VDD VSS sg13g2_decap_8
XFILLER_99_743 VDD VSS sg13g2_fill_2
XFILLER_28_1136 VDD VSS sg13g2_decap_8
XFILLER_67_1185 VDD VSS sg13g2_decap_8
Xfanout417 wire418/A _09938_/Y VDD VSS sg13g2_buf_1
X_09821_ _14409_/D _09887_/A0 _14409_/Q _09834_/S VDD VSS sg13g2_mux2_1
XFILLER_113_553 VDD VSS sg13g2_decap_8
XFILLER_154_1155 VDD VSS sg13g2_decap_8
Xfanout428 _09852_/S _09865_/S VDD VSS sg13g2_buf_1
XFILLER_86_404 VDD VSS sg13g2_decap_4
Xfanout439 _09766_/S _09769_/S VDD VSS sg13g2_buf_1
XFILLER_87_949 VDD VSS sg13g2_decap_4
XFILLER_98_275 VDD VSS sg13g2_fill_1
XFILLER_113_597 VDD VSS sg13g2_decap_8
XFILLER_98_297 VDD VSS sg13g2_fill_2
X_09752_ _14342_/D _14342_/Q _09884_/A0 _09765_/S VDD VSS sg13g2_mux2_1
XFILLER_39_331 VDD VSS sg13g2_decap_8
X_13907__2657 _13907_/RESET_B VDD VSS sg13g2_tiehi
X_14667__1897 _14667_/RESET_B VDD VSS sg13g2_tiehi
X_08703_ _15184_/D hold3437/X _15184_/Q _13333_/S VDD VSS sg13g2_mux2_1
XFILLER_27_504 VDD VSS sg13g2_decap_8
X_15002__2970 _15002_/RESET_B VDD VSS sg13g2_tiehi
X_09683_ _14275_/D _09914_/A1 _14275_/Q wire456/X VDD VSS sg13g2_mux2_1
XFILLER_67_673 VDD VSS sg13g2_decap_8
XFILLER_39_397 VDD VSS sg13g2_decap_8
XFILLER_82_632 VDD VSS sg13g2_fill_1
X_08634_ _08640_/C _13533_/A _08333_/Y _08688_/C VDD VSS sg13g2_o21ai_1
XFILLER_54_334 VDD VSS sg13g2_decap_8
XFILLER_82_676 VDD VSS sg13g2_fill_1
X_08565_ _08581_/A _07862_/Y _08565_/A2 _08306_/A _08608_/B _08563_/Y VDD VSS sg13g2_a221oi_1
XFILLER_74_1101 VDD VSS sg13g2_decap_4
XFILLER_120_14 VDD VSS sg13g2_decap_8
XFILLER_63_890 VDD VSS sg13g2_fill_2
XFILLER_81_186 VDD VSS sg13g2_decap_4
XFILLER_23_732 VDD VSS sg13g2_decap_8
XFILLER_22_220 VDD VSS sg13g2_decap_8
X_08496_ _08497_/B wire233/X _07829_/B _07950_/Y VDD VSS sg13g2_a21oi_1
XFILLER_10_404 VDD VSS sg13g2_fill_1
XFILLER_149_951 VDD VSS sg13g2_decap_8
XFILLER_50_595 VDD VSS sg13g2_decap_8
Xwire807 wire807/X wire807/A VDD VSS sg13g2_buf_4
XFILLER_13_56 VDD VSS sg13g2_decap_8
X_09117_ _09117_/Y _09158_/A _09117_/B _09117_/C VDD VSS sg13g2_nand3_1
X_14502__2062 _14502_/RESET_B VDD VSS sg13g2_tiehi
XFILLER_108_347 VDD VSS sg13g2_decap_8
XFILLER_11_1140 VDD VSS sg13g2_decap_8
XFILLER_135_144 VDD VSS sg13g2_decap_8
X_09048_ _10720_/B _09147_/B _15035_/Q _09047_/Y VDD VSS sg13g2_o21ai_1
XFILLER_135_155 VDD VSS sg13g2_fill_2
XFILLER_1_102 VDD VSS sg13g2_decap_8
XFILLER_1_113 VDD VSS sg13g2_fill_2
XFILLER_46_1203 VDD VSS sg13g2_fill_2
XFILLER_89_220 VDD VSS sg13g2_decap_8
XFILLER_2_658 VDD VSS sg13g2_decap_8
X_11010_ _11012_/B _11010_/A _11010_/B _11010_/C VDD VSS sg13g2_nand3_1
XFILLER_145_77 VDD VSS sg13g2_decap_8
XFILLER_1_157 VDD VSS sg13g2_decap_4
XFILLER_131_350 VDD VSS sg13g2_decap_8
XFILLER_81_1138 VDD VSS sg13g2_fill_1
Xfanout940 _11431_/A1 _07683_/X VDD VSS sg13g2_buf_1
Xfanout951 _10205_/S _13471_/S VDD VSS sg13g2_buf_1
Xfanout962 _11378_/S _07656_/Y VDD VSS sg13g2_buf_1
XFILLER_38_42 VDD VSS sg13g2_decap_8
Xfanout973 _12260_/A1 _12113_/C1 VDD VSS sg13g2_buf_1
XFILLER_77_459 VDD VSS sg13g2_fill_2
Xfanout984 _11227_/S _12324_/B VDD VSS sg13g2_buf_1
Xfanout995 _12304_/B _12328_/B1 VDD VSS sg13g2_buf_1
XFILLER_58_673 VDD VSS sg13g2_decap_8
X_12961_ _12962_/B _12961_/A _12988_/C _12961_/C VDD VSS sg13g2_nand3_1
XFILLER_58_684 VDD VSS sg13g2_decap_8
XFILLER_100_770 VDD VSS sg13g2_fill_1
X_14700_ _14700_/Q clkload51/A _14700_/D _14700_/RESET_B VDD VSS sg13g2_dfrbpq_1
XFILLER_46_857 VDD VSS sg13g2_decap_8
XFILLER_73_632 VDD VSS sg13g2_decap_8
X_11912_ _11913_/B wire210/X _11912_/B VDD VSS sg13g2_nor2_1
XFILLER_45_345 VDD VSS sg13g2_decap_8
X_12892_ _12894_/B _14900_/Q _13687_/Q VDD VSS sg13g2_xor2_1
XFILLER_79_1067 VDD VSS sg13g2_decap_8
X_14631_ _14631_/Q clkload5/A _14631_/D _14631_/RESET_B VDD VSS sg13g2_dfrbpq_1
XFILLER_61_827 VDD VSS sg13g2_decap_4
X_11843_ _11910_/B _11843_/A _13675_/Q VDD VSS sg13g2_xnor2_1
XFILLER_60_326 VDD VSS sg13g2_decap_4
XFILLER_14_721 VDD VSS sg13g2_decap_8
XFILLER_72_186 VDD VSS sg13g2_fill_1
X_14562_ _14562_/Q _14722_/CLK _14562_/D _14562_/RESET_B VDD VSS sg13g2_dfrbpq_1
X_14712__1852 _14712_/RESET_B VDD VSS sg13g2_tiehi
XFILLER_54_85 VDD VSS sg13g2_fill_1
X_11774_ _11774_/Y _11774_/A _11776_/B VDD VSS sg13g2_nand2_1
X_13513_ _15136_/D _15136_/Q _13534_/A1 _13547_/B VDD VSS sg13g2_mux2_1
X_10725_ _10725_/Y _10725_/A _10725_/B VDD VSS sg13g2_nor2_1
X_14493_ _14493_/Q clkload53/A _14493_/D _14493_/RESET_B VDD VSS sg13g2_dfrbpq_1
XFILLER_13_286 VDD VSS sg13g2_fill_1
X_13444_ _13444_/Y _13444_/A _13444_/B _13444_/C VDD VSS sg13g2_nor3_1
XFILLER_155_910 VDD VSS sg13g2_decap_8
XFILLER_16_1062 VDD VSS sg13g2_decap_8
X_10656_ _10658_/B _14891_/Q _10663_/D VDD VSS sg13g2_nor2_1
XFILLER_103_1021 VDD VSS sg13g2_fill_1
XFILLER_139_483 VDD VSS sg13g2_decap_4
Xclkload16 clkload16/Y clkload16/A VDD VSS sg13g2_inv_1
XFILLER_70_95 VDD VSS sg13g2_decap_4
X_10587_ _10587_/Y _12963_/A _10594_/D _10557_/C VDD VSS sg13g2_o21ai_1
Xclkload27 clkload27/Y clkload27/A VDD VSS sg13g2_inv_1
X_13375_ _13378_/C _15124_/Q _13375_/B VDD VSS sg13g2_nand2_1
XFILLER_154_431 VDD VSS sg13g2_decap_8
XFILLER_10_993 VDD VSS sg13g2_decap_8
Xclkload38 clkload38/Y clkload38/A VDD VSS sg13g2_inv_1
Xclkload49 clkload49/Y clkload49/A VDD VSS sg13g2_inv_2
XFILLER_115_807 VDD VSS sg13g2_fill_1
X_15114_ _15114_/Q _15178_/CLK _15114_/D _15114_/RESET_B VDD VSS sg13g2_dfrbpq_1
XFILLER_142_604 VDD VSS sg13g2_fill_1
XFILLER_6_975 VDD VSS sg13g2_decap_8
X_12326_ _12326_/Y _12328_/A1 _13882_/Q _11805_/C VDD VSS sg13g2_a21oi_1
XFILLER_138_1106 VDD VSS sg13g2_decap_4
XFILLER_55_7 VDD VSS sg13g2_decap_8
XFILLER_142_637 VDD VSS sg13g2_fill_2
X_15045_ _15045_/Q clkload18/A _15045_/D _15045_/RESET_B VDD VSS sg13g2_dfrbpq_1
X_12257_ _12257_/Y _12259_/S0 _13944_/Q _11690_/B VDD VSS sg13g2_a21oi_1
XFILLER_79_71 VDD VSS sg13g2_fill_2
X_11208_ _11209_/B _11206_/Y _11204_/Y _11207_/Y VDD VSS sg13g2_o21ai_1
X_12188_ _12188_/Y _12188_/A _12188_/B _12237_/C VDD VSS sg13g2_nand3_1
XFILLER_150_670 VDD VSS sg13g2_fill_2
XFILLER_96_735 VDD VSS sg13g2_decap_8
XFILLER_23_1000 VDD VSS sg13g2_decap_8
X_11139_ _11139_/Y _11190_/C _11163_/A _11179_/B VDD VSS sg13g2_a21oi_1
X_13686__2885 _13686_/RESET_B VDD VSS sg13g2_tiehi
XFILLER_27_1180 VDD VSS sg13g2_decap_8
XFILLER_37_802 VDD VSS sg13g2_decap_8
XFILLER_62_1082 VDD VSS sg13g2_decap_8
X_15197__3142 _15197_/RESET_B VDD VSS sg13g2_tiehi
XFILLER_114_1161 VDD VSS sg13g2_fill_2
XFILLER_49_684 VDD VSS sg13g2_decap_8
XFILLER_95_92 VDD VSS sg13g2_decap_8
XFILLER_114_1172 VDD VSS sg13g2_fill_2
XFILLER_23_1077 VDD VSS sg13g2_decap_8
XFILLER_64_632 VDD VSS sg13g2_decap_8
XFILLER_36_334 VDD VSS sg13g2_decap_4
XFILLER_97_1145 VDD VSS sg13g2_fill_2
XFILLER_92_963 VDD VSS sg13g2_decap_8
XFILLER_149_1235 VDD VSS sg13g2_fill_2
XFILLER_24_507 VDD VSS sg13g2_fill_2
X_14829_ _14829_/Q clkload70/A _14829_/D _14829_/RESET_B VDD VSS sg13g2_dfrbpq_1
XFILLER_17_592 VDD VSS sg13g2_decap_8
X_08350_ _08352_/A _07934_/Y _08350_/B VDD VSS sg13g2_nand2b_1
X_08281_ _08281_/Y _08560_/B _08207_/X _08279_/X VDD VSS sg13g2_a21oi_1
XFILLER_32_584 VDD VSS sg13g2_fill_2
XFILLER_81_0 VDD VSS sg13g2_decap_8
XFILLER_149_258 VDD VSS sg13g2_decap_8
XFILLER_146_910 VDD VSS sg13g2_fill_1
XFILLER_121_1110 VDD VSS sg13g2_fill_1
X_14849__3231 _14849_/RESET_B VDD VSS sg13g2_tiehi
XFILLER_145_420 VDD VSS sg13g2_fill_1
XFILLER_121_1143 VDD VSS sg13g2_decap_8
XFILLER_69_1214 VDD VSS sg13g2_fill_2
XFILLER_117_122 VDD VSS sg13g2_decap_8
XFILLER_146_976 VDD VSS sg13g2_fill_1
XFILLER_145_464 VDD VSS sg13g2_decap_8
XFILLER_156_1217 VDD VSS sg13g2_decap_8
X_14150__2414 _14150_/RESET_B VDD VSS sg13g2_tiehi
XFILLER_132_114 VDD VSS sg13g2_fill_1
Xfanout203 _09926_/A1 fanout204/X VDD VSS sg13g2_buf_1
XFILLER_119_1050 VDD VSS sg13g2_decap_8
Xfanout214 _10378_/D _10369_/Y VDD VSS sg13g2_buf_1
XFILLER_59_415 VDD VSS sg13g2_decap_4
XFILLER_113_361 VDD VSS sg13g2_fill_1
XFILLER_114_884 VDD VSS sg13g2_decap_8
XFILLER_115_14 VDD VSS sg13g2_decap_8
Xfanout225 _10090_/A0 _09083_/Y VDD VSS sg13g2_buf_1
Xfanout236 _13222_/A1 _13048_/X VDD VSS sg13g2_buf_1
X_09804_ _14393_/D _10135_/A0 _14393_/Q _09805_/S VDD VSS sg13g2_mux2_1
Xfanout247 _10021_/A0 _10087_/A0 VDD VSS sg13g2_buf_1
Xfanout258 _10153_/A1 _09921_/A1 VDD VSS sg13g2_buf_1
XFILLER_41_1100 VDD VSS sg13g2_decap_8
X_07996_ _07996_/X _15104_/Q _15091_/Q VDD VSS sg13g2_or2_1
XFILLER_80_1160 VDD VSS sg13g2_fill_1
XFILLER_68_960 VDD VSS sg13g2_fill_2
X_09735_ _14326_/D _09900_/A0 _14326_/Q _09737_/S VDD VSS sg13g2_mux2_1
XFILLER_68_982 VDD VSS sg13g2_fill_2
XFILLER_41_1155 VDD VSS sg13g2_decap_8
XFILLER_41_1166 VDD VSS sg13g2_fill_1
XFILLER_67_492 VDD VSS sg13g2_decap_8
XFILLER_41_1188 VDD VSS sg13g2_decap_8
X_09666_ _14259_/D _09930_/A1 _14259_/Q _09666_/S VDD VSS sg13g2_mux2_1
XFILLER_55_665 VDD VSS sg13g2_decap_8
XFILLER_82_451 VDD VSS sg13g2_decap_8
XFILLER_131_35 VDD VSS sg13g2_decap_8
XFILLER_43_816 VDD VSS sg13g2_decap_4
X_08617_ _08622_/C _08617_/A _08617_/B VDD VSS sg13g2_nor2_1
X_09597_ _14194_/D _14194_/Q _09698_/A0 _09604_/S VDD VSS sg13g2_mux2_1
X_08548_ _08548_/Y _08548_/A _08548_/B VDD VSS sg13g2_nand2_1
XFILLER_126_1010 VDD VSS sg13g2_fill_2
XFILLER_11_702 VDD VSS sg13g2_decap_8
XFILLER_50_370 VDD VSS sg13g2_decap_8
X_08479_ _08479_/Y _13555_/A _07804_/B _08497_/A VDD VSS sg13g2_a21oi_1
XFILLER_24_77 VDD VSS sg13g2_decap_8
XFILLER_10_223 VDD VSS sg13g2_fill_1
X_10510_ _10576_/C _15205_/Q _10510_/B wire388/X VDD VSS sg13g2_and3_1
XFILLER_13_1202 VDD VSS sg13g2_decap_8
X_11490_ _11490_/X _14562_/Q _14594_/Q _14626_/Q _14658_/Q _11493_/S0 _11493_/S1 VDD
+ VSS sg13g2_mux4_1
XFILLER_155_228 VDD VSS sg13g2_decap_8
X_10441_ _14836_/D _10441_/A _10442_/B _10444_/C VDD VSS sg13g2_and3_1
XFILLER_40_21 VDD VSS sg13g2_decap_4
XFILLER_100_1205 VDD VSS sg13g2_decap_8
XFILLER_156_21 VDD VSS sg13g2_decap_8
XFILLER_152_913 VDD VSS sg13g2_decap_8
X_10372_ _14815_/D _14815_/Q _10378_/D _10371_/Y VDD VSS sg13g2_a21oi_1
X_13160_ _13160_/Y _13159_/Y _13160_/B _13160_/C VDD VSS sg13g2_nand3b_1
XFILLER_2_411 VDD VSS sg13g2_decap_8
X_12111_ _12111_/Y _12235_/A _13908_/Q VDD VSS sg13g2_nand2b_1
X_13091_ _13091_/Y _13092_/A _13092_/C _13112_/A VDD VSS sg13g2_a21oi_1
XFILLER_124_648 VDD VSS sg13g2_decap_8
X_13779__2785 _13779_/RESET_B VDD VSS sg13g2_tiehi
XFILLER_151_467 VDD VSS sg13g2_fill_2
XFILLER_3_978 VDD VSS sg13g2_decap_8
X_12042_ _12042_/X _13970_/Q _14002_/Q _14034_/Q _14066_/Q _12025_/A _12026_/C VDD
+ VSS sg13g2_mux4_1
Xfanout1702 _12259_/S0 _11553_/A1 VDD VSS sg13g2_buf_1
Xfanout1713 fanout1713/X fanout1736/X VDD VSS sg13g2_buf_1
Xfanout1724 _11415_/S _11995_/S0 VDD VSS sg13g2_buf_1
XFILLER_137_1183 VDD VSS sg13g2_decap_8
XFILLER_46_1066 VDD VSS sg13g2_decap_8
Xfanout1735 _11400_/A fanout1736/X VDD VSS sg13g2_buf_1
XFILLER_49_74 VDD VSS sg13g2_fill_2
Xfanout1746 _11277_/S fanout1750/X VDD VSS sg13g2_buf_1
Xfanout1757 _13155_/A _13319_/A VDD VSS sg13g2_buf_1
Xfanout1768 _10602_/A _10623_/A VDD VSS sg13g2_buf_1
Xfanout770 _09907_/A1 _10139_/A1 VDD VSS sg13g2_buf_1
XFILLER_65_418 VDD VSS sg13g2_fill_2
Xfanout1779 _13302_/C fanout1795/X VDD VSS sg13g2_buf_1
Xfanout781 _09162_/A _08995_/B1 VDD VSS sg13g2_buf_1
Xfanout792 _13481_/C _13482_/B VDD VSS sg13g2_buf_1
X_13993_ _13993_/Q clkload6/A _13993_/D _13993_/RESET_B VDD VSS sg13g2_dfrbpq_1
XFILLER_65_429 VDD VSS sg13g2_decap_8
X_13994__2570 _13994_/RESET_B VDD VSS sg13g2_tiehi
XFILLER_46_632 VDD VSS sg13g2_decap_8
X_12944_ _12946_/A _12945_/A _12944_/B _12988_/B VDD VSS sg13g2_nand3_1
XFILLER_92_259 VDD VSS sg13g2_decap_8
XFILLER_2_1171 VDD VSS sg13g2_decap_8
XFILLER_45_175 VDD VSS sg13g2_decap_8
X_12875_ _12875_/Y _12861_/B _12877_/C VDD VSS sg13g2_nand2b_1
Xclkbuf_5_8__f_clk_i clkbuf_5_8__f_clk_i/X clkbuf_4_4_0_clk_i/X VDD VSS sg13g2_buf_16
X_14614_ _14614_/Q _14678_/CLK _14614_/D _14614_/RESET_B VDD VSS sg13g2_dfrbpq_1
X_11826_ _11826_/Y _11826_/A1 _13932_/Q _11416_/B VDD VSS sg13g2_a21oi_1
XFILLER_144_1121 VDD VSS sg13g2_decap_8
XFILLER_92_1053 VDD VSS sg13g2_fill_1
XFILLER_18_1135 VDD VSS sg13g2_decap_8
X_14374__2190 _14374_/RESET_B VDD VSS sg13g2_tiehi
XFILLER_53_1026 VDD VSS sg13g2_decap_4
X_14545_ _14545_/Q clkload45/A _14545_/D _14545_/RESET_B VDD VSS sg13g2_dfrbpq_1
X_11757_ _11761_/A _11756_/X _12233_/B VDD VSS sg13g2_nand2b_1
X_10708_ _10708_/Y _14905_/Q _10973_/B VDD VSS sg13g2_nand2_1
XFILLER_119_409 VDD VSS sg13g2_decap_4
X_14476_ _14476_/Q clkload54/A _14476_/D _14476_/RESET_B VDD VSS sg13g2_dfrbpq_1
XFILLER_144_1198 VDD VSS sg13g2_decap_8
X_11688_ _11688_/Y _11685_/Y _11687_/X _12265_/A2 VDD VSS sg13g2_o21ai_1
XFILLER_146_228 VDD VSS sg13g2_fill_1
X_13427_ _13427_/Y _13427_/A _13440_/B _13427_/C VDD VSS sg13g2_nand3_1
XFILLER_128_954 VDD VSS sg13g2_decap_4
X_10639_ _10639_/Y _14887_/Q _10642_/C _10655_/B VDD VSS sg13g2_a21oi_1
XFILLER_155_751 VDD VSS sg13g2_decap_8
Xmax_cap1065 _12691_/S0 _12636_/S VDD VSS sg13g2_buf_4
XFILLER_143_924 VDD VSS sg13g2_decap_8
X_13358_ _15072_/D _15072_/Q _13470_/A2 _13357_/Y VDD VSS sg13g2_a21o_1
XFILLER_128_998 VDD VSS sg13g2_fill_1
XFILLER_143_935 VDD VSS sg13g2_fill_1
XFILLER_142_412 VDD VSS sg13g2_decap_8
XFILLER_127_486 VDD VSS sg13g2_decap_8
XFILLER_154_294 VDD VSS sg13g2_decap_8
X_12309_ _12310_/A _13978_/Q _14010_/Q _14042_/Q _14074_/Q _12328_/A1 _12319_/B1 VDD
+ VSS sg13g2_mux4_1
XFILLER_143_979 VDD VSS sg13g2_fill_1
XFILLER_5_293 VDD VSS sg13g2_decap_8
X_13289_ _13290_/D _13293_/C _13312_/A _13289_/C _13289_/D VDD VSS sg13g2_nor4_1
XFILLER_114_158 VDD VSS sg13g2_fill_2
X_15028_ _15028_/Q clkload40/A _15028_/D _15028_/RESET_B VDD VSS sg13g2_dfrbpq_1
XFILLER_151_1114 VDD VSS sg13g2_decap_8
XFILLER_64_1166 VDD VSS sg13g2_decap_8
XFILLER_111_832 VDD VSS sg13g2_decap_4
XFILLER_123_692 VDD VSS sg13g2_fill_2
XFILLER_111_843 VDD VSS sg13g2_decap_4
X_07850_ _08646_/A _15016_/Q _08012_/B VDD VSS sg13g2_nand2_1
XFILLER_64_1188 VDD VSS sg13g2_decap_8
XFILLER_151_1147 VDD VSS sg13g2_decap_8
XFILLER_68_256 VDD VSS sg13g2_decap_8
XFILLER_56_418 VDD VSS sg13g2_decap_4
X_07781_ _08411_/A _07782_/A _15002_/Q VDD VSS sg13g2_nor2_1
Xinput3 input3/X mem_axi_bvalid VDD VSS sg13g2_buf_1
XFILLER_7_1082 VDD VSS sg13g2_decap_8
X_09520_ _14119_/D _10083_/A0 _14119_/Q _09520_/S VDD VSS sg13g2_mux2_1
X_13824__2740 _13824_/RESET_B VDD VSS sg13g2_tiehi
X_14584__1980 _14584_/RESET_B VDD VSS sg13g2_tiehi
XFILLER_36_120 VDD VSS sg13g2_decap_4
XFILLER_64_440 VDD VSS sg13g2_fill_1
X_09451_ _14052_/D _09616_/A0 _14052_/Q _09457_/S VDD VSS sg13g2_mux2_1
XFILLER_80_922 VDD VSS sg13g2_decap_8
XFILLER_92_793 VDD VSS sg13g2_decap_8
XFILLER_51_112 VDD VSS sg13g2_decap_8
XFILLER_52_635 VDD VSS sg13g2_decap_8
XFILLER_64_495 VDD VSS sg13g2_fill_1
XFILLER_149_1076 VDD VSS sg13g2_decap_4
X_08402_ _08402_/Y _08402_/A _08402_/B _08402_/C _08514_/B VDD VSS sg13g2_nor4_1
XFILLER_149_1087 VDD VSS sg13g2_decap_8
X_09382_ _13985_/D _09613_/A0 _13985_/Q _09391_/S VDD VSS sg13g2_mux2_1
XFILLER_40_808 VDD VSS sg13g2_fill_1
XFILLER_80_999 VDD VSS sg13g2_decap_8
X_14204__2360 _14204_/RESET_B VDD VSS sg13g2_tiehi
X_08333_ _08333_/Y _08270_/B _08149_/Y _08241_/Y VDD VSS sg13g2_o21ai_1
XFILLER_32_381 VDD VSS sg13g2_decap_8
XFILLER_60_690 VDD VSS sg13g2_decap_8
X_08264_ _08264_/Y _07927_/Y _07930_/A _08612_/S VDD VSS sg13g2_a21oi_1
XFILLER_123_1227 VDD VSS sg13g2_decap_8
X_08195_ _08195_/Y _08599_/B _08085_/A _08194_/Y VDD VSS sg13g2_o21ai_1
XFILLER_69_1000 VDD VSS sg13g2_decap_4
XFILLER_118_464 VDD VSS sg13g2_fill_2
XFILLER_145_272 VDD VSS sg13g2_fill_2
XFILLER_3_219 VDD VSS sg13g2_decap_8
XFILLER_10_35 VDD VSS sg13g2_decap_8
XFILLER_69_1088 VDD VSS sg13g2_decap_4
XFILLER_82_1200 VDD VSS sg13g2_decap_8
XFILLER_117_1009 VDD VSS sg13g2_decap_8
XFILLER_133_489 VDD VSS sg13g2_decap_4
XFILLER_82_1233 VDD VSS sg13g2_decap_4
Xfanout1009 _11043_/A _11070_/A1 VDD VSS sg13g2_buf_1
XFILLER_114_681 VDD VSS sg13g2_fill_1
XFILLER_0_959 VDD VSS sg13g2_fill_1
XFILLER_102_865 VDD VSS sg13g2_decap_8
XFILLER_59_256 VDD VSS sg13g2_fill_1
XFILLER_87_587 VDD VSS sg13g2_fill_1
XFILLER_47_429 VDD VSS sg13g2_decap_8
X_07979_ _07979_/Y _07979_/A _07981_/C _07979_/C VDD VSS sg13g2_nand3_1
XFILLER_19_77 VDD VSS sg13g2_decap_8
XFILLER_56_930 VDD VSS sg13g2_decap_8
XFILLER_142_56 VDD VSS sg13g2_decap_8
X_09718_ _14309_/D _09916_/A1 _14309_/Q wire449/X VDD VSS sg13g2_mux2_1
XFILLER_90_708 VDD VSS sg13g2_decap_8
XFILLER_56_963 VDD VSS sg13g2_fill_2
X_10990_ _11009_/C _15116_/Q _10995_/B VDD VSS sg13g2_xnor2_1
XFILLER_83_771 VDD VSS sg13g2_decap_4
XFILLER_15_304 VDD VSS sg13g2_fill_2
XFILLER_71_922 VDD VSS sg13g2_fill_2
XFILLER_35_21 VDD VSS sg13g2_decap_4
X_09649_ _14242_/D _09649_/A0 _14242_/Q _09667_/S VDD VSS sg13g2_mux2_1
XFILLER_55_484 VDD VSS sg13g2_decap_4
XFILLER_43_635 VDD VSS sg13g2_fill_2
XFILLER_71_955 VDD VSS sg13g2_decap_8
X_12660_ _12660_/X _14385_/Q _14417_/Q _14481_/Q _14513_/Q _12661_/S0 _12661_/S1 VDD
+ VSS sg13g2_mux4_1
XFILLER_35_76 VDD VSS sg13g2_decap_8
XFILLER_43_668 VDD VSS sg13g2_decap_8
XFILLER_43_679 VDD VSS sg13g2_fill_1
X_11611_ _11611_/Y _11614_/S0 _14470_/Q VDD VSS sg13g2_nand2b_1
X_12591_ _12591_/X _13836_/Q _13868_/Q _13900_/Q _13932_/Q _12592_/S0 _12592_/S1 VDD
+ VSS sg13g2_mux4_1
X_14330_ _14330_/Q clkload54/A _14330_/D _14330_/RESET_B VDD VSS sg13g2_dfrbpq_1
XFILLER_156_504 VDD VSS sg13g2_fill_2
X_11542_ _11542_/X _11542_/A _12246_/B VDD VSS sg13g2_and2_1
Xwire423 wire423/X wire423/A VDD VSS sg13g2_buf_4
XFILLER_7_525 VDD VSS sg13g2_fill_2
XFILLER_17_1190 VDD VSS sg13g2_decap_8
X_14261_ _14261_/Q clkload14/A _14261_/D _14261_/RESET_B VDD VSS sg13g2_dfrbpq_1
XFILLER_129_0 VDD VSS sg13g2_decap_8
XFILLER_156_559 VDD VSS sg13g2_decap_8
X_11473_ _11473_/X _14689_/Q _14721_/Q _13761_/Q _13793_/Q _11670_/S0 _11686_/S1 VDD
+ VSS sg13g2_mux4_1
XFILLER_52_1081 VDD VSS sg13g2_decap_8
Xwire456 wire456/X wire456/A VDD VSS sg13g2_buf_4
XFILLER_7_569 VDD VSS sg13g2_decap_4
X_13212_ _13228_/A _14921_/Q _13666_/Q VDD VSS sg13g2_nand2_1
XFILLER_136_250 VDD VSS sg13g2_decap_8
X_15178__3240 _15178_/RESET_B VDD VSS sg13g2_tiehi
XFILLER_125_913 VDD VSS sg13g2_decap_8
X_10424_ _10453_/C _10670_/A _10510_/B VDD VSS sg13g2_and2_1
XFILLER_13_1076 VDD VSS sg13g2_decap_8
X_14192_ _14192_/Q clkload46/A _14192_/D _14192_/RESET_B VDD VSS sg13g2_dfrbpq_1
XFILLER_100_1035 VDD VSS sg13g2_fill_1
XFILLER_152_732 VDD VSS sg13g2_decap_8
X_13902__2662 _13902_/RESET_B VDD VSS sg13g2_tiehi
XFILLER_3_720 VDD VSS sg13g2_fill_2
XFILLER_139_1234 VDD VSS sg13g2_fill_2
X_13143_ _13170_/C _14916_/Q _13671_/Q VDD VSS sg13g2_xnor2_1
XFILLER_124_434 VDD VSS sg13g2_fill_1
X_10355_ _10395_/A _14809_/Q _14810_/Q _14811_/Q VDD VSS sg13g2_nand3_1
XFILLER_83_1008 VDD VSS sg13g2_decap_4
X_10286_ _14789_/D _10286_/A _10288_/B _10295_/C VDD VSS sg13g2_and3_1
X_13074_ _15037_/D _13067_/Y _13073_/Y _13266_/A VDD VSS sg13g2_a21oi_1
XFILLER_78_510 VDD VSS sg13g2_decap_4
XFILLER_133_990 VDD VSS sg13g2_decap_8
Xfanout1510 _10760_/A _14917_/Q VDD VSS sg13g2_buf_1
X_14833__3263 _14833_/RESET_B VDD VSS sg13g2_tiehi
XFILLER_2_296 VDD VSS sg13g2_decap_8
X_12025_ _12026_/B _12025_/A _14674_/Q VDD VSS sg13g2_nand2_1
Xfanout1521 _10651_/D _14881_/Q VDD VSS sg13g2_buf_1
X_14246__2318 _14246_/RESET_B VDD VSS sg13g2_tiehi
Xfanout1532 _10330_/A _14798_/Q VDD VSS sg13g2_buf_1
XFILLER_78_576 VDD VSS sg13g2_fill_1
XFILLER_18_7 VDD VSS sg13g2_decap_8
Xfanout1576 _12221_/B1 _12173_/B1 VDD VSS sg13g2_buf_1
XFILLER_66_749 VDD VSS sg13g2_fill_1
XFILLER_76_72 VDD VSS sg13g2_fill_1
Xfanout1587 _12334_/C _12336_/B1 VDD VSS sg13g2_buf_1
XFILLER_76_83 VDD VSS sg13g2_decap_8
XFILLER_93_546 VDD VSS sg13g2_fill_2
Xfanout1598 _11284_/B1 _13660_/Q VDD VSS sg13g2_buf_1
XFILLER_24_1183 VDD VSS sg13g2_decap_8
X_13976_ _13976_/Q _14506_/CLK _13976_/D _13976_/RESET_B VDD VSS sg13g2_dfrbpq_1
XFILLER_18_131 VDD VSS sg13g2_decap_8
XFILLER_19_676 VDD VSS sg13g2_fill_1
XFILLER_59_1213 VDD VSS sg13g2_decap_8
X_14866__3197 _14866_/RESET_B VDD VSS sg13g2_tiehi
XFILLER_0_1119 VDD VSS sg13g2_decap_8
XFILLER_20_1058 VDD VSS sg13g2_decap_8
X_12927_ _12944_/B _12943_/A _12988_/A _12943_/D VDD VSS sg13g2_or3_1
XFILLER_61_410 VDD VSS sg13g2_fill_2
XFILLER_111_1186 VDD VSS sg13g2_decap_8
X_14461__2103 _14461_/RESET_B VDD VSS sg13g2_tiehi
XFILLER_73_281 VDD VSS sg13g2_fill_2
X_12858_ _12874_/A _12859_/A _13689_/Q VDD VSS sg13g2_and2_1
XFILLER_15_871 VDD VSS sg13g2_decap_8
X_11809_ _11809_/Y _11814_/S0 _14572_/Q VDD VSS sg13g2_nand2b_1
X_12789_ _12789_/X _12785_/X _12784_/X _12781_/X _12780_/X _12789_/S0 _12789_/S1 VDD
+ VSS sg13g2_mux4_1
XFILLER_109_1071 VDD VSS sg13g2_decap_8
X_14528_ _14528_/Q clkload9/A _14528_/D _14528_/RESET_B VDD VSS sg13g2_dfrbpq_1
XFILLER_30_874 VDD VSS sg13g2_fill_2
X_14459_ _14459_/Q _14776_/CLK _14459_/D _14459_/RESET_B VDD VSS sg13g2_dfrbpq_1
XFILLER_70_1192 VDD VSS sg13g2_decap_4
XFILLER_143_710 VDD VSS sg13g2_decap_8
XFILLER_127_272 VDD VSS sg13g2_decap_8
XFILLER_127_283 VDD VSS sg13g2_fill_1
XFILLER_116_957 VDD VSS sg13g2_decap_4
Xmax_cap756 _11425_/B _11234_/Y VDD VSS sg13g2_buf_4
XFILLER_116_968 VDD VSS sg13g2_decap_4
Xmax_cap767 _09030_/D _09018_/A2 VDD VSS sg13g2_buf_1
XFILLER_44_0 VDD VSS sg13g2_decap_8
X_08951_ _08951_/Y _12278_/A _08925_/S _08950_/Y VDD VSS sg13g2_a21oi_1
XFILLER_130_437 VDD VSS sg13g2_fill_2
X_07902_ _08074_/B _08063_/A _07903_/B _07884_/Y VDD VSS sg13g2_o21ai_1
XFILLER_97_852 VDD VSS sg13g2_fill_1
XFILLER_9_1155 VDD VSS sg13g2_decap_8
X_08882_ _08882_/X _08881_/X _11661_/A _08882_/S VDD VSS sg13g2_mux2_1
XFILLER_116_1053 VDD VSS sg13g2_fill_1
XFILLER_69_576 VDD VSS sg13g2_decap_8
X_07833_ _07981_/C _08692_/C _08692_/B VDD VSS sg13g2_nand2b_1
XFILLER_110_172 VDD VSS sg13g2_decap_4
XFILLER_99_1048 VDD VSS sg13g2_decap_8
XFILLER_2_91 VDD VSS sg13g2_decap_8
XFILLER_84_557 VDD VSS sg13g2_fill_1
X_07764_ _15216_/D _15098_/Q _15087_/Q _15074_/Q VDD VSS sg13g2_or3_1
X_09503_ _14103_/D _09967_/A1 _14103_/Q _09503_/S VDD VSS sg13g2_mux2_1
XFILLER_65_771 VDD VSS sg13g2_fill_2
XFILLER_65_782 VDD VSS sg13g2_decap_8
X_07695_ _07696_/C _15079_/Q _15082_/Q _07694_/Y VDD VSS sg13g2_o21ai_1
XFILLER_25_635 VDD VSS sg13g2_fill_2
XFILLER_92_590 VDD VSS sg13g2_decap_8
XFILLER_80_741 VDD VSS sg13g2_fill_2
X_09434_ _14036_/D _09898_/A0 _14036_/Q _09436_/S VDD VSS sg13g2_mux2_1
XFILLER_75_1070 VDD VSS sg13g2_decap_4
X_09365_ _13969_/D _09994_/A0 _13969_/Q wire689/X VDD VSS sg13g2_mux2_1
X_08316_ _08316_/Y _08275_/A _08303_/Y _08304_/Y VDD VSS sg13g2_o21ai_1
X_09296_ _13904_/D _13904_/Q _10159_/A1 _09306_/S VDD VSS sg13g2_mux2_1
X_15054__2900 _15054_/RESET_B VDD VSS sg13g2_tiehi
X_08247_ _08319_/C _08247_/A _08247_/B _08247_/C VDD VSS sg13g2_nor3_1
XFILLER_122_7 VDD VSS sg13g2_decap_8
XFILLER_119_762 VDD VSS sg13g2_decap_4
XFILLER_107_913 VDD VSS sg13g2_decap_8
XFILLER_21_56 VDD VSS sg13g2_decap_8
XFILLER_10_1227 VDD VSS sg13g2_decap_8
X_08178_ _08178_/Y _08060_/X _08029_/Y _08597_/A _08177_/X VDD VSS sg13g2_a22oi_1
XFILLER_4_528 VDD VSS sg13g2_decap_8
XFILLER_137_56 VDD VSS sg13g2_decap_8
X_10140_ _14717_/D _14717_/Q _10140_/A1 _10169_/S VDD VSS sg13g2_mux2_1
XFILLER_133_253 VDD VSS sg13g2_decap_4
XFILLER_82_1041 VDD VSS sg13g2_decap_8
X_10071_ _14651_/D _10071_/A0 _14651_/Q _10090_/S VDD VSS sg13g2_mux2_1
XFILLER_47_1172 VDD VSS sg13g2_fill_1
XFILLER_134_1131 VDD VSS sg13g2_decap_8
XFILLER_43_1025 VDD VSS sg13g2_fill_1
XFILLER_48_705 VDD VSS sg13g2_decap_8
XFILLER_47_1194 VDD VSS sg13g2_decap_8
XFILLER_82_1074 VDD VSS sg13g2_fill_2
XFILLER_82_1085 VDD VSS sg13g2_decap_8
XFILLER_87_362 VDD VSS sg13g2_decap_8
XFILLER_88_885 VDD VSS sg13g2_decap_8
XFILLER_0_789 VDD VSS sg13g2_decap_4
XFILLER_102_673 VDD VSS sg13g2_fill_1
XFILLER_153_77 VDD VSS sg13g2_decap_8
X_14793__3305 _14793_/RESET_B VDD VSS sg13g2_tiehi
XFILLER_48_738 VDD VSS sg13g2_decap_8
XFILLER_29_952 VDD VSS sg13g2_fill_2
X_13830_ _13830_/Q _14726_/CLK _13830_/D _13830_/RESET_B VDD VSS sg13g2_dfrbpq_1
XFILLER_44_922 VDD VSS sg13g2_decap_8
X_13761_ _13761_/Q clkload27/A _13761_/D _13761_/RESET_B VDD VSS sg13g2_dfrbpq_1
Xclkbuf_5_26__f_clk_i clkbuf_leaf_82_clk_i/A clkbuf_4_13_0_clk_i/X VDD VSS sg13g2_buf_16
XFILLER_16_624 VDD VSS sg13g2_decap_8
X_10973_ _10973_/Y _14940_/Q _10973_/B VDD VSS sg13g2_nand2_1
XFILLER_28_495 VDD VSS sg13g2_fill_1
X_12712_ _12712_/X _14581_/Q _14613_/Q _14645_/Q _14677_/Q _12770_/S0 _12770_/S1 VDD
+ VSS sg13g2_mux4_1
XFILLER_16_668 VDD VSS sg13g2_fill_1
XFILLER_71_763 VDD VSS sg13g2_decap_8
X_13692_ _13692_/Q _15250_/CLK _13692_/D _13692_/RESET_B VDD VSS sg13g2_dfrbpq_1
XFILLER_44_988 VDD VSS sg13g2_fill_1
XFILLER_43_487 VDD VSS sg13g2_decap_8
XFILLER_54_1121 VDD VSS sg13g2_fill_1
X_12643_ _12643_/X _14256_/Q _14288_/Q _14320_/Q _14352_/Q _12787_/S0 _12787_/S1 VDD
+ VSS sg13g2_mux4_1
XFILLER_106_1211 VDD VSS sg13g2_decap_8
XFILLER_12_841 VDD VSS sg13g2_decap_8
XFILLER_141_1124 VDD VSS sg13g2_decap_8
XFILLER_50_1007 VDD VSS sg13g2_decap_8
XFILLER_54_1176 VDD VSS sg13g2_fill_2
X_12574_ _12574_/X _13963_/Q _13995_/Q _14027_/Q _14059_/Q _12771_/S0 _12771_/S1 VDD
+ VSS sg13g2_mux4_1
XFILLER_141_1135 VDD VSS sg13g2_fill_2
XFILLER_7_14 VDD VSS sg13g2_decap_8
X_14313_ _14313_/Q _14505_/CLK _14313_/D _14313_/RESET_B VDD VSS sg13g2_dfrbpq_1
XFILLER_141_1157 VDD VSS sg13g2_fill_1
X_11525_ _11638_/A _11526_/A _12942_/B VDD VSS sg13g2_nor2_1
XFILLER_89_1217 VDD VSS sg13g2_decap_8
XFILLER_102_1108 VDD VSS sg13g2_fill_2
Xwire231 wire231/X wire231/A VDD VSS sg13g2_buf_2
XFILLER_141_1168 VDD VSS sg13g2_decap_8
XFILLER_129_559 VDD VSS sg13g2_decap_8
XFILLER_11_395 VDD VSS sg13g2_fill_2
XFILLER_156_367 VDD VSS sg13g2_decap_8
Xwire253 wire253/X wire253/A VDD VSS sg13g2_buf_2
X_14244_ _14244_/Q _15001_/CLK _14244_/D _14244_/RESET_B VDD VSS sg13g2_dfrbpq_1
XFILLER_137_570 VDD VSS sg13g2_fill_1
X_11456_ _11458_/B _11457_/A _11457_/B _11457_/C VDD VSS sg13g2_a21oi_1
XFILLER_125_721 VDD VSS sg13g2_fill_2
Xwire297 wire297/X wire297/A VDD VSS sg13g2_buf_2
X_10407_ _10407_/Y _14823_/Q _14824_/Q _14825_/Q _10413_/B VDD VSS sg13g2_nand4_1
X_14175_ _14175_/Q clkload56/A _14175_/D _14175_/RESET_B VDD VSS sg13g2_dfrbpq_1
X_11387_ _14960_/D _11384_/A _11248_/B _11386_/Y VDD VSS sg13g2_a21o_1
XFILLER_113_905 VDD VSS sg13g2_decap_8
X_13126_ _13127_/B _13265_/A1 _13125_/X _13120_/X _13160_/B wire563/X VDD VSS sg13g2_a221oi_1
XFILLER_125_787 VDD VSS sg13g2_decap_8
X_10338_ _10345_/D _14803_/Q _14804_/Q _14805_/Q _14806_/Q VDD VSS sg13g2_and4_1
XFILLER_152_595 VDD VSS sg13g2_decap_8
XFILLER_26_1212 VDD VSS sg13g2_decap_8
XFILLER_79_841 VDD VSS sg13g2_decap_4
X_13057_ _13058_/B _13057_/A _13057_/B _13057_/C VDD VSS sg13g2_and3_1
XFILLER_152_1231 VDD VSS sg13g2_decap_4
X_10269_ _14784_/D _10269_/A _10299_/B _10271_/B VDD VSS sg13g2_and3_1
Xfanout1340 _08383_/B _15004_/Q VDD VSS sg13g2_buf_1
X_12008_ _12008_/Y _12009_/A _13670_/Q VDD VSS sg13g2_nor2_1
Xfanout1351 _08429_/A _13561_/A0 VDD VSS sg13g2_buf_1
Xfanout1362 _08332_/A1 _08142_/B VDD VSS sg13g2_buf_1
XFILLER_93_310 VDD VSS sg13g2_decap_8
Xfanout1373 _13525_/A _14991_/Q VDD VSS sg13g2_buf_1
Xfanout1384 _08337_/S1 _14990_/Q VDD VSS sg13g2_buf_1
XFILLER_54_708 VDD VSS sg13g2_decap_8
X_13959_ _13959_/Q clkload5/A _13959_/D _13959_/RESET_B VDD VSS sg13g2_dfrbpq_1
XFILLER_81_549 VDD VSS sg13g2_decap_8
XFILLER_35_955 VDD VSS sg13g2_decap_4
XFILLER_146_1002 VDD VSS sg13g2_fill_2
XFILLER_62_796 VDD VSS sg13g2_fill_1
X_09150_ _09156_/B _14923_/Q _09150_/B _09150_/C _09157_/D VDD VSS sg13g2_nand4_1
X_08101_ _08101_/Y _08063_/A _07879_/A _08109_/A1 VDD VSS sg13g2_a21oi_1
X_13774__2790 _13774_/RESET_B VDD VSS sg13g2_tiehi
X_09081_ _09087_/B _14913_/Q _13088_/A _09103_/C VDD VSS sg13g2_nand3_1
X_08032_ _08032_/Y _08463_/A _08032_/B _08032_/C _08032_/D VDD VSS sg13g2_nor4_1
XFILLER_116_721 VDD VSS sg13g2_fill_2
XFILLER_122_1090 VDD VSS sg13g2_decap_8
XFILLER_128_581 VDD VSS sg13g2_decap_8
XFILLER_116_743 VDD VSS sg13g2_fill_2
XFILLER_66_1003 VDD VSS sg13g2_fill_1
X_15042__2926 _15042_/RESET_B VDD VSS sg13g2_tiehi
X_14914__3101 _14914_/RESET_B VDD VSS sg13g2_tiehi
XFILLER_143_551 VDD VSS sg13g2_decap_8
Xmax_cap553 wire552/A _08965_/Y VDD VSS sg13g2_buf_2
Xmax_cap575 _11164_/B _10777_/Y VDD VSS sg13g2_buf_2
Xmax_cap586 _10133_/S _10129_/S VDD VSS sg13g2_buf_4
Xmax_cap597 _10029_/S _10020_/S VDD VSS sg13g2_buf_4
X_09983_ _14566_/D _10149_/A1 _14566_/Q _09999_/S VDD VSS sg13g2_mux2_1
XFILLER_118_1148 VDD VSS sg13g2_decap_8
XFILLER_130_234 VDD VSS sg13g2_decap_8
X_08934_ _08934_/X _08933_/X _12128_/A _08940_/S VDD VSS sg13g2_mux2_1
XFILLER_112_960 VDD VSS sg13g2_fill_1
XFILLER_130_289 VDD VSS sg13g2_fill_1
X_08865_ _08865_/Y _10694_/S _14934_/Q VDD VSS sg13g2_nor2b_1
XFILLER_57_524 VDD VSS sg13g2_decap_8
X_14947__3035 _14947_/RESET_B VDD VSS sg13g2_tiehi
XFILLER_85_844 VDD VSS sg13g2_decap_8
XFILLER_123_14 VDD VSS sg13g2_decap_8
X_07816_ _07816_/X _15010_/Q _07818_/B VDD VSS sg13g2_and2_1
XFILLER_84_354 VDD VSS sg13g2_decap_4
X_08796_ _13683_/D _08796_/A _08796_/B VDD VSS sg13g2_nor2_1
XFILLER_38_782 VDD VSS sg13g2_fill_2
X_07747_ _13320_/C _13499_/C _12808_/A VDD VSS sg13g2_nand2_1
XFILLER_72_549 VDD VSS sg13g2_decap_8
XFILLER_26_955 VDD VSS sg13g2_decap_8
XFILLER_25_432 VDD VSS sg13g2_decap_8
XFILLER_25_443 VDD VSS sg13g2_fill_1
XFILLER_41_903 VDD VSS sg13g2_fill_1
XFILLER_16_56 VDD VSS sg13g2_decap_8
XFILLER_77_1176 VDD VSS sg13g2_decap_8
X_07678_ _07679_/D _13296_/A1 _13356_/B _13289_/C VDD VSS sg13g2_nand3b_1
XFILLER_25_465 VDD VSS sg13g2_fill_1
XFILLER_26_999 VDD VSS sg13g2_decap_8
XFILLER_40_402 VDD VSS sg13g2_decap_4
XFILLER_41_925 VDD VSS sg13g2_fill_2
X_09417_ _14019_/D _09650_/A0 _14019_/Q _09437_/S VDD VSS sg13g2_mux2_1
XFILLER_53_796 VDD VSS sg13g2_decap_8
XFILLER_40_435 VDD VSS sg13g2_decap_4
XFILLER_40_468 VDD VSS sg13g2_fill_2
X_09348_ _13952_/D _09447_/A0 _13952_/Q _09370_/S VDD VSS sg13g2_mux2_1
X_14557__2007 _14557_/RESET_B VDD VSS sg13g2_tiehi
Xmax_cap1609 _12308_/C _11898_/C VDD VSS sg13g2_buf_8
X_09279_ _13887_/D _13887_/Q _10142_/A1 _09279_/S VDD VSS sg13g2_mux2_1
XFILLER_138_345 VDD VSS sg13g2_fill_1
X_11310_ _11310_/Y _11310_/A1 _14525_/Q _11416_/B VDD VSS sg13g2_a21oi_1
XFILLER_153_315 VDD VSS sg13g2_decap_8
XFILLER_148_77 VDD VSS sg13g2_decap_8
X_12290_ _12291_/B _12281_/X _12282_/X _12285_/X _12286_/X _12290_/S0 _12290_/S1 VDD
+ VSS sg13g2_mux4_1
XFILLER_101_1152 VDD VSS sg13g2_decap_8
X_11241_ _11245_/A _11241_/A _13289_/C _11241_/C VDD VSS sg13g2_nand3_1
XFILLER_4_369 VDD VSS sg13g2_decap_8
XFILLER_101_1185 VDD VSS sg13g2_fill_1
XFILLER_136_1215 VDD VSS sg13g2_fill_1
X_11172_ _11197_/A _11172_/A _11181_/A VDD VSS sg13g2_xnor2_1
XFILLER_136_1226 VDD VSS sg13g2_decap_8
X_10123_ _14701_/D _10123_/A0 _14701_/Q _10127_/S VDD VSS sg13g2_mux2_1
XFILLER_48_502 VDD VSS sg13g2_decap_8
Xhold3470 _13637_/A _13745_/Q VDD VSS sg13g2_dlygate4sd3_1
Xhold3481 _13618_/A _13726_/Q VDD VSS sg13g2_dlygate4sd3_1
XFILLER_0_575 VDD VSS sg13g2_decap_8
X_14931_ _14931_/Q clkload39/A _14931_/D _14931_/RESET_B VDD VSS sg13g2_dfrbpq_1
X_10054_ _14635_/D _10087_/A0 _14635_/Q _10068_/S VDD VSS sg13g2_mux2_1
XFILLER_0_586 VDD VSS sg13g2_fill_1
Xhold3492 _10800_/A _14927_/Q VDD VSS sg13g2_dlygate4sd3_1
X_14163__2401 _14163_/RESET_B VDD VSS sg13g2_tiehi
XFILLER_87_192 VDD VSS sg13g2_decap_8
XFILLER_102_492 VDD VSS sg13g2_fill_2
XFILLER_76_877 VDD VSS sg13g2_decap_8
X_14862_ _14862_/Q clkload69/A _14862_/D _14862_/RESET_B VDD VSS sg13g2_dfrbpq_1
XFILLER_21_1131 VDD VSS sg13g2_decap_8
XFILLER_35_207 VDD VSS sg13g2_fill_2
X_13813_ _13813_/Q clkload14/A _13813_/D _13813_/RESET_B VDD VSS sg13g2_dfrbpq_1
X_14793_ _14793_/Q clkload82/A _14793_/D _14793_/RESET_B VDD VSS sg13g2_dfrbpq_1
XFILLER_28_281 VDD VSS sg13g2_fill_1
X_14757__3344 _14757_/RESET_B VDD VSS sg13g2_tiehi
XFILLER_17_966 VDD VSS sg13g2_fill_2
X_13744_ _13744_/Q clkload50/A _13744_/D _13744_/RESET_B VDD VSS sg13g2_dfrbpq_1
X_10956_ _10956_/Y _10956_/A _10956_/B _11044_/C VDD VSS sg13g2_nand3_1
XFILLER_32_925 VDD VSS sg13g2_decap_4
XFILLER_71_582 VDD VSS sg13g2_decap_8
X_14196__2368 _14196_/RESET_B VDD VSS sg13g2_tiehi
X_13675_ _13675_/Q clkload65/A _13675_/D _13675_/RESET_B VDD VSS sg13g2_dfrbpq_1
X_10887_ _14933_/D _10886_/X _10885_/Y _10875_/Y VDD VSS sg13g2_o21ai_1
X_12626_ _12626_/X _14127_/Q _14159_/Q _14191_/Q _14223_/Q _12630_/S0 _12689_/S1 VDD
+ VSS sg13g2_mux4_1
XFILLER_85_7 VDD VSS sg13g2_decap_8
XFILLER_129_312 VDD VSS sg13g2_fill_2
XFILLER_19_1093 VDD VSS sg13g2_decap_8
X_12557_ _12557_/X _13834_/Q _13866_/Q _13898_/Q _13930_/Q _12564_/S0 _12564_/S1 VDD
+ VSS sg13g2_mux4_1
XFILLER_8_653 VDD VSS sg13g2_fill_1
XFILLER_89_1025 VDD VSS sg13g2_fill_1
XFILLER_8_664 VDD VSS sg13g2_decap_8
X_11508_ _11508_/X _14691_/Q _14723_/Q _13763_/Q _13795_/Q _11514_/S0 _11715_/S1 VDD
+ VSS sg13g2_mux4_1
XFILLER_156_175 VDD VSS sg13g2_decap_8
XFILLER_117_529 VDD VSS sg13g2_fill_2
XFILLER_156_186 VDD VSS sg13g2_fill_1
X_12488_ _12488_/X _14693_/Q _14725_/Q _13765_/Q _13797_/Q _12492_/S0 _12494_/S1 VDD
+ VSS sg13g2_mux4_1
XFILLER_89_1069 VDD VSS sg13g2_decap_8
X_14227_ _14227_/Q clkload10/A _14227_/D _14227_/RESET_B VDD VSS sg13g2_dfrbpq_1
X_11439_ _11445_/A _11439_/A _11439_/B VDD VSS sg13g2_or2_1
XFILLER_153_860 VDD VSS sg13g2_decap_8
X_14158_ _14158_/Q _14763_/CLK _14158_/D _14158_/RESET_B VDD VSS sg13g2_dfrbpq_1
X_13109_ _13109_/Y _13106_/Y _13107_/Y _13108_/Y VDD VSS sg13g2_a21oi_1
XFILLER_113_757 VDD VSS sg13g2_fill_1
XFILLER_140_554 VDD VSS sg13g2_decap_4
XFILLER_112_245 VDD VSS sg13g2_decap_4
X_14089_ _14089_/Q _14722_/CLK _14089_/D _14089_/RESET_B VDD VSS sg13g2_dfrbpq_1
XFILLER_86_619 VDD VSS sg13g2_decap_4
XFILLER_6_1103 VDD VSS sg13g2_decap_8
XFILLER_100_418 VDD VSS sg13g2_decap_8
XFILLER_152_1083 VDD VSS sg13g2_decap_8
XFILLER_26_1086 VDD VSS sg13g2_decap_8
XFILLER_78_181 VDD VSS sg13g2_fill_2
Xfanout1170 _12759_/S0 _12754_/S0 VDD VSS sg13g2_buf_1
XFILLER_67_866 VDD VSS sg13g2_fill_2
X_08650_ _08650_/X _08650_/A _08650_/B VDD VSS sg13g2_xor2_1
Xfanout1181 fanout1181/X _15210_/Q VDD VSS sg13g2_buf_1
XFILLER_93_140 VDD VSS sg13g2_fill_1
Xfanout1192 _12674_/S0 fanout1194/X VDD VSS sg13g2_buf_1
XFILLER_39_579 VDD VSS sg13g2_decap_4
X_08581_ wire143/A _08581_/A _08581_/B _08581_/C _08581_/D VDD VSS sg13g2_nand4_1
XFILLER_90_880 VDD VSS sg13g2_fill_2
XFILLER_23_958 VDD VSS sg13g2_fill_1
XFILLER_22_435 VDD VSS sg13g2_decap_8
X_14026__2538 _14026_/RESET_B VDD VSS sg13g2_tiehi
X_13861__2703 _13861_/RESET_B VDD VSS sg13g2_tiehi
X_09202_ _13818_/D _13818_/Q _10169_/A1 _09202_/S VDD VSS sg13g2_mux2_1
XFILLER_22_479 VDD VSS sg13g2_fill_1
X_09133_ _09137_/B _13199_/A _09157_/C _14921_/Q VDD VSS sg13g2_a21oi_1
XFILLER_120_1016 VDD VSS sg13g2_fill_1
XFILLER_124_1185 VDD VSS sg13g2_fill_2
X_09064_ _13771_/D _13771_/Q _10154_/A1 _09106_/S VDD VSS sg13g2_mux2_1
X_14241__2323 _14241_/RESET_B VDD VSS sg13g2_tiehi
XFILLER_118_14 VDD VSS sg13g2_decap_8
X_08015_ _08015_/Y _08213_/S _08013_/X _08014_/Y VDD VSS sg13g2_o21ai_1
XFILLER_104_757 VDD VSS sg13g2_fill_2
X_09966_ _14550_/D _14550_/Q _10098_/A0 wire418/X VDD VSS sg13g2_mux2_1
XFILLER_77_608 VDD VSS sg13g2_fill_2
X_15154__3034 _15154_/RESET_B VDD VSS sg13g2_tiehi
XFILLER_134_35 VDD VSS sg13g2_decap_8
X_14979__2993 _14979_/RESET_B VDD VSS sg13g2_tiehi
XFILLER_58_822 VDD VSS sg13g2_fill_1
X_08917_ _13711_/D _08926_/S _08915_/Y _08916_/Y VDD VSS sg13g2_a21oi_1
X_09897_ _14483_/D _09930_/A1 _14483_/Q _09898_/S VDD VSS sg13g2_mux2_1
XFILLER_94_28 VDD VSS sg13g2_decap_8
X_08848_ _08848_/Y _08848_/A _14929_/Q VDD VSS sg13g2_nor2b_1
XFILLER_131_1156 VDD VSS sg13g2_decap_4
XFILLER_73_825 VDD VSS sg13g2_decap_8
X_08779_ _08779_/Y _08779_/A1 _15115_/Q _15184_/Q _07719_/X VDD VSS sg13g2_a22oi_1
XFILLER_150_56 VDD VSS sg13g2_decap_8
XFILLER_26_741 VDD VSS sg13g2_decap_4
X_10810_ _10810_/Y _10809_/Y _10807_/Y _10801_/Y VDD VSS sg13g2_a21oi_1
X_11790_ _11790_/X _11783_/X _11784_/X _11787_/X _11788_/X _11955_/B _12290_/S1 VDD
+ VSS sg13g2_mux4_1
XFILLER_26_774 VDD VSS sg13g2_decap_8
XFILLER_25_273 VDD VSS sg13g2_fill_2
XFILLER_43_21 VDD VSS sg13g2_decap_8
X_10741_ _10741_/Y _14913_/Q _11084_/B VDD VSS sg13g2_nand2_1
XFILLER_40_210 VDD VSS sg13g2_decap_8
X_13460_ _15106_/D _13456_/X _13459_/Y _13458_/Y VDD VSS sg13g2_o21ai_1
X_10672_ _10673_/A _07753_/B _10807_/B _10800_/B _14895_/Q VDD VSS sg13g2_a22oi_1
XFILLER_16_1233 VDD VSS sg13g2_decap_4
XFILLER_13_479 VDD VSS sg13g2_decap_8
X_12411_ _12411_/X _14687_/Q _14719_/Q _13759_/Q _13791_/Q _12411_/S0 _12411_/S1 VDD
+ VSS sg13g2_mux4_1
XFILLER_139_643 VDD VSS sg13g2_fill_2
XFILLER_90_1195 VDD VSS sg13g2_decap_4
X_13391_ _13391_/Y _13438_/B _13494_/B _13391_/C VDD VSS sg13g2_nor3_1
XFILLER_103_1214 VDD VSS sg13g2_decap_8
XFILLER_21_490 VDD VSS sg13g2_decap_8
X_15130_ _15130_/Q clkload80/A _15130_/D _15130_/RESET_B VDD VSS sg13g2_dfrbpq_1
X_12342_ _12342_/X _13947_/Q _13979_/Q _14011_/Q _14043_/Q _12351_/S0 _12351_/S1 VDD
+ VSS sg13g2_mux4_1
XFILLER_127_849 VDD VSS sg13g2_decap_8
XFILLER_153_112 VDD VSS sg13g2_decap_8
XFILLER_86_1209 VDD VSS sg13g2_fill_1
XFILLER_126_326 VDD VSS sg13g2_decap_8
XFILLER_154_646 VDD VSS sg13g2_fill_1
XFILLER_138_197 VDD VSS sg13g2_decap_8
XFILLER_111_0 VDD VSS sg13g2_decap_8
X_15061_ _15061_/Q clkload69/A _15061_/D _15061_/RESET_B VDD VSS sg13g2_dfrbpq_1
XFILLER_4_133 VDD VSS sg13g2_decap_8
X_12273_ _12273_/Y _12273_/A VDD VSS sg13g2_inv_1
XFILLER_107_562 VDD VSS sg13g2_decap_8
X_14012_ _14012_/Q clkload60/A _14012_/D _14012_/RESET_B VDD VSS sg13g2_dfrbpq_1
X_11224_ _11236_/D _11224_/A _11224_/B _11224_/C VDD VSS sg13g2_nor3_1
XFILLER_153_189 VDD VSS sg13g2_decap_8
XFILLER_150_830 VDD VSS sg13g2_decap_8
XFILLER_136_1012 VDD VSS sg13g2_decap_8
XFILLER_96_906 VDD VSS sg13g2_fill_2
X_11155_ _14952_/D _11154_/Y _11153_/Y _11143_/Y VDD VSS sg13g2_o21ai_1
X_10106_ _14684_/D _14684_/Q _10124_/S _10105_/X VDD VSS sg13g2_a21o_1
XFILLER_49_833 VDD VSS sg13g2_decap_8
X_11086_ _11118_/C _11086_/A _11086_/B VDD VSS sg13g2_xnor2_1
XFILLER_0_383 VDD VSS sg13g2_decap_8
XFILLER_0_394 VDD VSS sg13g2_fill_1
XFILLER_49_855 VDD VSS sg13g2_decap_8
X_14914_ _14914_/Q clkload48/A _14914_/D _14914_/RESET_B VDD VSS sg13g2_dfrbpq_1
X_10037_ _10037_/Y _10037_/A _10037_/B _10070_/C VDD VSS sg13g2_nand3_1
XFILLER_36_505 VDD VSS sg13g2_fill_1
XFILLER_91_600 VDD VSS sg13g2_fill_2
X_14845_ _14845_/Q clkload82/A _14845_/D _14845_/RESET_B VDD VSS sg13g2_dfrbpq_1
XFILLER_90_132 VDD VSS sg13g2_decap_8
X_14776_ _14776_/Q _14776_/CLK _14776_/D _14776_/RESET_B VDD VSS sg13g2_dfrbpq_1
X_11988_ _11988_/Y _11986_/A _11988_/B _11989_/A VDD VSS sg13g2_nand3b_1
XFILLER_95_1073 VDD VSS sg13g2_decap_8
X_13727_ _13727_/Q clkload56/A _13727_/D _13727_/RESET_B VDD VSS sg13g2_dfrbpq_1
XFILLER_95_1084 VDD VSS sg13g2_fill_1
XFILLER_32_733 VDD VSS sg13g2_decap_8
XFILLER_16_284 VDD VSS sg13g2_fill_2
X_10939_ _10939_/Y _11044_/C _10936_/B _10939_/B1 VDD VSS sg13g2_o21ai_1
XFILLER_143_1005 VDD VSS sg13g2_fill_2
XFILLER_17_1008 VDD VSS sg13g2_decap_8
X_14931__3067 _14931_/RESET_B VDD VSS sg13g2_tiehi
XFILLER_147_1174 VDD VSS sg13g2_fill_1
X_13658_ _13658_/Q _15188_/CLK _13658_/D _13658_/RESET_B VDD VSS sg13g2_dfrbpq_1
Xclkbuf_leaf_61_clk_i clkload60/A clkbuf_leaf_62_clk_i/A VDD VSS sg13g2_buf_8
X_12609_ _12609_/X _12607_/X _12608_/X _12609_/S VDD VSS sg13g2_mux2_1
X_13589_ _13589_/Y _15003_/Q _13589_/A2 _13569_/S _15019_/Q _13541_/X VDD VSS sg13g2_a221oi_1
XFILLER_118_816 VDD VSS sg13g2_decap_8
XFILLER_129_186 VDD VSS sg13g2_decap_8
XFILLER_144_123 VDD VSS sg13g2_decap_4
XFILLER_145_668 VDD VSS sg13g2_decap_4
Xclkbuf_leaf_76_clk_i clkload69/A clkbuf_leaf_83_clk_i/A VDD VSS sg13g2_buf_8
XFILLER_126_860 VDD VSS sg13g2_decap_8
XFILLER_99_711 VDD VSS sg13g2_fill_1
XFILLER_119_1221 VDD VSS sg13g2_decap_8
XFILLER_28_1115 VDD VSS sg13g2_decap_8
XFILLER_63_1006 VDD VSS sg13g2_decap_8
XFILLER_99_755 VDD VSS sg13g2_fill_2
XFILLER_113_532 VDD VSS sg13g2_decap_8
XFILLER_154_1134 VDD VSS sg13g2_decap_8
Xfanout407 fanout407/X _10070_/Y VDD VSS sg13g2_buf_1
X_09820_ _14408_/D _09919_/A1 _14408_/Q wire618/X VDD VSS sg13g2_mux2_1
XFILLER_8_1209 VDD VSS sg13g2_decap_8
XFILLER_63_1028 VDD VSS sg13g2_decap_4
XFILLER_98_243 VDD VSS sg13g2_fill_2
XFILLER_150_1009 VDD VSS sg13g2_fill_1
X_09751_ _14341_/D _14341_/Q _09916_/A1 _09765_/S VDD VSS sg13g2_mux2_1
XFILLER_95_950 VDD VSS sg13g2_decap_4
X_08702_ _15249_/D _08700_/Y _08701_/Y _08694_/Y VDD VSS sg13g2_o21ai_1
X_09682_ _14274_/D _09880_/A0 _14274_/Q wire456/X VDD VSS sg13g2_mux2_1
XFILLER_104_49 VDD VSS sg13g2_decap_8
X_08633_ _15245_/D _08633_/A _08633_/B _08633_/C VDD VSS sg13g2_nand3_1
XFILLER_55_858 VDD VSS sg13g2_decap_8
Xclkbuf_leaf_14_clk_i clkload17/A clkbuf_5_6__f_clk_i/X VDD VSS sg13g2_buf_8
XFILLER_81_121 VDD VSS sg13g2_decap_8
XFILLER_82_655 VDD VSS sg13g2_decap_8
X_08564_ _08581_/D _15013_/Q _07861_/B _08674_/B1 VDD VSS sg13g2_o21ai_1
XFILLER_39_1222 VDD VSS sg13g2_decap_8
XFILLER_54_379 VDD VSS sg13g2_decap_4
X_14259__2305 _14259_/RESET_B VDD VSS sg13g2_tiehi
XFILLER_82_688 VDD VSS sg13g2_decap_4
XFILLER_23_711 VDD VSS sg13g2_decap_8
XFILLER_35_582 VDD VSS sg13g2_decap_8
XFILLER_74_1124 VDD VSS sg13g2_decap_8
XFILLER_120_37 VDD VSS sg13g2_fill_1
XFILLER_126_1203 VDD VSS sg13g2_fill_2
X_08495_ _08495_/Y _08447_/B _08574_/C _08494_/Y VDD VSS sg13g2_a21oi_1
Xclkbuf_leaf_29_clk_i _14667_/CLK clkbuf_leaf_34_clk_i/A VDD VSS sg13g2_buf_8
XFILLER_11_928 VDD VSS sg13g2_decap_8
XFILLER_50_574 VDD VSS sg13g2_decap_8
Xwire808 wire808/X wire808/A VDD VSS sg13g2_buf_1
XFILLER_13_35 VDD VSS sg13g2_decap_8
XFILLER_129_35 VDD VSS sg13g2_decap_4
X_09116_ _09117_/C _13168_/A _10760_/A _13142_/A _09136_/B VDD VSS sg13g2_nand4_1
XFILLER_108_315 VDD VSS sg13g2_decap_4
XFILLER_108_337 VDD VSS sg13g2_decap_4
X_09047_ _09047_/Y _15232_/Q _09147_/B VDD VSS sg13g2_nand2b_1
XFILLER_135_178 VDD VSS sg13g2_decap_4
XFILLER_151_638 VDD VSS sg13g2_decap_4
XFILLER_11_1196 VDD VSS sg13g2_decap_8
XFILLER_150_126 VDD VSS sg13g2_decap_8
XFILLER_2_637 VDD VSS sg13g2_decap_8
XFILLER_150_137 VDD VSS sg13g2_decap_8
XFILLER_104_532 VDD VSS sg13g2_decap_8
XFILLER_150_148 VDD VSS sg13g2_fill_1
XFILLER_145_56 VDD VSS sg13g2_decap_8
XFILLER_89_276 VDD VSS sg13g2_decap_4
Xfanout930 _13279_/D _07703_/Y VDD VSS sg13g2_buf_1
Xfanout941 _12051_/A1 _12294_/B1 VDD VSS sg13g2_buf_1
XFILLER_38_21 VDD VSS sg13g2_decap_8
X_09949_ _14533_/D _14533_/Q _10081_/A0 _09951_/S VDD VSS sg13g2_mux2_1
XFILLER_77_438 VDD VSS sg13g2_decap_8
Xfanout952 _13479_/S _13471_/S VDD VSS sg13g2_buf_1
Xfanout963 wire964/A _12172_/B VDD VSS sg13g2_buf_1
Xfanout974 _12036_/B _11955_/B VDD VSS sg13g2_buf_1
Xfanout985 _12324_/B fanout986/X VDD VSS sg13g2_buf_1
XFILLER_58_652 VDD VSS sg13g2_decap_8
XFILLER_86_961 VDD VSS sg13g2_decap_8
XFILLER_38_65 VDD VSS sg13g2_fill_1
X_12960_ _12960_/Y _12961_/A _12961_/C _12988_/C VDD VSS sg13g2_a21oi_1
Xfanout996 _12328_/B1 _11279_/B1 VDD VSS sg13g2_buf_1
XFILLER_100_760 VDD VSS sg13g2_fill_2
XFILLER_38_87 VDD VSS sg13g2_decap_8
XFILLER_46_836 VDD VSS sg13g2_decap_8
X_11911_ _11912_/B _12056_/A _12056_/B VDD VSS sg13g2_nand2_1
X_12891_ _12925_/A _14900_/Q _13687_/Q VDD VSS sg13g2_nand2_1
XFILLER_45_357 VDD VSS sg13g2_fill_1
X_14630_ _14630_/Q _14662_/CLK _14630_/D _14630_/RESET_B VDD VSS sg13g2_dfrbpq_1
X_11842_ _11867_/A _11843_/A _13675_/Q VDD VSS sg13g2_nand2_1
XFILLER_45_379 VDD VSS sg13g2_decap_8
XFILLER_60_305 VDD VSS sg13g2_decap_8
XFILLER_72_165 VDD VSS sg13g2_decap_8
X_14561_ _14561_/Q clkload20/A _14561_/D _14561_/RESET_B VDD VSS sg13g2_dfrbpq_1
X_11773_ _11776_/B _11773_/A _11773_/B _11773_/C _11773_/D VDD VSS sg13g2_nor4_1
X_13512_ _15135_/D _15135_/Q _13529_/A _13560_/S VDD VSS sg13g2_mux2_1
X_10724_ _14908_/D _10724_/A VDD VSS sg13g2_inv_1
X_14492_ _14492_/Q clkload77/A _14492_/D _14492_/RESET_B VDD VSS sg13g2_dfrbpq_1
XFILLER_41_596 VDD VSS sg13g2_decap_8
XFILLER_16_1041 VDD VSS sg13g2_decap_8
X_13443_ _15103_/D _15103_/Q _13470_/A2 _13442_/Y VDD VSS sg13g2_a21o_1
XFILLER_110_92 VDD VSS sg13g2_fill_1
X_10655_ _14890_/D _10663_/D _10655_/B _10655_/C VDD VSS sg13g2_nor3_1
Xmax_cap1203 _12592_/S0 _12588_/S0 VDD VSS sg13g2_buf_4
XFILLER_142_1071 VDD VSS sg13g2_fill_2
XFILLER_70_74 VDD VSS sg13g2_decap_8
XFILLER_154_410 VDD VSS sg13g2_decap_8
X_13957__2607 _13957_/RESET_B VDD VSS sg13g2_tiehi
XFILLER_10_972 VDD VSS sg13g2_decap_8
XFILLER_6_921 VDD VSS sg13g2_decap_8
Xclkload17 clkload17/Y clkload17/A VDD VSS sg13g2_inv_2
X_13374_ _15077_/D _13374_/A1 _13444_/A _13372_/Y VDD VSS sg13g2_o21ai_1
X_10586_ _10597_/D _12963_/A _14872_/Q _14871_/Q _10586_/D VDD VSS sg13g2_and4_1
Xclkload28 clkload28/Y clkload28/A VDD VSS sg13g2_inv_2
Xclkload39 clkload39/Y clkload39/A VDD VSS sg13g2_inv_1
X_15113_ _15113_/Q _15178_/CLK _15113_/D _15113_/RESET_B VDD VSS sg13g2_dfrbpq_1
X_12325_ _12325_/Y _11801_/S _13850_/Q VDD VSS sg13g2_nand2b_1
XFILLER_155_988 VDD VSS sg13g2_fill_2
XFILLER_126_156 VDD VSS sg13g2_decap_4
XFILLER_142_616 VDD VSS sg13g2_decap_4
XFILLER_154_487 VDD VSS sg13g2_decap_4
XFILLER_5_464 VDD VSS sg13g2_fill_1
X_15044_ _15044_/Q clkload48/A _15044_/D _15044_/RESET_B VDD VSS sg13g2_dfrbpq_1
X_12256_ _12256_/Y _12255_/A1 _13912_/Q VDD VSS sg13g2_nand2b_1
XFILLER_5_486 VDD VSS sg13g2_decap_8
XFILLER_107_370 VDD VSS sg13g2_fill_1
XFILLER_48_7 VDD VSS sg13g2_decap_8
X_11207_ _11207_/Y _11205_/A _11207_/A2 _11207_/B1 VDD VSS sg13g2_a21oi_1
X_12187_ _12188_/B _12187_/A _12187_/B _12187_/C VDD VSS sg13g2_nand3_1
X_14337__2227 _14337_/RESET_B VDD VSS sg13g2_tiehi
X_11138_ _11138_/Y _11163_/A wire211/X _11138_/C VDD VSS sg13g2_nand3b_1
XFILLER_68_449 VDD VSS sg13g2_fill_2
XFILLER_77_950 VDD VSS sg13g2_decap_8
XFILLER_0_191 VDD VSS sg13g2_decap_4
X_11069_ _11069_/Y _11078_/B _11069_/B VDD VSS sg13g2_xnor2_1
XFILLER_23_1056 VDD VSS sg13g2_decap_8
XFILLER_3_1139 VDD VSS sg13g2_decap_8
XFILLER_110_1026 VDD VSS sg13g2_decap_8
XFILLER_48_184 VDD VSS sg13g2_decap_4
XFILLER_149_1214 VDD VSS sg13g2_decap_8
XFILLER_110_1037 VDD VSS sg13g2_fill_1
XFILLER_37_869 VDD VSS sg13g2_fill_1
X_14552__2012 _14552_/RESET_B VDD VSS sg13g2_tiehi
XFILLER_97_1168 VDD VSS sg13g2_decap_8
XFILLER_91_463 VDD VSS sg13g2_fill_1
X_14828_ _14828_/Q clkload70/A _14828_/D _14828_/RESET_B VDD VSS sg13g2_dfrbpq_1
XFILLER_63_165 VDD VSS sg13g2_fill_1
XFILLER_17_571 VDD VSS sg13g2_decap_8
X_14759_ _14759_/Q _15212_/CLK _14759_/D _14759_/RESET_B VDD VSS sg13g2_dfrbpq_1
XFILLER_44_390 VDD VSS sg13g2_fill_1
XFILLER_32_563 VDD VSS sg13g2_decap_8
X_08280_ _08280_/X _08560_/B _08207_/X _08279_/X VDD VSS sg13g2_a21o_1
XFILLER_20_714 VDD VSS sg13g2_fill_2
XFILLER_74_0 VDD VSS sg13g2_decap_8
XFILLER_121_1122 VDD VSS sg13g2_decap_8
XFILLER_34_1185 VDD VSS sg13g2_decap_8
XFILLER_121_1166 VDD VSS sg13g2_fill_1
XFILLER_146_988 VDD VSS sg13g2_decap_8
XFILLER_5_91 VDD VSS sg13g2_decap_8
Xfanout204 fanout204/X _09091_/Y VDD VSS sg13g2_buf_1
XFILLER_87_714 VDD VSS sg13g2_fill_1
Xfanout226 _09693_/A0 _10123_/A0 VDD VSS sg13g2_buf_1
X_09803_ _14392_/D _09836_/A0 _14392_/Q wire629/X VDD VSS sg13g2_mux2_1
XFILLER_113_373 VDD VSS sg13g2_decap_8
XFILLER_87_747 VDD VSS sg13g2_fill_2
XFILLER_113_384 VDD VSS sg13g2_fill_1
Xfanout248 _10087_/A0 _09691_/A0 VDD VSS sg13g2_buf_1
XFILLER_119_1095 VDD VSS sg13g2_decap_8
Xfanout259 _10086_/A0 _09921_/A1 VDD VSS sg13g2_buf_1
XFILLER_59_449 VDD VSS sg13g2_decap_8
X_07995_ _08001_/B _15104_/Q _15091_/Q VDD VSS sg13g2_nor2_1
XFILLER_80_1172 VDD VSS sg13g2_decap_4
X_09734_ _14325_/D _09899_/A0 _14325_/Q _09739_/S VDD VSS sg13g2_mux2_1
XFILLER_101_579 VDD VSS sg13g2_decap_8
XFILLER_68_994 VDD VSS sg13g2_decap_8
X_14191__2373 _14191_/RESET_B VDD VSS sg13g2_tiehi
X_09665_ _14258_/D _09698_/A0 _14258_/Q wire641/X VDD VSS sg13g2_mux2_1
XFILLER_27_335 VDD VSS sg13g2_decap_8
XFILLER_55_644 VDD VSS sg13g2_fill_1
XFILLER_131_14 VDD VSS sg13g2_decap_8
X_08616_ _08616_/Y _13533_/A _08616_/B VDD VSS sg13g2_nand2b_1
X_09596_ _14193_/D _14193_/Q _10093_/A0 _09605_/S VDD VSS sg13g2_mux2_1
XFILLER_39_1041 VDD VSS sg13g2_decap_8
X_08547_ _08547_/Y _13566_/A _07812_/B _08497_/A VDD VSS sg13g2_a21oi_1
XFILLER_78_1090 VDD VSS sg13g2_fill_2
XFILLER_152_7 VDD VSS sg13g2_decap_8
XFILLER_126_1022 VDD VSS sg13g2_fill_1
XFILLER_39_1085 VDD VSS sg13g2_fill_1
XFILLER_24_56 VDD VSS sg13g2_decap_8
X_08478_ _08478_/Y _08456_/C _07804_/B _08447_/B VDD VSS sg13g2_o21ai_1
XFILLER_11_747 VDD VSS sg13g2_decap_8
XFILLER_137_900 VDD VSS sg13g2_decap_4
XFILLER_7_707 VDD VSS sg13g2_decap_8
X_14415__2149 _14415_/RESET_B VDD VSS sg13g2_tiehi
XFILLER_155_207 VDD VSS sg13g2_decap_8
XFILLER_126_1099 VDD VSS sg13g2_decap_4
XFILLER_7_729 VDD VSS sg13g2_decap_8
XFILLER_149_793 VDD VSS sg13g2_fill_1
X_10440_ _10442_/B _14836_/Q _14835_/Q _10443_/D VDD VSS sg13g2_nand3_1
XFILLER_136_432 VDD VSS sg13g2_decap_8
X_10371_ _10371_/Y _14815_/Q _10378_/D _10496_/B VDD VSS sg13g2_o21ai_1
XFILLER_124_616 VDD VSS sg13g2_decap_8
X_12110_ _12110_/Y _12235_/A _13876_/Q _12236_/C VDD VSS sg13g2_a21oi_1
X_13090_ _13092_/C _14911_/Q _13676_/Q _13077_/X VDD VSS sg13g2_a21oi_1
XFILLER_3_957 VDD VSS sg13g2_decap_8
XFILLER_46_1023 VDD VSS sg13g2_decap_8
X_12041_ _12041_/Y _12037_/Y _12038_/Y _12040_/Y _12039_/Y _12036_/B VDD VSS sg13g2_a221oi_1
Xfanout1703 _11555_/S0 _11553_/A1 VDD VSS sg13g2_buf_1
Xfanout1714 _12040_/A1 _12017_/A VDD VSS sg13g2_buf_1
XFILLER_77_235 VDD VSS sg13g2_fill_2
Xfanout1736 fanout1736/X fanout1753/X VDD VSS sg13g2_buf_1
Xfanout1747 _11257_/S0 fanout1750/X VDD VSS sg13g2_buf_1
XFILLER_78_769 VDD VSS sg13g2_decap_8
Xfanout1758 _13319_/A _13328_/A VDD VSS sg13g2_buf_1
XFILLER_120_866 VDD VSS sg13g2_decap_8
Xfanout771 _10039_/A0 _10072_/A0 VDD VSS sg13g2_buf_1
Xfanout1769 _10623_/A _13328_/A VDD VSS sg13g2_buf_1
Xfanout782 _09158_/A _08995_/B1 VDD VSS sg13g2_buf_1
XFILLER_93_717 VDD VSS sg13g2_fill_1
X_13992_ _13992_/Q clkload23/A _13992_/D _13992_/RESET_B VDD VSS sg13g2_dfrbpq_1
Xfanout793 _13482_/B _13375_/B VDD VSS sg13g2_buf_1
X_14021__2543 _14021_/RESET_B VDD VSS sg13g2_tiehi
XFILLER_1_49 VDD VSS sg13g2_decap_8
XFILLER_74_920 VDD VSS sg13g2_fill_2
XFILLER_74_931 VDD VSS sg13g2_fill_2
XFILLER_19_847 VDD VSS sg13g2_fill_2
X_12943_ _12961_/A _12943_/A _12988_/A _12988_/B _12943_/D VDD VSS sg13g2_or4_1
XFILLER_65_63 VDD VSS sg13g2_decap_4
XFILLER_18_368 VDD VSS sg13g2_fill_1
XFILLER_2_1150 VDD VSS sg13g2_decap_8
XFILLER_45_154 VDD VSS sg13g2_decap_8
XFILLER_73_463 VDD VSS sg13g2_decap_8
XFILLER_33_305 VDD VSS sg13g2_fill_1
X_12874_ _12878_/A _12874_/A _12876_/A _12877_/C VDD VSS sg13g2_or3_1
X_14625__1939 _14625_/RESET_B VDD VSS sg13g2_tiehi
XFILLER_65_96 VDD VSS sg13g2_fill_1
XFILLER_61_636 VDD VSS sg13g2_decap_8
X_14613_ _14613_/Q clkload43/A _14613_/D _14613_/RESET_B VDD VSS sg13g2_dfrbpq_1
X_11825_ _11825_/Y _11826_/A1 _13900_/Q VDD VSS sg13g2_nand2b_1
XFILLER_144_1100 VDD VSS sg13g2_decap_8
XFILLER_18_1114 VDD VSS sg13g2_decap_8
X_13689__2879 _13689_/RESET_B VDD VSS sg13g2_tiehi
XFILLER_53_1005 VDD VSS sg13g2_decap_8
X_14544_ _14544_/Q clkload49/A _14544_/D _14544_/RESET_B VDD VSS sg13g2_dfrbpq_1
X_11756_ _11756_/X _13834_/Q _13866_/Q _11759_/A VDD VSS sg13g2_mux2_1
XFILLER_42_872 VDD VSS sg13g2_fill_2
XFILLER_92_1065 VDD VSS sg13g2_decap_8
XFILLER_42_883 VDD VSS sg13g2_decap_8
XFILLER_81_73 VDD VSS sg13g2_fill_2
X_15080__3218 _15080_/RESET_B VDD VSS sg13g2_tiehi
XFILLER_147_708 VDD VSS sg13g2_decap_8
X_10707_ _14904_/D _10886_/B1 _10923_/B _10706_/Y VDD VSS sg13g2_o21ai_1
XFILLER_140_1008 VDD VSS sg13g2_decap_4
X_14475_ _14475_/Q _14731_/CLK _14475_/D _14475_/RESET_B VDD VSS sg13g2_dfrbpq_1
X_11687_ _11687_/X _11687_/A _12246_/B VDD VSS sg13g2_and2_1
X_13426_ _15095_/D _13435_/B _13425_/Y _13423_/Y VDD VSS sg13g2_o21ai_1
X_10638_ _10640_/A _14886_/Q _10633_/C _14887_/Q VDD VSS sg13g2_a21oi_1
Xmax_cap1055 _12567_/S _12732_/S1 VDD VSS sg13g2_buf_4
XFILLER_128_977 VDD VSS sg13g2_fill_2
X_13357_ _13357_/Y _13381_/A _13401_/B _13438_/B _13361_/C VDD VSS sg13g2_nor4_1
XFILLER_127_454 VDD VSS sg13g2_fill_2
X_10569_ _14868_/D _10576_/C _10576_/D _10557_/B _07621_/Y _10595_/B VDD VSS sg13g2_a221oi_1
Xmax_cap1088 _12775_/S1 _12719_/S0 VDD VSS sg13g2_buf_4
XFILLER_114_104 VDD VSS sg13g2_decap_8
XFILLER_154_273 VDD VSS sg13g2_decap_8
XFILLER_115_638 VDD VSS sg13g2_fill_2
X_12308_ _12308_/Y _12308_/A _12308_/B _12308_/C VDD VSS sg13g2_nand3_1
X_13288_ _13289_/D _15204_/Q _13506_/A VDD VSS sg13g2_nand2b_1
XFILLER_108_690 VDD VSS sg13g2_decap_4
XFILLER_142_446 VDD VSS sg13g2_decap_8
XFILLER_29_1221 VDD VSS sg13g2_decap_8
X_15027_ _15027_/Q clkload40/A _15027_/D _15027_/RESET_B VDD VSS sg13g2_dfrbpq_1
XFILLER_142_468 VDD VSS sg13g2_fill_2
X_12239_ _12239_/Y _12239_/A _12253_/B VDD VSS sg13g2_nand2_1
XFILLER_64_1145 VDD VSS sg13g2_decap_8
XFILLER_116_1235 VDD VSS sg13g2_fill_2
X_07780_ _07797_/B _08318_/C _08318_/D VDD VSS sg13g2_or2_1
XFILLER_7_1061 VDD VSS sg13g2_decap_8
XFILLER_83_205 VDD VSS sg13g2_decap_4
XFILLER_65_920 VDD VSS sg13g2_decap_8
XFILLER_77_780 VDD VSS sg13g2_decap_8
XFILLER_96_599 VDD VSS sg13g2_decap_8
Xinput4 input4/X input4/A VDD VSS sg13g2_buf_1
XFILLER_65_931 VDD VSS sg13g2_fill_2
XFILLER_65_964 VDD VSS sg13g2_decap_8
X_09450_ _14051_/D _10146_/A1 _14051_/Q _09470_/S VDD VSS sg13g2_mux2_1
XFILLER_52_614 VDD VSS sg13g2_decap_8
X_08401_ _08401_/Y _15097_/Q _15092_/Q _13561_/A0 VDD VSS sg13g2_o21ai_1
XFILLER_80_956 VDD VSS sg13g2_decap_8
X_09381_ _13984_/D _09447_/A0 _13984_/Q _09404_/S VDD VSS sg13g2_mux2_1
XFILLER_80_978 VDD VSS sg13g2_fill_2
X_08332_ _08335_/C _08332_/A1 _08157_/X _08331_/Y VDD VSS sg13g2_o21ai_1
XFILLER_36_1236 VDD VSS sg13g2_fill_1
XFILLER_123_1206 VDD VSS sg13g2_decap_8
XFILLER_71_1149 VDD VSS sg13g2_fill_1
X_08263_ _08263_/Y _11502_/A _08263_/B VDD VSS sg13g2_nand2b_1
XFILLER_119_900 VDD VSS sg13g2_decap_8
XFILLER_137_218 VDD VSS sg13g2_decap_4
XFILLER_20_588 VDD VSS sg13g2_fill_1
X_08194_ _08194_/Y _08081_/X _08599_/B VDD VSS sg13g2_nand2b_1
XFILLER_119_944 VDD VSS sg13g2_decap_4
XFILLER_106_616 VDD VSS sg13g2_decap_8
XFILLER_10_14 VDD VSS sg13g2_decap_8
XFILLER_69_1067 VDD VSS sg13g2_decap_4
XFILLER_126_14 VDD VSS sg13g2_decap_8
XFILLER_0_905 VDD VSS sg13g2_fill_2
XFILLER_102_811 VDD VSS sg13g2_decap_8
XFILLER_120_118 VDD VSS sg13g2_fill_1
XFILLER_101_310 VDD VSS sg13g2_decap_8
XFILLER_102_833 VDD VSS sg13g2_decap_8
XFILLER_87_533 VDD VSS sg13g2_fill_2
XFILLER_99_393 VDD VSS sg13g2_decap_8
XFILLER_43_1229 VDD VSS sg13g2_decap_8
XFILLER_59_235 VDD VSS sg13g2_decap_8
XFILLER_87_544 VDD VSS sg13g2_fill_1
XFILLER_101_321 VDD VSS sg13g2_fill_2
XFILLER_48_909 VDD VSS sg13g2_decap_4
XFILLER_59_246 VDD VSS sg13g2_fill_2
XFILLER_19_56 VDD VSS sg13g2_decap_8
X_07978_ _07978_/Y _07905_/D _07960_/Y _07979_/A VDD VSS sg13g2_o21ai_1
XFILLER_102_899 VDD VSS sg13g2_decap_8
XFILLER_142_35 VDD VSS sg13g2_decap_8
X_09717_ _14308_/D _10147_/A1 _14308_/Q _09737_/S VDD VSS sg13g2_mux2_1
XFILLER_27_110 VDD VSS sg13g2_decap_8
XFILLER_27_121 VDD VSS sg13g2_fill_2
XFILLER_142_79 VDD VSS sg13g2_fill_1
X_09648_ _14241_/D _09747_/A1 _14241_/Q wire639/X VDD VSS sg13g2_mux2_1
XFILLER_56_986 VDD VSS sg13g2_fill_1
XFILLER_76_1016 VDD VSS sg13g2_fill_1
XFILLER_42_102 VDD VSS sg13g2_fill_2
X_09579_ _14176_/D _14176_/Q _09977_/A0 wire329/X VDD VSS sg13g2_mux2_1
XFILLER_71_989 VDD VSS sg13g2_decap_8
XFILLER_24_861 VDD VSS sg13g2_fill_1
XFILLER_70_466 VDD VSS sg13g2_decap_8
X_11610_ _11610_/Y _11614_/S0 _14406_/Q _11598_/C VDD VSS sg13g2_a21oi_1
XFILLER_30_308 VDD VSS sg13g2_decap_4
XFILLER_24_872 VDD VSS sg13g2_decap_8
XFILLER_70_477 VDD VSS sg13g2_fill_1
X_12590_ _12590_/X _13740_/Q _14092_/Q _14444_/Q _14540_/Q _12592_/S0 _12592_/S1 VDD
+ VSS sg13g2_mux4_1
X_11541_ _11542_/A _13732_/Q _14084_/Q _14436_/Q _14532_/Q _12259_/S0 _12259_/S1 VDD
+ VSS sg13g2_mux4_1
XFILLER_23_393 VDD VSS sg13g2_decap_8
XFILLER_50_190 VDD VSS sg13g2_fill_1
XFILLER_51_43 VDD VSS sg13g2_decap_4
XFILLER_156_527 VDD VSS sg13g2_decap_8
Xwire435 wire435/X wire435/A VDD VSS sg13g2_buf_8
X_14260_ _14260_/Q _14726_/CLK _14260_/D _14260_/RESET_B VDD VSS sg13g2_dfrbpq_1
X_11472_ _11472_/X _13825_/Q _13857_/Q _13889_/Q _13921_/Q _11670_/S0 _11686_/S1 VDD
+ VSS sg13g2_mux4_1
XFILLER_51_76 VDD VSS sg13g2_decap_8
XFILLER_51_87 VDD VSS sg13g2_fill_1
XFILLER_7_559 VDD VSS sg13g2_decap_4
XFILLER_51_98 VDD VSS sg13g2_decap_8
X_13211_ _15047_/D _13266_/A _13211_/B VDD VSS sg13g2_nor2_1
XFILLER_137_763 VDD VSS sg13g2_decap_4
XFILLER_13_1055 VDD VSS sg13g2_decap_8
XFILLER_100_1003 VDD VSS sg13g2_fill_1
X_10423_ _14830_/D _10423_/A _10423_/B _13363_/B VDD VSS sg13g2_and3_1
X_14191_ _14191_/Q clkload13/A _14191_/D _14191_/RESET_B VDD VSS sg13g2_dfrbpq_1
X_14039__2525 _14039_/RESET_B VDD VSS sg13g2_tiehi
X_13142_ _13174_/A _13142_/A _13671_/Q VDD VSS sg13g2_nand2_1
XFILLER_100_1047 VDD VSS sg13g2_decap_8
X_10354_ _10360_/C _14811_/Q _10353_/B VDD VSS sg13g2_nor2b_1
XFILLER_3_732 VDD VSS sg13g2_fill_2
XFILLER_100_1069 VDD VSS sg13g2_fill_1
XFILLER_3_743 VDD VSS sg13g2_decap_8
XFILLER_151_243 VDD VSS sg13g2_decap_8
XFILLER_87_1189 VDD VSS sg13g2_fill_2
XFILLER_4_0 VDD VSS sg13g2_decap_8
XFILLER_151_254 VDD VSS sg13g2_fill_1
XFILLER_97_308 VDD VSS sg13g2_decap_8
X_13073_ _13073_/Y _13222_/A1 _13072_/X _13071_/Y VDD VSS sg13g2_a21oi_1
X_10285_ _10288_/B _14788_/Q _14789_/Q _10305_/A _10305_/B VDD VSS sg13g2_nand4_1
XFILLER_2_275 VDD VSS sg13g2_decap_8
X_12024_ _12026_/A _12025_/A _14642_/Q VDD VSS sg13g2_nand2b_1
Xfanout1500 _12911_/B _13602_/A VDD VSS sg13g2_buf_1
Xfanout1511 _13142_/A _14916_/Q VDD VSS sg13g2_buf_1
Xfanout1522 _12963_/A _14873_/Q VDD VSS sg13g2_buf_1
X_14254__2310 _14254_/RESET_B VDD VSS sg13g2_tiehi
XFILLER_76_51 VDD VSS sg13g2_decap_8
Xfanout1577 _11446_/A _12173_/B1 VDD VSS sg13g2_buf_1
XFILLER_4_1223 VDD VSS sg13g2_decap_8
Xfanout1588 _12336_/B1 _12265_/B1 VDD VSS sg13g2_buf_1
XFILLER_24_1162 VDD VSS sg13g2_decap_8
XFILLER_65_238 VDD VSS sg13g2_fill_1
Xfanout1599 _11439_/A _12219_/S VDD VSS sg13g2_buf_1
X_13975_ _13975_/Q clkload3/A _13975_/D _13975_/RESET_B VDD VSS sg13g2_dfrbpq_1
XFILLER_150_1192 VDD VSS sg13g2_decap_8
XFILLER_20_1037 VDD VSS sg13g2_decap_8
XFILLER_62_912 VDD VSS sg13g2_decap_8
X_12926_ _12928_/B _14901_/Q _13686_/Q _12989_/B VDD VSS sg13g2_o21ai_1
XFILLER_59_1236 VDD VSS sg13g2_fill_1
XFILLER_73_260 VDD VSS sg13g2_decap_8
XFILLER_74_794 VDD VSS sg13g2_decap_4
XFILLER_61_433 VDD VSS sg13g2_fill_2
X_14287__2277 _14287_/RESET_B VDD VSS sg13g2_tiehi
XFILLER_146_1228 VDD VSS sg13g2_decap_8
XFILLER_34_669 VDD VSS sg13g2_decap_8
X_12857_ _12861_/A _12846_/Y _12848_/X _12847_/X VDD VSS sg13g2_a21oi_1
XFILLER_61_488 VDD VSS sg13g2_decap_8
X_11808_ _11808_/Y _11808_/A _12036_/B VDD VSS sg13g2_nand2_1
X_12788_ _12788_/X _12787_/X _12786_/X _12783_/X _12782_/X _12788_/S0 _12788_/S1 VDD
+ VSS sg13g2_mux4_1
X_14527_ _14527_/Q clkload56/A _14527_/D _14527_/RESET_B VDD VSS sg13g2_dfrbpq_1
X_11739_ _11743_/A _11738_/X _11739_/B VDD VSS sg13g2_nand2b_1
XFILLER_41_190 VDD VSS sg13g2_decap_8
XFILLER_70_1160 VDD VSS sg13g2_decap_8
X_14458_ _14458_/Q clkload58/A _14458_/D _14458_/RESET_B VDD VSS sg13g2_dfrbpq_1
XFILLER_128_741 VDD VSS sg13g2_fill_1
X_13409_ _13409_/Y _13507_/B _15092_/Q VDD VSS sg13g2_nor2b_1
X_14389_ _14389_/Q clkload42/A _14389_/D _14389_/RESET_B VDD VSS sg13g2_dfrbpq_1
XFILLER_116_914 VDD VSS sg13g2_decap_8
XFILLER_127_251 VDD VSS sg13g2_decap_8
XFILLER_128_774 VDD VSS sg13g2_decap_8
Xmax_cap713 _08780_/A1 _08728_/Y VDD VSS sg13g2_buf_2
XFILLER_31_1188 VDD VSS sg13g2_decap_8
XFILLER_116_936 VDD VSS sg13g2_fill_2
XFILLER_143_755 VDD VSS sg13g2_decap_8
Xmax_cap768 _09018_/A2 _09011_/Y VDD VSS sg13g2_buf_1
XFILLER_115_457 VDD VSS sg13g2_decap_4
X_08950_ _08950_/Y _08948_/Y _08949_/Y _08925_/S VDD VSS sg13g2_a21oi_1
XFILLER_88_308 VDD VSS sg13g2_fill_1
XFILLER_142_265 VDD VSS sg13g2_fill_2
XFILLER_115_479 VDD VSS sg13g2_decap_4
XFILLER_37_0 VDD VSS sg13g2_decap_8
X_07901_ _07904_/C _08073_/A _08073_/C _08073_/B VDD VSS sg13g2_a21oi_1
XFILLER_116_1010 VDD VSS sg13g2_fill_2
XFILLER_9_1134 VDD VSS sg13g2_decap_8
X_08881_ _08881_/X _15034_/Q _14938_/Q _10725_/A VDD VSS sg13g2_mux2_1
XFILLER_111_641 VDD VSS sg13g2_decap_8
XFILLER_69_566 VDD VSS sg13g2_decap_4
XFILLER_111_652 VDD VSS sg13g2_fill_1
X_07832_ _07834_/B _08692_/C _08692_/B VDD VSS sg13g2_nor2b_1
XFILLER_111_663 VDD VSS sg13g2_fill_2
XFILLER_96_363 VDD VSS sg13g2_fill_1
XFILLER_97_897 VDD VSS sg13g2_decap_8
X_13737__2827 _13737_/RESET_B VDD VSS sg13g2_tiehi
XFILLER_57_739 VDD VSS sg13g2_decap_8
XFILLER_84_514 VDD VSS sg13g2_decap_8
XFILLER_110_151 VDD VSS sg13g2_decap_8
XFILLER_99_1038 VDD VSS sg13g2_decap_4
XFILLER_116_1098 VDD VSS sg13g2_fill_1
XFILLER_2_70 VDD VSS sg13g2_decap_8
X_07763_ _15204_/D _07744_/B _07738_/Y _07762_/Y VDD VSS sg13g2_o21ai_1
XFILLER_37_430 VDD VSS sg13g2_fill_2
XFILLER_84_569 VDD VSS sg13g2_fill_2
X_09502_ _14102_/D _10098_/A0 _14102_/Q wire482/X VDD VSS sg13g2_mux2_1
XFILLER_25_614 VDD VSS sg13g2_fill_1
XFILLER_52_400 VDD VSS sg13g2_decap_8
X_07694_ _07694_/Y _11241_/A _15053_/Q _07674_/Y VDD VSS sg13g2_a21oi_1
XFILLER_53_956 VDD VSS sg13g2_fill_2
X_09433_ _14035_/D _09963_/A1 _14035_/Q _09436_/S VDD VSS sg13g2_mux2_1
XFILLER_64_282 VDD VSS sg13g2_decap_8
X_14117__2447 _14117_/RESET_B VDD VSS sg13g2_tiehi
X_13952__2612 _13952_/RESET_B VDD VSS sg13g2_tiehi
XFILLER_52_477 VDD VSS sg13g2_fill_1
X_09364_ _13968_/D _10092_/A0 _13968_/Q wire689/X VDD VSS sg13g2_mux2_1
XFILLER_12_319 VDD VSS sg13g2_decap_4
XFILLER_40_639 VDD VSS sg13g2_fill_1
XFILLER_36_1044 VDD VSS sg13g2_decap_8
X_08315_ _08315_/Y _08315_/A _08315_/B _08315_/C VDD VSS sg13g2_nor3_1
X_09295_ _13903_/D _13903_/Q _09893_/A0 _09299_/S VDD VSS sg13g2_mux2_1
XFILLER_123_1025 VDD VSS sg13g2_decap_8
X_08246_ _08246_/Y _08359_/B2 _08243_/Y _08244_/Y _08245_/Y _08240_/Y VDD VSS sg13g2_a221oi_1
XFILLER_119_730 VDD VSS sg13g2_fill_1
X_14332__2232 _14332_/RESET_B VDD VSS sg13g2_tiehi
XFILLER_21_35 VDD VSS sg13g2_decap_8
XFILLER_10_1206 VDD VSS sg13g2_decap_8
X_13985__2579 _13985_/RESET_B VDD VSS sg13g2_tiehi
X_08177_ _08177_/X _08042_/X _08059_/X _08328_/S VDD VSS sg13g2_mux2_1
XFILLER_115_7 VDD VSS sg13g2_decap_8
XFILLER_137_35 VDD VSS sg13g2_decap_8
XFILLER_133_210 VDD VSS sg13g2_decap_4
XFILLER_107_969 VDD VSS sg13g2_decap_4
XFILLER_97_39 VDD VSS sg13g2_fill_1
XFILLER_0_735 VDD VSS sg13g2_decap_8
XFILLER_121_438 VDD VSS sg13g2_fill_1
X_14365__2199 _14365_/RESET_B VDD VSS sg13g2_tiehi
XFILLER_0_746 VDD VSS sg13g2_fill_1
XFILLER_121_449 VDD VSS sg13g2_decap_8
X_10070_ _10070_/Y _10070_/A _10070_/B _10070_/C VDD VSS sg13g2_nand3_1
XFILLER_88_853 VDD VSS sg13g2_fill_1
XFILLER_87_341 VDD VSS sg13g2_decap_8
XFILLER_153_56 VDD VSS sg13g2_decap_8
XFILLER_75_525 VDD VSS sg13g2_decap_4
XFILLER_46_21 VDD VSS sg13g2_decap_8
XFILLER_28_441 VDD VSS sg13g2_decap_8
XFILLER_46_65 VDD VSS sg13g2_decap_8
X_13760_ _13760_/Q _14916_/CLK _13760_/D _13760_/RESET_B VDD VSS sg13g2_dfrbpq_1
XFILLER_56_783 VDD VSS sg13g2_fill_1
X_10972_ _14939_/D _10971_/Y _10970_/Y _10959_/Y VDD VSS sg13g2_o21ai_1
XFILLER_90_528 VDD VSS sg13g2_fill_2
XFILLER_83_580 VDD VSS sg13g2_fill_1
X_12711_ _12711_/X _13845_/Q _13877_/Q _13909_/Q _13941_/Q _12772_/S0 _12772_/S1 VDD
+ VSS sg13g2_mux4_1
X_13691_ _13691_/Q _15250_/CLK _13691_/D _13691_/RESET_B VDD VSS sg13g2_dfrbpq_1
X_14836__3257 _14836_/RESET_B VDD VSS sg13g2_tiehi
XFILLER_43_455 VDD VSS sg13g2_decap_4
XFILLER_15_157 VDD VSS sg13g2_decap_8
XFILLER_54_1100 VDD VSS sg13g2_decap_8
XFILLER_71_775 VDD VSS sg13g2_decap_8
X_12642_ _12642_/X _14384_/Q _14416_/Q _14480_/Q _14512_/Q _12787_/S0 _12787_/S1 VDD
+ VSS sg13g2_mux4_1
XFILLER_30_105 VDD VSS sg13g2_decap_8
XFILLER_30_116 VDD VSS sg13g2_fill_2
XFILLER_24_680 VDD VSS sg13g2_fill_1
XFILLER_93_1182 VDD VSS sg13g2_decap_8
XFILLER_141_0 VDD VSS sg13g2_decap_8
XFILLER_24_691 VDD VSS sg13g2_fill_2
XFILLER_54_1155 VDD VSS sg13g2_fill_2
X_12573_ _12573_/X _14123_/Q _14155_/Q _14187_/Q _14219_/Q _12578_/S0 _12771_/S1 VDD
+ VSS sg13g2_mux4_1
XFILLER_11_330 VDD VSS sg13g2_decap_8
X_14312_ _14312_/Q _14465_/CLK _14312_/D _14312_/RESET_B VDD VSS sg13g2_dfrbpq_1
X_11524_ _11527_/A _11502_/A _13685_/Q _11505_/X VDD VSS sg13g2_a21oi_1
Xwire210 wire210/X wire210/A VDD VSS sg13g2_buf_2
XFILLER_156_335 VDD VSS sg13g2_decap_8
Xwire232 wire232/X wire232/A VDD VSS sg13g2_buf_2
XFILLER_156_346 VDD VSS sg13g2_fill_1
XFILLER_7_345 VDD VSS sg13g2_decap_8
Xwire254 wire254/X wire255/X VDD VSS sg13g2_buf_2
X_14243_ _14243_/Q _14405_/CLK _14243_/D _14243_/RESET_B VDD VSS sg13g2_dfrbpq_1
X_11455_ _11457_/C _11430_/B _11430_/A _11427_/X VDD VSS sg13g2_a21o_1
X_13815__2749 _13815_/RESET_B VDD VSS sg13g2_tiehi
X_14575__1989 _14575_/RESET_B VDD VSS sg13g2_tiehi
Xwire298 wire298/X wire298/A VDD VSS sg13g2_buf_2
X_10406_ _14824_/D _10406_/A _10655_/B _10406_/C VDD VSS sg13g2_nor3_1
X_14174_ _14174_/Q _14494_/CLK _14174_/D _14174_/RESET_B VDD VSS sg13g2_dfrbpq_1
XFILLER_152_530 VDD VSS sg13g2_fill_2
X_11386_ _11386_/Y _07684_/B _11385_/Y wire271/X _11381_/Y _11248_/B VDD VSS sg13g2_a221oi_1
XFILLER_109_295 VDD VSS sg13g2_fill_2
XFILLER_152_541 VDD VSS sg13g2_fill_2
X_13125_ _13125_/X input16/X _13149_/A2 _13264_/B1 VDD VSS sg13g2_a21o_1
X_10337_ _14805_/D _10337_/A _10337_/B _10337_/C VDD VSS sg13g2_and3_1
XFILLER_152_574 VDD VSS sg13g2_decap_8
XFILLER_79_820 VDD VSS sg13g2_fill_1
XFILLER_79_831 VDD VSS sg13g2_fill_2
XFILLER_152_1210 VDD VSS sg13g2_decap_8
XFILLER_30_7 VDD VSS sg13g2_decap_8
XFILLER_3_595 VDD VSS sg13g2_fill_2
X_13056_ _15036_/D _13043_/Y wire209/X _13239_/A VDD VSS sg13g2_a21oi_1
X_10268_ _10299_/B _14782_/Q _14783_/Q _14784_/Q _10268_/D VDD VSS sg13g2_nand4_1
X_12007_ _12053_/A _12009_/A _12298_/B VDD VSS sg13g2_nor2_1
Xfanout1330 _13412_/B _15057_/Q VDD VSS sg13g2_buf_1
Xfanout1341 _08351_/B _15001_/Q VDD VSS sg13g2_buf_1
XFILLER_79_897 VDD VSS sg13g2_decap_8
Xfanout1352 _13561_/A0 _13534_/A1 VDD VSS sg13g2_buf_1
X_10199_ _15181_/D hold3433/X _10199_/A1 _13336_/S VDD VSS sg13g2_mux2_1
Xfanout1363 _08140_/B _08142_/B VDD VSS sg13g2_buf_1
Xfanout1374 _08235_/S0 _08686_/S1 VDD VSS sg13g2_buf_1
XFILLER_66_536 VDD VSS sg13g2_decap_4
Xfanout1385 _13521_/A _14990_/Q VDD VSS sg13g2_buf_1
XFILLER_94_856 VDD VSS sg13g2_decap_8
Xfanout1396 _08023_/A _07626_/A VDD VSS sg13g2_buf_1
XFILLER_35_901 VDD VSS sg13g2_decap_8
XFILLER_81_528 VDD VSS sg13g2_decap_8
X_13958_ _13958_/Q clkload12/A _13958_/D _13958_/RESET_B VDD VSS sg13g2_dfrbpq_1
X_14410__2154 _14410_/RESET_B VDD VSS sg13g2_tiehi
XFILLER_4_1097 VDD VSS sg13g2_decap_8
XFILLER_62_731 VDD VSS sg13g2_decap_8
XFILLER_62_742 VDD VSS sg13g2_fill_2
XFILLER_98_1093 VDD VSS sg13g2_decap_4
X_12909_ _12909_/Y _12925_/A _12925_/B _12909_/C VDD VSS sg13g2_nand3_1
X_13889_ _13889_/Q _14465_/CLK _13889_/D _13889_/RESET_B VDD VSS sg13g2_dfrbpq_1
XFILLER_50_915 VDD VSS sg13g2_fill_1
XFILLER_50_926 VDD VSS sg13g2_fill_1
XFILLER_22_639 VDD VSS sg13g2_decap_8
XFILLER_146_1069 VDD VSS sg13g2_decap_8
XFILLER_21_149 VDD VSS sg13g2_fill_1
X_08100_ _08104_/C _08140_/B _08452_/D _08200_/C VDD VSS sg13g2_nor3_1
X_09080_ _09082_/B _13088_/A _09103_/C _14913_/Q VDD VSS sg13g2_a21o_1
X_08031_ _08032_/D _08140_/B _08452_/D _08031_/C VDD VSS sg13g2_nor3_1
XFILLER_135_519 VDD VSS sg13g2_decap_8
XFILLER_116_755 VDD VSS sg13g2_decap_8
X_09982_ _14565_/D _10081_/A0 _14565_/Q _10000_/S VDD VSS sg13g2_mux2_1
XFILLER_118_1127 VDD VSS sg13g2_decap_8
X_08933_ _08933_/X _15047_/Q _14951_/Q _08943_/A VDD VSS sg13g2_mux2_1
X_14620__1944 _14620_/RESET_B VDD VSS sg13g2_tiehi
XFILLER_97_661 VDD VSS sg13g2_decap_8
X_08864_ _13699_/D _13699_/Q _08863_/X _08892_/S VDD VSS sg13g2_mux2_1
XFILLER_84_300 VDD VSS sg13g2_fill_2
XFILLER_57_547 VDD VSS sg13g2_decap_8
X_07815_ _07815_/X _15010_/Q _07815_/B VDD VSS sg13g2_or2_1
XFILLER_84_333 VDD VSS sg13g2_decap_8
X_08795_ _08796_/B _13683_/Q _08807_/B VDD VSS sg13g2_nor2_1
X_07746_ _07750_/B _13481_/A _15124_/Q _07746_/C VDD VSS sg13g2_nor3_1
XFILLER_16_35 VDD VSS sg13g2_decap_8
XFILLER_38_1106 VDD VSS sg13g2_decap_8
XFILLER_77_1155 VDD VSS sg13g2_decap_8
X_07677_ _07677_/Y _13356_/B _07677_/B _07677_/C _07721_/A VDD VSS sg13g2_nand4_1
XFILLER_41_915 VDD VSS sg13g2_fill_1
X_09416_ _14018_/D _09649_/A0 _14018_/Q _09437_/S VDD VSS sg13g2_mux2_1
XFILLER_73_1019 VDD VSS sg13g2_decap_8
XFILLER_13_628 VDD VSS sg13g2_decap_8
XFILLER_12_105 VDD VSS sg13g2_decap_8
XFILLER_40_414 VDD VSS sg13g2_decap_8
XFILLER_80_583 VDD VSS sg13g2_decap_8
X_09347_ _13951_/D _09646_/A0 _13951_/Q _09347_/S VDD VSS sg13g2_mux2_1
XFILLER_139_814 VDD VSS sg13g2_fill_2
XFILLER_21_650 VDD VSS sg13g2_fill_2
X_09278_ _13886_/D _13886_/Q _10074_/A0 _09297_/S VDD VSS sg13g2_mux2_1
XFILLER_148_56 VDD VSS sg13g2_decap_8
X_08229_ _08229_/Y _08229_/A _08229_/B _08229_/C VDD VSS sg13g2_nand3_1
XFILLER_107_711 VDD VSS sg13g2_decap_8
XFILLER_147_880 VDD VSS sg13g2_decap_8
XFILLER_14_1183 VDD VSS sg13g2_decap_8
XFILLER_10_1014 VDD VSS sg13g2_decap_8
XFILLER_101_1131 VDD VSS sg13g2_decap_8
X_11240_ _11248_/A _12866_/A _15123_/Q _11239_/Y VDD VSS sg13g2_a21oi_1
XFILLER_4_337 VDD VSS sg13g2_fill_1
XFILLER_4_348 VDD VSS sg13g2_decap_8
XFILLER_107_755 VDD VSS sg13g2_decap_8
XFILLER_134_541 VDD VSS sg13g2_fill_2
XFILLER_106_232 VDD VSS sg13g2_decap_4
XFILLER_106_254 VDD VSS sg13g2_decap_8
X_11171_ _11186_/A _11181_/A _11171_/B VDD VSS sg13g2_nand2_1
XFILLER_122_725 VDD VSS sg13g2_fill_1
XFILLER_84_1159 VDD VSS sg13g2_decap_8
XFILLER_134_596 VDD VSS sg13g2_fill_1
XFILLER_122_736 VDD VSS sg13g2_fill_2
X_10122_ _14700_/D _10155_/A1 _14700_/Q _10127_/S VDD VSS sg13g2_mux2_1
XFILLER_0_543 VDD VSS sg13g2_fill_1
Xhold3460 input22/A mem_axi_rdata[26] VDD VSS sg13g2_dlygate4sd3_1
XFILLER_88_661 VDD VSS sg13g2_decap_8
X_10053_ _14634_/D _10086_/A0 _14634_/Q _10067_/S VDD VSS sg13g2_mux2_1
X_14930_ _14930_/Q clkload39/A _14930_/D _14930_/RESET_B VDD VSS sg13g2_dfrbpq_1
Xhold3471 _13638_/A _13746_/Q VDD VSS sg13g2_dlygate4sd3_1
Xhold3482 _13617_/A _13725_/Q VDD VSS sg13g2_dlygate4sd3_1
Xhold3493 _13643_/A _13751_/Q VDD VSS sg13g2_dlygate4sd3_1
XFILLER_21_1110 VDD VSS sg13g2_decap_8
XFILLER_76_867 VDD VSS sg13g2_fill_1
X_14861_ _14861_/Q clkload69/A _14861_/D _14861_/RESET_B VDD VSS sg13g2_dfrbpq_1
XFILLER_75_355 VDD VSS sg13g2_decap_8
X_13812_ _13812_/Q clkload33/A _13812_/D _13812_/RESET_B VDD VSS sg13g2_dfrbpq_1
XFILLER_29_783 VDD VSS sg13g2_fill_1
XFILLER_16_400 VDD VSS sg13g2_fill_2
X_14792_ _14792_/Q clkload82/A _14792_/D _14792_/RESET_B VDD VSS sg13g2_dfrbpq_1
XFILLER_28_260 VDD VSS sg13g2_decap_8
XFILLER_1_1226 VDD VSS sg13g2_decap_8
XFILLER_113_70 VDD VSS sg13g2_fill_1
XFILLER_90_336 VDD VSS sg13g2_fill_1
XFILLER_21_1187 VDD VSS sg13g2_decap_8
X_10955_ _10956_/B _10954_/C _10965_/C _10953_/Y VDD VSS sg13g2_a21o_1
X_13743_ _13743_/Q clkload11/A _13743_/D _13743_/RESET_B VDD VSS sg13g2_dfrbpq_1
XFILLER_16_488 VDD VSS sg13g2_fill_2
XFILLER_31_425 VDD VSS sg13g2_decap_8
X_10886_ _10886_/X wire584/A _10886_/A2 _10886_/B1 VDD VSS sg13g2_a21o_1
X_13674_ _13674_/Q clkload64/A _13674_/D _13674_/RESET_B VDD VSS sg13g2_dfrbpq_1
XFILLER_31_436 VDD VSS sg13g2_fill_2
X_12625_ _15008_/D _12625_/A wire375/X VDD VSS sg13g2_nor2_1
XFILLER_31_469 VDD VSS sg13g2_decap_8
XFILLER_19_1072 VDD VSS sg13g2_decap_8
XFILLER_129_324 VDD VSS sg13g2_decap_8
X_12556_ _12569_/A _13005_/C _07737_/B _08383_/B VDD VSS sg13g2_a21oi_1
XFILLER_11_171 VDD VSS sg13g2_decap_8
XFILLER_78_7 VDD VSS sg13g2_decap_8
XFILLER_106_1075 VDD VSS sg13g2_fill_1
XFILLER_156_143 VDD VSS sg13g2_decap_8
XFILLER_129_357 VDD VSS sg13g2_decap_8
XFILLER_156_154 VDD VSS sg13g2_fill_1
X_11507_ _11507_/X _13827_/Q _13859_/Q _13891_/Q _13923_/Q _11710_/S0 _11715_/S1 VDD
+ VSS sg13g2_mux4_1
XFILLER_144_305 VDD VSS sg13g2_decap_8
X_12487_ _12487_/X _13829_/Q _13861_/Q _13893_/Q _13925_/Q _12492_/S0 _12494_/S1 VDD
+ VSS sg13g2_mux4_1
XFILLER_89_1048 VDD VSS sg13g2_decap_8
XFILLER_156_198 VDD VSS sg13g2_decap_4
XFILLER_144_349 VDD VSS sg13g2_decap_8
X_11438_ _11439_/B _14240_/Q _14272_/Q _14304_/Q _14336_/Q _12100_/S0 _11598_/C VDD
+ VSS sg13g2_mux4_1
X_14226_ _14226_/Q clkload46/A _14226_/D _14226_/RESET_B VDD VSS sg13g2_dfrbpq_1
XFILLER_99_926 VDD VSS sg13g2_decap_8
X_14157_ _14157_/Q _14669_/CLK _14157_/D _14157_/RESET_B VDD VSS sg13g2_dfrbpq_1
X_11369_ _11369_/Y _11367_/Y _11366_/Y _12317_/B _11368_/X VDD VSS sg13g2_a22oi_1
X_14428__2136 _14428_/RESET_B VDD VSS sg13g2_tiehi
XFILLER_140_511 VDD VSS sg13g2_fill_1
XFILLER_99_948 VDD VSS sg13g2_decap_8
XFILLER_98_82 VDD VSS sg13g2_fill_2
XFILLER_140_533 VDD VSS sg13g2_decap_8
XFILLER_112_224 VDD VSS sg13g2_decap_8
X_13108_ _13108_/Y _14786_/Q _13123_/A2 _13262_/B1 VDD VSS sg13g2_o21ai_1
X_14088_ _14088_/Q clkload28/A _14088_/D _14088_/RESET_B VDD VSS sg13g2_dfrbpq_1
XFILLER_101_909 VDD VSS sg13g2_decap_4
X_13039_ _13057_/C _14909_/Q _13678_/Q VDD VSS sg13g2_nand2_1
XFILLER_67_812 VDD VSS sg13g2_fill_2
XFILLER_113_1002 VDD VSS sg13g2_decap_8
XFILLER_78_160 VDD VSS sg13g2_decap_8
XFILLER_152_1062 VDD VSS sg13g2_decap_8
XFILLER_26_1065 VDD VSS sg13g2_decap_8
XFILLER_94_620 VDD VSS sg13g2_fill_2
Xfanout1160 _12686_/S0 _12740_/S0 VDD VSS sg13g2_buf_1
XFILLER_6_1159 VDD VSS sg13g2_decap_8
Xfanout1182 _12770_/S0 _12773_/S0 VDD VSS sg13g2_buf_1
XFILLER_67_889 VDD VSS sg13g2_decap_8
XFILLER_113_1079 VDD VSS sg13g2_fill_1
X_08580_ _08581_/B _08641_/D _08578_/Y _08579_/Y VDD VSS sg13g2_o21ai_1
XFILLER_47_591 VDD VSS sg13g2_fill_2
XFILLER_23_926 VDD VSS sg13g2_fill_1
XFILLER_50_712 VDD VSS sg13g2_decap_4
XFILLER_62_594 VDD VSS sg13g2_decap_8
X_14034__2530 _14034_/RESET_B VDD VSS sg13g2_tiehi
X_09201_ _13817_/D _13817_/Q _09705_/A0 _09201_/S VDD VSS sg13g2_mux2_1
XFILLER_50_778 VDD VSS sg13g2_decap_8
XFILLER_33_1014 VDD VSS sg13g2_decap_8
X_09132_ _13781_/D _13781_/Q _10131_/A0 _09160_/S VDD VSS sg13g2_mux2_1
XFILLER_33_1036 VDD VSS sg13g2_fill_2
X_14638__1926 _14638_/RESET_B VDD VSS sg13g2_tiehi
XFILLER_136_806 VDD VSS sg13g2_fill_2
XFILLER_33_1058 VDD VSS sg13g2_decap_8
XFILLER_124_1175 VDD VSS sg13g2_decap_4
XFILLER_136_817 VDD VSS sg13g2_fill_2
XFILLER_33_1069 VDD VSS sg13g2_fill_2
X_09063_ _09063_/X _08988_/A _09060_/X _09062_/Y VDD VSS sg13g2_a21o_1
X_14820__3278 _14820_/RESET_B VDD VSS sg13g2_tiehi
XFILLER_135_305 VDD VSS sg13g2_decap_8
XFILLER_8_91 VDD VSS sg13g2_decap_8
X_08014_ _08014_/Y _08011_/X _08213_/S VDD VSS sg13g2_nand2b_1
XFILLER_151_809 VDD VSS sg13g2_fill_2
X_14067__2497 _14067_/RESET_B VDD VSS sg13g2_tiehi
XFILLER_116_541 VDD VSS sg13g2_fill_2
XFILLER_144_872 VDD VSS sg13g2_decap_8
XFILLER_143_360 VDD VSS sg13g2_decap_8
XFILLER_104_725 VDD VSS sg13g2_fill_1
XFILLER_143_371 VDD VSS sg13g2_fill_2
XFILLER_103_213 VDD VSS sg13g2_decap_8
Xmax_cap395 _10168_/S _10169_/S VDD VSS sg13g2_buf_4
XFILLER_131_544 VDD VSS sg13g2_decap_4
XFILLER_134_14 VDD VSS sg13g2_decap_8
X_09965_ _14549_/D _14549_/Q _10064_/A0 _09969_/S VDD VSS sg13g2_mux2_1
X_15006__2966 _15006_/RESET_B VDD VSS sg13g2_tiehi
XFILLER_83_1181 VDD VSS sg13g2_fill_2
X_08916_ _08916_/Y _08835_/A _08835_/B _13711_/Q VDD VSS sg13g2_a21oi_1
XFILLER_98_992 VDD VSS sg13g2_fill_2
X_14282__2282 _14282_/RESET_B VDD VSS sg13g2_tiehi
XFILLER_58_834 VDD VSS sg13g2_decap_8
X_09896_ _14482_/D _09929_/A1 _14482_/Q _09903_/S VDD VSS sg13g2_mux2_1
XFILLER_112_780 VDD VSS sg13g2_decap_8
XFILLER_40_1029 VDD VSS sg13g2_decap_4
X_08847_ _13694_/D _13694_/Q wire554/X _08926_/S VDD VSS sg13g2_mux2_1
XFILLER_85_664 VDD VSS sg13g2_fill_2
XFILLER_17_208 VDD VSS sg13g2_decap_8
XFILLER_45_528 VDD VSS sg13g2_decap_8
X_08778_ _08778_/Y _13678_/Q _08778_/B VDD VSS sg13g2_nor2_1
XFILLER_150_35 VDD VSS sg13g2_decap_8
XFILLER_27_78 VDD VSS sg13g2_fill_1
XFILLER_27_89 VDD VSS sg13g2_decap_8
X_07729_ wire911/A _15105_/Q _12851_/B _13260_/B _12862_/B VDD VSS sg13g2_nor4_1
XFILLER_14_904 VDD VSS sg13g2_decap_8
XFILLER_60_509 VDD VSS sg13g2_decap_8
X_10740_ _11033_/B _08954_/S _09079_/Y _08907_/Y VDD VSS sg13g2_o21ai_1
XFILLER_41_723 VDD VSS sg13g2_fill_1
XFILLER_81_892 VDD VSS sg13g2_fill_1
XFILLER_53_594 VDD VSS sg13g2_fill_1
XFILLER_13_436 VDD VSS sg13g2_decap_8
XFILLER_80_391 VDD VSS sg13g2_decap_8
XFILLER_40_244 VDD VSS sg13g2_fill_2
X_10671_ _10671_/Y _13308_/B _10671_/B VDD VSS sg13g2_nand2b_1
XFILLER_129_1097 VDD VSS sg13g2_decap_8
X_14506__2058 _14506_/RESET_B VDD VSS sg13g2_tiehi
XFILLER_16_1212 VDD VSS sg13g2_decap_8
XFILLER_139_622 VDD VSS sg13g2_fill_2
XFILLER_90_1152 VDD VSS sg13g2_decap_4
XFILLER_142_1231 VDD VSS sg13g2_decap_4
X_12410_ _12410_/X _13823_/Q _13855_/Q _13887_/Q _13919_/Q _12411_/S0 _12411_/S1 VDD
+ VSS sg13g2_mux4_1
XFILLER_22_981 VDD VSS sg13g2_decap_8
X_13390_ _15083_/D _15083_/Q _13427_/A _13389_/Y VDD VSS sg13g2_a21o_1
XFILLER_139_666 VDD VSS sg13g2_decap_8
XFILLER_12_1109 VDD VSS sg13g2_decap_8
XFILLER_139_677 VDD VSS sg13g2_fill_1
X_12341_ _14988_/D _12302_/Y _12340_/Y _12298_/Y VDD VSS sg13g2_a21oi_1
XFILLER_127_828 VDD VSS sg13g2_decap_8
XFILLER_4_112 VDD VSS sg13g2_decap_8
X_15060_ _15060_/Q _15250_/CLK _15060_/D _15060_/RESET_B VDD VSS sg13g2_dfrbpq_1
X_12272_ _12273_/A _12272_/A _12231_/A VDD VSS sg13g2_nor2b_1
XFILLER_142_809 VDD VSS sg13g2_fill_2
X_14011_ _14011_/Q clkload60/A _14011_/D _14011_/RESET_B VDD VSS sg13g2_dfrbpq_1
X_13732__2832 _13732_/RESET_B VDD VSS sg13g2_tiehi
XFILLER_153_168 VDD VSS sg13g2_decap_8
X_11223_ _11224_/C _12334_/C _11223_/B _11223_/C VDD VSS sg13g2_nor3_1
XFILLER_104_0 VDD VSS sg13g2_decap_8
XFILLER_135_883 VDD VSS sg13g2_decap_8
XFILLER_4_178 VDD VSS sg13g2_decap_8
XFILLER_4_189 VDD VSS sg13g2_fill_2
XFILLER_4_49 VDD VSS sg13g2_decap_8
X_11154_ _11154_/Y _11109_/B _11180_/C _11183_/B1 VDD VSS sg13g2_o21ai_1
XFILLER_122_544 VDD VSS sg13g2_decap_8
XFILLER_1_841 VDD VSS sg13g2_fill_2
XFILLER_122_555 VDD VSS sg13g2_fill_1
X_10105_ _10105_/X _10105_/A wire765/X _10105_/C _10105_/D VDD VSS sg13g2_and4_1
XFILLER_0_351 VDD VSS sg13g2_decap_8
XFILLER_49_812 VDD VSS sg13g2_decap_8
XFILLER_0_362 VDD VSS sg13g2_fill_1
X_11085_ _11085_/Y _11185_/A _11115_/A VDD VSS sg13g2_nor2_1
XFILLER_110_739 VDD VSS sg13g2_decap_8
XFILLER_48_311 VDD VSS sg13g2_decap_4
X_14112__2452 _14112_/RESET_B VDD VSS sg13g2_tiehi
X_14913_ _14913_/Q clkload61/A _14913_/D _14913_/RESET_B VDD VSS sg13g2_dfrbpq_1
X_10036_ _14618_/D _10069_/A0 _14618_/Q wire601/X VDD VSS sg13g2_mux2_1
X_13765__2799 _13765_/RESET_B VDD VSS sg13g2_tiehi
XFILLER_36_517 VDD VSS sg13g2_fill_1
X_14844_ _14844_/Q clkload82/A _14844_/D _14844_/RESET_B VDD VSS sg13g2_dfrbpq_1
X_14716__1848 _14716_/RESET_B VDD VSS sg13g2_tiehi
XFILLER_5_1192 VDD VSS sg13g2_decap_8
XFILLER_1_1034 VDD VSS sg13g2_fill_1
Xclkbuf_5_10__f_clk_i clkbuf_leaf_99_clk_i/A clkbuf_4_5_0_clk_i/X VDD VSS sg13g2_buf_16
XFILLER_63_358 VDD VSS sg13g2_fill_2
XFILLER_51_509 VDD VSS sg13g2_fill_1
XFILLER_91_678 VDD VSS sg13g2_fill_1
X_14775_ _14775_/Q _14776_/CLK _14775_/D _14775_/RESET_B VDD VSS sg13g2_dfrbpq_1
XFILLER_44_550 VDD VSS sg13g2_fill_1
XFILLER_95_1052 VDD VSS sg13g2_decap_8
X_11987_ _11989_/B _11936_/A _13130_/B _11988_/B VDD VSS sg13g2_o21ai_1
X_13726_ _13726_/Q clkload53/A _13726_/D _13726_/RESET_B VDD VSS sg13g2_dfrbpq_1
XFILLER_56_1036 VDD VSS sg13g2_decap_4
X_10938_ _10938_/Y _10937_/Y _10935_/A _10935_/Y _10934_/Y _11207_/A2 VDD VSS sg13g2_a221oi_1
X_13980__2584 _13980_/RESET_B VDD VSS sg13g2_tiehi
XFILLER_31_211 VDD VSS sg13g2_decap_8
XFILLER_32_756 VDD VSS sg13g2_fill_1
XFILLER_31_233 VDD VSS sg13g2_decap_8
X_10869_ _10869_/Y _10935_/A _10869_/B VDD VSS sg13g2_nor2_1
X_13657_ _13657_/Q clkload73/A _13657_/D _13657_/RESET_B VDD VSS sg13g2_dfrbpq_1
XFILLER_31_266 VDD VSS sg13g2_decap_8
X_12608_ _12608_/X _12602_/X _12606_/X _12601_/X _12605_/X wire1073/X wire1090/X VDD
+ VSS sg13g2_mux4_1
XFILLER_13_992 VDD VSS sg13g2_decap_8
X_13588_ _15161_/D _13593_/B _13586_/Y _13587_/Y VDD VSS sg13g2_a21oi_1
XFILLER_12_491 VDD VSS sg13g2_fill_1
XFILLER_9_985 VDD VSS sg13g2_decap_8
XFILLER_129_165 VDD VSS sg13g2_decap_8
X_12539_ _12539_/X _12537_/X _12538_/X _12706_/S VDD VSS sg13g2_mux2_1
XFILLER_67_1121 VDD VSS sg13g2_fill_2
X_14209_ _14209_/Q clkload23/A _14209_/D _14209_/RESET_B VDD VSS sg13g2_dfrbpq_1
X_15189_ _15189_/Q _15212_/CLK _15189_/D _15189_/RESET_B VDD VSS sg13g2_dfrbpq_1
XFILLER_113_511 VDD VSS sg13g2_fill_2
XFILLER_154_1113 VDD VSS sg13g2_decap_8
Xfanout419 _09933_/S wire423/A VDD VSS sg13g2_buf_1
XFILLER_115_1108 VDD VSS sg13g2_decap_8
XFILLER_113_577 VDD VSS sg13g2_fill_2
XFILLER_140_374 VDD VSS sg13g2_fill_1
X_09750_ _14340_/D _14340_/Q _10147_/A1 _09770_/S VDD VSS sg13g2_mux2_1
XFILLER_98_299 VDD VSS sg13g2_fill_1
XFILLER_67_631 VDD VSS sg13g2_decap_8
X_08701_ _08701_/Y _07835_/Y _08699_/Y _08588_/B VDD VSS sg13g2_o21ai_1
X_09681_ _14273_/D _09747_/A1 _14273_/Q wire458/X VDD VSS sg13g2_mux2_1
XFILLER_104_28 VDD VSS sg13g2_decap_8
XFILLER_95_984 VDD VSS sg13g2_decap_4
X_08632_ _08633_/A _08641_/A _08630_/Y _08631_/Y VDD VSS sg13g2_o21ai_1
XFILLER_27_528 VDD VSS sg13g2_decap_8
XFILLER_27_539 VDD VSS sg13g2_fill_1
XFILLER_81_100 VDD VSS sg13g2_fill_2
XFILLER_39_1201 VDD VSS sg13g2_decap_8
X_08563_ _08563_/Y _08560_/A _08407_/Y _08562_/Y VDD VSS sg13g2_a21oi_1
XFILLER_81_166 VDD VSS sg13g2_fill_2
X_15157__3028 _15157_/RESET_B VDD VSS sg13g2_tiehi
X_08494_ _08494_/Y _08494_/A _08494_/B VDD VSS sg13g2_nor2_1
X_13810__2754 _13810_/RESET_B VDD VSS sg13g2_tiehi
X_14570__1994 _14570_/RESET_B VDD VSS sg13g2_tiehi
XFILLER_11_907 VDD VSS sg13g2_decap_8
XFILLER_50_553 VDD VSS sg13g2_decap_8
XFILLER_23_789 VDD VSS sg13g2_decap_8
XFILLER_22_266 VDD VSS sg13g2_decap_8
XFILLER_13_14 VDD VSS sg13g2_decap_8
Xwire809 wire809/X wire809/A VDD VSS sg13g2_buf_1
XFILLER_129_14 VDD VSS sg13g2_decap_8
X_09115_ _09117_/B _10760_/A _09150_/B _13168_/A VDD VSS sg13g2_a21o_1
XFILLER_109_828 VDD VSS sg13g2_decap_8
XFILLER_148_474 VDD VSS sg13g2_decap_8
X_09046_ _13768_/D _13768_/Q _10151_/A1 _09153_/S VDD VSS sg13g2_mux2_1
XFILLER_151_617 VDD VSS sg13g2_decap_8
XFILLER_11_1175 VDD VSS sg13g2_decap_8
XFILLER_150_105 VDD VSS sg13g2_decap_8
XFILLER_117_883 VDD VSS sg13g2_decap_8
XFILLER_144_680 VDD VSS sg13g2_fill_2
XFILLER_132_820 VDD VSS sg13g2_fill_2
XFILLER_104_511 VDD VSS sg13g2_decap_4
XFILLER_46_1205 VDD VSS sg13g2_fill_1
XFILLER_145_35 VDD VSS sg13g2_decap_8
XFILLER_8_7 VDD VSS sg13g2_decap_8
XFILLER_46_1216 VDD VSS sg13g2_fill_2
XFILLER_1_126 VDD VSS sg13g2_decap_4
XFILLER_81_1129 VDD VSS sg13g2_decap_8
Xfanout920 _13082_/B _13193_/B VDD VSS sg13g2_buf_1
Xfanout931 _11183_/B1 _07753_/B VDD VSS sg13g2_buf_1
X_09948_ _14532_/D _14532_/Q _10080_/A0 _09954_/S VDD VSS sg13g2_mux2_1
Xfanout942 _11868_/A _12294_/B1 VDD VSS sg13g2_buf_1
XFILLER_58_620 VDD VSS sg13g2_fill_1
Xfanout953 _13471_/S _07663_/Y VDD VSS sg13g2_buf_1
Xfanout975 _11973_/B _11955_/B VDD VSS sg13g2_buf_1
Xfanout986 fanout986/X _07655_/Y VDD VSS sg13g2_buf_1
X_09879_ _14465_/D _09912_/A1 _14465_/Q wire321/X VDD VSS sg13g2_mux2_1
XFILLER_57_141 VDD VSS sg13g2_decap_8
Xfanout997 _11894_/B _11279_/B1 VDD VSS sg13g2_buf_1
XFILLER_57_152 VDD VSS sg13g2_fill_1
XFILLER_79_1003 VDD VSS sg13g2_decap_8
X_11910_ _12056_/B _11910_/A _11910_/B _11910_/C VDD VSS sg13g2_nor3_1
XFILLER_45_325 VDD VSS sg13g2_fill_2
XFILLER_57_185 VDD VSS sg13g2_decap_8
X_12890_ _12894_/A _12875_/Y _12861_/A _12889_/Y VDD VSS sg13g2_o21ai_1
XFILLER_54_21 VDD VSS sg13g2_decap_4
XFILLER_72_144 VDD VSS sg13g2_decap_8
X_11841_ _11845_/C _11770_/A _13064_/B _13676_/Q _11798_/A _11779_/Y VDD VSS sg13g2_a221oi_1
XFILLER_26_572 VDD VSS sg13g2_fill_2
X_14560_ _14560_/Q _14710_/CLK _14560_/D _14560_/RESET_B VDD VSS sg13g2_dfrbpq_1
X_11772_ _11772_/Y _11706_/A _13679_/Q _13678_/Q _11726_/A _11771_/Y VDD VSS sg13g2_a221oi_1
XFILLER_92_1236 VDD VSS sg13g2_fill_1
XFILLER_41_531 VDD VSS sg13g2_decap_8
X_13511_ _15134_/D _15134_/Q _13525_/A _13539_/B VDD VSS sg13g2_mux2_1
X_10723_ _10724_/A _14908_/Q _10973_/B _11183_/B1 _10967_/B VDD VSS sg13g2_a22oi_1
XFILLER_13_255 VDD VSS sg13g2_fill_1
X_14491_ _14491_/Q _14776_/CLK _14491_/D _14491_/RESET_B VDD VSS sg13g2_dfrbpq_1
XFILLER_110_60 VDD VSS sg13g2_fill_2
XFILLER_13_277 VDD VSS sg13g2_decap_8
X_14901__3127 _14901_/RESET_B VDD VSS sg13g2_tiehi
X_13442_ _13442_/Y _13442_/A _13444_/B _13444_/C VDD VSS sg13g2_nor3_1
X_10654_ _10663_/D _10654_/A _10654_/B VDD VSS sg13g2_nor2_1
XFILLER_70_42 VDD VSS sg13g2_decap_4
XFILLER_139_463 VDD VSS sg13g2_fill_2
XFILLER_10_951 VDD VSS sg13g2_decap_8
X_13373_ _13444_/A _13401_/C _13401_/B _13429_/A VDD VSS sg13g2_nand3_1
X_10585_ _14872_/D _10591_/C _10591_/D _10581_/Y VDD VSS sg13g2_a21oi_1
XFILLER_155_945 VDD VSS sg13g2_decap_8
XFILLER_16_1097 VDD VSS sg13g2_decap_8
Xclkload18 clkload18/X clkload18/A VDD VSS sg13g2_buf_8
XFILLER_155_956 VDD VSS sg13g2_decap_4
Xclkload29 clkload29/Y clkload29/A VDD VSS sg13g2_inv_2
XFILLER_6_933 VDD VSS sg13g2_fill_1
X_15112_ _15112_/Q _15178_/CLK _15112_/D _15112_/RESET_B VDD VSS sg13g2_dfrbpq_1
XFILLER_126_124 VDD VSS sg13g2_decap_4
X_12324_ _12324_/X _12324_/A _12324_/B VDD VSS sg13g2_and2_1
XFILLER_154_466 VDD VSS sg13g2_decap_8
XFILLER_108_872 VDD VSS sg13g2_decap_8
XFILLER_141_105 VDD VSS sg13g2_decap_8
XFILLER_138_1119 VDD VSS sg13g2_decap_8
X_12255_ _12255_/Y _12255_/A1 _13880_/Q _12259_/S1 VDD VSS sg13g2_a21oi_1
X_15043_ _15043_/Q clkload48/A _15043_/D _15043_/RESET_B VDD VSS sg13g2_dfrbpq_1
X_11206_ _11206_/Y _11191_/A _11205_/X _11109_/B VDD VSS sg13g2_o21ai_1
XFILLER_79_73 VDD VSS sg13g2_fill_1
X_12186_ _12187_/B _12186_/A _13942_/Q VDD VSS sg13g2_nand2_1
XFILLER_69_929 VDD VSS sg13g2_decap_8
XFILLER_1_660 VDD VSS sg13g2_fill_1
X_11137_ _11152_/B _11163_/A _11190_/C VDD VSS sg13g2_nor2_1
X_13998__2566 _13998_/RESET_B VDD VSS sg13g2_tiehi
XFILLER_95_214 VDD VSS sg13g2_decap_4
XFILLER_49_620 VDD VSS sg13g2_fill_2
XFILLER_0_170 VDD VSS sg13g2_fill_1
X_11068_ _11097_/C _11068_/A _11068_/B wire577/X VDD VSS sg13g2_nand3_1
XFILLER_114_1141 VDD VSS sg13g2_decap_4
XFILLER_23_1035 VDD VSS sg13g2_decap_8
XFILLER_3_1118 VDD VSS sg13g2_decap_8
XFILLER_97_1103 VDD VSS sg13g2_fill_2
XFILLER_114_1163 VDD VSS sg13g2_fill_1
X_10019_ _14601_/D _10085_/A0 _14601_/Q _10033_/S VDD VSS sg13g2_mux2_1
XFILLER_36_303 VDD VSS sg13g2_fill_1
XFILLER_114_1174 VDD VSS sg13g2_fill_1
X_14827_ _14827_/Q clkload79/A _14827_/D _14827_/RESET_B VDD VSS sg13g2_dfrbpq_1
X_14378__2186 _14378_/RESET_B VDD VSS sg13g2_tiehi
XFILLER_64_678 VDD VSS sg13g2_decap_8
XFILLER_92_998 VDD VSS sg13g2_decap_4
XFILLER_51_328 VDD VSS sg13g2_decap_4
X_14758_ _14758_/Q _15212_/CLK _14758_/D _14758_/RESET_B VDD VSS sg13g2_dfrbpq_1
XFILLER_32_542 VDD VSS sg13g2_decap_8
X_13709_ _13709_/Q clkload19/A _13709_/D _13709_/RESET_B VDD VSS sg13g2_dfrbpq_1
X_14689_ _14689_/Q clkload27/A _14689_/D _14689_/RESET_B VDD VSS sg13g2_dfrbpq_1
XFILLER_32_586 VDD VSS sg13g2_fill_1
XFILLER_60_895 VDD VSS sg13g2_decap_8
XFILLER_34_1153 VDD VSS sg13g2_decap_8
XFILLER_146_945 VDD VSS sg13g2_decap_8
XFILLER_146_967 VDD VSS sg13g2_fill_1
XFILLER_8_281 VDD VSS sg13g2_decap_8
XFILLER_67_0 VDD VSS sg13g2_decap_8
XFILLER_118_658 VDD VSS sg13g2_decap_8
Xmax_cap1771 fanout1770/A _07625_/Y VDD VSS sg13g2_buf_4
XFILLER_133_628 VDD VSS sg13g2_fill_1
XFILLER_132_105 VDD VSS sg13g2_decap_8
XFILLER_5_70 VDD VSS sg13g2_decap_8
XFILLER_99_553 VDD VSS sg13g2_decap_4
XFILLER_125_190 VDD VSS sg13g2_fill_1
XFILLER_113_352 VDD VSS sg13g2_decap_8
XFILLER_99_575 VDD VSS sg13g2_fill_1
Xfanout216 _10159_/A1 _09562_/A0 VDD VSS sg13g2_buf_1
Xfanout227 _09924_/A1 _10123_/A0 VDD VSS sg13g2_buf_1
X_09802_ _14391_/D _09934_/A1 _14391_/Q _09802_/S VDD VSS sg13g2_mux2_1
X_13828__2736 _13828_/RESET_B VDD VSS sg13g2_tiehi
X_07994_ _07994_/X _15100_/Q _15089_/Q VDD VSS sg13g2_or2_1
Xfanout249 _10154_/A1 _09691_/A0 VDD VSS sg13g2_buf_1
X_14588__1976 _14588_/RESET_B VDD VSS sg13g2_tiehi
XFILLER_140_182 VDD VSS sg13g2_decap_8
XFILLER_80_1151 VDD VSS sg13g2_fill_2
X_09733_ _14324_/D _09898_/A0 _14324_/Q wire449/X VDD VSS sg13g2_mux2_1
XFILLER_41_1124 VDD VSS sg13g2_decap_8
XFILLER_68_973 VDD VSS sg13g2_decap_4
XFILLER_28_815 VDD VSS sg13g2_decap_8
XFILLER_27_314 VDD VSS sg13g2_decap_8
XFILLER_28_848 VDD VSS sg13g2_decap_4
X_09664_ _14257_/D _09730_/A0 _14257_/Q _09673_/S VDD VSS sg13g2_mux2_1
XFILLER_83_943 VDD VSS sg13g2_fill_2
XFILLER_83_954 VDD VSS sg13g2_decap_4
X_08615_ _15244_/D _08615_/A _08615_/B _08615_/C VDD VSS sg13g2_nand3_1
X_09595_ _14192_/D _14192_/Q _09927_/A1 _09604_/S VDD VSS sg13g2_mux2_1
X_14208__2356 _14208_/RESET_B VDD VSS sg13g2_tiehi
XFILLER_42_306 VDD VSS sg13g2_decap_4
XFILLER_70_626 VDD VSS sg13g2_decap_8
XFILLER_82_486 VDD VSS sg13g2_decap_4
XFILLER_70_637 VDD VSS sg13g2_fill_2
XFILLER_42_339 VDD VSS sg13g2_fill_2
X_08546_ _08546_/Y _13566_/A _07812_/B _08529_/Y VDD VSS sg13g2_o21ai_1
XFILLER_51_840 VDD VSS sg13g2_fill_2
XFILLER_126_1012 VDD VSS sg13g2_fill_1
XFILLER_24_35 VDD VSS sg13g2_decap_8
X_08477_ _08477_/Y _08443_/Y _07807_/C _08476_/Y VDD VSS sg13g2_a21oi_1
XFILLER_145_7 VDD VSS sg13g2_decap_8
XFILLER_51_873 VDD VSS sg13g2_decap_8
XFILLER_23_586 VDD VSS sg13g2_fill_1
XFILLER_51_895 VDD VSS sg13g2_decap_8
XFILLER_52_1231 VDD VSS sg13g2_decap_4
X_14423__2141 _14423_/RESET_B VDD VSS sg13g2_tiehi
Xwire639 wire639/X wire639/A VDD VSS sg13g2_buf_4
XFILLER_6_218 VDD VSS sg13g2_decap_8
X_10370_ _14814_/D _10378_/D _10602_/A _10370_/C VDD VSS sg13g2_nor3_1
XFILLER_137_978 VDD VSS sg13g2_decap_4
XFILLER_136_477 VDD VSS sg13g2_decap_4
XFILLER_156_56 VDD VSS sg13g2_fill_2
XFILLER_151_403 VDD VSS sg13g2_decap_8
XFILLER_3_914 VDD VSS sg13g2_decap_8
X_09029_ _09031_/C _14905_/Q _12957_/A _12942_/A _09030_/D VDD VSS sg13g2_and4_1
XFILLER_152_948 VDD VSS sg13g2_decap_4
XFILLER_3_936 VDD VSS sg13g2_decap_8
XFILLER_156_89 VDD VSS sg13g2_fill_2
XFILLER_117_691 VDD VSS sg13g2_decap_4
Xpicorv32_macro_1800 mem_axi_araddr[1] VDD VSS sg13g2_tielo
XFILLER_46_1002 VDD VSS sg13g2_decap_8
X_12040_ _12040_/Y _12040_/A1 _14226_/Q _12023_/B VDD VSS sg13g2_a21oi_1
XFILLER_105_842 VDD VSS sg13g2_decap_8
XFILLER_2_446 VDD VSS sg13g2_decap_8
XFILLER_151_469 VDD VSS sg13g2_fill_1
XFILLER_85_1073 VDD VSS sg13g2_fill_1
XFILLER_78_715 VDD VSS sg13g2_fill_1
XFILLER_85_1095 VDD VSS sg13g2_decap_8
Xfanout1704 _11553_/A1 fanout1705/X VDD VSS sg13g2_buf_1
XFILLER_104_363 VDD VSS sg13g2_decap_8
XFILLER_78_737 VDD VSS sg13g2_decap_4
Xfanout1715 _12017_/A _12025_/A VDD VSS sg13g2_buf_1
XFILLER_120_823 VDD VSS sg13g2_fill_2
Xfanout1726 _11995_/S0 fanout1736/X VDD VSS sg13g2_buf_1
Xfanout1737 _12303_/S _11890_/S0 VDD VSS sg13g2_buf_1
Xfanout750 _12429_/A2 _12358_/Y VDD VSS sg13g2_buf_1
Xfanout1748 _11275_/S0 fanout1750/X VDD VSS sg13g2_buf_1
Xfanout1759 _13281_/B _13353_/A VDD VSS sg13g2_buf_1
Xclkbuf_leaf_60_clk_i _15188_/CLK clkbuf_leaf_60_clk_i/A VDD VSS sg13g2_buf_8
Xfanout772 _10072_/A0 _10139_/A1 VDD VSS sg13g2_buf_1
XFILLER_1_28 VDD VSS sg13g2_decap_8
X_13991_ _13991_/Q clkload5/A _13991_/D _13991_/RESET_B VDD VSS sg13g2_dfrbpq_1
Xfanout783 _09024_/A _08995_/B1 VDD VSS sg13g2_buf_1
XFILLER_58_461 VDD VSS sg13g2_fill_1
XFILLER_92_206 VDD VSS sg13g2_decap_8
Xfanout794 _13507_/B _13375_/B VDD VSS sg13g2_buf_1
XFILLER_105_71 VDD VSS sg13g2_fill_1
XFILLER_20_1219 VDD VSS sg13g2_decap_8
X_12942_ _12988_/B _12942_/A _12942_/B VDD VSS sg13g2_xnor2_1
XFILLER_105_82 VDD VSS sg13g2_decap_8
XFILLER_18_325 VDD VSS sg13g2_decap_8
XFILLER_65_53 VDD VSS sg13g2_decap_4
X_13682__2893 _13682_/RESET_B VDD VSS sg13g2_tiehi
XFILLER_46_667 VDD VSS sg13g2_decap_8
XFILLER_46_678 VDD VSS sg13g2_fill_2
XFILLER_61_604 VDD VSS sg13g2_decap_8
X_12873_ _12877_/C _14899_/Q _13688_/Q VDD VSS sg13g2_xor2_1
Xclkbuf_leaf_75_clk_i clkload80/A clkbuf_leaf_75_clk_i/A VDD VSS sg13g2_buf_8
X_14633__1931 _14633_/RESET_B VDD VSS sg13g2_tiehi
X_14612_ _14612_/Q clkload16/A _14612_/D _14612_/RESET_B VDD VSS sg13g2_dfrbpq_1
XFILLER_92_1011 VDD VSS sg13g2_fill_1
X_11824_ _11824_/Y _11826_/A1 _13868_/Q _11828_/S1 VDD VSS sg13g2_a21oi_1
XFILLER_61_648 VDD VSS sg13g2_decap_8
XFILLER_57_1142 VDD VSS sg13g2_decap_8
X_15175__3260 _15175_/RESET_B VDD VSS sg13g2_tiehi
XFILLER_14_553 VDD VSS sg13g2_decap_4
X_14543_ _14543_/Q clkload11/A _14543_/D _14543_/RESET_B VDD VSS sg13g2_dfrbpq_1
X_11755_ _11755_/Y _11752_/Y _11754_/X _12191_/B1 VDD VSS sg13g2_o21ai_1
XFILLER_144_1167 VDD VSS sg13g2_decap_4
X_10706_ _10706_/Y _12957_/A _10903_/B VDD VSS sg13g2_nand2_1
X_14474_ _14474_/Q _14506_/CLK _14474_/D _14474_/RESET_B VDD VSS sg13g2_dfrbpq_1
X_11686_ _11687_/A _14248_/Q _14280_/Q _14312_/Q _14344_/Q _11686_/S0 _11686_/S1 VDD
+ VSS sg13g2_mux4_1
XFILLER_128_912 VDD VSS sg13g2_decap_8
X_13425_ _13425_/Y _13425_/A _15130_/Q _13469_/C VDD VSS sg13g2_nand3_1
XFILLER_128_923 VDD VSS sg13g2_fill_2
X_10637_ _14886_/D _10642_/C _10637_/B VDD VSS sg13g2_nor2_1
X_13906__2658 _13906_/RESET_B VDD VSS sg13g2_tiehi
X_14666__1898 _14666_/RESET_B VDD VSS sg13g2_tiehi
XFILLER_10_770 VDD VSS sg13g2_decap_8
X_15001__2971 _15001_/RESET_B VDD VSS sg13g2_tiehi
XFILLER_60_7 VDD VSS sg13g2_decap_8
Xmax_cap1067 _12748_/S _12455_/S VDD VSS sg13g2_buf_4
X_13356_ _13361_/C _13506_/A _13356_/B _13507_/B VDD VSS sg13g2_nand3_1
X_10568_ _10591_/C _10579_/B _10579_/C VDD VSS sg13g2_and2_1
XFILLER_154_252 VDD VSS sg13g2_decap_8
Xclkbuf_leaf_13_clk_i clkload16/A clkbuf_5_6__f_clk_i/X VDD VSS sg13g2_buf_8
XFILLER_155_797 VDD VSS sg13g2_decap_4
X_12307_ _12308_/B _12307_/A _12307_/B _12307_/C VDD VSS sg13g2_nand3_1
X_10499_ _14853_/D _10499_/A _10499_/B _10626_/B VDD VSS sg13g2_and3_1
XFILLER_29_1200 VDD VSS sg13g2_decap_8
X_13287_ _13291_/B _13287_/A _13287_/B _13287_/C VDD VSS sg13g2_or3_1
X_15026_ _15026_/Q clkload41/A _15026_/D _15026_/RESET_B VDD VSS sg13g2_dfrbpq_1
XFILLER_114_149 VDD VSS sg13g2_fill_1
X_12238_ _12239_/A _13976_/Q _14008_/Q _14040_/Q _14072_/Q _12186_/A _12187_/C VDD
+ VSS sg13g2_mux4_1
XFILLER_64_1124 VDD VSS sg13g2_decap_8
XFILLER_116_1214 VDD VSS sg13g2_decap_8
X_12169_ _12170_/B _12169_/A _12169_/B _12169_/C VDD VSS sg13g2_nand3_1
XFILLER_2_980 VDD VSS sg13g2_decap_8
XFILLER_68_214 VDD VSS sg13g2_decap_8
XFILLER_96_523 VDD VSS sg13g2_fill_2
Xclkbuf_leaf_28_clk_i _14745_/CLK clkbuf_leaf_30_clk_i/A VDD VSS sg13g2_buf_8
XFILLER_68_247 VDD VSS sg13g2_fill_1
X_14878__3173 _14878_/RESET_B VDD VSS sg13g2_tiehi
XFILLER_96_578 VDD VSS sg13g2_decap_8
Xinput5 input5/X input5/A VDD VSS sg13g2_buf_1
XFILLER_64_420 VDD VSS sg13g2_decap_4
XFILLER_149_1001 VDD VSS sg13g2_fill_2
X_14501__2063 _14501_/RESET_B VDD VSS sg13g2_tiehi
XFILLER_37_667 VDD VSS sg13g2_decap_8
XFILLER_65_998 VDD VSS sg13g2_decap_8
X_08400_ _08544_/B _08400_/A _08034_/A VDD VSS sg13g2_nor2b_1
XFILLER_80_935 VDD VSS sg13g2_fill_1
X_09380_ _13983_/D _09646_/A0 _13983_/Q _09380_/S VDD VSS sg13g2_mux2_1
XFILLER_36_199 VDD VSS sg13g2_decap_8
XFILLER_101_18 VDD VSS sg13g2_fill_2
XFILLER_17_380 VDD VSS sg13g2_decap_8
XFILLER_52_659 VDD VSS sg13g2_decap_8
X_08331_ _08331_/Y _08147_/Y _08332_/A1 _08027_/Y VDD VSS sg13g2_a21oi_1
XFILLER_36_1215 VDD VSS sg13g2_decap_8
X_08262_ _08262_/Y _08256_/Y _08257_/Y _08252_/Y _08359_/B2 _08261_/Y VDD VSS sg13g2_a221oi_1
X_08193_ _08193_/Y _07890_/B _08191_/Y _08192_/Y VDD VSS sg13g2_a21oi_1
XFILLER_9_590 VDD VSS sg13g2_decap_8
XFILLER_119_967 VDD VSS sg13g2_decap_8
XFILLER_69_1046 VDD VSS sg13g2_decap_8
XFILLER_146_797 VDD VSS sg13g2_decap_8
XFILLER_156_1005 VDD VSS sg13g2_fill_1
XFILLER_145_274 VDD VSS sg13g2_fill_1
XFILLER_134_948 VDD VSS sg13g2_decap_8
XFILLER_133_436 VDD VSS sg13g2_fill_2
XFILLER_126_37 VDD VSS sg13g2_decap_4
XFILLER_114_672 VDD VSS sg13g2_decap_8
X_14711__1853 _14711_/RESET_B VDD VSS sg13g2_tiehi
XFILLER_99_372 VDD VSS sg13g2_decap_8
XFILLER_142_992 VDD VSS sg13g2_fill_2
XFILLER_87_523 VDD VSS sg13g2_decap_4
XFILLER_19_35 VDD VSS sg13g2_decap_8
XFILLER_142_14 VDD VSS sg13g2_decap_8
X_07977_ _07977_/Y _08577_/B _07866_/Y _07976_/X VDD VSS sg13g2_a21oi_1
XFILLER_28_601 VDD VSS sg13g2_decap_4
X_09716_ _14307_/D _09914_/A1 _14307_/Q wire449/X VDD VSS sg13g2_mux2_1
XFILLER_27_133 VDD VSS sg13g2_decap_8
XFILLER_56_965 VDD VSS sg13g2_fill_1
X_09647_ _14240_/D _09680_/A0 _14240_/Q wire641/X VDD VSS sg13g2_mux2_1
XFILLER_15_306 VDD VSS sg13g2_fill_1
XFILLER_70_401 VDD VSS sg13g2_fill_1
XFILLER_76_1028 VDD VSS sg13g2_decap_4
XFILLER_43_637 VDD VSS sg13g2_fill_1
X_09578_ _14175_/D _14175_/Q _09646_/A0 _09578_/S VDD VSS sg13g2_mux2_1
XFILLER_42_147 VDD VSS sg13g2_decap_8
XFILLER_70_456 VDD VSS sg13g2_fill_1
XFILLER_42_158 VDD VSS sg13g2_fill_2
X_08529_ _08529_/Y _08566_/C _08495_/Y _08567_/C VDD VSS sg13g2_o21ai_1
XFILLER_11_501 VDD VSS sg13g2_decap_8
X_11540_ _11540_/Y _11536_/Y _11537_/Y _11539_/Y _11538_/Y _12246_/B VDD VSS sg13g2_a221oi_1
XFILLER_129_709 VDD VSS sg13g2_decap_8
XFILLER_51_22 VDD VSS sg13g2_decap_4
XFILLER_156_506 VDD VSS sg13g2_fill_1
X_11471_ _11471_/X _13729_/Q _14081_/Q _14433_/Q _14529_/Q _11741_/A _11760_/C VDD
+ VSS sg13g2_mux4_1
XFILLER_7_527 VDD VSS sg13g2_fill_1
Xwire447 wire447/X wire447/A VDD VSS sg13g2_buf_2
XFILLER_13_1034 VDD VSS sg13g2_decap_8
Xwire458 wire458/X wire458/A VDD VSS sg13g2_buf_4
X_13210_ _13211_/B _13265_/A1 _13205_/X _13204_/Y _13247_/D wire560/X VDD VSS sg13g2_a221oi_1
X_10422_ _10423_/B _14828_/Q _14829_/Q _14830_/Q _10422_/D VDD VSS sg13g2_nand4_1
X_14190_ _14190_/Q _14763_/CLK _14190_/D _14190_/RESET_B VDD VSS sg13g2_dfrbpq_1
XFILLER_137_786 VDD VSS sg13g2_decap_8
XFILLER_87_1146 VDD VSS sg13g2_decap_8
XFILLER_125_937 VDD VSS sg13g2_fill_2
X_10353_ _14810_/D _10353_/A _10353_/B _10496_/B VDD VSS sg13g2_and3_1
X_13141_ _15042_/D _13155_/A _13141_/B VDD VSS sg13g2_nor2_1
XFILLER_139_1236 VDD VSS sg13g2_fill_1
XFILLER_48_1119 VDD VSS sg13g2_fill_1
X_13072_ _13072_/X input11/X _12914_/A _13252_/B1 VDD VSS sg13g2_a21o_1
XFILLER_152_778 VDD VSS sg13g2_decap_8
X_10284_ _10284_/Y _14788_/Q _14789_/Q _10305_/A _10305_/B VDD VSS sg13g2_nand4_1
XFILLER_3_766 VDD VSS sg13g2_decap_4
XFILLER_2_254 VDD VSS sg13g2_decap_8
X_12023_ _12027_/A _12022_/X _12023_/B VDD VSS sg13g2_nand2b_1
Xfanout1501 _13602_/A _14958_/Q VDD VSS sg13g2_buf_1
XFILLER_105_694 VDD VSS sg13g2_decap_8
Xfanout1512 _13088_/A _14912_/Q VDD VSS sg13g2_buf_1
Xfanout1523 _12895_/A _14869_/Q VDD VSS sg13g2_buf_1
Xfanout1534 _11171_/B _11202_/A VDD VSS sg13g2_buf_1
XFILLER_24_1141 VDD VSS sg13g2_decap_8
XFILLER_4_1202 VDD VSS sg13g2_decap_8
Xfanout580 _10967_/B _11015_/C VDD VSS sg13g2_buf_1
Xfanout1589 _12265_/B1 _13661_/Q VDD VSS sg13g2_buf_1
Xfanout591 _10127_/S _10124_/S VDD VSS sg13g2_buf_1
XFILLER_47_932 VDD VSS sg13g2_decap_8
XFILLER_150_1171 VDD VSS sg13g2_decap_8
X_13974_ _13974_/Q _14710_/CLK _13974_/D _13974_/RESET_B VDD VSS sg13g2_dfrbpq_1
XFILLER_18_111 VDD VSS sg13g2_fill_2
XFILLER_20_1016 VDD VSS sg13g2_decap_8
X_12925_ _12989_/B _12925_/A _12925_/B _12925_/C VDD VSS sg13g2_nand3_1
XFILLER_74_773 VDD VSS sg13g2_decap_8
XFILLER_18_166 VDD VSS sg13g2_decap_8
XFILLER_46_486 VDD VSS sg13g2_fill_2
XFILLER_132_91 VDD VSS sg13g2_decap_8
X_15019__2953 _15019_/RESET_B VDD VSS sg13g2_tiehi
XFILLER_146_1207 VDD VSS sg13g2_decap_8
X_12856_ _15024_/D _12855_/Y _12850_/X _13281_/B VDD VSS sg13g2_a21oi_1
X_11807_ _11808_/A _13964_/Q _13996_/Q _14028_/Q _14060_/Q _11951_/A _11970_/C VDD
+ VSS sg13g2_mux4_1
X_12787_ _12787_/X _14714_/Q _14746_/Q _13786_/Q _13818_/Q _12787_/S0 _12787_/S1 VDD
+ VSS sg13g2_mux4_1
X_14526_ _14526_/Q clkload59/A _14526_/D _14526_/RESET_B VDD VSS sg13g2_dfrbpq_1
X_11738_ _11738_/X _14570_/Q _14602_/Q _11741_/A VDD VSS sg13g2_mux2_1
XFILLER_30_876 VDD VSS sg13g2_fill_1
X_14457_ _14457_/Q clkload43/A _14457_/D _14457_/RESET_B VDD VSS sg13g2_dfrbpq_1
XFILLER_128_720 VDD VSS sg13g2_decap_8
X_11669_ _11669_/Y _11665_/Y _11666_/Y _11668_/Y _11667_/Y _11696_/B VDD VSS sg13g2_a221oi_1
XFILLER_128_731 VDD VSS sg13g2_fill_2
X_13408_ _15091_/D _13444_/A _13396_/D _13407_/Y VDD VSS sg13g2_o21ai_1
XFILLER_127_230 VDD VSS sg13g2_decap_8
XFILLER_128_753 VDD VSS sg13g2_decap_8
XFILLER_31_1167 VDD VSS sg13g2_decap_8
X_14388_ _14388_/Q clkload8/A _14388_/D _14388_/RESET_B VDD VSS sg13g2_dfrbpq_1
Xmax_cap714 _08452_/A _08110_/A VDD VSS sg13g2_buf_2
X_13339_ _13341_/A _13654_/S _13502_/B _15175_/D _13351_/B VDD VSS sg13g2_or4_1
X_14519__2045 _14519_/RESET_B VDD VSS sg13g2_tiehi
XFILLER_115_436 VDD VSS sg13g2_decap_8
Xmax_cap758 _10579_/C _10571_/C VDD VSS sg13g2_buf_1
XFILLER_143_789 VDD VSS sg13g2_decap_8
XFILLER_124_970 VDD VSS sg13g2_fill_2
XFILLER_9_1113 VDD VSS sg13g2_decap_8
X_07900_ _07900_/Y _07903_/B _08023_/A VDD VSS sg13g2_nand2b_1
X_15009_ _15009_/Q clkload41/A _15009_/D _15009_/RESET_B VDD VSS sg13g2_dfrbpq_1
X_08880_ _13703_/D _13703_/Q _08879_/X _08892_/S VDD VSS sg13g2_mux2_1
XFILLER_69_545 VDD VSS sg13g2_decap_8
XFILLER_123_491 VDD VSS sg13g2_decap_8
XFILLER_57_707 VDD VSS sg13g2_fill_2
XFILLER_116_1044 VDD VSS sg13g2_decap_8
X_07831_ _07979_/C _08048_/B _08692_/C VDD VSS sg13g2_nand2b_1
XFILLER_57_718 VDD VSS sg13g2_decap_8
XFILLER_99_1017 VDD VSS sg13g2_decap_8
XFILLER_56_217 VDD VSS sg13g2_decap_8
XFILLER_116_1088 VDD VSS sg13g2_fill_1
XFILLER_111_697 VDD VSS sg13g2_fill_2
XFILLER_38_932 VDD VSS sg13g2_decap_8
XFILLER_84_548 VDD VSS sg13g2_decap_8
X_07762_ _07762_/Y _10177_/A _15204_/Q _07754_/Y VDD VSS sg13g2_a21oi_1
XFILLER_49_280 VDD VSS sg13g2_fill_2
X_09501_ _14101_/D _10064_/A0 _14101_/Q _09505_/S VDD VSS sg13g2_mux2_1
X_07693_ _07696_/B _15084_/Q _07701_/B VDD VSS sg13g2_nand2_1
XFILLER_112_28 VDD VSS sg13g2_decap_8
XFILLER_64_261 VDD VSS sg13g2_decap_8
XFILLER_37_486 VDD VSS sg13g2_decap_8
XFILLER_25_637 VDD VSS sg13g2_fill_1
X_09432_ _14034_/D _09962_/A1 _14034_/Q _09439_/S VDD VSS sg13g2_mux2_1
XFILLER_53_968 VDD VSS sg13g2_fill_2
XFILLER_40_618 VDD VSS sg13g2_decap_8
X_09363_ _13967_/D _09992_/A0 _13967_/Q _09373_/S VDD VSS sg13g2_mux2_1
X_13778__2786 _13778_/RESET_B VDD VSS sg13g2_tiehi
XFILLER_36_1034 VDD VSS sg13g2_decap_4
X_08314_ _08350_/B _08315_/B _07776_/Y _08287_/Y _07779_/Y _07773_/Y VDD VSS sg13g2_a221oi_1
X_09294_ _13902_/D _13902_/Q _09991_/A0 _09294_/S VDD VSS sg13g2_mux2_1
XANTENNA_10 _16884_/A VDD VSS sg13g2_antennanp
X_14729__1835 _14729_/RESET_B VDD VSS sg13g2_tiehi
X_08245_ _08245_/Y _08363_/S0 _08021_/A _08027_/Y VDD VSS sg13g2_a21oi_1
XFILLER_123_1059 VDD VSS sg13g2_decap_8
XFILLER_21_14 VDD VSS sg13g2_decap_8
X_08176_ _08187_/C _08188_/B _08541_/A _08175_/Y _07876_/A _08174_/Y VDD VSS sg13g2_a221oi_1
XFILLER_137_14 VDD VSS sg13g2_decap_8
X_13993__2571 _13993_/RESET_B VDD VSS sg13g2_tiehi
XFILLER_146_583 VDD VSS sg13g2_fill_1
XFILLER_108_7 VDD VSS sg13g2_decap_8
XFILLER_0_703 VDD VSS sg13g2_decap_8
XFILLER_82_1010 VDD VSS sg13g2_fill_1
XFILLER_115_970 VDD VSS sg13g2_decap_8
XFILLER_0_714 VDD VSS sg13g2_fill_1
XFILLER_115_981 VDD VSS sg13g2_fill_2
XFILLER_134_1100 VDD VSS sg13g2_decap_8
XFILLER_88_832 VDD VSS sg13g2_decap_8
XFILLER_134_1111 VDD VSS sg13g2_fill_2
XFILLER_114_491 VDD VSS sg13g2_decap_8
XFILLER_153_35 VDD VSS sg13g2_decap_8
X_14373__2191 _14373_/RESET_B VDD VSS sg13g2_tiehi
XFILLER_0_758 VDD VSS sg13g2_decap_4
XFILLER_82_1076 VDD VSS sg13g2_fill_1
XFILLER_102_686 VDD VSS sg13g2_decap_4
XFILLER_87_397 VDD VSS sg13g2_decap_8
XFILLER_29_954 VDD VSS sg13g2_fill_1
XFILLER_29_987 VDD VSS sg13g2_decap_8
X_10971_ _10971_/Y _10969_/B _10967_/B _11183_/B1 VDD VSS sg13g2_o21ai_1
XFILLER_55_261 VDD VSS sg13g2_decap_8
XFILLER_71_732 VDD VSS sg13g2_decap_8
X_12710_ _12710_/X _14709_/Q _14741_/Q _13781_/Q _13813_/Q _12715_/S0 _12770_/S1 VDD
+ VSS sg13g2_mux4_1
XFILLER_46_99 VDD VSS sg13g2_fill_1
X_13690_ _13690_/Q _15250_/CLK _13690_/D _13690_/RESET_B VDD VSS sg13g2_dfrbpq_1
XFILLER_31_607 VDD VSS sg13g2_decap_4
XFILLER_62_21 VDD VSS sg13g2_fill_2
X_12641_ _12641_/X _14704_/Q _14736_/Q _13776_/Q _13808_/Q _12646_/S0 _12647_/S1 VDD
+ VSS sg13g2_mux4_1
XFILLER_71_798 VDD VSS sg13g2_decap_8
X_12572_ _12572_/X _13739_/Q _14091_/Q _14443_/Q _14539_/Q _12771_/S0 _12771_/S1 VDD
+ VSS sg13g2_mux4_1
XFILLER_156_303 VDD VSS sg13g2_decap_8
XFILLER_134_0 VDD VSS sg13g2_decap_8
XFILLER_15_1129 VDD VSS sg13g2_decap_8
XFILLER_12_876 VDD VSS sg13g2_decap_8
X_14311_ _14311_/Q _14725_/CLK _14311_/D _14311_/RESET_B VDD VSS sg13g2_dfrbpq_1
XFILLER_156_314 VDD VSS sg13g2_fill_1
X_11523_ _11566_/A _11526_/A _12227_/B VDD VSS sg13g2_nor2_1
Xwire211 wire211/X wire211/A VDD VSS sg13g2_buf_1
XFILLER_141_1148 VDD VSS sg13g2_fill_2
XFILLER_7_324 VDD VSS sg13g2_decap_8
Xwire233 wire233/X wire233/A VDD VSS sg13g2_buf_2
XFILLER_156_358 VDD VSS sg13g2_decap_4
XFILLER_7_49 VDD VSS sg13g2_decap_8
X_14242_ _14242_/Q clkload22/A _14242_/D _14242_/RESET_B VDD VSS sg13g2_dfrbpq_1
XFILLER_11_397 VDD VSS sg13g2_fill_1
Xwire255 wire255/X wire255/A VDD VSS sg13g2_buf_2
X_11454_ _11457_/B _11454_/A _13688_/Q VDD VSS sg13g2_nand2_1
X_13823__2741 _13823_/RESET_B VDD VSS sg13g2_tiehi
X_14583__1981 _14583_/RESET_B VDD VSS sg13g2_tiehi
Xwire299 wire299/X wire299/A VDD VSS sg13g2_buf_2
X_10405_ _10406_/A _14823_/Q _14824_/Q _10405_/C _10414_/C VDD VSS sg13g2_and4_1
X_14173_ _14173_/Q _14525_/CLK _14173_/D _14173_/RESET_B VDD VSS sg13g2_dfrbpq_1
X_11385_ _11385_/Y _11385_/A _11385_/B VDD VSS sg13g2_xnor2_1
XFILLER_3_530 VDD VSS sg13g2_fill_2
X_13124_ wire563/A _13121_/Y _13122_/Y _13123_/Y VDD VSS sg13g2_a21oi_1
XFILLER_11_91 VDD VSS sg13g2_decap_8
X_10336_ _10337_/B _14803_/Q _14804_/Q _14805_/Q _10336_/D VDD VSS sg13g2_nand4_1
XFILLER_3_574 VDD VSS sg13g2_fill_2
XFILLER_112_428 VDD VSS sg13g2_fill_2
XFILLER_127_91 VDD VSS sg13g2_decap_4
X_10267_ _10269_/A _14783_/Q _10262_/Y _14784_/Q VDD VSS sg13g2_a21o_1
X_13055_ wire209/A _13222_/A1 _13050_/X _13054_/Y VDD VSS sg13g2_a21oi_1
X_14203__2361 _14203_/RESET_B VDD VSS sg13g2_tiehi
Xfanout1320 _09155_/A1 _15059_/Q VDD VSS sg13g2_buf_1
X_12006_ _14979_/D _12006_/A _12006_/B VDD VSS sg13g2_nand2_1
XFILLER_23_7 VDD VSS sg13g2_decap_8
XFILLER_79_887 VDD VSS sg13g2_decap_4
Xfanout1331 _13613_/A _15056_/Q VDD VSS sg13g2_buf_1
Xfanout1342 _08306_/B _15000_/Q VDD VSS sg13g2_buf_1
X_10198_ _14756_/D _15199_/D _14756_/Q _13653_/S VDD VSS sg13g2_mux2_1
XFILLER_66_515 VDD VSS sg13g2_decap_8
XFILLER_94_824 VDD VSS sg13g2_decap_4
Xfanout1353 _13534_/A1 _14993_/Q VDD VSS sg13g2_buf_1
Xfanout1364 _08142_/B _08484_/B VDD VSS sg13g2_buf_1
XFILLER_78_397 VDD VSS sg13g2_decap_4
XFILLER_66_548 VDD VSS sg13g2_decap_8
XFILLER_4_1021 VDD VSS sg13g2_decap_8
Xfanout1386 wire1387/A _08457_/S0 VDD VSS sg13g2_buf_1
XFILLER_66_559 VDD VSS sg13g2_fill_2
Xfanout1397 _07626_/A wire1401/A VDD VSS sg13g2_buf_1
XFILLER_59_1001 VDD VSS sg13g2_decap_8
X_13957_ _13957_/Q clkload0/A _13957_/D _13957_/RESET_B VDD VSS sg13g2_dfrbpq_1
XFILLER_4_1076 VDD VSS sg13g2_decap_8
XFILLER_59_1012 VDD VSS sg13g2_fill_1
XFILLER_74_570 VDD VSS sg13g2_decap_8
XFILLER_59_1034 VDD VSS sg13g2_fill_2
X_12908_ _12910_/A _12925_/A _12925_/B _12909_/C VDD VSS sg13g2_a21oi_1
XFILLER_146_1004 VDD VSS sg13g2_fill_1
XFILLER_59_1056 VDD VSS sg13g2_fill_2
XFILLER_35_968 VDD VSS sg13g2_fill_2
X_13888_ _13888_/Q _14917_/CLK _13888_/D _13888_/RESET_B VDD VSS sg13g2_dfrbpq_1
XFILLER_35_979 VDD VSS sg13g2_decap_8
XFILLER_62_765 VDD VSS sg13g2_decap_8
X_15088__3198 _15088_/RESET_B VDD VSS sg13g2_tiehi
XFILLER_146_1048 VDD VSS sg13g2_decap_8
XFILLER_62_787 VDD VSS sg13g2_decap_4
X_12839_ _12840_/B _12836_/Y _12838_/Y _12828_/Y _11236_/A _12832_/Y VDD VSS sg13g2_a221oi_1
XFILLER_34_489 VDD VSS sg13g2_fill_2
XFILLER_72_1234 VDD VSS sg13g2_fill_2
XFILLER_33_1218 VDD VSS sg13g2_decap_8
X_14509_ _14509_/Q _14509_/CLK _14509_/D _14509_/RESET_B VDD VSS sg13g2_dfrbpq_1
XFILLER_30_684 VDD VSS sg13g2_decap_4
X_08030_ _08030_/Y _08617_/A _08621_/B VDD VSS sg13g2_nand2_1
Xinput30 input30/X input30/A VDD VSS sg13g2_buf_1
Xmax_cap500 _09297_/S _09294_/S VDD VSS sg13g2_buf_4
XFILLER_116_723 VDD VSS sg13g2_fill_1
XFILLER_116_734 VDD VSS sg13g2_fill_2
X_09981_ _14564_/D _10080_/A0 _14564_/Q _09987_/S VDD VSS sg13g2_mux2_1
XFILLER_107_28 VDD VSS sg13g2_decap_8
XFILLER_118_1106 VDD VSS sg13g2_fill_2
Xmax_cap588 _10134_/S _10132_/S VDD VSS sg13g2_buf_4
Xmax_cap599 _10035_/S _10009_/S VDD VSS sg13g2_buf_4
X_08932_ _13716_/D _16878_/A _08931_/X _08935_/S VDD VSS sg13g2_mux2_1
XFILLER_97_640 VDD VSS sg13g2_fill_2
XFILLER_112_940 VDD VSS sg13g2_decap_8
X_08863_ _08863_/X _08862_/X _11502_/A _08882_/S VDD VSS sg13g2_mux2_1
XFILLER_84_312 VDD VSS sg13g2_decap_8
X_07814_ _08567_/B _08522_/A _08548_/B VDD VSS sg13g2_nand2_1
XFILLER_96_194 VDD VSS sg13g2_fill_1
X_08794_ _08796_/A _10924_/B1 _14756_/Q _08727_/X _15199_/Q _08809_/C1 VDD VSS sg13g2_a221oi_1
XFILLER_42_1082 VDD VSS sg13g2_decap_8
X_07745_ _15208_/D _07741_/Y _07746_/C _07740_/Y VDD VSS sg13g2_o21ai_1
XFILLER_37_250 VDD VSS sg13g2_decap_4
XFILLER_16_14 VDD VSS sg13g2_decap_8
XFILLER_65_581 VDD VSS sg13g2_decap_8
XFILLER_77_1134 VDD VSS sg13g2_fill_2
XFILLER_37_294 VDD VSS sg13g2_decap_8
X_07676_ _07721_/A _15079_/Q _15082_/Q _15080_/Q VDD VSS sg13g2_nor3_1
X_13901__2663 _13901_/RESET_B VDD VSS sg13g2_tiehi
XFILLER_129_1235 VDD VSS sg13g2_fill_2
X_09415_ _14017_/D _09613_/A0 _14017_/Q _09424_/S VDD VSS sg13g2_mux2_1
XFILLER_53_776 VDD VSS sg13g2_decap_8
XFILLER_80_562 VDD VSS sg13g2_decap_8
XFILLER_41_938 VDD VSS sg13g2_fill_2
XFILLER_52_275 VDD VSS sg13g2_fill_2
XFILLER_34_990 VDD VSS sg13g2_fill_2
X_09346_ _13950_/D _09744_/A1 _13950_/Q wire689/X VDD VSS sg13g2_mux2_1
XFILLER_12_139 VDD VSS sg13g2_decap_8
XFILLER_32_35 VDD VSS sg13g2_fill_1
X_14245__2319 _14245_/RESET_B VDD VSS sg13g2_tiehi
X_09277_ _13885_/D _13885_/Q _10140_/A1 _09279_/S VDD VSS sg13g2_mux2_1
XFILLER_138_336 VDD VSS sg13g2_decap_8
XFILLER_148_35 VDD VSS sg13g2_decap_8
XFILLER_32_68 VDD VSS sg13g2_decap_4
XFILLER_20_172 VDD VSS sg13g2_fill_1
XFILLER_5_806 VDD VSS sg13g2_decap_8
X_08228_ _08229_/A _07909_/Y _07921_/Y _07889_/A VDD VSS sg13g2_o21ai_1
XFILLER_14_1162 VDD VSS sg13g2_decap_8
XFILLER_107_701 VDD VSS sg13g2_fill_2
XFILLER_134_520 VDD VSS sg13g2_decap_8
X_08159_ _08166_/B _08158_/X _08026_/Y _08381_/A _08150_/X VDD VSS sg13g2_a22oi_1
XFILLER_106_211 VDD VSS sg13g2_decap_8
XFILLER_10_1059 VDD VSS sg13g2_decap_8
XFILLER_49_1236 VDD VSS sg13g2_fill_1
X_11170_ _11170_/Y _11170_/A _11170_/B VDD VSS sg13g2_nand2_1
X_14460__2104 _14460_/RESET_B VDD VSS sg13g2_tiehi
XFILLER_101_1198 VDD VSS sg13g2_decap_8
X_10121_ _14699_/D _10154_/A1 _14699_/Q _10127_/S VDD VSS sg13g2_mux2_1
XFILLER_0_511 VDD VSS sg13g2_decap_8
XFILLER_0_522 VDD VSS sg13g2_fill_1
XFILLER_106_299 VDD VSS sg13g2_decap_4
Xhold3450 input30/A mem_axi_rdata[4] VDD VSS sg13g2_dlygate4sd3_1
Xhold3461 input20/A mem_axi_rdata[24] VDD VSS sg13g2_dlygate4sd3_1
X_10052_ _14633_/D _10085_/A0 _14633_/Q _10066_/S VDD VSS sg13g2_mux2_1
Xhold3472 _13634_/A _13742_/Q VDD VSS sg13g2_dlygate4sd3_1
XFILLER_0_566 VDD VSS sg13g2_decap_4
XFILLER_57_21 VDD VSS sg13g2_decap_8
XFILLER_121_269 VDD VSS sg13g2_decap_8
Xhold3483 _13616_/A _13724_/Q VDD VSS sg13g2_dlygate4sd3_1
XFILLER_75_301 VDD VSS sg13g2_fill_1
XFILLER_57_43 VDD VSS sg13g2_decap_4
Xhold3494 _13636_/A _13744_/Q VDD VSS sg13g2_dlygate4sd3_1
XFILLER_102_494 VDD VSS sg13g2_fill_1
X_14860_ _14860_/Q clkload70/A _14860_/D _14860_/RESET_B VDD VSS sg13g2_dfrbpq_1
XFILLER_29_751 VDD VSS sg13g2_decap_8
X_13811_ _13811_/Q clkload13/A _13811_/D _13811_/RESET_B VDD VSS sg13g2_dfrbpq_1
XFILLER_91_816 VDD VSS sg13g2_fill_2
XFILLER_35_209 VDD VSS sg13g2_fill_1
XFILLER_1_1205 VDD VSS sg13g2_decap_8
X_14791_ _14791_/Q clkload82/A _14791_/D _14791_/RESET_B VDD VSS sg13g2_dfrbpq_1
XFILLER_21_1166 VDD VSS sg13g2_decap_8
XFILLER_91_849 VDD VSS sg13g2_fill_1
X_13742_ _13742_/Q _14763_/CLK _13742_/D _13742_/RESET_B VDD VSS sg13g2_dfrbpq_1
XFILLER_17_968 VDD VSS sg13g2_fill_1
XFILLER_44_743 VDD VSS sg13g2_decap_8
X_10954_ _10967_/A wire582/X _10954_/B _10954_/C _10954_/D VDD VSS sg13g2_nor4_1
XFILLER_113_93 VDD VSS sg13g2_fill_1
XFILLER_56_1229 VDD VSS sg13g2_decap_8
XFILLER_31_404 VDD VSS sg13g2_decap_8
X_13673_ _13673_/Q clkload64/A _13673_/D _13673_/RESET_B VDD VSS sg13g2_dfrbpq_1
XFILLER_44_798 VDD VSS sg13g2_decap_4
X_10885_ _10885_/Y _10885_/A1 _10883_/X _10884_/Y VDD VSS sg13g2_a21oi_1
XFILLER_25_990 VDD VSS sg13g2_decap_8
XFILLER_31_448 VDD VSS sg13g2_decap_8
XFILLER_19_1051 VDD VSS sg13g2_decap_8
X_12624_ wire375/A _13674_/Q _12679_/A2 _12623_/X _12679_/B2 _12791_/C1 VDD VSS sg13g2_a221oi_1
XFILLER_12_640 VDD VSS sg13g2_decap_8
XFILLER_145_1070 VDD VSS sg13g2_fill_2
XFILLER_129_314 VDD VSS sg13g2_fill_1
XFILLER_156_111 VDD VSS sg13g2_decap_8
X_12555_ _15003_/D _12555_/A _12555_/B VDD VSS sg13g2_nor2_1
XFILLER_156_122 VDD VSS sg13g2_fill_1
X_11506_ _11506_/Y _11636_/A _11506_/B VDD VSS sg13g2_xnor2_1
XFILLER_11_194 VDD VSS sg13g2_fill_1
XFILLER_156_166 VDD VSS sg13g2_decap_4
X_12486_ _12499_/A _10213_/A _07737_/B _08276_/B VDD VSS sg13g2_a21oi_1
XFILLER_8_688 VDD VSS sg13g2_fill_1
X_15099__3160 _15099_/RESET_B VDD VSS sg13g2_tiehi
X_14225_ _14225_/Q clkload44/A _14225_/D _14225_/RESET_B VDD VSS sg13g2_dfrbpq_1
X_11437_ _11445_/C _11436_/X _11439_/A VDD VSS sg13g2_nand2b_1
XFILLER_7_198 VDD VSS sg13g2_decap_8
X_14156_ _14156_/Q _14714_/CLK _14156_/D _14156_/RESET_B VDD VSS sg13g2_dfrbpq_1
X_11368_ _11368_/X _14238_/Q _14270_/Q _14302_/Q _14334_/Q _11365_/A _12307_/C VDD
+ VSS sg13g2_mux4_1
XFILLER_153_895 VDD VSS sg13g2_decap_8
XFILLER_152_372 VDD VSS sg13g2_fill_2
XFILLER_112_203 VDD VSS sg13g2_decap_8
X_13107_ _13107_/Y _14818_/Q _13068_/B _13028_/B _14882_/Q _13193_/B VDD VSS sg13g2_a221oi_1
X_10319_ _14799_/D _10347_/B _10319_/B _10319_/C VDD VSS sg13g2_nor3_1
X_14087_ _14087_/Q clkload10/A _14087_/D _14087_/RESET_B VDD VSS sg13g2_dfrbpq_1
X_11299_ _11299_/Y _11295_/Y _11296_/Y _11298_/Y _11297_/Y _11395_/B VDD VSS sg13g2_a221oi_1
XFILLER_3_393 VDD VSS sg13g2_decap_8
X_13038_ _13057_/B _14909_/Q _13678_/Q VDD VSS sg13g2_or2_1
X_15219__3372 _15219_/RESET_B VDD VSS sg13g2_tiehi
XFILLER_26_1044 VDD VSS sg13g2_decap_8
XFILLER_67_824 VDD VSS sg13g2_fill_2
XFILLER_121_770 VDD VSS sg13g2_fill_1
Xfanout1150 _12452_/S0 _12729_/S0 VDD VSS sg13g2_buf_1
XFILLER_113_1014 VDD VSS sg13g2_fill_1
XFILLER_6_1138 VDD VSS sg13g2_decap_8
Xfanout1161 _12740_/S0 fanout1181/X VDD VSS sg13g2_buf_1
Xfanout1172 _12754_/S0 _12758_/S0 VDD VSS sg13g2_buf_1
XFILLER_66_334 VDD VSS sg13g2_fill_2
XFILLER_93_131 VDD VSS sg13g2_decap_8
Xfanout1194 fanout1194/X fanout1205/X VDD VSS sg13g2_buf_1
XFILLER_113_1058 VDD VSS sg13g2_fill_1
XFILLER_82_827 VDD VSS sg13g2_decap_8
X_14469__2095 _14469_/RESET_B VDD VSS sg13g2_tiehi
XFILLER_94_687 VDD VSS sg13g2_decap_8
XFILLER_47_570 VDD VSS sg13g2_fill_1
X_14989_ _14989_/Q clkload62/A _14989_/D _14989_/RESET_B VDD VSS sg13g2_dfrbpq_1
XFILLER_82_849 VDD VSS sg13g2_decap_8
X_14943__3043 _14943_/RESET_B VDD VSS sg13g2_tiehi
XFILLER_23_905 VDD VSS sg13g2_decap_8
XFILLER_34_242 VDD VSS sg13g2_fill_1
XFILLER_90_860 VDD VSS sg13g2_fill_2
XFILLER_22_404 VDD VSS sg13g2_decap_8
XFILLER_23_949 VDD VSS sg13g2_decap_8
X_09200_ _13816_/D _13816_/Q _10100_/A0 _09200_/S VDD VSS sg13g2_mux2_1
XFILLER_97_0 VDD VSS sg13g2_decap_8
XFILLER_72_1031 VDD VSS sg13g2_fill_2
XFILLER_124_1110 VDD VSS sg13g2_decap_8
X_09131_ _09131_/X _09137_/A _10772_/A _09130_/Y VDD VSS sg13g2_a21o_1
XFILLER_37_1195 VDD VSS sg13g2_decap_8
XFILLER_72_1075 VDD VSS sg13g2_fill_2
XFILLER_30_470 VDD VSS sg13g2_fill_1
X_14792__3306 _14792_/RESET_B VDD VSS sg13g2_tiehi
X_09062_ _09062_/Y _13064_/A _09089_/C _09061_/Y VDD VSS sg13g2_a21oi_1
XFILLER_8_70 VDD VSS sg13g2_decap_8
XFILLER_124_1187 VDD VSS sg13g2_fill_1
XFILLER_147_177 VDD VSS sg13g2_decap_8
X_08013_ _08013_/X _07861_/B _07859_/B _07853_/B _08012_/B _08055_/S0 _08669_/B1 VDD
+ VSS sg13g2_mux4_1
X_15121__3102 _15121_/RESET_B VDD VSS sg13g2_tiehi
XFILLER_118_49 VDD VSS sg13g2_fill_2
Xmax_cap341 _09436_/S _09424_/S VDD VSS sg13g2_buf_4
XFILLER_116_564 VDD VSS sg13g2_fill_2
XFILLER_116_586 VDD VSS sg13g2_decap_8
XFILLER_104_748 VDD VSS sg13g2_decap_4
XFILLER_143_394 VDD VSS sg13g2_decap_8
X_09964_ _14548_/D _14548_/Q _10030_/A0 _09964_/S VDD VSS sg13g2_mux2_1
X_13919__2645 _13919_/RESET_B VDD VSS sg13g2_tiehi
X_14679__1885 _14679_/RESET_B VDD VSS sg13g2_tiehi
XFILLER_83_1171 VDD VSS sg13g2_fill_1
XFILLER_103_258 VDD VSS sg13g2_decap_4
X_08915_ _08915_/Y _11914_/A _08925_/S _08914_/Y VDD VSS sg13g2_a21oi_1
XFILLER_58_813 VDD VSS sg13g2_decap_8
XFILLER_69_150 VDD VSS sg13g2_decap_8
XFILLER_57_301 VDD VSS sg13g2_decap_4
X_09895_ _14481_/D _09928_/A1 _14481_/Q _09904_/S VDD VSS sg13g2_mux2_1
XFILLER_44_1166 VDD VSS sg13g2_decap_4
XFILLER_85_621 VDD VSS sg13g2_decap_8
XFILLER_40_1008 VDD VSS sg13g2_decap_8
XFILLER_100_943 VDD VSS sg13g2_fill_2
X_08846_ wire554/A _08871_/S _08845_/Y _08843_/Y VDD VSS sg13g2_o21ai_1
XFILLER_85_643 VDD VSS sg13g2_decap_8
XFILLER_58_868 VDD VSS sg13g2_decap_8
XFILLER_44_1199 VDD VSS sg13g2_fill_1
XFILLER_79_1218 VDD VSS sg13g2_decap_8
XFILLER_100_976 VDD VSS sg13g2_decap_4
XFILLER_45_507 VDD VSS sg13g2_decap_4
XFILLER_27_35 VDD VSS sg13g2_decap_8
XFILLER_150_14 VDD VSS sg13g2_decap_8
X_08777_ _13677_/D _08780_/A1 _08776_/Y _08775_/Y VDD VSS sg13g2_a21oi_1
XFILLER_72_337 VDD VSS sg13g2_decap_4
X_07728_ _07728_/X _07728_/A _13150_/B _12963_/B VDD VSS sg13g2_or3_1
X_07659_ _07659_/Y _14763_/Q _07658_/X VDD VSS sg13g2_nor2b_1
XFILLER_25_275 VDD VSS sg13g2_fill_1
XFILLER_80_370 VDD VSS sg13g2_decap_8
XFILLER_129_1065 VDD VSS sg13g2_fill_2
XFILLER_25_297 VDD VSS sg13g2_fill_1
XFILLER_90_1120 VDD VSS sg13g2_decap_4
XFILLER_43_56 VDD VSS sg13g2_decap_8
X_10670_ wire844/A _10670_/A _13281_/B VDD VSS sg13g2_nor2_1
XFILLER_142_1210 VDD VSS sg13g2_decap_8
XFILLER_22_960 VDD VSS sg13g2_decap_8
XFILLER_51_1104 VDD VSS sg13g2_fill_1
X_14514__2050 _14514_/RESET_B VDD VSS sg13g2_tiehi
X_09329_ _13936_/D _10159_/A1 _13936_/Q _09339_/S VDD VSS sg13g2_mux2_1
XFILLER_51_1126 VDD VSS sg13g2_decap_8
XFILLER_21_481 VDD VSS sg13g2_fill_1
X_12340_ _12340_/Y _12340_/A VDD VSS sg13g2_inv_1
X_14768__3330 _14768_/RESET_B VDD VSS sg13g2_tiehi
X_12271_ _12297_/A _12271_/A _12278_/A VDD VSS sg13g2_nand2_1
XFILLER_153_147 VDD VSS sg13g2_decap_8
XFILLER_135_851 VDD VSS sg13g2_fill_1
XFILLER_49_1022 VDD VSS sg13g2_decap_8
X_14010_ _14010_/Q _15040_/CLK _14010_/D _14010_/RESET_B VDD VSS sg13g2_dfrbpq_1
X_11222_ _11223_/C _11230_/S _11222_/B VDD VSS sg13g2_nor2_1
XFILLER_4_28 VDD VSS sg13g2_decap_8
XFILLER_49_1077 VDD VSS sg13g2_fill_2
X_15069__3252 _15069_/RESET_B VDD VSS sg13g2_tiehi
XFILLER_1_831 VDD VSS sg13g2_fill_1
X_11153_ _11153_/Y _11152_/Y _11151_/A _11151_/Y _11150_/Y _11192_/B1 VDD VSS sg13g2_a221oi_1
XFILLER_49_1088 VDD VSS sg13g2_fill_1
XFILLER_96_908 VDD VSS sg13g2_fill_1
XFILLER_136_1047 VDD VSS sg13g2_decap_8
XFILLER_136_1058 VDD VSS sg13g2_decap_4
X_10104_ _14683_/D _10138_/A1 _14683_/Q _10124_/S VDD VSS sg13g2_mux2_1
X_11084_ _11084_/Y _14948_/Q _11084_/B VDD VSS sg13g2_nand2_1
XFILLER_95_418 VDD VSS sg13g2_decap_8
XFILLER_0_374 VDD VSS sg13g2_decap_4
XFILLER_88_481 VDD VSS sg13g2_decap_8
XFILLER_23_1217 VDD VSS sg13g2_decap_8
XFILLER_88_492 VDD VSS sg13g2_fill_2
X_14912_ _14912_/Q clkload48/A _14912_/D _14912_/RESET_B VDD VSS sg13g2_dfrbpq_1
X_10035_ _14617_/D _10068_/A0 _14617_/Q _10035_/S VDD VSS sg13g2_mux2_1
X_13773__2791 _13773_/RESET_B VDD VSS sg13g2_tiehi
XFILLER_64_816 VDD VSS sg13g2_decap_4
X_14843_ _14843_/Q clkload82/A _14843_/D _14843_/RESET_B VDD VSS sg13g2_dfrbpq_1
XFILLER_64_827 VDD VSS sg13g2_decap_8
XFILLER_36_529 VDD VSS sg13g2_decap_8
XFILLER_76_698 VDD VSS sg13g2_fill_1
XFILLER_5_1171 VDD VSS sg13g2_decap_8
X_14724__1840 _14724_/RESET_B VDD VSS sg13g2_tiehi
XFILLER_91_646 VDD VSS sg13g2_fill_2
XFILLER_29_592 VDD VSS sg13g2_fill_1
XFILLER_95_1031 VDD VSS sg13g2_fill_2
X_14774_ _14774_/Q clkload74/A _14774_/D _14774_/RESET_B VDD VSS sg13g2_dfrbpq_1
XFILLER_17_754 VDD VSS sg13g2_decap_8
X_11986_ _11986_/Y _11986_/A _11986_/B VDD VSS sg13g2_nor2_1
XFILLER_147_1110 VDD VSS sg13g2_decap_8
X_13725_ _13725_/Q clkload52/A _13725_/D _13725_/RESET_B VDD VSS sg13g2_dfrbpq_1
XFILLER_72_871 VDD VSS sg13g2_fill_1
XFILLER_147_1143 VDD VSS sg13g2_decap_8
X_10937_ _10937_/Y _10954_/B _10937_/B VDD VSS sg13g2_xnor2_1
XFILLER_140_91 VDD VSS sg13g2_decap_8
XFILLER_108_1116 VDD VSS sg13g2_fill_2
XFILLER_143_1007 VDD VSS sg13g2_fill_1
X_13656_ _15122_/D _15192_/D _15122_/Q _13656_/S VDD VSS sg13g2_mux2_1
X_10868_ _10869_/B _10890_/A _10890_/B _10868_/C VDD VSS sg13g2_nor3_1
XFILLER_108_1149 VDD VSS sg13g2_fill_1
X_12607_ _12607_/X _12600_/X _12604_/X _12599_/X _12603_/X wire1073/X wire1090/X VDD
+ VSS sg13g2_mux4_1
XFILLER_13_971 VDD VSS sg13g2_decap_8
X_13587_ _13587_/Y _15161_/Q _13593_/B VDD VSS sg13g2_nor2_1
X_10799_ _14926_/D _13279_/D _10798_/X _10796_/Y VDD VSS sg13g2_o21ai_1
XFILLER_9_964 VDD VSS sg13g2_decap_8
XFILLER_129_144 VDD VSS sg13g2_decap_8
X_12538_ _12538_/X _12536_/X _12535_/X _12532_/X _12531_/X _12760_/S0 _12567_/S VDD
+ VSS sg13g2_mux4_1
X_12469_ _12469_/X _12467_/X _12468_/X _12553_/S VDD VSS sg13g2_mux2_1
XFILLER_126_840 VDD VSS sg13g2_fill_2
XFILLER_67_1111 VDD VSS sg13g2_fill_1
X_14208_ _14208_/Q _14678_/CLK _14208_/D _14208_/RESET_B VDD VSS sg13g2_dfrbpq_1
XFILLER_99_702 VDD VSS sg13g2_fill_2
XFILLER_132_309 VDD VSS sg13g2_decap_4
X_15188_ _15188_/Q _15188_/CLK _15188_/D _15188_/RESET_B VDD VSS sg13g2_dfrbpq_1
XFILLER_98_201 VDD VSS sg13g2_decap_4
XFILLER_67_1166 VDD VSS sg13g2_fill_2
X_14139_ _14139_/Q clkload73/A _14139_/D _14139_/RESET_B VDD VSS sg13g2_dfrbpq_1
Xfanout409 _09951_/S _09964_/S VDD VSS sg13g2_buf_1
XFILLER_140_331 VDD VSS sg13g2_decap_8
XFILLER_98_245 VDD VSS sg13g2_fill_1
XFILLER_67_1199 VDD VSS sg13g2_fill_1
XFILLER_113_567 VDD VSS sg13g2_decap_4
XFILLER_154_1169 VDD VSS sg13g2_decap_8
XFILLER_100_217 VDD VSS sg13g2_decap_4
X_14556__2008 _14556_/RESET_B VDD VSS sg13g2_tiehi
X_08700_ _08700_/Y _08698_/X _08697_/Y _08695_/Y _08696_/Y _07974_/D VDD VSS sg13g2_a221oi_1
X_09680_ _14272_/D _09680_/A0 _14272_/Q _09705_/S VDD VSS sg13g2_mux2_1
XFILLER_12_0 VDD VSS sg13g2_decap_8
X_15150__3042 _15150_/RESET_B VDD VSS sg13g2_tiehi
X_08631_ _08631_/Y _08641_/A _08630_/Y _08395_/A VDD VSS sg13g2_a21oi_1
XFILLER_54_304 VDD VSS sg13g2_fill_2
XFILLER_67_687 VDD VSS sg13g2_decap_8
XFILLER_82_624 VDD VSS sg13g2_fill_2
XFILLER_66_197 VDD VSS sg13g2_fill_1
X_08562_ _08562_/Y _08030_/Y _08488_/B _08561_/Y VDD VSS sg13g2_o21ai_1
XFILLER_54_348 VDD VSS sg13g2_decap_4
XFILLER_120_28 VDD VSS sg13g2_decap_8
X_08493_ _08494_/B _15008_/Q _08471_/B _08456_/C _08456_/B VDD VSS sg13g2_a22oi_1
XFILLER_126_1205 VDD VSS sg13g2_fill_1
XFILLER_23_746 VDD VSS sg13g2_fill_1
XFILLER_50_532 VDD VSS sg13g2_decap_8
XFILLER_22_234 VDD VSS sg13g2_decap_8
XFILLER_148_442 VDD VSS sg13g2_fill_1
X_09114_ _10762_/B _09161_/S _15045_/Q _09113_/Y VDD VSS sg13g2_o21ai_1
XFILLER_149_987 VDD VSS sg13g2_decap_8
X_14162__2402 _14162_/RESET_B VDD VSS sg13g2_tiehi
XFILLER_136_626 VDD VSS sg13g2_fill_2
X_09045_ _09045_/Y _09024_/A _10716_/B _09044_/X VDD VSS sg13g2_o21ai_1
XFILLER_11_1154 VDD VSS sg13g2_decap_8
X_14756__3345 _14756_/RESET_B VDD VSS sg13g2_tiehi
XFILLER_145_14 VDD VSS sg13g2_decap_8
XFILLER_132_832 VDD VSS sg13g2_decap_8
XFILLER_46_1228 VDD VSS sg13g2_decap_8
XFILLER_89_234 VDD VSS sg13g2_fill_1
XFILLER_89_256 VDD VSS sg13g2_fill_2
XFILLER_132_876 VDD VSS sg13g2_decap_8
Xfanout910 _08659_/B _08400_/A VDD VSS sg13g2_buf_1
Xfanout921 _13193_/B _13248_/B VDD VSS sg13g2_buf_1
X_14195__2369 _14195_/RESET_B VDD VSS sg13g2_tiehi
X_09947_ _14531_/D _14531_/Q _10079_/A0 _09967_/S VDD VSS sg13g2_mux2_1
Xfanout932 _11082_/B1 _07753_/B VDD VSS sg13g2_buf_1
Xfanout943 _07684_/B _12294_/B1 VDD VSS sg13g2_buf_1
XFILLER_131_386 VDD VSS sg13g2_decap_8
Xfanout965 _12108_/B _11615_/B VDD VSS sg13g2_buf_1
Xfanout976 _11955_/B _12113_/C1 VDD VSS sg13g2_buf_1
XFILLER_38_56 VDD VSS sg13g2_decap_8
X_09878_ _14464_/D _09911_/A1 _14464_/Q _09901_/S VDD VSS sg13g2_mux2_1
XFILLER_100_751 VDD VSS sg13g2_fill_1
Xfanout998 _11279_/B1 _07654_/Y VDD VSS sg13g2_buf_1
XFILLER_100_762 VDD VSS sg13g2_fill_1
XFILLER_45_304 VDD VSS sg13g2_decap_8
XFILLER_57_164 VDD VSS sg13g2_decap_8
X_08829_ _08830_/C _15055_/Q _13283_/A _08832_/D VDD VSS sg13g2_nor3_1
XFILLER_58_698 VDD VSS sg13g2_decap_8
XFILLER_79_1026 VDD VSS sg13g2_decap_8
XFILLER_85_484 VDD VSS sg13g2_fill_1
XFILLER_85_495 VDD VSS sg13g2_fill_1
X_11840_ _11907_/B _11770_/A _13064_/B _13676_/Q _11798_/A VDD VSS sg13g2_a22oi_1
XFILLER_73_668 VDD VSS sg13g2_decap_4
XFILLER_61_819 VDD VSS sg13g2_decap_4
XFILLER_54_860 VDD VSS sg13g2_decap_8
XFILLER_92_1204 VDD VSS sg13g2_decap_4
X_11771_ _11771_/Y _11771_/A _11771_/B _11773_/C VDD VSS sg13g2_nor3_1
XFILLER_81_690 VDD VSS sg13g2_decap_8
X_13510_ _15133_/D _15133_/Q _13521_/A _13568_/S VDD VSS sg13g2_mux2_1
XFILLER_13_234 VDD VSS sg13g2_decap_8
X_10722_ _11015_/C _08862_/S _10720_/B _08885_/Y VDD VSS sg13g2_o21ai_1
XFILLER_14_768 VDD VSS sg13g2_decap_8
X_14490_ _14490_/Q clkload47/A _14490_/D _14490_/RESET_B VDD VSS sg13g2_dfrbpq_1
XFILLER_70_21 VDD VSS sg13g2_decap_8
X_13441_ _15102_/D _13421_/Y _13438_/Y _13440_/Y VDD VSS sg13g2_o21ai_1
XFILLER_110_83 VDD VSS sg13g2_decap_8
X_10653_ _10654_/B _10653_/A _10653_/B _10653_/C _10653_/D VDD VSS sg13g2_nand4_1
XFILLER_139_431 VDD VSS sg13g2_fill_2
X_15218__3371 _15218_/RESET_B VDD VSS sg13g2_tiehi
XFILLER_22_790 VDD VSS sg13g2_decap_4
XFILLER_139_453 VDD VSS sg13g2_fill_2
XFILLER_155_924 VDD VSS sg13g2_decap_8
XFILLER_16_1076 VDD VSS sg13g2_decap_8
X_13372_ _13372_/Y _13440_/A _13425_/A _15077_/Q VDD VSS sg13g2_nand3_1
X_10584_ _10606_/A _14872_/Q _14871_/Q _10584_/C VDD VSS sg13g2_nand3_1
XFILLER_5_400 VDD VSS sg13g2_decap_8
Xclkload19 clkload19/Y clkload19/A VDD VSS sg13g2_inv_2
XFILLER_126_103 VDD VSS sg13g2_decap_8
X_15111_ _15111_/Q clkload74/A _15111_/D _15111_/RESET_B VDD VSS sg13g2_dfrbpq_1
XFILLER_103_1057 VDD VSS sg13g2_decap_8
X_12323_ _12324_/A _14266_/Q _14298_/Q _14330_/Q _14362_/Q _11804_/A _11805_/C VDD
+ VSS sg13g2_mux4_1
XFILLER_154_445 VDD VSS sg13g2_decap_8
X_15042_ _15042_/Q clkload47/A _15042_/D _15042_/RESET_B VDD VSS sg13g2_dfrbpq_1
X_12254_ _12254_/Y _12255_/A1 _13848_/Q VDD VSS sg13g2_nand2b_1
XFILLER_108_895 VDD VSS sg13g2_fill_2
X_11205_ _11205_/X _11205_/A _11205_/B VDD VSS sg13g2_xor2_1
XFILLER_134_180 VDD VSS sg13g2_fill_2
X_12185_ _12187_/A _12186_/A _13910_/Q VDD VSS sg13g2_nand2b_1
X_14025__2539 _14025_/RESET_B VDD VSS sg13g2_tiehi
X_11136_ _11136_/Y _11146_/B _11136_/B VDD VSS sg13g2_xnor2_1
X_13668__2921 _13668_/RESET_B VDD VSS sg13g2_tiehi
X_13860__2704 _13860_/RESET_B VDD VSS sg13g2_tiehi
XFILLER_7_1222 VDD VSS sg13g2_decap_8
XFILLER_96_749 VDD VSS sg13g2_decap_8
XFILLER_23_1014 VDD VSS sg13g2_decap_8
XFILLER_0_182 VDD VSS sg13g2_decap_4
X_11067_ _11067_/Y _11118_/A _11088_/A _11066_/Y VDD VSS sg13g2_a21oi_1
XFILLER_114_1131 VDD VSS sg13g2_fill_2
XFILLER_153_1191 VDD VSS sg13g2_decap_8
XFILLER_27_1194 VDD VSS sg13g2_decap_8
XFILLER_48_131 VDD VSS sg13g2_decap_4
XFILLER_49_665 VDD VSS sg13g2_decap_4
XFILLER_37_816 VDD VSS sg13g2_fill_2
XFILLER_62_1096 VDD VSS sg13g2_decap_8
X_10018_ _14600_/D _10084_/A0 _14600_/Q _10020_/S VDD VSS sg13g2_mux2_1
XFILLER_49_698 VDD VSS sg13g2_decap_8
X_14826_ _14826_/Q clkload79/A _14826_/D _14826_/RESET_B VDD VSS sg13g2_dfrbpq_1
X_14240__2324 _14240_/RESET_B VDD VSS sg13g2_tiehi
X_14757_ _14757_/Q _15212_/CLK _14757_/D _14757_/RESET_B VDD VSS sg13g2_dfrbpq_1
XFILLER_45_893 VDD VSS sg13g2_decap_8
XFILLER_91_498 VDD VSS sg13g2_decap_8
X_11969_ _11970_/B _11969_/A _13936_/Q VDD VSS sg13g2_nand2_1
XFILLER_32_521 VDD VSS sg13g2_decap_4
X_13708_ _13708_/Q clkload19/A _13708_/D _13708_/RESET_B VDD VSS sg13g2_dfrbpq_1
XFILLER_149_206 VDD VSS sg13g2_decap_8
XFILLER_60_863 VDD VSS sg13g2_decap_8
X_14688_ _14688_/Q _14916_/CLK _14688_/D _14688_/RESET_B VDD VSS sg13g2_dfrbpq_1
XFILLER_149_217 VDD VSS sg13g2_fill_2
XFILLER_20_716 VDD VSS sg13g2_fill_1
X_13639_ _13747_/D _13639_/A VDD VSS sg13g2_buf_1
XFILLER_34_1132 VDD VSS sg13g2_decap_8
X_14978__2994 _14978_/RESET_B VDD VSS sg13g2_tiehi
XFILLER_145_412 VDD VSS sg13g2_fill_2
XFILLER_30_1018 VDD VSS sg13g2_fill_2
XFILLER_118_637 VDD VSS sg13g2_decap_8
XFILLER_121_1157 VDD VSS sg13g2_decap_8
XFILLER_69_1228 VDD VSS sg13g2_decap_8
XFILLER_117_136 VDD VSS sg13g2_fill_2
XFILLER_133_607 VDD VSS sg13g2_decap_8
XFILLER_99_510 VDD VSS sg13g2_decap_8
XFILLER_114_821 VDD VSS sg13g2_decap_8
XFILLER_8_1008 VDD VSS sg13g2_decap_8
XFILLER_87_705 VDD VSS sg13g2_decap_8
X_09801_ _14390_/D _09900_/A0 _14390_/Q _09801_/S VDD VSS sg13g2_mux2_1
Xfanout217 _10092_/A0 _09562_/A0 VDD VSS sg13g2_buf_1
Xfanout228 _10156_/A1 _10089_/A0 VDD VSS sg13g2_buf_1
XFILLER_8_1019 VDD VSS sg13g2_fill_2
XFILLER_101_504 VDD VSS sg13g2_decap_8
XFILLER_101_515 VDD VSS sg13g2_fill_1
XFILLER_115_28 VDD VSS sg13g2_fill_2
X_07993_ _07993_/Y _15100_/Q _15089_/Q VDD VSS sg13g2_nor2_1
XFILLER_99_598 VDD VSS sg13g2_decap_8
XFILLER_87_749 VDD VSS sg13g2_fill_1
XFILLER_113_397 VDD VSS sg13g2_fill_2
X_09732_ _14323_/D _09930_/A1 _14323_/Q wire449/X VDD VSS sg13g2_mux2_1
XFILLER_132_1231 VDD VSS sg13g2_decap_4
X_09663_ _14256_/D _09696_/A0 _14256_/Q _09673_/S VDD VSS sg13g2_mux2_1
X_08614_ _08615_/B _08641_/B _08612_/X _08613_/Y VDD VSS sg13g2_o21ai_1
XFILLER_27_359 VDD VSS sg13g2_decap_8
X_09594_ _14191_/D _14191_/Q _10158_/A1 _09599_/S VDD VSS sg13g2_mux2_1
XFILLER_131_49 VDD VSS sg13g2_decap_8
XFILLER_82_476 VDD VSS sg13g2_decap_4
XFILLER_36_882 VDD VSS sg13g2_decap_8
X_08545_ _08545_/X _08545_/A _08545_/B _08545_/C _08545_/D VDD VSS sg13g2_and4_1
X_13869__2695 _13869_/RESET_B VDD VSS sg13g2_tiehi
XFILLER_24_14 VDD VSS sg13g2_decap_8
XFILLER_23_543 VDD VSS sg13g2_decap_4
X_08476_ _08476_/Y _08476_/A _08497_/A VDD VSS sg13g2_nand2_1
XFILLER_23_565 VDD VSS sg13g2_fill_1
XFILLER_11_716 VDD VSS sg13g2_fill_2
XFILLER_50_351 VDD VSS sg13g2_decap_8
XFILLER_51_885 VDD VSS sg13g2_decap_4
XFILLER_149_740 VDD VSS sg13g2_decap_4
XFILLER_138_7 VDD VSS sg13g2_decap_8
Xwire618 wire618/X wire618/A VDD VSS sg13g2_buf_4
XFILLER_137_913 VDD VSS sg13g2_fill_2
Xwire629 wire629/X wire629/A VDD VSS sg13g2_buf_4
XFILLER_137_924 VDD VSS sg13g2_fill_2
XFILLER_13_1216 VDD VSS sg13g2_decap_8
XFILLER_136_423 VDD VSS sg13g2_decap_4
XFILLER_108_114 VDD VSS sg13g2_decap_8
XFILLER_108_125 VDD VSS sg13g2_decap_8
XFILLER_109_648 VDD VSS sg13g2_fill_2
XFILLER_108_136 VDD VSS sg13g2_fill_1
XFILLER_109_659 VDD VSS sg13g2_fill_2
XFILLER_100_1219 VDD VSS sg13g2_decap_8
XFILLER_156_35 VDD VSS sg13g2_decap_8
XFILLER_108_147 VDD VSS sg13g2_decap_8
XFILLER_152_927 VDD VSS sg13g2_decap_8
X_09028_ _09031_/B _14905_/Q _09024_/B VDD VSS sg13g2_nor2b_1
XFILLER_123_106 VDD VSS sg13g2_decap_8
XFILLER_105_810 VDD VSS sg13g2_decap_8
XFILLER_145_990 VDD VSS sg13g2_decap_8
XFILLER_2_425 VDD VSS sg13g2_decap_8
Xpicorv32_macro_1801 mem_axi_arprot[0] VDD VSS sg13g2_tielo
Xfanout1705 fanout1705/X _12235_/A VDD VSS sg13g2_buf_1
XFILLER_77_204 VDD VSS sg13g2_decap_4
Xfanout1716 _12025_/A fanout1736/X VDD VSS sg13g2_buf_1
XFILLER_132_695 VDD VSS sg13g2_fill_2
Xfanout1727 _11814_/S0 _11828_/S0 VDD VSS sg13g2_buf_1
XFILLER_137_1197 VDD VSS sg13g2_decap_4
Xfanout740 _13551_/S _13508_/X VDD VSS sg13g2_buf_1
Xclkbuf_leaf_9_clk_i clkload12/A clkbuf_leaf_9_clk_i/A VDD VSS sg13g2_buf_8
Xfanout1738 _11365_/A _11890_/S0 VDD VSS sg13g2_buf_1
Xfanout1749 _11263_/A1 fanout1750/X VDD VSS sg13g2_buf_1
Xfanout751 _12077_/A _11477_/A VDD VSS sg13g2_buf_1
XFILLER_131_194 VDD VSS sg13g2_decap_4
Xfanout773 _10139_/A1 _08972_/X VDD VSS sg13g2_buf_1
X_13990_ _13990_/Q clkload12/A _13990_/D _13990_/RESET_B VDD VSS sg13g2_dfrbpq_1
XFILLER_19_816 VDD VSS sg13g2_decap_4
Xfanout784 _08995_/B1 _08967_/Y VDD VSS sg13g2_buf_1
XFILLER_59_985 VDD VSS sg13g2_decap_8
XFILLER_86_771 VDD VSS sg13g2_fill_1
Xfanout795 _13375_/B _08723_/Y VDD VSS sg13g2_buf_1
XFILLER_18_304 VDD VSS sg13g2_decap_8
X_12941_ _15029_/D _12984_/A _12941_/B VDD VSS sg13g2_nor2_1
XFILLER_65_21 VDD VSS sg13g2_fill_2
XFILLER_74_933 VDD VSS sg13g2_fill_1
XFILLER_19_849 VDD VSS sg13g2_fill_1
XFILLER_65_32 VDD VSS sg13g2_decap_8
XFILLER_46_646 VDD VSS sg13g2_decap_8
XFILLER_73_443 VDD VSS sg13g2_fill_1
X_12872_ _12872_/X _14899_/Q _13688_/Q VDD VSS sg13g2_and2_1
XFILLER_74_988 VDD VSS sg13g2_fill_2
X_14611_ _14611_/Q clkload11/A _14611_/D _14611_/RESET_B VDD VSS sg13g2_dfrbpq_1
X_11823_ _11823_/Y _11826_/A1 _13836_/Q VDD VSS sg13g2_nand2b_1
XFILLER_2_1185 VDD VSS sg13g2_decap_8
XFILLER_60_126 VDD VSS sg13g2_decap_8
XFILLER_92_1034 VDD VSS sg13g2_decap_8
X_14542_ _14542_/Q _14670_/CLK _14542_/D _14542_/RESET_B VDD VSS sg13g2_dfrbpq_1
XFILLER_109_1222 VDD VSS sg13g2_decap_8
XFILLER_144_1113 VDD VSS sg13g2_fill_2
X_11754_ _11754_/X _11754_/A _11763_/B VDD VSS sg13g2_and2_1
XFILLER_92_1045 VDD VSS sg13g2_fill_1
XFILLER_144_1135 VDD VSS sg13g2_decap_8
XFILLER_42_874 VDD VSS sg13g2_fill_1
XFILLER_18_1149 VDD VSS sg13g2_decap_8
XFILLER_14_587 VDD VSS sg13g2_fill_2
X_10705_ _10936_/D _09021_/X _08877_/A _08869_/Y VDD VSS sg13g2_a21o_1
XFILLER_81_75 VDD VSS sg13g2_fill_1
X_14473_ _14473_/Q _14505_/CLK _14473_/D _14473_/RESET_B VDD VSS sg13g2_dfrbpq_1
XFILLER_81_86 VDD VSS sg13g2_decap_8
X_11685_ _11685_/Y _11681_/Y _11682_/Y _11684_/Y _11683_/Y _11696_/B VDD VSS sg13g2_a221oi_1
XFILLER_41_384 VDD VSS sg13g2_fill_2
XFILLER_105_1119 VDD VSS sg13g2_decap_8
XFILLER_144_1179 VDD VSS sg13g2_decap_8
X_13424_ _13444_/C _13425_/A _15130_/Q VDD VSS sg13g2_nand2_1
X_10636_ _10642_/C _10636_/A _10636_/B VDD VSS sg13g2_nor2_1
XFILLER_14_91 VDD VSS sg13g2_decap_8
X_13914__2650 _13914_/RESET_B VDD VSS sg13g2_tiehi
X_14674__1890 _14674_/RESET_B VDD VSS sg13g2_tiehi
X_13355_ _13469_/C _13401_/C _13401_/B _13438_/B VDD VSS sg13g2_nor3_1
XFILLER_154_231 VDD VSS sg13g2_decap_4
X_10567_ _10571_/C _10567_/A _10567_/B _10567_/C _10567_/D VDD VSS sg13g2_nor4_1
XFILLER_6_753 VDD VSS sg13g2_decap_8
XFILLER_127_456 VDD VSS sg13g2_fill_1
XFILLER_155_776 VDD VSS sg13g2_fill_2
Xmax_cap1079 _12746_/S1 _12747_/S1 VDD VSS sg13g2_buf_4
XFILLER_127_467 VDD VSS sg13g2_fill_2
X_12306_ _12307_/B _12306_/A _14234_/Q VDD VSS sg13g2_nand2_1
XFILLER_53_7 VDD VSS sg13g2_decap_8
X_13286_ _13287_/B _13300_/C _07751_/Y _07710_/Y VDD VSS sg13g2_o21ai_1
X_10498_ _10499_/B _14853_/Q _14852_/Q _10513_/D _10498_/D VDD VSS sg13g2_nand4_1
XFILLER_142_426 VDD VSS sg13g2_decap_4
XFILLER_114_128 VDD VSS sg13g2_decap_8
X_15025_ _15025_/Q _15250_/CLK _15025_/D _15025_/RESET_B VDD VSS sg13g2_dfrbpq_1
X_12237_ _12237_/Y _12237_/A _12237_/B _12237_/C VDD VSS sg13g2_nand3_1
XFILLER_64_1103 VDD VSS sg13g2_decap_8
X_14258__2306 _14258_/RESET_B VDD VSS sg13g2_tiehi
XFILLER_68_204 VDD VSS sg13g2_decap_4
XFILLER_69_727 VDD VSS sg13g2_decap_8
X_12168_ _12169_/B _12168_/A _14678_/Q VDD VSS sg13g2_nand2_1
XFILLER_25_1109 VDD VSS sg13g2_decap_8
XFILLER_151_1128 VDD VSS sg13g2_fill_1
XFILLER_1_480 VDD VSS sg13g2_decap_4
X_11119_ _11119_/Y _11119_/A _11119_/B VDD VSS sg13g2_nor2_1
XFILLER_96_557 VDD VSS sg13g2_decap_8
XFILLER_111_868 VDD VSS sg13g2_fill_2
X_12099_ _12099_/Y _12095_/Y _12096_/Y _12098_/Y _12097_/Y _12108_/B VDD VSS sg13g2_a221oi_1
XFILLER_65_900 VDD VSS sg13g2_fill_2
XFILLER_37_613 VDD VSS sg13g2_decap_8
Xinput6 input6/X input6/A VDD VSS sg13g2_buf_1
XFILLER_49_473 VDD VSS sg13g2_decap_8
XFILLER_7_1096 VDD VSS sg13g2_decap_8
XFILLER_37_635 VDD VSS sg13g2_decap_8
XFILLER_149_1013 VDD VSS sg13g2_decap_8
XFILLER_25_808 VDD VSS sg13g2_fill_2
XFILLER_149_1024 VDD VSS sg13g2_fill_1
XFILLER_65_988 VDD VSS sg13g2_decap_4
XFILLER_36_178 VDD VSS sg13g2_decap_8
X_14809_ _14809_/Q _14873_/CLK _14809_/D _14809_/RESET_B VDD VSS sg13g2_dfrbpq_1
XFILLER_17_370 VDD VSS sg13g2_decap_8
XFILLER_51_126 VDD VSS sg13g2_decap_8
XFILLER_75_1232 VDD VSS sg13g2_decap_4
X_08330_ _08330_/Y _08452_/C _08484_/C _08329_/Y VDD VSS sg13g2_o21ai_1
XFILLER_32_362 VDD VSS sg13g2_decap_8
X_08261_ _08261_/Y _08539_/B1 _08590_/B _08260_/Y VDD VSS sg13g2_o21ai_1
XFILLER_32_395 VDD VSS sg13g2_decap_8
XFILLER_146_710 VDD VSS sg13g2_decap_8
X_08192_ _08192_/Y _07890_/B _08191_/Y _08588_/B VDD VSS sg13g2_o21ai_1
XFILLER_69_1025 VDD VSS sg13g2_decap_8
XFILLER_105_106 VDD VSS sg13g2_decap_8
XFILLER_10_49 VDD VSS sg13g2_decap_8
XFILLER_82_1214 VDD VSS sg13g2_fill_1
XFILLER_0_918 VDD VSS sg13g2_decap_4
XFILLER_142_982 VDD VSS sg13g2_fill_2
XFILLER_87_535 VDD VSS sg13g2_fill_1
XFILLER_113_183 VDD VSS sg13g2_decap_8
XFILLER_19_14 VDD VSS sg13g2_decap_8
X_07976_ _07976_/X _07976_/A _07976_/B _07976_/C VDD VSS sg13g2_or3_1
XFILLER_87_568 VDD VSS sg13g2_fill_2
XFILLER_45_1080 VDD VSS sg13g2_decap_8
XFILLER_56_911 VDD VSS sg13g2_fill_1
X_15217__3370 _15217_/RESET_B VDD VSS sg13g2_tiehi
X_09715_ _14306_/D _09880_/A0 _14306_/Q _09737_/S VDD VSS sg13g2_mux2_1
XFILLER_101_389 VDD VSS sg13g2_decap_4
XFILLER_132_1083 VDD VSS sg13g2_decap_4
X_13956__2608 _13956_/RESET_B VDD VSS sg13g2_tiehi
XFILLER_55_443 VDD VSS sg13g2_fill_1
X_09646_ _14239_/D _09646_/A0 _14239_/Q wire641/A VDD VSS sg13g2_mux2_1
XFILLER_27_167 VDD VSS sg13g2_fill_2
XFILLER_42_104 VDD VSS sg13g2_fill_1
X_09577_ _14174_/D _14174_/Q _09909_/A1 _09605_/S VDD VSS sg13g2_mux2_1
XFILLER_42_126 VDD VSS sg13g2_decap_8
XFILLER_71_969 VDD VSS sg13g2_fill_2
XFILLER_24_852 VDD VSS sg13g2_decap_8
X_08528_ _08567_/C _07815_/X _07822_/B _07816_/X VDD VSS sg13g2_a21oi_1
X_14336__2228 _14336_/RESET_B VDD VSS sg13g2_tiehi
X_08459_ _08459_/Y _08281_/Y _08597_/A _08539_/B1 VDD VSS sg13g2_a21oi_1
XFILLER_11_546 VDD VSS sg13g2_fill_1
XFILLER_156_518 VDD VSS sg13g2_decap_4
XFILLER_7_506 VDD VSS sg13g2_fill_1
X_11470_ _11470_/X _14561_/Q _14593_/Q _14625_/Q _14657_/Q _11741_/A _11693_/C VDD
+ VSS sg13g2_mux4_1
X_13685__2887 _13685_/RESET_B VDD VSS sg13g2_tiehi
XFILLER_13_1013 VDD VSS sg13g2_decap_8
XFILLER_11_579 VDD VSS sg13g2_fill_1
X_10421_ _10423_/A _14830_/Q _10421_/B VDD VSS sg13g2_nand2b_1
XFILLER_137_754 VDD VSS sg13g2_decap_4
XFILLER_52_1095 VDD VSS sg13g2_decap_4
XFILLER_104_1185 VDD VSS sg13g2_fill_1
X_13140_ _13141_/B _13265_/A1 _13136_/X _13139_/Y _13140_/B2 _13135_/Y VDD VSS sg13g2_a221oi_1
XFILLER_139_1215 VDD VSS sg13g2_fill_1
X_10352_ _10353_/B _14809_/Q _14810_/Q _10352_/C VDD VSS sg13g2_nand3_1
X_14551__2013 _14551_/RESET_B VDD VSS sg13g2_tiehi
XFILLER_136_286 VDD VSS sg13g2_decap_8
XFILLER_3_734 VDD VSS sg13g2_fill_1
X_13071_ _13071_/Y _13068_/Y _13069_/Y _13070_/Y VDD VSS sg13g2_a21oi_1
X_10283_ _10286_/A _14788_/Q _10311_/A _14789_/Q VDD VSS sg13g2_a21o_1
XFILLER_2_233 VDD VSS sg13g2_decap_8
XFILLER_105_651 VDD VSS sg13g2_fill_2
X_12022_ _12022_/X _14578_/Q _14610_/Q _12025_/A VDD VSS sg13g2_mux2_1
XFILLER_151_289 VDD VSS sg13g2_decap_8
Xfanout1502 _07903_/B _13601_/A VDD VSS sg13g2_buf_1
Xfanout1513 _13064_/A _14910_/Q VDD VSS sg13g2_buf_1
XFILLER_120_621 VDD VSS sg13g2_fill_2
XFILLER_104_183 VDD VSS sg13g2_decap_8
Xfanout1524 _13273_/A _14862_/Q VDD VSS sg13g2_buf_1
Xfanout1535 _11202_/A _10206_/A1 VDD VSS sg13g2_buf_1
XFILLER_78_568 VDD VSS sg13g2_fill_1
XFILLER_24_1120 VDD VSS sg13g2_decap_8
XFILLER_93_505 VDD VSS sg13g2_fill_2
XFILLER_120_665 VDD VSS sg13g2_decap_8
Xfanout570 _12763_/B2 _12429_/B2 VDD VSS sg13g2_buf_1
XFILLER_65_207 VDD VSS sg13g2_fill_2
Xfanout1579 _12118_/C _12173_/B1 VDD VSS sg13g2_buf_1
Xfanout592 _10124_/S wire593/A VDD VSS sg13g2_buf_1
XFILLER_59_782 VDD VSS sg13g2_decap_8
X_13973_ _13973_/Q clkload43/A _13973_/D _13973_/RESET_B VDD VSS sg13g2_dfrbpq_1
XFILLER_98_1221 VDD VSS sg13g2_decap_8
X_14848__3233 _14848_/RESET_B VDD VSS sg13g2_tiehi
XFILLER_76_97 VDD VSS sg13g2_fill_2
XFILLER_24_1197 VDD VSS sg13g2_decap_8
X_12924_ _12943_/D _12925_/A _12925_/B _12925_/C VDD VSS sg13g2_and3_1
XFILLER_111_1145 VDD VSS sg13g2_fill_1
XFILLER_18_145 VDD VSS sg13g2_decap_8
XFILLER_47_977 VDD VSS sg13g2_decap_8
XFILLER_111_1156 VDD VSS sg13g2_decap_8
XFILLER_132_70 VDD VSS sg13g2_decap_8
XFILLER_59_1227 VDD VSS sg13g2_decap_8
XFILLER_94_1107 VDD VSS sg13g2_fill_2
XFILLER_34_616 VDD VSS sg13g2_decap_8
XFILLER_94_1118 VDD VSS sg13g2_fill_2
X_12855_ _12855_/Y _12845_/Y _13048_/B _12854_/Y VDD VSS sg13g2_a21oi_1
X_11806_ _11806_/Y _11806_/A _11806_/B _12027_/C VDD VSS sg13g2_nand3_1
XFILLER_92_85 VDD VSS sg13g2_decap_8
XFILLER_92_96 VDD VSS sg13g2_fill_1
X_12786_ _12786_/X _13850_/Q _13882_/Q _13914_/Q _13946_/Q _12787_/S0 _12787_/S1 VDD
+ VSS sg13g2_mux4_1
XFILLER_15_885 VDD VSS sg13g2_decap_8
X_14525_ _14525_/Q _14525_/CLK _14525_/D _14525_/RESET_B VDD VSS sg13g2_dfrbpq_1
XFILLER_109_1052 VDD VSS sg13g2_fill_1
X_11737_ _11737_/Y _11734_/Y _11736_/X _12191_/B1 VDD VSS sg13g2_o21ai_1
XFILLER_42_682 VDD VSS sg13g2_fill_2
XFILLER_70_991 VDD VSS sg13g2_fill_1
XFILLER_42_693 VDD VSS sg13g2_decap_4
X_14751__3350 _14751_/RESET_B VDD VSS sg13g2_tiehi
XFILLER_30_855 VDD VSS sg13g2_decap_8
XFILLER_109_1085 VDD VSS sg13g2_decap_8
X_14456_ _14456_/Q _15248_/CLK _14456_/D _14456_/RESET_B VDD VSS sg13g2_dfrbpq_1
X_11668_ _11668_/Y _11670_/S0 _13928_/Q _11690_/B VDD VSS sg13g2_a21oi_1
X_13407_ _13407_/Y _13440_/A _13440_/B _15091_/Q VDD VSS sg13g2_nand3_1
X_10619_ _14881_/D _10619_/A _10626_/B _10619_/C VDD VSS sg13g2_and3_1
X_14190__2374 _14190_/RESET_B VDD VSS sg13g2_tiehi
X_14387_ _14387_/Q clkload7/A _14387_/D _14387_/RESET_B VDD VSS sg13g2_dfrbpq_1
X_11599_ _11599_/Y _11599_/A _11599_/B _12092_/C VDD VSS sg13g2_nand3_1
XFILLER_116_927 VDD VSS sg13g2_decap_4
XFILLER_155_573 VDD VSS sg13g2_decap_8
X_13338_ _13351_/B _13338_/A _15170_/D _15169_/D VDD VSS sg13g2_nand3_1
XFILLER_143_724 VDD VSS sg13g2_fill_2
XFILLER_142_223 VDD VSS sg13g2_decap_8
Xmax_cap759 _10471_/D _10460_/A VDD VSS sg13g2_buf_2
XFILLER_143_768 VDD VSS sg13g2_decap_8
X_13269_ _13269_/Y _13270_/A _13270_/B _13270_/C VDD VSS sg13g2_a21oi_1
X_15008_ _15008_/Q _15200_/CLK _15008_/D _15008_/RESET_B VDD VSS sg13g2_dfrbpq_1
XFILLER_142_278 VDD VSS sg13g2_decap_4
XFILLER_111_610 VDD VSS sg13g2_decap_8
XFILLER_111_621 VDD VSS sg13g2_fill_2
XFILLER_155_1072 VDD VSS sg13g2_decap_4
XFILLER_29_1075 VDD VSS sg13g2_fill_2
X_07830_ _07834_/A _08048_/B _08692_/C VDD VSS sg13g2_nor2b_1
XFILLER_9_1169 VDD VSS sg13g2_decap_8
XFILLER_111_665 VDD VSS sg13g2_fill_1
XFILLER_38_911 VDD VSS sg13g2_decap_8
XFILLER_42_1231 VDD VSS sg13g2_decap_4
X_07761_ _14766_/D _10177_/A _07761_/B VDD VSS sg13g2_and2_1
XFILLER_65_730 VDD VSS sg13g2_decap_4
XFILLER_37_432 VDD VSS sg13g2_fill_1
X_09500_ _14100_/D _10063_/A0 _14100_/Q _09500_/S VDD VSS sg13g2_mux2_1
X_07692_ _07701_/B _07690_/A _15053_/Q _07679_/D VDD VSS sg13g2_a21oi_1
XFILLER_37_465 VDD VSS sg13g2_decap_8
XFILLER_80_700 VDD VSS sg13g2_fill_2
X_09431_ _14033_/D _09994_/A0 _14033_/Q _09431_/S VDD VSS sg13g2_mux2_1
X_09362_ _13966_/D _09925_/A1 _13966_/Q wire689/X VDD VSS sg13g2_mux2_1
XFILLER_40_608 VDD VSS sg13g2_decap_4
XFILLER_75_1040 VDD VSS sg13g2_decap_8
XFILLER_52_468 VDD VSS sg13g2_decap_8
XFILLER_36_1013 VDD VSS sg13g2_decap_8
XFILLER_127_1130 VDD VSS sg13g2_fill_2
X_08313_ _15229_/D _08539_/B1 _08625_/B _08312_/Y VDD VSS sg13g2_o21ai_1
XFILLER_75_1084 VDD VSS sg13g2_decap_8
X_09293_ _13901_/D _13901_/Q _10156_/A1 _09297_/S VDD VSS sg13g2_mux2_1
XFILLER_75_1095 VDD VSS sg13g2_fill_2
XANTENNA_11 _16884_/A VDD VSS sg13g2_antennanp
XFILLER_127_1185 VDD VSS sg13g2_decap_8
X_08244_ _08244_/Y _08008_/B _08244_/B VDD VSS sg13g2_nand2b_1
XFILLER_20_365 VDD VSS sg13g2_decap_4
XFILLER_20_387 VDD VSS sg13g2_decap_4
X_08175_ _08175_/Y _08188_/B _08001_/A _08542_/A2 VDD VSS sg13g2_o21ai_1
X_14020__2544 _14020_/RESET_B VDD VSS sg13g2_tiehi
XFILLER_118_242 VDD VSS sg13g2_decap_4
XFILLER_4_509 VDD VSS sg13g2_fill_2
XFILLER_107_927 VDD VSS sg13g2_decap_8
XFILLER_107_938 VDD VSS sg13g2_fill_2
XFILLER_134_746 VDD VSS sg13g2_decap_8
Xclkbuf_leaf_74_clk_i _14873_/CLK clkbuf_leaf_75_clk_i/A VDD VSS sg13g2_buf_8
Xoutput140 mem_axi_wvalid _07662_/Y VDD VSS sg13g2_buf_1
XFILLER_47_1120 VDD VSS sg13g2_decap_4
XFILLER_47_1131 VDD VSS sg13g2_fill_1
XFILLER_86_1191 VDD VSS sg13g2_decap_8
XFILLER_0_726 VDD VSS sg13g2_decap_4
XFILLER_121_429 VDD VSS sg13g2_fill_1
XFILLER_153_14 VDD VSS sg13g2_decap_8
XFILLER_82_1055 VDD VSS sg13g2_fill_2
XFILLER_87_321 VDD VSS sg13g2_fill_2
XFILLER_102_632 VDD VSS sg13g2_decap_8
XFILLER_134_1145 VDD VSS sg13g2_decap_8
X_15199__3126 _15199_/RESET_B VDD VSS sg13g2_tiehi
XFILLER_29_900 VDD VSS sg13g2_decap_8
XFILLER_82_1099 VDD VSS sg13g2_decap_8
XFILLER_87_376 VDD VSS sg13g2_decap_8
Xclkbuf_leaf_89_clk_i clkload39/A clkbuf_leaf_92_clk_i/A VDD VSS sg13g2_buf_8
XFILLER_102_698 VDD VSS sg13g2_fill_2
X_07959_ _07959_/Y _07961_/B VDD VSS sg13g2_inv_1
XFILLER_44_903 VDD VSS sg13g2_fill_2
XFILLER_56_763 VDD VSS sg13g2_fill_1
X_10970_ _10970_/Y _11099_/B2 _10964_/Y _10969_/Y VDD VSS sg13g2_a21oi_1
XFILLER_44_936 VDD VSS sg13g2_decap_4
XFILLER_43_413 VDD VSS sg13g2_decap_8
X_09629_ _14225_/D _10093_/A0 _14225_/Q wire470/X VDD VSS sg13g2_mux2_1
XFILLER_16_638 VDD VSS sg13g2_fill_1
Xclkbuf_leaf_12_clk_i _14726_/CLK clkbuf_5_3__f_clk_i/X VDD VSS sg13g2_buf_8
XFILLER_70_221 VDD VSS sg13g2_fill_1
X_12640_ _12640_/X _13840_/Q _13872_/Q _13904_/Q _13936_/Q _12646_/S0 _12647_/S1 VDD
+ VSS sg13g2_mux4_1
XFILLER_145_1230 VDD VSS sg13g2_decap_8
XFILLER_19_1233 VDD VSS sg13g2_decap_4
XFILLER_12_811 VDD VSS sg13g2_fill_2
XFILLER_24_693 VDD VSS sg13g2_fill_1
X_12571_ _12571_/X _14571_/Q _14603_/Q _14635_/Q _14667_/Q _12771_/S0 _12771_/S1 VDD
+ VSS sg13g2_mux4_1
XFILLER_141_1105 VDD VSS sg13g2_fill_2
XFILLER_23_181 VDD VSS sg13g2_decap_8
XFILLER_15_1108 VDD VSS sg13g2_decap_8
XFILLER_106_1225 VDD VSS sg13g2_decap_8
XFILLER_129_507 VDD VSS sg13g2_decap_4
XFILLER_12_855 VDD VSS sg13g2_decap_4
X_14310_ _14310_/Q _14662_/CLK _14310_/D _14310_/RESET_B VDD VSS sg13g2_dfrbpq_1
XFILLER_106_1236 VDD VSS sg13g2_fill_1
X_11522_ _14965_/D _11502_/A _11522_/A2 _11521_/Y VDD VSS sg13g2_a21o_1
XFILLER_8_826 VDD VSS sg13g2_decap_4
Xclkbuf_leaf_27_clk_i clkload43/A clkbuf_leaf_30_clk_i/A VDD VSS sg13g2_buf_8
XFILLER_129_529 VDD VSS sg13g2_decap_4
XFILLER_156_326 VDD VSS sg13g2_decap_4
XFILLER_7_303 VDD VSS sg13g2_decap_8
XFILLER_11_365 VDD VSS sg13g2_decap_4
XFILLER_7_28 VDD VSS sg13g2_decap_8
Xwire234 wire234/X wire234/A VDD VSS sg13g2_buf_2
X_14241_ _14241_/Q clkload27/A _14241_/D _14241_/RESET_B VDD VSS sg13g2_dfrbpq_1
XFILLER_127_0 VDD VSS sg13g2_decap_8
X_11453_ _11457_/A _11454_/A _13688_/Q VDD VSS sg13g2_or2_1
Xwire256 wire256/X wire256/A VDD VSS sg13g2_buf_2
X_10404_ _10406_/C _14823_/Q _10404_/A2 _14824_/Q VDD VSS sg13g2_a21oi_1
X_14172_ _14172_/Q clkload75/A _14172_/D _14172_/RESET_B VDD VSS sg13g2_dfrbpq_1
X_11384_ _11385_/B _11384_/A _13690_/Q VDD VSS sg13g2_xnor2_1
XFILLER_137_595 VDD VSS sg13g2_decap_8
XFILLER_152_532 VDD VSS sg13g2_fill_1
XFILLER_109_297 VDD VSS sg13g2_fill_1
XFILLER_124_223 VDD VSS sg13g2_fill_2
X_13123_ _13123_/Y _14787_/Q _13123_/A2 _13123_/B1 VDD VSS sg13g2_o21ai_1
XFILLER_124_234 VDD VSS sg13g2_fill_1
XFILLER_11_70 VDD VSS sg13g2_decap_8
XFILLER_125_768 VDD VSS sg13g2_fill_1
X_10335_ _10337_/A _14805_/Q _10335_/B VDD VSS sg13g2_nand2b_1
XFILLER_113_919 VDD VSS sg13g2_decap_8
XFILLER_3_553 VDD VSS sg13g2_decap_8
XFILLER_127_70 VDD VSS sg13g2_decap_8
XFILLER_140_727 VDD VSS sg13g2_fill_1
XFILLER_65_1231 VDD VSS sg13g2_decap_4
X_13054_ _13054_/Y _13123_/A2 _13052_/Y _13053_/Y VDD VSS sg13g2_a21oi_1
X_10266_ _14783_/D _10278_/C _13319_/A _10266_/C VDD VSS sg13g2_nor3_1
XFILLER_26_1226 VDD VSS sg13g2_decap_8
XFILLER_78_321 VDD VSS sg13g2_decap_8
X_12005_ _12006_/B _12301_/B1 _11989_/Y _12004_/Y VDD VSS sg13g2_o21ai_1
Xfanout1310 _09806_/A _15065_/Q VDD VSS sg13g2_buf_1
Xfanout1321 _09034_/S _09039_/B VDD VSS sg13g2_buf_1
XFILLER_87_74 VDD VSS sg13g2_decap_8
Xfanout1332 _13296_/A1 _15056_/Q VDD VSS sg13g2_buf_1
Xfanout1343 _08276_/B _14999_/Q VDD VSS sg13g2_buf_1
XFILLER_61_1139 VDD VSS sg13g2_decap_4
X_10197_ _15199_/D input27/X _15199_/Q _13340_/S VDD VSS sg13g2_mux2_1
Xfanout1354 _08621_/A _08560_/A VDD VSS sg13g2_buf_1
XFILLER_4_1000 VDD VSS sg13g2_decap_8
Xfanout1365 _08484_/B _13529_/A VDD VSS sg13g2_buf_1
Xfanout1376 _08686_/S1 _08337_/S1 VDD VSS sg13g2_buf_1
XFILLER_93_324 VDD VSS sg13g2_decap_8
XFILLER_16_7 VDD VSS sg13g2_decap_8
XFILLER_93_335 VDD VSS sg13g2_fill_2
XFILLER_120_495 VDD VSS sg13g2_decap_4
Xfanout1398 _08215_/S0 wire1401/A VDD VSS sg13g2_buf_1
XFILLER_4_1044 VDD VSS sg13g2_fill_2
XFILLER_4_1055 VDD VSS sg13g2_decap_8
XFILLER_93_368 VDD VSS sg13g2_decap_4
X_13956_ _13956_/Q clkload31/A _13956_/D _13956_/RESET_B VDD VSS sg13g2_dfrbpq_1
XFILLER_47_796 VDD VSS sg13g2_fill_2
X_12907_ _12909_/C _12943_/A _12925_/C VDD VSS sg13g2_nand2b_1
X_13887_ _13887_/Q clkload56/A _13887_/D _13887_/RESET_B VDD VSS sg13g2_dfrbpq_1
XFILLER_146_1027 VDD VSS sg13g2_decap_8
XFILLER_59_1079 VDD VSS sg13g2_fill_1
X_12838_ _12838_/Y _12838_/A _12808_/A VDD VSS sg13g2_nor2b_1
XFILLER_72_1202 VDD VSS sg13g2_fill_2
X_12769_ _12769_/X _14713_/Q _14745_/Q _13785_/Q _13817_/Q _12769_/S0 _12772_/S1 VDD
+ VSS sg13g2_mux4_1
X_14508_ _14508_/Q clkload58/A _14508_/D _14508_/RESET_B VDD VSS sg13g2_dfrbpq_1
XFILLER_147_337 VDD VSS sg13g2_decap_8
XFILLER_147_348 VDD VSS sg13g2_fill_1
Xinput20 input20/X input20/A VDD VSS sg13g2_buf_1
Xinput31 input31/X input31/A VDD VSS sg13g2_buf_1
X_14439_ _14439_/Q clkload10/A _14439_/D _14439_/RESET_B VDD VSS sg13g2_dfrbpq_1
XFILLER_156_871 VDD VSS sg13g2_fill_1
Xmax_cap501 fanout495/A _09274_/Y VDD VSS sg13g2_buf_2
Xmax_cap512 _09198_/S _09199_/S VDD VSS sg13g2_buf_4
XFILLER_7_881 VDD VSS sg13g2_fill_1
XFILLER_115_212 VDD VSS sg13g2_fill_2
XFILLER_128_595 VDD VSS sg13g2_decap_8
Xmax_cap545 _09146_/S _09038_/S VDD VSS sg13g2_buf_4
Xclkbuf_5_1__f_clk_i clkbuf_leaf_5_clk_i/A clkbuf_4_0_0_clk_i/X VDD VSS sg13g2_buf_16
X_09980_ _14563_/D _10146_/A1 _14563_/Q _10000_/S VDD VSS sg13g2_mux2_1
XFILLER_89_608 VDD VSS sg13g2_decap_8
XFILLER_143_565 VDD VSS sg13g2_decap_8
XFILLER_42_0 VDD VSS sg13g2_decap_8
Xmax_cap578 _11042_/D _11002_/A VDD VSS sg13g2_buf_2
X_08931_ _08931_/X _08930_/X _12084_/A _08940_/S VDD VSS sg13g2_mux2_1
XFILLER_130_248 VDD VSS sg13g2_decap_8
X_08862_ _08862_/X _15029_/Q _14933_/Q _08862_/S VDD VSS sg13g2_mux2_1
X_07813_ _07954_/B _08522_/A _08548_/B VDD VSS sg13g2_and2_1
X_08793_ _13682_/D _08790_/Y _08791_/Y _08792_/Y VDD VSS sg13g2_a21oi_1
XFILLER_123_28 VDD VSS sg13g2_decap_8
XFILLER_42_1061 VDD VSS sg13g2_decap_8
X_07744_ _07746_/C _07748_/B _07744_/B _07744_/C _07744_/D VDD VSS sg13g2_nand4_1
XFILLER_53_711 VDD VSS sg13g2_decap_4
XFILLER_77_1113 VDD VSS sg13g2_decap_8
XFILLER_77_1124 VDD VSS sg13g2_fill_1
X_14038__2526 _14038_/RESET_B VDD VSS sg13g2_tiehi
X_07675_ _07677_/C _15078_/Q _15081_/Q VDD VSS sg13g2_nor2_1
XFILLER_129_1203 VDD VSS sg13g2_fill_1
XFILLER_26_969 VDD VSS sg13g2_decap_8
X_09414_ _14016_/D _09447_/A0 _14016_/Q _09437_/S VDD VSS sg13g2_mux2_1
XFILLER_13_608 VDD VSS sg13g2_fill_1
X_09345_ _13949_/D _09609_/A0 _13949_/Q _09347_/S VDD VSS sg13g2_mux2_1
XFILLER_52_287 VDD VSS sg13g2_fill_2
XFILLER_32_14 VDD VSS sg13g2_decap_8
X_14832__3265 _14832_/RESET_B VDD VSS sg13g2_tiehi
X_09276_ _13884_/D _13884_/Q _10072_/A0 _09294_/S VDD VSS sg13g2_mux2_1
XFILLER_138_315 VDD VSS sg13g2_decap_8
XFILLER_148_14 VDD VSS sg13g2_decap_8
X_14253__2311 _14253_/RESET_B VDD VSS sg13g2_tiehi
X_08227_ _08227_/Y _07888_/B _14995_/Q _08247_/C VDD VSS sg13g2_a21oi_1
XFILLER_14_1141 VDD VSS sg13g2_decap_8
XFILLER_120_7 VDD VSS sg13g2_decap_8
XFILLER_119_551 VDD VSS sg13g2_decap_4
XFILLER_153_329 VDD VSS sg13g2_decap_8
X_08158_ _08158_/X _08005_/X _08019_/B _08018_/X _08031_/C _08363_/S0 _08199_/B VDD
+ VSS sg13g2_mux4_1
XFILLER_140_1193 VDD VSS sg13g2_decap_4
XFILLER_49_1204 VDD VSS sg13g2_fill_2
XFILLER_10_1038 VDD VSS sg13g2_decap_8
XFILLER_84_1106 VDD VSS sg13g2_fill_2
XFILLER_101_1166 VDD VSS sg13g2_decap_8
X_14865__3199 _14865_/RESET_B VDD VSS sg13g2_tiehi
XFILLER_101_1177 VDD VSS sg13g2_fill_2
X_08089_ _08090_/C _08023_/A _07903_/B _07884_/A _08023_/B VDD VSS sg13g2_a22oi_1
X_10120_ _14698_/D _10153_/A1 _14698_/Q _10134_/S VDD VSS sg13g2_mux2_1
XFILLER_106_278 VDD VSS sg13g2_decap_8
X_14286__2278 _14286_/RESET_B VDD VSS sg13g2_tiehi
Xhold3440 input9/A mem_axi_rdata[14] VDD VSS sg13g2_dlygate4sd3_1
XFILLER_0_534 VDD VSS sg13g2_decap_4
XFILLER_103_941 VDD VSS sg13g2_decap_8
Xhold3451 input13/A mem_axi_rdata[18] VDD VSS sg13g2_dlygate4sd3_1
X_10051_ _14632_/D _10084_/A0 _14632_/Q _10067_/S VDD VSS sg13g2_mux2_1
Xhold3462 input27/A mem_axi_rdata[30] VDD VSS sg13g2_dlygate4sd3_1
Xhold3473 _13627_/A _13735_/Q VDD VSS sg13g2_dlygate4sd3_1
XFILLER_48_516 VDD VSS sg13g2_decap_8
Xhold3484 _13635_/A _13743_/Q VDD VSS sg13g2_dlygate4sd3_1
Xhold3495 _13645_/A _13753_/Q VDD VSS sg13g2_dlygate4sd3_1
XFILLER_103_996 VDD VSS sg13g2_decap_8
XFILLER_48_538 VDD VSS sg13g2_decap_4
X_13810_ _13810_/Q _14738_/CLK _13810_/D _13810_/RESET_B VDD VSS sg13g2_dfrbpq_1
X_14790_ _14790_/Q clkload82/A _14790_/D _14790_/RESET_B VDD VSS sg13g2_dfrbpq_1
XFILLER_21_1145 VDD VSS sg13g2_decap_8
XFILLER_60_1194 VDD VSS sg13g2_fill_1
XFILLER_75_379 VDD VSS sg13g2_fill_2
XFILLER_44_711 VDD VSS sg13g2_decap_8
X_13741_ _13741_/Q _14669_/CLK _13741_/D _13741_/RESET_B VDD VSS sg13g2_dfrbpq_1
XFILLER_16_413 VDD VSS sg13g2_decap_8
XFILLER_84_891 VDD VSS sg13g2_fill_1
XFILLER_73_21 VDD VSS sg13g2_decap_4
X_10953_ _10953_/Y _10954_/C _10965_/C _11043_/A VDD VSS sg13g2_o21ai_1
XFILLER_90_349 VDD VSS sg13g2_decap_4
XFILLER_56_1208 VDD VSS sg13g2_decap_8
XFILLER_71_552 VDD VSS sg13g2_fill_1
X_13672_ _13672_/Q clkload64/A _13672_/D _13672_/RESET_B VDD VSS sg13g2_dfrbpq_1
X_10884_ _10884_/Y _10885_/A1 _10878_/Y _10797_/C VDD VSS sg13g2_o21ai_1
XFILLER_19_1030 VDD VSS sg13g2_decap_8
XFILLER_71_596 VDD VSS sg13g2_decap_8
X_12623_ _12623_/X _12622_/X _12621_/X _12790_/S VDD VSS sg13g2_mux2_1
X_12554_ _12555_/B _13679_/Q _12749_/A2 _12553_/X _12749_/B2 _12749_/C1 VDD VSS sg13g2_a221oi_1
XFILLER_12_674 VDD VSS sg13g2_decap_8
XFILLER_11_151 VDD VSS sg13g2_decap_4
XFILLER_106_1055 VDD VSS sg13g2_decap_8
XFILLER_40_994 VDD VSS sg13g2_decap_8
XFILLER_89_1006 VDD VSS sg13g2_decap_4
XFILLER_106_1066 VDD VSS sg13g2_fill_2
XFILLER_156_134 VDD VSS sg13g2_decap_4
XFILLER_12_696 VDD VSS sg13g2_decap_8
X_11505_ _11505_/X _11636_/A _11506_/B VDD VSS sg13g2_and2_1
X_13736__2828 _13736_/RESET_B VDD VSS sg13g2_tiehi
X_12485_ _14998_/D _12485_/A _12485_/B VDD VSS sg13g2_nor2_1
X_14224_ _14224_/Q clkload49/A _14224_/D _14224_/RESET_B VDD VSS sg13g2_dfrbpq_1
X_15127__3090 _15127_/RESET_B VDD VSS sg13g2_tiehi
X_11436_ _11436_/X _14368_/Q _14400_/Q _14464_/Q _14496_/Q _12100_/S0 _11598_/C VDD
+ VSS sg13g2_mux4_1
XFILLER_137_370 VDD VSS sg13g2_fill_2
XFILLER_137_392 VDD VSS sg13g2_decap_8
XFILLER_125_532 VDD VSS sg13g2_decap_8
XFILLER_125_543 VDD VSS sg13g2_fill_1
X_14155_ _14155_/Q _14667_/CLK _14155_/D _14155_/RESET_B VDD VSS sg13g2_dfrbpq_1
X_11367_ _11367_/Y _11362_/Y _11363_/Y _12317_/B VDD VSS sg13g2_a21oi_1
XFILLER_153_874 VDD VSS sg13g2_decap_8
XFILLER_125_565 VDD VSS sg13g2_decap_8
XFILLER_140_502 VDD VSS sg13g2_decap_8
X_13106_ _13106_/Y _14850_/Q _13150_/B VDD VSS sg13g2_nand2_1
X_10318_ _10319_/C _14798_/Q _14799_/Q _10327_/B _10327_/C VDD VSS sg13g2_and4_1
X_14116__2448 _14116_/RESET_B VDD VSS sg13g2_tiehi
XFILLER_3_361 VDD VSS sg13g2_decap_8
XFILLER_98_84 VDD VSS sg13g2_fill_1
X_13951__2613 _13951_/RESET_B VDD VSS sg13g2_tiehi
X_14086_ _14086_/Q clkload7/A _14086_/D _14086_/RESET_B VDD VSS sg13g2_dfrbpq_1
X_11298_ _11298_/Y _11300_/S0 _13917_/Q _11416_/B VDD VSS sg13g2_a21oi_1
XFILLER_26_1023 VDD VSS sg13g2_fill_1
X_13037_ _13037_/Y _14909_/Q _13678_/Q VDD VSS sg13g2_nor2_1
XFILLER_112_259 VDD VSS sg13g2_decap_8
X_10249_ _10251_/A _14778_/Q _10255_/D _10271_/B VDD VSS sg13g2_o21ai_1
XFILLER_65_1083 VDD VSS sg13g2_decap_8
XFILLER_6_1117 VDD VSS sg13g2_decap_8
Xfanout1140 _12368_/S1 _12351_/S1 VDD VSS sg13g2_buf_1
Xfanout1162 _12699_/S0 _12703_/S0 VDD VSS sg13g2_buf_1
XFILLER_113_1037 VDD VSS sg13g2_decap_8
Xfanout1173 _12529_/S0 _12480_/S0 VDD VSS sg13g2_buf_1
Xfanout1184 _12769_/S0 _12773_/S0 VDD VSS sg13g2_buf_1
Xfanout1195 _12659_/S0 _12661_/S0 VDD VSS sg13g2_buf_1
XFILLER_82_806 VDD VSS sg13g2_decap_8
X_14331__2233 _14331_/RESET_B VDD VSS sg13g2_tiehi
XFILLER_35_700 VDD VSS sg13g2_decap_8
X_14988_ _14988_/Q clkload61/A _14988_/D _14988_/RESET_B VDD VSS sg13g2_dfrbpq_1
XFILLER_19_284 VDD VSS sg13g2_fill_2
X_13939_ _13939_/Q clkload12/A _13939_/D _13939_/RESET_B VDD VSS sg13g2_dfrbpq_1
XFILLER_62_541 VDD VSS sg13g2_decap_4
XFILLER_62_563 VDD VSS sg13g2_decap_4
XFILLER_50_725 VDD VSS sg13g2_fill_1
XFILLER_34_287 VDD VSS sg13g2_fill_2
XFILLER_22_449 VDD VSS sg13g2_decap_8
XFILLER_148_613 VDD VSS sg13g2_fill_2
X_09130_ _09130_/Y _13199_/A _09157_/C _09129_/Y VDD VSS sg13g2_a21oi_1
XFILLER_31_983 VDD VSS sg13g2_fill_1
XFILLER_124_1144 VDD VSS sg13g2_decap_8
XFILLER_33_1038 VDD VSS sg13g2_fill_1
X_09061_ _09061_/Y _13064_/A _09089_/C _09162_/A VDD VSS sg13g2_o21ai_1
XFILLER_136_819 VDD VSS sg13g2_fill_1
X_08012_ _08012_/Y _08046_/B _08012_/B VDD VSS sg13g2_nand2_1
XFILLER_118_28 VDD VSS sg13g2_decap_8
Xmax_cap331 _09599_/S _09587_/S VDD VSS sg13g2_buf_4
XFILLER_1_309 VDD VSS sg13g2_decap_4
XFILLER_116_576 VDD VSS sg13g2_fill_2
X_09963_ _14547_/D _14547_/Q _09963_/A1 _09964_/S VDD VSS sg13g2_mux2_1
X_08914_ _08914_/Y _08912_/Y _08913_/Y _08925_/S VDD VSS sg13g2_a21oi_1
XFILLER_98_961 VDD VSS sg13g2_fill_1
XFILLER_44_1123 VDD VSS sg13g2_fill_2
X_09894_ _14480_/D _09927_/A1 _14480_/Q _09903_/S VDD VSS sg13g2_mux2_1
XFILLER_131_579 VDD VSS sg13g2_decap_4
XFILLER_134_49 VDD VSS sg13g2_decap_8
XFILLER_85_600 VDD VSS sg13g2_decap_8
XFILLER_44_1156 VDD VSS sg13g2_fill_2
XFILLER_98_994 VDD VSS sg13g2_fill_1
X_08845_ _08845_/Y _15024_/Q _10669_/S _08844_/Y VDD VSS sg13g2_a21oi_1
XFILLER_97_493 VDD VSS sg13g2_decap_8
XFILLER_27_14 VDD VSS sg13g2_decap_8
XFILLER_85_666 VDD VSS sg13g2_fill_1
X_08776_ _08776_/Y _08779_/A1 _15116_/Q _15185_/Q _07719_/X VDD VSS sg13g2_a22oi_1
XFILLER_73_839 VDD VSS sg13g2_decap_8
XFILLER_27_69 VDD VSS sg13g2_decap_8
X_07727_ _07727_/Y _13206_/B _13234_/B _12862_/B VDD VSS sg13g2_nor3_1
X_07658_ _07658_/X _14749_/Q wire954/X VDD VSS sg13g2_and2_1
XFILLER_53_563 VDD VSS sg13g2_fill_2
XFILLER_53_585 VDD VSS sg13g2_decap_8
XFILLER_43_35 VDD VSS sg13g2_decap_8
XFILLER_40_224 VDD VSS sg13g2_fill_2
XFILLER_129_1077 VDD VSS sg13g2_decap_8
XFILLER_40_246 VDD VSS sg13g2_fill_1
X_09328_ _13935_/D _09893_/A0 _13935_/Q _09333_/S VDD VSS sg13g2_mux2_1
XFILLER_139_624 VDD VSS sg13g2_fill_1
XFILLER_40_268 VDD VSS sg13g2_decap_8
XFILLER_138_123 VDD VSS sg13g2_decap_4
XFILLER_103_1228 VDD VSS sg13g2_decap_8
X_09259_ _13868_/D _13868_/Q _09923_/A1 _09264_/S VDD VSS sg13g2_mux2_1
XFILLER_138_167 VDD VSS sg13g2_decap_8
XFILLER_126_307 VDD VSS sg13g2_fill_1
XFILLER_126_318 VDD VSS sg13g2_decap_4
XFILLER_138_178 VDD VSS sg13g2_fill_2
X_12270_ _14986_/D _12270_/A _12270_/B VDD VSS sg13g2_nor2_1
XFILLER_153_126 VDD VSS sg13g2_decap_8
XFILLER_107_532 VDD VSS sg13g2_decap_4
X_11221_ _11222_/B _13723_/Q _14075_/Q _14427_/Q _14523_/Q _11277_/S _11282_/S1 VDD
+ VSS sg13g2_mux4_1
XFILLER_4_147 VDD VSS sg13g2_decap_4
XFILLER_107_576 VDD VSS sg13g2_decap_8
XFILLER_135_896 VDD VSS sg13g2_fill_1
XFILLER_107_587 VDD VSS sg13g2_decap_8
XFILLER_108_61 VDD VSS sg13g2_decap_8
XFILLER_122_513 VDD VSS sg13g2_decap_4
X_11152_ _11152_/Y _11164_/B _11152_/B VDD VSS sg13g2_xnor2_1
XFILLER_107_598 VDD VSS sg13g2_fill_1
XFILLER_150_844 VDD VSS sg13g2_decap_4
XFILLER_136_1026 VDD VSS sg13g2_decap_8
XFILLER_68_21 VDD VSS sg13g2_decap_4
XFILLER_1_843 VDD VSS sg13g2_fill_1
X_10103_ wire593/A _10105_/C _10105_/D wire765/X VDD VSS sg13g2_nand3_1
XFILLER_0_342 VDD VSS sg13g2_decap_4
X_11083_ _14947_/D _11082_/Y _11081_/Y _11074_/Y VDD VSS sg13g2_o21ai_1
XFILLER_88_460 VDD VSS sg13g2_decap_8
XFILLER_89_983 VDD VSS sg13g2_decap_8
XFILLER_68_98 VDD VSS sg13g2_fill_2
X_10034_ _14616_/D _10100_/A0 _14616_/Q wire603/X VDD VSS sg13g2_mux2_1
XFILLER_49_847 VDD VSS sg13g2_decap_4
X_14911_ _14911_/Q clkload61/A _14911_/D _14911_/RESET_B VDD VSS sg13g2_dfrbpq_1
XFILLER_49_869 VDD VSS sg13g2_fill_2
XFILLER_76_666 VDD VSS sg13g2_decap_4
X_14842_ _14842_/Q clkload82/A _14842_/D _14842_/RESET_B VDD VSS sg13g2_dfrbpq_1
XFILLER_5_1150 VDD VSS sg13g2_decap_8
XFILLER_76_677 VDD VSS sg13g2_decap_8
XFILLER_48_379 VDD VSS sg13g2_decap_8
XFILLER_84_42 VDD VSS sg13g2_fill_2
XFILLER_17_711 VDD VSS sg13g2_fill_1
XFILLER_17_733 VDD VSS sg13g2_decap_8
XFILLER_16_210 VDD VSS sg13g2_decap_8
X_11985_ _11988_/B _12055_/A _11917_/A _11986_/B VDD VSS sg13g2_o21ai_1
X_14773_ _14773_/Q _14776_/CLK _14773_/D _14773_/RESET_B VDD VSS sg13g2_dfrbpq_1
XFILLER_90_146 VDD VSS sg13g2_decap_4
XFILLER_1_1069 VDD VSS sg13g2_decap_8
X_15041__2928 _15041_/RESET_B VDD VSS sg13g2_tiehi
X_13724_ _13724_/Q clkload75/A _13724_/D _13724_/RESET_B VDD VSS sg13g2_dfrbpq_1
XFILLER_17_777 VDD VSS sg13g2_decap_8
X_10936_ _10965_/C _10936_/A _10936_/B _10936_/C _10936_/D VDD VSS sg13g2_nand4_1
XFILLER_17_91 VDD VSS sg13g2_decap_8
XFILLER_90_179 VDD VSS sg13g2_decap_8
X_14913__3103 _14913_/RESET_B VDD VSS sg13g2_tiehi
XFILLER_140_70 VDD VSS sg13g2_decap_8
XFILLER_95_1098 VDD VSS sg13g2_decap_8
XFILLER_32_747 VDD VSS sg13g2_decap_8
X_10867_ _10867_/Y _10890_/A _10868_/C _10890_/B VDD VSS sg13g2_o21ai_1
X_13655_ _15121_/D _15191_/D _15121_/Q _13655_/S VDD VSS sg13g2_mux2_1
XFILLER_20_909 VDD VSS sg13g2_decap_4
XFILLER_13_950 VDD VSS sg13g2_decap_8
X_12606_ _12606_/X _14253_/Q _14285_/Q _14317_/Q _14349_/Q _12657_/S0 _12659_/S1 VDD
+ VSS sg13g2_mux4_1
X_13586_ _13586_/Y _15002_/Q _13589_/A2 _13569_/S _15018_/Q _13537_/X VDD VSS sg13g2_a221oi_1
XFILLER_83_7 VDD VSS sg13g2_decap_8
X_10798_ _10798_/X _10807_/B _10798_/B VDD VSS sg13g2_xor2_1
XFILLER_129_123 VDD VSS sg13g2_decap_8
X_12537_ _12537_/X _12534_/X _12533_/X _12530_/X _12529_/X _12760_/S0 _12567_/S VDD
+ VSS sg13g2_mux4_1
X_14946__3037 _14946_/RESET_B VDD VSS sg13g2_tiehi
XFILLER_8_453 VDD VSS sg13g2_decap_8
X_12468_ _12468_/X _12466_/X _12465_/X _12462_/X _12461_/X _12746_/S1 _12748_/S VDD
+ VSS sg13g2_mux4_1
XFILLER_8_497 VDD VSS sg13g2_decap_8
X_14207_ _14207_/Q clkload56/A _14207_/D _14207_/RESET_B VDD VSS sg13g2_dfrbpq_1
X_11419_ _11420_/B _11419_/A _11419_/B _11419_/C VDD VSS sg13g2_nand3_1
X_14349__2215 _14349_/RESET_B VDD VSS sg13g2_tiehi
X_15187_ _15187_/Q clkload65/A _15187_/D _15187_/RESET_B VDD VSS sg13g2_dfrbpq_1
X_12399_ _12400_/B _12397_/X _12398_/X _12790_/S VDD VSS sg13g2_mux2_1
XFILLER_125_351 VDD VSS sg13g2_decap_8
XFILLER_126_874 VDD VSS sg13g2_decap_8
XFILLER_113_513 VDD VSS sg13g2_fill_1
X_14138_ _14138_/Q clkload57/A _14138_/D _14138_/RESET_B VDD VSS sg13g2_dfrbpq_1
XFILLER_119_1235 VDD VSS sg13g2_fill_2
XFILLER_152_181 VDD VSS sg13g2_decap_8
XFILLER_28_1129 VDD VSS sg13g2_decap_8
XFILLER_113_546 VDD VSS sg13g2_fill_2
XFILLER_154_1148 VDD VSS sg13g2_decap_8
XFILLER_86_408 VDD VSS sg13g2_fill_2
X_14069_ _14069_/Q clkload15/A _14069_/D _14069_/RESET_B VDD VSS sg13g2_dfrbpq_1
X_14564__2000 _14564_/RESET_B VDD VSS sg13g2_tiehi
XFILLER_121_590 VDD VSS sg13g2_decap_8
X_08630_ _08630_/Y _08612_/S _08629_/Y _08628_/Y VDD VSS sg13g2_o21ai_1
XFILLER_67_666 VDD VSS sg13g2_decap_8
XFILLER_55_828 VDD VSS sg13g2_decap_4
XFILLER_54_327 VDD VSS sg13g2_decap_8
XFILLER_81_113 VDD VSS sg13g2_decap_4
X_08561_ _08561_/Y _13533_/A _08659_/B _08561_/C VDD VSS sg13g2_nor3_1
XFILLER_35_530 VDD VSS sg13g2_decap_8
XFILLER_81_135 VDD VSS sg13g2_decap_4
XFILLER_82_669 VDD VSS sg13g2_decap_8
XFILLER_35_541 VDD VSS sg13g2_fill_2
XFILLER_63_872 VDD VSS sg13g2_decap_8
XFILLER_74_1105 VDD VSS sg13g2_fill_2
XFILLER_81_168 VDD VSS sg13g2_fill_1
XFILLER_39_1236 VDD VSS sg13g2_fill_1
X_08492_ _08574_/C _07950_/A _07949_/B _07807_/C _08476_/A VDD VSS sg13g2_a22oi_1
XFILLER_81_179 VDD VSS sg13g2_decap_8
XFILLER_35_574 VDD VSS sg13g2_decap_4
XFILLER_50_500 VDD VSS sg13g2_decap_4
XFILLER_23_725 VDD VSS sg13g2_decap_8
XFILLER_22_213 VDD VSS sg13g2_decap_8
XFILLER_74_1138 VDD VSS sg13g2_fill_2
XFILLER_50_588 VDD VSS sg13g2_decap_8
X_09113_ _09113_/Y _15242_/Q _09161_/S VDD VSS sg13g2_nand2b_1
XFILLER_13_49 VDD VSS sg13g2_decap_8
X_09044_ _09044_/X _09044_/A _09044_/B _09056_/C VDD VSS sg13g2_or3_1
XFILLER_135_137 VDD VSS sg13g2_decap_8
XFILLER_11_1133 VDD VSS sg13g2_decap_8
XFILLER_50_1182 VDD VSS sg13g2_decap_8
XFILLER_132_822 VDD VSS sg13g2_fill_1
XFILLER_89_213 VDD VSS sg13g2_decap_8
XFILLER_143_170 VDD VSS sg13g2_decap_8
XFILLER_143_181 VDD VSS sg13g2_fill_2
XFILLER_81_1109 VDD VSS sg13g2_fill_2
XFILLER_104_546 VDD VSS sg13g2_fill_1
Xfanout900 _08453_/B1 _08689_/B1 VDD VSS sg13g2_buf_1
Xfanout922 _13248_/B _07727_/Y VDD VSS sg13g2_buf_1
X_09946_ _14530_/D _14530_/Q _10078_/A0 _09967_/S VDD VSS sg13g2_mux2_1
Xfanout933 _10939_/B1 _07753_/B VDD VSS sg13g2_buf_1
XFILLER_58_611 VDD VSS sg13g2_decap_8
Xfanout944 _12294_/B1 _07683_/X VDD VSS sg13g2_buf_1
XFILLER_86_931 VDD VSS sg13g2_decap_8
XFILLER_38_35 VDD VSS sg13g2_decap_8
Xfanout966 _11615_/B _11928_/S0 VDD VSS sg13g2_buf_1
X_09877_ _14463_/D _09877_/A0 _14463_/Q _09877_/S VDD VSS sg13g2_mux2_1
Xfanout988 _12233_/B fanout992/X VDD VSS sg13g2_buf_1
XFILLER_58_666 VDD VSS sg13g2_decap_8
Xfanout999 _11192_/B1 _11207_/A2 VDD VSS sg13g2_buf_1
XFILLER_86_975 VDD VSS sg13g2_decap_8
XFILLER_86_986 VDD VSS sg13g2_fill_1
X_08828_ _08828_/Y _10177_/B _13266_/A VDD VSS sg13g2_nor2_1
XFILLER_45_327 VDD VSS sg13g2_fill_1
XFILLER_45_338 VDD VSS sg13g2_decap_8
X_08759_ _13671_/D _08765_/A1 _08757_/Y _08758_/Y VDD VSS sg13g2_a21oi_1
X_11770_ _11910_/A _11770_/A _13064_/B VDD VSS sg13g2_xnor2_1
XFILLER_60_319 VDD VSS sg13g2_decap_8
XFILLER_72_179 VDD VSS sg13g2_decap_8
XFILLER_41_511 VDD VSS sg13g2_fill_2
X_14427__2137 _14427_/RESET_B VDD VSS sg13g2_tiehi
X_10721_ _10965_/B _14939_/Q _08862_/S _10720_/Y VDD VSS sg13g2_a21oi_1
XFILLER_16_1000 VDD VSS sg13g2_decap_8
XFILLER_41_566 VDD VSS sg13g2_fill_1
X_13440_ _13440_/Y _13440_/A _13440_/B _15102_/Q VDD VSS sg13g2_nand3_1
X_10652_ _10653_/D _10652_/A _10652_/B _10652_/C _10652_/D VDD VSS sg13g2_nor4_1
XFILLER_16_1055 VDD VSS sg13g2_decap_8
XFILLER_155_903 VDD VSS sg13g2_decap_8
X_13371_ _15076_/D _13374_/A1 _13442_/A _13369_/Y VDD VSS sg13g2_o21ai_1
XFILLER_103_1014 VDD VSS sg13g2_decap_8
X_10583_ _10594_/D _14872_/Q _14871_/Q _10591_/C _10583_/D VDD VSS sg13g2_and4_1
XFILLER_139_476 VDD VSS sg13g2_decap_8
XFILLER_70_88 VDD VSS sg13g2_decap_8
XFILLER_70_99 VDD VSS sg13g2_fill_1
X_12322_ _12322_/Y _12318_/Y _12319_/Y _12321_/Y _12320_/Y _12324_/B VDD VSS sg13g2_a221oi_1
X_15110_ _15110_/Q _15178_/CLK _15110_/D _15110_/RESET_B VDD VSS sg13g2_dfrbpq_1
XFILLER_154_424 VDD VSS sg13g2_decap_8
XFILLER_139_498 VDD VSS sg13g2_decap_8
XFILLER_10_986 VDD VSS sg13g2_decap_8
XFILLER_6_968 VDD VSS sg13g2_decap_8
X_15041_ _15041_/Q clkload64/A _15041_/D _15041_/RESET_B VDD VSS sg13g2_dfrbpq_1
X_12253_ _12253_/X _12253_/A _12253_/B VDD VSS sg13g2_and2_1
X_11204_ _11204_/Y _11203_/Y _11201_/A _11201_/Y _11202_/Y _11151_/A VDD VSS sg13g2_a221oi_1
X_12184_ _12188_/A _12183_/X _12233_/B VDD VSS sg13g2_nand2b_1
X_11135_ _11136_/B _11172_/A _11147_/A _11128_/Y VDD VSS sg13g2_o21ai_1
XFILLER_96_717 VDD VSS sg13g2_decap_4
XFILLER_96_728 VDD VSS sg13g2_decap_8
X_15190__3170 _15190_/RESET_B VDD VSS sg13g2_tiehi
XFILLER_7_1201 VDD VSS sg13g2_decap_8
X_14033__2531 _14033_/RESET_B VDD VSS sg13g2_tiehi
XFILLER_150_685 VDD VSS sg13g2_fill_1
XFILLER_135_70 VDD VSS sg13g2_decap_8
XFILLER_0_150 VDD VSS sg13g2_decap_4
XFILLER_49_622 VDD VSS sg13g2_fill_1
XFILLER_114_1110 VDD VSS sg13g2_fill_2
XFILLER_153_1170 VDD VSS sg13g2_decap_8
XFILLER_27_1173 VDD VSS sg13g2_decap_8
XFILLER_1_695 VDD VSS sg13g2_decap_8
X_11066_ _11066_/Y _11118_/A _11088_/A _11191_/A VDD VSS sg13g2_o21ai_1
XFILLER_95_52 VDD VSS sg13g2_fill_2
X_10017_ _14599_/D _10017_/A0 _14599_/Q _10017_/S VDD VSS sg13g2_mux2_1
XFILLER_114_1154 VDD VSS sg13g2_decap_8
X_14637__1927 _14637_/RESET_B VDD VSS sg13g2_tiehi
XFILLER_48_165 VDD VSS sg13g2_decap_4
XFILLER_64_625 VDD VSS sg13g2_decap_8
XFILLER_76_485 VDD VSS sg13g2_fill_1
XFILLER_92_934 VDD VSS sg13g2_fill_2
XFILLER_36_327 VDD VSS sg13g2_decap_8
XFILLER_91_422 VDD VSS sg13g2_decap_8
XFILLER_97_1138 VDD VSS sg13g2_decap_8
XFILLER_36_338 VDD VSS sg13g2_fill_2
X_14825_ _14825_/Q clkload79/A _14825_/D _14825_/RESET_B VDD VSS sg13g2_dfrbpq_1
XFILLER_149_1228 VDD VSS sg13g2_decap_8
XFILLER_151_91 VDD VSS sg13g2_decap_8
XFILLER_45_872 VDD VSS sg13g2_fill_1
X_14066__2498 _14066_/RESET_B VDD VSS sg13g2_tiehi
X_14756_ _14756_/Q clkload63/A _14756_/D _14756_/RESET_B VDD VSS sg13g2_dfrbpq_1
X_11968_ _11970_/A _11969_/A _13904_/Q VDD VSS sg13g2_nand2b_1
XFILLER_17_585 VDD VSS sg13g2_fill_2
XFILLER_72_680 VDD VSS sg13g2_fill_1
XFILLER_72_691 VDD VSS sg13g2_decap_8
XFILLER_60_842 VDD VSS sg13g2_fill_2
X_13707_ _13707_/Q _14916_/CLK _13707_/D _13707_/RESET_B VDD VSS sg13g2_dfrbpq_1
X_10919_ _10920_/B _10904_/B _10945_/B _10945_/A VDD VSS sg13g2_a21oi_1
X_14687_ _14687_/Q clkload56/A _14687_/D _14687_/RESET_B VDD VSS sg13g2_dfrbpq_1
X_11899_ _11900_/A _13966_/Q _13998_/Q _14030_/Q _14062_/Q _11896_/A _11897_/C VDD
+ VSS sg13g2_mux4_1
XFILLER_34_1100 VDD VSS sg13g2_decap_4
XFILLER_149_229 VDD VSS sg13g2_fill_2
XFILLER_32_577 VDD VSS sg13g2_decap_8
X_15153__3036 _15153_/RESET_B VDD VSS sg13g2_tiehi
X_13638_ _13746_/D _13638_/A VDD VSS sg13g2_buf_1
X_15005__2967 _15005_/RESET_B VDD VSS sg13g2_tiehi
XFILLER_146_903 VDD VSS sg13g2_decap_8
X_14281__2283 _14281_/RESET_B VDD VSS sg13g2_tiehi
X_13569_ _13569_/X _13545_/A _15012_/Q _13569_/S VDD VSS sg13g2_mux2_1
XFILLER_117_104 VDD VSS sg13g2_decap_8
XFILLER_34_1199 VDD VSS sg13g2_decap_8
XFILLER_9_795 VDD VSS sg13g2_decap_8
XFILLER_117_115 VDD VSS sg13g2_decap_8
X_15239_ _15239_/Q clkload68/A _15239_/D _15239_/RESET_B VDD VSS sg13g2_dfrbpq_1
XFILLER_119_1010 VDD VSS sg13g2_decap_8
XFILLER_119_1021 VDD VSS sg13g2_fill_2
XFILLER_114_855 VDD VSS sg13g2_decap_4
XFILLER_119_1043 VDD VSS sg13g2_decap_8
X_09800_ _14389_/D _09899_/A0 _14389_/Q _09805_/S VDD VSS sg13g2_mux2_1
XFILLER_114_877 VDD VSS sg13g2_decap_8
Xfanout218 _09562_/A0 _09696_/A0 VDD VSS sg13g2_buf_1
Xfanout229 _10089_/A0 _10123_/A0 VDD VSS sg13g2_buf_1
X_07992_ _15250_/D _13499_/A _07991_/A _07988_/Y VDD VSS sg13g2_a21oi_1
XFILLER_114_899 VDD VSS sg13g2_decap_8
X_14505__2059 _14505_/RESET_B VDD VSS sg13g2_tiehi
X_09731_ _14322_/D _09830_/A0 _14322_/Q _09739_/S VDD VSS sg13g2_mux2_1
Xclkbuf_4_14_0_clk_i clkbuf_4_14_0_clk_i/X clkbuf_0_clk_i/X VDD VSS sg13g2_buf_8
XFILLER_41_1148 VDD VSS sg13g2_decap_8
X_09662_ _14255_/D _09893_/A0 _14255_/Q wire641/X VDD VSS sg13g2_mux2_1
XFILLER_82_411 VDD VSS sg13g2_decap_8
X_08613_ _08613_/Y _08641_/B _08612_/X _08395_/A VDD VSS sg13g2_a21oi_1
XFILLER_83_945 VDD VSS sg13g2_fill_1
XFILLER_94_282 VDD VSS sg13g2_fill_2
X_09593_ _14190_/D _14190_/Q _10157_/A1 _09593_/S VDD VSS sg13g2_mux2_1
XFILLER_55_658 VDD VSS sg13g2_decap_8
XFILLER_131_28 VDD VSS sg13g2_decap_8
XFILLER_82_444 VDD VSS sg13g2_decap_8
XFILLER_39_1000 VDD VSS sg13g2_fill_2
XFILLER_54_168 VDD VSS sg13g2_decap_4
X_08544_ _08545_/D _08544_/A _08544_/B _08544_/C VDD VSS sg13g2_nand3_1
X_13731__2833 _13731_/RESET_B VDD VSS sg13g2_tiehi
XFILLER_35_371 VDD VSS sg13g2_decap_8
XFILLER_23_522 VDD VSS sg13g2_decap_8
XFILLER_126_1003 VDD VSS sg13g2_decap_8
X_08475_ _08475_/Y _08475_/A _08475_/B _08475_/C _08475_/D VDD VSS sg13g2_nor4_1
XFILLER_62_190 VDD VSS sg13g2_decap_8
XFILLER_50_341 VDD VSS sg13g2_decap_4
X_14111__2453 _14111_/RESET_B VDD VSS sg13g2_tiehi
XFILLER_40_14 VDD VSS sg13g2_decap_8
XFILLER_156_14 VDD VSS sg13g2_decap_8
XFILLER_136_446 VDD VSS sg13g2_fill_1
XFILLER_152_906 VDD VSS sg13g2_decap_8
X_09027_ _09027_/X _15032_/Q _15229_/Q _09039_/B VDD VSS sg13g2_mux2_1
XFILLER_156_58 VDD VSS sg13g2_fill_1
X_14715__1849 _14715_/RESET_B VDD VSS sg13g2_tiehi
XFILLER_2_404 VDD VSS sg13g2_decap_8
XFILLER_151_438 VDD VSS sg13g2_fill_2
Xpicorv32_macro_1802 mem_axi_arprot[1] VDD VSS sg13g2_tielo
XFILLER_116_181 VDD VSS sg13g2_fill_2
XFILLER_46_1037 VDD VSS sg13g2_fill_2
Xfanout1706 _12235_/A fanout1753/X VDD VSS sg13g2_buf_1
XFILLER_46_1059 VDD VSS sg13g2_decap_8
X_14930__3069 _14930_/RESET_B VDD VSS sg13g2_tiehi
Xfanout1717 _11969_/A fanout1721/X VDD VSS sg13g2_buf_1
XFILLER_120_836 VDD VSS sg13g2_fill_2
Xfanout1728 _11826_/A1 _11828_/S0 VDD VSS sg13g2_buf_1
XFILLER_104_387 VDD VSS sg13g2_fill_1
Xfanout1739 _11890_/S0 _12306_/A VDD VSS sg13g2_buf_1
X_09929_ _14514_/D _14514_/Q _09929_/A1 _09936_/S VDD VSS sg13g2_mux2_1
XFILLER_86_750 VDD VSS sg13g2_fill_1
Xfanout774 _09741_/A1 _09574_/A1 VDD VSS sg13g2_buf_1
Xfanout785 _08835_/A fanout785/A VDD VSS sg13g2_buf_1
Xfanout796 _08452_/B _08544_/B VDD VSS sg13g2_buf_1
X_12940_ _12941_/B _07682_/A _12939_/Y _12928_/X _13271_/C wire567/X VDD VSS sg13g2_a221oi_1
XFILLER_85_260 VDD VSS sg13g2_fill_2
XFILLER_46_625 VDD VSS sg13g2_decap_8
XFILLER_58_496 VDD VSS sg13g2_fill_1
XFILLER_85_282 VDD VSS sg13g2_fill_2
X_12871_ _15025_/D _13306_/A _12871_/B VDD VSS sg13g2_nor2_1
XFILLER_2_1164 VDD VSS sg13g2_decap_8
XFILLER_45_168 VDD VSS sg13g2_decap_8
XFILLER_73_477 VDD VSS sg13g2_decap_4
X_14610_ _14610_/Q _14706_/CLK _14610_/D _14610_/RESET_B VDD VSS sg13g2_dfrbpq_1
X_11822_ _11822_/X _11822_/A _11822_/B VDD VSS sg13g2_and2_1
XFILLER_92_1002 VDD VSS sg13g2_fill_1
Xclkbuf_5_29__f_clk_i clkbuf_leaf_66_clk_i/A clkbuf_4_14_0_clk_i/X VDD VSS sg13g2_buf_16
XFILLER_54_680 VDD VSS sg13g2_fill_2
XFILLER_121_61 VDD VSS sg13g2_decap_8
X_14541_ _14541_/Q _14669_/CLK _14541_/D _14541_/RESET_B VDD VSS sg13g2_dfrbpq_1
XFILLER_26_393 VDD VSS sg13g2_decap_8
X_11753_ _11754_/A _14250_/Q _14282_/Q _14314_/Q _14346_/Q _11759_/A _11760_/C VDD
+ VSS sg13g2_mux4_1
XFILLER_81_21 VDD VSS sg13g2_decap_8
XFILLER_41_330 VDD VSS sg13g2_decap_4
XFILLER_18_1128 VDD VSS sg13g2_decap_8
XFILLER_53_1019 VDD VSS sg13g2_decap_8
X_10704_ _10923_/B _09021_/X _10694_/S _08869_/Y VDD VSS sg13g2_a21oi_1
X_14472_ _14472_/Q clkload30/A _14472_/D _14472_/RESET_B VDD VSS sg13g2_dfrbpq_1
X_11684_ _11684_/Y _11686_/S0 _14504_/Q _11690_/B VDD VSS sg13g2_a21oi_1
XFILLER_42_897 VDD VSS sg13g2_decap_4
X_10635_ _10636_/B _14886_/Q _14885_/Q _14884_/Q _14883_/Q VDD VSS sg13g2_nand4_1
XFILLER_14_70 VDD VSS sg13g2_decap_8
X_13423_ _13423_/Y _13427_/A _13440_/B _13423_/C VDD VSS sg13g2_nand3_1
XFILLER_127_402 VDD VSS sg13g2_fill_2
XFILLER_128_947 VDD VSS sg13g2_fill_2
XFILLER_154_210 VDD VSS sg13g2_decap_8
X_13354_ _13364_/B _13401_/C _13401_/B VDD VSS sg13g2_nor2_1
XFILLER_139_295 VDD VSS sg13g2_decap_8
X_10566_ _10567_/D _14868_/Q _14867_/Q _14866_/Q _14862_/Q VDD VSS sg13g2_nand4_1
Xmax_cap1058 _12581_/S _12678_/S VDD VSS sg13g2_buf_4
XFILLER_143_917 VDD VSS sg13g2_decap_8
Xmax_cap1069 _12706_/S _12483_/S VDD VSS sg13g2_buf_4
X_12305_ _12307_/A _12306_/A _14202_/Q VDD VSS sg13g2_nand2b_1
XFILLER_142_405 VDD VSS sg13g2_decap_8
X_13285_ _13287_/C _13481_/A _07744_/D _13284_/Y VDD VSS sg13g2_a21oi_1
X_10497_ _10499_/A _14853_/Q _10497_/B VDD VSS sg13g2_nand2b_1
XFILLER_5_264 VDD VSS sg13g2_decap_4
XFILLER_120_1180 VDD VSS sg13g2_fill_1
XFILLER_154_287 VDD VSS sg13g2_decap_8
XFILLER_136_991 VDD VSS sg13g2_decap_8
X_12236_ _12237_/B _12236_/A _12236_/B _12236_/C VDD VSS sg13g2_nand3_1
X_15024_ _15024_/Q _15200_/CLK _15024_/D _15024_/RESET_B VDD VSS sg13g2_dfrbpq_1
XFILLER_46_7 VDD VSS sg13g2_decap_8
XFILLER_29_1235 VDD VSS sg13g2_fill_2
XFILLER_123_641 VDD VSS sg13g2_fill_2
X_12167_ _12169_/A _12168_/A _14646_/Q VDD VSS sg13g2_nand2b_1
XFILLER_111_825 VDD VSS sg13g2_fill_2
XFILLER_64_1159 VDD VSS sg13g2_fill_2
XFILLER_96_525 VDD VSS sg13g2_fill_1
XFILLER_123_685 VDD VSS sg13g2_decap_8
XFILLER_111_836 VDD VSS sg13g2_fill_2
X_11118_ _11119_/B _11118_/A _11118_/B _11118_/C _11118_/D VDD VSS sg13g2_nand4_1
XFILLER_111_847 VDD VSS sg13g2_fill_1
X_12098_ _12098_/Y _12098_/A1 _14676_/Q _12088_/B VDD VSS sg13g2_a21oi_1
XFILLER_110_357 VDD VSS sg13g2_fill_2
X_11049_ _11064_/D _11185_/A wire577/X VDD VSS sg13g2_xnor2_1
XFILLER_7_1075 VDD VSS sg13g2_decap_8
Xinput7 input7/X input7/A VDD VSS sg13g2_buf_1
XFILLER_77_794 VDD VSS sg13g2_decap_8
XFILLER_36_113 VDD VSS sg13g2_decap_8
XFILLER_149_1003 VDD VSS sg13g2_fill_1
XFILLER_36_124 VDD VSS sg13g2_fill_2
XFILLER_76_293 VDD VSS sg13g2_decap_8
X_14299__2265 _14299_/RESET_B VDD VSS sg13g2_tiehi
XFILLER_65_978 VDD VSS sg13g2_decap_4
XFILLER_92_764 VDD VSS sg13g2_fill_2
XFILLER_36_157 VDD VSS sg13g2_decap_8
X_14808_ _14808_/Q clkload81/A _14808_/D _14808_/RESET_B VDD VSS sg13g2_dfrbpq_1
XFILLER_64_477 VDD VSS sg13g2_decap_4
XFILLER_51_105 VDD VSS sg13g2_decap_8
XFILLER_52_628 VDD VSS sg13g2_decap_8
XFILLER_75_1211 VDD VSS sg13g2_decap_8
XFILLER_51_149 VDD VSS sg13g2_fill_2
X_14739_ _14739_/Q clkload13/A _14739_/D _14739_/RESET_B VDD VSS sg13g2_dfrbpq_1
XFILLER_32_341 VDD VSS sg13g2_decap_8
X_08260_ _08260_/Y _08318_/B _08565_/A2 _08259_/Y VDD VSS sg13g2_a21oi_1
XFILLER_33_897 VDD VSS sg13g2_decap_8
XFILLER_32_374 VDD VSS sg13g2_decap_8
XFILLER_60_683 VDD VSS sg13g2_decap_8
X_08191_ _08191_/Y _07922_/Y _08229_/B _08190_/Y VDD VSS sg13g2_a21oi_1
XFILLER_119_914 VDD VSS sg13g2_decap_8
XFILLER_72_0 VDD VSS sg13g2_decap_8
XFILLER_118_435 VDD VSS sg13g2_fill_2
XFILLER_145_221 VDD VSS sg13g2_fill_2
Xmax_cap1570 _16855_/A _13693_/Q VDD VSS sg13g2_buf_4
XFILLER_10_28 VDD VSS sg13g2_decap_8
XFILLER_145_298 VDD VSS sg13g2_decap_8
XFILLER_126_28 VDD VSS sg13g2_decap_4
XFILLER_142_961 VDD VSS sg13g2_fill_1
XFILLER_99_341 VDD VSS sg13g2_decap_4
XFILLER_82_1226 VDD VSS sg13g2_decap_8
X_13749__2815 _13749_/RESET_B VDD VSS sg13g2_tiehi
XFILLER_142_994 VDD VSS sg13g2_fill_1
X_07975_ _07979_/A _07976_/A _07976_/B _07976_/C VDD VSS sg13g2_nor3_1
XFILLER_45_1070 VDD VSS sg13g2_decap_4
X_09714_ _14305_/D _09747_/A1 _14305_/Q wire449/A VDD VSS sg13g2_mux2_1
XFILLER_68_772 VDD VSS sg13g2_decap_8
XFILLER_56_923 VDD VSS sg13g2_decap_8
XFILLER_142_49 VDD VSS sg13g2_decap_8
XFILLER_132_1062 VDD VSS sg13g2_decap_8
XFILLER_83_742 VDD VSS sg13g2_fill_2
X_14129__2435 _14129_/RESET_B VDD VSS sg13g2_tiehi
X_09645_ _14238_/D _09744_/A1 _14238_/Q _09661_/S VDD VSS sg13g2_mux2_1
X_13964__2600 _13964_/RESET_B VDD VSS sg13g2_tiehi
XFILLER_35_14 VDD VSS sg13g2_decap_8
XFILLER_43_606 VDD VSS sg13g2_fill_2
XFILLER_71_915 VDD VSS sg13g2_decap_8
XFILLER_83_775 VDD VSS sg13g2_fill_1
XFILLER_35_25 VDD VSS sg13g2_fill_1
X_09576_ _14173_/D _14173_/Q _09609_/A0 _09578_/S VDD VSS sg13g2_mux2_1
XFILLER_55_488 VDD VSS sg13g2_fill_1
XFILLER_24_842 VDD VSS sg13g2_decap_4
X_08527_ _08566_/C _08527_/A _08527_/B VDD VSS sg13g2_nand2_1
XFILLER_150_7 VDD VSS sg13g2_decap_8
XFILLER_23_352 VDD VSS sg13g2_decap_8
XFILLER_51_661 VDD VSS sg13g2_decap_8
XFILLER_24_897 VDD VSS sg13g2_decap_8
X_08458_ _08458_/X _08362_/X _08457_/X _08597_/B VDD VSS sg13g2_mux2_1
X_14344__2220 _14344_/RESET_B VDD VSS sg13g2_tiehi
X_13997__2567 _13997_/RESET_B VDD VSS sg13g2_tiehi
XFILLER_91_1090 VDD VSS sg13g2_fill_1
X_08389_ _08394_/B _08415_/A _08389_/B VDD VSS sg13g2_nor2_1
XFILLER_17_1183 VDD VSS sg13g2_decap_8
Xwire438 wire438/X wire438/A VDD VSS sg13g2_buf_1
Xwire449 wire449/X wire449/A VDD VSS sg13g2_buf_4
XFILLER_52_1074 VDD VSS sg13g2_decap_8
X_10420_ _14829_/D _10420_/A _10421_/B _13363_/B VDD VSS sg13g2_and3_1
XFILLER_136_221 VDD VSS sg13g2_decap_4
XFILLER_136_243 VDD VSS sg13g2_decap_8
XFILLER_125_906 VDD VSS sg13g2_decap_8
XFILLER_13_1069 VDD VSS sg13g2_decap_8
X_10351_ _10353_/A _14809_/Q _10352_/C _14810_/Q VDD VSS sg13g2_a21o_1
XFILLER_139_1227 VDD VSS sg13g2_decap_8
X_13070_ _13070_/Y _14783_/Q _13123_/A2 _13123_/B1 VDD VSS sg13g2_o21ai_1
X_14377__2187 _14377_/RESET_B VDD VSS sg13g2_tiehi
XFILLER_2_212 VDD VSS sg13g2_decap_8
X_10282_ _14788_/D _10282_/A _10281_/Y VDD VSS sg13g2_nor2b_1
X_12021_ _12021_/Y _12021_/A _12036_/B VDD VSS sg13g2_nand2_1
XFILLER_78_503 VDD VSS sg13g2_decap_8
XFILLER_133_983 VDD VSS sg13g2_decap_8
XFILLER_78_514 VDD VSS sg13g2_fill_2
XFILLER_120_600 VDD VSS sg13g2_decap_8
Xfanout1503 _13601_/A _14957_/Q VDD VSS sg13g2_buf_1
XFILLER_2_289 VDD VSS sg13g2_decap_8
Xfanout1514 _12957_/A _14904_/Q VDD VSS sg13g2_buf_1
Xfanout1525 _10558_/B _14858_/Q VDD VSS sg13g2_buf_1
XFILLER_76_21 VDD VSS sg13g2_decap_8
Xfanout1536 _11086_/A _10206_/A1 VDD VSS sg13g2_buf_1
XFILLER_59_761 VDD VSS sg13g2_decap_8
XFILLER_47_912 VDD VSS sg13g2_fill_2
Xfanout571 _12415_/A _12429_/B2 VDD VSS sg13g2_buf_1
XFILLER_76_65 VDD VSS sg13g2_decap_8
XFILLER_98_1200 VDD VSS sg13g2_decap_8
XFILLER_150_1151 VDD VSS sg13g2_fill_2
X_13972_ _13972_/Q clkload16/A _13972_/D _13972_/RESET_B VDD VSS sg13g2_dfrbpq_1
XFILLER_120_699 VDD VSS sg13g2_decap_8
XFILLER_46_411 VDD VSS sg13g2_fill_1
XFILLER_93_539 VDD VSS sg13g2_decap_8
XFILLER_24_1176 VDD VSS sg13g2_decap_8
XFILLER_18_113 VDD VSS sg13g2_fill_1
XFILLER_18_124 VDD VSS sg13g2_decap_8
X_12923_ _12988_/A _14902_/Q _13685_/Q VDD VSS sg13g2_xnor2_1
XFILLER_74_742 VDD VSS sg13g2_decap_8
XFILLER_46_444 VDD VSS sg13g2_decap_4
X_14874__3181 _14874_/RESET_B VDD VSS sg13g2_tiehi
XFILLER_19_669 VDD VSS sg13g2_decap_8
XFILLER_47_989 VDD VSS sg13g2_fill_1
XFILLER_111_1179 VDD VSS sg13g2_decap_8
XFILLER_73_274 VDD VSS sg13g2_decap_8
X_12854_ _12854_/Y _12851_/Y _12852_/Y _12853_/Y VDD VSS sg13g2_a21oi_1
XFILLER_62_959 VDD VSS sg13g2_fill_1
XFILLER_61_447 VDD VSS sg13g2_fill_2
X_11805_ _11806_/B _11805_/A _11805_/B _11805_/C VDD VSS sg13g2_nand3_1
XFILLER_26_190 VDD VSS sg13g2_decap_8
X_12785_ _12785_/X _13754_/Q _14106_/Q _14458_/Q _14554_/Q _12785_/S0 _12785_/S1 VDD
+ VSS sg13g2_mux4_1
X_14524_ _14524_/Q _14670_/CLK _14524_/D _14524_/RESET_B VDD VSS sg13g2_dfrbpq_1
X_11736_ _11736_/X _11736_/A _11763_/B VDD VSS sg13g2_and2_1
XFILLER_25_91 VDD VSS sg13g2_decap_8
XFILLER_109_1064 VDD VSS sg13g2_decap_8
X_13827__2737 _13827_/RESET_B VDD VSS sg13g2_tiehi
X_14587__1977 _14587_/RESET_B VDD VSS sg13g2_tiehi
X_14455_ _14455_/Q clkload3/A _14455_/D _14455_/RESET_B VDD VSS sg13g2_dfrbpq_1
X_11667_ _11667_/Y _11670_/S0 _13896_/Q VDD VSS sg13g2_nand2b_1
XFILLER_122_1231 VDD VSS sg13g2_decap_4
X_13406_ _15090_/D _13442_/A _13396_/D _13405_/Y VDD VSS sg13g2_o21ai_1
X_10618_ _10619_/A _10651_/D _14880_/Q _14879_/Q _10629_/C VDD VSS sg13g2_nand4_1
X_11598_ _11599_/B _11598_/A _11598_/B _11598_/C VDD VSS sg13g2_nand3_1
XFILLER_70_1196 VDD VSS sg13g2_fill_2
X_14386_ _14386_/Q clkload46/A _14386_/D _14386_/RESET_B VDD VSS sg13g2_dfrbpq_1
XFILLER_10_580 VDD VSS sg13g2_fill_2
X_10549_ _10567_/C _14865_/Q _14864_/Q _14863_/Q VDD VSS sg13g2_nand3_1
X_13337_ _13338_/A _15172_/D _15171_/D VDD VSS sg13g2_nor2b_1
XFILLER_127_265 VDD VSS sg13g2_decap_8
XFILLER_128_788 VDD VSS sg13g2_decap_8
XFILLER_109_991 VDD VSS sg13g2_decap_8
XFILLER_142_235 VDD VSS sg13g2_fill_2
X_14207__2357 _14207_/RESET_B VDD VSS sg13g2_tiehi
X_13268_ _13270_/B _14924_/Q _13663_/Q _13259_/A VDD VSS sg13g2_o21ai_1
X_15007_ _15007_/Q _15200_/CLK _15007_/D _15007_/RESET_B VDD VSS sg13g2_dfrbpq_1
XFILLER_29_1043 VDD VSS sg13g2_fill_2
X_12219_ _12219_/X _12205_/X _12206_/X _12219_/S VDD VSS sg13g2_mux2_1
XFILLER_124_983 VDD VSS sg13g2_fill_1
X_13199_ _13199_/X _13199_/A _13667_/Q VDD VSS sg13g2_and2_1
XFILLER_155_1062 VDD VSS sg13g2_fill_2
XFILLER_29_1065 VDD VSS sg13g2_fill_1
XFILLER_151_791 VDD VSS sg13g2_fill_1
XFILLER_9_1148 VDD VSS sg13g2_decap_8
XFILLER_110_121 VDD VSS sg13g2_fill_2
XFILLER_99_1008 VDD VSS sg13g2_decap_4
X_07760_ _15205_/D _13302_/C _07759_/Y _07754_/Y VDD VSS sg13g2_a21oi_1
X_14422__2142 _14422_/RESET_B VDD VSS sg13g2_tiehi
XFILLER_84_528 VDD VSS sg13g2_decap_4
XFILLER_110_165 VDD VSS sg13g2_decap_8
XFILLER_2_84 VDD VSS sg13g2_decap_8
XFILLER_49_282 VDD VSS sg13g2_fill_1
XFILLER_38_967 VDD VSS sg13g2_decap_8
X_07691_ _07691_/Y _13507_/A _11241_/A _08832_/D VDD VSS sg13g2_o21ai_1
X_09430_ _14032_/D _09562_/A0 _14032_/Q _09431_/S VDD VSS sg13g2_mux2_1
XFILLER_25_628 VDD VSS sg13g2_decap_8
XFILLER_52_414 VDD VSS sg13g2_fill_2
XFILLER_65_797 VDD VSS sg13g2_fill_2
XFILLER_92_583 VDD VSS sg13g2_fill_2
XFILLER_80_734 VDD VSS sg13g2_decap_8
X_09361_ _13965_/D _09693_/A0 _13965_/Q wire689/X VDD VSS sg13g2_mux2_1
XFILLER_75_1052 VDD VSS sg13g2_decap_4
X_08312_ _08312_/Y _08312_/A _08312_/B _08312_/C _08312_/D VDD VSS sg13g2_nor4_1
XFILLER_75_1063 VDD VSS sg13g2_decap_8
X_09292_ _13900_/D _13900_/Q _09824_/A0 _09297_/S VDD VSS sg13g2_mux2_1
XFILLER_60_480 VDD VSS sg13g2_fill_2
XANTENNA_12 _16883_/A VDD VSS sg13g2_antennanp
X_15167__2890 _15167_/RESET_B VDD VSS sg13g2_tiehi
X_08243_ _08243_/Y _08244_/B _08015_/Y _08241_/Y VDD VSS sg13g2_o21ai_1
Xclkbuf_leaf_8_clk_i clkload13/A clkbuf_leaf_8_clk_i/A VDD VSS sg13g2_buf_8
XFILLER_119_700 VDD VSS sg13g2_fill_2
XFILLER_123_1039 VDD VSS sg13g2_decap_4
X_08174_ _08174_/Y _08429_/A _08659_/B _08514_/A VDD VSS sg13g2_nor3_1
XFILLER_107_906 VDD VSS sg13g2_decap_8
XFILLER_119_766 VDD VSS sg13g2_fill_1
XFILLER_21_49 VDD VSS sg13g2_decap_8
XFILLER_137_49 VDD VSS sg13g2_decap_8
Xoutput130 mem_axi_wdata[4] _15136_/Q VDD VSS sg13g2_buf_1
Xoutput141 trap _10177_/B VDD VSS sg13g2_buf_1
X_14632__1932 _14632_/RESET_B VDD VSS sg13g2_tiehi
X_15192__3162 _15192_/RESET_B VDD VSS sg13g2_tiehi
XFILLER_88_812 VDD VSS sg13g2_fill_1
X_14959__3013 _14959_/RESET_B VDD VSS sg13g2_tiehi
XFILLER_82_1034 VDD VSS sg13g2_decap_8
XFILLER_102_611 VDD VSS sg13g2_decap_8
XFILLER_142_791 VDD VSS sg13g2_decap_8
XFILLER_99_171 VDD VSS sg13g2_fill_2
XFILLER_134_1124 VDD VSS sg13g2_decap_8
XFILLER_130_942 VDD VSS sg13g2_decap_8
XFILLER_82_1067 VDD VSS sg13g2_fill_2
XFILLER_88_878 VDD VSS sg13g2_decap_8
XFILLER_87_355 VDD VSS sg13g2_decap_8
X_07958_ _07961_/B _07958_/A _07958_/B VDD VSS sg13g2_and2_1
X_13905__2659 _13905_/RESET_B VDD VSS sg13g2_tiehi
X_14665__1899 _14665_/RESET_B VDD VSS sg13g2_tiehi
X_07889_ _07890_/B _07889_/A _08229_/C VDD VSS sg13g2_nand2_1
XFILLER_28_466 VDD VSS sg13g2_decap_4
X_15000__2972 _15000_/RESET_B VDD VSS sg13g2_tiehi
XFILLER_16_617 VDD VSS sg13g2_decap_8
X_09628_ _14224_/D _09927_/A1 _14224_/Q _09637_/S VDD VSS sg13g2_mux2_1
XFILLER_55_296 VDD VSS sg13g2_decap_4
XFILLER_110_1190 VDD VSS sg13g2_fill_2
X_09559_ _14157_/D _10089_/A0 _14157_/Q wire651/X VDD VSS sg13g2_mux2_1
XFILLER_19_1212 VDD VSS sg13g2_decap_8
XFILLER_62_23 VDD VSS sg13g2_fill_1
XFILLER_52_981 VDD VSS sg13g2_decap_4
X_12570_ _12583_/A _10671_/B _12779_/A2 _15005_/Q VDD VSS sg13g2_a21oi_1
XFILLER_106_1204 VDD VSS sg13g2_decap_8
XFILLER_93_1196 VDD VSS sg13g2_decap_8
X_11521_ _11521_/Y _11520_/Y wire304/X _11506_/Y _11521_/B2 _11522_/A2 VDD VSS sg13g2_a221oi_1
XFILLER_54_1169 VDD VSS sg13g2_decap_8
X_11452_ _11463_/A _11454_/A _13688_/Q VDD VSS sg13g2_nor2_1
X_14240_ _14240_/Q _14738_/CLK _14240_/D _14240_/RESET_B VDD VSS sg13g2_dfrbpq_1
XFILLER_11_388 VDD VSS sg13g2_decap_8
Xwire246 wire246/X wire246/A VDD VSS sg13g2_buf_2
XFILLER_137_552 VDD VSS sg13g2_decap_8
XFILLER_7_359 VDD VSS sg13g2_fill_2
Xwire268 wire268/X wire268/A VDD VSS sg13g2_buf_2
X_10403_ _14823_/D _14823_/Q _10400_/Y _10402_/Y VDD VSS sg13g2_a21oi_1
X_14171_ _14171_/Q clkload73/A _14171_/D _14171_/RESET_B VDD VSS sg13g2_dfrbpq_1
X_11383_ _11383_/Y _11384_/A _13690_/Q VDD VSS sg13g2_nand2_1
X_14500__2064 _14500_/RESET_B VDD VSS sg13g2_tiehi
X_13122_ _13122_/Y _14883_/Q _13028_/B _13193_/B VDD VSS sg13g2_a21oi_1
X_10334_ _14804_/D _10334_/A _10335_/B _10444_/C VDD VSS sg13g2_and3_1
XFILLER_139_1068 VDD VSS sg13g2_fill_1
XFILLER_2_0 VDD VSS sg13g2_decap_8
X_13053_ _13053_/Y _14782_/Q _13123_/A2 _13123_/B1 VDD VSS sg13g2_o21ai_1
XFILLER_152_588 VDD VSS sg13g2_decap_8
X_10265_ _10278_/C _10265_/A _10265_/B _10265_/C _10265_/D VDD VSS sg13g2_nor4_1
XFILLER_3_576 VDD VSS sg13g2_fill_1
XFILLER_78_300 VDD VSS sg13g2_decap_8
XFILLER_26_1205 VDD VSS sg13g2_decap_8
X_12004_ _12004_/Y wire299/X _12003_/Y _11980_/A VDD VSS sg13g2_a21oi_1
Xfanout1300 _13343_/B _15069_/Q VDD VSS sg13g2_buf_1
XFILLER_152_1224 VDD VSS sg13g2_decap_8
Xfanout1311 _09641_/A _15064_/Q VDD VSS sg13g2_buf_1
XFILLER_152_1235 VDD VSS sg13g2_fill_2
X_10196_ _14755_/D _15198_/D _14755_/Q _10206_/S VDD VSS sg13g2_mux2_1
Xfanout1322 _09085_/B _13305_/A VDD VSS sg13g2_buf_1
Xfanout1333 _13283_/A _15054_/Q VDD VSS sg13g2_buf_1
Xfanout1344 _08263_/B _14997_/Q VDD VSS sg13g2_buf_1
XFILLER_120_452 VDD VSS sg13g2_decap_8
Xfanout1355 _08560_/A _13529_/A VDD VSS sg13g2_buf_1
XFILLER_93_303 VDD VSS sg13g2_decap_8
Xfanout1366 _13529_/A _14992_/Q VDD VSS sg13g2_buf_1
XFILLER_94_837 VDD VSS sg13g2_decap_4
XFILLER_121_997 VDD VSS sg13g2_decap_8
XFILLER_8_1181 VDD VSS sg13g2_decap_8
Xfanout1377 _08099_/S0 _08044_/S1 VDD VSS sg13g2_buf_1
Xfanout390 _10150_/S _10163_/S VDD VSS sg13g2_buf_1
Xfanout1388 _08427_/S0 _08457_/S0 VDD VSS sg13g2_buf_1
XFILLER_93_358 VDD VSS sg13g2_fill_2
X_13955_ _13955_/Q clkload2/A _13955_/D _13955_/RESET_B VDD VSS sg13g2_dfrbpq_1
XFILLER_47_753 VDD VSS sg13g2_fill_2
XFILLER_35_915 VDD VSS sg13g2_decap_4
XFILLER_47_786 VDD VSS sg13g2_fill_1
XFILLER_59_1025 VDD VSS sg13g2_decap_4
X_12906_ _12925_/C _14901_/Q _13686_/Q VDD VSS sg13g2_nand2_1
X_13886_ _13886_/Q clkload59/A _13886_/D _13886_/RESET_B VDD VSS sg13g2_dfrbpq_1
XFILLER_35_948 VDD VSS sg13g2_decap_8
X_12837_ _12838_/A _14895_/Q _13692_/Q _12836_/C VDD VSS sg13g2_a21oi_1
XFILLER_43_992 VDD VSS sg13g2_decap_8
XFILLER_72_1236 VDD VSS sg13g2_fill_1
X_12768_ _12768_/X _13849_/Q _13881_/Q _13913_/Q _13945_/Q _12769_/S0 _12772_/S1 VDD
+ VSS sg13g2_mux4_1
X_14710__1854 _14710_/RESET_B VDD VSS sg13g2_tiehi
X_14507_ _14507_/Q _14731_/CLK _14507_/D _14507_/RESET_B VDD VSS sg13g2_dfrbpq_1
X_11719_ _11719_/Y _12223_/A _11719_/B VDD VSS sg13g2_nor2_1
X_12699_ _12699_/X _14260_/Q _14292_/Q _14324_/Q _14356_/Q _12699_/S0 _12745_/S1 VDD
+ VSS sg13g2_mux4_1
Xinput10 input10/X input10/A VDD VSS sg13g2_buf_1
XFILLER_35_1091 VDD VSS sg13g2_decap_8
X_14438_ _14438_/Q clkload7/A _14438_/D _14438_/RESET_B VDD VSS sg13g2_dfrbpq_1
Xinput21 input21/X input21/A VDD VSS sg13g2_buf_1
Xinput32 input32/X input32/A VDD VSS sg13g2_buf_1
XFILLER_128_541 VDD VSS sg13g2_fill_1
XFILLER_122_1083 VDD VSS sg13g2_decap_8
XFILLER_128_574 VDD VSS sg13g2_decap_8
X_14369_ _14369_/Q _14465_/CLK _14369_/D _14369_/RESET_B VDD VSS sg13g2_dfrbpq_1
XFILLER_116_736 VDD VSS sg13g2_fill_1
XFILLER_7_893 VDD VSS sg13g2_decap_8
X_15050__2910 _15050_/RESET_B VDD VSS sg13g2_tiehi
XFILLER_143_544 VDD VSS sg13g2_fill_2
XFILLER_6_392 VDD VSS sg13g2_decap_8
Xmax_cap557 _13396_/D _13395_/Y VDD VSS sg13g2_buf_2
XFILLER_116_769 VDD VSS sg13g2_fill_2
Xmax_cap579 _10995_/B _10729_/Y VDD VSS sg13g2_buf_2
XFILLER_88_108 VDD VSS sg13g2_fill_2
X_08930_ _08930_/X _15046_/Q _14950_/Q _10767_/A VDD VSS sg13g2_mux2_1
XFILLER_69_300 VDD VSS sg13g2_decap_8
XFILLER_97_631 VDD VSS sg13g2_fill_2
XFILLER_35_0 VDD VSS sg13g2_decap_8
XFILLER_97_642 VDD VSS sg13g2_fill_1
XFILLER_112_953 VDD VSS sg13g2_decap_8
X_08861_ _13698_/D _13698_/Q _08860_/X _08892_/S VDD VSS sg13g2_mux2_1
XFILLER_111_441 VDD VSS sg13g2_decap_8
X_07812_ _08548_/B _13566_/A _07812_/B VDD VSS sg13g2_nand2_1
X_08792_ _08792_/Y _13682_/Q _13481_/C VDD VSS sg13g2_nor2_1
XFILLER_111_485 VDD VSS sg13g2_fill_2
XFILLER_38_742 VDD VSS sg13g2_decap_8
XFILLER_84_347 VDD VSS sg13g2_decap_8
X_07743_ _07744_/D _12348_/A _15217_/Q _15126_/Q VDD VSS sg13g2_nor3_1
XFILLER_65_550 VDD VSS sg13g2_decap_8
X_07674_ _07674_/Y _13356_/B _07677_/B VDD VSS sg13g2_nand2_1
XFILLER_52_222 VDD VSS sg13g2_decap_4
X_09413_ _14015_/D _09646_/A0 _14015_/Q _09413_/S VDD VSS sg13g2_mux2_1
XFILLER_16_49 VDD VSS sg13g2_decap_8
X_13699__2865 _13699_/RESET_B VDD VSS sg13g2_tiehi
XFILLER_25_458 VDD VSS sg13g2_decap_8
XFILLER_34_970 VDD VSS sg13g2_decap_8
XFILLER_34_981 VDD VSS sg13g2_fill_1
X_09344_ _13948_/D _10105_/A _13948_/Q wire689/A VDD VSS sg13g2_mux2_1
XFILLER_12_119 VDD VSS sg13g2_decap_4
XFILLER_40_428 VDD VSS sg13g2_decap_8
XFILLER_80_597 VDD VSS sg13g2_decap_8
XFILLER_40_439 VDD VSS sg13g2_fill_2
X_09275_ _13883_/D _13883_/Q _10138_/A1 _09294_/S VDD VSS sg13g2_mux2_1
XFILLER_14_1120 VDD VSS sg13g2_decap_8
X_08226_ _08247_/C _08203_/A _08203_/B _07909_/B _07910_/A _08188_/Y VDD VSS sg13g2_a221oi_1
X_14079__2485 _14079_/RESET_B VDD VSS sg13g2_tiehi
XFILLER_153_308 VDD VSS sg13g2_decap_8
XFILLER_140_1172 VDD VSS sg13g2_decap_8
X_08157_ _08157_/X _08005_/X _08018_/X _08199_/B VDD VSS sg13g2_mux2_1
XFILLER_107_725 VDD VSS sg13g2_fill_2
XFILLER_113_7 VDD VSS sg13g2_decap_8
XFILLER_147_894 VDD VSS sg13g2_decap_8
XFILLER_14_1197 VDD VSS sg13g2_decap_8
XFILLER_10_1028 VDD VSS sg13g2_fill_2
XFILLER_101_1145 VDD VSS sg13g2_decap_8
X_08088_ _08088_/Y _13553_/A1 _08023_/B _08649_/S VDD VSS sg13g2_a21oi_1
XFILLER_134_555 VDD VSS sg13g2_decap_8
X_15018__2954 _15018_/RESET_B VDD VSS sg13g2_tiehi
XFILLER_136_1208 VDD VSS sg13g2_decap_8
XFILLER_106_268 VDD VSS sg13g2_decap_4
XFILLER_0_502 VDD VSS sg13g2_decap_4
X_14294__2270 _14294_/RESET_B VDD VSS sg13g2_tiehi
XFILLER_103_920 VDD VSS sg13g2_decap_8
XFILLER_121_227 VDD VSS sg13g2_decap_4
Xhold3430 input24/A mem_axi_rdata[28] VDD VSS sg13g2_dlygate4sd3_1
Xhold3441 hold3441/X input9/X VDD VSS sg13g2_dlygate4sd3_1
X_10050_ _14631_/D _10083_/A0 _14631_/Q _10062_/S VDD VSS sg13g2_mux2_1
XFILLER_88_642 VDD VSS sg13g2_decap_8
Xhold3452 input17/A mem_axi_rdata[21] VDD VSS sg13g2_dlygate4sd3_1
Xhold3463 input36/A mem_axi_rvalid VDD VSS sg13g2_dlygate4sd3_1
Xhold3474 _13633_/A _13741_/Q VDD VSS sg13g2_dlygate4sd3_1
Xhold3485 _13628_/A _13736_/Q VDD VSS sg13g2_dlygate4sd3_1
XFILLER_87_163 VDD VSS sg13g2_fill_2
Xhold3496 _13621_/A _13729_/Q VDD VSS sg13g2_dlygate4sd3_1
XFILLER_76_848 VDD VSS sg13g2_decap_8
XFILLER_102_485 VDD VSS sg13g2_decap_8
XFILLER_21_1124 VDD VSS sg13g2_decap_8
XFILLER_91_818 VDD VSS sg13g2_fill_1
Xclkbuf_leaf_109_clk_i clkload35/A clkbuf_leaf_88_clk_i/A VDD VSS sg13g2_buf_8
X_13740_ _13740_/Q clkload50/A _13740_/D _13740_/RESET_B VDD VSS sg13g2_dfrbpq_1
XFILLER_28_274 VDD VSS sg13g2_decap_8
X_10952_ _10952_/Y wire582/X _10954_/B _10954_/C _10954_/D VDD VSS sg13g2_nor4_1
XFILLER_17_959 VDD VSS sg13g2_decap_8
X_14518__2046 _14518_/RESET_B VDD VSS sg13g2_tiehi
X_13671_ _13671_/Q _15212_/CLK _13671_/D _13671_/RESET_B VDD VSS sg13g2_dfrbpq_1
X_10883_ _10883_/X _10890_/C _10883_/B VDD VSS sg13g2_xor2_1
X_12622_ _12622_/X _12618_/X _12617_/X _12614_/X _12613_/X _12789_/S0 _12788_/S1 VDD
+ VSS sg13g2_mux4_1
XFILLER_145_1072 VDD VSS sg13g2_fill_1
XFILLER_19_1086 VDD VSS sg13g2_decap_8
X_12553_ _12553_/X _12551_/X _12552_/X _12553_/S VDD VSS sg13g2_mux2_1
XFILLER_156_102 VDD VSS sg13g2_decap_4
X_14808__3290 _14808_/RESET_B VDD VSS sg13g2_tiehi
X_13659__1812 _13659_/RESET_B VDD VSS sg13g2_tiehi
X_11504_ _11506_/B _11777_/A _11777_/C VDD VSS sg13g2_nor2_1
X_12484_ _12485_/B _12942_/B _12763_/A2 _12483_/X _12763_/B2 _12498_/C1 VDD VSS sg13g2_a221oi_1
XFILLER_11_185 VDD VSS sg13g2_fill_1
X_13744__2820 _13744_/RESET_B VDD VSS sg13g2_tiehi
XFILLER_144_319 VDD VSS sg13g2_fill_1
XFILLER_138_872 VDD VSS sg13g2_decap_8
XFILLER_22_70 VDD VSS sg13g2_decap_8
X_14223_ _14223_/Q clkload13/A _14223_/D _14223_/RESET_B VDD VSS sg13g2_dfrbpq_1
X_11435_ _11435_/X _13952_/Q _13984_/Q _14016_/Q _14048_/Q _12107_/S0 _12091_/C VDD
+ VSS sg13g2_mux4_1
XFILLER_138_70 VDD VSS sg13g2_decap_8
XFILLER_138_81 VDD VSS sg13g2_fill_1
XFILLER_153_853 VDD VSS sg13g2_decap_8
X_11366_ _11366_/Y _11366_/A _11366_/B _12307_/C VDD VSS sg13g2_nand3_1
X_14154_ _14154_/Q clkload20/A _14154_/D _14154_/RESET_B VDD VSS sg13g2_dfrbpq_1
XFILLER_4_863 VDD VSS sg13g2_decap_4
X_10317_ _10319_/B _10330_/A _10342_/C _14799_/Q VDD VSS sg13g2_a21oi_1
X_13105_ _13105_/X input14/X _13149_/A2 _13264_/B1 VDD VSS sg13g2_a21o_1
XFILLER_152_374 VDD VSS sg13g2_fill_1
X_11297_ _11297_/Y _11300_/S0 _13885_/Q VDD VSS sg13g2_nand2b_1
X_14085_ _14085_/Q clkload0/A _14085_/D _14085_/RESET_B VDD VSS sg13g2_dfrbpq_1
XFILLER_152_396 VDD VSS sg13g2_decap_8
XFILLER_79_620 VDD VSS sg13g2_fill_2
X_14124__2440 _14124_/RESET_B VDD VSS sg13g2_tiehi
XFILLER_112_238 VDD VSS sg13g2_decap_8
XFILLER_140_547 VDD VSS sg13g2_decap_8
XFILLER_26_1013 VDD VSS sg13g2_decap_4
XFILLER_65_1062 VDD VSS sg13g2_decap_8
XFILLER_140_558 VDD VSS sg13g2_fill_1
X_10248_ _14777_/D _10255_/D _10347_/B _10248_/C VDD VSS sg13g2_nor3_1
X_13036_ _15035_/D _13027_/Y wire237/X _13239_/A VDD VSS sg13g2_a21oi_1
XFILLER_112_249 VDD VSS sg13g2_fill_1
X_13777__2787 _13777_/RESET_B VDD VSS sg13g2_tiehi
XFILLER_78_130 VDD VSS sg13g2_decap_8
XFILLER_79_664 VDD VSS sg13g2_fill_2
Xfanout1130 _12604_/S1 _12661_/S1 VDD VSS sg13g2_buf_1
XFILLER_154_91 VDD VSS sg13g2_decap_8
XFILLER_67_826 VDD VSS sg13g2_fill_1
Xfanout1141 _12351_/S1 _12782_/S1 VDD VSS sg13g2_buf_1
Xfanout1152 _12727_/S0 _12729_/S0 VDD VSS sg13g2_buf_1
X_14728__1836 _14728_/RESET_B VDD VSS sg13g2_tiehi
XFILLER_78_174 VDD VSS sg13g2_decap_8
X_10179_ _10179_/Y _10182_/A _13613_/B VDD VSS sg13g2_nand2_1
XFILLER_152_1076 VDD VSS sg13g2_decap_8
XFILLER_26_1079 VDD VSS sg13g2_decap_8
XFILLER_152_1098 VDD VSS sg13g2_decap_8
X_14987_ _14987_/Q clkload19/A _14987_/D _14987_/RESET_B VDD VSS sg13g2_dfrbpq_1
X_13992__2572 _13992_/RESET_B VDD VSS sg13g2_tiehi
X_13938_ _13938_/Q _14916_/CLK _13938_/D _13938_/RESET_B VDD VSS sg13g2_dfrbpq_1
XFILLER_62_520 VDD VSS sg13g2_fill_2
X_13869_ _13869_/Q clkload55/A _13869_/D _13869_/RESET_B VDD VSS sg13g2_dfrbpq_1
XFILLER_90_873 VDD VSS sg13g2_decap_8
Xclkbuf_leaf_73_clk_i clkload79/A clkbuf_leaf_75_clk_i/A VDD VSS sg13g2_buf_8
XFILLER_50_737 VDD VSS sg13g2_fill_2
XFILLER_37_1142 VDD VSS sg13g2_decap_8
XFILLER_15_480 VDD VSS sg13g2_decap_4
XFILLER_31_962 VDD VSS sg13g2_decap_8
XFILLER_72_1055 VDD VSS sg13g2_fill_1
X_14372__2192 _14372_/RESET_B VDD VSS sg13g2_tiehi
XFILLER_72_1088 VDD VSS sg13g2_fill_2
XFILLER_31_995 VDD VSS sg13g2_decap_8
X_09060_ _09060_/X _15037_/Q _15234_/Q _09100_/B VDD VSS sg13g2_mux2_1
Xclkbuf_leaf_88_clk_i clkload34/A clkbuf_leaf_88_clk_i/A VDD VSS sg13g2_buf_8
X_08011_ _08011_/X _07972_/B _08653_/B _08673_/B _08048_/B _13517_/A _13521_/A VDD
+ VSS sg13g2_mux4_1
XFILLER_129_894 VDD VSS sg13g2_decap_4
Xmax_cap310 _10067_/S _10063_/S VDD VSS sg13g2_buf_4
Xmax_cap343 _09439_/S _09413_/S VDD VSS sg13g2_buf_4
XFILLER_116_566 VDD VSS sg13g2_fill_1
Xclkbuf_leaf_11_clk_i clkload7/A clkbuf_5_3__f_clk_i/X VDD VSS sg13g2_buf_8
X_09962_ _14546_/D _14546_/Q _09962_/A1 _09969_/S VDD VSS sg13g2_mux2_1
X_14835__3259 _14835_/RESET_B VDD VSS sg13g2_tiehi
Xmax_cap387 _10547_/D _10538_/Y VDD VSS sg13g2_buf_1
XFILLER_98_940 VDD VSS sg13g2_fill_2
XFILLER_83_1162 VDD VSS sg13g2_decap_8
X_08913_ _08913_/Y _10735_/A _14945_/Q VDD VSS sg13g2_nand2_1
XFILLER_134_28 VDD VSS sg13g2_decap_8
X_09893_ _14479_/D _09893_/A0 _14479_/Q _09898_/S VDD VSS sg13g2_mux2_1
XFILLER_98_973 VDD VSS sg13g2_fill_2
XFILLER_97_472 VDD VSS sg13g2_fill_2
X_08844_ _08844_/Y _10669_/S _14928_/Q VDD VSS sg13g2_nor2b_1
XFILLER_112_794 VDD VSS sg13g2_fill_1
Xclkbuf_leaf_26_clk_i _14671_/CLK clkbuf_leaf_8_clk_i/A VDD VSS sg13g2_buf_8
XFILLER_100_945 VDD VSS sg13g2_fill_1
XFILLER_57_347 VDD VSS sg13g2_fill_2
XFILLER_111_293 VDD VSS sg13g2_decap_4
XFILLER_73_818 VDD VSS sg13g2_decap_8
X_08775_ _08775_/Y _13064_/B _08778_/B VDD VSS sg13g2_nor2_1
XFILLER_85_689 VDD VSS sg13g2_fill_2
XFILLER_72_328 VDD VSS sg13g2_decap_4
X_07726_ _07735_/C _07726_/A _07726_/B _07726_/C _07726_/D VDD VSS sg13g2_nand4_1
X_13822__2742 _13822_/RESET_B VDD VSS sg13g2_tiehi
XFILLER_150_49 VDD VSS sg13g2_decap_8
XFILLER_26_745 VDD VSS sg13g2_fill_1
X_14582__1982 _14582_/RESET_B VDD VSS sg13g2_tiehi
XFILLER_53_520 VDD VSS sg13g2_fill_1
X_14919__3091 _14919_/RESET_B VDD VSS sg13g2_tiehi
X_07657_ wire955/A _15165_/Q _15164_/Q _15167_/Q _15166_/Q VDD VSS sg13g2_nor4_2
XFILLER_26_789 VDD VSS sg13g2_fill_1
XFILLER_43_14 VDD VSS sg13g2_decap_8
XFILLER_129_1045 VDD VSS sg13g2_fill_2
XFILLER_40_203 VDD VSS sg13g2_decap_8
X_09327_ _13934_/D _09991_/A0 _13934_/Q _09330_/S VDD VSS sg13g2_mux2_1
XFILLER_16_1226 VDD VSS sg13g2_decap_8
X_14202__2362 _14202_/RESET_B VDD VSS sg13g2_tiehi
XFILLER_22_995 VDD VSS sg13g2_decap_8
XFILLER_103_1207 VDD VSS sg13g2_decap_8
XFILLER_90_1199 VDD VSS sg13g2_fill_1
X_09258_ _13867_/D _13867_/Q _09922_/A1 _09272_/S VDD VSS sg13g2_mux2_1
XFILLER_153_105 VDD VSS sg13g2_decap_8
X_08209_ _08209_/X _08209_/A _08452_/C VDD VSS sg13g2_and2_1
X_09189_ _13805_/D _13805_/Q _10156_/A1 _09193_/S VDD VSS sg13g2_mux2_1
X_11220_ _11223_/B _11894_/B _11217_/X _11219_/X VDD VSS sg13g2_a21oi_1
XFILLER_4_126 VDD VSS sg13g2_decap_8
XFILLER_107_555 VDD VSS sg13g2_decap_8
XFILLER_150_823 VDD VSS sg13g2_decap_8
XFILLER_136_1005 VDD VSS sg13g2_decap_8
X_11151_ _11151_/Y _11151_/A _11151_/B VDD VSS sg13g2_nor2_1
XFILLER_49_1079 VDD VSS sg13g2_fill_1
X_10102_ _14682_/D _10102_/A0 _14682_/Q _10102_/S VDD VSS sg13g2_mux2_1
X_11082_ _11082_/Y _11029_/C _10754_/X _11082_/B1 VDD VSS sg13g2_o21ai_1
XFILLER_89_962 VDD VSS sg13g2_decap_8
X_10033_ _14615_/D _10033_/A0 _14615_/Q _10033_/S VDD VSS sg13g2_mux2_1
XFILLER_49_826 VDD VSS sg13g2_decap_8
X_14910_ _14910_/Q clkload61/A _14910_/D _14910_/RESET_B VDD VSS sg13g2_dfrbpq_1
XFILLER_76_623 VDD VSS sg13g2_decap_4
XFILLER_75_133 VDD VSS sg13g2_fill_2
X_14841_ _14841_/Q _14854_/CLK _14841_/D _14841_/RESET_B VDD VSS sg13g2_dfrbpq_1
XFILLER_84_21 VDD VSS sg13g2_decap_8
XFILLER_57_892 VDD VSS sg13g2_fill_2
XFILLER_91_648 VDD VSS sg13g2_fill_1
X_14772_ _14772_/Q _14776_/CLK _14772_/D _14772_/RESET_B VDD VSS sg13g2_dfrbpq_1
X_11984_ _11986_/B _11914_/A _13673_/Q _13130_/B _11936_/A VDD VSS sg13g2_a22oi_1
XFILLER_44_531 VDD VSS sg13g2_fill_2
XFILLER_72_840 VDD VSS sg13g2_fill_2
XFILLER_95_1033 VDD VSS sg13g2_fill_1
XFILLER_72_851 VDD VSS sg13g2_decap_4
X_13723_ _13723_/Q clkload60/A _13723_/D _13723_/RESET_B VDD VSS sg13g2_dfrbpq_1
XFILLER_17_70 VDD VSS sg13g2_decap_8
X_10935_ _10935_/Y _10935_/A _10935_/B VDD VSS sg13g2_nor2_1
XFILLER_95_1066 VDD VSS sg13g2_decap_8
X_13654_ _15120_/D _15190_/D _12346_/A _13654_/S VDD VSS sg13g2_mux2_1
XFILLER_108_1118 VDD VSS sg13g2_fill_1
X_10866_ _10868_/C _14752_/Q _10691_/X _10857_/A VDD VSS sg13g2_a21oi_1
X_12605_ _12605_/X _14381_/Q _14413_/Q _14477_/Q _14509_/Q _12661_/S0 _12661_/S1 VDD
+ VSS sg13g2_mux4_1
X_13585_ _15160_/D _13590_/B _13583_/Y _13584_/Y VDD VSS sg13g2_a21oi_1
X_10797_ _10798_/B _13345_/B _12346_/A _10797_/C VDD VSS sg13g2_nand3_1
XFILLER_8_432 VDD VSS sg13g2_decap_8
X_12536_ _12536_/X _14696_/Q _14728_/Q _13768_/Q _13800_/Q _12536_/S0 _12536_/S1 VDD
+ VSS sg13g2_mux4_1
XFILLER_118_809 VDD VSS sg13g2_decap_8
XFILLER_76_7 VDD VSS sg13g2_decap_8
XFILLER_117_308 VDD VSS sg13g2_decap_4
XFILLER_149_91 VDD VSS sg13g2_decap_8
XFILLER_129_179 VDD VSS sg13g2_decap_8
XFILLER_9_999 VDD VSS sg13g2_decap_8
X_12467_ _12467_/X _12464_/X _12463_/X _12460_/X _12459_/X _12746_/S1 _12748_/S VDD
+ VSS sg13g2_mux4_1
XFILLER_144_127 VDD VSS sg13g2_fill_2
XFILLER_138_691 VDD VSS sg13g2_decap_8
X_14206_ _14206_/Q _14763_/CLK _14206_/D _14206_/RESET_B VDD VSS sg13g2_dfrbpq_1
XFILLER_67_1102 VDD VSS sg13g2_decap_8
X_11418_ _11419_/B _11418_/A _14207_/Q VDD VSS sg13g2_nand2_1
X_15194__3154 _15194_/RESET_B VDD VSS sg13g2_tiehi
XFILLER_126_853 VDD VSS sg13g2_decap_8
XFILLER_99_704 VDD VSS sg13g2_fill_1
X_15186_ _15186_/Q clkload65/A _15186_/D _15186_/RESET_B VDD VSS sg13g2_dfrbpq_1
X_12398_ _12398_/X _12389_/X _12390_/X _12396_/X _12395_/X _12789_/S0 _12788_/S1 VDD
+ VSS sg13g2_mux4_1
XFILLER_119_1214 VDD VSS sg13g2_decap_8
XFILLER_140_300 VDD VSS sg13g2_decap_8
XFILLER_28_1108 VDD VSS sg13g2_decap_8
X_14137_ _14137_/Q clkload43/A _14137_/D _14137_/RESET_B VDD VSS sg13g2_dfrbpq_1
X_11349_ _11349_/Y _11373_/A _13758_/Q VDD VSS sg13g2_nand2b_1
XFILLER_67_1168 VDD VSS sg13g2_fill_1
XFILLER_113_525 VDD VSS sg13g2_decap_8
X_13900__2664 _13900_/RESET_B VDD VSS sg13g2_tiehi
XFILLER_154_1127 VDD VSS sg13g2_decap_8
X_14068_ _14068_/Q clkload16/A _14068_/D _14068_/RESET_B VDD VSS sg13g2_dfrbpq_1
X_13019_ wire252/A _13017_/Y _13018_/Y _12933_/Y VDD VSS sg13g2_o21ai_1
XFILLER_79_483 VDD VSS sg13g2_decap_4
XFILLER_95_943 VDD VSS sg13g2_decap_8
XFILLER_95_954 VDD VSS sg13g2_fill_1
XFILLER_82_604 VDD VSS sg13g2_fill_1
XFILLER_94_464 VDD VSS sg13g2_fill_2
XFILLER_82_626 VDD VSS sg13g2_fill_1
X_08560_ _08561_/C _08560_/A _08560_/B _08560_/C VDD VSS sg13g2_nor3_1
XFILLER_78_1231 VDD VSS sg13g2_decap_4
XFILLER_130_1182 VDD VSS sg13g2_decap_8
XFILLER_39_1215 VDD VSS sg13g2_decap_8
X_08491_ _08501_/D _08617_/A _08329_/A _08490_/Y VDD VSS sg13g2_o21ai_1
XFILLER_23_704 VDD VSS sg13g2_decap_8
XFILLER_74_1117 VDD VSS sg13g2_decap_8
XFILLER_50_567 VDD VSS sg13g2_decap_8
XFILLER_13_28 VDD VSS sg13g2_decap_8
X_09112_ _13778_/D _13778_/Q _10161_/A1 _09160_/S VDD VSS sg13g2_mux2_1
Xclkbuf_4_10_0_clk_i clkbuf_4_10_0_clk_i/X clkbuf_0_clk_i/X VDD VSS sg13g2_buf_8
XFILLER_109_809 VDD VSS sg13g2_fill_1
XFILLER_129_28 VDD VSS sg13g2_decap_8
XFILLER_108_308 VDD VSS sg13g2_decap_8
XFILLER_129_39 VDD VSS sg13g2_fill_2
X_09043_ _09056_/C _09043_/A _09043_/B VDD VSS sg13g2_nor2_1
XFILLER_108_319 VDD VSS sg13g2_fill_1
XFILLER_148_499 VDD VSS sg13g2_decap_8
XFILLER_11_1112 VDD VSS sg13g2_decap_8
XFILLER_50_1161 VDD VSS sg13g2_decap_8
XFILLER_85_1202 VDD VSS sg13g2_fill_1
XFILLER_85_1235 VDD VSS sg13g2_fill_2
XFILLER_11_1189 VDD VSS sg13g2_decap_8
XFILLER_150_119 VDD VSS sg13g2_decap_8
XFILLER_117_897 VDD VSS sg13g2_decap_4
XFILLER_104_525 VDD VSS sg13g2_decap_8
XFILLER_144_694 VDD VSS sg13g2_fill_1
XFILLER_145_49 VDD VSS sg13g2_decap_8
Xfanout901 _08689_/B1 _07993_/Y VDD VSS sg13g2_buf_1
X_09945_ _14529_/D _14529_/Q _10077_/A0 _09954_/S VDD VSS sg13g2_mux2_1
XFILLER_89_269 VDD VSS sg13g2_decap_8
Xfanout934 _07753_/B _07702_/X VDD VSS sg13g2_buf_1
Xfanout945 _12301_/B1 _11664_/A VDD VSS sg13g2_buf_1
XFILLER_38_14 VDD VSS sg13g2_decap_8
Xfanout956 _12217_/A _12192_/A VDD VSS sg13g2_buf_1
X_09876_ _14462_/D _09909_/A1 _14462_/Q _09904_/S VDD VSS sg13g2_mux2_1
Xfanout967 _11928_/S0 _12172_/B VDD VSS sg13g2_buf_1
Xfanout978 _11395_/B _11422_/B VDD VSS sg13g2_buf_1
XFILLER_86_954 VDD VSS sg13g2_decap_8
Xfanout989 _12088_/B fanout992/X VDD VSS sg13g2_buf_1
X_13658__1811 _13658_/RESET_B VDD VSS sg13g2_tiehi
X_08827_ _13692_/D _08825_/Y _08824_/Y _08826_/Y VDD VSS sg13g2_a21oi_1
XFILLER_46_829 VDD VSS sg13g2_decap_8
XFILLER_57_199 VDD VSS sg13g2_fill_2
X_08758_ _08758_/Y _13671_/Q _08787_/B VDD VSS sg13g2_nor2_1
XFILLER_73_659 VDD VSS sg13g2_fill_1
XFILLER_54_840 VDD VSS sg13g2_fill_1
XFILLER_72_158 VDD VSS sg13g2_decap_8
X_07709_ _07754_/B _13283_/A _14895_/Q _07708_/Y VDD VSS sg13g2_a21oi_1
X_08689_ _08690_/C _08692_/C _08048_/B _08689_/B1 VDD VSS sg13g2_a21oi_1
XFILLER_41_501 VDD VSS sg13g2_fill_2
X_10720_ _10720_/Y _10725_/A _10720_/B VDD VSS sg13g2_nor2_1
XFILLER_41_545 VDD VSS sg13g2_decap_4
X_10651_ _10652_/D _14886_/Q _14885_/Q _14882_/Q _10651_/D VDD VSS sg13g2_nand4_1
XFILLER_55_1061 VDD VSS sg13g2_decap_8
XFILLER_16_1034 VDD VSS sg13g2_decap_8
XFILLER_142_1042 VDD VSS sg13g2_decap_8
XFILLER_107_1162 VDD VSS sg13g2_decap_4
X_13370_ _13442_/A _13401_/C _13401_/B _13429_/A VDD VSS sg13g2_nand3b_1
X_10582_ _10591_/D _14872_/Q _14871_/Q _14870_/Q _14869_/Q VDD VSS sg13g2_and4_1
Xmax_cap1207 _12785_/S0 _12615_/S0 VDD VSS sg13g2_buf_4
XFILLER_142_1064 VDD VSS sg13g2_decap_8
XFILLER_70_67 VDD VSS sg13g2_decap_8
XFILLER_10_965 VDD VSS sg13g2_decap_8
XFILLER_6_914 VDD VSS sg13g2_decap_8
XFILLER_103_1037 VDD VSS sg13g2_fill_1
X_12321_ _12321_/Y _12328_/A1 _14522_/Q _12328_/B1 VDD VSS sg13g2_a21oi_1
XFILLER_127_628 VDD VSS sg13g2_fill_2
X_14468__2096 _14468_/RESET_B VDD VSS sg13g2_tiehi
X_15040_ _15040_/Q _15040_/CLK _15040_/D _15040_/RESET_B VDD VSS sg13g2_dfrbpq_1
XFILLER_142_609 VDD VSS sg13g2_decap_8
XFILLER_5_446 VDD VSS sg13g2_fill_1
X_12252_ _12253_/A _14264_/Q _14296_/Q _14328_/Q _14360_/Q _12252_/S0 _12187_/C VDD
+ VSS sg13g2_mux4_1
XFILLER_5_457 VDD VSS sg13g2_decap_8
XFILLER_135_672 VDD VSS sg13g2_decap_4
XFILLER_102_0 VDD VSS sg13g2_decap_8
XFILLER_107_363 VDD VSS sg13g2_decap_8
XFILLER_108_886 VDD VSS sg13g2_fill_1
XFILLER_141_119 VDD VSS sg13g2_fill_1
X_11203_ _11203_/Y _11202_/A _11199_/Y _11202_/Y VDD VSS sg13g2_a21oi_1
X_12183_ _12183_/X _13846_/Q _13878_/Q _12186_/A VDD VSS sg13g2_mux2_1
XFILLER_122_322 VDD VSS sg13g2_decap_8
XFILLER_122_333 VDD VSS sg13g2_fill_1
X_11134_ _11146_/B _11172_/A _11163_/A VDD VSS sg13g2_xnor2_1
XFILLER_62_1010 VDD VSS sg13g2_decap_8
XFILLER_27_1152 VDD VSS sg13g2_decap_8
XFILLER_62_1043 VDD VSS sg13g2_decap_8
X_11065_ _11088_/A _11119_/A _11011_/Y _11063_/Y VDD VSS sg13g2_o21ai_1
XFILLER_62_1054 VDD VSS sg13g2_fill_2
XFILLER_77_943 VDD VSS sg13g2_decap_8
X_13694__2870 _13694_/RESET_B VDD VSS sg13g2_tiehi
XFILLER_122_399 VDD VSS sg13g2_fill_1
XFILLER_114_1133 VDD VSS sg13g2_fill_1
X_10016_ _14598_/D _10149_/A1 _14598_/Q _10017_/S VDD VSS sg13g2_mux2_1
XFILLER_76_442 VDD VSS sg13g2_decap_8
XFILLER_95_75 VDD VSS sg13g2_decap_8
XFILLER_23_1049 VDD VSS sg13g2_decap_8
X_14791__3307 _14791_/RESET_B VDD VSS sg13g2_tiehi
XFILLER_97_1117 VDD VSS sg13g2_decap_8
XFILLER_149_1207 VDD VSS sg13g2_decap_8
XFILLER_48_188 VDD VSS sg13g2_fill_2
X_14824_ _14824_/Q clkload79/A _14824_/D _14824_/RESET_B VDD VSS sg13g2_dfrbpq_1
XFILLER_151_70 VDD VSS sg13g2_decap_8
XFILLER_17_542 VDD VSS sg13g2_decap_4
XFILLER_91_456 VDD VSS sg13g2_decap_8
XFILLER_63_158 VDD VSS sg13g2_decap_8
X_14755_ _14755_/Q _15200_/CLK _14755_/D _14755_/RESET_B VDD VSS sg13g2_dfrbpq_1
XFILLER_17_564 VDD VSS sg13g2_decap_8
X_11967_ _11971_/A _11966_/X _12023_/B VDD VSS sg13g2_nand2b_1
X_14074__2490 _14074_/RESET_B VDD VSS sg13g2_tiehi
XFILLER_72_670 VDD VSS sg13g2_decap_4
XFILLER_44_372 VDD VSS sg13g2_decap_8
X_13706_ _13706_/Q clkload33/A _13706_/D _13706_/RESET_B VDD VSS sg13g2_dfrbpq_1
X_10918_ _10945_/B _14756_/Q _10936_/D _10888_/Y VDD VSS sg13g2_a21oi_1
X_14686_ _14686_/Q clkload59/A _14686_/D _14686_/RESET_B VDD VSS sg13g2_dfrbpq_1
X_11898_ _11898_/Y _11898_/A _11898_/B _11898_/C VDD VSS sg13g2_nand3_1
XFILLER_32_556 VDD VSS sg13g2_decap_8
X_13918__2646 _13918_/RESET_B VDD VSS sg13g2_tiehi
X_13637_ _13745_/D _13637_/A VDD VSS sg13g2_buf_1
X_14678__1886 _14678_/RESET_B VDD VSS sg13g2_tiehi
X_10849_ _14930_/D _10849_/A _10849_/B VDD VSS sg13g2_nand2_1
XFILLER_73_1172 VDD VSS sg13g2_fill_2
XFILLER_9_741 VDD VSS sg13g2_decap_8
X_13568_ _15154_/D _15154_/Q _13567_/Y _13568_/S VDD VSS sg13g2_mux2_1
XFILLER_121_1115 VDD VSS sg13g2_decap_8
XFILLER_34_1178 VDD VSS sg13g2_decap_8
XFILLER_30_1009 VDD VSS sg13g2_decap_4
X_12519_ _12519_/X _14567_/Q _14599_/Q _14631_/Q _14663_/Q _12685_/S0 _12685_/S1 VDD
+ VSS sg13g2_mux4_1
XFILLER_146_959 VDD VSS sg13g2_fill_2
X_13499_ _13499_/Y _13499_/A _13499_/B _13499_/C VDD VSS sg13g2_nand3_1
XFILLER_117_138 VDD VSS sg13g2_fill_1
XFILLER_8_295 VDD VSS sg13g2_fill_1
X_15238_ _15238_/Q clkload68/A _15238_/D _15238_/RESET_B VDD VSS sg13g2_dfrbpq_1
XFILLER_154_981 VDD VSS sg13g2_decap_4
XFILLER_114_812 VDD VSS sg13g2_decap_4
XFILLER_126_683 VDD VSS sg13g2_decap_8
X_15169_ _15169_/Q clkload73/A _15169_/D _15169_/RESET_B VDD VSS sg13g2_dfrbpq_1
XFILLER_141_631 VDD VSS sg13g2_decap_8
XFILLER_119_1033 VDD VSS sg13g2_decap_4
XFILLER_5_84 VDD VSS sg13g2_decap_8
Xfanout219 _09927_/A1 _09696_/A0 VDD VSS sg13g2_buf_1
X_07991_ _15057_/D _07991_/A VDD VSS sg13g2_inv_1
XFILLER_113_366 VDD VSS sg13g2_decap_8
XFILLER_86_206 VDD VSS sg13g2_decap_4
XFILLER_119_1088 VDD VSS sg13g2_decap_8
X_09730_ _14321_/D _09730_/A0 _14321_/Q _09738_/S VDD VSS sg13g2_mux2_1
XFILLER_80_1143 VDD VSS sg13g2_decap_4
XFILLER_68_943 VDD VSS sg13g2_fill_1
X_14513__2051 _14513_/RESET_B VDD VSS sg13g2_tiehi
XFILLER_140_196 VDD VSS sg13g2_fill_1
XFILLER_80_1176 VDD VSS sg13g2_fill_2
XFILLER_39_144 VDD VSS sg13g2_decap_4
X_09661_ _14254_/D _09925_/A1 _14254_/Q _09661_/S VDD VSS sg13g2_mux2_1
XFILLER_39_166 VDD VSS sg13g2_fill_1
X_08612_ _08612_/X _08611_/Y _08610_/Y _08612_/S VDD VSS sg13g2_mux2_1
XFILLER_27_328 VDD VSS sg13g2_decap_8
X_14767__3331 _14767_/RESET_B VDD VSS sg13g2_tiehi
X_09592_ _14189_/D _14189_/Q _09693_/A0 _09605_/S VDD VSS sg13g2_mux2_1
X_08543_ _08545_/C _08553_/A _08522_/C _08542_/Y VDD VSS sg13g2_a21oi_1
XFILLER_51_810 VDD VSS sg13g2_fill_2
XFILLER_39_1034 VDD VSS sg13g2_decap_8
XFILLER_78_1083 VDD VSS sg13g2_decap_8
X_08474_ _08475_/A _08138_/X _08452_/B _08473_/Y VDD VSS sg13g2_a21o_1
XFILLER_39_1078 VDD VSS sg13g2_decap_8
XFILLER_24_49 VDD VSS sg13g2_decap_8
XFILLER_11_718 VDD VSS sg13g2_fill_1
XFILLER_137_904 VDD VSS sg13g2_fill_2
XFILLER_137_915 VDD VSS sg13g2_fill_1
XFILLER_109_606 VDD VSS sg13g2_fill_1
XFILLER_137_926 VDD VSS sg13g2_fill_1
XFILLER_148_285 VDD VSS sg13g2_decap_4
X_13772__2792 _13772_/RESET_B VDD VSS sg13g2_tiehi
X_09026_ _13765_/D _13765_/Q _10081_/A0 _09038_/S VDD VSS sg13g2_mux2_1
XFILLER_124_609 VDD VSS sg13g2_decap_8
X_14723__1841 _14723_/RESET_B VDD VSS sg13g2_tiehi
XFILLER_89_1190 VDD VSS sg13g2_decap_8
XFILLER_117_672 VDD VSS sg13g2_decap_8
XFILLER_137_1100 VDD VSS sg13g2_fill_2
XFILLER_104_300 VDD VSS sg13g2_fill_2
Xpicorv32_macro_1803 mem_axi_awaddr[0] VDD VSS sg13g2_tielo
XFILLER_6_7 VDD VSS sg13g2_decap_8
XFILLER_46_1016 VDD VSS sg13g2_decap_8
XFILLER_105_856 VDD VSS sg13g2_decap_4
XFILLER_132_653 VDD VSS sg13g2_fill_2
Xfanout1707 _12139_/S0 fanout1713/X VDD VSS sg13g2_buf_1
Xfanout720 _13651_/S _13652_/S VDD VSS sg13g2_buf_1
Xfanout1718 _11951_/A fanout1721/X VDD VSS sg13g2_buf_1
XFILLER_59_921 VDD VSS sg13g2_fill_1
Xfanout1729 _11828_/S0 fanout1736/X VDD VSS sg13g2_buf_1
X_09928_ _14513_/D _14513_/Q _09928_/A1 _09937_/S VDD VSS sg13g2_mux2_1
Xfanout753 _11477_/A _11235_/X VDD VSS sg13g2_buf_1
Xfanout775 _09574_/A1 _09906_/A1 VDD VSS sg13g2_buf_1
Xfanout786 _13600_/A _08833_/Y VDD VSS sg13g2_buf_1
X_09859_ _14446_/D _14446_/Q _09991_/A0 wire435/A VDD VSS sg13g2_mux2_1
Xfanout797 _08688_/C _08398_/Y VDD VSS sg13g2_buf_1
XFILLER_74_913 VDD VSS sg13g2_decap_8
XFILLER_85_294 VDD VSS sg13g2_decap_8
X_12870_ _12871_/B _12869_/Y _13048_/B _12808_/A _12861_/X _12865_/Y VDD VSS sg13g2_a221oi_1
XFILLER_65_67 VDD VSS sg13g2_fill_2
XFILLER_2_1143 VDD VSS sg13g2_decap_8
XFILLER_27_851 VDD VSS sg13g2_decap_8
XFILLER_73_456 VDD VSS sg13g2_decap_8
XFILLER_27_862 VDD VSS sg13g2_decap_8
XFILLER_22_1093 VDD VSS sg13g2_decap_8
X_11821_ _11822_/A _14252_/Q _14284_/Q _14316_/Q _14348_/Q _11826_/A1 _11828_/S1 VDD
+ VSS sg13g2_mux4_1
XFILLER_96_1150 VDD VSS sg13g2_decap_4
XFILLER_57_1112 VDD VSS sg13g2_decap_8
XFILLER_61_629 VDD VSS sg13g2_decap_8
XFILLER_26_372 VDD VSS sg13g2_decap_8
XFILLER_42_832 VDD VSS sg13g2_fill_1
XFILLER_109_1202 VDD VSS sg13g2_decap_4
X_14540_ _14540_/Q clkload51/A _14540_/D _14540_/RESET_B VDD VSS sg13g2_dfrbpq_1
X_11752_ _11752_/Y _11748_/Y _11749_/Y _11751_/Y _11750_/Y _11763_/B VDD VSS sg13g2_a221oi_1
XFILLER_18_1107 VDD VSS sg13g2_decap_8
XFILLER_144_1115 VDD VSS sg13g2_fill_1
XFILLER_42_865 VDD VSS sg13g2_decap_8
XFILLER_81_44 VDD VSS sg13g2_decap_4
X_10703_ _14903_/D _10886_/B1 _10701_/Y _10702_/Y VDD VSS sg13g2_o21ai_1
XFILLER_57_1189 VDD VSS sg13g2_fill_2
X_14471_ _14471_/Q clkload4/A _14471_/D _14471_/RESET_B VDD VSS sg13g2_dfrbpq_1
XFILLER_81_66 VDD VSS sg13g2_decap_8
X_11683_ _11683_/Y _11686_/S0 _14472_/Q VDD VSS sg13g2_nand2b_1
XFILLER_14_589 VDD VSS sg13g2_fill_1
XFILLER_41_386 VDD VSS sg13g2_fill_1
X_13422_ _15094_/D _13490_/D _13421_/Y _13419_/Y VDD VSS sg13g2_o21ai_1
X_10634_ _10637_/B _14886_/Q _10633_/C _10630_/C VDD VSS sg13g2_o21ai_1
X_14555__2009 _14555_/RESET_B VDD VSS sg13g2_tiehi
XFILLER_10_751 VDD VSS sg13g2_fill_2
XFILLER_6_700 VDD VSS sg13g2_decap_8
X_13353_ _13353_/Y _13353_/A _13507_/B VDD VSS sg13g2_nor2_1
Xmax_cap1037 _09141_/A _08969_/B VDD VSS sg13g2_buf_4
X_10565_ _10576_/D _10567_/C _10565_/B _10565_/C _10565_/D VDD VSS sg13g2_nor4_1
XFILLER_10_795 VDD VSS sg13g2_fill_2
XFILLER_127_447 VDD VSS sg13g2_decap_8
X_12304_ _12308_/A _12303_/X _12304_/B VDD VSS sg13g2_nand2b_1
XFILLER_155_778 VDD VSS sg13g2_fill_1
XFILLER_127_469 VDD VSS sg13g2_fill_1
X_13284_ _13284_/Y _11241_/C _13284_/B _13300_/C VDD VSS sg13g2_nand3b_1
XFILLER_154_266 VDD VSS sg13g2_decap_8
X_10496_ _14852_/D _10497_/B _10496_/B _10496_/C VDD VSS sg13g2_and3_1
X_15023_ _15023_/Q clkload62/A _15023_/D _15023_/RESET_B VDD VSS sg13g2_dfrbpq_1
XFILLER_142_439 VDD VSS sg13g2_decap_8
X_12235_ _12236_/B _12235_/A _14232_/Q VDD VSS sg13g2_nand2_1
XFILLER_108_683 VDD VSS sg13g2_decap_8
XFILLER_29_1214 VDD VSS sg13g2_decap_8
XFILLER_135_491 VDD VSS sg13g2_decap_8
XFILLER_146_70 VDD VSS sg13g2_decap_8
XFILLER_155_1233 VDD VSS sg13g2_decap_4
X_12166_ _12170_/A _12165_/X _12233_/B VDD VSS sg13g2_nand2b_1
XFILLER_64_1138 VDD VSS sg13g2_decap_8
XFILLER_39_7 VDD VSS sg13g2_decap_8
XFILLER_116_1228 VDD VSS sg13g2_decap_8
X_11117_ _11117_/Y wire211/X _11138_/C _11179_/B VDD VSS sg13g2_a21oi_1
XFILLER_68_228 VDD VSS sg13g2_fill_2
XFILLER_96_548 VDD VSS sg13g2_decap_4
X_12097_ _12097_/Y _12098_/A1 _14644_/Q VDD VSS sg13g2_nand2b_1
XFILLER_7_1054 VDD VSS sg13g2_decap_8
XFILLER_65_913 VDD VSS sg13g2_fill_2
XFILLER_83_209 VDD VSS sg13g2_fill_2
X_11048_ _11048_/Y _11048_/A _11084_/B VDD VSS sg13g2_nand2_1
XFILLER_77_773 VDD VSS sg13g2_decap_8
Xinput8 input8/X input8/A VDD VSS sg13g2_buf_1
X_14161__2403 _14161_/RESET_B VDD VSS sg13g2_tiehi
XFILLER_65_957 VDD VSS sg13g2_decap_8
X_14807_ _14807_/Q clkload81/A _14807_/D _14807_/RESET_B VDD VSS sg13g2_dfrbpq_1
XFILLER_18_862 VDD VSS sg13g2_decap_4
XFILLER_52_607 VDD VSS sg13g2_decap_8
XFILLER_33_810 VDD VSS sg13g2_fill_1
X_12999_ _12999_/Y _12996_/Y _12998_/Y _12933_/Y VDD VSS sg13g2_o21ai_1
X_14755__3346 _14755_/RESET_B VDD VSS sg13g2_tiehi
X_14738_ _14738_/Q _14738_/CLK _14738_/D _14738_/RESET_B VDD VSS sg13g2_dfrbpq_1
XFILLER_17_394 VDD VSS sg13g2_decap_8
XFILLER_36_1229 VDD VSS sg13g2_decap_8
XFILLER_71_1109 VDD VSS sg13g2_fill_2
X_14669_ _14669_/Q _14669_/CLK _14669_/D _14669_/RESET_B VDD VSS sg13g2_dfrbpq_1
X_08190_ _08190_/Y _08229_/B _08190_/B VDD VSS sg13g2_nor2_1
XFILLER_118_403 VDD VSS sg13g2_decap_4
XFILLER_119_937 VDD VSS sg13g2_decap_8
X_13657__1810 _13657_/RESET_B VDD VSS sg13g2_tiehi
XFILLER_118_425 VDD VSS sg13g2_fill_2
XFILLER_65_0 VDD VSS sg13g2_decap_8
Xmax_cap1560 _16865_/A _13703_/Q VDD VSS sg13g2_buf_8
XFILLER_106_609 VDD VSS sg13g2_decap_8
XFILLER_127_970 VDD VSS sg13g2_decap_8
XFILLER_156_1019 VDD VSS sg13g2_fill_1
XFILLER_99_386 VDD VSS sg13g2_decap_8
XFILLER_101_303 VDD VSS sg13g2_fill_2
XFILLER_141_483 VDD VSS sg13g2_decap_4
XFILLER_59_228 VDD VSS sg13g2_decap_8
XFILLER_102_848 VDD VSS sg13g2_fill_1
X_07974_ _07976_/B _08697_/B _08698_/A _07974_/C _07974_/D VDD VSS sg13g2_and4_1
XFILLER_68_751 VDD VSS sg13g2_fill_2
XFILLER_132_1030 VDD VSS sg13g2_decap_8
X_14900__3129 _14900_/RESET_B VDD VSS sg13g2_tiehi
X_09713_ _14304_/D _10143_/A1 _14304_/Q _09739_/S VDD VSS sg13g2_mux2_1
XFILLER_19_49 VDD VSS sg13g2_decap_8
XFILLER_68_762 VDD VSS sg13g2_fill_2
XFILLER_142_28 VDD VSS sg13g2_decap_8
XFILLER_27_103 VDD VSS sg13g2_decap_8
XFILLER_68_795 VDD VSS sg13g2_decap_8
XFILLER_83_721 VDD VSS sg13g2_decap_8
XFILLER_28_637 VDD VSS sg13g2_fill_2
X_09644_ _14237_/D _09908_/A1 _14237_/Q wire641/A VDD VSS sg13g2_mux2_1
XFILLER_132_1096 VDD VSS sg13g2_fill_2
XFILLER_76_1009 VDD VSS sg13g2_decap_8
X_09575_ _14172_/D _14172_/Q _10105_/A _09593_/S VDD VSS sg13g2_mux2_1
X_08526_ _08535_/B _08526_/A _08526_/B _08526_/C VDD VSS sg13g2_and3_1
XFILLER_51_640 VDD VSS sg13g2_fill_2
X_08457_ _08457_/X _07949_/C _07798_/B _07825_/B _07794_/A _08457_/S0 _08598_/S1 VDD
+ VSS sg13g2_mux4_1
XFILLER_143_7 VDD VSS sg13g2_decap_8
XFILLER_50_172 VDD VSS sg13g2_decap_8
XFILLER_51_36 VDD VSS sg13g2_decap_8
XFILLER_17_1162 VDD VSS sg13g2_decap_8
X_08388_ _08388_/Y _08374_/Y _08375_/Y _08387_/Y VDD VSS sg13g2_o21ai_1
XFILLER_51_47 VDD VSS sg13g2_fill_1
XFILLER_104_1132 VDD VSS sg13g2_fill_1
XFILLER_109_403 VDD VSS sg13g2_decap_8
XFILLER_51_69 VDD VSS sg13g2_decap_8
XFILLER_13_1048 VDD VSS sg13g2_decap_8
X_15196__3146 _15196_/RESET_B VDD VSS sg13g2_tiehi
XFILLER_137_767 VDD VSS sg13g2_fill_1
X_10350_ _14809_/D _10350_/A _10350_/B _10350_/C VDD VSS sg13g2_and3_1
XFILLER_87_1127 VDD VSS sg13g2_decap_4
XFILLER_104_1198 VDD VSS sg13g2_decap_8
X_09009_ _10697_/A _15029_/Q _15226_/Q _09034_/S VDD VSS sg13g2_mux2_1
XFILLER_118_992 VDD VSS sg13g2_decap_8
X_10281_ _10281_/Y _14786_/Q _14787_/Q _14788_/Q _10281_/D VDD VSS sg13g2_nand4_1
XFILLER_151_236 VDD VSS sg13g2_decap_8
X_12020_ _12021_/A _14706_/Q _14738_/Q _13778_/Q _13810_/Q _12025_/A _12026_/C VDD
+ VSS sg13g2_mux4_1
XFILLER_105_653 VDD VSS sg13g2_fill_1
XFILLER_2_268 VDD VSS sg13g2_decap_8
Xfanout1504 _12866_/A _12899_/A VDD VSS sg13g2_buf_1
Xfanout1515 _12942_/A _12959_/A1 VDD VSS sg13g2_buf_1
XFILLER_116_51 VDD VSS sg13g2_fill_1
XFILLER_120_623 VDD VSS sg13g2_fill_1
XFILLER_78_548 VDD VSS sg13g2_decap_4
Xfanout1526 _10564_/D _14857_/Q VDD VSS sg13g2_buf_1
Xfanout1537 _10206_/A1 _14761_/Q VDD VSS sg13g2_buf_1
XFILLER_63_1160 VDD VSS sg13g2_decap_4
Xfanout550 _09106_/S _09084_/S VDD VSS sg13g2_buf_1
XFILLER_59_751 VDD VSS sg13g2_fill_2
XFILLER_76_44 VDD VSS sg13g2_decap_8
Xfanout572 _12679_/B2 _12429_/B2 VDD VSS sg13g2_buf_1
X_13971_ _13971_/Q clkload10/A _13971_/D _13971_/RESET_B VDD VSS sg13g2_dfrbpq_1
XFILLER_63_1193 VDD VSS sg13g2_decap_8
X_14977__2995 _14977_/RESET_B VDD VSS sg13g2_tiehi
XFILLER_24_1155 VDD VSS sg13g2_decap_8
XFILLER_4_1216 VDD VSS sg13g2_decap_8
XFILLER_46_401 VDD VSS sg13g2_fill_2
Xfanout594 _10017_/S _10029_/S VDD VSS sg13g2_buf_1
XFILLER_47_946 VDD VSS sg13g2_decap_4
X_12922_ _12945_/A _14902_/Q _13685_/Q VDD VSS sg13g2_nand2_1
XFILLER_86_592 VDD VSS sg13g2_decap_4
XFILLER_101_892 VDD VSS sg13g2_fill_2
XFILLER_150_1185 VDD VSS sg13g2_decap_8
XFILLER_59_1207 VDD VSS sg13g2_fill_2
XFILLER_62_905 VDD VSS sg13g2_decap_8
XFILLER_73_253 VDD VSS sg13g2_decap_8
XFILLER_92_21 VDD VSS sg13g2_decap_4
XFILLER_74_787 VDD VSS sg13g2_decap_8
X_12853_ _12853_/Y _14770_/Q _12918_/A2 _13297_/A0 VDD VSS sg13g2_o21ai_1
XFILLER_74_798 VDD VSS sg13g2_fill_1
XFILLER_73_297 VDD VSS sg13g2_fill_2
X_11804_ _11805_/B _11804_/A _14220_/Q VDD VSS sg13g2_nand2_1
X_12784_ _12784_/X _14586_/Q _14618_/Q _14650_/Q _14682_/Q _12785_/S0 _12785_/S1 VDD
+ VSS sg13g2_mux4_1
X_14523_ _14523_/Q clkload60/A _14523_/D _14523_/RESET_B VDD VSS sg13g2_dfrbpq_1
XFILLER_25_70 VDD VSS sg13g2_decap_8
X_11735_ _11736_/A _13962_/Q _13994_/Q _14026_/Q _14058_/Q _11759_/A _11760_/C VDD
+ VSS sg13g2_mux4_1
XFILLER_42_684 VDD VSS sg13g2_fill_1
XFILLER_70_1120 VDD VSS sg13g2_decap_4
X_14454_ _14454_/Q _14678_/CLK _14454_/D _14454_/RESET_B VDD VSS sg13g2_dfrbpq_1
XFILLER_41_183 VDD VSS sg13g2_decap_8
X_11666_ _11666_/Y _11670_/S0 _13864_/Q _11686_/S1 VDD VSS sg13g2_a21oi_1
XFILLER_70_1131 VDD VSS sg13g2_fill_1
XFILLER_70_1142 VDD VSS sg13g2_fill_2
XFILLER_70_1153 VDD VSS sg13g2_decap_8
X_13405_ _13405_/Y _13440_/A _13440_/B _15090_/Q VDD VSS sg13g2_nand3_1
X_10617_ _10619_/C _10651_/D _10622_/C VDD VSS sg13g2_or2_1
X_14385_ _14385_/Q clkload50/A _14385_/D _14385_/RESET_B VDD VSS sg13g2_dfrbpq_1
X_11597_ _11598_/B _11597_/A _14214_/Q VDD VSS sg13g2_nand2_1
XFILLER_127_244 VDD VSS sg13g2_decap_8
XFILLER_128_767 VDD VSS sg13g2_decap_8
XFILLER_41_80 VDD VSS sg13g2_fill_1
X_13336_ _15172_/D hold3420/X _15172_/Q _13336_/S VDD VSS sg13g2_mux2_1
X_10548_ _14864_/D _10556_/D _13507_/A _10548_/C VDD VSS sg13g2_nor3_1
XFILLER_143_726 VDD VSS sg13g2_fill_1
XFILLER_143_748 VDD VSS sg13g2_decap_8
X_13267_ _13270_/C _14925_/Q _13662_/Q VDD VSS sg13g2_xnor2_1
X_10479_ _10505_/B _13084_/A _14847_/Q VDD VSS sg13g2_and2_1
XFILLER_29_1022 VDD VSS sg13g2_decap_8
X_15006_ _15006_/Q _15209_/CLK _15006_/D _15006_/RESET_B VDD VSS sg13g2_dfrbpq_1
X_12218_ _12223_/B _12217_/Y _12208_/Y _12217_/A _12216_/X _12221_/B1 VDD VSS sg13g2_a221oi_1
X_13868__2696 _13868_/RESET_B VDD VSS sg13g2_tiehi
X_13198_ _15046_/D _13191_/Y wire208/X _13239_/A VDD VSS sg13g2_a21oi_1
XFILLER_9_1127 VDD VSS sg13g2_decap_8
XFILLER_116_1003 VDD VSS sg13g2_decap_8
X_12149_ _14983_/D _12149_/A _12149_/B VDD VSS sg13g2_nand2_1
XFILLER_111_634 VDD VSS sg13g2_decap_8
XFILLER_69_559 VDD VSS sg13g2_decap_8
XFILLER_96_356 VDD VSS sg13g2_decap_8
XFILLER_84_507 VDD VSS sg13g2_fill_2
XFILLER_110_144 VDD VSS sg13g2_decap_8
XFILLER_49_250 VDD VSS sg13g2_decap_8
XFILLER_2_63 VDD VSS sg13g2_decap_8
XFILLER_65_710 VDD VSS sg13g2_fill_1
XFILLER_37_423 VDD VSS sg13g2_decap_8
XFILLER_38_946 VDD VSS sg13g2_decap_4
X_07690_ _07690_/X _07690_/A _08832_/D VDD VSS sg13g2_and2_1
XFILLER_64_231 VDD VSS sg13g2_decap_8
XFILLER_25_607 VDD VSS sg13g2_decap_8
XFILLER_92_562 VDD VSS sg13g2_decap_8
XFILLER_64_275 VDD VSS sg13g2_decap_8
XFILLER_64_297 VDD VSS sg13g2_fill_2
X_09360_ _13964_/D _09956_/A1 _13964_/Q _09373_/S VDD VSS sg13g2_mux2_1
XFILLER_17_191 VDD VSS sg13g2_decap_8
X_08311_ _08312_/C _08616_/B _08359_/B2 VDD VSS sg13g2_nor2b_1
XFILLER_61_982 VDD VSS sg13g2_decap_4
X_09291_ _13899_/D _13899_/Q _09922_/A1 _09306_/S VDD VSS sg13g2_mux2_1
XANTENNA_13 _16883_/A VDD VSS sg13g2_antennanp
XFILLER_127_1176 VDD VSS sg13g2_decap_4
X_08242_ _08688_/B _08242_/A _08270_/B VDD VSS sg13g2_nand2_1
X_08173_ _08514_/A _08340_/B _08173_/B VDD VSS sg13g2_nand2_1
XFILLER_21_28 VDD VSS sg13g2_decap_8
XFILLER_137_28 VDD VSS sg13g2_decap_8
X_13681__2895 _13681_/RESET_B VDD VSS sg13g2_tiehi
XFILLER_133_214 VDD VSS sg13g2_fill_2
XFILLER_12_1081 VDD VSS sg13g2_decap_8
Xoutput120 mem_axi_wdata[24] _15156_/Q VDD VSS sg13g2_buf_1
Xoutput131 mem_axi_wdata[5] _15137_/Q VDD VSS sg13g2_buf_1
XFILLER_86_1171 VDD VSS sg13g2_fill_1
XFILLER_142_770 VDD VSS sg13g2_decap_8
XFILLER_87_323 VDD VSS sg13g2_fill_1
XFILLER_88_846 VDD VSS sg13g2_decap_8
XFILLER_82_1057 VDD VSS sg13g2_fill_1
XFILLER_101_111 VDD VSS sg13g2_fill_1
XFILLER_141_280 VDD VSS sg13g2_decap_4
XFILLER_87_334 VDD VSS sg13g2_fill_2
XFILLER_153_49 VDD VSS sg13g2_decap_8
XFILLER_75_518 VDD VSS sg13g2_decap_8
X_07957_ _07958_/A _08567_/A _07956_/Y _07950_/Y _07829_/A _07954_/Y VDD VSS sg13g2_a221oi_1
XFILLER_130_998 VDD VSS sg13g2_decap_8
XFILLER_29_924 VDD VSS sg13g2_fill_1
XFILLER_75_529 VDD VSS sg13g2_fill_2
XFILLER_28_412 VDD VSS sg13g2_decap_8
XFILLER_46_14 VDD VSS sg13g2_decap_8
XFILLER_101_188 VDD VSS sg13g2_decap_4
XFILLER_28_434 VDD VSS sg13g2_decap_8
X_07888_ _08229_/C _08203_/B _07888_/B VDD VSS sg13g2_nand2_1
XFILLER_83_540 VDD VSS sg13g2_decap_4
X_13913__2651 _13913_/RESET_B VDD VSS sg13g2_tiehi
XFILLER_44_905 VDD VSS sg13g2_fill_1
X_14673__1891 _14673_/RESET_B VDD VSS sg13g2_tiehi
XFILLER_56_776 VDD VSS sg13g2_decap_8
X_09627_ _14223_/D _10158_/A1 _14223_/Q _09631_/S VDD VSS sg13g2_mux2_1
X_14844__3241 _14844_/RESET_B VDD VSS sg13g2_tiehi
X_09558_ _14156_/D _09923_/A1 _14156_/Q _09564_/S VDD VSS sg13g2_mux2_1
XFILLER_43_459 VDD VSS sg13g2_fill_1
XFILLER_93_1153 VDD VSS sg13g2_fill_2
XFILLER_102_75 VDD VSS sg13g2_fill_2
X_14257__2307 _14257_/RESET_B VDD VSS sg13g2_tiehi
XFILLER_24_662 VDD VSS sg13g2_decap_8
X_08509_ _08517_/B _08034_/A _08170_/X _08518_/B1 VDD VSS sg13g2_o21ai_1
XFILLER_12_813 VDD VSS sg13g2_fill_1
X_09489_ _14089_/D _10085_/A0 _14089_/Q _09503_/S VDD VSS sg13g2_mux2_1
XFILLER_52_993 VDD VSS sg13g2_decap_4
XFILLER_12_835 VDD VSS sg13g2_fill_2
XFILLER_141_1107 VDD VSS sg13g2_fill_1
XFILLER_11_323 VDD VSS sg13g2_decap_8
X_11520_ _11520_/Y _14902_/Q _11655_/B _11521_/B2 VDD VSS sg13g2_a21oi_1
XFILLER_141_1118 VDD VSS sg13g2_fill_1
X_14877__3175 _14877_/RESET_B VDD VSS sg13g2_tiehi
X_11451_ _11451_/Y _11450_/Y _11448_/X _11433_/Y VDD VSS sg13g2_o21ai_1
XFILLER_7_338 VDD VSS sg13g2_decap_8
XFILLER_149_391 VDD VSS sg13g2_fill_2
Xwire269 wire269/X wire269/A VDD VSS sg13g2_buf_1
X_10402_ _10402_/Y _14823_/Q _10404_/A2 _10557_/C VDD VSS sg13g2_o21ai_1
X_14170_ _14170_/Q clkload57/A _14170_/D _14170_/RESET_B VDD VSS sg13g2_dfrbpq_1
X_11382_ _11385_/A _11339_/B _11335_/X _11336_/A VDD VSS sg13g2_a21oi_1
X_13121_ _13121_/Y _14819_/Q _13068_/B _13162_/A2 _14851_/Q VDD VSS sg13g2_a22oi_1
XFILLER_124_214 VDD VSS sg13g2_decap_4
X_10333_ _10335_/B _14803_/Q _14804_/Q _10405_/C _10345_/C VDD VSS sg13g2_nand4_1
XFILLER_152_556 VDD VSS sg13g2_fill_2
XFILLER_106_951 VDD VSS sg13g2_decap_8
XFILLER_139_1058 VDD VSS sg13g2_fill_1
X_13052_ _13052_/Y _10504_/C _13162_/A2 _13028_/B _14878_/Q _13051_/X VDD VSS sg13g2_a221oi_1
XFILLER_79_802 VDD VSS sg13g2_decap_8
X_10264_ _10266_/C _14782_/Q _10268_/D _14783_/Q VDD VSS sg13g2_a21oi_1
XFILLER_105_450 VDD VSS sg13g2_decap_8
XFILLER_152_1203 VDD VSS sg13g2_decap_8
X_12003_ _12003_/Y _13142_/A _11792_/B _12051_/A1 VDD VSS sg13g2_a21oi_1
Xfanout1301 _08751_/A2 _15068_/Q VDD VSS sg13g2_buf_1
X_10195_ _15198_/D input25/X _15198_/Q _10205_/S VDD VSS sg13g2_mux2_1
Xfanout1312 _09707_/B _10004_/B VDD VSS sg13g2_buf_1
XFILLER_132_291 VDD VSS sg13g2_fill_1
Xfanout1323 _13305_/A _09039_/B VDD VSS sg13g2_buf_1
Xfanout1334 _08832_/D _11241_/C VDD VSS sg13g2_buf_1
XFILLER_87_98 VDD VSS sg13g2_decap_8
XFILLER_121_976 VDD VSS sg13g2_decap_8
Xfanout1345 _13545_/A _14996_/Q VDD VSS sg13g2_buf_1
XFILLER_8_1160 VDD VSS sg13g2_decap_8
Xfanout1356 _08270_/B _08599_/A VDD VSS sg13g2_buf_1
Xfanout1367 _08599_/B _08213_/S VDD VSS sg13g2_buf_1
XFILLER_66_529 VDD VSS sg13g2_decap_8
Xfanout1378 _08598_/S1 _08044_/S1 VDD VSS sg13g2_buf_1
XFILLER_115_1080 VDD VSS sg13g2_decap_8
X_13954_ _13954_/Q clkload6/A _13954_/D _13954_/RESET_B VDD VSS sg13g2_dfrbpq_1
XFILLER_74_540 VDD VSS sg13g2_decap_4
X_12905_ _12943_/A _14901_/Q _13686_/Q VDD VSS sg13g2_nor2_1
X_13885_ _13885_/Q clkload53/A _13885_/D _13885_/RESET_B VDD VSS sg13g2_dfrbpq_1
XFILLER_47_798 VDD VSS sg13g2_fill_1
XFILLER_62_724 VDD VSS sg13g2_decap_8
XFILLER_74_584 VDD VSS sg13g2_fill_2
XFILLER_98_1097 VDD VSS sg13g2_fill_2
XFILLER_36_80 VDD VSS sg13g2_decap_4
XFILLER_61_234 VDD VSS sg13g2_fill_1
X_12836_ _12836_/Y _14895_/Q _12836_/B _12836_/C VDD VSS sg13g2_nand3_1
XFILLER_50_919 VDD VSS sg13g2_decap_8
XFILLER_62_779 VDD VSS sg13g2_fill_2
Xclkbuf_5_13__f_clk_i clkbuf_leaf_88_clk_i/A clkbuf_4_6_0_clk_i/X VDD VSS sg13g2_buf_16
XFILLER_72_1204 VDD VSS sg13g2_fill_1
X_12767_ _12767_/X _13753_/Q _14105_/Q _14457_/Q _14553_/Q _12770_/S0 _12770_/S1 VDD
+ VSS sg13g2_mux4_1
X_14506_ _14506_/Q _14506_/CLK _14506_/D _14506_/RESET_B VDD VSS sg13g2_dfrbpq_1
X_11718_ _11718_/X _11710_/X _11711_/X _11714_/X _11715_/X wire964/X _12173_/B1 VDD
+ VSS sg13g2_mux4_1
XFILLER_42_492 VDD VSS sg13g2_decap_8
XFILLER_30_643 VDD VSS sg13g2_decap_4
X_12698_ _12698_/X _14388_/Q _14420_/Q _14484_/Q _14516_/Q _12703_/S0 _12703_/S1 VDD
+ VSS sg13g2_mux4_1
X_14437_ _14437_/Q clkload0/A _14437_/D _14437_/RESET_B VDD VSS sg13g2_dfrbpq_1
XFILLER_35_1070 VDD VSS sg13g2_decap_8
Xinput11 input11/X input11/A VDD VSS sg13g2_buf_1
X_11649_ _11649_/X _14375_/Q _14407_/Q _14471_/Q _14503_/Q _12207_/S0 _12207_/S1 VDD
+ VSS sg13g2_mux4_1
Xinput22 input22/X input22/A VDD VSS sg13g2_buf_1
Xinput33 input33/X input33/A VDD VSS sg13g2_buf_1
X_14368_ _14368_/Q _14917_/CLK _14368_/D _14368_/RESET_B VDD VSS sg13g2_dfrbpq_1
XFILLER_155_361 VDD VSS sg13g2_decap_8
XFILLER_7_872 VDD VSS sg13g2_decap_8
Xmax_cap503 _09269_/S _09270_/S VDD VSS sg13g2_buf_4
X_13955__2609 _13955_/RESET_B VDD VSS sg13g2_tiehi
Xmax_cap514 _09200_/S _09196_/S VDD VSS sg13g2_buf_4
XFILLER_115_214 VDD VSS sg13g2_fill_1
X_13319_ _15063_/D _13319_/A _13319_/B VDD VSS sg13g2_nor2_1
XFILLER_143_534 VDD VSS sg13g2_fill_2
Xmax_cap547 _09153_/S _09127_/S VDD VSS sg13g2_buf_4
X_14299_ _14299_/Q _15188_/CLK _14299_/D _14299_/RESET_B VDD VSS sg13g2_dfrbpq_1
Xmax_cap558 _13374_/A1 _13361_/C VDD VSS sg13g2_buf_2
XFILLER_103_409 VDD VSS sg13g2_decap_4
XFILLER_124_781 VDD VSS sg13g2_decap_8
X_08860_ _08860_/X _08859_/X _11483_/A _08882_/S VDD VSS sg13g2_mux2_1
XFILLER_97_654 VDD VSS sg13g2_decap_8
XFILLER_85_805 VDD VSS sg13g2_decap_4
X_14335__2229 _14335_/RESET_B VDD VSS sg13g2_tiehi
XFILLER_28_0 VDD VSS sg13g2_decap_8
X_07811_ _08522_/A _13566_/A _07812_/B VDD VSS sg13g2_or2_1
XFILLER_85_816 VDD VSS sg13g2_fill_2
X_08791_ _08791_/Y _13499_/C _15176_/Q _15119_/Q _13345_/B _08825_/C1 VDD VSS sg13g2_a221oi_1
XFILLER_112_998 VDD VSS sg13g2_decap_8
XFILLER_42_1041 VDD VSS sg13g2_decap_8
XFILLER_81_1090 VDD VSS sg13g2_fill_2
XFILLER_84_326 VDD VSS sg13g2_fill_2
X_07742_ _07744_/C _13300_/C wire911/X VDD VSS sg13g2_and2_1
XFILLER_42_1096 VDD VSS sg13g2_fill_2
XFILLER_93_882 VDD VSS sg13g2_fill_1
X_07673_ _07677_/B _15055_/Q _11243_/B VDD VSS sg13g2_nor2b_1
X_15177__3244 _15177_/RESET_B VDD VSS sg13g2_tiehi
XFILLER_16_28 VDD VSS sg13g2_decap_8
XFILLER_65_595 VDD VSS sg13g2_decap_4
X_14550__2014 _14550_/RESET_B VDD VSS sg13g2_tiehi
XFILLER_77_1148 VDD VSS sg13g2_decap_8
X_09412_ _14014_/D _09744_/A1 _14014_/Q _09431_/S VDD VSS sg13g2_mux2_1
XFILLER_80_532 VDD VSS sg13g2_fill_2
XFILLER_41_908 VDD VSS sg13g2_fill_2
XFILLER_80_576 VDD VSS sg13g2_decap_8
X_09343_ _13947_/D _09741_/A1 _13947_/Q wire689/A VDD VSS sg13g2_mux2_1
XFILLER_33_470 VDD VSS sg13g2_fill_2
XFILLER_52_289 VDD VSS sg13g2_fill_1
XFILLER_61_790 VDD VSS sg13g2_fill_2
X_09274_ _09274_/Y _09307_/B _09707_/B _09707_/C VDD VSS sg13g2_nor3_2
XFILLER_20_142 VDD VSS sg13g2_fill_2
X_08225_ _08233_/B _08224_/X _08397_/A _08359_/B2 _08214_/X VDD VSS sg13g2_a22oi_1
XFILLER_148_49 VDD VSS sg13g2_decap_8
XFILLER_147_873 VDD VSS sg13g2_decap_8
XFILLER_10_1007 VDD VSS sg13g2_decap_8
X_08156_ _08166_/C _08188_/A _08456_/A _08155_/Y _07869_/X _08154_/Y VDD VSS sg13g2_a221oi_1
XFILLER_14_1176 VDD VSS sg13g2_decap_8
XFILLER_49_1206 VDD VSS sg13g2_fill_1
XFILLER_106_225 VDD VSS sg13g2_decap_8
X_08087_ _08087_/X _08085_/A _08079_/X _08086_/B _08081_/X _08244_/B _08198_/S VDD
+ VSS sg13g2_mux4_1
XFILLER_106_7 VDD VSS sg13g2_decap_8
XFILLER_106_247 VDD VSS sg13g2_decap_8
XFILLER_134_589 VDD VSS sg13g2_decap_8
Xhold3420 hold3420/X input29/X VDD VSS sg13g2_dlygate4sd3_1
Xhold3431 wire1799/A input24/X VDD VSS sg13g2_dlygate4sd3_1
XFILLER_88_632 VDD VSS sg13g2_fill_1
Xhold3442 input8/A mem_axi_rdata[13] VDD VSS sg13g2_dlygate4sd3_1
XFILLER_0_547 VDD VSS sg13g2_fill_1
Xhold3453 input16/A mem_axi_rdata[20] VDD VSS sg13g2_dlygate4sd3_1
XFILLER_87_142 VDD VSS sg13g2_decap_8
Xhold3464 _10185_/C _10184_/X VDD VSS sg13g2_dlygate4sd3_1
Xhold3475 _10837_/A _14930_/Q VDD VSS sg13g2_dlygate4sd3_1
XFILLER_103_976 VDD VSS sg13g2_decap_8
XFILLER_57_35 VDD VSS sg13g2_decap_4
XFILLER_103_987 VDD VSS sg13g2_decap_4
X_14750__3351 _14750_/RESET_B VDD VSS sg13g2_tiehi
Xhold3486 _13632_/A _13740_/Q VDD VSS sg13g2_dlygate4sd3_1
X_08989_ _08989_/X _08988_/A _08985_/X _08988_/Y VDD VSS sg13g2_a21o_1
Xhold3497 _13641_/A _13749_/Q VDD VSS sg13g2_dlygate4sd3_1
XFILLER_29_721 VDD VSS sg13g2_decap_8
XFILLER_60_1141 VDD VSS sg13g2_fill_2
XFILLER_21_1103 VDD VSS sg13g2_decap_8
XFILLER_75_348 VDD VSS sg13g2_decap_8
XFILLER_29_776 VDD VSS sg13g2_decap_8
XFILLER_84_860 VDD VSS sg13g2_fill_1
XFILLER_1_1219 VDD VSS sg13g2_decap_8
X_10951_ _10956_/A _11004_/A _10949_/Y _10950_/Y VDD VSS sg13g2_o21ai_1
XFILLER_113_63 VDD VSS sg13g2_decap_8
XFILLER_71_532 VDD VSS sg13g2_fill_2
XFILLER_3_1090 VDD VSS sg13g2_decap_8
XFILLER_44_757 VDD VSS sg13g2_fill_2
X_13670_ _13670_/Q clkload64/A _13670_/D _13670_/RESET_B VDD VSS sg13g2_dfrbpq_1
XFILLER_44_768 VDD VSS sg13g2_fill_1
X_10882_ _10883_/B _14753_/Q _10871_/A _10869_/B VDD VSS sg13g2_a21oi_1
XFILLER_32_919 VDD VSS sg13g2_fill_1
X_12621_ _12621_/X _12620_/X _12619_/X _12616_/X _12615_/X _12789_/S0 _12788_/S1 VDD
+ VSS sg13g2_mux4_1
XFILLER_31_418 VDD VSS sg13g2_decap_8
XFILLER_52_790 VDD VSS sg13g2_fill_2
XFILLER_19_1065 VDD VSS sg13g2_decap_8
X_12552_ _12552_/X _12550_/X _12549_/X _12546_/X _12545_/X _12733_/S0 _12455_/S VDD
+ VSS sg13g2_mux4_1
XFILLER_40_963 VDD VSS sg13g2_decap_8
X_15066__3262 _15066_/RESET_B VDD VSS sg13g2_tiehi
XFILLER_132_0 VDD VSS sg13g2_decap_8
X_11503_ _11777_/C _11461_/A _13687_/Q _13686_/Q _11483_/A _11463_/Y VDD VSS sg13g2_a221oi_1
XFILLER_32_1232 VDD VSS sg13g2_decap_4
X_12483_ _12483_/X _12481_/X _12482_/X _12483_/S VDD VSS sg13g2_mux2_1
X_14222_ _14222_/Q _14763_/CLK _14222_/D _14222_/RESET_B VDD VSS sg13g2_dfrbpq_1
X_11434_ _11434_/X _14112_/Q _14144_/Q _14176_/Q _14208_/Q _12213_/S0 _12169_/C VDD
+ VSS sg13g2_mux4_1
X_14153_ _14153_/Q _14678_/CLK _14153_/D _14153_/RESET_B VDD VSS sg13g2_dfrbpq_1
X_11365_ _11366_/B _11365_/A _14494_/Q VDD VSS sg13g2_nand2_1
XFILLER_152_331 VDD VSS sg13g2_decap_4
XFILLER_98_42 VDD VSS sg13g2_decap_8
X_13104_ _13104_/Y _13104_/A _13104_/B VDD VSS sg13g2_xnor2_1
X_10316_ _14798_/D _10330_/A _10342_/C _10315_/Y VDD VSS sg13g2_a21oi_1
X_14084_ _14084_/Q clkload23/A _14084_/D _14084_/RESET_B VDD VSS sg13g2_dfrbpq_1
XFILLER_98_75 VDD VSS sg13g2_decap_8
X_11296_ _11296_/Y _11300_/S0 _13853_/Q _11391_/B VDD VSS sg13g2_a21oi_1
XFILLER_112_217 VDD VSS sg13g2_decap_8
X_13035_ wire237/A _13034_/Y _13035_/A2 _13031_/Y VDD VSS sg13g2_a21oi_1
X_10247_ _10255_/D _14775_/Q _14776_/Q _14777_/Q wire762/X VDD VSS sg13g2_and4_1
XFILLER_154_70 VDD VSS sg13g2_decap_8
XFILLER_67_805 VDD VSS sg13g2_fill_2
Xfanout1120 fanout1120/X _15211_/Q VDD VSS sg13g2_buf_1
XFILLER_78_153 VDD VSS sg13g2_decap_8
Xfanout1131 _12661_/S1 fanout1135/X VDD VSS sg13g2_buf_1
Xfanout1142 _12782_/S1 _15211_/Q VDD VSS sg13g2_buf_1
XFILLER_26_1058 VDD VSS sg13g2_decap_8
XFILLER_21_7 VDD VSS sg13g2_decap_8
XFILLER_94_613 VDD VSS sg13g2_decap_8
X_10178_ _10182_/A _10178_/A _10185_/B _10184_/C VDD VSS sg13g2_nand3_1
XFILLER_113_1028 VDD VSS sg13g2_decap_4
Xclkbuf_leaf_7_clk_i clkload11/A clkbuf_leaf_9_clk_i/A VDD VSS sg13g2_buf_8
Xfanout1164 _12424_/S0 _12703_/S0 VDD VSS sg13g2_buf_1
Xfanout1175 _12536_/S0 _12480_/S0 VDD VSS sg13g2_buf_1
XFILLER_94_657 VDD VSS sg13g2_decap_4
Xfanout1186 _12771_/S0 _12773_/S0 VDD VSS sg13g2_buf_1
Xfanout1197 _12604_/S0 _12661_/S0 VDD VSS sg13g2_buf_1
X_15053__2904 _15053_/RESET_B VDD VSS sg13g2_tiehi
X_14986_ _14986_/Q _15248_/CLK _14986_/D _14986_/RESET_B VDD VSS sg13g2_dfrbpq_1
XFILLER_75_871 VDD VSS sg13g2_fill_1
XFILLER_75_882 VDD VSS sg13g2_decap_8
X_13937_ _13937_/Q _14509_/CLK _13937_/D _13937_/RESET_B VDD VSS sg13g2_dfrbpq_1
X_13868_ _13868_/Q clkload54/A _13868_/D _13868_/RESET_B VDD VSS sg13g2_dfrbpq_1
XFILLER_23_919 VDD VSS sg13g2_decap_8
XFILLER_62_587 VDD VSS sg13g2_decap_8
X_12819_ _12819_/Y _14768_/Q _12918_/A2 _13297_/A0 VDD VSS sg13g2_o21ai_1
X_13799_ _13799_/Q _14725_/CLK _13799_/D _13799_/RESET_B VDD VSS sg13g2_dfrbpq_1
XFILLER_31_941 VDD VSS sg13g2_decap_8
XFILLER_148_615 VDD VSS sg13g2_fill_1
XFILLER_33_1007 VDD VSS sg13g2_decap_8
X_15198__3138 _15198_/RESET_B VDD VSS sg13g2_tiehi
XFILLER_124_1179 VDD VSS sg13g2_fill_2
X_08010_ _08010_/Y _08046_/B _08653_/B VDD VSS sg13g2_nand2_1
XFILLER_8_84 VDD VSS sg13g2_decap_8
Xmax_cap333 _09604_/S _09578_/S VDD VSS sg13g2_buf_4
XFILLER_144_865 VDD VSS sg13g2_decap_8
XFILLER_143_342 VDD VSS sg13g2_fill_2
X_09961_ _14545_/D _14545_/Q _09994_/A0 _09961_/S VDD VSS sg13g2_mux2_1
XFILLER_131_537 VDD VSS sg13g2_decap_8
X_08912_ _08912_/Y _08966_/A _08959_/B _15041_/Q VDD VSS sg13g2_nand3_1
XFILLER_131_548 VDD VSS sg13g2_fill_2
XFILLER_135_1220 VDD VSS sg13g2_decap_8
X_09892_ _14478_/D _09892_/A0 _14478_/Q _09904_/S VDD VSS sg13g2_mux2_1
XFILLER_44_1125 VDD VSS sg13g2_fill_1
XFILLER_69_131 VDD VSS sg13g2_decap_8
XFILLER_97_440 VDD VSS sg13g2_fill_1
XFILLER_58_827 VDD VSS sg13g2_decap_8
XFILLER_69_164 VDD VSS sg13g2_decap_4
X_08843_ _08843_/Y _11384_/A _08871_/S VDD VSS sg13g2_nand2_1
XFILLER_57_326 VDD VSS sg13g2_fill_1
XFILLER_111_272 VDD VSS sg13g2_fill_2
XFILLER_131_1139 VDD VSS sg13g2_decap_8
XFILLER_69_197 VDD VSS sg13g2_decap_4
XFILLER_85_657 VDD VSS sg13g2_decap_8
X_08774_ _13676_/D _08780_/A1 _08773_/Y _08772_/Y VDD VSS sg13g2_a21oi_1
XFILLER_27_49 VDD VSS sg13g2_fill_2
X_07725_ _07726_/D _15089_/Q _15086_/Q _15076_/Q _15074_/Q VDD VSS sg13g2_nor4_1
XFILLER_150_28 VDD VSS sg13g2_decap_8
XFILLER_38_595 VDD VSS sg13g2_decap_4
X_07656_ _07656_/Y _12000_/A VDD VSS sg13g2_inv_1
XFILLER_81_852 VDD VSS sg13g2_decap_8
XFILLER_81_874 VDD VSS sg13g2_fill_2
XFILLER_20_1191 VDD VSS sg13g2_decap_8
XFILLER_41_716 VDD VSS sg13g2_decap_8
XFILLER_81_885 VDD VSS sg13g2_fill_2
XFILLER_129_1057 VDD VSS sg13g2_decap_4
XFILLER_80_384 VDD VSS sg13g2_decap_8
XFILLER_40_226 VDD VSS sg13g2_fill_1
XFILLER_40_237 VDD VSS sg13g2_decap_8
X_09326_ _13933_/D _10156_/A1 _13933_/Q _09330_/S VDD VSS sg13g2_mux2_1
XFILLER_16_1205 VDD VSS sg13g2_decap_8
XFILLER_142_1224 VDD VSS sg13g2_decap_8
XFILLER_139_615 VDD VSS sg13g2_fill_2
XFILLER_22_974 VDD VSS sg13g2_decap_8
XFILLER_142_1235 VDD VSS sg13g2_fill_2
X_09257_ _13866_/D _13866_/Q _10153_/A1 _09269_/S VDD VSS sg13g2_mux2_1
X_08208_ _08209_/A _08452_/A _08207_/X _08452_/D VDD VSS sg13g2_mux2_1
X_09188_ _13804_/D _13804_/Q _10155_/A1 _09193_/S VDD VSS sg13g2_mux2_1
XFILLER_4_105 VDD VSS sg13g2_decap_8
X_08139_ _08182_/B _08142_/C _08140_/B VDD VSS sg13g2_nor2_1
XFILLER_49_1036 VDD VSS sg13g2_fill_2
XFILLER_150_813 VDD VSS sg13g2_decap_4
X_11150_ _11150_/Y _11150_/A _11150_/B VDD VSS sg13g2_nand2_1
XFILLER_89_930 VDD VSS sg13g2_fill_2
X_10101_ _14681_/D _10101_/A0 _14681_/Q _10101_/S VDD VSS sg13g2_mux2_1
X_11081_ _11081_/Y _11191_/A _11077_/Y _11080_/Y VDD VSS sg13g2_a21oi_1
XFILLER_49_805 VDD VSS sg13g2_decap_8
XFILLER_76_602 VDD VSS sg13g2_decap_8
X_10032_ _14614_/D _10098_/A0 _14614_/Q _10033_/S VDD VSS sg13g2_mux2_1
XFILLER_48_304 VDD VSS sg13g2_decap_8
XFILLER_48_315 VDD VSS sg13g2_fill_2
XFILLER_124_40 VDD VSS sg13g2_fill_1
XFILLER_0_399 VDD VSS sg13g2_decap_8
X_14840_ _14840_/Q clkload81/A _14840_/D _14840_/RESET_B VDD VSS sg13g2_dfrbpq_1
XFILLER_17_702 VDD VSS sg13g2_decap_8
XFILLER_84_44 VDD VSS sg13g2_fill_1
X_14771_ _14771_/Q clkload74/A _14771_/D _14771_/RESET_B VDD VSS sg13g2_dfrbpq_1
XFILLER_16_201 VDD VSS sg13g2_fill_1
XFILLER_5_1185 VDD VSS sg13g2_decap_8
XFILLER_84_66 VDD VSS sg13g2_decap_8
X_11983_ _12055_/C _11983_/A _13671_/Q VDD VSS sg13g2_xnor2_1
X_13722_ _13722_/Q clkload34/A _13722_/D _13722_/RESET_B VDD VSS sg13g2_dfrbpq_1
X_10934_ _10934_/Y _10946_/A _10934_/B _10948_/D VDD VSS sg13g2_nand3_1
XFILLER_95_1045 VDD VSS sg13g2_decap_8
XFILLER_56_1007 VDD VSS sg13g2_decap_8
XFILLER_147_1124 VDD VSS sg13g2_decap_8
XFILLER_56_1029 VDD VSS sg13g2_decap_8
XFILLER_147_1157 VDD VSS sg13g2_fill_2
XFILLER_31_204 VDD VSS sg13g2_decap_8
X_13653_ _15119_/D _15189_/D _15119_/Q _13653_/S VDD VSS sg13g2_mux2_1
X_10865_ _10865_/Y _10865_/A _10865_/B VDD VSS sg13g2_nand2_1
XFILLER_31_226 VDD VSS sg13g2_decap_8
X_12604_ _12604_/X _14701_/Q _14733_/Q _13773_/Q _13805_/Q _12604_/S0 _12604_/S1 VDD
+ VSS sg13g2_mux4_1
XFILLER_31_259 VDD VSS sg13g2_decap_8
X_13584_ _13584_/Y _15160_/Q _13590_/B VDD VSS sg13g2_nor2_1
X_10796_ _10796_/Y _10796_/A _10800_/B VDD VSS sg13g2_nand2_1
XFILLER_13_985 VDD VSS sg13g2_decap_8
X_12535_ _12535_/X _13832_/Q _13864_/Q _13896_/Q _13928_/Q _12535_/S0 _12536_/S1 VDD
+ VSS sg13g2_mux4_1
XFILLER_33_92 VDD VSS sg13g2_decap_4
XFILLER_149_70 VDD VSS sg13g2_decap_8
XFILLER_9_978 VDD VSS sg13g2_decap_8
XFILLER_129_158 VDD VSS sg13g2_decap_8
X_12466_ _12466_/X _13955_/Q _13987_/Q _14019_/Q _14051_/Q _12546_/S0 _12546_/S1 VDD
+ VSS sg13g2_mux4_1
XFILLER_69_7 VDD VSS sg13g2_decap_8
XFILLER_126_821 VDD VSS sg13g2_decap_4
X_14205_ _14205_/Q _14525_/CLK _14205_/D _14205_/RESET_B VDD VSS sg13g2_dfrbpq_1
XFILLER_144_139 VDD VSS sg13g2_decap_4
X_11417_ _11419_/A _11418_/A _14175_/Q VDD VSS sg13g2_nand2b_1
X_15185_ _15185_/Q clkload73/A _15185_/D _15185_/RESET_B VDD VSS sg13g2_dfrbpq_1
X_12397_ _12397_/X _12392_/X _12394_/X _12391_/X _12393_/X _12788_/S1 _12789_/S0 VDD
+ VSS sg13g2_mux4_1
X_14037__2527 _14037_/RESET_B VDD VSS sg13g2_tiehi
X_14136_ _14136_/Q clkload32/A _14136_/D _14136_/RESET_B VDD VSS sg13g2_dfrbpq_1
XFILLER_113_504 VDD VSS sg13g2_decap_8
X_11348_ _11348_/Y _11348_/A1 _14718_/Q _11374_/C VDD VSS sg13g2_a21oi_1
XFILLER_154_1106 VDD VSS sg13g2_decap_8
XFILLER_152_161 VDD VSS sg13g2_fill_2
XFILLER_153_695 VDD VSS sg13g2_decap_8
XFILLER_98_226 VDD VSS sg13g2_decap_4
XFILLER_113_548 VDD VSS sg13g2_fill_1
X_14067_ _14067_/Q clkload10/A _14067_/D _14067_/RESET_B VDD VSS sg13g2_dfrbpq_1
X_11279_ _11279_/Y _11277_/S _14204_/Q _11279_/B1 VDD VSS sg13g2_a21oi_1
XFILLER_140_345 VDD VSS sg13g2_fill_1
XFILLER_3_193 VDD VSS sg13g2_fill_2
XFILLER_95_900 VDD VSS sg13g2_decap_8
X_13018_ _13018_/Y input25/X _12795_/Y _12937_/Y VDD VSS sg13g2_o21ai_1
XFILLER_67_624 VDD VSS sg13g2_decap_8
XFILLER_66_112 VDD VSS sg13g2_decap_4
XFILLER_94_432 VDD VSS sg13g2_decap_4
XFILLER_67_657 VDD VSS sg13g2_fill_2
X_14252__2312 _14252_/RESET_B VDD VSS sg13g2_tiehi
XFILLER_95_977 VDD VSS sg13g2_decap_8
XFILLER_95_988 VDD VSS sg13g2_fill_1
XFILLER_78_1210 VDD VSS sg13g2_decap_8
X_14969_ _14969_/Q clkload38/A _14969_/D _14969_/RESET_B VDD VSS sg13g2_dfrbpq_1
X_08490_ _08490_/Y _08489_/Y _08488_/Y _08539_/B1 VDD VSS sg13g2_a21oi_1
XFILLER_81_159 VDD VSS sg13g2_decap_8
XFILLER_90_671 VDD VSS sg13g2_decap_8
XFILLER_90_682 VDD VSS sg13g2_fill_1
X_14285__2279 _14285_/RESET_B VDD VSS sg13g2_tiehi
XFILLER_149_902 VDD VSS sg13g2_fill_2
XFILLER_50_546 VDD VSS sg13g2_decap_8
XFILLER_22_248 VDD VSS sg13g2_fill_1
XFILLER_95_0 VDD VSS sg13g2_decap_4
XFILLER_22_259 VDD VSS sg13g2_decap_8
X_09111_ _09111_/Y _09159_/A1 _10757_/B _09110_/X VDD VSS sg13g2_o21ai_1
XFILLER_149_968 VDD VSS sg13g2_fill_1
XFILLER_31_793 VDD VSS sg13g2_fill_1
XFILLER_148_467 VDD VSS sg13g2_decap_8
XFILLER_50_1140 VDD VSS sg13g2_decap_8
X_09042_ _09043_/B _14907_/Q _14906_/Q VDD VSS sg13g2_nand2_1
XFILLER_129_670 VDD VSS sg13g2_fill_2
XFILLER_117_832 VDD VSS sg13g2_fill_1
Xclkbuf_leaf_108_clk_i _15248_/CLK clkbuf_leaf_88_clk_i/A VDD VSS sg13g2_buf_8
XFILLER_116_331 VDD VSS sg13g2_fill_2
XFILLER_128_191 VDD VSS sg13g2_decap_4
XFILLER_11_1168 VDD VSS sg13g2_decap_8
XFILLER_144_673 VDD VSS sg13g2_decap_8
XFILLER_104_504 VDD VSS sg13g2_decap_8
XFILLER_145_28 VDD VSS sg13g2_decap_8
XFILLER_104_515 VDD VSS sg13g2_fill_2
XFILLER_1_119 VDD VSS sg13g2_decap_8
XFILLER_131_312 VDD VSS sg13g2_decap_8
XFILLER_132_846 VDD VSS sg13g2_decap_4
X_09944_ _14528_/D _14528_/Q _09977_/A0 _09967_/S VDD VSS sg13g2_mux2_1
Xfanout913 _12918_/A2 _13275_/A2 VDD VSS sg13g2_buf_1
Xfanout924 _11168_/B1 _10985_/B1 VDD VSS sg13g2_buf_1
Xfanout935 _12156_/A _12146_/B1 VDD VSS sg13g2_buf_1
Xfanout946 _11664_/A wire947/X VDD VSS sg13g2_buf_1
X_09875_ _14461_/D _09908_/A1 _14461_/Q _09877_/S VDD VSS sg13g2_mux2_1
Xfanout957 _12192_/A _11765_/A VDD VSS sg13g2_buf_1
Xfanout968 _12172_/B _12113_/C1 VDD VSS sg13g2_buf_1
XFILLER_57_112 VDD VSS sg13g2_decap_8
XFILLER_97_281 VDD VSS sg13g2_decap_8
Xfanout979 _11822_/B _11422_/B VDD VSS sg13g2_buf_1
XFILLER_57_134 VDD VSS sg13g2_decap_8
X_08826_ _08826_/Y _12836_/B _13481_/C VDD VSS sg13g2_nor2_1
X_13735__2829 _13735_/RESET_B VDD VSS sg13g2_tiehi
XFILLER_45_318 VDD VSS sg13g2_decap_8
XFILLER_57_178 VDD VSS sg13g2_decap_8
XFILLER_100_787 VDD VSS sg13g2_decap_8
X_08757_ _08757_/Y _13343_/B _11288_/A _15191_/Q VDD VSS sg13g2_o21ai_1
XFILLER_100_798 VDD VSS sg13g2_decap_8
XFILLER_54_14 VDD VSS sg13g2_decap_8
XFILLER_72_137 VDD VSS sg13g2_decap_8
XFILLER_38_392 VDD VSS sg13g2_decap_4
X_07708_ _07708_/Y _07708_/A _07708_/B _07708_/C VDD VSS sg13g2_nor3_1
XFILLER_26_543 VDD VSS sg13g2_fill_2
X_08688_ _08693_/A _08688_/A _08688_/B _08688_/C _08688_/D VDD VSS sg13g2_nand4_1
XFILLER_26_565 VDD VSS sg13g2_decap_8
XFILLER_54_874 VDD VSS sg13g2_decap_4
XFILLER_14_716 VDD VSS sg13g2_fill_1
X_07639_ _10237_/B _14774_/Q VDD VSS sg13g2_inv_1
XFILLER_0_1071 VDD VSS sg13g2_decap_8
XFILLER_41_524 VDD VSS sg13g2_decap_8
XFILLER_0_1082 VDD VSS sg13g2_fill_1
X_14115__2449 _14115_/RESET_B VDD VSS sg13g2_tiehi
X_13950__2614 _13950_/RESET_B VDD VSS sg13g2_tiehi
XFILLER_13_248 VDD VSS sg13g2_decap_8
X_10650_ _10652_/C _14890_/Q _14889_/Q _14888_/Q _14887_/Q VDD VSS sg13g2_nand4_1
XFILLER_142_1021 VDD VSS sg13g2_decap_8
XFILLER_107_1141 VDD VSS sg13g2_decap_8
X_09309_ _13916_/D _10072_/A0 _13916_/Q _09311_/S VDD VSS sg13g2_mux2_1
XFILLER_70_35 VDD VSS sg13g2_decap_8
XFILLER_110_97 VDD VSS sg13g2_decap_4
XFILLER_10_933 VDD VSS sg13g2_fill_2
X_10581_ _10581_/Y _14872_/Q _10580_/A _10557_/C VDD VSS sg13g2_o21ai_1
XFILLER_10_944 VDD VSS sg13g2_decap_8
X_12320_ _12320_/Y _12328_/A1 _14490_/Q VDD VSS sg13g2_nand2b_1
XFILLER_155_938 VDD VSS sg13g2_decap_8
XFILLER_142_1098 VDD VSS sg13g2_decap_4
XFILLER_126_117 VDD VSS sg13g2_decap_8
XFILLER_148_990 VDD VSS sg13g2_decap_4
XFILLER_126_128 VDD VSS sg13g2_fill_1
XFILLER_108_832 VDD VSS sg13g2_fill_1
X_12251_ _12251_/Y _12247_/Y _12248_/Y _12250_/Y _12249_/Y _12253_/B VDD VSS sg13g2_a221oi_1
XFILLER_107_320 VDD VSS sg13g2_fill_2
X_14330__2234 _14330_/RESET_B VDD VSS sg13g2_tiehi
XFILLER_119_180 VDD VSS sg13g2_decap_4
XFILLER_154_459 VDD VSS sg13g2_decap_8
XFILLER_79_11 VDD VSS sg13g2_decap_8
XFILLER_119_73 VDD VSS sg13g2_fill_2
X_14942__3045 _14942_/RESET_B VDD VSS sg13g2_tiehi
X_11202_ _11202_/Y _11202_/A _11205_/A VDD VSS sg13g2_xnor2_1
X_12182_ _12182_/Y _12179_/Y _12181_/X _12191_/B1 VDD VSS sg13g2_o21ai_1
X_11133_ _11133_/Y _11133_/A _11170_/B VDD VSS sg13g2_nand2_1
Xclkbuf_leaf_72_clk_i clkload78/A clkbuf_leaf_75_clk_i/A VDD VSS sg13g2_buf_8
XFILLER_1_642 VDD VSS sg13g2_decap_8
XFILLER_27_1131 VDD VSS sg13g2_decap_8
XFILLER_95_207 VDD VSS sg13g2_decap_8
XFILLER_66_1191 VDD VSS sg13g2_decap_4
XFILLER_89_771 VDD VSS sg13g2_decap_8
XFILLER_95_218 VDD VSS sg13g2_fill_2
X_11064_ _11119_/A _11064_/A _11064_/B _11064_/C _11064_/D VDD VSS sg13g2_nand4_1
XFILLER_122_389 VDD VSS sg13g2_decap_4
XFILLER_7_1236 VDD VSS sg13g2_fill_1
XFILLER_103_570 VDD VSS sg13g2_decap_8
XFILLER_23_1028 VDD VSS sg13g2_decap_8
X_10015_ _14597_/D _10081_/A0 _14597_/Q _10017_/S VDD VSS sg13g2_mux2_1
XFILLER_77_999 VDD VSS sg13g2_decap_8
Xclkbuf_leaf_87_clk_i _15214_/CLK clkbuf_leaf_87_clk_i/A VDD VSS sg13g2_buf_8
X_15179__3236 _15179_/RESET_B VDD VSS sg13g2_tiehi
XFILLER_97_1129 VDD VSS sg13g2_decap_4
X_14823_ _14823_/Q clkload79/A _14823_/D _14823_/RESET_B VDD VSS sg13g2_dfrbpq_1
X_15120__3104 _15120_/RESET_B VDD VSS sg13g2_tiehi
XFILLER_45_863 VDD VSS sg13g2_fill_1
X_14754_ _14754_/Q _15214_/CLK _14754_/D _14754_/RESET_B VDD VSS sg13g2_dfrbpq_1
X_11966_ _11966_/X _13840_/Q _13872_/Q _11969_/A VDD VSS sg13g2_mux2_1
XFILLER_44_351 VDD VSS sg13g2_decap_8
XFILLER_32_502 VDD VSS sg13g2_fill_2
XFILLER_32_513 VDD VSS sg13g2_fill_2
XFILLER_17_587 VDD VSS sg13g2_fill_1
X_13705_ _16867_/A _14917_/CLK _13705_/D _13705_/RESET_B VDD VSS sg13g2_dfrbpq_1
X_10917_ _10948_/C _15119_/Q wire582/X VDD VSS sg13g2_xor2_1
X_14685_ _14685_/Q clkload52/A _14685_/D _14685_/RESET_B VDD VSS sg13g2_dfrbpq_1
Xclkbuf_leaf_10_clk_i _14662_/CLK clkbuf_leaf_9_clk_i/A VDD VSS sg13g2_buf_8
X_11897_ _11898_/B _11897_/A _11897_/B _11897_/C VDD VSS sg13g2_nand3_1
XFILLER_32_535 VDD VSS sg13g2_decap_8
XFILLER_60_844 VDD VSS sg13g2_fill_1
X_13636_ _13744_/D _13636_/A VDD VSS sg13g2_buf_1
X_10848_ _10849_/B _10797_/C _10851_/C _10847_/Y VDD VSS sg13g2_o21ai_1
XFILLER_60_888 VDD VSS sg13g2_fill_2
XFILLER_34_1146 VDD VSS sg13g2_decap_8
X_13567_ _13567_/Y _08203_/B _13600_/B _13566_/Y VDD VSS sg13g2_a21oi_1
XFILLER_73_1195 VDD VSS sg13g2_decap_8
X_10779_ _10779_/Y _14921_/Q _11170_/B VDD VSS sg13g2_nand2_1
XFILLER_12_281 VDD VSS sg13g2_decap_8
X_12518_ _12518_/X _14247_/Q _14279_/Q _14311_/Q _14343_/Q _12521_/S0 _12685_/S1 VDD
+ VSS sg13g2_mux4_1
Xclkbuf_leaf_25_clk_i clkload15/A clkbuf_leaf_8_clk_i/A VDD VSS sg13g2_buf_8
XFILLER_146_938 VDD VSS sg13g2_decap_8
X_13498_ _15127_/D _13498_/A VDD VSS sg13g2_inv_1
X_12449_ _12449_/X _14114_/Q _14146_/Q _14178_/Q _14210_/Q _12450_/S0 _12452_/S1 VDD
+ VSS sg13g2_mux4_1
X_15237_ _15237_/Q clkload68/A _15237_/D _15237_/RESET_B VDD VSS sg13g2_dfrbpq_1
X_15168_ _16854_/A clkload61/A _15168_/D _15168_/RESET_B VDD VSS sg13g2_dfrbpq_1
XFILLER_119_1001 VDD VSS sg13g2_fill_1
XFILLER_113_301 VDD VSS sg13g2_decap_8
XFILLER_153_481 VDD VSS sg13g2_decap_8
XFILLER_5_63 VDD VSS sg13g2_decap_8
XFILLER_5_992 VDD VSS sg13g2_decap_8
XFILLER_99_546 VDD VSS sg13g2_decap_8
X_14119_ _14119_/Q clkload5/A _14119_/D _14119_/RESET_B VDD VSS sg13g2_dfrbpq_1
X_15099_ _15099_/Q clkload66/A _15099_/D _15099_/RESET_B VDD VSS sg13g2_dfrbpq_1
X_07990_ _07991_/A _11241_/C _13306_/A wire947/X _11241_/A VDD VSS sg13g2_or4_1
XFILLER_113_345 VDD VSS sg13g2_decap_8
XFILLER_80_1122 VDD VSS sg13g2_decap_8
XFILLER_39_101 VDD VSS sg13g2_decap_4
XFILLER_132_1212 VDD VSS sg13g2_fill_1
XFILLER_68_966 VDD VSS sg13g2_decap_8
X_09660_ _14253_/D _09693_/A0 _14253_/Q _09673_/S VDD VSS sg13g2_mux2_1
XFILLER_28_808 VDD VSS sg13g2_decap_8
XFILLER_68_977 VDD VSS sg13g2_fill_1
XFILLER_10_0 VDD VSS sg13g2_decap_8
X_08611_ _08611_/Y _07864_/Y _07960_/Y _07964_/Y VDD VSS sg13g2_o21ai_1
XFILLER_27_307 VDD VSS sg13g2_decap_8
XFILLER_83_936 VDD VSS sg13g2_decap_8
X_09591_ _14188_/D _14188_/Q _09923_/A1 _09604_/S VDD VSS sg13g2_mux2_1
XFILLER_83_958 VDD VSS sg13g2_fill_1
X_08542_ _08542_/Y _07808_/Y _08542_/A2 _08541_/Y VDD VSS sg13g2_o21ai_1
XFILLER_70_619 VDD VSS sg13g2_decap_8
XFILLER_36_874 VDD VSS sg13g2_decap_4
XFILLER_91_980 VDD VSS sg13g2_decap_8
XFILLER_36_896 VDD VSS sg13g2_decap_8
X_08473_ _08473_/Y _08472_/X _08542_/A2 _08494_/A VDD VSS sg13g2_a21oi_1
XFILLER_63_693 VDD VSS sg13g2_decap_8
XFILLER_24_28 VDD VSS sg13g2_decap_8
X_15068__3254 _15068_/RESET_B VDD VSS sg13g2_tiehi
XFILLER_126_1027 VDD VSS sg13g2_decap_4
XFILLER_52_1224 VDD VSS sg13g2_decap_8
XFILLER_148_220 VDD VSS sg13g2_decap_8
XFILLER_52_1235 VDD VSS sg13g2_fill_2
X_15129__3084 _15129_/RESET_B VDD VSS sg13g2_tiehi
XFILLER_149_787 VDD VSS sg13g2_fill_2
X_09025_ _09025_/X _09044_/A _09021_/X _09024_/X VDD VSS sg13g2_a21o_1
XFILLER_156_49 VDD VSS sg13g2_decap_8
XFILLER_3_907 VDD VSS sg13g2_decap_8
XFILLER_144_470 VDD VSS sg13g2_decap_4
XFILLER_105_824 VDD VSS sg13g2_fill_2
XFILLER_117_684 VDD VSS sg13g2_decap_8
XFILLER_85_1044 VDD VSS sg13g2_fill_2
XFILLER_105_835 VDD VSS sg13g2_decap_8
XFILLER_117_695 VDD VSS sg13g2_fill_2
XFILLER_2_439 VDD VSS sg13g2_decap_8
Xpicorv32_macro_1804 mem_axi_awaddr[1] VDD VSS sg13g2_tielo
XFILLER_116_183 VDD VSS sg13g2_fill_1
Xclkbuf_4_8_0_clk_i clkbuf_4_8_0_clk_i/X clkbuf_0_clk_i/X VDD VSS sg13g2_buf_8
XFILLER_131_120 VDD VSS sg13g2_fill_2
XFILLER_78_708 VDD VSS sg13g2_decap_8
XFILLER_46_1039 VDD VSS sg13g2_fill_1
XFILLER_85_1088 VDD VSS sg13g2_fill_2
XFILLER_104_356 VDD VSS sg13g2_decap_8
Xfanout710 _08941_/S _08834_/X VDD VSS sg13g2_buf_1
XFILLER_120_816 VDD VSS sg13g2_decap_8
Xfanout721 _13654_/S _13502_/A VDD VSS sg13g2_buf_1
Xfanout1719 _11801_/S fanout1721/X VDD VSS sg13g2_buf_1
X_09927_ _14512_/D _14512_/Q _09927_/A1 _09936_/S VDD VSS sg13g2_mux2_1
XFILLER_120_838 VDD VSS sg13g2_fill_1
Xfanout754 _12292_/A _12001_/A VDD VSS sg13g2_buf_1
XFILLER_105_42 VDD VSS sg13g2_fill_2
Xfanout776 _09906_/A1 _08969_/X VDD VSS sg13g2_buf_1
X_09858_ _14445_/D _14445_/Q _10089_/A0 wire435/X VDD VSS sg13g2_mux2_1
XFILLER_100_540 VDD VSS sg13g2_decap_8
Xfanout798 _08518_/B1 _08398_/Y VDD VSS sg13g2_buf_1
XFILLER_85_262 VDD VSS sg13g2_fill_1
XFILLER_18_318 VDD VSS sg13g2_decap_8
X_08809_ _08811_/A _10885_/A1 _14751_/Q _08727_/X _15194_/Q _08809_/C1 VDD VSS sg13g2_a221oi_1
X_09789_ _14378_/D _09789_/A0 _14378_/Q wire629/X VDD VSS sg13g2_mux2_1
XFILLER_65_46 VDD VSS sg13g2_decap_8
XFILLER_2_1122 VDD VSS sg13g2_decap_8
XFILLER_65_57 VDD VSS sg13g2_fill_2
XFILLER_22_1072 VDD VSS sg13g2_decap_8
X_11820_ _11820_/Y _11816_/Y _11817_/Y _11819_/Y _11818_/Y _11822_/B VDD VSS sg13g2_a221oi_1
XFILLER_42_811 VDD VSS sg13g2_decap_8
X_14348__2216 _14348_/RESET_B VDD VSS sg13g2_tiehi
X_11751_ _11751_/Y _11531_/A _14506_/Q _11739_/B VDD VSS sg13g2_a21oi_1
XFILLER_2_1199 VDD VSS sg13g2_decap_8
XFILLER_57_1135 VDD VSS sg13g2_decap_8
XFILLER_14_546 VDD VSS sg13g2_decap_8
XFILLER_14_557 VDD VSS sg13g2_fill_2
X_10702_ _10702_/Y _12942_/A _10903_/B VDD VSS sg13g2_nand2_1
XFILLER_109_1236 VDD VSS sg13g2_fill_1
X_14470_ _14470_/Q clkload17/A _14470_/D _14470_/RESET_B VDD VSS sg13g2_dfrbpq_1
X_11682_ _11682_/Y _11686_/S0 _14408_/Q _11686_/S1 VDD VSS sg13g2_a21oi_1
XFILLER_144_1149 VDD VSS sg13g2_decap_8
X_13421_ _13421_/Y _13448_/B wire809/X _13459_/C VDD VSS sg13g2_nand3b_1
X_10633_ _14885_/D _10655_/B _10633_/B _10633_/C VDD VSS sg13g2_nor3_1
XFILLER_22_590 VDD VSS sg13g2_decap_8
X_14563__2001 _14563_/RESET_B VDD VSS sg13g2_tiehi
X_13352_ _15071_/D _15071_/Q _13654_/S _13351_/Y VDD VSS sg13g2_a21o_1
XFILLER_10_763 VDD VSS sg13g2_fill_2
X_10564_ _10565_/D _14860_/Q _14859_/Q _14858_/Q _10564_/D VDD VSS sg13g2_nand4_1
XFILLER_127_415 VDD VSS sg13g2_decap_8
X_12303_ _12303_/X _14138_/Q _14170_/Q _12303_/S VDD VSS sg13g2_mux2_1
XFILLER_154_245 VDD VSS sg13g2_decap_8
X_13283_ _13291_/A _13283_/A _13287_/A VDD VSS sg13g2_nand2_1
X_10495_ _10497_/B _14852_/Q _10513_/D _14850_/Q _10495_/D VDD VSS sg13g2_nand4_1
XFILLER_136_960 VDD VSS sg13g2_decap_8
X_15022_ _15022_/Q _15250_/CLK _15022_/D _15022_/RESET_B VDD VSS sg13g2_dfrbpq_1
XFILLER_108_662 VDD VSS sg13g2_decap_8
X_12234_ _12236_/A _12235_/A _14200_/Q VDD VSS sg13g2_nand2b_1
XFILLER_135_470 VDD VSS sg13g2_decap_8
XFILLER_155_1212 VDD VSS sg13g2_decap_8
XFILLER_151_952 VDD VSS sg13g2_decap_4
XFILLER_64_1117 VDD VSS sg13g2_decap_8
X_12165_ _12165_/X _14582_/Q _14614_/Q _12168_/A VDD VSS sg13g2_mux2_1
XFILLER_116_1207 VDD VSS sg13g2_decap_8
XFILLER_150_462 VDD VSS sg13g2_fill_2
XFILLER_2_973 VDD VSS sg13g2_decap_8
X_11116_ _11190_/C wire211/X _11138_/C VDD VSS sg13g2_nand2_1
XFILLER_111_827 VDD VSS sg13g2_fill_1
X_12096_ _12096_/Y _12098_/A1 _14612_/Q _12114_/S1 VDD VSS sg13g2_a21oi_1
XFILLER_77_730 VDD VSS sg13g2_decap_8
X_11047_ _14944_/D _07616_/Y _10671_/Y _11046_/Y VDD VSS sg13g2_o21ai_1
XFILLER_110_359 VDD VSS sg13g2_fill_1
Xinput9 input9/X input9/A VDD VSS sg13g2_buf_1
XFILLER_92_711 VDD VSS sg13g2_decap_8
XFILLER_49_487 VDD VSS sg13g2_fill_1
XFILLER_64_413 VDD VSS sg13g2_decap_8
XFILLER_64_424 VDD VSS sg13g2_fill_2
XFILLER_37_649 VDD VSS sg13g2_decap_4
XFILLER_18_841 VDD VSS sg13g2_decap_8
X_14806_ _14806_/Q clkload81/A _14806_/D _14806_/RESET_B VDD VSS sg13g2_dfrbpq_1
X_12998_ _12998_/Y _12866_/D _12997_/Y _12937_/Y VDD VSS sg13g2_o21ai_1
XFILLER_73_980 VDD VSS sg13g2_fill_2
XFILLER_32_310 VDD VSS sg13g2_decap_4
X_14737_ _14737_/Q _14737_/CLK _14737_/D _14737_/RESET_B VDD VSS sg13g2_dfrbpq_1
X_11949_ _11953_/A _11948_/X _12023_/B VDD VSS sg13g2_nand2b_1
XFILLER_36_1208 VDD VSS sg13g2_decap_8
X_14668_ _14668_/Q clkload51/A _14668_/D _14668_/RESET_B VDD VSS sg13g2_dfrbpq_1
X_13619_ _13727_/D _13619_/A VDD VSS sg13g2_buf_1
X_14599_ _14599_/Q clkload5/A _14599_/D _14599_/RESET_B VDD VSS sg13g2_dfrbpq_1
XFILLER_9_583 VDD VSS sg13g2_decap_8
XFILLER_145_223 VDD VSS sg13g2_fill_1
XFILLER_118_437 VDD VSS sg13g2_fill_1
XFILLER_146_757 VDD VSS sg13g2_fill_1
Xmax_cap1550 _16875_/A _13713_/Q VDD VSS sg13g2_buf_4
Xmax_cap1561 _16864_/A _13702_/Q VDD VSS sg13g2_buf_8
XFILLER_69_1039 VDD VSS sg13g2_decap_8
XFILLER_58_0 VDD VSS sg13g2_decap_8
XFILLER_133_429 VDD VSS sg13g2_decap_8
XFILLER_114_643 VDD VSS sg13g2_fill_2
XFILLER_114_665 VDD VSS sg13g2_decap_8
XFILLER_87_516 VDD VSS sg13g2_decap_8
X_14426__2138 _14426_/RESET_B VDD VSS sg13g2_tiehi
XFILLER_87_527 VDD VSS sg13g2_fill_2
X_07973_ _07974_/C _08663_/A _08678_/A _07971_/Y VDD VSS sg13g2_o21ai_1
XFILLER_101_337 VDD VSS sg13g2_fill_2
XFILLER_19_28 VDD VSS sg13g2_decap_8
X_09712_ _14303_/D _09877_/A0 _14303_/Q _09738_/S VDD VSS sg13g2_mux2_1
XFILLER_28_605 VDD VSS sg13g2_fill_1
XFILLER_83_700 VDD VSS sg13g2_decap_8
X_09643_ _14236_/D _10105_/A _14236_/Q _09661_/S VDD VSS sg13g2_mux2_1
XFILLER_95_582 VDD VSS sg13g2_decap_4
XFILLER_95_593 VDD VSS sg13g2_fill_1
X_09574_ _14171_/D _14171_/Q _09574_/A1 _09593_/S VDD VSS sg13g2_mux2_1
XFILLER_36_682 VDD VSS sg13g2_decap_4
X_08525_ _08526_/A _08209_/X _08452_/B _08521_/X _08110_/D _08524_/Y VDD VSS sg13g2_a221oi_1
XFILLER_35_192 VDD VSS sg13g2_decap_8
X_08456_ _08461_/C _08456_/A _08456_/B _08456_/C VDD VSS sg13g2_nand3_1
XFILLER_50_151 VDD VSS sg13g2_decap_8
XFILLER_17_1141 VDD VSS sg13g2_decap_8
X_13667__2923 _13667_/RESET_B VDD VSS sg13g2_tiehi
X_14032__2532 _14032_/RESET_B VDD VSS sg13g2_tiehi
X_08387_ _08387_/Y _08692_/A _08382_/X _08380_/Y _08637_/B _08386_/Y VDD VSS sg13g2_a221oi_1
XFILLER_136_7 VDD VSS sg13g2_decap_8
XFILLER_143_1160 VDD VSS sg13g2_fill_2
XFILLER_137_702 VDD VSS sg13g2_fill_2
Xwire418 wire418/X wire418/A VDD VSS sg13g2_buf_8
XFILLER_149_573 VDD VSS sg13g2_decap_4
XFILLER_13_1027 VDD VSS sg13g2_decap_8
XFILLER_104_1144 VDD VSS sg13g2_fill_2
X_14636__1928 _14636_/RESET_B VDD VSS sg13g2_tiehi
XFILLER_152_705 VDD VSS sg13g2_fill_2
XFILLER_137_779 VDD VSS sg13g2_decap_8
XFILLER_87_1139 VDD VSS sg13g2_decap_8
X_09008_ _13762_/D _13762_/Q _10078_/A0 _09146_/S VDD VSS sg13g2_mux2_1
X_10280_ _10282_/A _14788_/Q _10311_/A _10271_/B VDD VSS sg13g2_o21ai_1
XFILLER_105_621 VDD VSS sg13g2_decap_8
XFILLER_3_759 VDD VSS sg13g2_decap_8
XFILLER_117_492 VDD VSS sg13g2_fill_2
X_14065__2499 _14065_/RESET_B VDD VSS sg13g2_tiehi
XFILLER_133_963 VDD VSS sg13g2_decap_8
XFILLER_2_247 VDD VSS sg13g2_decap_8
XFILLER_105_687 VDD VSS sg13g2_decap_8
Xfanout1505 _12899_/A _12799_/A VDD VSS sg13g2_buf_1
Xfanout1516 _12959_/A1 _14903_/Q VDD VSS sg13g2_buf_1
Xfanout1527 _10513_/D _14851_/Q VDD VSS sg13g2_buf_1
Xfanout540 _10107_/A0 fanout542/X VDD VSS sg13g2_buf_1
Xfanout1538 _12347_/B _14750_/Q VDD VSS sg13g2_buf_1
XFILLER_104_197 VDD VSS sg13g2_decap_8
Xfanout551 _09084_/S _08965_/Y VDD VSS sg13g2_buf_1
X_15004__2968 _15004_/RESET_B VDD VSS sg13g2_tiehi
XFILLER_24_1134 VDD VSS sg13g2_decap_8
Xfanout573 _12429_/B2 _12348_/Y VDD VSS sg13g2_buf_1
X_13970_ _13970_/Q _14706_/CLK _13970_/D _13970_/RESET_B VDD VSS sg13g2_dfrbpq_1
XFILLER_47_925 VDD VSS sg13g2_decap_8
XFILLER_86_571 VDD VSS sg13g2_decap_8
XFILLER_150_1164 VDD VSS sg13g2_decap_8
X_14280__2284 _14280_/RESET_B VDD VSS sg13g2_tiehi
XFILLER_18_104 VDD VSS sg13g2_decap_8
XFILLER_20_1009 VDD VSS sg13g2_decap_8
X_12921_ _15028_/D _12984_/A _12921_/B VDD VSS sg13g2_nor2_1
XFILLER_98_1235 VDD VSS sg13g2_fill_2
XFILLER_73_232 VDD VSS sg13g2_decap_8
XFILLER_18_159 VDD VSS sg13g2_decap_8
X_12852_ _12852_/Y _14834_/Q _13260_/B _12862_/B _14866_/Q _13180_/C1 VDD VSS sg13g2_a221oi_1
XFILLER_132_84 VDD VSS sg13g2_decap_8
X_11803_ _11805_/A _11801_/S _14188_/Q VDD VSS sg13g2_nand2b_1
X_12783_ _12783_/X _14266_/Q _14298_/Q _14330_/Q _14362_/Q _12787_/S0 _12787_/S1 VDD
+ VSS sg13g2_mux4_1
XFILLER_42_630 VDD VSS sg13g2_decap_8
XFILLER_61_449 VDD VSS sg13g2_fill_1
XFILLER_148_1071 VDD VSS sg13g2_fill_2
X_11734_ _11734_/Y _11730_/Y _11731_/Y _11733_/Y _11732_/Y _11763_/B VDD VSS sg13g2_a221oi_1
X_14522_ _14522_/Q _15040_/CLK _14522_/D _14522_/RESET_B VDD VSS sg13g2_dfrbpq_1
XFILLER_41_140 VDD VSS sg13g2_decap_8
XFILLER_14_365 VDD VSS sg13g2_fill_2
XFILLER_30_825 VDD VSS sg13g2_fill_2
XFILLER_15_899 VDD VSS sg13g2_decap_8
X_11665_ _11665_/Y _11670_/S0 _13832_/Q VDD VSS sg13g2_nand2b_1
X_14453_ _14453_/Q _14671_/CLK _14453_/D _14453_/RESET_B VDD VSS sg13g2_dfrbpq_1
XFILLER_109_1099 VDD VSS sg13g2_fill_2
X_10616_ _14880_/D _07620_/Y _10611_/A _10615_/Y VDD VSS sg13g2_a21oi_1
XFILLER_31_1105 VDD VSS sg13g2_decap_4
X_13404_ _15089_/D _13435_/A _13395_/Y _13403_/Y VDD VSS sg13g2_o21ai_1
XFILLER_128_713 VDD VSS sg13g2_decap_8
XFILLER_31_1116 VDD VSS sg13g2_fill_2
X_14384_ _14384_/Q clkload46/A _14384_/D _14384_/RESET_B VDD VSS sg13g2_dfrbpq_1
X_11596_ _11598_/A _11597_/A _14182_/Q VDD VSS sg13g2_nand2b_1
XFILLER_128_746 VDD VSS sg13g2_decap_8
XFILLER_127_223 VDD VSS sg13g2_decap_8
X_13335_ _15170_/D hold3427/X _15170_/Q _13336_/S VDD VSS sg13g2_mux2_1
X_10547_ _10556_/D _14864_/Q _14863_/Q _13273_/A _10547_/D VDD VSS sg13g2_and4_1
XFILLER_41_92 VDD VSS sg13g2_decap_8
XFILLER_109_971 VDD VSS sg13g2_fill_1
XFILLER_51_7 VDD VSS sg13g2_decap_8
X_13266_ _15051_/D _13266_/A _13266_/B VDD VSS sg13g2_nor2_1
X_10478_ _14847_/D _10490_/A _10478_/B _10489_/D VDD VSS sg13g2_nor3_1
XFILLER_142_237 VDD VSS sg13g2_fill_1
X_12217_ _12217_/Y _12217_/A _12217_/B VDD VSS sg13g2_nor2_1
X_15005_ _15005_/Q _15200_/CLK _15005_/D _15005_/RESET_B VDD VSS sg13g2_dfrbpq_1
X_13730__2834 _13730_/RESET_B VDD VSS sg13g2_tiehi
XFILLER_124_963 VDD VSS sg13g2_decap_8
XFILLER_9_1106 VDD VSS sg13g2_decap_8
XFILLER_68_1083 VDD VSS sg13g2_decap_4
X_13197_ wire208/A _13196_/Y _13297_/A0 _13192_/X _13222_/A1 VDD VSS sg13g2_a22oi_1
X_12148_ _12149_/B _11664_/A _12132_/Y _12147_/Y VDD VSS sg13g2_o21ai_1
XFILLER_69_538 VDD VSS sg13g2_decap_8
XFILLER_123_484 VDD VSS sg13g2_decap_8
XFILLER_110_101 VDD VSS sg13g2_fill_2
XFILLER_2_42 VDD VSS sg13g2_decap_8
X_12079_ _12079_/Y _13168_/A _12267_/A2 _12146_/B1 VDD VSS sg13g2_a21oi_1
XFILLER_38_925 VDD VSS sg13g2_decap_8
X_14110__2454 _14110_/RESET_B VDD VSS sg13g2_tiehi
XFILLER_92_541 VDD VSS sg13g2_decap_8
XFILLER_92_552 VDD VSS sg13g2_fill_2
XFILLER_64_254 VDD VSS sg13g2_decap_8
XFILLER_37_479 VDD VSS sg13g2_decap_8
XFILLER_53_939 VDD VSS sg13g2_fill_2
XFILLER_18_671 VDD VSS sg13g2_decap_8
XFILLER_46_991 VDD VSS sg13g2_fill_1
XFILLER_17_170 VDD VSS sg13g2_decap_4
XFILLER_80_769 VDD VSS sg13g2_fill_2
X_08310_ _08616_/B _08599_/A _08126_/B _08688_/B VDD VSS sg13g2_o21ai_1
XFILLER_61_961 VDD VSS sg13g2_decap_8
X_09290_ _13898_/D _13898_/Q _10153_/A1 wire496/X VDD VSS sg13g2_mux2_1
XFILLER_36_1027 VDD VSS sg13g2_decap_8
XFILLER_36_1038 VDD VSS sg13g2_fill_1
X_08241_ _08241_/Y _08244_/B _08241_/B VDD VSS sg13g2_nand2_1
XFILLER_127_1166 VDD VSS sg13g2_decap_4
XANTENNA_14 _16857_/A VDD VSS sg13g2_antennanp
XFILLER_127_1199 VDD VSS sg13g2_decap_4
XFILLER_146_510 VDD VSS sg13g2_fill_1
X_08172_ _08340_/B _08431_/A _08171_/X _08538_/S VDD VSS sg13g2_mux2_1
XFILLER_118_212 VDD VSS sg13g2_decap_4
XFILLER_12_1060 VDD VSS sg13g2_decap_8
Xoutput110 mem_axi_wdata[15] _15147_/Q VDD VSS sg13g2_buf_1
Xoutput121 mem_axi_wdata[25] _15157_/Q VDD VSS sg13g2_buf_1
Xoutput132 mem_axi_wdata[6] _15138_/Q VDD VSS sg13g2_buf_1
XFILLER_86_1161 VDD VSS sg13g2_decap_4
XFILLER_82_1003 VDD VSS sg13g2_fill_2
XFILLER_115_963 VDD VSS sg13g2_decap_8
XFILLER_86_1183 VDD VSS sg13g2_decap_4
XFILLER_88_825 VDD VSS sg13g2_fill_2
XFILLER_47_1156 VDD VSS sg13g2_fill_2
XFILLER_153_28 VDD VSS sg13g2_decap_8
XFILLER_99_184 VDD VSS sg13g2_decap_4
XFILLER_114_484 VDD VSS sg13g2_decap_8
XFILLER_102_646 VDD VSS sg13g2_fill_2
X_07956_ _07956_/Y _13566_/A _07812_/B VDD VSS sg13g2_nor2b_1
XFILLER_102_679 VDD VSS sg13g2_decap_8
XFILLER_68_593 VDD VSS sg13g2_decap_4
X_07887_ _07889_/A _08203_/A _14995_/Q VDD VSS sg13g2_nand2_1
XFILLER_110_690 VDD VSS sg13g2_decap_4
X_09626_ _14222_/D _10157_/A1 _14222_/Q wire470/X VDD VSS sg13g2_mux2_1
XFILLER_71_725 VDD VSS sg13g2_decap_8
XFILLER_102_21 VDD VSS sg13g2_decap_8
XFILLER_37_991 VDD VSS sg13g2_decap_8
XFILLER_15_129 VDD VSS sg13g2_fill_2
X_09557_ _14155_/D _10087_/A0 _14155_/Q _09571_/S VDD VSS sg13g2_mux2_1
XFILLER_110_1192 VDD VSS sg13g2_fill_1
XFILLER_52_950 VDD VSS sg13g2_fill_2
XFILLER_62_14 VDD VSS sg13g2_decap_8
X_08508_ _08517_/A _07818_/Y _08506_/Y _08507_/Y VDD VSS sg13g2_o21ai_1
X_09488_ _14088_/D _10084_/A0 _14088_/Q _09490_/S VDD VSS sg13g2_mux2_1
X_08439_ _08439_/Y _08574_/A _08438_/Y _08685_/A1 VDD VSS sg13g2_a21oi_1
XFILLER_51_493 VDD VSS sg13g2_decap_8
XFILLER_12_869 VDD VSS sg13g2_decap_8
X_11450_ _11450_/Y _12075_/A _11449_/X _11234_/Y VDD VSS sg13g2_o21ai_1
XFILLER_7_317 VDD VSS sg13g2_decap_8
Xwire237 wire237/X wire237/A VDD VSS sg13g2_buf_2
X_10401_ _14822_/D _10401_/A _10623_/A _10401_/C VDD VSS sg13g2_nor3_1
X_11381_ _11381_/Y _10681_/A _12338_/A2 _07684_/B VDD VSS sg13g2_a21oi_1
X_13120_ _13120_/X _13120_/A _13170_/A VDD VSS sg13g2_xor2_1
X_14298__2266 _14298_/RESET_B VDD VSS sg13g2_tiehi
X_10332_ _10334_/A _14803_/Q _10336_/D _14804_/Q VDD VSS sg13g2_a21o_1
XFILLER_3_512 VDD VSS sg13g2_decap_8
XFILLER_30_1193 VDD VSS sg13g2_decap_8
X_13051_ _13051_/X _14814_/Q _13068_/B VDD VSS sg13g2_and2_1
XFILLER_11_84 VDD VSS sg13g2_decap_8
XFILLER_65_1212 VDD VSS sg13g2_fill_2
XFILLER_152_568 VDD VSS sg13g2_fill_2
X_10263_ _14782_/D _14782_/Q _10268_/D _10261_/Y VDD VSS sg13g2_a21oi_1
XFILLER_87_11 VDD VSS sg13g2_fill_2
XFILLER_127_84 VDD VSS sg13g2_decap_8
X_12002_ wire299/A _11330_/S _11998_/X _12001_/Y VDD VSS sg13g2_o21ai_1
XFILLER_87_44 VDD VSS sg13g2_fill_2
XFILLER_127_95 VDD VSS sg13g2_fill_2
Xfanout1302 _11288_/A _15068_/Q VDD VSS sg13g2_buf_1
X_10194_ _14754_/D _15197_/D _14754_/Q _13653_/S VDD VSS sg13g2_mux2_1
XFILLER_105_495 VDD VSS sg13g2_decap_8
XFILLER_78_335 VDD VSS sg13g2_decap_4
Xfanout1313 _10004_/B _09806_/B VDD VSS sg13g2_buf_1
Xfanout1324 _09039_/B _15059_/Q VDD VSS sg13g2_buf_1
Xfanout1335 _11241_/C _15053_/Q VDD VSS sg13g2_buf_1
Xfanout1346 _13533_/A _08668_/A VDD VSS sg13g2_buf_1
Xfanout1357 _08599_/A _08344_/A2 VDD VSS sg13g2_buf_1
XFILLER_59_560 VDD VSS sg13g2_fill_1
Xfanout1368 _08213_/S _08560_/B VDD VSS sg13g2_buf_1
XFILLER_4_1014 VDD VSS sg13g2_decap_8
Xfanout1379 _08669_/B1 _08044_/S1 VDD VSS sg13g2_buf_1
Xfanout392 _10163_/S wire398/X VDD VSS sg13g2_buf_1
X_13953_ _13953_/Q clkload20/A _13953_/D _13953_/RESET_B VDD VSS sg13g2_dfrbpq_1
XFILLER_46_210 VDD VSS sg13g2_fill_2
XFILLER_59_593 VDD VSS sg13g2_decap_4
XFILLER_19_435 VDD VSS sg13g2_fill_1
XFILLER_47_744 VDD VSS sg13g2_decap_4
XFILLER_4_1069 VDD VSS sg13g2_decap_8
X_12904_ _15027_/D _13306_/A _12904_/B VDD VSS sg13g2_nor2_1
XFILLER_74_563 VDD VSS sg13g2_decap_8
X_13884_ _13884_/Q clkload77/A _13884_/D _13884_/RESET_B VDD VSS sg13g2_dfrbpq_1
XFILLER_28_991 VDD VSS sg13g2_decap_8
X_12835_ _12836_/C _12835_/A _13691_/Q VDD VSS sg13g2_xor2_1
XFILLER_27_490 VDD VSS sg13g2_decap_8
XFILLER_15_630 VDD VSS sg13g2_decap_4
XFILLER_43_961 VDD VSS sg13g2_decap_8
XFILLER_43_972 VDD VSS sg13g2_fill_1
X_12766_ _12766_/X _14585_/Q _14617_/Q _14649_/Q _14681_/Q _12771_/S0 _12771_/S1 VDD
+ VSS sg13g2_mux4_1
XFILLER_72_1227 VDD VSS sg13g2_decap_8
XFILLER_99_7 VDD VSS sg13g2_fill_2
X_13748__2816 _13748_/RESET_B VDD VSS sg13g2_tiehi
X_14505_ _14505_/Q _14505_/CLK _14505_/D _14505_/RESET_B VDD VSS sg13g2_dfrbpq_1
X_11717_ _11719_/B _12174_/A _11717_/B VDD VSS sg13g2_nor2_1
XFILLER_14_195 VDD VSS sg13g2_fill_2
X_12697_ _12697_/X _13972_/Q _14004_/Q _14036_/Q _14068_/Q _12699_/S0 _12745_/S1 VDD
+ VSS sg13g2_mux4_1
XFILLER_35_1060 VDD VSS sg13g2_fill_1
X_14436_ _14436_/Q clkload36/A _14436_/D _14436_/RESET_B VDD VSS sg13g2_dfrbpq_1
X_11648_ _11648_/X _14247_/Q _14279_/Q _14311_/Q _14343_/Q _11648_/S0 _12067_/S1 VDD
+ VSS sg13g2_mux4_1
Xinput12 input12/X input12/A VDD VSS sg13g2_buf_1
Xinput23 input23/X input23/A VDD VSS sg13g2_buf_1
XFILLER_156_841 VDD VSS sg13g2_fill_2
Xinput34 input34/X input34/A VDD VSS sg13g2_buf_1
XFILLER_7_851 VDD VSS sg13g2_decap_8
X_14367_ _14367_/Q _14509_/CLK _14367_/D _14367_/RESET_B VDD VSS sg13g2_dfrbpq_1
X_11579_ _11579_/X _14373_/Q _14405_/Q _14469_/Q _14501_/Q _12215_/S0 _12215_/S1 VDD
+ VSS sg13g2_mux4_1
XFILLER_116_705 VDD VSS sg13g2_decap_4
Xwire760 wire760/X wire760/A VDD VSS sg13g2_buf_2
XFILLER_156_885 VDD VSS sg13g2_fill_2
XFILLER_10_390 VDD VSS sg13g2_fill_2
X_14128__2436 _14128_/RESET_B VDD VSS sg13g2_tiehi
X_13963__2601 _13963_/RESET_B VDD VSS sg13g2_tiehi
X_13318_ _13319_/B _15110_/Q wire810/X _13309_/Y _09806_/B VDD VSS sg13g2_a22oi_1
X_14298_ _14298_/Q _14714_/CLK _14298_/D _14298_/RESET_B VDD VSS sg13g2_dfrbpq_1
X_13249_ _13251_/B _14892_/Q _13249_/B VDD VSS sg13g2_nand2_1
XFILLER_97_600 VDD VSS sg13g2_decap_8
XFILLER_97_622 VDD VSS sg13g2_fill_1
XFILLER_112_933 VDD VSS sg13g2_fill_2
X_07810_ _08567_/A _15012_/Q _12009_/A VDD VSS sg13g2_xnor2_1
X_14343__2221 _14343_/RESET_B VDD VSS sg13g2_tiehi
XFILLER_96_154 VDD VSS sg13g2_decap_4
X_08790_ _08790_/Y _13481_/A _13482_/A _13448_/B VDD VSS sg13g2_o21ai_1
X_13996__2568 _13996_/RESET_B VDD VSS sg13g2_tiehi
XFILLER_111_487 VDD VSS sg13g2_fill_1
X_07741_ _07741_/Y _15124_/Q _13481_/A VDD VSS sg13g2_nand2b_1
XFILLER_111_498 VDD VSS sg13g2_decap_8
X_13684__2889 _13684_/RESET_B VDD VSS sg13g2_tiehi
XFILLER_37_221 VDD VSS sg13g2_fill_2
XFILLER_42_1075 VDD VSS sg13g2_decap_8
XFILLER_37_254 VDD VSS sg13g2_fill_1
X_07672_ _07672_/X _07665_/X _07670_/Y _07667_/Y VDD VSS sg13g2_a21o_1
XFILLER_38_788 VDD VSS sg13g2_decap_8
X_09411_ _14013_/D _09609_/A0 _14013_/Q _09413_/S VDD VSS sg13g2_mux2_1
XFILLER_80_544 VDD VSS sg13g2_decap_8
X_14376__2188 _14376_/RESET_B VDD VSS sg13g2_tiehi
XFILLER_80_555 VDD VSS sg13g2_decap_8
X_09342_ _09342_/Y _09971_/B _09441_/D VDD VSS sg13g2_nand2_1
XFILLER_52_268 VDD VSS sg13g2_decap_8
X_09273_ _13882_/D _13882_/Q _10169_/A1 _09273_/S VDD VSS sg13g2_mux2_1
XFILLER_32_28 VDD VSS sg13g2_decap_8
X_08224_ _08224_/X _08119_/X _08128_/X _08129_/X _08132_/X _08488_/A _08329_/B VDD
+ VSS sg13g2_mux4_1
XFILLER_138_329 VDD VSS sg13g2_decap_8
XFILLER_148_28 VDD VSS sg13g2_decap_8
XFILLER_14_1155 VDD VSS sg13g2_decap_8
X_08155_ _08155_/Y _08188_/A _08453_/B1 _08001_/C VDD VSS sg13g2_o21ai_1
X_14847__3235 _14847_/RESET_B VDD VSS sg13g2_tiehi
XFILLER_88_1234 VDD VSS sg13g2_fill_2
XFILLER_134_513 VDD VSS sg13g2_decap_8
XFILLER_107_727 VDD VSS sg13g2_fill_1
X_08086_ _08270_/A _08198_/S _08086_/B VDD VSS sg13g2_nand2_1
XFILLER_49_1229 VDD VSS sg13g2_decap_8
XFILLER_103_900 VDD VSS sg13g2_fill_2
XFILLER_115_760 VDD VSS sg13g2_decap_4
Xhold3410 input34/A mem_axi_rdata[8] VDD VSS sg13g2_dlygate4sd3_1
Xhold3421 input26/A mem_axi_rdata[2] VDD VSS sg13g2_dlygate4sd3_1
Xhold3432 input7/A mem_axi_rdata[12] VDD VSS sg13g2_dlygate4sd3_1
Xhold3443 hold3443/X input8/X VDD VSS sg13g2_dlygate4sd3_1
Xhold3454 input28/A mem_axi_rdata[31] VDD VSS sg13g2_dlygate4sd3_1
XFILLER_138_1092 VDD VSS sg13g2_decap_8
XFILLER_0_559 VDD VSS sg13g2_decap_8
XFILLER_57_14 VDD VSS sg13g2_decap_8
Xhold3465 _13624_/A _13732_/Q VDD VSS sg13g2_dlygate4sd3_1
Xhold3476 _13619_/A _13727_/Q VDD VSS sg13g2_dlygate4sd3_1
Xhold3487 _13629_/A _13737_/Q VDD VSS sg13g2_dlygate4sd3_1
Xhold3498 _10929_/A _14937_/Q VDD VSS sg13g2_dlygate4sd3_1
X_08988_ _08988_/Y _08988_/A _08988_/B _08988_/C VDD VSS sg13g2_nor3_1
X_13826__2738 _13826_/RESET_B VDD VSS sg13g2_tiehi
X_14586__1978 _14586_/RESET_B VDD VSS sg13g2_tiehi
XFILLER_29_744 VDD VSS sg13g2_decap_8
X_07939_ _07939_/Y _08315_/B _07776_/Y _07773_/Y VDD VSS sg13g2_a21oi_1
XFILLER_60_1175 VDD VSS sg13g2_fill_2
X_10950_ _10950_/Y _10949_/Y _11004_/A _11151_/A VDD VSS sg13g2_a21oi_1
XFILLER_113_42 VDD VSS sg13g2_decap_8
XFILLER_21_1159 VDD VSS sg13g2_decap_8
XFILLER_44_725 VDD VSS sg13g2_decap_8
XFILLER_113_75 VDD VSS sg13g2_decap_4
XFILLER_44_736 VDD VSS sg13g2_decap_8
XFILLER_56_596 VDD VSS sg13g2_fill_2
X_09609_ _14205_/D _09609_/A0 _14205_/Q _09611_/S VDD VSS sg13g2_mux2_1
X_10881_ _10890_/C _14754_/Q wire584/X VDD VSS sg13g2_xor2_1
X_14206__2358 _14206_/RESET_B VDD VSS sg13g2_tiehi
X_12620_ _12620_/X _14702_/Q _14734_/Q _13774_/Q _13806_/Q _12620_/S0 _12620_/S1 VDD
+ VSS sg13g2_mux4_1
XFILLER_43_268 VDD VSS sg13g2_decap_4
XFILLER_25_983 VDD VSS sg13g2_decap_8
XFILLER_19_1044 VDD VSS sg13g2_decap_8
X_12551_ _12551_/X _12548_/X _12547_/X _12544_/X _12543_/X _12733_/S0 _12455_/S VDD
+ VSS sg13g2_mux4_1
XFILLER_145_1063 VDD VSS sg13g2_decap_8
XFILLER_12_633 VDD VSS sg13g2_decap_8
XFILLER_40_942 VDD VSS sg13g2_decap_8
XFILLER_40_975 VDD VSS sg13g2_decap_4
X_11502_ _11636_/A _11502_/A _13685_/Q VDD VSS sg13g2_xor2_1
XFILLER_32_1211 VDD VSS sg13g2_decap_8
X_12482_ _12482_/X _12480_/X _12479_/X _12476_/X _12475_/X _12760_/S0 _12732_/S1 VDD
+ VSS sg13g2_mux4_1
XFILLER_12_688 VDD VSS sg13g2_decap_4
XFILLER_156_159 VDD VSS sg13g2_decap_8
X_14221_ _14221_/Q _14669_/CLK _14221_/D _14221_/RESET_B VDD VSS sg13g2_dfrbpq_1
X_11433_ _11433_/Y _14899_/Q _11433_/B VDD VSS sg13g2_nand2_1
X_14421__2143 _14421_/RESET_B VDD VSS sg13g2_tiehi
XFILLER_125_0 VDD VSS sg13g2_decap_8
XFILLER_7_147 VDD VSS sg13g2_fill_2
XFILLER_125_513 VDD VSS sg13g2_fill_1
XFILLER_22_94 VDD VSS sg13g2_fill_2
X_14152_ _14152_/Q clkload23/A _14152_/D _14152_/RESET_B VDD VSS sg13g2_dfrbpq_1
XFILLER_152_310 VDD VSS sg13g2_fill_2
X_11364_ _11366_/A _11365_/A _14462_/Q VDD VSS sg13g2_nand2b_1
XFILLER_98_21 VDD VSS sg13g2_decap_8
X_10315_ _10315_/Y _10330_/A _10342_/C _10337_/C VDD VSS sg13g2_o21ai_1
X_13103_ _13104_/B _14912_/Q _13675_/Q _13091_/Y VDD VSS sg13g2_a21oi_1
XFILLER_113_708 VDD VSS sg13g2_decap_8
X_14083_ _14083_/Q clkload2/A _14083_/D _14083_/RESET_B VDD VSS sg13g2_dfrbpq_1
XFILLER_153_888 VDD VSS sg13g2_decap_8
X_11295_ _11295_/Y _11300_/S0 _13821_/Q VDD VSS sg13g2_nand2b_1
X_13034_ _13034_/Y _13032_/Y _13033_/Y _12933_/Y VDD VSS sg13g2_o21ai_1
XFILLER_152_1001 VDD VSS sg13g2_fill_2
X_10246_ _10248_/C _14776_/Q _10250_/D _14777_/Q VDD VSS sg13g2_a21oi_1
Xfanout1110 _12508_/S1 _12703_/S1 VDD VSS sg13g2_buf_1
XFILLER_26_1037 VDD VSS sg13g2_decap_8
Xfanout1121 _12770_/S1 _12773_/S1 VDD VSS sg13g2_buf_1
XFILLER_121_752 VDD VSS sg13g2_decap_8
XFILLER_152_1045 VDD VSS sg13g2_decap_8
Xfanout1132 _12411_/S1 _12381_/S1 VDD VSS sg13g2_buf_1
X_10177_ _10184_/C _10177_/A _10177_/B VDD VSS sg13g2_nand2_1
Xfanout1143 _12492_/S0 fanout1155/X VDD VSS sg13g2_buf_1
Xfanout1154 _12729_/S0 fanout1155/X VDD VSS sg13g2_buf_1
XFILLER_79_699 VDD VSS sg13g2_decap_8
XFILLER_120_273 VDD VSS sg13g2_fill_2
XFILLER_14_7 VDD VSS sg13g2_decap_8
XFILLER_93_124 VDD VSS sg13g2_decap_8
X_14985_ _14985_/Q clkload32/A _14985_/D _14985_/RESET_B VDD VSS sg13g2_dfrbpq_1
XFILLER_59_390 VDD VSS sg13g2_fill_2
XFILLER_19_232 VDD VSS sg13g2_decap_8
XFILLER_94_669 VDD VSS sg13g2_fill_2
XFILLER_47_563 VDD VSS sg13g2_decap_8
X_13936_ _13936_/Q clkload49/A _13936_/D _13936_/RESET_B VDD VSS sg13g2_dfrbpq_1
XFILLER_74_360 VDD VSS sg13g2_decap_8
XFILLER_74_371 VDD VSS sg13g2_fill_1
XFILLER_62_522 VDD VSS sg13g2_fill_1
XFILLER_90_842 VDD VSS sg13g2_fill_1
X_13867_ _13867_/Q clkload50/A _13867_/D _13867_/RESET_B VDD VSS sg13g2_dfrbpq_1
XFILLER_37_1111 VDD VSS sg13g2_decap_8
X_12818_ _12818_/Y _14800_/Q _12851_/B _13260_/B _14832_/Q _13180_/C1 VDD VSS sg13g2_a221oi_1
X_14631__1933 _14631_/RESET_B VDD VSS sg13g2_tiehi
XFILLER_90_897 VDD VSS sg13g2_decap_4
XFILLER_50_739 VDD VSS sg13g2_fill_1
X_13798_ _13798_/Q clkload16/A _13798_/D _13798_/RESET_B VDD VSS sg13g2_dfrbpq_1
X_14958__3014 _14958_/RESET_B VDD VSS sg13g2_tiehi
XFILLER_30_430 VDD VSS sg13g2_fill_1
X_12749_ _12750_/B _13665_/Q _12749_/A2 _12748_/X _12749_/B2 _12749_/C1 VDD VSS sg13g2_a221oi_1
XFILLER_37_1188 VDD VSS sg13g2_decap_8
XFILLER_72_1068 VDD VSS sg13g2_decap_8
XFILLER_124_1158 VDD VSS sg13g2_decap_8
XFILLER_8_63 VDD VSS sg13g2_decap_8
XFILLER_30_496 VDD VSS sg13g2_decap_4
X_14419_ _14419_/Q clkload7/A _14419_/D _14419_/RESET_B VDD VSS sg13g2_dfrbpq_1
Xmax_cap312 _10068_/S _10061_/S VDD VSS sg13g2_buf_4
XFILLER_128_395 VDD VSS sg13g2_decap_8
Xmax_cap323 _09903_/S _09877_/S VDD VSS sg13g2_buf_4
Xmax_cap345 _09431_/S _09410_/S VDD VSS sg13g2_buf_4
XFILLER_104_708 VDD VSS sg13g2_fill_2
X_09960_ _14544_/D _14544_/Q _10092_/A0 _09969_/S VDD VSS sg13g2_mux2_1
Xmax_cap389 wire388/A _10509_/Y VDD VSS sg13g2_buf_1
XFILLER_40_0 VDD VSS sg13g2_decap_8
XFILLER_135_1210 VDD VSS sg13g2_decap_4
X_08911_ _13710_/D _08926_/S _08909_/Y _08910_/Y VDD VSS sg13g2_a21oi_1
X_09891_ _14477_/D _09924_/A1 _14477_/Q _09904_/S VDD VSS sg13g2_mux2_1
XFILLER_98_953 VDD VSS sg13g2_decap_4
XFILLER_58_806 VDD VSS sg13g2_decap_8
X_08842_ _13693_/D _08841_/Y _13693_/Q _08842_/S VDD VSS sg13g2_mux2_1
XFILLER_85_614 VDD VSS sg13g2_decap_8
XFILLER_97_474 VDD VSS sg13g2_fill_1
XFILLER_100_936 VDD VSS sg13g2_decap_8
XFILLER_131_1129 VDD VSS sg13g2_fill_2
X_08773_ _08773_/Y _08779_/A1 _15117_/Q _15186_/Q _07719_/X VDD VSS sg13g2_a22oi_1
XFILLER_57_349 VDD VSS sg13g2_fill_1
XFILLER_84_135 VDD VSS sg13g2_decap_4
XFILLER_100_969 VDD VSS sg13g2_decap_8
XFILLER_27_28 VDD VSS sg13g2_decap_8
X_07724_ _07726_/C _15073_/Q _15072_/Q _15071_/Q _15083_/Q VDD VSS sg13g2_nor4_1
XFILLER_81_820 VDD VSS sg13g2_fill_1
XFILLER_81_831 VDD VSS sg13g2_fill_2
X_07655_ _07655_/Y _11420_/C VDD VSS sg13g2_inv_1
XFILLER_65_393 VDD VSS sg13g2_fill_1
XFILLER_0_1231 VDD VSS sg13g2_decap_4
XFILLER_20_1170 VDD VSS sg13g2_decap_8
XFILLER_80_363 VDD VSS sg13g2_decap_8
XFILLER_55_1222 VDD VSS sg13g2_decap_8
XFILLER_90_1113 VDD VSS sg13g2_decap_8
XFILLER_43_49 VDD VSS sg13g2_decap_8
XFILLER_90_1124 VDD VSS sg13g2_fill_1
X_09325_ _13932_/D _09824_/A0 _13932_/Q _09330_/S VDD VSS sg13g2_mux2_1
XFILLER_142_1203 VDD VSS sg13g2_decap_8
XFILLER_22_953 VDD VSS sg13g2_decap_8
XFILLER_21_430 VDD VSS sg13g2_decap_8
X_09256_ _13865_/D _13865_/Q _10152_/A1 _09269_/S VDD VSS sg13g2_mux2_1
XFILLER_21_474 VDD VSS sg13g2_decap_8
X_08207_ _08207_/X _08235_/A3 _07910_/B _07912_/B _07893_/B _07626_/A _08402_/A VDD
+ VSS sg13g2_mux4_1
XFILLER_154_608 VDD VSS sg13g2_fill_2
X_09187_ _13803_/D _13803_/Q _10154_/A1 _09193_/S VDD VSS sg13g2_mux2_1
XFILLER_105_1080 VDD VSS sg13g2_decap_4
X_08138_ _08138_/X _08138_/A _08511_/S _08173_/B VDD VSS sg13g2_and3_1
XFILLER_119_384 VDD VSS sg13g2_decap_4
XFILLER_49_1015 VDD VSS sg13g2_decap_8
X_08069_ _08431_/A _08037_/B _08063_/Y _08109_/A1 VDD VSS sg13g2_a21oi_1
XFILLER_49_1059 VDD VSS sg13g2_fill_1
X_10100_ _14680_/D _10100_/A0 _14680_/Q _10102_/S VDD VSS sg13g2_mux2_1
XFILLER_108_75 VDD VSS sg13g2_decap_8
XFILLER_150_858 VDD VSS sg13g2_decap_4
X_11080_ _11080_/Y _11191_/A _11079_/Y _11029_/C VDD VSS sg13g2_o21ai_1
XFILLER_62_1204 VDD VSS sg13g2_decap_4
XFILLER_89_953 VDD VSS sg13g2_decap_4
XFILLER_103_730 VDD VSS sg13g2_fill_1
X_10031_ _14613_/D _10064_/A0 _14613_/Q _10035_/S VDD VSS sg13g2_mux2_1
XFILLER_0_367 VDD VSS sg13g2_decap_8
XFILLER_88_474 VDD VSS sg13g2_decap_8
XFILLER_102_251 VDD VSS sg13g2_decap_8
XFILLER_0_378 VDD VSS sg13g2_fill_1
XFILLER_102_284 VDD VSS sg13g2_decap_4
XFILLER_75_135 VDD VSS sg13g2_fill_1
XFILLER_64_809 VDD VSS sg13g2_decap_8
XFILLER_25_1081 VDD VSS sg13g2_decap_8
XFILLER_57_861 VDD VSS sg13g2_decap_8
XFILLER_112_1040 VDD VSS sg13g2_decap_8
XFILLER_124_85 VDD VSS sg13g2_fill_2
XFILLER_5_1164 VDD VSS sg13g2_decap_8
X_14770_ _14770_/Q clkload74/A _14770_/D _14770_/RESET_B VDD VSS sg13g2_dfrbpq_1
X_11982_ _11989_/A _11983_/A _13671_/Q VDD VSS sg13g2_xor2_1
XFILLER_57_894 VDD VSS sg13g2_fill_1
X_14439__2125 _14439_/RESET_B VDD VSS sg13g2_tiehi
XFILLER_17_747 VDD VSS sg13g2_decap_8
XFILLER_44_533 VDD VSS sg13g2_fill_1
XFILLER_72_842 VDD VSS sg13g2_fill_1
X_13721_ _13721_/Q clkload19/A _13721_/D _13721_/RESET_B VDD VSS sg13g2_dfrbpq_1
X_10933_ _10935_/B _10946_/A _10934_/B _10948_/D VDD VSS sg13g2_a21oi_1
XFILLER_83_190 VDD VSS sg13g2_fill_1
XFILLER_147_1136 VDD VSS sg13g2_decap_8
XFILLER_32_728 VDD VSS sg13g2_fill_1
X_10864_ _10890_/B _14753_/Q _10871_/A VDD VSS sg13g2_xnor2_1
X_13652_ _15118_/D _15187_/D _15118_/Q _13652_/S VDD VSS sg13g2_mux2_1
XFILLER_140_84 VDD VSS sg13g2_decap_8
XFILLER_44_599 VDD VSS sg13g2_decap_8
X_12603_ _12603_/X _13837_/Q _13869_/Q _13901_/Q _13933_/Q _12603_/S0 _12604_/S1 VDD
+ VSS sg13g2_mux4_1
X_13583_ _13583_/Y _15001_/Q _13589_/A2 _13569_/S _15017_/Q _13533_/X VDD VSS sg13g2_a221oi_1
X_10795_ _14925_/D _11207_/B1 _11205_/A _10792_/Y VDD VSS sg13g2_o21ai_1
XFILLER_13_964 VDD VSS sg13g2_decap_8
XFILLER_12_452 VDD VSS sg13g2_fill_1
X_12534_ _12534_/X _13736_/Q _14088_/Q _14440_/Q _14536_/Q _12534_/S0 _12534_/S1 VDD
+ VSS sg13g2_mux4_1
XFILLER_33_71 VDD VSS sg13g2_decap_8
XFILLER_129_137 VDD VSS sg13g2_decap_8
XFILLER_12_496 VDD VSS sg13g2_decap_8
X_12465_ _12465_/X _14115_/Q _14147_/Q _14179_/Q _14211_/Q _12546_/S0 _12546_/S1 VDD
+ VSS sg13g2_mux4_1
XFILLER_8_467 VDD VSS sg13g2_decap_4
X_14204_ _14204_/Q clkload75/A _14204_/D _14204_/RESET_B VDD VSS sg13g2_dfrbpq_1
X_11416_ _11420_/A _11415_/X _11416_/B VDD VSS sg13g2_nand2b_1
X_15184_ _15184_/Q clkload65/A _15184_/D _15184_/RESET_B VDD VSS sg13g2_dfrbpq_1
X_12396_ _12396_/X _14238_/Q _14270_/Q _14302_/Q _14334_/Q _12785_/S0 _12785_/S1 VDD
+ VSS sg13g2_mux4_1
XFILLER_152_140 VDD VSS sg13g2_decap_8
X_11347_ _11347_/Y _11353_/S _14686_/Q VDD VSS sg13g2_nand2b_1
X_14135_ _14135_/Q _14505_/CLK _14135_/D _14135_/RESET_B VDD VSS sg13g2_dfrbpq_1
XFILLER_126_888 VDD VSS sg13g2_decap_4
XFILLER_67_1159 VDD VSS sg13g2_decap_8
XFILLER_99_739 VDD VSS sg13g2_decap_4
X_13698__2866 _13698_/RESET_B VDD VSS sg13g2_tiehi
XFILLER_3_161 VDD VSS sg13g2_fill_1
XFILLER_140_324 VDD VSS sg13g2_decap_8
XFILLER_125_398 VDD VSS sg13g2_fill_1
XFILLER_152_195 VDD VSS sg13g2_decap_8
X_11278_ _11278_/Y _11277_/S _14172_/Q VDD VSS sg13g2_nand2b_1
X_14066_ _14066_/Q _14738_/CLK _14066_/D _14066_/RESET_B VDD VSS sg13g2_dfrbpq_1
XFILLER_67_603 VDD VSS sg13g2_fill_1
X_14649__1915 _14649_/RESET_B VDD VSS sg13g2_tiehi
X_13017_ _13017_/Y _13045_/A1 _12997_/A input8/X VDD VSS sg13g2_a21oi_1
X_10229_ _14771_/D _10237_/A _10237_/C _10228_/Y VDD VSS sg13g2_a21oi_1
XFILLER_39_305 VDD VSS sg13g2_fill_2
X_14831__3267 _14831_/RESET_B VDD VSS sg13g2_tiehi
XFILLER_39_338 VDD VSS sg13g2_fill_2
XFILLER_67_647 VDD VSS sg13g2_decap_4
X_14078__2486 _14078_/RESET_B VDD VSS sg13g2_tiehi
XFILLER_94_466 VDD VSS sg13g2_fill_1
XFILLER_43_1192 VDD VSS sg13g2_fill_2
XFILLER_82_617 VDD VSS sg13g2_fill_2
XFILLER_48_872 VDD VSS sg13g2_fill_2
XFILLER_130_1151 VDD VSS sg13g2_fill_2
X_14968_ _14968_/Q clkload38/A _14968_/D _14968_/RESET_B VDD VSS sg13g2_dfrbpq_1
Xwire1090 wire1090/X wire1090/A VDD VSS sg13g2_buf_4
X_13919_ _13919_/Q clkload52/A _13919_/D _13919_/RESET_B VDD VSS sg13g2_dfrbpq_1
X_14899_ _14899_/Q clkload39/A _14899_/D _14899_/RESET_B VDD VSS sg13g2_dfrbpq_1
X_15017__2955 _15017_/RESET_B VDD VSS sg13g2_tiehi
XFILLER_63_886 VDD VSS sg13g2_decap_4
XFILLER_23_739 VDD VSS sg13g2_decap_8
XFILLER_90_694 VDD VSS sg13g2_decap_8
XFILLER_22_227 VDD VSS sg13g2_decap_8
X_14293__2271 _14293_/RESET_B VDD VSS sg13g2_tiehi
X_09110_ _09110_/X _10760_/A _09150_/B _09109_/Y VDD VSS sg13g2_a21o_1
XFILLER_128_1080 VDD VSS sg13g2_decap_4
XFILLER_88_0 VDD VSS sg13g2_decap_8
XFILLER_149_958 VDD VSS sg13g2_decap_4
XFILLER_148_435 VDD VSS sg13g2_decap_8
X_09041_ _09044_/B _14906_/Q _09031_/C _14907_/Q VDD VSS sg13g2_a21oi_1
XFILLER_136_619 VDD VSS sg13g2_decap_8
XFILLER_156_490 VDD VSS sg13g2_fill_1
XFILLER_11_1147 VDD VSS sg13g2_decap_8
XFILLER_50_1196 VDD VSS sg13g2_decap_8
XFILLER_143_140 VDD VSS sg13g2_decap_8
XFILLER_116_354 VDD VSS sg13g2_fill_1
XFILLER_1_109 VDD VSS sg13g2_decap_4
XFILLER_116_376 VDD VSS sg13g2_fill_2
XFILLER_89_227 VDD VSS sg13g2_decap_8
X_14517__2047 _14517_/RESET_B VDD VSS sg13g2_tiehi
X_09943_ _14527_/D _14527_/Q _10075_/A0 _09943_/S VDD VSS sg13g2_mux2_1
Xfanout903 _12749_/C1 _12763_/C1 VDD VSS sg13g2_buf_1
Xfanout914 _13275_/A2 _07728_/X VDD VSS sg13g2_buf_1
Xfanout925 _11207_/B1 _10985_/B1 VDD VSS sg13g2_buf_1
XFILLER_131_357 VDD VSS sg13g2_decap_8
Xfanout936 _12269_/A2 _12146_/B1 VDD VSS sg13g2_buf_1
XFILLER_135_1051 VDD VSS sg13g2_fill_2
X_09874_ _14460_/D _09907_/A1 _14460_/Q _09874_/S VDD VSS sg13g2_mux2_1
XFILLER_98_783 VDD VSS sg13g2_decap_4
XFILLER_140_880 VDD VSS sg13g2_decap_8
Xfanout958 _11765_/A _07656_/Y VDD VSS sg13g2_buf_1
Xfanout969 _11763_/B _12260_/A1 VDD VSS sg13g2_buf_1
XFILLER_112_582 VDD VSS sg13g2_fill_2
XFILLER_38_49 VDD VSS sg13g2_decap_8
X_14807__3291 _14807_/RESET_B VDD VSS sg13g2_tiehi
XFILLER_100_744 VDD VSS sg13g2_decap_8
X_08825_ _08825_/Y _13279_/B _12346_/A _08727_/D _15177_/Q _08825_/C1 VDD VSS sg13g2_a221oi_1
XFILLER_46_809 VDD VSS sg13g2_decap_4
XFILLER_57_157 VDD VSS sg13g2_decap_8
XFILLER_79_1019 VDD VSS sg13g2_decap_8
X_13743__2821 _13743_/RESET_B VDD VSS sg13g2_tiehi
X_08756_ _13670_/D _08765_/A1 _08754_/Y _08755_/Y VDD VSS sg13g2_a21oi_1
XFILLER_73_639 VDD VSS sg13g2_decap_4
XFILLER_66_680 VDD VSS sg13g2_decap_8
X_15126__3092 _15126_/RESET_B VDD VSS sg13g2_tiehi
X_07707_ _07708_/C _12997_/B _15201_/Q VDD VSS sg13g2_nor2_1
XFILLER_54_853 VDD VSS sg13g2_decap_8
X_08687_ _08687_/X _08465_/X _08537_/X _08621_/C _08686_/X _08538_/S _08544_/C VDD
+ VSS sg13g2_mux4_1
XFILLER_53_341 VDD VSS sg13g2_fill_1
XFILLER_92_1208 VDD VSS sg13g2_fill_1
XFILLER_0_1050 VDD VSS sg13g2_fill_1
XFILLER_14_728 VDD VSS sg13g2_fill_2
XFILLER_81_683 VDD VSS sg13g2_decap_8
X_07638_ _07638_/Y _14773_/Q VDD VSS sg13g2_inv_1
Xclkbuf_4_4_0_clk_i clkbuf_4_4_0_clk_i/X clkbuf_0_clk_i/X VDD VSS sg13g2_buf_8
XFILLER_0_1094 VDD VSS sg13g2_decap_4
X_14123__2441 _14123_/RESET_B VDD VSS sg13g2_tiehi
XFILLER_142_1000 VDD VSS sg13g2_decap_8
XFILLER_70_14 VDD VSS sg13g2_decap_8
X_13776__2788 _13776_/RESET_B VDD VSS sg13g2_tiehi
X_09308_ _13915_/D _10138_/A1 _13915_/Q _09311_/S VDD VSS sg13g2_mux2_1
XFILLER_139_424 VDD VSS sg13g2_fill_2
X_10580_ _14871_/D _10580_/A _10595_/B _10580_/C VDD VSS sg13g2_nor3_1
XFILLER_22_783 VDD VSS sg13g2_decap_8
XFILLER_142_1055 VDD VSS sg13g2_decap_4
XFILLER_22_794 VDD VSS sg13g2_fill_2
Xmax_cap1209 _12393_/S0 _12617_/S0 VDD VSS sg13g2_buf_4
XFILLER_16_1069 VDD VSS sg13g2_decap_8
XFILLER_155_917 VDD VSS sg13g2_decap_8
X_14727__1837 _14727_/RESET_B VDD VSS sg13g2_tiehi
Xclkbuf_leaf_6_clk_i clkload10/A clkbuf_leaf_9_clk_i/A VDD VSS sg13g2_buf_8
X_09239_ _13850_/D _10169_/A1 _13850_/Q _09239_/S VDD VSS sg13g2_mux2_1
XFILLER_154_438 VDD VSS sg13g2_decap_8
X_12250_ _12250_/Y _12250_/A1 _14520_/Q _11739_/B VDD VSS sg13g2_a21oi_1
X_11201_ _11201_/Y _11201_/A _11201_/B VDD VSS sg13g2_nand2_1
X_13991__2573 _13991_/RESET_B VDD VSS sg13g2_tiehi
XFILLER_107_354 VDD VSS sg13g2_decap_4
X_12181_ _12181_/X _12181_/A _12253_/B VDD VSS sg13g2_and2_1
XFILLER_134_162 VDD VSS sg13g2_decap_8
X_11132_ _14950_/D _11131_/Y _11130_/Y _11113_/Y VDD VSS sg13g2_o21ai_1
XFILLER_27_1110 VDD VSS sg13g2_decap_8
XFILLER_150_666 VDD VSS sg13g2_decap_4
XFILLER_66_1170 VDD VSS sg13g2_decap_8
XFILLER_77_912 VDD VSS sg13g2_decap_8
X_11063_ _11063_/Y _11060_/X _11035_/Y _11062_/Y VDD VSS sg13g2_a21oi_1
XFILLER_7_1215 VDD VSS sg13g2_decap_8
XFILLER_77_923 VDD VSS sg13g2_fill_1
XFILLER_77_934 VDD VSS sg13g2_decap_4
XFILLER_95_33 VDD VSS sg13g2_decap_4
X_10014_ _14596_/D _10080_/A0 _14596_/Q _10020_/S VDD VSS sg13g2_mux2_1
XFILLER_23_1007 VDD VSS sg13g2_decap_8
XFILLER_0_175 VDD VSS sg13g2_decap_8
XFILLER_153_1184 VDD VSS sg13g2_decap_8
XFILLER_27_1187 VDD VSS sg13g2_decap_8
X_14371__2193 _14371_/RESET_B VDD VSS sg13g2_tiehi
XFILLER_0_186 VDD VSS sg13g2_fill_1
XFILLER_88_293 VDD VSS sg13g2_decap_4
XFILLER_37_809 VDD VSS sg13g2_decap_8
XFILLER_49_669 VDD VSS sg13g2_fill_2
XFILLER_62_1089 VDD VSS sg13g2_decap_8
X_14822_ _14822_/Q clkload83/A _14822_/D _14822_/RESET_B VDD VSS sg13g2_dfrbpq_1
XFILLER_91_403 VDD VSS sg13g2_fill_1
XFILLER_95_99 VDD VSS sg13g2_fill_1
XFILLER_64_639 VDD VSS sg13g2_fill_1
XFILLER_91_436 VDD VSS sg13g2_fill_2
X_14753_ _14753_/Q _15200_/CLK _14753_/D _14753_/RESET_B VDD VSS sg13g2_dfrbpq_1
XFILLER_44_330 VDD VSS sg13g2_decap_8
X_11965_ _11965_/Y _11962_/Y _11964_/X _12048_/A1 VDD VSS sg13g2_o21ai_1
XFILLER_45_886 VDD VSS sg13g2_decap_8
X_13704_ _13704_/Q clkload33/A _13704_/D _13704_/RESET_B VDD VSS sg13g2_dfrbpq_1
X_10916_ _10920_/A _15119_/Q wire582/X VDD VSS sg13g2_xnor2_1
X_14684_ _14684_/Q _14776_/CLK _14684_/D _14684_/RESET_B VDD VSS sg13g2_dfrbpq_1
X_11896_ _11897_/B _11896_/A _14222_/Q VDD VSS sg13g2_nand2_1
XFILLER_17_599 VDD VSS sg13g2_decap_8
XFILLER_60_856 VDD VSS sg13g2_decap_8
XFILLER_73_1130 VDD VSS sg13g2_fill_2
X_13635_ _13743_/D _13635_/A VDD VSS sg13g2_buf_1
X_10847_ _10847_/Y _10843_/Y _10846_/Y _13279_/D VDD VSS sg13g2_a21oi_1
XFILLER_13_750 VDD VSS sg13g2_decap_8
XFILLER_34_1125 VDD VSS sg13g2_decap_8
XFILLER_13_783 VDD VSS sg13g2_decap_4
XFILLER_12_260 VDD VSS sg13g2_fill_1
X_13566_ _13566_/Y _13566_/A _13566_/B _15202_/Q VDD VSS sg13g2_nor3_1
XFILLER_81_7 VDD VSS sg13g2_decap_8
XFILLER_40_580 VDD VSS sg13g2_fill_1
X_10778_ _11180_/C _14952_/Q _10767_/A _10776_/X VDD VSS sg13g2_a21o_1
XFILLER_121_1106 VDD VSS sg13g2_decap_4
X_12517_ _12517_/X _14375_/Q _14407_/Q _14471_/Q _14503_/Q _12740_/S0 _12740_/S1 VDD
+ VSS sg13g2_mux4_1
XFILLER_145_405 VDD VSS sg13g2_decap_8
XFILLER_8_253 VDD VSS sg13g2_decap_8
X_13497_ _13498_/A _13481_/A _13656_/S _15174_/D _13487_/Y VDD VSS sg13g2_a22oi_1
XFILLER_117_129 VDD VSS sg13g2_decap_8
X_15236_ _15236_/Q clkload68/A _15236_/D _15236_/RESET_B VDD VSS sg13g2_dfrbpq_1
X_12448_ _12448_/X _14690_/Q _14722_/Q _13762_/Q _13794_/Q _12452_/S0 _12452_/S1 VDD
+ VSS sg13g2_mux4_1
XFILLER_60_91 VDD VSS sg13g2_decap_8
X_13821__2743 _13821_/RESET_B VDD VSS sg13g2_tiehi
XFILLER_153_460 VDD VSS sg13g2_decap_8
XFILLER_5_971 VDD VSS sg13g2_decap_8
X_15167_ _15167_/Q clkload67/A _15167_/D _15167_/RESET_B VDD VSS sg13g2_dfrbpq_1
X_14581__1983 _14581_/RESET_B VDD VSS sg13g2_tiehi
XFILLER_125_151 VDD VSS sg13g2_decap_4
X_12379_ _12379_/X _14109_/Q _14141_/Q _14173_/Q _14205_/Q _12381_/S0 _12381_/S1 VDD
+ VSS sg13g2_mux4_1
XFILLER_5_42 VDD VSS sg13g2_decap_8
X_14118_ _14118_/Q _14662_/CLK _14118_/D _14118_/RESET_B VDD VSS sg13g2_dfrbpq_1
XFILLER_113_335 VDD VSS sg13g2_decap_4
X_15098_ _15098_/Q clkload66/A _15098_/D _15098_/RESET_B VDD VSS sg13g2_dfrbpq_1
XFILLER_119_1057 VDD VSS sg13g2_decap_4
XFILLER_140_143 VDD VSS sg13g2_fill_2
XFILLER_45_1232 VDD VSS sg13g2_decap_4
X_14049_ _14049_/Q clkload20/A _14049_/D _14049_/RESET_B VDD VSS sg13g2_dfrbpq_1
XFILLER_41_1107 VDD VSS sg13g2_decap_4
XFILLER_132_1224 VDD VSS sg13g2_decap_8
XFILLER_68_956 VDD VSS sg13g2_decap_4
XFILLER_95_742 VDD VSS sg13g2_decap_8
XFILLER_132_1235 VDD VSS sg13g2_fill_2
XFILLER_79_293 VDD VSS sg13g2_decap_8
X_14201__2363 _14201_/RESET_B VDD VSS sg13g2_tiehi
XFILLER_94_230 VDD VSS sg13g2_fill_2
X_08610_ _08610_/Y _08576_/Y _08608_/Y _08643_/A VDD VSS sg13g2_a21oi_1
XFILLER_95_786 VDD VSS sg13g2_decap_8
X_09590_ _14187_/D _14187_/Q _10087_/A0 _09604_/S VDD VSS sg13g2_mux2_1
XFILLER_67_499 VDD VSS sg13g2_decap_4
XFILLER_48_691 VDD VSS sg13g2_decap_4
X_08541_ _08541_/Y _08541_/A _08541_/B _15012_/Q VDD VSS sg13g2_nand3_1
XFILLER_82_458 VDD VSS sg13g2_fill_2
XFILLER_82_469 VDD VSS sg13g2_decap_8
XFILLER_51_812 VDD VSS sg13g2_fill_1
X_08472_ _08472_/X _15008_/Q _08471_/B _08001_/A VDD VSS sg13g2_a21o_1
XFILLER_23_536 VDD VSS sg13g2_decap_8
XFILLER_62_171 VDD VSS sg13g2_fill_1
XFILLER_23_547 VDD VSS sg13g2_fill_1
XFILLER_50_322 VDD VSS sg13g2_decap_4
XFILLER_23_558 VDD VSS sg13g2_decap_8
XFILLER_149_711 VDD VSS sg13g2_fill_1
XFILLER_11_709 VDD VSS sg13g2_decap_8
XFILLER_51_889 VDD VSS sg13g2_fill_1
XFILLER_149_733 VDD VSS sg13g2_decap_8
XFILLER_50_377 VDD VSS sg13g2_fill_1
XFILLER_149_744 VDD VSS sg13g2_fill_2
XFILLER_10_219 VDD VSS sg13g2_decap_4
XFILLER_50_399 VDD VSS sg13g2_decap_8
XFILLER_13_1209 VDD VSS sg13g2_decap_8
XFILLER_136_416 VDD VSS sg13g2_decap_8
XFILLER_108_107 VDD VSS sg13g2_decap_8
XFILLER_136_427 VDD VSS sg13g2_fill_1
X_09024_ _09024_/X _09024_/A _09024_/B _09024_/C VDD VSS sg13g2_and3_1
XFILLER_15_1080 VDD VSS sg13g2_decap_8
XFILLER_156_28 VDD VSS sg13g2_decap_8
XFILLER_105_803 VDD VSS sg13g2_decap_8
XFILLER_145_983 VDD VSS sg13g2_decap_8
XFILLER_137_1102 VDD VSS sg13g2_fill_1
XFILLER_2_418 VDD VSS sg13g2_decap_8
XFILLER_104_302 VDD VSS sg13g2_fill_1
Xpicorv32_macro_1805 mem_axi_awprot[0] VDD VSS sg13g2_tielo
X_14912__3105 _14912_/RESET_B VDD VSS sg13g2_tiehi
XFILLER_104_335 VDD VSS sg13g2_fill_1
XFILLER_85_1078 VDD VSS sg13g2_fill_1
XFILLER_132_655 VDD VSS sg13g2_fill_1
XFILLER_59_901 VDD VSS sg13g2_fill_2
XFILLER_77_208 VDD VSS sg13g2_fill_2
Xfanout711 _08753_/A1 _08729_/Y VDD VSS sg13g2_buf_1
Xfanout1709 _12287_/S0 fanout1713/X VDD VSS sg13g2_buf_1
X_09926_ _14511_/D _14511_/Q _09926_/A1 _09930_/S VDD VSS sg13g2_mux2_1
Xfanout722 _13502_/A _13652_/S VDD VSS sg13g2_buf_1
Xfanout733 _13539_/B _13551_/S VDD VSS sg13g2_buf_1
XFILLER_59_934 VDD VSS sg13g2_decap_4
Xfanout744 _12841_/B _12798_/Y VDD VSS sg13g2_buf_1
Xfanout755 _12001_/A _11235_/X VDD VSS sg13g2_buf_1
XFILLER_131_187 VDD VSS sg13g2_decap_8
XFILLER_105_21 VDD VSS sg13g2_decap_8
Xfanout777 _10071_/A0 _08969_/X VDD VSS sg13g2_buf_1
X_09857_ _14444_/D _14444_/Q _09956_/A1 _09870_/S VDD VSS sg13g2_mux2_1
XFILLER_19_809 VDD VSS sg13g2_decap_8
XFILLER_59_978 VDD VSS sg13g2_decap_8
Xfanout788 _08752_/B _13482_/B VDD VSS sg13g2_buf_1
XFILLER_65_14 VDD VSS sg13g2_decap_8
X_08808_ _13687_/D _08808_/A _08808_/B VDD VSS sg13g2_nor2_1
X_14945__3039 _14945_/RESET_B VDD VSS sg13g2_tiehi
XFILLER_2_1101 VDD VSS sg13g2_decap_8
X_09788_ _14377_/D _09887_/A0 _14377_/Q _09801_/S VDD VSS sg13g2_mux2_1
XFILLER_46_639 VDD VSS sg13g2_decap_8
XFILLER_22_1051 VDD VSS sg13g2_decap_8
XFILLER_27_831 VDD VSS sg13g2_decap_4
X_08739_ _08739_/Y _08751_/A1 _08751_/A2 _15197_/Q VDD VSS sg13g2_o21ai_1
XFILLER_26_330 VDD VSS sg13g2_decap_4
XFILLER_2_1178 VDD VSS sg13g2_decap_8
XFILLER_82_970 VDD VSS sg13g2_fill_2
XFILLER_27_886 VDD VSS sg13g2_fill_2
XFILLER_121_42 VDD VSS sg13g2_decap_4
X_11750_ _11750_/Y _12186_/A _14474_/Q VDD VSS sg13g2_nand2b_1
XFILLER_14_514 VDD VSS sg13g2_decap_4
XFILLER_92_1027 VDD VSS sg13g2_decap_8
XFILLER_109_1215 VDD VSS sg13g2_decap_8
XFILLER_121_75 VDD VSS sg13g2_fill_1
X_10701_ _10701_/Y _09016_/B _10694_/S _08865_/Y VDD VSS sg13g2_a21oi_1
XFILLER_144_1128 VDD VSS sg13g2_decap_8
X_11681_ _11681_/Y _11686_/S0 _14376_/Q VDD VSS sg13g2_nand2b_1
XFILLER_41_377 VDD VSS sg13g2_decap_8
X_13420_ _13459_/C _15199_/Q _13448_/C VDD VSS sg13g2_and2_1
X_10632_ _10633_/C _14885_/Q _14884_/Q _14883_/Q _10632_/D VDD VSS sg13g2_and4_1
XFILLER_139_243 VDD VSS sg13g2_fill_2
XFILLER_14_84 VDD VSS sg13g2_decap_8
X_13351_ _13351_/Y _15183_/D _13351_/B _13351_/C _13351_/D VDD VSS sg13g2_nor4_1
X_10563_ _10565_/C _14866_/Q _13273_/A _14861_/Q VDD VSS sg13g2_nand3_1
X_14389__2175 _14389_/RESET_B VDD VSS sg13g2_tiehi
XFILLER_154_224 VDD VSS sg13g2_decap_8
X_12302_ _12302_/Y _12299_/Y _12300_/Y _12301_/Y VDD VSS sg13g2_o21ai_1
XFILLER_10_797 VDD VSS sg13g2_fill_1
X_10494_ _10496_/C _10513_/D _10498_/D _14852_/Q VDD VSS sg13g2_a21o_1
XFILLER_6_746 VDD VSS sg13g2_decap_8
X_13282_ _13287_/A _13282_/A1 _10671_/Y _07744_/B _07744_/C _13281_/C VDD VSS sg13g2_a221oi_1
XFILLER_6_768 VDD VSS sg13g2_decap_8
X_15021_ _15021_/Q clkload72/A _15021_/D _15021_/RESET_B VDD VSS sg13g2_dfrbpq_1
XFILLER_142_419 VDD VSS sg13g2_decap_8
X_12233_ _12237_/A _12232_/X _12233_/B VDD VSS sg13g2_nand2b_1
XFILLER_68_1232 VDD VSS sg13g2_decap_4
XFILLER_30_72 VDD VSS sg13g2_fill_1
XFILLER_123_622 VDD VSS sg13g2_fill_2
XFILLER_30_94 VDD VSS sg13g2_fill_1
X_12164_ _12164_/Y _12161_/Y _12163_/X _12173_/B1 VDD VSS sg13g2_o21ai_1
XFILLER_122_110 VDD VSS sg13g2_fill_1
XFILLER_122_121 VDD VSS sg13g2_fill_2
X_11115_ _11138_/C _11115_/A _11115_/B _11147_/A VDD VSS sg13g2_nor3_1
XFILLER_151_997 VDD VSS sg13g2_decap_8
XFILLER_68_208 VDD VSS sg13g2_fill_2
XFILLER_49_400 VDD VSS sg13g2_decap_8
X_12095_ _12095_/Y _12098_/A1 _14580_/Q VDD VSS sg13g2_nand2b_1
XFILLER_1_473 VDD VSS sg13g2_decap_8
XFILLER_7_1012 VDD VSS sg13g2_fill_2
XFILLER_1_495 VDD VSS sg13g2_decap_4
X_11046_ _11046_/Y _11046_/A _11046_/B VDD VSS sg13g2_nand2_1
XFILLER_49_466 VDD VSS sg13g2_decap_8
XFILLER_65_915 VDD VSS sg13g2_fill_1
XFILLER_7_1089 VDD VSS sg13g2_decap_8
XFILLER_37_628 VDD VSS sg13g2_decap_8
XFILLER_18_820 VDD VSS sg13g2_decap_8
XFILLER_40_1162 VDD VSS sg13g2_decap_4
X_14805_ _14805_/Q clkload74/A _14805_/D _14805_/RESET_B VDD VSS sg13g2_dfrbpq_1
XFILLER_80_929 VDD VSS sg13g2_fill_2
X_12997_ _12997_/Y _12997_/A _12997_/B VDD VSS sg13g2_nand2_1
Xclkbuf_leaf_107_clk_i clkload38/A clkbuf_5_14__f_clk_i/X VDD VSS sg13g2_buf_8
XFILLER_17_363 VDD VSS sg13g2_decap_8
XFILLER_51_119 VDD VSS sg13g2_decap_8
XFILLER_75_1225 VDD VSS sg13g2_decap_8
X_14736_ _14736_/Q clkload42/A _14736_/D _14736_/RESET_B VDD VSS sg13g2_dfrbpq_1
XFILLER_55_91 VDD VSS sg13g2_fill_1
XFILLER_75_1236 VDD VSS sg13g2_fill_1
X_11948_ _11948_/X _14576_/Q _14608_/Q _11951_/A VDD VSS sg13g2_mux2_1
X_14599__1965 _14599_/RESET_B VDD VSS sg13g2_tiehi
X_13839__2725 _13839_/RESET_B VDD VSS sg13g2_tiehi
X_14667_ _14667_/Q _14667_/CLK _14667_/D _14667_/RESET_B VDD VSS sg13g2_dfrbpq_1
X_11879_ _11879_/Y _11882_/S0 _14638_/Q VDD VSS sg13g2_nand2b_1
X_13618_ _13726_/D _13618_/A VDD VSS sg13g2_buf_1
XFILLER_32_388 VDD VSS sg13g2_decap_8
XFILLER_60_697 VDD VSS sg13g2_fill_2
XFILLER_13_580 VDD VSS sg13g2_decap_8
X_14598_ _14598_/Q _14662_/CLK _14598_/D _14598_/RESET_B VDD VSS sg13g2_dfrbpq_1
XFILLER_71_90 VDD VSS sg13g2_decap_8
XFILLER_9_562 VDD VSS sg13g2_decap_8
X_13549_ _13549_/Y _15005_/Q _13566_/B _13563_/C VDD VSS sg13g2_nor3_1
X_14219__2345 _14219_/RESET_B VDD VSS sg13g2_tiehi
Xmax_cap1551 _16874_/A _13712_/Q VDD VSS sg13g2_buf_4
Xmax_cap1562 output39/A _16863_/A VDD VSS sg13g2_buf_4
X_15219_ _15219_/Q clkload41/A _15219_/D _15219_/RESET_B VDD VSS sg13g2_dfrbpq_1
XFILLER_154_791 VDD VSS sg13g2_fill_1
XFILLER_82_1207 VDD VSS sg13g2_decap_8
Xclkbuf_5_4__f_clk_i clkbuf_leaf_9_clk_i/A clkbuf_4_2_0_clk_i/X VDD VSS sg13g2_buf_16
XFILLER_142_975 VDD VSS sg13g2_decap_8
XFILLER_113_132 VDD VSS sg13g2_decap_8
XFILLER_113_143 VDD VSS sg13g2_fill_2
X_14434__2130 _14434_/RESET_B VDD VSS sg13g2_tiehi
XFILLER_101_305 VDD VSS sg13g2_fill_1
X_07972_ _08663_/A _15017_/Q _07972_/B VDD VSS sg13g2_nand2b_1
XFILLER_113_176 VDD VSS sg13g2_fill_2
X_09711_ _14302_/D _09744_/A1 _14302_/Q _09727_/S VDD VSS sg13g2_mux2_1
XFILLER_68_753 VDD VSS sg13g2_fill_1
XFILLER_56_904 VDD VSS sg13g2_decap_8
XFILLER_56_937 VDD VSS sg13g2_fill_1
XFILLER_67_263 VDD VSS sg13g2_fill_2
XFILLER_110_883 VDD VSS sg13g2_fill_1
X_09642_ _14235_/D _09741_/A1 _14235_/Q _09661_/S VDD VSS sg13g2_mux2_1
XFILLER_132_1076 VDD VSS sg13g2_fill_2
XFILLER_28_639 VDD VSS sg13g2_fill_1
XFILLER_110_894 VDD VSS sg13g2_decap_4
XFILLER_55_436 VDD VSS sg13g2_decap_8
X_09573_ _09573_/X _10037_/A _10037_/B _09606_/C VDD VSS sg13g2_and3_1
XFILLER_36_650 VDD VSS sg13g2_decap_4
X_14467__2097 _14467_/RESET_B VDD VSS sg13g2_tiehi
XFILLER_64_981 VDD VSS sg13g2_decap_8
X_08524_ _08524_/Y _08548_/B _08275_/B _08523_/Y VDD VSS sg13g2_o21ai_1
XFILLER_42_119 VDD VSS sg13g2_decap_8
XFILLER_35_171 VDD VSS sg13g2_decap_8
XFILLER_51_642 VDD VSS sg13g2_fill_1
X_08455_ _08461_/B _08456_/C _08456_/B _08454_/X VDD VSS sg13g2_o21ai_1
Xclkbuf_leaf_71_clk_i clkload83/A clkbuf_leaf_71_clk_i/A VDD VSS sg13g2_buf_8
XFILLER_50_141 VDD VSS sg13g2_decap_4
XFILLER_17_1120 VDD VSS sg13g2_decap_8
X_08386_ _08386_/Y _08412_/B _08385_/Y _08381_/Y VDD VSS sg13g2_o21ai_1
XFILLER_149_552 VDD VSS sg13g2_decap_8
XFILLER_13_1006 VDD VSS sg13g2_decap_8
X_13693__2871 _13693_/RESET_B VDD VSS sg13g2_tiehi
XFILLER_17_1197 VDD VSS sg13g2_decap_8
XFILLER_129_7 VDD VSS sg13g2_decap_8
XFILLER_52_1088 VDD VSS sg13g2_decap_8
XFILLER_52_1099 VDD VSS sg13g2_fill_1
XFILLER_109_449 VDD VSS sg13g2_fill_1
X_14790__3308 _14790_/RESET_B VDD VSS sg13g2_tiehi
X_14644__1920 _14644_/RESET_B VDD VSS sg13g2_tiehi
Xclkbuf_leaf_86_clk_i clkload63/A clkbuf_leaf_87_clk_i/A VDD VSS sg13g2_buf_8
XFILLER_136_257 VDD VSS sg13g2_fill_1
XFILLER_136_268 VDD VSS sg13g2_decap_4
X_09007_ _09007_/X _09137_/A _09003_/X _09006_/Y VDD VSS sg13g2_a21o_1
XFILLER_3_716 VDD VSS sg13g2_decap_4
XFILLER_117_471 VDD VSS sg13g2_decap_8
XFILLER_2_226 VDD VSS sg13g2_decap_8
X_14073__2491 _14073_/RESET_B VDD VSS sg13g2_tiehi
XFILLER_133_997 VDD VSS sg13g2_fill_2
Xfanout1506 _12799_/A _14957_/Q VDD VSS sg13g2_buf_1
XFILLER_120_614 VDD VSS sg13g2_decap_8
Xfanout1517 _12859_/A _14898_/Q VDD VSS sg13g2_buf_1
XFILLER_104_176 VDD VSS sg13g2_decap_8
Xfanout1528 _13084_/A _14848_/Q VDD VSS sg13g2_buf_1
Xfanout530 _09913_/A1 _09007_/X VDD VSS sg13g2_buf_1
X_13917__2647 _13917_/RESET_B VDD VSS sg13g2_tiehi
Xfanout541 _10140_/A1 fanout542/X VDD VSS sg13g2_buf_1
Xfanout1539 _13613_/C _14748_/Q VDD VSS sg13g2_buf_1
XFILLER_24_1113 VDD VSS sg13g2_decap_8
X_14677__1887 _14677_/RESET_B VDD VSS sg13g2_tiehi
X_09909_ _14494_/D _14494_/Q _09909_/A1 _09937_/S VDD VSS sg13g2_mux2_1
X_15152__3038 _15152_/RESET_B VDD VSS sg13g2_tiehi
Xfanout574 _11181_/A _10785_/Y VDD VSS sg13g2_buf_1
X_15012__2960 _15012_/RESET_B VDD VSS sg13g2_tiehi
XFILLER_101_850 VDD VSS sg13g2_fill_2
XFILLER_59_775 VDD VSS sg13g2_decap_8
Xfanout585 _10129_/S _10132_/S VDD VSS sg13g2_buf_1
Xfanout596 _10020_/S wire603/X VDD VSS sg13g2_buf_1
XFILLER_46_403 VDD VSS sg13g2_fill_1
X_12920_ _12921_/B _07682_/A _12933_/A _12910_/Y _13271_/C wire568/X VDD VSS sg13g2_a221oi_1
XFILLER_98_1214 VDD VSS sg13g2_decap_8
Xclkbuf_leaf_24_clk_i clkload14/A clkbuf_leaf_8_clk_i/A VDD VSS sg13g2_buf_8
XFILLER_111_1138 VDD VSS sg13g2_decap_8
XFILLER_58_296 VDD VSS sg13g2_fill_1
XFILLER_18_138 VDD VSS sg13g2_fill_2
XFILLER_74_756 VDD VSS sg13g2_decap_8
XFILLER_132_63 VDD VSS sg13g2_decap_8
X_12851_ _12851_/Y _14802_/Q _12851_/B VDD VSS sg13g2_nand2_1
XFILLER_34_609 VDD VSS sg13g2_decap_8
X_11802_ _11806_/A _11801_/X _12023_/B VDD VSS sg13g2_nand2b_1
X_12782_ _12782_/X _14394_/Q _14426_/Q _14490_/Q _14522_/Q _12782_/S0 _12782_/S1 VDD
+ VSS sg13g2_mux4_1
XFILLER_92_78 VDD VSS sg13g2_decap_8
XFILLER_155_0 VDD VSS sg13g2_decap_8
X_14521_ _14521_/Q _14706_/CLK _14521_/D _14521_/RESET_B VDD VSS sg13g2_dfrbpq_1
X_11733_ _11733_/Y _11733_/A1 _14218_/Q _11739_/B VDD VSS sg13g2_a21oi_1
XFILLER_15_878 VDD VSS sg13g2_decap_8
X_14889__3151 _14889_/RESET_B VDD VSS sg13g2_tiehi
Xclkbuf_leaf_39_clk_i clkload51/A clkbuf_leaf_49_clk_i/A VDD VSS sg13g2_buf_8
XFILLER_109_1045 VDD VSS sg13g2_decap_8
XFILLER_42_675 VDD VSS sg13g2_decap_8
XFILLER_41_163 VDD VSS sg13g2_decap_4
XFILLER_42_697 VDD VSS sg13g2_fill_2
X_14452_ _14452_/Q clkload17/A _14452_/D _14452_/RESET_B VDD VSS sg13g2_dfrbpq_1
X_11664_ _11664_/Y _11664_/A _11664_/B VDD VSS sg13g2_nor2_1
XFILLER_109_1078 VDD VSS sg13g2_decap_8
X_13403_ _13403_/Y _13490_/B _13425_/A _15089_/Q VDD VSS sg13g2_nand3_1
X_10615_ _10615_/Y _10614_/A _10614_/B _10626_/B VDD VSS sg13g2_o21ai_1
X_14512__2052 _14512_/RESET_B VDD VSS sg13g2_tiehi
X_14383_ _14383_/Q clkload12/A _14383_/D _14383_/RESET_B VDD VSS sg13g2_dfrbpq_1
X_11595_ _11599_/A _11594_/X _12233_/B VDD VSS sg13g2_nand2b_1
XFILLER_155_522 VDD VSS sg13g2_decap_8
XFILLER_31_1128 VDD VSS sg13g2_fill_2
XFILLER_155_533 VDD VSS sg13g2_fill_2
X_13334_ _15169_/D hold3429/X _15169_/Q _13336_/S VDD VSS sg13g2_mux2_1
Xwire964 wire964/X wire964/A VDD VSS sg13g2_buf_4
X_10546_ _10561_/A _14864_/Q _14863_/Q VDD VSS sg13g2_nand2_1
XFILLER_155_566 VDD VSS sg13g2_decap_8
XFILLER_143_717 VDD VSS sg13g2_decap_8
X_14766__3332 _14766_/RESET_B VDD VSS sg13g2_tiehi
XFILLER_127_279 VDD VSS sg13g2_decap_4
X_13265_ _13266_/B _13265_/A1 _13264_/X _13259_/Y _13271_/C _13263_/Y VDD VSS sg13g2_a221oi_1
X_10477_ _10489_/D _14847_/Q _10504_/C _10477_/C VDD VSS sg13g2_and3_1
XFILLER_124_931 VDD VSS sg13g2_fill_2
X_15004_ _15004_/Q clkload37/A _15004_/D _15004_/RESET_B VDD VSS sg13g2_dfrbpq_1
X_12216_ _12216_/X _12211_/X _12212_/X wire964/A VDD VSS sg13g2_mux2_1
XFILLER_68_1062 VDD VSS sg13g2_decap_8
XFILLER_44_7 VDD VSS sg13g2_decap_8
X_13196_ _13196_/Y _13196_/A _13196_/B _13196_/C VDD VSS sg13g2_nand3_1
XFILLER_97_815 VDD VSS sg13g2_fill_2
XFILLER_111_603 VDD VSS sg13g2_decap_8
X_12147_ _12147_/Y wire298/X _12146_/Y _12147_/B1 VDD VSS sg13g2_a21oi_1
XFILLER_155_1076 VDD VSS sg13g2_fill_2
XFILLER_150_293 VDD VSS sg13g2_decap_8
XFILLER_2_21 VDD VSS sg13g2_decap_8
X_14799__3299 _14799_/RESET_B VDD VSS sg13g2_tiehi
XFILLER_38_904 VDD VSS sg13g2_decap_8
XFILLER_42_1224 VDD VSS sg13g2_decap_8
X_12078_ _12078_/Y _12192_/A _12076_/X _12077_/Y VDD VSS sg13g2_o21ai_1
XFILLER_42_1235 VDD VSS sg13g2_fill_2
XFILLER_65_723 VDD VSS sg13g2_decap_8
X_11029_ _11029_/Y _11029_/A _11029_/B _11029_/C VDD VSS sg13g2_nand3_1
XFILLER_65_734 VDD VSS sg13g2_fill_1
XFILLER_2_98 VDD VSS sg13g2_decap_8
XFILLER_37_447 VDD VSS sg13g2_fill_2
X_13771__2793 _13771_/RESET_B VDD VSS sg13g2_tiehi
XFILLER_18_650 VDD VSS sg13g2_decap_8
XFILLER_65_789 VDD VSS sg13g2_fill_2
XFILLER_46_981 VDD VSS sg13g2_fill_2
XFILLER_92_597 VDD VSS sg13g2_decap_4
X_14722__1842 _14722_/RESET_B VDD VSS sg13g2_tiehi
XFILLER_45_491 VDD VSS sg13g2_fill_1
XFILLER_75_1033 VDD VSS sg13g2_decap_8
XFILLER_127_1101 VDD VSS sg13g2_fill_2
X_14719_ _14719_/Q clkload56/A _14719_/D _14719_/RESET_B VDD VSS sg13g2_dfrbpq_1
XFILLER_36_1006 VDD VSS sg13g2_decap_8
XFILLER_32_130 VDD VSS sg13g2_fill_1
XFILLER_33_664 VDD VSS sg13g2_fill_2
XFILLER_33_686 VDD VSS sg13g2_fill_2
X_08240_ _08240_/Y _08539_/B1 _08237_/Y _08239_/Y VDD VSS sg13g2_o21ai_1
XANTENNA_15 _16857_/A VDD VSS sg13g2_antennanp
X_08171_ _08171_/X _11384_/A _08171_/A1 _07910_/B _07912_/B _07626_/A _13553_/A1 VDD
+ VSS sg13g2_mux4_1
XFILLER_70_0 VDD VSS sg13g2_decap_8
XFILLER_118_235 VDD VSS sg13g2_decap_8
XFILLER_134_739 VDD VSS sg13g2_decap_8
Xoutput100 mem_axi_awaddr[9] _16862_/X VDD VSS sg13g2_buf_1
Xoutput111 mem_axi_wdata[16] _15148_/Q VDD VSS sg13g2_buf_1
XFILLER_86_1140 VDD VSS sg13g2_fill_2
Xoutput122 mem_axi_wdata[26] _15158_/Q VDD VSS sg13g2_buf_1
Xoutput133 mem_axi_wdata[7] _15139_/Q VDD VSS sg13g2_buf_1
XFILLER_47_1113 VDD VSS sg13g2_decap_8
XFILLER_47_1124 VDD VSS sg13g2_fill_1
XFILLER_0_719 VDD VSS sg13g2_decap_8
X_15174__3264 _15174_/RESET_B VDD VSS sg13g2_tiehi
XFILLER_130_923 VDD VSS sg13g2_fill_2
XFILLER_82_1048 VDD VSS sg13g2_decap_8
XFILLER_102_625 VDD VSS sg13g2_decap_8
XFILLER_134_1138 VDD VSS sg13g2_decap_8
X_07955_ _07958_/B _15012_/Q _08541_/B VDD VSS sg13g2_nand2b_1
XFILLER_102_669 VDD VSS sg13g2_decap_4
XFILLER_87_369 VDD VSS sg13g2_decap_8
XFILLER_56_701 VDD VSS sg13g2_decap_4
XFILLER_68_572 VDD VSS sg13g2_decap_8
X_07886_ _07924_/C _08219_/A _13545_/A VDD VSS sg13g2_xor2_1
XFILLER_83_520 VDD VSS sg13g2_decap_4
XFILLER_110_680 VDD VSS sg13g2_decap_4
X_09625_ _14221_/D _09924_/A1 _14221_/Q wire470/X VDD VSS sg13g2_mux2_1
XFILLER_83_553 VDD VSS sg13g2_decap_4
XFILLER_44_929 VDD VSS sg13g2_decap_8
X_09556_ _14154_/D _09888_/A0 _14154_/Q _09556_/S VDD VSS sg13g2_mux2_1
XFILLER_102_44 VDD VSS sg13g2_decap_4
XFILLER_52_940 VDD VSS sg13g2_fill_2
X_08507_ _08507_/Y _07818_/Y _08506_/Y _08039_/A VDD VSS sg13g2_a21oi_1
XFILLER_145_1223 VDD VSS sg13g2_decap_8
XFILLER_19_1226 VDD VSS sg13g2_decap_8
X_09487_ _14087_/D _10017_/A0 _14087_/Q _09495_/S VDD VSS sg13g2_mux2_1
X_08438_ _08438_/Y _08436_/Y _08437_/Y _08183_/A _08435_/Y VDD VSS sg13g2_a22oi_1
XFILLER_106_1218 VDD VSS sg13g2_decap_8
XFILLER_12_848 VDD VSS sg13g2_decap_8
Xwire205 wire205/X wire205/A VDD VSS sg13g2_buf_2
XFILLER_156_319 VDD VSS sg13g2_decap_8
XFILLER_11_358 VDD VSS sg13g2_decap_8
XFILLER_11_369 VDD VSS sg13g2_fill_2
X_08369_ _08389_/B _08369_/A _08369_/B VDD VSS sg13g2_nand2_1
Xwire238 wire238/X wire238/A VDD VSS sg13g2_buf_2
XFILLER_149_393 VDD VSS sg13g2_fill_1
X_10400_ _10400_/Y _10400_/A _10400_/B _10400_/C _10400_/D VDD VSS sg13g2_nor4_1
XFILLER_20_881 VDD VSS sg13g2_fill_2
X_11380_ wire271/A _11360_/Y _11361_/Y _11379_/Y VDD VSS sg13g2_o21ai_1
XFILLER_137_566 VDD VSS sg13g2_decap_4
X_14160__2404 _14160_/RESET_B VDD VSS sg13g2_tiehi
XFILLER_137_588 VDD VSS sg13g2_decap_8
X_10331_ _14803_/D _10331_/A _10331_/B _10337_/C VDD VSS sg13g2_and3_1
XFILLER_125_739 VDD VSS sg13g2_fill_2
XFILLER_30_1172 VDD VSS sg13g2_decap_8
XFILLER_118_780 VDD VSS sg13g2_decap_8
XFILLER_11_63 VDD VSS sg13g2_decap_8
XFILLER_118_791 VDD VSS sg13g2_fill_1
X_10262_ _10262_/Y _10265_/B _10262_/B VDD VSS sg13g2_nor2_1
XFILLER_3_546 VDD VSS sg13g2_decap_8
X_13050_ _13050_/X _15062_/Q _15061_/Q _13050_/C VDD VSS sg13g2_or3_1
XFILLER_65_1224 VDD VSS sg13g2_decap_8
XFILLER_127_63 VDD VSS sg13g2_decap_8
XFILLER_65_1235 VDD VSS sg13g2_fill_2
X_14754__3347 _14754_/RESET_B VDD VSS sg13g2_tiehi
XFILLER_121_912 VDD VSS sg13g2_fill_2
X_12001_ _12001_/Y _12001_/A _12001_/B VDD VSS sg13g2_nor2_1
XFILLER_78_314 VDD VSS sg13g2_decap_8
X_10193_ _15197_/D _12866_/D _15197_/Q _13340_/S VDD VSS sg13g2_mux2_1
XFILLER_26_1219 VDD VSS sg13g2_decap_8
Xfanout1303 _09938_/A _09905_/A VDD VSS sg13g2_buf_1
Xfanout1314 _09806_/B _15063_/Q VDD VSS sg13g2_buf_1
Xfanout1325 _10793_/B _15058_/Q VDD VSS sg13g2_buf_1
Xfanout1336 _08692_/C _15020_/Q VDD VSS sg13g2_buf_1
Xfanout1347 _08668_/A _13534_/A1 VDD VSS sg13g2_buf_1
Xfanout360 _10144_/A1 _09001_/X VDD VSS sg13g2_buf_1
Xfanout1358 _08244_/B _08597_/A VDD VSS sg13g2_buf_1
XFILLER_120_466 VDD VSS sg13g2_decap_4
Xfanout1369 _08560_/B _13525_/A VDD VSS sg13g2_buf_1
XFILLER_93_317 VDD VSS sg13g2_decap_8
XFILLER_59_572 VDD VSS sg13g2_decap_8
XFILLER_120_488 VDD VSS sg13g2_decap_8
X_13952_ _13952_/Q _14726_/CLK _13952_/D _13952_/RESET_B VDD VSS sg13g2_dfrbpq_1
XFILLER_8_1195 VDD VSS sg13g2_decap_8
XFILLER_74_520 VDD VSS sg13g2_decap_4
X_12903_ _12904_/B _13048_/B _12902_/Y _12894_/X _12808_/A _12898_/Y VDD VSS sg13g2_a221oi_1
X_13883_ _13883_/Q clkload76/A _13883_/D _13883_/RESET_B VDD VSS sg13g2_dfrbpq_1
XFILLER_62_715 VDD VSS sg13g2_fill_2
XFILLER_46_288 VDD VSS sg13g2_decap_8
X_12834_ _12834_/Y _12835_/A _13691_/Q VDD VSS sg13g2_nor2_1
X_15096__3172 _15096_/RESET_B VDD VSS sg13g2_tiehi
X_12765_ _12778_/A _10177_/A _12779_/A2 _15019_/Q VDD VSS sg13g2_a21oi_1
XFILLER_42_450 VDD VSS sg13g2_fill_2
X_14504_ _14504_/Q _15160_/CLK _14504_/D _14504_/RESET_B VDD VSS sg13g2_dfrbpq_1
X_11716_ _11717_/B _11708_/X _11709_/X _11712_/X _11713_/X wire964/X _12221_/B1 VDD
+ VSS sg13g2_mux4_1
X_12696_ _12696_/X _14132_/Q _14164_/Q _14196_/Q _14228_/Q _12699_/S0 _12745_/S1 VDD
+ VSS sg13g2_mux4_1
X_14435_ _14435_/Q clkload1/A _14435_/D _14435_/RESET_B VDD VSS sg13g2_dfrbpq_1
X_11647_ _11647_/X _13735_/Q _14087_/Q _14439_/Q _14535_/Q _12067_/S0 _12067_/S1 VDD
+ VSS sg13g2_mux4_1
Xinput13 input13/X input13/A VDD VSS sg13g2_buf_1
XFILLER_122_1031 VDD VSS sg13g2_decap_8
XFILLER_156_853 VDD VSS sg13g2_fill_2
Xinput24 input24/X input24/A VDD VSS sg13g2_buf_1
Xinput35 input35/X input35/A VDD VSS sg13g2_buf_1
X_14366_ _14366_/Q _14494_/CLK _14366_/D _14366_/RESET_B VDD VSS sg13g2_dfrbpq_1
X_11578_ _11578_/X _13957_/Q _13989_/Q _14021_/Q _14053_/Q _11578_/S0 _11580_/S1 VDD
+ VSS sg13g2_mux4_1
X_13317_ _15062_/D _15078_/Q _07694_/Y _13316_/X VDD VSS sg13g2_a21o_1
Xmax_cap516 _09201_/S _09202_/S VDD VSS sg13g2_buf_4
XFILLER_122_1097 VDD VSS sg13g2_decap_4
XFILLER_128_588 VDD VSS sg13g2_decap_8
X_10529_ _14858_/D _10529_/A _10529_/B _10557_/C VDD VSS sg13g2_and3_1
X_14297_ _14297_/Q _14731_/CLK _14297_/D _14297_/RESET_B VDD VSS sg13g2_dfrbpq_1
X_13789__2775 _13789_/RESET_B VDD VSS sg13g2_tiehi
Xmax_cap549 _09160_/S _09167_/S VDD VSS sg13g2_buf_4
XFILLER_143_558 VDD VSS sg13g2_decap_8
Xclkbuf_5_22__f_clk_i clkbuf_leaf_60_clk_i/A clkbuf_4_11_0_clk_i/X VDD VSS sg13g2_buf_16
X_13248_ _13251_/A _14796_/Q _13248_/B VDD VSS sg13g2_nand2_1
XFILLER_112_901 VDD VSS sg13g2_decap_4
XFILLER_69_314 VDD VSS sg13g2_decap_4
X_13179_ _13179_/Y _14855_/Q _13234_/B VDD VSS sg13g2_nand2_1
XFILLER_42_1010 VDD VSS sg13g2_fill_2
XFILLER_85_818 VDD VSS sg13g2_fill_1
XFILLER_111_455 VDD VSS sg13g2_fill_2
XFILLER_38_712 VDD VSS sg13g2_fill_1
X_14169__2395 _14169_/RESET_B VDD VSS sg13g2_tiehi
XFILLER_81_1092 VDD VSS sg13g2_fill_1
XFILLER_84_328 VDD VSS sg13g2_fill_1
X_07740_ _07740_/Y _07740_/A _13289_/C VDD VSS sg13g2_nand2_1
XFILLER_93_851 VDD VSS sg13g2_decap_4
XFILLER_53_704 VDD VSS sg13g2_decap_8
XFILLER_77_1106 VDD VSS sg13g2_decap_8
X_07671_ _13281_/C _07665_/X _07670_/Y _07667_/Y VDD VSS sg13g2_a21oi_1
X_16869_ _16869_/X _16869_/A VDD VSS sg13g2_buf_1
XFILLER_93_873 VDD VSS sg13g2_fill_1
X_09410_ _14012_/D _10105_/A _14012_/Q _09410_/S VDD VSS sg13g2_mux2_1
XFILLER_19_981 VDD VSS sg13g2_decap_8
XFILLER_93_895 VDD VSS sg13g2_fill_2
XFILLER_25_439 VDD VSS sg13g2_decap_4
XFILLER_34_940 VDD VSS sg13g2_decap_8
X_14384__2180 _14384_/RESET_B VDD VSS sg13g2_tiehi
X_09341_ _09441_/D _10037_/A _09606_/C VDD VSS sg13g2_nor2b_1
XFILLER_61_770 VDD VSS sg13g2_decap_4
X_09272_ _13881_/D _13881_/Q _09705_/A0 _09272_/S VDD VSS sg13g2_mux2_1
XFILLER_138_308 VDD VSS sg13g2_fill_2
X_08223_ _08223_/X _08119_/X _08128_/X _08488_/A VDD VSS sg13g2_mux2_1
XFILLER_20_144 VDD VSS sg13g2_fill_1
XFILLER_119_522 VDD VSS sg13g2_fill_1
XFILLER_14_1134 VDD VSS sg13g2_decap_8
X_14976__2996 _14976_/RESET_B VDD VSS sg13g2_tiehi
XFILLER_147_853 VDD VSS sg13g2_fill_2
XFILLER_140_1153 VDD VSS sg13g2_fill_2
X_08154_ _08154_/Y _08200_/A _08201_/A _08659_/B _08484_/C VDD VSS sg13g2_nor4_1
XFILLER_140_1186 VDD VSS sg13g2_decap_8
XFILLER_140_1197 VDD VSS sg13g2_fill_2
X_08085_ _08270_/C _08085_/A _08599_/B VDD VSS sg13g2_nand2_1
XFILLER_101_1159 VDD VSS sg13g2_decap_8
X_14873__3183 _14873_/RESET_B VDD VSS sg13g2_tiehi
Xhold3411 hold3411/X input34/X VDD VSS sg13g2_dlygate4sd3_1
Xhold3422 hold3422/X input26/X VDD VSS sg13g2_dlygate4sd3_1
XFILLER_88_623 VDD VSS sg13g2_fill_1
XFILLER_0_527 VDD VSS sg13g2_decap_8
XFILLER_103_934 VDD VSS sg13g2_decap_8
Xhold3433 hold3433/X input7/X VDD VSS sg13g2_dlygate4sd3_1
XFILLER_0_538 VDD VSS sg13g2_fill_1
Xhold3444 input11/A mem_axi_rdata[16] VDD VSS sg13g2_dlygate4sd3_1
Xhold3455 input18/A mem_axi_rdata[22] VDD VSS sg13g2_dlygate4sd3_1
Xhold3466 _13640_/A _13748_/Q VDD VSS sg13g2_dlygate4sd3_1
XFILLER_48_509 VDD VSS sg13g2_decap_8
Xhold3477 _13642_/A _13750_/Q VDD VSS sg13g2_dlygate4sd3_1
X_08987_ _08988_/C _12859_/A _10681_/A _10674_/A VDD VSS sg13g2_and3_1
Xhold3488 _10903_/A _14935_/Q VDD VSS sg13g2_dlygate4sd3_1
XFILLER_60_1132 VDD VSS sg13g2_fill_1
Xhold3499 _13631_/A _13739_/Q VDD VSS sg13g2_dlygate4sd3_1
X_13834__2730 _13834_/RESET_B VDD VSS sg13g2_tiehi
X_14594__1970 _14594_/RESET_B VDD VSS sg13g2_tiehi
X_07938_ _07938_/Y _07797_/D _07935_/Y _07937_/Y VDD VSS sg13g2_o21ai_1
X_15059__2882 _15059_/RESET_B VDD VSS sg13g2_tiehi
XFILLER_87_199 VDD VSS sg13g2_fill_2
XFILLER_28_222 VDD VSS sg13g2_decap_8
XFILLER_113_21 VDD VSS sg13g2_decap_8
XFILLER_21_1138 VDD VSS sg13g2_decap_8
XFILLER_60_1187 VDD VSS sg13g2_decap_8
XFILLER_44_704 VDD VSS sg13g2_decap_8
X_07869_ _07869_/X _07912_/B _08201_/A VDD VSS sg13g2_or2_1
XFILLER_16_406 VDD VSS sg13g2_decap_8
XFILLER_84_884 VDD VSS sg13g2_decap_8
XFILLER_73_14 VDD VSS sg13g2_decap_8
X_09608_ _14204_/D _10105_/A _14204_/Q wire470/A VDD VSS sg13g2_mux2_1
XFILLER_73_25 VDD VSS sg13g2_fill_1
X_10880_ _10880_/Y wire584/X _14754_/Q VDD VSS sg13g2_nor2b_1
XFILLER_44_759 VDD VSS sg13g2_fill_1
XFILLER_71_545 VDD VSS sg13g2_decap_8
XFILLER_25_962 VDD VSS sg13g2_decap_8
X_14214__2350 _14214_/RESET_B VDD VSS sg13g2_tiehi
X_09539_ _14138_/D _10102_/A0 _14138_/Q _09539_/S VDD VSS sg13g2_mux2_1
XFILLER_19_1023 VDD VSS sg13g2_decap_8
XFILLER_71_589 VDD VSS sg13g2_decap_8
XFILLER_12_601 VDD VSS sg13g2_fill_1
X_13867__2697 _13867_/RESET_B VDD VSS sg13g2_tiehi
XFILLER_24_472 VDD VSS sg13g2_fill_2
X_12550_ _12550_/X _13961_/Q _13993_/Q _14025_/Q _14057_/Q _12550_/S0 _12550_/S1 VDD
+ VSS sg13g2_mux4_1
XFILLER_51_291 VDD VSS sg13g2_decap_8
XFILLER_8_605 VDD VSS sg13g2_decap_8
X_11501_ _14964_/D _11483_/A _11522_/A2 _11500_/Y VDD VSS sg13g2_a21o_1
XFILLER_106_1048 VDD VSS sg13g2_decap_8
X_12481_ _12481_/X _12478_/X _12477_/X _12474_/X _12473_/X _12761_/S0 _12732_/S1 VDD
+ VSS sg13g2_mux4_1
XFILLER_11_155 VDD VSS sg13g2_fill_2
XFILLER_40_987 VDD VSS sg13g2_decap_8
XFILLER_156_127 VDD VSS sg13g2_decap_8
XFILLER_156_138 VDD VSS sg13g2_fill_1
XFILLER_8_649 VDD VSS sg13g2_decap_4
X_14220_ _14220_/Q clkload54/A _14220_/D _14220_/RESET_B VDD VSS sg13g2_dfrbpq_1
X_11432_ _14961_/D _11428_/A _11522_/A2 _11431_/Y VDD VSS sg13g2_a21o_1
XFILLER_138_886 VDD VSS sg13g2_fill_1
XFILLER_137_363 VDD VSS sg13g2_decap_8
XFILLER_22_84 VDD VSS sg13g2_decap_4
X_14151_ _14151_/Q _14725_/CLK _14151_/D _14151_/RESET_B VDD VSS sg13g2_dfrbpq_1
XFILLER_118_0 VDD VSS sg13g2_decap_8
XFILLER_137_385 VDD VSS sg13g2_fill_2
X_11363_ _11363_/Y _11365_/A _14398_/Q _12307_/C VDD VSS sg13g2_a21oi_1
XFILLER_125_525 VDD VSS sg13g2_decap_8
XFILLER_3_321 VDD VSS sg13g2_decap_4
X_13102_ _13104_/A _14913_/Q _13674_/Q VDD VSS sg13g2_xor2_1
XFILLER_153_867 VDD VSS sg13g2_decap_8
XFILLER_125_558 VDD VSS sg13g2_decap_8
X_10314_ _10359_/A _14796_/Q _14797_/Q _10330_/A _10327_/B VDD VSS sg13g2_nand4_1
X_14082_ _14082_/Q _14722_/CLK _14082_/D _14082_/RESET_B VDD VSS sg13g2_dfrbpq_1
X_11294_ _14958_/D _12825_/B _11248_/B _11293_/Y VDD VSS sg13g2_a21o_1
XFILLER_3_354 VDD VSS sg13g2_decap_8
XFILLER_79_601 VDD VSS sg13g2_fill_2
XFILLER_0_0 VDD VSS sg13g2_decap_8
X_13033_ _13033_/Y input27/X _12997_/Y _12937_/Y VDD VSS sg13g2_o21ai_1
X_10245_ _14776_/D _10245_/A _13319_/A _10245_/C VDD VSS sg13g2_nor3_1
XFILLER_117_1122 VDD VSS sg13g2_decap_4
Xfanout1100 _12550_/S1 _12729_/S1 VDD VSS sg13g2_buf_1
XFILLER_121_731 VDD VSS sg13g2_decap_8
XFILLER_65_1076 VDD VSS sg13g2_decap_8
XFILLER_67_807 VDD VSS sg13g2_fill_1
Xfanout1111 _12703_/S1 fanout1120/X VDD VSS sg13g2_buf_1
XFILLER_78_144 VDD VSS sg13g2_decap_4
X_10176_ _10176_/Y _14747_/Q _10174_/Y _10175_/Y VDD VSS sg13g2_a21oi_1
Xfanout1122 _12772_/S1 _12773_/S1 VDD VSS sg13g2_buf_1
Xfanout1133 _12592_/S1 fanout1135/X VDD VSS sg13g2_buf_1
XFILLER_120_252 VDD VSS sg13g2_decap_8
Xfanout1155 fanout1155/X fanout1181/X VDD VSS sg13g2_buf_1
Xfanout1166 _12425_/S0 fanout1181/X VDD VSS sg13g2_buf_1
Xfanout1177 _12757_/S0 _12480_/S0 VDD VSS sg13g2_buf_1
X_14984_ _14984_/Q clkload32/A _14984_/D _14984_/RESET_B VDD VSS sg13g2_dfrbpq_1
Xfanout190 _09698_/A0 _09929_/A1 VDD VSS sg13g2_buf_1
Xfanout1188 _12773_/S0 fanout1194/X VDD VSS sg13g2_buf_1
Xfanout1199 _12661_/S0 fanout1205/X VDD VSS sg13g2_buf_1
XFILLER_75_851 VDD VSS sg13g2_decap_4
XFILLER_47_70 VDD VSS sg13g2_decap_4
X_13935_ _13935_/Q clkload12/A _13935_/D _13935_/RESET_B VDD VSS sg13g2_dfrbpq_1
XFILLER_19_277 VDD VSS sg13g2_decap_8
XFILLER_34_214 VDD VSS sg13g2_fill_1
XFILLER_90_832 VDD VSS sg13g2_decap_4
X_13866_ _13866_/Q clkload22/A _13866_/D _13866_/RESET_B VDD VSS sg13g2_dfrbpq_1
XFILLER_62_534 VDD VSS sg13g2_decap_8
XFILLER_62_545 VDD VSS sg13g2_fill_1
XFILLER_16_962 VDD VSS sg13g2_decap_8
XFILLER_76_1150 VDD VSS sg13g2_decap_8
X_12817_ _12817_/Y _14864_/Q _12862_/B VDD VSS sg13g2_nand2_1
X_13797_ _13797_/Q _14405_/CLK _13797_/D _13797_/RESET_B VDD VSS sg13g2_dfrbpq_1
XFILLER_37_1156 VDD VSS sg13g2_fill_1
X_12748_ _12748_/X _12746_/X _12747_/X _12748_/S VDD VSS sg13g2_mux2_1
XFILLER_31_976 VDD VSS sg13g2_decap_8
XFILLER_8_42 VDD VSS sg13g2_decap_8
X_12679_ wire372/A _13670_/Q _12679_/A2 _12678_/X _12679_/B2 _12679_/C1 VDD VSS sg13g2_a221oi_1
X_14418_ _14418_/Q clkload19/A _14418_/D _14418_/RESET_B VDD VSS sg13g2_dfrbpq_1
XFILLER_129_886 VDD VSS sg13g2_decap_4
X_13912__2652 _13912_/RESET_B VDD VSS sg13g2_tiehi
X_14349_ _14349_/Q _14737_/CLK _14349_/D _14349_/RESET_B VDD VSS sg13g2_dfrbpq_1
X_14672__1892 _14672_/RESET_B VDD VSS sg13g2_tiehi
Xmax_cap335 _09605_/S _09593_/S VDD VSS sg13g2_buf_4
XFILLER_6_170 VDD VSS sg13g2_decap_8
XFILLER_155_193 VDD VSS sg13g2_decap_8
XFILLER_6_181 VDD VSS sg13g2_fill_1
XFILLER_143_355 VDD VSS sg13g2_fill_1
X_08910_ _08910_/Y _08835_/A _08835_/B hold3520/X VDD VSS sg13g2_a21oi_1
X_09890_ _14476_/D _09923_/A1 _14476_/Q _09903_/S VDD VSS sg13g2_mux2_1
X_14256__2308 _14256_/RESET_B VDD VSS sg13g2_tiehi
XFILLER_112_731 VDD VSS sg13g2_fill_2
XFILLER_33_0 VDD VSS sg13g2_decap_8
XFILLER_44_1116 VDD VSS sg13g2_decap_8
XFILLER_112_742 VDD VSS sg13g2_decap_8
XFILLER_44_1138 VDD VSS sg13g2_fill_2
X_08841_ _08841_/Y _08871_/S _08840_/Y _08836_/Y VDD VSS sg13g2_o21ai_1
XFILLER_111_230 VDD VSS sg13g2_fill_1
XFILLER_97_486 VDD VSS sg13g2_decap_8
XFILLER_111_274 VDD VSS sg13g2_fill_1
X_08772_ _08772_/Y _13676_/Q _08778_/B VDD VSS sg13g2_nor2_1
X_07723_ _07726_/B _08183_/A _15095_/Q _15091_/Q _15090_/Q VDD VSS sg13g2_nor4_1
XFILLER_0_1210 VDD VSS sg13g2_fill_1
X_07654_ _07654_/Y _11970_/C VDD VSS sg13g2_inv_1
XFILLER_53_556 VDD VSS sg13g2_decap_8
XFILLER_80_342 VDD VSS sg13g2_decap_8
XFILLER_129_1026 VDD VSS sg13g2_fill_2
XFILLER_81_876 VDD VSS sg13g2_fill_1
XFILLER_55_1201 VDD VSS sg13g2_decap_8
XFILLER_81_887 VDD VSS sg13g2_fill_1
XFILLER_43_28 VDD VSS sg13g2_decap_8
XFILLER_90_1103 VDD VSS sg13g2_decap_4
XFILLER_40_217 VDD VSS sg13g2_decap_8
X_09324_ _13931_/D _09922_/A1 _13931_/Q _09339_/S VDD VSS sg13g2_mux2_1
X_09255_ _13864_/D _13864_/Q _09787_/A0 _09271_/S VDD VSS sg13g2_mux2_1
XFILLER_138_116 VDD VSS sg13g2_decap_8
XFILLER_138_127 VDD VSS sg13g2_fill_2
X_08206_ _08211_/B _15104_/Q _15091_/Q _08247_/A VDD VSS sg13g2_o21ai_1
XFILLER_21_497 VDD VSS sg13g2_decap_8
X_09186_ _13802_/D _13802_/Q _10153_/A1 _09200_/S VDD VSS sg13g2_mux2_1
XFILLER_153_119 VDD VSS sg13g2_decap_8
XFILLER_119_363 VDD VSS sg13g2_decap_8
X_08137_ _08138_/A _11384_/A _11335_/A _13602_/A _13601_/A _08215_/S0 _08337_/S1 VDD
+ VSS sg13g2_mux4_1
XFILLER_88_1032 VDD VSS sg13g2_decap_4
XFILLER_107_525 VDD VSS sg13g2_decap_8
XFILLER_111_7 VDD VSS sg13g2_decap_8
XFILLER_107_536 VDD VSS sg13g2_fill_2
XFILLER_88_1065 VDD VSS sg13g2_decap_4
XFILLER_108_21 VDD VSS sg13g2_decap_8
X_08068_ _08068_/Y _08029_/Y _08066_/Y _08256_/A _08200_/A _08067_/Y VDD VSS sg13g2_a221oi_1
XFILLER_107_569 VDD VSS sg13g2_decap_8
XFILLER_89_910 VDD VSS sg13g2_fill_1
XFILLER_108_54 VDD VSS sg13g2_decap_8
XFILLER_122_517 VDD VSS sg13g2_fill_1
XFILLER_136_1019 VDD VSS sg13g2_decap_8
XFILLER_68_14 VDD VSS sg13g2_decap_8
XFILLER_150_837 VDD VSS sg13g2_decap_8
Xclkbuf_4_0_0_clk_i clkbuf_4_0_0_clk_i/X clkbuf_0_clk_i/X VDD VSS sg13g2_buf_8
XFILLER_68_25 VDD VSS sg13g2_fill_1
XFILLER_122_539 VDD VSS sg13g2_fill_1
X_10030_ _14612_/D _10030_/A0 _14612_/Q wire603/X VDD VSS sg13g2_mux2_1
XFILLER_0_346 VDD VSS sg13g2_fill_1
XFILLER_89_976 VDD VSS sg13g2_decap_8
XFILLER_88_453 VDD VSS sg13g2_decap_8
XFILLER_103_775 VDD VSS sg13g2_decap_8
XFILLER_25_1060 VDD VSS sg13g2_decap_8
XFILLER_5_1143 VDD VSS sg13g2_decap_8
XFILLER_84_35 VDD VSS sg13g2_decap_8
X_11981_ _12012_/A _11983_/A _13671_/Q VDD VSS sg13g2_nand2_1
XFILLER_91_629 VDD VSS sg13g2_fill_2
XFILLER_17_726 VDD VSS sg13g2_decap_8
X_13720_ _16882_/A clkload18/A _13720_/D _13720_/RESET_B VDD VSS sg13g2_dfrbpq_1
XFILLER_29_597 VDD VSS sg13g2_decap_8
X_10932_ _10948_/D _10946_/B _10932_/B VDD VSS sg13g2_nand2_1
XFILLER_90_139 VDD VSS sg13g2_decap_8
XFILLER_17_84 VDD VSS sg13g2_decap_8
X_13651_ _15117_/D _15186_/D _15117_/Q _13651_/S VDD VSS sg13g2_mux2_1
XFILLER_140_63 VDD VSS sg13g2_decap_8
XFILLER_71_364 VDD VSS sg13g2_decap_4
X_10863_ _10863_/X _10871_/A _14753_/Q VDD VSS sg13g2_and2_1
XFILLER_147_1159 VDD VSS sg13g2_fill_1
X_12602_ _12602_/X _13965_/Q _13997_/Q _14029_/Q _14061_/Q _12603_/S0 _12604_/S1 VDD
+ VSS sg13g2_mux4_1
X_13582_ _15159_/D _13593_/B _13580_/Y _13581_/Y VDD VSS sg13g2_a21oi_1
X_10794_ _11205_/A _14956_/Q _08954_/S _10793_/X VDD VSS sg13g2_a21oi_1
XFILLER_12_431 VDD VSS sg13g2_decap_8
XFILLER_33_50 VDD VSS sg13g2_decap_8
X_12533_ _12533_/X _14568_/Q _14600_/Q _14632_/Q _14664_/Q _12534_/S0 _12534_/S1 VDD
+ VSS sg13g2_mux4_1
XFILLER_12_464 VDD VSS sg13g2_fill_1
XFILLER_12_486 VDD VSS sg13g2_fill_1
XFILLER_32_1031 VDD VSS sg13g2_decap_8
XFILLER_8_446 VDD VSS sg13g2_decap_8
X_14954__3021 _14954_/RESET_B VDD VSS sg13g2_tiehi
XFILLER_32_1042 VDD VSS sg13g2_fill_1
X_12464_ _12464_/X _13731_/Q _14083_/Q _14435_/Q _14531_/Q _12464_/S0 _12546_/S1 VDD
+ VSS sg13g2_mux4_1
XFILLER_32_1053 VDD VSS sg13g2_decap_4
XFILLER_138_672 VDD VSS sg13g2_decap_4
X_14203_ _14203_/Q clkload73/A _14203_/D _14203_/RESET_B VDD VSS sg13g2_dfrbpq_1
X_11415_ _11415_/X _14111_/Q _14143_/Q _11415_/S VDD VSS sg13g2_mux2_1
XFILLER_123_1192 VDD VSS sg13g2_fill_2
XFILLER_32_1086 VDD VSS sg13g2_decap_8
X_15183_ _15183_/Q clkload65/A _15183_/D _15183_/RESET_B VDD VSS sg13g2_dfrbpq_1
XFILLER_137_171 VDD VSS sg13g2_decap_4
X_12395_ _12395_/X _14366_/Q _14398_/Q _14462_/Q _14494_/Q _12615_/S0 _12785_/S1 VDD
+ VSS sg13g2_mux4_1
XFILLER_153_642 VDD VSS sg13g2_fill_1
XFILLER_4_630 VDD VSS sg13g2_decap_8
X_14134_ _14134_/Q _14710_/CLK _14134_/D _14134_/RESET_B VDD VSS sg13g2_dfrbpq_1
XFILLER_125_344 VDD VSS sg13g2_decap_8
XFILLER_126_867 VDD VSS sg13g2_fill_2
X_11346_ _11346_/Y _11342_/Y _11343_/Y _11345_/Y _11344_/Y _11875_/B VDD VSS sg13g2_a221oi_1
X_15176__3256 _15176_/RESET_B VDD VSS sg13g2_tiehi
XFILLER_3_140 VDD VSS sg13g2_decap_8
XFILLER_4_674 VDD VSS sg13g2_decap_4
XFILLER_119_1228 VDD VSS sg13g2_decap_8
XFILLER_152_174 VDD VSS sg13g2_decap_8
XFILLER_113_539 VDD VSS sg13g2_decap_8
X_14065_ _14065_/Q clkload44/A _14065_/D _14065_/RESET_B VDD VSS sg13g2_dfrbpq_1
X_11277_ _11277_/X _14108_/Q _14140_/Q _11277_/S VDD VSS sg13g2_mux2_1
XFILLER_4_696 VDD VSS sg13g2_decap_4
XFILLER_106_580 VDD VSS sg13g2_decap_8
XFILLER_106_591 VDD VSS sg13g2_fill_2
X_13016_ wire565/A _13013_/Y _13014_/Y _13015_/Y VDD VSS sg13g2_a21oi_1
X_10228_ _10228_/Y _10237_/A _10237_/C _10337_/C VDD VSS sg13g2_o21ai_1
XFILLER_121_550 VDD VSS sg13g2_decap_4
XFILLER_121_583 VDD VSS sg13g2_decap_8
X_10159_ _14736_/D _14736_/Q _10159_/A1 _10168_/S VDD VSS sg13g2_mux2_1
XFILLER_48_862 VDD VSS sg13g2_fill_2
XFILLER_130_1130 VDD VSS sg13g2_decap_8
X_14967_ _14967_/Q clkload37/A _14967_/D _14967_/RESET_B VDD VSS sg13g2_dfrbpq_1
XFILLER_81_106 VDD VSS sg13g2_decap_8
XFILLER_47_383 VDD VSS sg13g2_fill_2
XFILLER_81_128 VDD VSS sg13g2_decap_8
X_13918_ _13918_/Q clkload59/A _13918_/D _13918_/RESET_B VDD VSS sg13g2_dfrbpq_1
XFILLER_81_139 VDD VSS sg13g2_fill_2
X_14898_ _14898_/Q clkload63/A _14898_/D _14898_/RESET_B VDD VSS sg13g2_dfrbpq_1
XFILLER_130_1196 VDD VSS sg13g2_decap_4
XFILLER_63_865 VDD VSS sg13g2_decap_8
XFILLER_35_567 VDD VSS sg13g2_decap_8
XFILLER_39_1229 VDD VSS sg13g2_decap_8
XFILLER_23_718 VDD VSS sg13g2_decap_8
XFILLER_50_504 VDD VSS sg13g2_fill_1
X_13849_ _13849_/Q clkload15/A _13849_/D _13849_/RESET_B VDD VSS sg13g2_dfrbpq_1
XFILLER_35_589 VDD VSS sg13g2_fill_1
XFILLER_22_206 VDD VSS sg13g2_decap_8
XFILLER_62_386 VDD VSS sg13g2_fill_1
XFILLER_128_1070 VDD VSS sg13g2_fill_2
XFILLER_31_751 VDD VSS sg13g2_fill_1
XFILLER_30_261 VDD VSS sg13g2_decap_8
X_09040_ _10716_/B _09034_/S _15034_/Q _09039_/Y VDD VSS sg13g2_o21ai_1
XFILLER_129_672 VDD VSS sg13g2_fill_1
XFILLER_11_1126 VDD VSS sg13g2_decap_8
XFILLER_8_980 VDD VSS sg13g2_decap_8
XFILLER_50_1175 VDD VSS sg13g2_decap_8
XFILLER_144_620 VDD VSS sg13g2_fill_2
XFILLER_116_333 VDD VSS sg13g2_fill_1
X_09942_ _14526_/D _14526_/Q _10141_/A1 _09961_/S VDD VSS sg13g2_mux2_1
XFILLER_104_539 VDD VSS sg13g2_decap_8
Xfanout904 _12763_/C1 _12498_/C1 VDD VSS sg13g2_buf_1
XFILLER_48_1060 VDD VSS sg13g2_fill_1
Xfanout915 _13123_/A2 _13220_/A2 VDD VSS sg13g2_buf_1
Xfanout926 _10985_/B1 _10999_/B1 VDD VSS sg13g2_buf_1
X_09873_ _14459_/D _09906_/A1 _14459_/Q _09874_/S VDD VSS sg13g2_mux2_1
Xfanout937 _12146_/B1 _11431_/A1 VDD VSS sg13g2_buf_1
XFILLER_86_924 VDD VSS sg13g2_decap_8
Xfanout948 _13336_/S _13333_/S VDD VSS sg13g2_buf_1
Xfanout959 _11313_/A1 _11378_/S VDD VSS sg13g2_buf_1
XFILLER_38_28 VDD VSS sg13g2_decap_8
X_08824_ _08824_/Y _13482_/A _15190_/Q VDD VSS sg13g2_nand2_1
XFILLER_58_659 VDD VSS sg13g2_decap_8
XFILLER_86_968 VDD VSS sg13g2_fill_2
XFILLER_39_840 VDD VSS sg13g2_fill_1
XFILLER_39_851 VDD VSS sg13g2_fill_1
XFILLER_22_1233 VDD VSS sg13g2_decap_4
X_08755_ _08755_/Y _13670_/Q _08787_/B VDD VSS sg13g2_nor2_1
XFILLER_94_990 VDD VSS sg13g2_decap_8
X_07706_ _07708_/B _12911_/B _15201_/Q _12799_/A VDD VSS sg13g2_a21oi_1
XFILLER_66_692 VDD VSS sg13g2_fill_2
X_08686_ _08686_/X _08048_/B _08686_/A1 _08686_/A2 _08686_/A3 _08686_/S0 _08686_/S1
+ VDD VSS sg13g2_mux4_1
X_15098__3164 _15098_/RESET_B VDD VSS sg13g2_tiehi
XFILLER_26_545 VDD VSS sg13g2_fill_1
XFILLER_81_662 VDD VSS sg13g2_decap_8
X_07637_ _10237_/A _14771_/Q VDD VSS sg13g2_inv_1
XFILLER_0_1062 VDD VSS sg13g2_decap_4
XFILLER_22_740 VDD VSS sg13g2_decap_8
XFILLER_41_559 VDD VSS sg13g2_decap_8
X_09307_ _09307_/X _09938_/D _09307_/B VDD VSS sg13g2_or2_1
XFILLER_10_902 VDD VSS sg13g2_fill_2
X_13784__2780 _13784_/RESET_B VDD VSS sg13g2_tiehi
XFILLER_55_1075 VDD VSS sg13g2_fill_1
XFILLER_16_1048 VDD VSS sg13g2_decap_8
XFILLER_10_935 VDD VSS sg13g2_fill_1
XFILLER_103_1007 VDD VSS sg13g2_decap_8
X_09238_ _13849_/D _09705_/A0 _13849_/Q _09239_/S VDD VSS sg13g2_mux2_1
XFILLER_139_469 VDD VSS sg13g2_decap_8
XFILLER_154_417 VDD VSS sg13g2_decap_8
XFILLER_10_979 VDD VSS sg13g2_decap_8
XFILLER_6_928 VDD VSS sg13g2_fill_1
XFILLER_119_42 VDD VSS sg13g2_decap_4
X_09169_ _09938_/D _09641_/A _09707_/B _09441_/C VDD VSS sg13g2_nand3_1
X_11200_ _11201_/B _10785_/Y _11185_/B _11202_/A VDD VSS sg13g2_o21ai_1
XFILLER_134_141 VDD VSS sg13g2_decap_8
X_12180_ _12181_/A _14262_/Q _14294_/Q _14326_/Q _14358_/Q _12252_/S0 _12187_/C VDD
+ VSS sg13g2_mux4_1
XFILLER_79_46 VDD VSS sg13g2_decap_4
X_11131_ _11131_/Y _11109_/B _10769_/X _11183_/B1 VDD VSS sg13g2_o21ai_1
X_11062_ _11062_/Y _11185_/A _11078_/A _11061_/Y VDD VSS sg13g2_a21oi_1
XFILLER_135_63 VDD VSS sg13g2_decap_8
XFILLER_0_143 VDD VSS sg13g2_decap_8
XFILLER_0_154 VDD VSS sg13g2_fill_1
XFILLER_114_1103 VDD VSS sg13g2_decap_8
XFILLER_153_1163 VDD VSS sg13g2_decap_8
XFILLER_27_1166 VDD VSS sg13g2_decap_8
XFILLER_1_688 VDD VSS sg13g2_decap_8
X_10013_ _14595_/D _10079_/A0 _14595_/Q _10033_/S VDD VSS sg13g2_mux2_1
XFILLER_88_272 VDD VSS sg13g2_decap_8
XFILLER_77_957 VDD VSS sg13g2_fill_2
XFILLER_0_198 VDD VSS sg13g2_decap_4
X_14821_ _14821_/Q clkload83/A _14821_/D _14821_/RESET_B VDD VSS sg13g2_dfrbpq_1
XFILLER_48_158 VDD VSS sg13g2_decap_8
XFILLER_48_169 VDD VSS sg13g2_fill_1
XFILLER_57_670 VDD VSS sg13g2_decap_4
XFILLER_91_415 VDD VSS sg13g2_decap_8
XFILLER_17_523 VDD VSS sg13g2_fill_1
XFILLER_45_832 VDD VSS sg13g2_fill_1
X_14752_ _14752_/Q clkload63/A _14752_/D _14752_/RESET_B VDD VSS sg13g2_dfrbpq_1
X_11964_ _11964_/X _11964_/A _11973_/B VDD VSS sg13g2_and2_1
XFILLER_151_84 VDD VSS sg13g2_decap_8
XFILLER_45_854 VDD VSS sg13g2_fill_1
X_13703_ _13703_/Q clkload16/A _13703_/D _13703_/RESET_B VDD VSS sg13g2_dfrbpq_1
X_10915_ _10946_/A _10936_/C _15119_/Q VDD VSS sg13g2_nand2_1
X_14683_ _14683_/Q clkload76/A _14683_/D _14683_/RESET_B VDD VSS sg13g2_dfrbpq_1
XFILLER_17_578 VDD VSS sg13g2_decap_8
X_11895_ _11897_/A _11896_/A _14190_/Q VDD VSS sg13g2_nand2b_1
XFILLER_32_515 VDD VSS sg13g2_fill_1
XFILLER_71_150 VDD VSS sg13g2_decap_8
XFILLER_71_161 VDD VSS sg13g2_fill_2
XFILLER_44_386 VDD VSS sg13g2_decap_4
X_13634_ _13742_/D _13634_/A VDD VSS sg13g2_buf_1
X_10846_ _10846_/Y _10845_/Y _10897_/D _10886_/A2 VDD VSS sg13g2_a21oi_1
XFILLER_34_1104 VDD VSS sg13g2_fill_2
X_15161__3020 _15161_/RESET_B VDD VSS sg13g2_tiehi
X_13565_ _15153_/D _15153_/Q wire729/X _13568_/S VDD VSS sg13g2_mux2_1
X_10777_ _10777_/Y _14952_/Q _10767_/A _10776_/X VDD VSS sg13g2_a21oi_1
X_12516_ _12516_/X _14695_/Q _14727_/Q _13767_/Q _13799_/Q _12685_/S0 _12685_/S1 VDD
+ VSS sg13g2_mux4_1
Xmax_cap1711 _12286_/S0 _11787_/S0 VDD VSS sg13g2_buf_4
XFILLER_74_7 VDD VSS sg13g2_decap_8
X_13496_ _15126_/D _13494_/Y _13495_/Y _13493_/Y VDD VSS sg13g2_o21ai_1
XFILLER_60_70 VDD VSS sg13g2_decap_8
X_15235_ _15235_/Q clkload68/A _15235_/D _15235_/RESET_B VDD VSS sg13g2_dfrbpq_1
X_12447_ _12447_/X _13826_/Q _13858_/Q _13890_/Q _13922_/Q _12452_/S0 _12452_/S1 VDD
+ VSS sg13g2_mux4_1
XFILLER_126_653 VDD VSS sg13g2_fill_2
XFILLER_5_21 VDD VSS sg13g2_decap_8
XFILLER_5_950 VDD VSS sg13g2_decap_8
X_15166_ _15166_/Q clkload67/A _15166_/D _15166_/RESET_B VDD VSS sg13g2_dfrbpq_1
X_12378_ _12378_/X _14685_/Q _14717_/Q _13757_/Q _13789_/Q _12378_/S0 _12411_/S1 VDD
+ VSS sg13g2_mux4_1
X_14117_ _14117_/Q clkload0/A _14117_/D _14117_/RESET_B VDD VSS sg13g2_dfrbpq_1
X_11329_ _11329_/Y _11327_/Y _11326_/Y _11422_/B _11328_/X VDD VSS sg13g2_a22oi_1
X_14918__3093 _14918_/RESET_B VDD VSS sg13g2_tiehi
XFILLER_10_1192 VDD VSS sg13g2_decap_8
X_15097_ _15097_/Q clkload67/A _15097_/D _15097_/RESET_B VDD VSS sg13g2_dfrbpq_1
XFILLER_141_645 VDD VSS sg13g2_fill_2
XFILLER_5_98 VDD VSS sg13g2_decap_8
XFILLER_45_1211 VDD VSS sg13g2_decap_8
X_14048_ _14048_/Q clkload8/A _14048_/D _14048_/RESET_B VDD VSS sg13g2_dfrbpq_1
XFILLER_68_902 VDD VSS sg13g2_fill_2
XFILLER_95_721 VDD VSS sg13g2_decap_8
XFILLER_121_380 VDD VSS sg13g2_fill_2
XFILLER_83_905 VDD VSS sg13g2_decap_4
XFILLER_95_798 VDD VSS sg13g2_fill_2
XFILLER_48_681 VDD VSS sg13g2_fill_1
XFILLER_36_832 VDD VSS sg13g2_decap_8
X_08540_ _08545_/B _08621_/A _08538_/X _08539_/Y VDD VSS sg13g2_o21ai_1
XFILLER_82_437 VDD VSS sg13g2_decap_8
XFILLER_36_854 VDD VSS sg13g2_decap_8
XFILLER_35_364 VDD VSS sg13g2_decap_8
X_08471_ _08494_/A _15008_/Q _08471_/B VDD VSS sg13g2_nor2_1
XFILLER_39_1048 VDD VSS sg13g2_fill_1
XFILLER_78_1097 VDD VSS sg13g2_decap_8
XFILLER_62_183 VDD VSS sg13g2_decap_8
XFILLER_50_334 VDD VSS sg13g2_decap_8
XFILLER_50_345 VDD VSS sg13g2_fill_2
X_09023_ _09024_/C _12942_/A _09030_/D _12957_/A VDD VSS sg13g2_a21o_1
XFILLER_136_439 VDD VSS sg13g2_decap_8
XFILLER_85_1013 VDD VSS sg13g2_fill_1
XFILLER_105_826 VDD VSS sg13g2_fill_1
XFILLER_132_623 VDD VSS sg13g2_fill_1
Xpicorv32_macro_1806 mem_axi_awprot[1] VDD VSS sg13g2_tielo
XFILLER_131_122 VDD VSS sg13g2_fill_1
XFILLER_49_38 VDD VSS sg13g2_fill_1
Xfanout701 _09646_/A0 _09877_/A0 VDD VSS sg13g2_buf_1
Xfanout712 _08765_/A1 _08729_/Y VDD VSS sg13g2_buf_1
X_09925_ _14510_/D _14510_/Q _09925_/A1 _09937_/S VDD VSS sg13g2_mux2_1
X_15168__2884 _15168_/RESET_B VDD VSS sg13g2_tiehi
Xfanout723 _13652_/S _13655_/S VDD VSS sg13g2_buf_1
X_15229__3382 _15229_/RESET_B VDD VSS sg13g2_tiehi
XFILLER_120_829 VDD VSS sg13g2_decap_8
Xfanout734 _13547_/B _13551_/S VDD VSS sg13g2_buf_1
Xfanout745 _12749_/A2 _12429_/A2 VDD VSS sg13g2_buf_1
X_09856_ _14443_/D _14443_/Q _10021_/A0 _09870_/S VDD VSS sg13g2_mux2_1
Xfanout778 _10138_/A1 _08969_/X VDD VSS sg13g2_buf_1
XFILLER_112_391 VDD VSS sg13g2_fill_1
Xfanout789 _08807_/B _13482_/B VDD VSS sg13g2_buf_1
X_08807_ _08808_/B _13687_/Q _08807_/B VDD VSS sg13g2_nor2_1
XFILLER_22_1030 VDD VSS sg13g2_decap_8
X_09787_ _14376_/D _09787_/A0 _14376_/Q wire629/X VDD VSS sg13g2_mux2_1
XFILLER_58_489 VDD VSS sg13g2_decap_8
XFILLER_73_415 VDD VSS sg13g2_fill_1
XFILLER_85_275 VDD VSS sg13g2_decap_8
XFILLER_100_586 VDD VSS sg13g2_decap_4
XFILLER_105_99 VDD VSS sg13g2_decap_8
X_08738_ _13664_/D _08753_/A1 _08736_/Y _08737_/Y VDD VSS sg13g2_a21oi_1
XFILLER_2_1157 VDD VSS sg13g2_decap_8
XFILLER_121_21 VDD VSS sg13g2_decap_8
XFILLER_148_1221 VDD VSS sg13g2_decap_8
X_08669_ _08669_/Y _08048_/A _08686_/A1 _08669_/B1 VDD VSS sg13g2_a21oi_1
XFILLER_54_673 VDD VSS sg13g2_decap_8
X_14036__2528 _14036_/RESET_B VDD VSS sg13g2_tiehi
XFILLER_26_386 VDD VSS sg13g2_decap_8
XFILLER_81_14 VDD VSS sg13g2_decap_8
X_10700_ _14902_/D _10886_/B1 wire584/A _10699_/Y VDD VSS sg13g2_o21ai_1
XFILLER_41_323 VDD VSS sg13g2_decap_8
X_11680_ _11680_/Y _11765_/A _11679_/X _12263_/C VDD VSS sg13g2_a21oi_1
XFILLER_41_334 VDD VSS sg13g2_fill_2
X_10631_ _10633_/B _14885_/Q _10630_/B VDD VSS sg13g2_nor2b_1
XFILLER_14_63 VDD VSS sg13g2_decap_8
X_13350_ _13351_/D _15181_/D _15182_/D VDD VSS sg13g2_or2_1
XFILLER_139_255 VDD VSS sg13g2_fill_1
X_10562_ _10565_/B _14868_/Q _14867_/Q _14856_/Q _14855_/Q VDD VSS sg13g2_nand4_1
XFILLER_154_203 VDD VSS sg13g2_decap_8
X_12301_ _12301_/Y _12299_/Y _12300_/Y _12301_/B1 VDD VSS sg13g2_a21oi_1
X_14251__2313 _14251_/RESET_B VDD VSS sg13g2_tiehi
X_13281_ _15053_/D _13281_/A _13281_/B _13281_/C VDD VSS sg13g2_nor3_1
XFILLER_108_620 VDD VSS sg13g2_fill_1
X_10493_ _14851_/D _10493_/A _10492_/Y VDD VSS sg13g2_nor2b_1
XFILLER_136_951 VDD VSS sg13g2_decap_4
X_15020_ _15020_/Q _15200_/CLK _15020_/D _15020_/RESET_B VDD VSS sg13g2_dfrbpq_1
X_12232_ _12232_/X _14136_/Q _14168_/Q _12235_/A VDD VSS sg13g2_mux2_1
XFILLER_108_653 VDD VSS sg13g2_decap_4
XFILLER_120_1173 VDD VSS sg13g2_decap_8
XFILLER_136_984 VDD VSS sg13g2_decap_8
XFILLER_100_0 VDD VSS sg13g2_decap_4
XFILLER_2_920 VDD VSS sg13g2_decap_4
XFILLER_107_174 VDD VSS sg13g2_fill_1
X_12163_ _12163_/X _12163_/A _12172_/B VDD VSS sg13g2_and2_1
XFILLER_29_1228 VDD VSS sg13g2_decap_8
XFILLER_123_634 VDD VSS sg13g2_decap_8
X_11114_ _11114_/X _11097_/Y _10764_/X _10769_/X VDD VSS sg13g2_a21o_1
XFILLER_150_464 VDD VSS sg13g2_fill_1
X_14989__2983 _14989_/RESET_B VDD VSS sg13g2_tiehi
X_12094_ _12094_/Y _12094_/A _12108_/B VDD VSS sg13g2_nand2_1
XFILLER_77_710 VDD VSS sg13g2_decap_8
XFILLER_110_328 VDD VSS sg13g2_fill_2
X_11045_ _11046_/B _11052_/B _11045_/A2 _11207_/B1 VDD VSS sg13g2_a21oi_1
XFILLER_7_1068 VDD VSS sg13g2_decap_8
XFILLER_65_927 VDD VSS sg13g2_decap_4
XFILLER_77_787 VDD VSS sg13g2_decap_8
XFILLER_36_106 VDD VSS sg13g2_decap_8
XFILLER_92_735 VDD VSS sg13g2_fill_2
X_14804_ _14804_/Q clkload81/A _14804_/D _14804_/RESET_B VDD VSS sg13g2_dfrbpq_1
XFILLER_45_640 VDD VSS sg13g2_fill_1
X_12996_ _12996_/Y _12900_/A _12997_/A input7/X VDD VSS sg13g2_a21oi_1
XFILLER_40_1185 VDD VSS sg13g2_decap_4
XFILLER_17_342 VDD VSS sg13g2_decap_8
XFILLER_75_1204 VDD VSS sg13g2_decap_8
XFILLER_73_982 VDD VSS sg13g2_fill_1
X_14735_ _14735_/Q clkload15/A _14735_/D _14735_/RESET_B VDD VSS sg13g2_dfrbpq_1
X_11947_ _11947_/Y _11944_/Y _11946_/X _12290_/S1 VDD VSS sg13g2_o21ai_1
XFILLER_32_334 VDD VSS sg13g2_decap_8
X_14666_ _14666_/Q clkload20/A _14666_/D _14666_/RESET_B VDD VSS sg13g2_dfrbpq_1
X_11878_ _11878_/Y _11882_/S0 _14606_/Q _11897_/C VDD VSS sg13g2_a21oi_1
X_13617_ _13725_/D _13617_/A VDD VSS sg13g2_buf_1
X_10829_ _10831_/C _10818_/A _10818_/B _10823_/C VDD VSS sg13g2_o21ai_1
X_14597_ _14597_/Q clkload5/A _14597_/D _14597_/RESET_B VDD VSS sg13g2_dfrbpq_1
XFILLER_119_907 VDD VSS sg13g2_decap_8
X_13548_ _15147_/D _13539_/B _13546_/Y _13547_/Y VDD VSS sg13g2_a21oi_1
XFILLER_145_214 VDD VSS sg13g2_decap_8
XFILLER_12_1221 VDD VSS sg13g2_decap_8
Xmax_cap1541 _16884_/A _13722_/Q VDD VSS sg13g2_buf_8
X_13479_ _15180_/D hold3415/X _15180_/Q _13479_/S VDD VSS sg13g2_mux2_1
Xmax_cap1552 _16873_/A _13711_/Q VDD VSS sg13g2_buf_8
X_15218_ _15218_/Q clkload67/A _15218_/D _15218_/RESET_B VDD VSS sg13g2_dfrbpq_1
XFILLER_127_984 VDD VSS sg13g2_decap_8
XFILLER_142_910 VDD VSS sg13g2_decap_4
XFILLER_127_995 VDD VSS sg13g2_decap_8
X_15149_ _15149_/Q clkload26/A _15149_/D _15149_/RESET_B VDD VSS sg13g2_dfrbpq_1
XFILLER_153_280 VDD VSS sg13g2_decap_8
XFILLER_99_334 VDD VSS sg13g2_decap_8
XFILLER_142_954 VDD VSS sg13g2_decap_8
XFILLER_82_1219 VDD VSS sg13g2_decap_8
XFILLER_102_818 VDD VSS sg13g2_fill_1
X_07971_ _07971_/Y _15018_/Q _08653_/B VDD VSS sg13g2_nand2b_1
XFILLER_101_317 VDD VSS sg13g2_decap_4
X_09710_ _14301_/D _09908_/A1 _14301_/Q _09738_/S VDD VSS sg13g2_mux2_1
XFILLER_101_339 VDD VSS sg13g2_fill_1
XFILLER_45_1074 VDD VSS sg13g2_fill_2
XFILLER_56_916 VDD VSS sg13g2_decap_8
XFILLER_110_862 VDD VSS sg13g2_decap_8
XFILLER_132_1055 VDD VSS sg13g2_decap_8
XFILLER_95_562 VDD VSS sg13g2_fill_1
X_09641_ _09641_/X _09641_/A _09740_/B _09707_/B _09641_/D VDD VSS sg13g2_or4_1
XFILLER_55_404 VDD VSS sg13g2_decap_4
XFILLER_27_117 VDD VSS sg13g2_decap_4
Xclkbuf_leaf_5_clk_i clkload5/A clkbuf_leaf_5_clk_i/A VDD VSS sg13g2_buf_8
XFILLER_83_735 VDD VSS sg13g2_decap_8
X_09572_ _14170_/D _10102_/A0 _14170_/Q wire651/X VDD VSS sg13g2_mux2_1
XFILLER_71_908 VDD VSS sg13g2_decap_8
X_08523_ _08523_/Y _13566_/A _08591_/A3 _08523_/B1 VDD VSS sg13g2_o21ai_1
XFILLER_23_301 VDD VSS sg13g2_decap_8
XFILLER_24_846 VDD VSS sg13g2_fill_2
X_08454_ _08454_/X _15103_/Q _15090_/Q _08454_/C VDD VSS sg13g2_or3_1
XFILLER_24_879 VDD VSS sg13g2_decap_8
X_08385_ _08385_/Y _15103_/Q _15090_/Q _08385_/C VDD VSS sg13g2_nor3_1
XFILLER_149_531 VDD VSS sg13g2_decap_8
XFILLER_32_890 VDD VSS sg13g2_fill_2
XFILLER_50_186 VDD VSS sg13g2_decap_4
XFILLER_104_1102 VDD VSS sg13g2_decap_8
XFILLER_17_1176 VDD VSS sg13g2_decap_8
XFILLER_143_1184 VDD VSS sg13g2_fill_2
XFILLER_52_1067 VDD VSS sg13g2_fill_2
XFILLER_136_214 VDD VSS sg13g2_decap_8
XFILLER_136_225 VDD VSS sg13g2_fill_1
XFILLER_136_236 VDD VSS sg13g2_decap_8
XFILLER_118_951 VDD VSS sg13g2_decap_8
X_09006_ _09006_/Y _09137_/A _09006_/B _09022_/D VDD VSS sg13g2_nor3_1
XFILLER_2_205 VDD VSS sg13g2_decap_8
XFILLER_145_792 VDD VSS sg13g2_decap_8
XFILLER_117_494 VDD VSS sg13g2_fill_1
XFILLER_4_7 VDD VSS sg13g2_decap_8
XFILLER_116_21 VDD VSS sg13g2_decap_8
Xfanout1507 _13245_/A _14922_/Q VDD VSS sg13g2_buf_1
Xfanout520 _10079_/A0 _10146_/A1 VDD VSS sg13g2_buf_1
Xfanout1518 _10681_/A _14897_/Q VDD VSS sg13g2_buf_1
Xfanout1529 _10504_/C _14846_/Q VDD VSS sg13g2_buf_1
Xfanout531 _09977_/A0 _10076_/A0 VDD VSS sg13g2_buf_1
XFILLER_59_721 VDD VSS sg13g2_decap_8
XFILLER_76_14 VDD VSS sg13g2_fill_2
Xfanout542 fanout542/X wire543/X VDD VSS sg13g2_buf_1
X_09908_ _14493_/D _14493_/Q _09908_/A1 _09910_/S VDD VSS sg13g2_mux2_1
XFILLER_58_231 VDD VSS sg13g2_fill_2
XFILLER_47_905 VDD VSS sg13g2_decap_8
XFILLER_76_58 VDD VSS sg13g2_decap_8
X_09839_ wire438/A _09938_/A _09938_/B _10137_/A _09839_/D VDD VSS sg13g2_nor4_1
XFILLER_24_1169 VDD VSS sg13g2_decap_8
XFILLER_58_264 VDD VSS sg13g2_fill_1
XFILLER_74_735 VDD VSS sg13g2_decap_8
XFILLER_46_437 VDD VSS sg13g2_decap_8
XFILLER_150_1199 VDD VSS sg13g2_decap_8
XFILLER_132_42 VDD VSS sg13g2_decap_8
XFILLER_46_448 VDD VSS sg13g2_fill_2
X_12850_ _12850_/X _12846_/Y _12848_/X _12849_/Y VDD VSS sg13g2_a21o_1
XFILLER_62_919 VDD VSS sg13g2_fill_1
XFILLER_55_960 VDD VSS sg13g2_fill_2
XFILLER_73_267 VDD VSS sg13g2_decap_8
X_11801_ _11801_/X _14124_/Q _14156_/Q _11801_/S VDD VSS sg13g2_mux2_1
XFILLER_15_813 VDD VSS sg13g2_decap_4
X_12781_ _12781_/X _13978_/Q _14010_/Q _14042_/Q _14074_/Q _12782_/S0 _12782_/S1 VDD
+ VSS sg13g2_mux4_1
X_14520_ _14520_/Q clkload31/A _14520_/D _14520_/RESET_B VDD VSS sg13g2_dfrbpq_1
XFILLER_54_481 VDD VSS sg13g2_fill_2
XFILLER_148_1062 VDD VSS sg13g2_fill_2
XFILLER_26_183 VDD VSS sg13g2_decap_8
X_11732_ _11732_/Y _11733_/A1 _14186_/Q VDD VSS sg13g2_nand2b_1
XFILLER_14_323 VDD VSS sg13g2_decap_8
XFILLER_148_0 VDD VSS sg13g2_decap_8
XFILLER_30_827 VDD VSS sg13g2_fill_1
XFILLER_25_84 VDD VSS sg13g2_decap_8
X_14451_ _14451_/Q clkload11/A _14451_/D _14451_/RESET_B VDD VSS sg13g2_dfrbpq_1
XFILLER_109_1057 VDD VSS sg13g2_decap_8
X_11663_ _11663_/Y _11663_/A _11663_/B _11773_/B VDD VSS sg13g2_nand3_1
X_13402_ _15088_/D _13396_/D _13433_/A _13400_/Y VDD VSS sg13g2_o21ai_1
X_10614_ _10622_/C _10614_/A _10614_/B VDD VSS sg13g2_nor2_1
XFILLER_41_197 VDD VSS sg13g2_decap_8
X_14382_ _14382_/Q _14494_/CLK _14382_/D _14382_/RESET_B VDD VSS sg13g2_dfrbpq_1
X_11594_ _11594_/X _14118_/Q _14150_/Q _11597_/A VDD VSS sg13g2_mux2_1
XFILLER_122_1224 VDD VSS sg13g2_decap_8
XFILLER_31_1118 VDD VSS sg13g2_fill_1
XFILLER_70_1167 VDD VSS sg13g2_decap_4
XFILLER_122_1235 VDD VSS sg13g2_fill_2
X_13333_ _15171_/D hold3422/X _15171_/Q _13333_/S VDD VSS sg13g2_mux2_1
X_10545_ _10548_/C _14864_/Q _10544_/B VDD VSS sg13g2_nor2b_1
Xwire954 wire954/X wire955/X VDD VSS sg13g2_buf_2
XFILLER_109_951 VDD VSS sg13g2_fill_2
XFILLER_127_258 VDD VSS sg13g2_decap_8
X_13264_ _13264_/X input27/X _13264_/A2 _13264_/B1 VDD VSS sg13g2_a21o_1
X_10476_ _10478_/B _10504_/C _10492_/C _14847_/Q VDD VSS sg13g2_a21oi_1
XFILLER_109_984 VDD VSS sg13g2_decap_8
XFILLER_136_770 VDD VSS sg13g2_decap_8
X_15003_ _15003_/Q clkload30/A _15003_/D _15003_/RESET_B VDD VSS sg13g2_dfrbpq_1
XFILLER_124_921 VDD VSS sg13g2_decap_4
X_12215_ _12215_/X _13975_/Q _14007_/Q _14039_/Q _14071_/Q _12215_/S0 _12215_/S1 VDD
+ VSS sg13g2_mux4_1
XFILLER_68_1052 VDD VSS sg13g2_fill_1
XFILLER_135_280 VDD VSS sg13g2_decap_8
X_13195_ _13196_/C _14824_/Q _13206_/B _13249_/B _14888_/Q VDD VSS sg13g2_a22oi_1
XFILLER_151_740 VDD VSS sg13g2_decap_8
XFILLER_29_1036 VDD VSS sg13g2_decap_8
XFILLER_97_805 VDD VSS sg13g2_decap_4
XFILLER_151_762 VDD VSS sg13g2_decap_8
XFILLER_29_1058 VDD VSS sg13g2_decap_8
X_12146_ _12146_/Y _13199_/A _11433_/B _12146_/B1 VDD VSS sg13g2_a21oi_1
XFILLER_151_784 VDD VSS sg13g2_decap_8
XFILLER_69_529 VDD VSS sg13g2_fill_1
XFILLER_37_7 VDD VSS sg13g2_decap_8
X_15093__3180 _15093_/RESET_B VDD VSS sg13g2_tiehi
XFILLER_111_648 VDD VSS sg13g2_decap_4
X_12077_ _12077_/Y _12077_/A _12077_/B VDD VSS sg13g2_nor2_1
XFILLER_1_293 VDD VSS sg13g2_decap_8
XFILLER_110_158 VDD VSS sg13g2_decap_8
X_11028_ _11029_/B _11052_/A wire239/X _11027_/Y VDD VSS sg13g2_o21ai_1
XFILLER_2_77 VDD VSS sg13g2_decap_8
XFILLER_77_595 VDD VSS sg13g2_fill_1
XFILLER_53_908 VDD VSS sg13g2_decap_4
XFILLER_66_91 VDD VSS sg13g2_decap_8
XFILLER_52_407 VDD VSS sg13g2_decap_8
X_12979_ wire566/A _12976_/Y _12977_/Y _12978_/Y VDD VSS sg13g2_a21oi_1
XFILLER_64_289 VDD VSS sg13g2_fill_2
XFILLER_75_1012 VDD VSS sg13g2_fill_1
X_14718_ _14718_/Q _14763_/CLK _14718_/D _14718_/RESET_B VDD VSS sg13g2_dfrbpq_1
XFILLER_32_120 VDD VSS sg13g2_fill_2
XFILLER_75_1056 VDD VSS sg13g2_fill_2
XFILLER_127_1124 VDD VSS sg13g2_fill_1
XFILLER_60_473 VDD VSS sg13g2_decap_8
X_14649_ _14649_/Q _14745_/CLK _14649_/D _14649_/RESET_B VDD VSS sg13g2_dfrbpq_1
X_15228__3381 _15228_/RESET_B VDD VSS sg13g2_tiehi
X_08170_ _08170_/X _08044_/X _08052_/Y _08167_/B _08241_/B _08244_/B _08560_/B VDD
+ VSS sg13g2_mux4_1
XFILLER_119_726 VDD VSS sg13g2_decap_4
XFILLER_9_382 VDD VSS sg13g2_decap_8
X_13663__2931 _13663_/RESET_B VDD VSS sg13g2_tiehi
XFILLER_63_0 VDD VSS sg13g2_decap_8
Xoutput101 mem_axi_awvalid _07766_/Y VDD VSS sg13g2_buf_1
Xoutput112 mem_axi_wdata[17] _15149_/Q VDD VSS sg13g2_buf_1
XFILLER_12_1095 VDD VSS sg13g2_decap_8
Xoutput123 mem_axi_wdata[27] _15159_/Q VDD VSS sg13g2_buf_1
Xoutput134 mem_axi_wdata[8] _15140_/Q VDD VSS sg13g2_buf_1
XFILLER_82_1005 VDD VSS sg13g2_fill_1
X_14347__2217 _14347_/RESET_B VDD VSS sg13g2_tiehi
XFILLER_114_431 VDD VSS sg13g2_decap_4
XFILLER_114_453 VDD VSS sg13g2_fill_1
XFILLER_82_1027 VDD VSS sg13g2_decap_8
XFILLER_102_604 VDD VSS sg13g2_decap_8
XFILLER_47_1158 VDD VSS sg13g2_fill_1
XFILLER_99_164 VDD VSS sg13g2_decap_8
XFILLER_142_784 VDD VSS sg13g2_decap_8
XFILLER_134_1117 VDD VSS sg13g2_decap_8
XFILLER_130_935 VDD VSS sg13g2_decap_8
XFILLER_102_648 VDD VSS sg13g2_fill_1
XFILLER_141_294 VDD VSS sg13g2_decap_8
X_07954_ _07954_/Y _08553_/A _07954_/B _07954_/C VDD VSS sg13g2_nor3_1
XFILLER_87_348 VDD VSS sg13g2_decap_8
XFILLER_68_551 VDD VSS sg13g2_decap_8
XFILLER_68_562 VDD VSS sg13g2_fill_2
X_07885_ _07926_/A _13545_/A _08219_/A VDD VSS sg13g2_nor2b_1
X_14562__2002 _14562_/RESET_B VDD VSS sg13g2_tiehi
XFILLER_46_28 VDD VSS sg13g2_decap_8
X_09624_ _14220_/D _09923_/A1 _14220_/Q _09637_/S VDD VSS sg13g2_mux2_1
XFILLER_28_448 VDD VSS sg13g2_decap_4
XFILLER_3_1230 VDD VSS sg13g2_decap_8
XFILLER_71_705 VDD VSS sg13g2_fill_2
XFILLER_83_565 VDD VSS sg13g2_fill_2
X_09555_ _14153_/D _09621_/A0 _14153_/Q _09569_/S VDD VSS sg13g2_mux2_1
XFILLER_55_289 VDD VSS sg13g2_decap_8
XFILLER_71_749 VDD VSS sg13g2_fill_2
XFILLER_110_1172 VDD VSS sg13g2_decap_8
XFILLER_24_632 VDD VSS sg13g2_decap_8
X_08506_ _08506_/Y _08502_/Y _08503_/Y _08505_/Y VDD VSS sg13g2_o21ai_1
XFILLER_19_1205 VDD VSS sg13g2_decap_8
X_09486_ _14086_/D _10149_/A1 _14086_/Q _09503_/S VDD VSS sg13g2_mux2_1
XFILLER_54_1107 VDD VSS sg13g2_fill_2
XFILLER_52_974 VDD VSS sg13g2_decap_8
XFILLER_24_676 VDD VSS sg13g2_decap_4
X_08437_ _08437_/Y _15005_/Q _07946_/B _08183_/A VDD VSS sg13g2_a21oi_1
XFILLER_93_1189 VDD VSS sg13g2_decap_8
XFILLER_141_7 VDD VSS sg13g2_decap_8
X_14859__3211 _14859_/RESET_B VDD VSS sg13g2_tiehi
X_08368_ _08369_/A _07797_/C _08350_/B _07935_/Y VDD VSS sg13g2_o21ai_1
Xwire206 wire206/X wire206/A VDD VSS sg13g2_buf_2
Xwire239 wire239/X wire239/A VDD VSS sg13g2_buf_2
X_08299_ _08312_/D _08318_/C _08297_/Y _08298_/Y VDD VSS sg13g2_a21oi_1
X_10330_ _10331_/B _10330_/A _14803_/Q _10342_/C _10345_/C VDD VSS sg13g2_nand4_1
XFILLER_30_1151 VDD VSS sg13g2_decap_8
XFILLER_11_42 VDD VSS sg13g2_decap_8
XFILLER_124_206 VDD VSS sg13g2_decap_4
XFILLER_152_537 VDD VSS sg13g2_decap_4
X_10261_ _10261_/Y _14782_/Q _10268_/D _10271_/B VDD VSS sg13g2_o21ai_1
XFILLER_127_42 VDD VSS sg13g2_decap_8
Xclkbuf_leaf_106_clk_i clkload37/A clkbuf_5_14__f_clk_i/X VDD VSS sg13g2_buf_8
XFILLER_65_1214 VDD VSS sg13g2_fill_1
XFILLER_133_751 VDD VSS sg13g2_fill_1
XFILLER_106_965 VDD VSS sg13g2_fill_2
X_12000_ _12001_/B _12000_/A _12000_/B VDD VSS sg13g2_nor2_1
XFILLER_79_816 VDD VSS sg13g2_decap_4
X_10192_ _14753_/D _15196_/D _14753_/Q _10206_/S VDD VSS sg13g2_mux2_1
XFILLER_87_46 VDD VSS sg13g2_fill_1
XFILLER_106_998 VDD VSS sg13g2_fill_2
XFILLER_152_1217 VDD VSS sg13g2_decap_8
XFILLER_133_795 VDD VSS sg13g2_decap_8
XFILLER_121_935 VDD VSS sg13g2_fill_2
Xfanout1304 _09905_/A _15067_/Q VDD VSS sg13g2_buf_1
Xfanout1315 _08966_/A _15060_/Q VDD VSS sg13g2_buf_1
XFILLER_120_423 VDD VSS sg13g2_fill_2
Xfanout1326 _10697_/B _15058_/Q VDD VSS sg13g2_buf_1
Xfanout1337 _13566_/A _15011_/Q VDD VSS sg13g2_buf_1
Xfanout350 _10148_/A1 _10115_/A0 VDD VSS sg13g2_buf_1
XFILLER_59_540 VDD VSS sg13g2_fill_2
Xfanout1348 _08463_/A _08034_/A VDD VSS sg13g2_buf_1
Xfanout361 _09744_/A1 _09909_/A1 VDD VSS sg13g2_buf_1
Xfanout1359 _08597_/A _08344_/A2 VDD VSS sg13g2_buf_1
XFILLER_8_1174 VDD VSS sg13g2_decap_8
XFILLER_143_63 VDD VSS sg13g2_decap_4
X_13951_ _13951_/Q _14509_/CLK _13951_/D _13951_/RESET_B VDD VSS sg13g2_dfrbpq_1
Xfanout383 _11052_/A _11040_/A VDD VSS sg13g2_buf_1
Xfanout394 _10169_/S _10157_/S VDD VSS sg13g2_buf_1
XFILLER_47_735 VDD VSS sg13g2_fill_1
XFILLER_46_223 VDD VSS sg13g2_decap_8
XFILLER_115_1094 VDD VSS sg13g2_decap_8
X_12902_ _12902_/Y _12902_/A _12902_/B _12902_/C VDD VSS sg13g2_nand3_1
XFILLER_35_908 VDD VSS sg13g2_decap_8
X_13882_ _13882_/Q clkload47/A _13882_/D _13882_/RESET_B VDD VSS sg13g2_dfrbpq_1
XFILLER_35_919 VDD VSS sg13g2_fill_2
XFILLER_47_779 VDD VSS sg13g2_decap_8
XFILLER_59_1018 VDD VSS sg13g2_decap_8
XFILLER_59_1029 VDD VSS sg13g2_fill_1
XFILLER_34_418 VDD VSS sg13g2_decap_8
X_12833_ _12833_/Y _12835_/A _13691_/Q VDD VSS sg13g2_nand2_1
XFILLER_62_738 VDD VSS sg13g2_decap_4
XFILLER_15_610 VDD VSS sg13g2_decap_8
X_12764_ _15018_/D _12764_/A _12764_/B VDD VSS sg13g2_nor2_1
X_11715_ _11715_/X _14249_/Q _14281_/Q _14313_/Q _14345_/Q _11715_/S0 _11715_/S1 VDD
+ VSS sg13g2_mux4_1
X_14503_ _14503_/Q clkload4/A _14503_/D _14503_/RESET_B VDD VSS sg13g2_dfrbpq_1
XFILLER_42_473 VDD VSS sg13g2_decap_4
X_12695_ _12708_/A _07625_/A _12751_/A2 _15014_/Q VDD VSS sg13g2_a21oi_1
X_14425__2139 _14425_/RESET_B VDD VSS sg13g2_tiehi
XFILLER_35_1040 VDD VSS sg13g2_decap_8
X_14434_ _14434_/Q _14722_/CLK _14434_/D _14434_/RESET_B VDD VSS sg13g2_dfrbpq_1
X_11646_ _11646_/X _14567_/Q _14599_/Q _14631_/Q _14663_/Q _12067_/S0 _12067_/S1 VDD
+ VSS sg13g2_mux4_1
XFILLER_122_1010 VDD VSS sg13g2_decap_8
Xinput14 input14/X input14/A VDD VSS sg13g2_buf_1
Xinput25 input25/X input25/A VDD VSS sg13g2_buf_1
XFILLER_156_843 VDD VSS sg13g2_fill_1
X_14365_ _14365_/Q _14525_/CLK _14365_/D _14365_/RESET_B VDD VSS sg13g2_dfrbpq_1
Xinput36 input36/X input36/A VDD VSS sg13g2_buf_1
X_11577_ _11577_/X _14117_/Q _14149_/Q _14181_/Q _14213_/Q _11578_/S0 _11580_/S1 VDD
+ VSS sg13g2_mux4_1
XFILLER_11_893 VDD VSS sg13g2_decap_8
Xwire762 wire762/X wire763/X VDD VSS sg13g2_buf_1
XFILLER_128_567 VDD VSS sg13g2_decap_8
X_13316_ _13316_/X _15062_/Q _13363_/B _13316_/C VDD VSS sg13g2_and3_1
XFILLER_156_887 VDD VSS sg13g2_fill_1
X_10528_ _10529_/B _10558_/B _10564_/D _10531_/D VDD VSS sg13g2_nand3_1
XFILLER_7_886 VDD VSS sg13g2_decap_8
X_14296_ _14296_/Q clkload32/A _14296_/D _14296_/RESET_B VDD VSS sg13g2_dfrbpq_1
XFILLER_6_363 VDD VSS sg13g2_fill_2
XFILLER_155_397 VDD VSS sg13g2_decap_8
X_13247_ _13247_/Y _13247_/A _13247_/B _13247_/C _13247_/D VDD VSS sg13g2_nand4_1
X_10459_ _10460_/A _10538_/A _10459_/B _10459_/C _10459_/D VDD VSS sg13g2_nor4_2
X_13178_ _13178_/X input20/X _13264_/A2 _13264_/B1 VDD VSS sg13g2_a21o_1
XFILLER_151_592 VDD VSS sg13g2_decap_8
X_12129_ _12198_/C _12061_/A _13189_/B _13668_/Q _12084_/A VDD VSS sg13g2_a22oi_1
Xclkbuf_leaf_70_clk_i _14854_/CLK clkbuf_leaf_71_clk_i/A VDD VSS sg13g2_buf_8
XFILLER_69_359 VDD VSS sg13g2_decap_4
XFILLER_97_668 VDD VSS sg13g2_decap_4
X_14031__2533 _14031_/RESET_B VDD VSS sg13g2_tiehi
XFILLER_111_478 VDD VSS sg13g2_decap_8
XFILLER_77_370 VDD VSS sg13g2_fill_2
XFILLER_42_1055 VDD VSS sg13g2_fill_1
XFILLER_93_830 VDD VSS sg13g2_decap_8
XFILLER_65_543 VDD VSS sg13g2_decap_8
X_07670_ _07670_/Y _13283_/A _13613_/B _13613_/C VDD VSS sg13g2_nand3_1
X_16868_ _16868_/X _16868_/A VDD VSS sg13g2_buf_1
XFILLER_19_960 VDD VSS sg13g2_decap_8
XFILLER_92_351 VDD VSS sg13g2_fill_2
X_14635__1929 _14635_/RESET_B VDD VSS sg13g2_tiehi
Xclkbuf_leaf_85_clk_i clkload62/A clkbuf_leaf_87_clk_i/A VDD VSS sg13g2_buf_8
XFILLER_80_513 VDD VSS sg13g2_decap_8
XFILLER_92_373 VDD VSS sg13g2_fill_1
XFILLER_52_215 VDD VSS sg13g2_decap_8
XFILLER_18_481 VDD VSS sg13g2_decap_4
X_09340_ _09606_/C _09938_/B _09938_/A VDD VSS sg13g2_nor2b_1
X_09271_ _13880_/D _13880_/Q _10100_/A0 _09271_/S VDD VSS sg13g2_mux2_1
X_08222_ _08233_/C _08541_/A _08247_/B _08217_/X _08110_/D _08221_/Y VDD VSS sg13g2_a221oi_1
XFILLER_14_1113 VDD VSS sg13g2_decap_8
XFILLER_147_821 VDD VSS sg13g2_fill_1
XFILLER_147_832 VDD VSS sg13g2_decap_8
X_15003__2969 _15003_/RESET_B VDD VSS sg13g2_tiehi
XFILLER_140_1132 VDD VSS sg13g2_decap_8
X_08153_ _08484_/C _08025_/B _08151_/X _08152_/Y VDD VSS sg13g2_o21ai_1
XFILLER_147_887 VDD VSS sg13g2_decap_8
XFILLER_88_1236 VDD VSS sg13g2_fill_1
Xclkbuf_leaf_23_clk_i _14706_/CLK clkbuf_5_7__f_clk_i/X VDD VSS sg13g2_buf_8
XFILLER_107_718 VDD VSS sg13g2_decap_8
X_08084_ _08085_/A _08591_/A3 _08598_/A3 _07861_/B _07859_/B _08598_/S0 _08669_/B1
+ VDD VSS sg13g2_mux4_1
XFILLER_101_1138 VDD VSS sg13g2_decap_8
XFILLER_106_206 VDD VSS sg13g2_fill_1
XFILLER_134_548 VDD VSS sg13g2_decap_8
Xmax_cap1190 _12646_/S0 _12647_/S0 VDD VSS sg13g2_buf_4
XFILLER_103_902 VDD VSS sg13g2_fill_1
XFILLER_0_506 VDD VSS sg13g2_fill_1
XFILLER_88_602 VDD VSS sg13g2_decap_8
Xhold3412 input35/A mem_axi_rdata[9] VDD VSS sg13g2_dlygate4sd3_1
XFILLER_138_1050 VDD VSS sg13g2_fill_2
Xhold3423 input1/A mem_axi_arready VDD VSS sg13g2_dlygate4sd3_1
Xhold3434 input32/A mem_axi_rdata[6] VDD VSS sg13g2_dlygate4sd3_1
Xhold3445 hold3445/X input11/X VDD VSS sg13g2_dlygate4sd3_1
Xclkbuf_leaf_38_clk_i _14509_/CLK clkbuf_leaf_38_clk_i/A VDD VSS sg13g2_buf_8
Xhold3456 input23/A mem_axi_rdata[27] VDD VSS sg13g2_dlygate4sd3_1
Xhold3467 _13615_/A _13723_/Q VDD VSS sg13g2_dlygate4sd3_1
X_08986_ _08988_/B _10681_/A _10674_/A _12859_/A VDD VSS sg13g2_a21oi_1
Xhold3478 _13644_/A _13752_/Q VDD VSS sg13g2_dlygate4sd3_1
XFILLER_87_156 VDD VSS sg13g2_decap_8
Xhold3489 _13620_/A _13728_/Q VDD VSS sg13g2_dlygate4sd3_1
X_07937_ _07937_/Y _08414_/C _07936_/Y _07793_/Y VDD VSS sg13g2_a21oi_1
XFILLER_69_882 VDD VSS sg13g2_decap_8
XFILLER_68_370 VDD VSS sg13g2_fill_2
XFILLER_56_521 VDD VSS sg13g2_fill_2
XFILLER_21_1117 VDD VSS sg13g2_decap_8
XFILLER_29_768 VDD VSS sg13g2_decap_4
X_07868_ _08183_/B _07912_/B _08463_/A VDD VSS sg13g2_nor2_1
XFILLER_28_267 VDD VSS sg13g2_decap_8
XFILLER_71_502 VDD VSS sg13g2_fill_2
XFILLER_84_896 VDD VSS sg13g2_decap_4
X_09607_ _14203_/D _09906_/A1 _14203_/Q wire470/A VDD VSS sg13g2_mux2_1
XFILLER_56_598 VDD VSS sg13g2_fill_1
X_07799_ _07799_/X _15006_/Q _07800_/B VDD VSS sg13g2_and2_1
X_09538_ _14137_/D _10101_/A0 _14137_/Q _09538_/S VDD VSS sg13g2_mux2_1
XFILLER_19_1002 VDD VSS sg13g2_decap_8
XFILLER_71_568 VDD VSS sg13g2_fill_1
XFILLER_145_1032 VDD VSS sg13g2_decap_4
X_09469_ _14070_/D _10165_/A1 _14070_/Q _09470_/S VDD VSS sg13g2_mux2_1
XFILLER_106_1005 VDD VSS sg13g2_fill_2
XFILLER_11_112 VDD VSS sg13g2_decap_8
XFILLER_11_123 VDD VSS sg13g2_fill_1
X_11500_ _11500_/Y _11499_/Y wire305/X _11485_/Y _11521_/B2 _11701_/C1 VDD VSS sg13g2_a221oi_1
XFILLER_19_1079 VDD VSS sg13g2_decap_8
X_12480_ _12480_/X _14692_/Q _14724_/Q _13764_/Q _13796_/Q _12480_/S0 _12480_/S1 VDD
+ VSS sg13g2_mux4_1
XFILLER_156_106 VDD VSS sg13g2_fill_1
XFILLER_7_105 VDD VSS sg13g2_decap_4
XFILLER_11_178 VDD VSS sg13g2_decap_8
X_11431_ _11431_/Y _11431_/A1 _11430_/Y wire254/X _11426_/Y _11522_/A2 VDD VSS sg13g2_a221oi_1
XFILLER_7_149 VDD VSS sg13g2_fill_1
XFILLER_22_63 VDD VSS sg13g2_decap_8
X_14150_ _14150_/Q _14662_/CLK _14150_/D _14150_/RESET_B VDD VSS sg13g2_dfrbpq_1
X_11362_ _11362_/Y _11365_/A _14366_/Q VDD VSS sg13g2_nand2b_1
XFILLER_138_63 VDD VSS sg13g2_decap_8
XFILLER_152_312 VDD VSS sg13g2_fill_1
XFILLER_153_846 VDD VSS sg13g2_decap_8
XFILLER_3_300 VDD VSS sg13g2_decap_8
X_13101_ _13116_/A _14913_/Q _13674_/Q VDD VSS sg13g2_nand2_1
X_10313_ _10414_/B _14796_/Q _14797_/Q _10330_/A _10327_/B VDD VSS sg13g2_and4_1
X_14081_ _14081_/Q clkload28/A _14081_/D _14081_/RESET_B VDD VSS sg13g2_dfrbpq_1
XFILLER_4_856 VDD VSS sg13g2_decap_8
X_11293_ _11293_/Y _12294_/B1 _11292_/Y _11287_/Y _11289_/Y _11248_/B VDD VSS sg13g2_a221oi_1
XFILLER_69_1191 VDD VSS sg13g2_decap_8
X_13032_ _13032_/Y _12900_/A _12884_/C input9/X VDD VSS sg13g2_a21oi_1
X_10244_ _10245_/A _14775_/Q _14776_/Q wire762/X VDD VSS sg13g2_and3_1
XFILLER_65_1033 VDD VSS sg13g2_fill_2
XFILLER_121_710 VDD VSS sg13g2_decap_8
XFILLER_26_1006 VDD VSS sg13g2_decap_8
XFILLER_26_1017 VDD VSS sg13g2_fill_1
Xfanout1101 _12452_/S1 _12729_/S1 VDD VSS sg13g2_buf_1
Xfanout1112 _12564_/S1 _12754_/S1 VDD VSS sg13g2_buf_1
XFILLER_79_657 VDD VSS sg13g2_decap_8
XFILLER_120_220 VDD VSS sg13g2_decap_8
X_10175_ _10175_/Y _13613_/A _14747_/Q _14748_/Q VDD VSS sg13g2_nor3_1
XFILLER_154_84 VDD VSS sg13g2_decap_8
Xfanout1123 _12771_/S1 _12773_/S1 VDD VSS sg13g2_buf_1
Xfanout1134 _12381_/S1 fanout1135/X VDD VSS sg13g2_buf_1
Xfanout1145 _12743_/S0 fanout1155/X VDD VSS sg13g2_buf_1
X_15227__3380 _15227_/RESET_B VDD VSS sg13g2_tiehi
XFILLER_78_167 VDD VSS sg13g2_decap_8
XFILLER_152_1069 VDD VSS sg13g2_decap_8
Xfanout1156 _12521_/S0 _12740_/S0 VDD VSS sg13g2_buf_1
XFILLER_120_275 VDD VSS sg13g2_fill_1
X_14983_ _14983_/Q clkload32/A _14983_/D _14983_/RESET_B VDD VSS sg13g2_dfrbpq_1
Xfanout180 _10163_/A1 _10030_/A0 VDD VSS sg13g2_buf_1
XFILLER_59_392 VDD VSS sg13g2_fill_1
Xfanout191 _09830_/A0 _09929_/A1 VDD VSS sg13g2_buf_1
Xfanout1189 _12647_/S0 fanout1194/X VDD VSS sg13g2_buf_1
X_13934_ _13934_/Q clkload60/A _13934_/D _13934_/RESET_B VDD VSS sg13g2_dfrbpq_1
XFILLER_47_93 VDD VSS sg13g2_decap_8
XFILLER_47_587 VDD VSS sg13g2_decap_4
XFILLER_75_896 VDD VSS sg13g2_fill_1
X_13865_ _13865_/Q _14633_/CLK _13865_/D _13865_/RESET_B VDD VSS sg13g2_dfrbpq_1
X_13680__2897 _13680_/RESET_B VDD VSS sg13g2_tiehi
XFILLER_90_866 VDD VSS sg13g2_decap_8
X_12816_ _12816_/Y _12914_/A _12814_/Y _12815_/Y VDD VSS sg13g2_o21ai_1
X_13796_ _13796_/Q clkload30/A _13796_/D _13796_/RESET_B VDD VSS sg13g2_dfrbpq_1
XFILLER_76_1162 VDD VSS sg13g2_decap_4
XFILLER_37_1135 VDD VSS sg13g2_decap_8
XFILLER_15_484 VDD VSS sg13g2_fill_1
X_12747_ _12747_/X _12741_/X _12745_/X _12740_/X _12744_/X _12497_/S _12747_/S1 VDD
+ VSS sg13g2_mux4_1
XFILLER_63_81 VDD VSS sg13g2_fill_1
XFILLER_72_1037 VDD VSS sg13g2_fill_2
XFILLER_31_955 VDD VSS sg13g2_decap_8
XFILLER_8_21 VDD VSS sg13g2_decap_8
X_12678_ _12678_/X _12676_/X _12677_/X _12678_/S VDD VSS sg13g2_mux2_1
XFILLER_31_988 VDD VSS sg13g2_decap_8
X_11629_ _11629_/Y _14905_/Q _12267_/A2 _11625_/Y _11628_/Y VDD VSS sg13g2_a22oi_1
X_14417_ _14417_/Q _14737_/CLK _14417_/D _14417_/RESET_B VDD VSS sg13g2_dfrbpq_1
X_14049__2515 _14049_/RESET_B VDD VSS sg13g2_tiehi
XFILLER_8_98 VDD VSS sg13g2_decap_8
XFILLER_156_673 VDD VSS sg13g2_decap_8
XFILLER_7_661 VDD VSS sg13g2_decap_8
X_14348_ _14348_/Q clkload54/A _14348_/D _14348_/RESET_B VDD VSS sg13g2_dfrbpq_1
XFILLER_129_898 VDD VSS sg13g2_fill_1
Xmax_cap314 _10060_/S _10057_/S VDD VSS sg13g2_buf_4
XFILLER_155_172 VDD VSS sg13g2_decap_8
XFILLER_143_312 VDD VSS sg13g2_fill_2
Xmax_cap325 _09904_/S _09874_/S VDD VSS sg13g2_buf_4
X_14279_ _14279_/Q _14725_/CLK _14279_/D _14279_/RESET_B VDD VSS sg13g2_dfrbpq_1
XFILLER_144_879 VDD VSS sg13g2_fill_2
XFILLER_98_900 VDD VSS sg13g2_fill_2
XFILLER_100_1171 VDD VSS sg13g2_fill_2
XFILLER_143_367 VDD VSS sg13g2_decap_4
X_14843__3243 _14843_/RESET_B VDD VSS sg13g2_tiehi
XFILLER_143_378 VDD VSS sg13g2_fill_2
XFILLER_98_922 VDD VSS sg13g2_decap_8
X_14264__2300 _14264_/RESET_B VDD VSS sg13g2_tiehi
XFILLER_135_1234 VDD VSS sg13g2_fill_2
X_08840_ _08840_/Y _15023_/Q _10669_/S _10805_/B VDD VSS sg13g2_a21oi_1
XFILLER_26_0 VDD VSS sg13g2_decap_8
XFILLER_112_787 VDD VSS sg13g2_decap_8
X_08771_ _13675_/D _08780_/A1 _08770_/Y _08769_/Y VDD VSS sg13g2_a21oi_1
X_14876__3177 _14876_/RESET_B VDD VSS sg13g2_tiehi
X_07722_ _07726_/A _15109_/Q _15104_/Q _15103_/Q _15100_/Q VDD VSS sg13g2_nor4_1
XFILLER_66_852 VDD VSS sg13g2_fill_1
XFILLER_66_874 VDD VSS sg13g2_fill_1
XFILLER_38_587 VDD VSS sg13g2_fill_2
X_07653_ _07653_/Y _10510_/B VDD VSS sg13g2_inv_1
XFILLER_0_1222 VDD VSS sg13g2_decap_4
X_14297__2267 _14297_/RESET_B VDD VSS sg13g2_tiehi
X_09323_ _13930_/D _10086_/A0 _13930_/Q _09337_/S VDD VSS sg13g2_mux2_1
XFILLER_16_1219 VDD VSS sg13g2_decap_8
X_09254_ _13863_/D _13863_/Q _10150_/A1 _09266_/S VDD VSS sg13g2_mux2_1
XFILLER_22_988 VDD VSS sg13g2_decap_8
X_08205_ _08211_/C _07888_/B _14995_/Q _08204_/Y VDD VSS sg13g2_o21ai_1
X_09185_ _13801_/D _13801_/Q _10152_/A1 _09198_/S VDD VSS sg13g2_mux2_1
XFILLER_105_1071 VDD VSS sg13g2_fill_2
X_08136_ _08145_/B _08402_/C _08133_/X _08135_/Y VDD VSS sg13g2_o21ai_1
XFILLER_88_1022 VDD VSS sg13g2_decap_4
XFILLER_4_119 VDD VSS sg13g2_decap_8
X_08067_ _08067_/Y _08402_/C _08064_/X _08026_/Y VDD VSS sg13g2_o21ai_1
XFILLER_104_7 VDD VSS sg13g2_decap_8
XFILLER_0_303 VDD VSS sg13g2_decap_4
XFILLER_88_410 VDD VSS sg13g2_decap_8
XFILLER_143_890 VDD VSS sg13g2_decap_4
XFILLER_130_540 VDD VSS sg13g2_decap_8
XFILLER_0_358 VDD VSS sg13g2_decap_4
XFILLER_49_819 VDD VSS sg13g2_decap_8
X_13747__2817 _13747_/RESET_B VDD VSS sg13g2_tiehi
XFILLER_76_616 VDD VSS sg13g2_decap_8
XFILLER_124_21 VDD VSS sg13g2_decap_8
XFILLER_76_627 VDD VSS sg13g2_fill_2
XFILLER_5_1122 VDD VSS sg13g2_decap_8
XFILLER_75_126 VDD VSS sg13g2_decap_8
X_08969_ _08969_/X _08969_/A _08969_/B _08977_/C VDD VSS sg13g2_and3_1
XFILLER_84_14 VDD VSS sg13g2_decap_8
X_11980_ _12006_/A _11980_/A _11983_/A VDD VSS sg13g2_nand2_1
XFILLER_124_87 VDD VSS sg13g2_fill_1
XFILLER_124_98 VDD VSS sg13g2_decap_4
XFILLER_72_811 VDD VSS sg13g2_decap_8
X_10931_ _10932_/B _14757_/Q _10954_/B VDD VSS sg13g2_nand2b_1
XFILLER_5_1199 VDD VSS sg13g2_decap_8
XFILLER_56_384 VDD VSS sg13g2_fill_2
X_13962__2602 _13962_/RESET_B VDD VSS sg13g2_tiehi
X_14127__2437 _14127_/RESET_B VDD VSS sg13g2_tiehi
XFILLER_17_63 VDD VSS sg13g2_decap_8
XFILLER_71_332 VDD VSS sg13g2_decap_8
XFILLER_72_855 VDD VSS sg13g2_fill_2
XFILLER_140_42 VDD VSS sg13g2_decap_8
XFILLER_95_1059 VDD VSS sg13g2_decap_8
X_10862_ _10862_/Y _10862_/A _10903_/B VDD VSS sg13g2_nand2_1
X_13650_ _15116_/D _15185_/D _15116_/Q _13652_/S VDD VSS sg13g2_mux2_1
XFILLER_72_899 VDD VSS sg13g2_decap_8
X_12601_ _12601_/X _14125_/Q _14157_/Q _14189_/Q _14221_/Q _12603_/S0 _12604_/S1 VDD
+ VSS sg13g2_mux4_1
XFILLER_13_922 VDD VSS sg13g2_fill_1
X_13581_ _13581_/Y _13581_/A _13593_/B VDD VSS sg13g2_nor2_1
XFILLER_12_410 VDD VSS sg13g2_decap_8
X_10793_ _10793_/X _10793_/A _10793_/B _10793_/C VDD VSS sg13g2_and3_1
X_12532_ _12532_/X _14248_/Q _14280_/Q _14312_/Q _14344_/Q _12536_/S0 _12536_/S1 VDD
+ VSS sg13g2_mux4_1
XFILLER_32_1010 VDD VSS sg13g2_decap_8
XFILLER_13_999 VDD VSS sg13g2_decap_8
X_14342__2222 _14342_/RESET_B VDD VSS sg13g2_tiehi
XFILLER_130_0 VDD VSS sg13g2_decap_8
X_12463_ _12463_/X _14563_/Q _14595_/Q _14627_/Q _14659_/Q _12464_/S0 _12546_/S1 VDD
+ VSS sg13g2_mux4_1
X_13995__2569 _13995_/RESET_B VDD VSS sg13g2_tiehi
XFILLER_149_84 VDD VSS sg13g2_decap_8
X_11414_ _11424_/C _11411_/Y _11413_/X _12000_/A VDD VSS sg13g2_o21ai_1
X_14202_ _14202_/Q clkload57/A _14202_/D _14202_/RESET_B VDD VSS sg13g2_dfrbpq_1
X_15182_ _15182_/Q _15250_/CLK _15182_/D _15182_/RESET_B VDD VSS sg13g2_dfrbpq_1
X_12394_ _12394_/X _13950_/Q _13982_/Q _14014_/Q _14046_/Q _12615_/S0 _12785_/S1 VDD
+ VSS sg13g2_mux4_1
XFILLER_32_1098 VDD VSS sg13g2_decap_8
XFILLER_126_846 VDD VSS sg13g2_decap_8
X_14133_ _14133_/Q _14671_/CLK _14133_/D _14133_/RESET_B VDD VSS sg13g2_dfrbpq_1
X_11345_ _11345_/Y _11353_/S _13918_/Q _12304_/B VDD VSS sg13g2_a21oi_1
XFILLER_67_1117 VDD VSS sg13g2_decap_4
XFILLER_113_518 VDD VSS sg13g2_decap_8
X_14064_ _14064_/Q clkload49/A _14064_/D _14064_/RESET_B VDD VSS sg13g2_dfrbpq_1
X_11276_ _11276_/Y _11275_/X _11227_/S _11274_/Y VDD VSS sg13g2_a21oi_1
X_14375__2189 _14375_/RESET_B VDD VSS sg13g2_tiehi
X_13015_ _13015_/Y _14780_/Q _13123_/A2 _13123_/B1 VDD VSS sg13g2_o21ai_1
X_10227_ _14770_/D _10234_/D _10347_/B _10227_/C VDD VSS sg13g2_nor3_1
XFILLER_79_476 VDD VSS sg13g2_decap_8
XFILLER_79_487 VDD VSS sg13g2_fill_1
XFILLER_67_638 VDD VSS sg13g2_fill_1
X_10158_ _14735_/D _14735_/Q _10158_/A1 _10168_/S VDD VSS sg13g2_mux2_1
XFILLER_43_1161 VDD VSS sg13g2_decap_4
X_10089_ _14669_/D _10089_/A0 _14669_/Q _10093_/S VDD VSS sg13g2_mux2_1
X_14966_ _14966_/Q clkload37/A _14966_/D _14966_/RESET_B VDD VSS sg13g2_dfrbpq_1
XFILLER_75_660 VDD VSS sg13g2_decap_8
XFILLER_130_1153 VDD VSS sg13g2_fill_1
XFILLER_63_822 VDD VSS sg13g2_decap_8
Xwire1081 wire1081/X wire1081/A VDD VSS sg13g2_buf_4
XFILLER_78_1224 VDD VSS sg13g2_decap_8
X_13917_ _13917_/Q clkload53/A _13917_/D _13917_/RESET_B VDD VSS sg13g2_dfrbpq_1
XFILLER_75_682 VDD VSS sg13g2_fill_2
XFILLER_78_1235 VDD VSS sg13g2_fill_2
XFILLER_62_321 VDD VSS sg13g2_fill_1
X_14897_ _14897_/Q clkload63/A _14897_/D _14897_/RESET_B VDD VSS sg13g2_dfrbpq_1
XFILLER_39_1208 VDD VSS sg13g2_decap_8
X_13848_ _13848_/Q clkload36/A _13848_/D _13848_/RESET_B VDD VSS sg13g2_dfrbpq_1
X_13779_ _13779_/Q clkload13/A _13779_/D _13779_/RESET_B VDD VSS sg13g2_dfrbpq_1
XFILLER_148_448 VDD VSS sg13g2_fill_2
XFILLER_129_640 VDD VSS sg13g2_decap_8
X_13825__2739 _13825_/RESET_B VDD VSS sg13g2_tiehi
X_14585__1979 _14585_/RESET_B VDD VSS sg13g2_tiehi
XFILLER_11_1105 VDD VSS sg13g2_decap_8
XFILLER_50_1154 VDD VSS sg13g2_decap_8
XFILLER_128_150 VDD VSS sg13g2_decap_8
XFILLER_156_470 VDD VSS sg13g2_decap_4
XFILLER_102_1233 VDD VSS sg13g2_decap_4
XFILLER_117_824 VDD VSS sg13g2_fill_2
XFILLER_117_868 VDD VSS sg13g2_fill_2
XFILLER_116_378 VDD VSS sg13g2_fill_1
X_09941_ _14525_/D _14525_/Q _10107_/A0 _09943_/S VDD VSS sg13g2_mux2_1
X_14205__2359 _14205_/RESET_B VDD VSS sg13g2_tiehi
Xfanout905 _12498_/C1 _07737_/Y VDD VSS sg13g2_buf_1
Xfanout916 _13220_/A2 _13236_/A2 VDD VSS sg13g2_buf_1
XFILLER_48_1072 VDD VSS sg13g2_fill_1
Xfanout927 _09204_/C _10999_/B1 VDD VSS sg13g2_buf_1
X_09872_ wire327/A _09905_/A _10105_/C _10037_/A _10037_/B VDD VSS sg13g2_nand4_1
Xfanout938 _11631_/A2 _11521_/B2 VDD VSS sg13g2_buf_1
XFILLER_86_914 VDD VSS sg13g2_decap_4
XFILLER_135_1053 VDD VSS sg13g2_fill_1
Xfanout949 _13333_/S _13340_/S VDD VSS sg13g2_buf_1
XFILLER_97_262 VDD VSS sg13g2_fill_1
XFILLER_85_413 VDD VSS sg13g2_fill_1
X_08823_ _13691_/D _08821_/Y _08820_/Y _08822_/Y VDD VSS sg13g2_a21oi_1
XFILLER_112_584 VDD VSS sg13g2_fill_1
XFILLER_57_126 VDD VSS sg13g2_decap_4
XFILLER_97_295 VDD VSS sg13g2_fill_2
XFILLER_22_1212 VDD VSS sg13g2_decap_8
XFILLER_57_148 VDD VSS sg13g2_decap_4
XFILLER_100_768 VDD VSS sg13g2_fill_2
X_08754_ _08754_/Y _13343_/B _11288_/A _15192_/Q VDD VSS sg13g2_o21ai_1
X_14420__2144 _14420_/RESET_B VDD VSS sg13g2_tiehi
XFILLER_54_811 VDD VSS sg13g2_decap_4
X_07705_ _15201_/D _07705_/A _13279_/D _07705_/C VDD VSS sg13g2_nand3_1
XFILLER_54_822 VDD VSS sg13g2_decap_8
X_08685_ wire144/A _08685_/A1 _08684_/X _08676_/Y VDD VSS sg13g2_o21ai_1
XFILLER_0_1030 VDD VSS sg13g2_decap_4
X_07636_ _07636_/Y _15009_/Q VDD VSS sg13g2_inv_1
XFILLER_53_376 VDD VSS sg13g2_fill_2
XFILLER_41_538 VDD VSS sg13g2_decap_8
XFILLER_55_1032 VDD VSS sg13g2_fill_2
XFILLER_55_1054 VDD VSS sg13g2_decap_8
X_09306_ _13914_/D _13914_/Q _10169_/A1 _09306_/S VDD VSS sg13g2_mux2_1
XFILLER_146_1193 VDD VSS sg13g2_decap_8
XFILLER_16_1027 VDD VSS sg13g2_decap_8
XFILLER_10_914 VDD VSS sg13g2_fill_1
XFILLER_142_1035 VDD VSS sg13g2_decap_8
XFILLER_107_1155 VDD VSS sg13g2_decap_8
XFILLER_107_1166 VDD VSS sg13g2_fill_1
XFILLER_139_448 VDD VSS sg13g2_fill_1
X_09237_ _13848_/D _10100_/A0 _13848_/Q wire700/X VDD VSS sg13g2_mux2_1
XFILLER_139_459 VDD VSS sg13g2_decap_4
XFILLER_10_958 VDD VSS sg13g2_decap_8
XFILLER_148_971 VDD VSS sg13g2_fill_2
XFILLER_119_21 VDD VSS sg13g2_decap_8
X_15052__2906 _15052_/RESET_B VDD VSS sg13g2_tiehi
X_09168_ _10070_/B _09641_/A _10004_/B _09441_/C VDD VSS sg13g2_and3_1
XFILLER_5_439 VDD VSS sg13g2_decap_8
X_08119_ _08119_/X _07801_/B _07820_/B _07815_/B _08591_/A3 wire1387/X _08598_/S1
+ VDD VSS sg13g2_mux4_1
XFILLER_79_25 VDD VSS sg13g2_fill_2
X_09099_ _13776_/D _13776_/Q _10159_/A1 _09160_/S VDD VSS sg13g2_mux2_1
XFILLER_108_879 VDD VSS sg13g2_decap_8
XFILLER_135_665 VDD VSS sg13g2_decap_8
XFILLER_135_676 VDD VSS sg13g2_fill_1
X_11130_ _11130_/Y _11129_/Y _11127_/Y _11114_/X _11117_/Y _11192_/B1 VDD VSS sg13g2_a221oi_1
XFILLER_123_827 VDD VSS sg13g2_decap_4
XFILLER_0_111 VDD VSS sg13g2_decap_4
XFILLER_135_42 VDD VSS sg13g2_decap_8
XFILLER_0_122 VDD VSS sg13g2_fill_1
XFILLER_62_1003 VDD VSS sg13g2_decap_8
X_14630__1934 _14630_/RESET_B VDD VSS sg13g2_tiehi
X_11061_ _11061_/Y wire577/X _11202_/A _14760_/Q _11033_/B VDD VSS sg13g2_a22oi_1
XFILLER_1_656 VDD VSS sg13g2_decap_4
XFILLER_153_1142 VDD VSS sg13g2_decap_8
XFILLER_27_1145 VDD VSS sg13g2_decap_8
X_14957__3015 _14957_/RESET_B VDD VSS sg13g2_tiehi
XFILLER_62_1036 VDD VSS sg13g2_decap_8
X_10012_ _14594_/D _10078_/A0 _14594_/Q _10029_/S VDD VSS sg13g2_mux2_1
XFILLER_76_402 VDD VSS sg13g2_decap_8
XFILLER_89_785 VDD VSS sg13g2_fill_1
XFILLER_0_166 VDD VSS sg13g2_decap_4
XFILLER_131_893 VDD VSS sg13g2_decap_4
X_14820_ _14820_/Q clkload83/A _14820_/D _14820_/RESET_B VDD VSS sg13g2_dfrbpq_1
XFILLER_17_502 VDD VSS sg13g2_decap_8
XFILLER_29_373 VDD VSS sg13g2_fill_2
XFILLER_45_822 VDD VSS sg13g2_decap_4
XFILLER_151_63 VDD VSS sg13g2_decap_8
X_14751_ _14751_/Q clkload62/A _14751_/D _14751_/RESET_B VDD VSS sg13g2_dfrbpq_1
XFILLER_91_438 VDD VSS sg13g2_fill_1
X_11963_ _11964_/A _14256_/Q _14288_/Q _14320_/Q _14352_/Q _11804_/A _11805_/C VDD
+ VSS sg13g2_mux4_1
XFILLER_17_535 VDD VSS sg13g2_decap_8
XFILLER_56_181 VDD VSS sg13g2_decap_8
XFILLER_17_546 VDD VSS sg13g2_fill_1
XFILLER_17_557 VDD VSS sg13g2_decap_8
X_13702_ _13702_/Q clkload16/A _13702_/D _13702_/RESET_B VDD VSS sg13g2_dfrbpq_1
X_10914_ _10914_/Y _10914_/A _10973_/B VDD VSS sg13g2_nand2_1
X_11894_ _11898_/A _11893_/X _11894_/B VDD VSS sg13g2_nand2b_1
XFILLER_72_663 VDD VSS sg13g2_decap_8
X_14682_ _14682_/Q _15040_/CLK _14682_/D _14682_/RESET_B VDD VSS sg13g2_dfrbpq_1
XFILLER_44_365 VDD VSS sg13g2_decap_8
XFILLER_72_674 VDD VSS sg13g2_fill_1
XFILLER_60_825 VDD VSS sg13g2_decap_8
XFILLER_72_685 VDD VSS sg13g2_fill_2
X_13633_ _13741_/D _13633_/A VDD VSS sg13g2_buf_1
X_10845_ _10845_/Y _10876_/D _10876_/A _10885_/A1 VDD VSS sg13g2_a21oi_1
XFILLER_32_549 VDD VSS sg13g2_decap_8
XFILLER_73_1132 VDD VSS sg13g2_fill_1
XFILLER_34_1116 VDD VSS sg13g2_decap_4
XFILLER_73_1165 VDD VSS sg13g2_decap_8
XFILLER_12_240 VDD VSS sg13g2_decap_8
XFILLER_9_712 VDD VSS sg13g2_decap_8
X_10776_ _10776_/X _10776_/A _10793_/B _10793_/A VDD VSS sg13g2_and3_1
X_13564_ wire729/A _07910_/A _13600_/B _13563_/Y VDD VSS sg13g2_a21oi_1
XFILLER_9_723 VDD VSS sg13g2_fill_1
XFILLER_9_734 VDD VSS sg13g2_decap_8
XFILLER_8_211 VDD VSS sg13g2_fill_1
X_12515_ _12515_/X _13831_/Q _13863_/Q _13895_/Q _13927_/Q _12521_/S0 _12685_/S1 VDD
+ VSS sg13g2_mux4_1
X_13495_ _13495_/Y _15129_/Q _15071_/Q _13507_/B VDD VSS sg13g2_o21ai_1
XFILLER_12_295 VDD VSS sg13g2_decap_4
XFILLER_9_778 VDD VSS sg13g2_decap_8
Xmax_cap1723 _11997_/S0 _11992_/S0 VDD VSS sg13g2_buf_4
XFILLER_145_418 VDD VSS sg13g2_fill_2
X_12446_ _12446_/X _13730_/Q _14082_/Q _14434_/Q _14530_/Q _12450_/S0 _12452_/S1 VDD
+ VSS sg13g2_mux4_1
X_15234_ _15234_/Q clkload67/A _15234_/D _15234_/RESET_B VDD VSS sg13g2_dfrbpq_1
XFILLER_8_288 VDD VSS sg13g2_decap_8
XFILLER_67_7 VDD VSS sg13g2_decap_8
X_12377_ _12377_/X _13821_/Q _13853_/Q _13885_/Q _13917_/Q _12378_/S0 _12411_/S1 VDD
+ VSS sg13g2_mux4_1
X_15165_ _15165_/Q clkload67/A _15165_/D _15165_/RESET_B VDD VSS sg13g2_dfrbpq_1
XFILLER_154_974 VDD VSS sg13g2_decap_8
XFILLER_114_805 VDD VSS sg13g2_decap_8
XFILLER_154_985 VDD VSS sg13g2_fill_1
XFILLER_114_816 VDD VSS sg13g2_fill_1
XFILLER_126_676 VDD VSS sg13g2_decap_8
X_11328_ _11328_/X _13949_/Q _13981_/Q _14013_/Q _14045_/Q _11328_/S0 _11328_/S1 VDD
+ VSS sg13g2_mux4_1
X_14116_ _14116_/Q clkload31/A _14116_/D _14116_/RESET_B VDD VSS sg13g2_dfrbpq_1
XFILLER_141_624 VDD VSS sg13g2_decap_8
XFILLER_10_1171 VDD VSS sg13g2_decap_8
X_15096_ _15096_/Q clkload66/A _15096_/D _15096_/RESET_B VDD VSS sg13g2_dfrbpq_1
XFILLER_153_495 VDD VSS sg13g2_decap_8
XFILLER_5_77 VDD VSS sg13g2_decap_8
XFILLER_119_1037 VDD VSS sg13g2_fill_1
XFILLER_125_186 VDD VSS sg13g2_decap_4
X_11259_ _11259_/Y _11263_/A1 _13820_/Q VDD VSS sg13g2_nand2b_1
X_14047_ _14047_/Q _14509_/CLK _14047_/D _14047_/RESET_B VDD VSS sg13g2_dfrbpq_1
XFILLER_113_359 VDD VSS sg13g2_fill_2
XFILLER_80_1114 VDD VSS sg13g2_decap_4
XFILLER_122_860 VDD VSS sg13g2_fill_2
XFILLER_80_1136 VDD VSS sg13g2_decap_8
XFILLER_140_189 VDD VSS sg13g2_decap_8
XFILLER_80_1158 VDD VSS sg13g2_fill_2
XFILLER_94_243 VDD VSS sg13g2_fill_2
XFILLER_48_660 VDD VSS sg13g2_decap_8
XFILLER_36_811 VDD VSS sg13g2_decap_8
X_14949_ _14949_/Q clkload18/A _14949_/D _14949_/RESET_B VDD VSS sg13g2_dfrbpq_1
X_08470_ _08475_/B _08541_/A _08471_/B _15008_/Q VDD VSS sg13g2_and3_1
XFILLER_39_1016 VDD VSS sg13g2_decap_4
XFILLER_78_1076 VDD VSS sg13g2_decap_8
XFILLER_50_302 VDD VSS sg13g2_decap_4
XFILLER_91_994 VDD VSS sg13g2_fill_1
XFILLER_149_702 VDD VSS sg13g2_decap_8
XFILLER_93_0 VDD VSS sg13g2_decap_8
XFILLER_148_201 VDD VSS sg13g2_fill_2
XFILLER_148_256 VDD VSS sg13g2_fill_1
X_09022_ _09024_/B _12957_/A _12942_/A _14902_/Q _09022_/D VDD VSS sg13g2_nand4_1
X_15206__3359 _15206_/RESET_B VDD VSS sg13g2_tiehi
XFILLER_148_278 VDD VSS sg13g2_decap_8
XFILLER_148_289 VDD VSS sg13g2_fill_1
XFILLER_145_952 VDD VSS sg13g2_decap_8
XFILLER_89_1183 VDD VSS sg13g2_decap_8
XFILLER_117_665 VDD VSS sg13g2_decap_8
X_14438__2126 _14438_/RESET_B VDD VSS sg13g2_tiehi
XFILLER_85_1025 VDD VSS sg13g2_decap_8
XFILLER_85_1036 VDD VSS sg13g2_decap_4
Xpicorv32_macro_1807 mem_axi_awprot[2] VDD VSS sg13g2_tielo
XFILLER_46_1009 VDD VSS sg13g2_decap_8
XFILLER_105_849 VDD VSS sg13g2_decap_8
X_09924_ _14509_/D _14509_/Q _09924_/A1 _09937_/S VDD VSS sg13g2_mux2_1
Xfanout702 _09877_/A0 _09910_/A1 VDD VSS sg13g2_buf_1
XFILLER_59_914 VDD VSS sg13g2_decap_8
Xfanout724 _13656_/S _13499_/A VDD VSS sg13g2_buf_1
Xfanout735 _13560_/S _13568_/S VDD VSS sg13g2_buf_1
Xfanout746 _12763_/A2 _12429_/A2 VDD VSS sg13g2_buf_1
XFILLER_113_882 VDD VSS sg13g2_decap_4
XFILLER_86_722 VDD VSS sg13g2_decap_8
XFILLER_98_582 VDD VSS sg13g2_decap_4
X_09855_ _14442_/D _14442_/Q _10086_/A0 _09855_/S VDD VSS sg13g2_mux2_1
Xfanout757 _10870_/A _10691_/X VDD VSS sg13g2_buf_1
XFILLER_85_210 VDD VSS sg13g2_fill_2
XFILLER_100_510 VDD VSS sg13g2_decap_8
Xfanout779 _09090_/A _09159_/A1 VDD VSS sg13g2_buf_1
XFILLER_58_457 VDD VSS sg13g2_decap_4
X_08806_ _08808_/A _10895_/B1 _14752_/Q _08727_/X _15195_/Q _08809_/C1 VDD VSS sg13g2_a221oi_1
XFILLER_27_800 VDD VSS sg13g2_decap_8
X_09786_ _14375_/D _09918_/A1 _14375_/Q _09802_/S VDD VSS sg13g2_mux2_1
XFILLER_27_811 VDD VSS sg13g2_fill_2
XFILLER_61_1091 VDD VSS sg13g2_decap_8
XFILLER_100_598 VDD VSS sg13g2_decap_8
XFILLER_26_310 VDD VSS sg13g2_fill_2
X_08737_ _08737_/Y _13664_/Q _08752_/B VDD VSS sg13g2_nor2_1
XFILLER_27_844 VDD VSS sg13g2_decap_8
XFILLER_2_1136 VDD VSS sg13g2_decap_8
XFILLER_148_1200 VDD VSS sg13g2_decap_8
XFILLER_22_1086 VDD VSS sg13g2_decap_8
XFILLER_96_1143 VDD VSS sg13g2_decap_8
XFILLER_57_1105 VDD VSS sg13g2_decap_8
XFILLER_27_877 VDD VSS sg13g2_fill_2
X_08668_ _08668_/X _08668_/A _08668_/B VDD VSS sg13g2_or2_1
XFILLER_92_1007 VDD VSS sg13g2_decap_4
XFILLER_42_825 VDD VSS sg13g2_decap_8
X_14044__2520 _14044_/RESET_B VDD VSS sg13g2_tiehi
XFILLER_57_1149 VDD VSS sg13g2_decap_4
XFILLER_81_482 VDD VSS sg13g2_fill_2
X_07619_ _09011_/C _14900_/Q VDD VSS sg13g2_inv_1
XFILLER_42_858 VDD VSS sg13g2_decap_8
X_08599_ _08600_/D _08599_/A _08599_/B _08599_/C VDD VSS sg13g2_nor3_1
X_13697__2867 _13697_/RESET_B VDD VSS sg13g2_tiehi
XFILLER_81_48 VDD VSS sg13g2_fill_1
X_10630_ _14884_/D _10630_/A _10630_/B _10630_/C VDD VSS sg13g2_and3_1
XFILLER_81_59 VDD VSS sg13g2_decap_8
XFILLER_14_42 VDD VSS sg13g2_decap_8
X_14648__1916 _14648_/RESET_B VDD VSS sg13g2_tiehi
X_10561_ _10653_/A _10561_/A _10561_/B _10561_/C _10561_/D VDD VSS sg13g2_nor4_1
X_14830__3268 _14830_/RESET_B VDD VSS sg13g2_tiehi
XFILLER_128_919 VDD VSS sg13g2_decap_4
X_12300_ _12300_/Y _12300_/A _13662_/Q VDD VSS sg13g2_xnor2_1
XFILLER_10_777 VDD VSS sg13g2_fill_2
X_13280_ _13281_/A _11241_/C _07752_/Y _13279_/Y VDD VSS sg13g2_a21oi_1
X_10492_ _10492_/Y _10513_/D _14850_/Q _10492_/C _10508_/C VDD VSS sg13g2_nand4_1
X_14077__2487 _14077_/RESET_B VDD VSS sg13g2_tiehi
XFILLER_33_1182 VDD VSS sg13g2_decap_8
XFILLER_120_1130 VDD VSS sg13g2_decap_4
XFILLER_108_632 VDD VSS sg13g2_decap_8
XFILLER_5_236 VDD VSS sg13g2_fill_1
X_12231_ _12231_/X _12231_/A _12231_/B VDD VSS sg13g2_xor2_1
XFILLER_120_1152 VDD VSS sg13g2_decap_8
XFILLER_154_259 VDD VSS sg13g2_decap_8
XFILLER_135_451 VDD VSS sg13g2_fill_1
XFILLER_108_676 VDD VSS sg13g2_decap_8
XFILLER_151_922 VDD VSS sg13g2_fill_2
XFILLER_29_1207 VDD VSS sg13g2_decap_8
XFILLER_120_1196 VDD VSS sg13g2_decap_8
X_12162_ _12163_/A _13974_/Q _14006_/Q _14038_/Q _14070_/Q _12162_/S0 _12169_/C VDD
+ VSS sg13g2_mux4_1
XFILLER_123_624 VDD VSS sg13g2_fill_1
XFILLER_146_63 VDD VSS sg13g2_decap_8
XFILLER_135_484 VDD VSS sg13g2_decap_8
XFILLER_155_1226 VDD VSS sg13g2_decap_8
XFILLER_150_421 VDD VSS sg13g2_fill_2
X_15016__2956 _15016_/RESET_B VDD VSS sg13g2_tiehi
X_11113_ _11113_/Y _14950_/Q _11170_/B VDD VSS sg13g2_nand2_1
X_12093_ _12094_/A _13972_/Q _14004_/Q _14036_/Q _14068_/Q _12098_/A1 _12114_/S1 VDD
+ VSS sg13g2_mux4_1
XFILLER_1_453 VDD VSS sg13g2_decap_4
XFILLER_2_987 VDD VSS sg13g2_decap_8
XFILLER_89_560 VDD VSS sg13g2_decap_8
XFILLER_7_1014 VDD VSS sg13g2_fill_1
X_14292__2272 _14292_/RESET_B VDD VSS sg13g2_tiehi
XFILLER_89_571 VDD VSS sg13g2_fill_1
X_11044_ _11046_/A _11044_/A _11044_/B _11044_/C VDD VSS sg13g2_nand3_1
XFILLER_39_61 VDD VSS sg13g2_decap_4
XFILLER_77_744 VDD VSS sg13g2_decap_8
XFILLER_103_381 VDD VSS sg13g2_fill_1
XFILLER_7_1047 VDD VSS sg13g2_decap_8
XFILLER_65_906 VDD VSS sg13g2_decap_8
XFILLER_77_766 VDD VSS sg13g2_decap_8
XFILLER_39_94 VDD VSS sg13g2_decap_8
XFILLER_40_1131 VDD VSS sg13g2_decap_4
XFILLER_92_725 VDD VSS sg13g2_fill_2
X_14803_ _14803_/Q clkload74/A _14803_/D _14803_/RESET_B VDD VSS sg13g2_dfrbpq_1
XFILLER_64_438 VDD VSS sg13g2_fill_2
XFILLER_17_310 VDD VSS sg13g2_decap_8
X_12995_ _13005_/A _13010_/A _13247_/D _12995_/C VDD VSS sg13g2_nand3_1
XFILLER_18_855 VDD VSS sg13g2_decap_8
XFILLER_18_866 VDD VSS sg13g2_fill_1
X_14734_ _14734_/Q _14763_/CLK _14734_/D _14734_/RESET_B VDD VSS sg13g2_dfrbpq_1
XFILLER_33_803 VDD VSS sg13g2_decap_8
X_11946_ _11946_/X _11946_/A _11973_/B VDD VSS sg13g2_and2_1
XFILLER_33_825 VDD VSS sg13g2_decap_8
XFILLER_17_387 VDD VSS sg13g2_decap_8
X_14665_ _14665_/Q clkload6/A _14665_/D _14665_/RESET_B VDD VSS sg13g2_dfrbpq_1
XFILLER_72_493 VDD VSS sg13g2_fill_2
X_11877_ _11877_/Y _11882_/S0 _14574_/Q VDD VSS sg13g2_nand2b_1
X_14516__2048 _14516_/RESET_B VDD VSS sg13g2_tiehi
X_13616_ _13724_/D _13616_/A VDD VSS sg13g2_buf_1
Xclkbuf_5_16__f_clk_i clkbuf_leaf_30_clk_i/A clkbuf_4_8_0_clk_i/X VDD VSS sg13g2_buf_16
X_10828_ _10831_/B _10851_/D _12347_/B VDD VSS sg13g2_nand2_1
X_14596_ _14596_/Q _15001_/CLK _14596_/D _14596_/RESET_B VDD VSS sg13g2_dfrbpq_1
XFILLER_60_699 VDD VSS sg13g2_fill_1
XFILLER_125_1052 VDD VSS sg13g2_decap_8
X_13547_ _13547_/Y _13547_/A _13547_/B VDD VSS sg13g2_nor2_1
X_10759_ _10759_/X _14948_/Q _10757_/A _10757_/Y VDD VSS sg13g2_a21o_1
X_14806__3292 _14806_/RESET_B VDD VSS sg13g2_tiehi
XFILLER_12_1200 VDD VSS sg13g2_decap_8
XFILLER_9_597 VDD VSS sg13g2_decap_8
XFILLER_69_1009 VDD VSS sg13g2_fill_1
Xmax_cap1542 _16883_/A _13721_/Q VDD VSS sg13g2_buf_4
X_13478_ _15113_/D _15179_/D _15113_/Q _13656_/S VDD VSS sg13g2_mux2_1
XFILLER_127_930 VDD VSS sg13g2_fill_1
Xmax_cap1553 _16872_/A _13710_/Q VDD VSS sg13g2_buf_8
X_13742__2822 _13742_/RESET_B VDD VSS sg13g2_tiehi
X_15217_ _15217_/Q _15250_/CLK _15217_/D _15217_/RESET_B VDD VSS sg13g2_dfrbpq_1
X_12429_ _12429_/Y _13688_/Q _12429_/A2 _12428_/X _12429_/B2 _12498_/C1 VDD VSS sg13g2_a221oi_1
XFILLER_127_963 VDD VSS sg13g2_decap_8
X_15148_ _15148_/Q _15148_/CLK _15148_/D _15148_/RESET_B VDD VSS sg13g2_dfrbpq_1
XFILLER_141_432 VDD VSS sg13g2_decap_8
XFILLER_141_443 VDD VSS sg13g2_decap_4
X_07970_ _07976_/A _08697_/B _07834_/A _07981_/C VDD VSS sg13g2_o21ai_1
XFILLER_99_379 VDD VSS sg13g2_decap_8
X_15079_ _15079_/Q clkload71/A _15079_/D _15079_/RESET_B VDD VSS sg13g2_dfrbpq_1
XFILLER_114_679 VDD VSS sg13g2_fill_2
XFILLER_141_487 VDD VSS sg13g2_fill_2
X_14122__2442 _14122_/RESET_B VDD VSS sg13g2_tiehi
XFILLER_68_722 VDD VSS sg13g2_decap_8
XFILLER_113_178 VDD VSS sg13g2_fill_1
XFILLER_141_498 VDD VSS sg13g2_decap_8
X_13775__2789 _13775_/RESET_B VDD VSS sg13g2_tiehi
XFILLER_132_1023 VDD VSS sg13g2_decap_8
XFILLER_68_744 VDD VSS sg13g2_fill_2
XFILLER_67_232 VDD VSS sg13g2_fill_2
XFILLER_110_841 VDD VSS sg13g2_decap_8
X_09640_ _09740_/B _10137_/A _09938_/B _09938_/A VDD VSS sg13g2_nand3b_1
XFILLER_68_788 VDD VSS sg13g2_decap_8
XFILLER_67_265 VDD VSS sg13g2_fill_1
XFILLER_83_714 VDD VSS sg13g2_decap_8
XFILLER_132_1078 VDD VSS sg13g2_fill_1
X_14726__1838 _14726_/RESET_B VDD VSS sg13g2_tiehi
XFILLER_67_276 VDD VSS sg13g2_fill_2
X_09571_ _14169_/D _10101_/A0 _14169_/Q _09571_/S VDD VSS sg13g2_mux2_1
X_08522_ _08526_/B _08522_/A _08548_/B _08522_/C VDD VSS sg13g2_nand3_1
XFILLER_64_961 VDD VSS sg13g2_fill_1
X_13990__2574 _13990_/RESET_B VDD VSS sg13g2_tiehi
X_14941__3047 _14941_/RESET_B VDD VSS sg13g2_tiehi
X_08453_ _08454_/C _08456_/C _08456_/B _08453_/B1 VDD VSS sg13g2_a21oi_1
XFILLER_91_791 VDD VSS sg13g2_decap_8
XFILLER_51_633 VDD VSS sg13g2_decap_8
XFILLER_11_508 VDD VSS sg13g2_fill_1
XFILLER_91_1040 VDD VSS sg13g2_decap_4
XFILLER_149_510 VDD VSS sg13g2_decap_8
X_08384_ _08385_/C _08383_/A _08383_/B _08689_/B1 VDD VSS sg13g2_a21oi_1
XFILLER_50_165 VDD VSS sg13g2_decap_8
XFILLER_32_880 VDD VSS sg13g2_decap_4
XFILLER_17_1155 VDD VSS sg13g2_decap_8
XFILLER_143_1174 VDD VSS sg13g2_decap_4
X_14370__2194 _14370_/RESET_B VDD VSS sg13g2_tiehi
X_09005_ _09022_/D _09011_/B _09011_/C _09011_/D VDD VSS sg13g2_nor3_1
XFILLER_118_963 VDD VSS sg13g2_fill_1
XFILLER_151_229 VDD VSS sg13g2_decap_8
XFILLER_105_635 VDD VSS sg13g2_fill_2
XFILLER_104_112 VDD VSS sg13g2_decap_8
XFILLER_144_292 VDD VSS sg13g2_fill_2
XFILLER_104_145 VDD VSS sg13g2_decap_4
XFILLER_105_668 VDD VSS sg13g2_fill_2
Xfanout1508 _13199_/A _14920_/Q VDD VSS sg13g2_buf_1
Xfanout521 _10146_/A1 wire524/X VDD VSS sg13g2_buf_1
Xfanout1519 _10674_/A _14896_/Q VDD VSS sg13g2_buf_1
X_09907_ _14492_/D _14492_/Q _09907_/A1 _09907_/S VDD VSS sg13g2_mux2_1
Xfanout532 _10076_/A0 _09447_/A0 VDD VSS sg13g2_buf_1
XFILLER_63_1153 VDD VSS sg13g2_decap_8
XFILLER_150_1112 VDD VSS sg13g2_decap_8
XFILLER_59_744 VDD VSS sg13g2_fill_2
XFILLER_63_1164 VDD VSS sg13g2_fill_2
XFILLER_76_37 VDD VSS sg13g2_decap_8
XFILLER_63_1186 VDD VSS sg13g2_decap_8
XFILLER_101_852 VDD VSS sg13g2_fill_1
XFILLER_4_1209 VDD VSS sg13g2_decap_8
Xfanout576 _11163_/A _11164_/A VDD VSS sg13g2_buf_1
XFILLER_24_1148 VDD VSS sg13g2_decap_8
Xfanout587 _10132_/S wire593/X VDD VSS sg13g2_buf_1
X_09838_ _14426_/D _10136_/A0 _14426_/Q _09838_/S VDD VSS sg13g2_mux2_1
Xfanout598 _10009_/S wire601/X VDD VSS sg13g2_buf_1
XFILLER_47_939 VDD VSS sg13g2_decap_8
XFILLER_86_585 VDD VSS sg13g2_decap_8
XFILLER_101_885 VDD VSS sg13g2_decap_8
XFILLER_150_1178 VDD VSS sg13g2_decap_8
XFILLER_132_21 VDD VSS sg13g2_decap_8
XFILLER_73_202 VDD VSS sg13g2_fill_2
XFILLER_86_596 VDD VSS sg13g2_fill_1
X_09769_ _14359_/D _14359_/Q _09934_/A1 _09769_/S VDD VSS sg13g2_mux2_1
XFILLER_100_395 VDD VSS sg13g2_decap_4
XFILLER_73_246 VDD VSS sg13g2_decap_8
XFILLER_92_14 VDD VSS sg13g2_decap_8
X_11800_ _11800_/Y _12056_/A _11800_/B VDD VSS sg13g2_xnor2_1
XFILLER_55_972 VDD VSS sg13g2_fill_2
XFILLER_132_98 VDD VSS sg13g2_decap_8
X_12780_ _12780_/X _14138_/Q _14170_/Q _14202_/Q _14234_/Q _12785_/S0 _12785_/S1 VDD
+ VSS sg13g2_mux4_1
X_13820__2744 _13820_/RESET_B VDD VSS sg13g2_tiehi
X_14580__1984 _14580_/RESET_B VDD VSS sg13g2_tiehi
X_11731_ _11731_/Y _11733_/A1 _14154_/Q _11760_/C VDD VSS sg13g2_a21oi_1
XFILLER_25_63 VDD VSS sg13g2_decap_8
XFILLER_148_1096 VDD VSS sg13g2_decap_8
XFILLER_70_975 VDD VSS sg13g2_fill_1
XFILLER_41_154 VDD VSS sg13g2_decap_4
X_14450_ _14450_/Q _14706_/CLK _14450_/D _14450_/RESET_B VDD VSS sg13g2_dfrbpq_1
X_11662_ _11664_/B _11663_/A _11663_/B _11773_/B VDD VSS sg13g2_a21oi_1
XFILLER_70_997 VDD VSS sg13g2_fill_2
XFILLER_35_1222 VDD VSS sg13g2_decap_8
XFILLER_70_1113 VDD VSS sg13g2_decap_8
XFILLER_23_891 VDD VSS sg13g2_decap_8
XFILLER_70_1124 VDD VSS sg13g2_fill_2
X_13401_ _13433_/A _13429_/A _13401_/B _13401_/C VDD VSS sg13g2_nand3b_1
X_10613_ _10625_/D _10613_/A _10614_/B VDD VSS sg13g2_nor2_1
X_14381_ _14381_/Q clkload55/A _14381_/D _14381_/RESET_B VDD VSS sg13g2_dfrbpq_1
X_11593_ _11593_/Y _11636_/C _11593_/B VDD VSS sg13g2_xnor2_1
XFILLER_22_390 VDD VSS sg13g2_decap_8
Xwire911 wire911/X wire911/A VDD VSS sg13g2_buf_1
X_14200__2364 _14200_/RESET_B VDD VSS sg13g2_tiehi
XFILLER_128_727 VDD VSS sg13g2_decap_4
X_10544_ _14863_/D _10544_/A _10544_/B _13356_/B VDD VSS sg13g2_and3_1
X_13332_ _15175_/D hold3435/X _15175_/Q _13336_/S VDD VSS sg13g2_mux2_1
Xwire955 wire955/X wire955/A VDD VSS sg13g2_buf_2
XFILLER_127_237 VDD VSS sg13g2_decap_8
X_10475_ _14846_/D _10504_/C _10492_/C _10474_/Y VDD VSS sg13g2_a21oi_1
X_13263_ _13263_/Y _13260_/Y _13261_/Y _13262_/Y VDD VSS sg13g2_a21oi_1
XFILLER_124_900 VDD VSS sg13g2_decap_8
X_15002_ _15002_/Q clkload37/A _15002_/D _15002_/RESET_B VDD VSS sg13g2_dfrbpq_1
XFILLER_68_1031 VDD VSS sg13g2_decap_8
X_12214_ _12214_/Y _12213_/X _12219_/S VDD VSS sg13g2_nand2b_1
XFILLER_68_1042 VDD VSS sg13g2_fill_2
X_13194_ _13196_/B _14856_/Q _13234_/B VDD VSS sg13g2_nand2_1
XFILLER_29_1015 VDD VSS sg13g2_decap_8
XFILLER_123_421 VDD VSS sg13g2_fill_1
XFILLER_124_944 VDD VSS sg13g2_decap_8
X_12145_ wire298/A _11975_/A _12141_/X _12144_/Y VDD VSS sg13g2_o21ai_1
XFILLER_150_240 VDD VSS sg13g2_decap_8
XFILLER_111_627 VDD VSS sg13g2_decap_8
XFILLER_1_261 VDD VSS sg13g2_decap_8
XFILLER_123_498 VDD VSS sg13g2_decap_4
X_12076_ _12076_/X _12073_/X _12072_/X _12069_/X _12068_/X _12092_/C _12076_/S1 VDD
+ VSS sg13g2_mux4_1
XFILLER_77_530 VDD VSS sg13g2_decap_8
XFILLER_49_243 VDD VSS sg13g2_decap_8
X_11027_ _11027_/Y wire239/X _11052_/A _11191_/A VDD VSS sg13g2_a21oi_1
XFILLER_2_56 VDD VSS sg13g2_decap_8
X_16884_ _16884_/X _16884_/A VDD VSS sg13g2_buf_1
XFILLER_38_939 VDD VSS sg13g2_decap_8
XFILLER_92_500 VDD VSS sg13g2_decap_8
XFILLER_64_213 VDD VSS sg13g2_fill_2
XFILLER_64_224 VDD VSS sg13g2_decap_8
X_15205__3358 _15205_/RESET_B VDD VSS sg13g2_tiehi
XFILLER_64_268 VDD VSS sg13g2_decap_8
X_12978_ _12978_/Y _14778_/Q _13220_/A2 _12978_/B1 VDD VSS sg13g2_o21ai_1
XFILLER_46_983 VDD VSS sg13g2_fill_1
X_14717_ _14717_/Q clkload52/A _14717_/D _14717_/RESET_B VDD VSS sg13g2_dfrbpq_1
XFILLER_127_1103 VDD VSS sg13g2_fill_1
XFILLER_17_184 VDD VSS sg13g2_decap_8
X_11929_ _11929_/Y _12292_/A _11929_/B VDD VSS sg13g2_nor2_1
XFILLER_60_441 VDD VSS sg13g2_decap_8
XFILLER_33_666 VDD VSS sg13g2_fill_1
XFILLER_61_975 VDD VSS sg13g2_decap_8
XFILLER_75_1079 VDD VSS sg13g2_fill_1
X_14648_ _14648_/Q clkload36/A _14648_/D _14648_/RESET_B VDD VSS sg13g2_dfrbpq_1
XFILLER_33_688 VDD VSS sg13g2_fill_1
XFILLER_33_699 VDD VSS sg13g2_decap_4
X_14579_ _14579_/Q clkload11/A _14579_/D _14579_/RESET_B VDD VSS sg13g2_dfrbpq_1
XFILLER_9_361 VDD VSS sg13g2_decap_8
XFILLER_146_568 VDD VSS sg13g2_fill_1
XFILLER_146_579 VDD VSS sg13g2_decap_4
XFILLER_12_1074 VDD VSS sg13g2_decap_8
Xoutput102 mem_axi_bready _07661_/Y VDD VSS sg13g2_buf_1
Xoutput113 mem_axi_wdata[18] _15150_/Q VDD VSS sg13g2_buf_1
XFILLER_56_0 VDD VSS sg13g2_decap_8
XFILLER_127_782 VDD VSS sg13g2_decap_4
Xoutput124 mem_axi_wdata[28] _15160_/Q VDD VSS sg13g2_buf_1
XFILLER_86_1142 VDD VSS sg13g2_fill_1
Xoutput135 mem_axi_wdata[9] _15141_/Q VDD VSS sg13g2_buf_1
XFILLER_99_143 VDD VSS sg13g2_decap_4
XFILLER_115_977 VDD VSS sg13g2_decap_4
XFILLER_134_1107 VDD VSS sg13g2_decap_4
XFILLER_88_839 VDD VSS sg13g2_decap_8
XFILLER_130_925 VDD VSS sg13g2_fill_1
XFILLER_141_273 VDD VSS sg13g2_decap_8
XFILLER_114_498 VDD VSS sg13g2_decap_8
X_07953_ _07954_/C _07818_/Y _07952_/Y _07951_/Y VDD VSS sg13g2_a21oi_1
XFILLER_101_159 VDD VSS sg13g2_fill_2
X_07884_ _07884_/Y _07884_/A _08023_/B VDD VSS sg13g2_xnor2_1
XFILLER_96_894 VDD VSS sg13g2_fill_2
XFILLER_28_427 VDD VSS sg13g2_fill_2
X_09623_ _14219_/D _10087_/A0 _14219_/Q _09637_/S VDD VSS sg13g2_mux2_1
X_14388__2176 _14388_/RESET_B VDD VSS sg13g2_tiehi
X_09554_ _14152_/D _09655_/A0 _14152_/Q _09556_/S VDD VSS sg13g2_mux2_1
XFILLER_55_268 VDD VSS sg13g2_fill_1
XFILLER_71_739 VDD VSS sg13g2_fill_2
XFILLER_36_471 VDD VSS sg13g2_decap_8
XFILLER_58_1233 VDD VSS sg13g2_decap_4
X_08505_ _08505_/Y _07822_/A _08495_/Y _08504_/Y VDD VSS sg13g2_o21ai_1
XFILLER_110_1184 VDD VSS sg13g2_fill_1
X_09485_ _14085_/D _10081_/A0 _14085_/Q _09495_/S VDD VSS sg13g2_mux2_1
XFILLER_93_1146 VDD VSS sg13g2_decap_8
XFILLER_54_1119 VDD VSS sg13g2_fill_2
X_08436_ _08436_/Y wire232/X _08436_/B VDD VSS sg13g2_nand2b_1
XFILLER_52_997 VDD VSS sg13g2_fill_2
X_08367_ _08367_/Y _08411_/A _08411_/C _08366_/X VDD VSS sg13g2_o21ai_1
XFILLER_23_198 VDD VSS sg13g2_decap_8
XFILLER_149_351 VDD VSS sg13g2_decap_8
XFILLER_134_7 VDD VSS sg13g2_decap_8
Xwire207 wire207/X wire207/A VDD VSS sg13g2_buf_2
XFILLER_149_362 VDD VSS sg13g2_fill_2
X_08298_ _08298_/Y _08318_/C _08297_/Y _08588_/B VDD VSS sg13g2_o21ai_1
XFILLER_11_21 VDD VSS sg13g2_decap_8
XFILLER_124_218 VDD VSS sg13g2_fill_1
XFILLER_127_21 VDD VSS sg13g2_decap_8
X_10260_ _14781_/D _10265_/A _10265_/D _10259_/Y VDD VSS sg13g2_a21oi_1
XFILLER_3_526 VDD VSS sg13g2_decap_4
XFILLER_117_281 VDD VSS sg13g2_decap_8
XFILLER_11_98 VDD VSS sg13g2_decap_8
XFILLER_105_443 VDD VSS sg13g2_decap_8
X_10191_ _15196_/D input23/X _15196_/Q _10205_/S VDD VSS sg13g2_mux2_1
X_13838__2726 _13838_/RESET_B VDD VSS sg13g2_tiehi
XFILLER_132_251 VDD VSS sg13g2_fill_1
X_14598__1966 _14598_/RESET_B VDD VSS sg13g2_tiehi
XFILLER_132_273 VDD VSS sg13g2_fill_2
Xfanout1305 _09938_/B _10105_/C VDD VSS sg13g2_buf_1
XFILLER_132_284 VDD VSS sg13g2_decap_8
Xfanout1316 _10793_/A _15060_/Q VDD VSS sg13g2_buf_1
Xfanout1327 _08959_/B _08977_/C VDD VSS sg13g2_buf_1
Xfanout340 _09424_/S _09440_/S VDD VSS sg13g2_buf_1
Xfanout1338 _08456_/C _13555_/A VDD VSS sg13g2_buf_1
XFILLER_87_850 VDD VSS sg13g2_fill_1
XFILLER_8_1153 VDD VSS sg13g2_decap_8
Xfanout351 _10115_/A0 _09025_/X VDD VSS sg13g2_buf_1
Xfanout1349 _08034_/A _08201_/A VDD VSS sg13g2_buf_1
XFILLER_143_42 VDD VSS sg13g2_decap_8
Xfanout362 _09909_/A1 _08983_/X VDD VSS sg13g2_buf_1
X_13950_ _13950_/Q clkload58/A _13950_/D _13950_/RESET_B VDD VSS sg13g2_dfrbpq_1
XFILLER_115_1051 VDD VSS sg13g2_decap_8
Xfanout384 _11040_/A _10736_/Y VDD VSS sg13g2_buf_1
XFILLER_4_1028 VDD VSS sg13g2_decap_4
XFILLER_115_1073 VDD VSS sg13g2_decap_8
X_12901_ _12902_/A input32/X _12841_/B _12803_/X input9/X VDD VSS sg13g2_a22oi_1
XFILLER_74_533 VDD VSS sg13g2_decap_8
X_13881_ _13881_/Q clkload15/A _13881_/D _13881_/RESET_B VDD VSS sg13g2_dfrbpq_1
X_14218__2346 _14218_/RESET_B VDD VSS sg13g2_tiehi
XFILLER_59_1008 VDD VSS sg13g2_decap_4
XFILLER_74_577 VDD VSS sg13g2_decap_8
X_12832_ _12832_/Y _12829_/Y _12830_/Y _12831_/Y VDD VSS sg13g2_a21oi_1
XFILLER_36_84 VDD VSS sg13g2_fill_1
XFILLER_43_931 VDD VSS sg13g2_decap_8
XFILLER_61_227 VDD VSS sg13g2_decap_8
X_12763_ _12764_/B _13664_/Q _12763_/A2 _12762_/X _12763_/B2 _12763_/C1 VDD VSS sg13g2_a221oi_1
X_14502_ _14502_/Q _14917_/CLK _14502_/D _14502_/RESET_B VDD VSS sg13g2_dfrbpq_1
X_11714_ _11714_/X _14377_/Q _14409_/Q _14473_/Q _14505_/Q _11714_/S0 _11714_/S1 VDD
+ VSS sg13g2_mux4_1
XFILLER_14_154 VDD VSS sg13g2_decap_4
XFILLER_70_772 VDD VSS sg13g2_decap_8
X_12694_ _15013_/D _12694_/A wire371/X VDD VSS sg13g2_nor2_1
XFILLER_42_485 VDD VSS sg13g2_decap_8
XFILLER_30_636 VDD VSS sg13g2_decap_8
X_14433__2131 _14433_/RESET_B VDD VSS sg13g2_tiehi
X_14433_ _14433_/Q clkload28/A _14433_/D _14433_/RESET_B VDD VSS sg13g2_dfrbpq_1
X_11645_ _11645_/X _13831_/Q _13863_/Q _13895_/Q _13927_/Q _11648_/S0 _12067_/S1 VDD
+ VSS sg13g2_mux4_1
XFILLER_11_872 VDD VSS sg13g2_decap_8
XFILLER_35_1085 VDD VSS sg13g2_fill_1
Xinput15 input15/X input15/A VDD VSS sg13g2_buf_1
X_14364_ _14364_/Q clkload77/A _14364_/D _14364_/RESET_B VDD VSS sg13g2_dfrbpq_1
Xwire730 wire730/X wire730/A VDD VSS sg13g2_buf_2
Xinput26 input26/X input26/A VDD VSS sg13g2_buf_1
X_11576_ _11576_/X _14693_/Q _14725_/Q _13765_/Q _13797_/Q _11578_/S0 _11580_/S1 VDD
+ VSS sg13g2_mux4_1
Xwire741 wire741/X wire742/X VDD VSS sg13g2_buf_1
XFILLER_156_855 VDD VSS sg13g2_fill_1
Xinput37 input37/X input37/A VDD VSS sg13g2_buf_1
Xwire763 wire763/X wire763/A VDD VSS sg13g2_buf_1
XFILLER_155_354 VDD VSS sg13g2_decap_8
XFILLER_7_865 VDD VSS sg13g2_decap_8
X_13315_ _15061_/D _15079_/Q _07694_/Y _13314_/X VDD VSS sg13g2_a21o_1
Xmax_cap507 _09272_/S _09273_/S VDD VSS sg13g2_buf_4
Xclkbuf_leaf_4_clk_i _14725_/CLK clkbuf_leaf_5_clk_i/A VDD VSS sg13g2_buf_8
X_10527_ _10529_/A _10564_/D _10531_/D _10558_/B VDD VSS sg13g2_a21o_1
X_14295_ _14295_/Q clkload7/A _14295_/D _14295_/RESET_B VDD VSS sg13g2_dfrbpq_1
XFILLER_143_527 VDD VSS sg13g2_decap_8
X_10458_ _10512_/A _14842_/Q _14841_/Q _14840_/Q _14839_/Q VDD VSS sg13g2_nand4_1
X_13246_ _13247_/C _14922_/Q _13665_/Q _13246_/C VDD VSS sg13g2_nand3_1
X_14466__2098 _14466_/RESET_B VDD VSS sg13g2_tiehi
XFILLER_108_281 VDD VSS sg13g2_decap_8
XFILLER_108_292 VDD VSS sg13g2_fill_2
X_10389_ _14820_/D _10378_/D _10387_/X _10388_/Y VDD VSS sg13g2_a21oi_1
X_13177_ _13177_/X _13225_/A wire182/X VDD VSS sg13g2_xor2_1
XFILLER_124_774 VDD VSS sg13g2_decap_8
XFILLER_112_947 VDD VSS sg13g2_fill_1
X_12128_ _12198_/B _12128_/A _13667_/Q VDD VSS sg13g2_xnor2_1
XFILLER_97_647 VDD VSS sg13g2_decap_8
XFILLER_42_1012 VDD VSS sg13g2_fill_1
X_13666__2925 _13666_/RESET_B VDD VSS sg13g2_tiehi
XFILLER_133_1140 VDD VSS sg13g2_decap_4
X_12059_ wire380/A _12054_/Y _11986_/Y _11913_/A _12056_/C _12058_/Y VDD VSS sg13g2_a221oi_1
XFILLER_133_1151 VDD VSS sg13g2_decap_4
XFILLER_42_1034 VDD VSS sg13g2_decap_8
XFILLER_84_319 VDD VSS sg13g2_decap_8
X_16867_ _16867_/X _16867_/A VDD VSS sg13g2_buf_1
XFILLER_42_1089 VDD VSS sg13g2_decap_8
Xclkbuf_5_31__f_clk_i clkbuf_leaf_71_clk_i/A clkbuf_4_15_0_clk_i/X VDD VSS sg13g2_buf_16
X_14643__1921 _14643_/RESET_B VDD VSS sg13g2_tiehi
XFILLER_65_588 VDD VSS sg13g2_decap_8
XFILLER_93_897 VDD VSS sg13g2_fill_1
XFILLER_34_920 VDD VSS sg13g2_decap_4
XFILLER_65_599 VDD VSS sg13g2_fill_1
XFILLER_80_525 VDD VSS sg13g2_decap_8
XFILLER_46_791 VDD VSS sg13g2_decap_8
XFILLER_80_569 VDD VSS sg13g2_decap_8
X_14072__2492 _14072_/RESET_B VDD VSS sg13g2_tiehi
XFILLER_34_986 VDD VSS sg13g2_decap_4
X_09270_ _13879_/D _13879_/Q _10166_/A1 _09270_/S VDD VSS sg13g2_mux2_1
X_08221_ _08221_/Y _08220_/X _08542_/A2 _08319_/A VDD VSS sg13g2_a21oi_1
XFILLER_92_1190 VDD VSS sg13g2_decap_8
X_13916__2648 _13916_/RESET_B VDD VSS sg13g2_tiehi
X_14676__1888 _14676_/RESET_B VDD VSS sg13g2_tiehi
XFILLER_140_1111 VDD VSS sg13g2_fill_2
X_08152_ _08152_/Y _08402_/A _08402_/B _08025_/B VDD VSS sg13g2_o21ai_1
X_15011__2961 _15011_/RESET_B VDD VSS sg13g2_tiehi
XFILLER_119_535 VDD VSS sg13g2_decap_4
XFILLER_147_855 VDD VSS sg13g2_fill_1
XFILLER_146_343 VDD VSS sg13g2_fill_1
XFILLER_140_1155 VDD VSS sg13g2_fill_1
XFILLER_14_1169 VDD VSS sg13g2_decap_8
X_08083_ _08086_/B _07949_/C _07801_/B _07820_/B _07815_/B _08598_/S0 _08598_/S1 VDD
+ VSS sg13g2_mux4_1
XFILLER_134_527 VDD VSS sg13g2_decap_4
XFILLER_106_218 VDD VSS sg13g2_decap_8
XFILLER_146_398 VDD VSS sg13g2_decap_8
Xhold3402 input37/A mem_axi_wready VDD VSS sg13g2_dlygate4sd3_1
Xhold3413 hold3413/X input35/X VDD VSS sg13g2_dlygate4sd3_1
XFILLER_0_518 VDD VSS sg13g2_decap_4
Xhold3424 _10210_/C input1/X VDD VSS sg13g2_dlygate4sd3_1
Xhold3435 hold3435/X input32/X VDD VSS sg13g2_dlygate4sd3_1
Xhold3446 input14/A mem_axi_rdata[19] VDD VSS sg13g2_dlygate4sd3_1
XFILLER_142_593 VDD VSS sg13g2_decap_8
Xhold3457 input21/A mem_axi_rdata[25] VDD VSS sg13g2_dlygate4sd3_1
X_08985_ _08985_/X _15025_/Q _15222_/Q _09085_/B VDD VSS sg13g2_mux2_1
XFILLER_87_135 VDD VSS sg13g2_decap_8
XFILLER_103_969 VDD VSS sg13g2_decap_8
XFILLER_25_1221 VDD VSS sg13g2_decap_8
XFILLER_57_28 VDD VSS sg13g2_decap_8
Xhold3468 _13646_/A _13754_/Q VDD VSS sg13g2_dlygate4sd3_1
Xhold3479 _13625_/A _13733_/Q VDD VSS sg13g2_dlygate4sd3_1
X_07936_ _07936_/Y _15003_/Q _07790_/A VDD VSS sg13g2_nor2b_1
X_14511__2053 _14511_/RESET_B VDD VSS sg13g2_tiehi
XFILLER_111_991 VDD VSS sg13g2_decap_8
XFILLER_29_758 VDD VSS sg13g2_fill_2
X_07867_ _07905_/D _07969_/A _08666_/A _08650_/A _07867_/D VDD VSS sg13g2_or4_1
X_15248__3401 _15248_/RESET_B VDD VSS sg13g2_tiehi
XFILLER_56_566 VDD VSS sg13g2_fill_2
XFILLER_83_352 VDD VSS sg13g2_decap_4
XFILLER_113_56 VDD VSS sg13g2_decap_8
X_09606_ _09606_/Y _10037_/A _10070_/B _09606_/C VDD VSS sg13g2_nand3_1
XFILLER_3_1061 VDD VSS sg13g2_decap_4
X_07798_ _07798_/X _15006_/Q _07798_/B VDD VSS sg13g2_or2_1
XFILLER_71_525 VDD VSS sg13g2_decap_8
X_14765__3333 _14765_/RESET_B VDD VSS sg13g2_tiehi
XFILLER_3_1083 VDD VSS sg13g2_decap_8
X_09537_ _14136_/D _09902_/A0 _14136_/Q _09537_/S VDD VSS sg13g2_mux2_1
XFILLER_145_1011 VDD VSS sg13g2_decap_8
XFILLER_25_997 VDD VSS sg13g2_decap_8
XFILLER_24_474 VDD VSS sg13g2_fill_1
XFILLER_52_783 VDD VSS sg13g2_fill_2
X_09468_ _14069_/D _10097_/A0 _14069_/Q _09472_/S VDD VSS sg13g2_mux2_1
XFILLER_19_1058 VDD VSS sg13g2_decap_8
XFILLER_145_1077 VDD VSS sg13g2_fill_1
X_08419_ _08419_/Y _08419_/A VDD VSS sg13g2_inv_1
XFILLER_12_647 VDD VSS sg13g2_decap_4
XFILLER_40_956 VDD VSS sg13g2_decap_8
X_09399_ _14002_/D _09962_/A1 _14002_/Q _09406_/S VDD VSS sg13g2_mux2_1
XFILLER_156_118 VDD VSS sg13g2_decap_4
XFILLER_32_1225 VDD VSS sg13g2_decap_8
X_11430_ _11430_/Y _11430_/A _11430_/B VDD VSS sg13g2_xnor2_1
XFILLER_32_1236 VDD VSS sg13g2_fill_1
XFILLER_22_42 VDD VSS sg13g2_decap_8
XFILLER_149_192 VDD VSS sg13g2_decap_4
X_11361_ _11361_/Y _12334_/C _11361_/B VDD VSS sg13g2_nand2b_1
XFILLER_138_42 VDD VSS sg13g2_decap_8
X_15204__3357 _15204_/RESET_B VDD VSS sg13g2_tiehi
X_13770__2794 _13770_/RESET_B VDD VSS sg13g2_tiehi
XFILLER_137_387 VDD VSS sg13g2_fill_1
X_13100_ _15039_/D _13093_/Y _13099_/Y _13266_/A VDD VSS sg13g2_a21oi_1
X_10312_ _14797_/D _10347_/B _10312_/B _10342_/C VDD VSS sg13g2_nor3_1
XFILLER_152_324 VDD VSS sg13g2_decap_8
XFILLER_98_35 VDD VSS sg13g2_decap_8
X_14080_ _14080_/Q clkload9/A _14080_/D _14080_/RESET_B VDD VSS sg13g2_dfrbpq_1
X_11292_ _11292_/Y _11292_/A _11292_/B VDD VSS sg13g2_xnor2_1
XFILLER_106_752 VDD VSS sg13g2_fill_1
X_13031_ _13031_/Y _13028_/Y _13029_/Y _13030_/Y VDD VSS sg13g2_a21oi_1
X_10243_ _10245_/C _14775_/Q wire762/X _14776_/Q VDD VSS sg13g2_a21oi_1
X_14721__1843 _14721_/RESET_B VDD VSS sg13g2_tiehi
XFILLER_79_603 VDD VSS sg13g2_fill_1
XFILLER_121_700 VDD VSS sg13g2_fill_2
XFILLER_156_1173 VDD VSS sg13g2_fill_2
XFILLER_133_582 VDD VSS sg13g2_decap_8
XFILLER_152_1015 VDD VSS sg13g2_decap_8
Xfanout1102 _12742_/S1 _12729_/S1 VDD VSS sg13g2_buf_1
XFILLER_78_124 VDD VSS sg13g2_fill_2
X_10174_ _10174_/Y _15055_/Q _15054_/Q _14748_/Q VDD VSS sg13g2_nor3_1
XFILLER_154_63 VDD VSS sg13g2_decap_8
Xfanout1113 _12759_/S1 _12754_/S1 VDD VSS sg13g2_buf_1
Xfanout1124 _12773_/S1 fanout1128/X VDD VSS sg13g2_buf_1
XFILLER_120_232 VDD VSS sg13g2_fill_2
XFILLER_94_606 VDD VSS sg13g2_fill_2
Xfanout1135 fanout1135/X _15211_/Q VDD VSS sg13g2_buf_1
XFILLER_117_1168 VDD VSS sg13g2_fill_2
XFILLER_121_766 VDD VSS sg13g2_decap_4
Xfanout1146 _12546_/S0 fanout1155/X VDD VSS sg13g2_buf_1
X_15166__2894 _15166_/RESET_B VDD VSS sg13g2_tiehi
X_14982_ _14982_/Q _15046_/CLK _14982_/D _14982_/RESET_B VDD VSS sg13g2_dfrbpq_1
Xfanout1168 _12561_/S0 _12754_/S0 VDD VSS sg13g2_buf_1
Xfanout170 _10165_/A1 _09138_/X VDD VSS sg13g2_buf_1
XFILLER_47_511 VDD VSS sg13g2_decap_4
Xfanout1179 _12480_/S0 _12758_/S0 VDD VSS sg13g2_buf_1
Xfanout181 _10030_/A0 _09126_/Y VDD VSS sg13g2_buf_1
XFILLER_87_680 VDD VSS sg13g2_fill_1
Xfanout192 _09929_/A1 _09111_/Y VDD VSS sg13g2_buf_1
XFILLER_87_691 VDD VSS sg13g2_decap_8
X_13933_ _13933_/Q clkload55/A _13933_/D _13933_/RESET_B VDD VSS sg13g2_dfrbpq_1
XFILLER_93_138 VDD VSS sg13g2_fill_2
X_13864_ _13864_/Q _15148_/CLK _13864_/D _13864_/RESET_B VDD VSS sg13g2_dfrbpq_1
XFILLER_62_514 VDD VSS sg13g2_fill_1
XFILLER_90_856 VDD VSS sg13g2_decap_4
X_12815_ _12815_/Y input15/X _12841_/B _12803_/X input35/X _12813_/X VDD VSS sg13g2_a221oi_1
X_13795_ _13795_/Q clkload2/A _13795_/D _13795_/RESET_B VDD VSS sg13g2_dfrbpq_1
XFILLER_31_901 VDD VSS sg13g2_decap_8
X_15191__3166 _15191_/RESET_B VDD VSS sg13g2_tiehi
X_12746_ _12746_/X _12739_/X _12743_/X _12738_/X _12742_/X _12497_/S _12746_/S1 VDD
+ VSS sg13g2_mux4_1
XFILLER_31_934 VDD VSS sg13g2_decap_8
XFILLER_72_1027 VDD VSS sg13g2_decap_4
XFILLER_97_7 VDD VSS sg13g2_fill_2
XFILLER_70_591 VDD VSS sg13g2_fill_1
X_12677_ _12677_/X _12675_/X _12674_/X _12668_/X _12669_/X _12788_/S0 _12720_/S VDD
+ VSS sg13g2_mux4_1
XFILLER_147_118 VDD VSS sg13g2_fill_2
XFILLER_30_466 VDD VSS sg13g2_decap_4
X_14416_ _14416_/Q clkload46/A _14416_/D _14416_/RESET_B VDD VSS sg13g2_dfrbpq_1
XFILLER_129_833 VDD VSS sg13g2_fill_1
X_11628_ _11628_/Y _11626_/Y _11627_/Y _12223_/A VDD VSS sg13g2_a21oi_1
XFILLER_8_77 VDD VSS sg13g2_decap_8
XFILLER_7_640 VDD VSS sg13g2_decap_8
XFILLER_155_140 VDD VSS sg13g2_decap_8
X_14347_ _14347_/Q _14731_/CLK _14347_/D _14347_/RESET_B VDD VSS sg13g2_dfrbpq_1
Xwire560 wire560/X wire560/A VDD VSS sg13g2_buf_2
X_11559_ _11559_/Y _11557_/Y _11559_/B _12263_/C VDD VSS sg13g2_nand3b_1
XFILLER_10_190 VDD VSS sg13g2_decap_4
Xwire582 wire582/X wire582/A VDD VSS sg13g2_buf_2
Xwire593 wire593/X wire593/A VDD VSS sg13g2_buf_2
X_14278_ _14278_/Q _14662_/CLK _14278_/D _14278_/RESET_B VDD VSS sg13g2_dfrbpq_1
XFILLER_48_1210 VDD VSS sg13g2_fill_1
XFILLER_83_1112 VDD VSS sg13g2_decap_8
X_13229_ _13232_/A wire182/X _13225_/X _13228_/Y VDD VSS sg13g2_a21oi_1
XFILLER_97_433 VDD VSS sg13g2_decap_8
XFILLER_111_221 VDD VSS sg13g2_decap_8
XFILLER_69_157 VDD VSS sg13g2_decap_8
XFILLER_69_168 VDD VSS sg13g2_fill_2
XFILLER_85_628 VDD VSS sg13g2_fill_2
XFILLER_111_265 VDD VSS sg13g2_decap_8
X_08770_ _08770_/Y _08779_/A1 _15118_/Q _15187_/Q _07719_/X VDD VSS sg13g2_a22oi_1
XFILLER_111_287 VDD VSS sg13g2_fill_1
XFILLER_19_0 VDD VSS sg13g2_decap_8
Xfanout1680 _12107_/S0 _11621_/S0 VDD VSS sg13g2_buf_1
X_07721_ _07735_/B _07721_/A _07721_/B _08032_/B VDD VSS sg13g2_nand3_1
Xfanout1691 _11733_/A1 _11759_/A VDD VSS sg13g2_buf_1
XFILLER_77_190 VDD VSS sg13g2_decap_8
X_15029__2943 _15029_/RESET_B VDD VSS sg13g2_tiehi
X_07652_ _07652_/Y _11202_/A VDD VSS sg13g2_inv_1
XFILLER_81_845 VDD VSS sg13g2_decap_8
XFILLER_20_1184 VDD VSS sg13g2_decap_8
XFILLER_41_709 VDD VSS sg13g2_decap_8
Xclkbuf_leaf_105_clk_i _15001_/CLK clkbuf_5_14__f_clk_i/X VDD VSS sg13g2_buf_8
X_09322_ _13929_/D _10152_/A1 _13929_/Q _09336_/S VDD VSS sg13g2_mux2_1
XFILLER_80_377 VDD VSS sg13g2_fill_2
XFILLER_22_923 VDD VSS sg13g2_fill_2
XFILLER_55_1236 VDD VSS sg13g2_fill_1
X_14753__3348 _14753_/RESET_B VDD VSS sg13g2_tiehi
XFILLER_61_591 VDD VSS sg13g2_fill_2
XFILLER_142_1217 VDD VSS sg13g2_decap_8
XFILLER_22_967 VDD VSS sg13g2_decap_8
X_09253_ _13862_/D _13862_/Q _10082_/A0 _09266_/S VDD VSS sg13g2_mux2_1
XFILLER_21_444 VDD VSS sg13g2_decap_8
XFILLER_21_455 VDD VSS sg13g2_fill_2
X_08204_ _08204_/Y _08001_/A _08247_/A _08542_/A2 VDD VSS sg13g2_o21ai_1
X_09184_ _13800_/D _13800_/Q _09787_/A0 _09200_/S VDD VSS sg13g2_mux2_1
XFILLER_88_1001 VDD VSS sg13g2_fill_2
X_08135_ _08135_/Y _08599_/A _08131_/Y _08134_/Y VDD VSS sg13g2_a21oi_1
X_14529__2035 _14529_/RESET_B VDD VSS sg13g2_tiehi
X_08066_ _08066_/Y _08066_/A VDD VSS sg13g2_inv_1
XFILLER_107_549 VDD VSS sg13g2_fill_1
XFILLER_49_1029 VDD VSS sg13g2_decap_8
XFILLER_150_806 VDD VSS sg13g2_decap_8
XFILLER_150_817 VDD VSS sg13g2_fill_2
XFILLER_89_923 VDD VSS sg13g2_decap_8
Xmax_cap882 _08625_/A _08514_/B VDD VSS sg13g2_buf_2
XFILLER_0_326 VDD VSS sg13g2_fill_2
XFILLER_115_593 VDD VSS sg13g2_decap_8
XFILLER_5_1101 VDD VSS sg13g2_decap_8
XFILLER_88_488 VDD VSS sg13g2_decap_4
XFILLER_102_265 VDD VSS sg13g2_fill_2
X_08968_ _08969_/A _15021_/Q _15218_/Q _09085_/B VDD VSS sg13g2_mux2_1
XFILLER_88_499 VDD VSS sg13g2_decap_4
XFILLER_102_298 VDD VSS sg13g2_decap_8
X_07919_ _07919_/Y _08160_/B _08160_/C _07871_/X VDD VSS sg13g2_o21ai_1
XFILLER_25_1095 VDD VSS sg13g2_decap_8
X_08899_ _08899_/Y _08897_/Y _08898_/Y _08955_/S VDD VSS sg13g2_a21oi_1
XFILLER_57_875 VDD VSS sg13g2_decap_4
XFILLER_5_1178 VDD VSS sg13g2_decap_8
XFILLER_84_59 VDD VSS sg13g2_decap_8
XFILLER_84_661 VDD VSS sg13g2_fill_1
XFILLER_99_1163 VDD VSS sg13g2_fill_1
X_10930_ _10946_/B _10936_/B _14757_/Q VDD VSS sg13g2_nand2_1
XFILLER_99_1174 VDD VSS sg13g2_fill_2
XFILLER_17_42 VDD VSS sg13g2_decap_8
XFILLER_140_21 VDD VSS sg13g2_decap_8
XFILLER_95_1038 VDD VSS sg13g2_decap_8
XFILLER_147_1117 VDD VSS sg13g2_decap_8
X_10861_ _14931_/D _10860_/Y _10859_/Y _10850_/Y VDD VSS sg13g2_o21ai_1
X_13788__2776 _13788_/RESET_B VDD VSS sg13g2_tiehi
X_12600_ _12600_/X _13741_/Q _14093_/Q _14445_/Q _14541_/Q _12603_/S0 _12604_/S1 VDD
+ VSS sg13g2_mux4_1
X_15169__2876 _15169_/RESET_B VDD VSS sg13g2_tiehi
XFILLER_140_98 VDD VSS sg13g2_fill_1
X_13580_ _13580_/Y _08306_/B _13589_/A2 _13569_/S _15016_/Q _13529_/X VDD VSS sg13g2_a221oi_1
X_10792_ _10792_/Y _14925_/Q _11196_/B VDD VSS sg13g2_nand2_1
X_14739__1825 _14739_/RESET_B VDD VSS sg13g2_tiehi
X_12531_ _12531_/X _14376_/Q _14408_/Q _14472_/Q _14504_/Q _12535_/S0 _12536_/S1 VDD
+ VSS sg13g2_mux4_1
XFILLER_13_978 VDD VSS sg13g2_decap_8
XFILLER_8_404 VDD VSS sg13g2_decap_8
XFILLER_36_1180 VDD VSS sg13g2_decap_8
XFILLER_71_1060 VDD VSS sg13g2_decap_8
X_15250_ _15250_/Q _15250_/CLK _15250_/D _15250_/RESET_B VDD VSS sg13g2_dfrbpq_1
XFILLER_138_630 VDD VSS sg13g2_fill_1
XFILLER_33_85 VDD VSS sg13g2_decap_8
X_12462_ _12462_/X _14243_/Q _14275_/Q _14307_/Q _14339_/Q _12494_/S0 _12494_/S1 VDD
+ VSS sg13g2_mux4_1
XFILLER_149_63 VDD VSS sg13g2_decap_8
XFILLER_138_641 VDD VSS sg13g2_fill_1
X_14168__2396 _14168_/RESET_B VDD VSS sg13g2_tiehi
X_14201_ _14201_/Q clkload43/A _14201_/D _14201_/RESET_B VDD VSS sg13g2_dfrbpq_1
XFILLER_123_0 VDD VSS sg13g2_decap_8
X_11413_ _11413_/X _11413_/A _11822_/B VDD VSS sg13g2_and2_1
X_15181_ _15181_/Q _15212_/CLK _15181_/D _15181_/RESET_B VDD VSS sg13g2_dfrbpq_1
XFILLER_126_814 VDD VSS sg13g2_decap_8
X_12393_ _12393_/X _14110_/Q _14142_/Q _14174_/Q _14206_/Q _12393_/S0 _12617_/S1 VDD
+ VSS sg13g2_mux4_1
XFILLER_126_825 VDD VSS sg13g2_fill_1
XFILLER_123_1194 VDD VSS sg13g2_fill_1
X_14132_ _14132_/Q clkload8/A _14132_/D _14132_/RESET_B VDD VSS sg13g2_dfrbpq_1
X_11344_ _11344_/Y _11353_/S _13886_/Q VDD VSS sg13g2_nand2b_1
XFILLER_99_709 VDD VSS sg13g2_fill_2
Xclkbuf_leaf_84_clk_i _15250_/CLK clkbuf_leaf_84_clk_i/A VDD VSS sg13g2_buf_8
XFILLER_126_869 VDD VSS sg13g2_fill_1
XFILLER_152_154 VDD VSS sg13g2_decap_8
XFILLER_125_368 VDD VSS sg13g2_fill_1
XFILLER_153_688 VDD VSS sg13g2_decap_8
X_14063_ _14063_/Q _14671_/CLK _14063_/D _14063_/RESET_B VDD VSS sg13g2_dfrbpq_1
XFILLER_98_219 VDD VSS sg13g2_decap_8
XFILLER_141_839 VDD VSS sg13g2_fill_2
X_11275_ _11275_/X _14236_/Q _14268_/Q _14300_/Q _14332_/Q _11275_/S0 _11262_/B VDD
+ VSS sg13g2_mux4_1
X_14383__2181 _14383_/RESET_B VDD VSS sg13g2_tiehi
X_13014_ _13014_/Y _14812_/Q _07728_/A _13094_/B1 _10511_/C _13082_/B VDD VSS sg13g2_a221oi_1
XFILLER_140_338 VDD VSS sg13g2_decap_8
X_10226_ _10237_/C _14767_/Q _14768_/Q _14769_/Q _14770_/Q VDD VSS sg13g2_nand4_1
XFILLER_121_541 VDD VSS sg13g2_decap_4
XFILLER_67_617 VDD VSS sg13g2_decap_8
X_10157_ _14734_/D _14734_/Q _10157_/A1 _10157_/S VDD VSS sg13g2_mux2_1
Xclkbuf_leaf_99_clk_i clkload27/A clkbuf_leaf_99_clk_i/A VDD VSS sg13g2_buf_8
XFILLER_94_403 VDD VSS sg13g2_fill_1
XFILLER_66_105 VDD VSS sg13g2_decap_8
XFILLER_0_882 VDD VSS sg13g2_fill_2
XFILLER_43_1140 VDD VSS sg13g2_decap_8
XFILLER_66_116 VDD VSS sg13g2_fill_2
XFILLER_94_425 VDD VSS sg13g2_decap_8
XFILLER_94_436 VDD VSS sg13g2_fill_2
XFILLER_12_7 VDD VSS sg13g2_decap_8
X_14965_ _14965_/Q clkload37/A _14965_/D _14965_/RESET_B VDD VSS sg13g2_dfrbpq_1
X_10088_ _14668_/D _10155_/A1 _14668_/Q _10093_/S VDD VSS sg13g2_mux2_1
XFILLER_78_1203 VDD VSS sg13g2_decap_8
X_14975__2997 _14975_/RESET_B VDD VSS sg13g2_tiehi
X_13916_ _13916_/Q clkload77/A _13916_/D _13916_/RESET_B VDD VSS sg13g2_dfrbpq_1
XFILLER_130_1165 VDD VSS sg13g2_decap_8
X_14846__3237 _14846_/RESET_B VDD VSS sg13g2_tiehi
X_14896_ _14896_/Q clkload62/A _14896_/D _14896_/RESET_B VDD VSS sg13g2_dfrbpq_1
Xclkbuf_leaf_22_clk_i clkload42/A clkbuf_leaf_30_clk_i/A VDD VSS sg13g2_buf_8
X_13847_ _13847_/Q clkload4/A _13847_/D _13847_/RESET_B VDD VSS sg13g2_dfrbpq_1
XFILLER_90_664 VDD VSS sg13g2_fill_2
XFILLER_16_783 VDD VSS sg13g2_fill_2
XFILLER_50_539 VDD VSS sg13g2_fill_2
X_13778_ _13778_/Q _14706_/CLK _13778_/D _13778_/RESET_B VDD VSS sg13g2_dfrbpq_1
XFILLER_31_720 VDD VSS sg13g2_decap_4
XFILLER_95_4 VDD VSS sg13g2_fill_2
Xclkbuf_leaf_37_clk_i clkload56/A clkbuf_leaf_38_clk_i/A VDD VSS sg13g2_buf_8
X_12729_ _12729_/X _13750_/Q _14102_/Q _14454_/Q _14550_/Q _12729_/S0 _12729_/S1 VDD
+ VSS sg13g2_mux4_1
XFILLER_31_786 VDD VSS sg13g2_decap_8
XFILLER_15_1220 VDD VSS sg13g2_decap_8
XFILLER_50_1133 VDD VSS sg13g2_decap_8
X_13833__2731 _13833_/RESET_B VDD VSS sg13g2_tiehi
X_14593__1971 _14593_/RESET_B VDD VSS sg13g2_tiehi
XFILLER_102_1212 VDD VSS sg13g2_decap_8
XFILLER_116_302 VDD VSS sg13g2_decap_8
X_15247__3400 _15247_/RESET_B VDD VSS sg13g2_tiehi
XFILLER_116_324 VDD VSS sg13g2_decap_8
XFILLER_128_184 VDD VSS sg13g2_decap_8
XFILLER_7_492 VDD VSS sg13g2_decap_8
XFILLER_128_195 VDD VSS sg13g2_fill_1
XFILLER_132_806 VDD VSS sg13g2_fill_2
X_09940_ _14524_/D _14524_/Q _10039_/A0 _09961_/S VDD VSS sg13g2_mux2_1
XFILLER_143_154 VDD VSS sg13g2_fill_2
XFILLER_132_839 VDD VSS sg13g2_decap_8
XFILLER_131_305 VDD VSS sg13g2_decap_8
XFILLER_144_699 VDD VSS sg13g2_fill_1
X_14213__2351 _14213_/RESET_B VDD VSS sg13g2_tiehi
Xfanout906 _12791_/C1 _12679_/C1 VDD VSS sg13g2_buf_1
Xfanout917 _13236_/A2 _07728_/X VDD VSS sg13g2_buf_1
XFILLER_98_753 VDD VSS sg13g2_fill_2
XFILLER_112_530 VDD VSS sg13g2_decap_4
X_09871_ _14458_/D _14458_/Q _09970_/A1 wire435/X VDD VSS sg13g2_mux2_1
X_13866__2698 _13866_/RESET_B VDD VSS sg13g2_tiehi
XFILLER_86_904 VDD VSS sg13g2_fill_2
Xfanout928 _10999_/B1 _07703_/Y VDD VSS sg13g2_buf_1
XFILLER_135_1043 VDD VSS sg13g2_fill_2
Xfanout939 _11521_/B2 _11431_/A1 VDD VSS sg13g2_buf_1
X_08822_ _08822_/Y _13691_/Q _13481_/C VDD VSS sg13g2_nor2_1
XFILLER_97_274 VDD VSS sg13g2_decap_8
XFILLER_85_425 VDD VSS sg13g2_fill_2
XFILLER_39_831 VDD VSS sg13g2_decap_8
X_08753_ _13669_/D _08753_/A1 _08751_/Y _08752_/Y VDD VSS sg13g2_a21oi_1
X_07704_ _07705_/A _15080_/Q _07694_/Y _15201_/Q _07697_/A VDD VSS sg13g2_a22oi_1
XFILLER_26_514 VDD VSS sg13g2_fill_1
X_08684_ _08684_/X _08684_/A _08684_/B VDD VSS sg13g2_xor2_1
XFILLER_66_694 VDD VSS sg13g2_fill_1
X_15203__3356 _15203_/RESET_B VDD VSS sg13g2_tiehi
XFILLER_26_536 VDD VSS sg13g2_decap_8
XFILLER_26_558 VDD VSS sg13g2_decap_8
XFILLER_54_867 VDD VSS sg13g2_decap_8
X_07635_ _07910_/A _14994_/Q VDD VSS sg13g2_inv_1
XFILLER_41_517 VDD VSS sg13g2_decap_8
XFILLER_55_1011 VDD VSS sg13g2_decap_8
XFILLER_81_697 VDD VSS sg13g2_decap_8
XFILLER_55_1044 VDD VSS sg13g2_decap_4
X_09305_ _13913_/D _13913_/Q _09705_/A0 _09306_/S VDD VSS sg13g2_mux2_1
XFILLER_94_1093 VDD VSS sg13g2_decap_8
XFILLER_107_1112 VDD VSS sg13g2_fill_2
XFILLER_70_28 VDD VSS sg13g2_decap_8
XFILLER_10_926 VDD VSS sg13g2_decap_8
X_09236_ _13847_/D _10166_/A1 _13847_/Q _09236_/S VDD VSS sg13g2_mux2_1
XFILLER_148_950 VDD VSS sg13g2_decap_8
XFILLER_148_983 VDD VSS sg13g2_decap_8
XFILLER_5_407 VDD VSS sg13g2_fill_1
X_09167_ _13786_/D _13786_/Q _10169_/A1 _09167_/S VDD VSS sg13g2_mux2_1
XFILLER_148_994 VDD VSS sg13g2_fill_2
XFILLER_107_313 VDD VSS sg13g2_decap_8
XFILLER_119_173 VDD VSS sg13g2_decap_8
X_08118_ _08145_/A _07904_/B _08116_/Y _08117_/Y VDD VSS sg13g2_o21ai_1
XFILLER_119_184 VDD VSS sg13g2_fill_1
XFILLER_134_121 VDD VSS sg13g2_fill_1
X_09098_ _09098_/Y _09090_/A _10747_/B _09097_/X VDD VSS sg13g2_o21ai_1
X_08049_ _08397_/B _08049_/A _08692_/B VDD VSS sg13g2_nor2b_1
XFILLER_134_176 VDD VSS sg13g2_decap_4
XFILLER_135_21 VDD VSS sg13g2_decap_8
XFILLER_66_1151 VDD VSS sg13g2_fill_1
XFILLER_1_635 VDD VSS sg13g2_decap_8
X_11060_ _11060_/X _11064_/C _11064_/D VDD VSS sg13g2_and2_1
XFILLER_153_1121 VDD VSS sg13g2_decap_8
XFILLER_27_1124 VDD VSS sg13g2_decap_8
XFILLER_0_134 VDD VSS sg13g2_decap_4
XFILLER_66_1184 VDD VSS sg13g2_decap_8
XFILLER_88_241 VDD VSS sg13g2_decap_8
X_10011_ _14593_/D _10077_/A0 _14593_/Q _10020_/S VDD VSS sg13g2_mux2_1
XFILLER_103_563 VDD VSS sg13g2_decap_8
XFILLER_7_1229 VDD VSS sg13g2_decap_8
XFILLER_153_1198 VDD VSS sg13g2_decap_8
XFILLER_114_1149 VDD VSS sg13g2_fill_1
XFILLER_151_42 VDD VSS sg13g2_decap_8
XFILLER_63_119 VDD VSS sg13g2_fill_2
X_14750_ _14750_/Q _15214_/CLK _14750_/D _14750_/RESET_B VDD VSS sg13g2_dfrbpq_1
XFILLER_57_683 VDD VSS sg13g2_fill_2
X_11962_ _11962_/Y _11958_/Y _11959_/Y _11961_/Y _11960_/Y _11973_/B VDD VSS sg13g2_a221oi_1
XFILLER_84_480 VDD VSS sg13g2_fill_2
X_13911__2653 _13911_/RESET_B VDD VSS sg13g2_tiehi
X_13701_ _16863_/A clkload17/A _13701_/D _13701_/RESET_B VDD VSS sg13g2_dfrbpq_1
X_14671__1893 _14671_/RESET_B VDD VSS sg13g2_tiehi
X_10913_ _14935_/D _10912_/Y _10911_/Y _10903_/Y VDD VSS sg13g2_o21ai_1
XFILLER_44_344 VDD VSS sg13g2_decap_8
X_14681_ _14681_/Q _14745_/CLK _14681_/D _14681_/RESET_B VDD VSS sg13g2_dfrbpq_1
X_11893_ _11893_/X _14126_/Q _14158_/Q _11896_/A VDD VSS sg13g2_mux2_1
X_13632_ _13740_/D _13632_/A VDD VSS sg13g2_buf_1
X_10844_ _10897_/D _10844_/A _10844_/B _10851_/D _10851_/C VDD VSS sg13g2_nand4_1
XFILLER_13_742 VDD VSS sg13g2_decap_4
X_13563_ _13563_/Y _15010_/Q _13566_/B _13563_/C VDD VSS sg13g2_nor3_1
X_14255__2309 _14255_/RESET_B VDD VSS sg13g2_tiehi
XFILLER_13_764 VDD VSS sg13g2_decap_8
X_10775_ _14920_/D _11168_/B1 _11163_/A _10774_/Y VDD VSS sg13g2_o21ai_1
X_12514_ _12527_/A _10213_/A _07737_/B _08351_/B VDD VSS sg13g2_a21oi_1
XFILLER_13_797 VDD VSS sg13g2_decap_8
XFILLER_12_274 VDD VSS sg13g2_decap_8
X_13494_ _13494_/Y _15071_/Q _13494_/B VDD VSS sg13g2_nor2_1
X_15233_ _15233_/Q _15248_/CLK _15233_/D _15233_/RESET_B VDD VSS sg13g2_dfrbpq_1
X_12445_ _12445_/X _14562_/Q _14594_/Q _14626_/Q _14658_/Q _12548_/S0 _12550_/S1 VDD
+ VSS sg13g2_mux4_1
XFILLER_154_931 VDD VSS sg13g2_decap_8
X_15164_ _15164_/Q clkload67/A _15164_/D _15164_/RESET_B VDD VSS sg13g2_dfrbpq_1
X_12376_ _12376_/X _13725_/Q _14077_/Q _14429_/Q _14525_/Q _12411_/S0 _12411_/S1 VDD
+ VSS sg13g2_mux4_1
XFILLER_125_121 VDD VSS sg13g2_decap_4
XFILLER_126_655 VDD VSS sg13g2_fill_1
X_14115_ _14115_/Q clkload0/A _14115_/D _14115_/RESET_B VDD VSS sg13g2_dfrbpq_1
XFILLER_10_1150 VDD VSS sg13g2_decap_8
XFILLER_99_517 VDD VSS sg13g2_fill_2
XFILLER_153_474 VDD VSS sg13g2_decap_8
X_11327_ _11327_/Y _11322_/Y _11323_/Y _11395_/B VDD VSS sg13g2_a21oi_1
XFILLER_5_985 VDD VSS sg13g2_decap_8
XFILLER_114_828 VDD VSS sg13g2_fill_2
XFILLER_5_56 VDD VSS sg13g2_decap_8
X_15095_ _15095_/Q clkload66/A _15095_/D _15095_/RESET_B VDD VSS sg13g2_dfrbpq_1
XFILLER_99_539 VDD VSS sg13g2_decap_8
XFILLER_141_647 VDD VSS sg13g2_fill_1
X_14046_ _14046_/Q _14494_/CLK _14046_/D _14046_/RESET_B VDD VSS sg13g2_dfrbpq_1
X_11258_ _11258_/Y _11256_/Y _11255_/Y _11283_/B _11257_/X VDD VSS sg13g2_a22oi_1
XFILLER_68_926 VDD VSS sg13g2_decap_8
XFILLER_132_1205 VDD VSS sg13g2_decap_8
X_10209_ _14762_/D _13239_/A wire847/X _10209_/C VDD VSS sg13g2_nor3_1
X_11189_ _11189_/Y _11190_/C _11190_/A _11199_/B VDD VSS sg13g2_o21ai_1
XFILLER_95_756 VDD VSS sg13g2_decap_8
XFILLER_76_981 VDD VSS sg13g2_fill_2
X_14948_ _14948_/Q clkload18/A _14948_/D _14948_/RESET_B VDD VSS sg13g2_dfrbpq_1
XFILLER_75_480 VDD VSS sg13g2_decap_4
XFILLER_39_1006 VDD VSS sg13g2_fill_2
X_14879_ _14879_/Q clkload78/A _14879_/D _14879_/RESET_B VDD VSS sg13g2_dfrbpq_1
XFILLER_62_130 VDD VSS sg13g2_fill_2
XFILLER_91_973 VDD VSS sg13g2_fill_2
XFILLER_23_506 VDD VSS sg13g2_decap_8
XFILLER_36_889 VDD VSS sg13g2_decap_8
XFILLER_63_686 VDD VSS sg13g2_decap_8
XFILLER_50_358 VDD VSS sg13g2_fill_2
XFILLER_52_1217 VDD VSS sg13g2_fill_2
XFILLER_86_0 VDD VSS sg13g2_decap_8
X_09021_ _09021_/X _15031_/Q _15228_/Q _09034_/S VDD VSS sg13g2_mux2_1
XFILLER_15_1094 VDD VSS sg13g2_decap_8
XFILLER_102_1053 VDD VSS sg13g2_fill_1
XFILLER_144_463 VDD VSS sg13g2_decap_8
XFILLER_105_817 VDD VSS sg13g2_decap_8
XFILLER_145_997 VDD VSS sg13g2_decap_8
XFILLER_144_474 VDD VSS sg13g2_fill_2
XFILLER_131_113 VDD VSS sg13g2_decap_8
X_09923_ _14508_/D _14508_/Q _09923_/A1 _09936_/S VDD VSS sg13g2_mux2_1
Xfanout703 _10075_/A0 _09910_/A1 VDD VSS sg13g2_buf_1
XFILLER_86_701 VDD VSS sg13g2_decap_4
Xfanout725 _13499_/A _10206_/S VDD VSS sg13g2_buf_1
Xfanout736 _13568_/S _13551_/S VDD VSS sg13g2_buf_1
X_09854_ _14441_/D _14441_/Q _10085_/A0 _09868_/S VDD VSS sg13g2_mux2_1
Xfanout747 _12679_/A2 _12791_/A2 VDD VSS sg13g2_buf_1
Xfanout769 _10105_/A _10139_/A1 VDD VSS sg13g2_buf_1
XFILLER_105_35 VDD VSS sg13g2_decap_8
X_08805_ _13686_/D _08805_/A _08805_/B VDD VSS sg13g2_nor2_1
XFILLER_85_233 VDD VSS sg13g2_decap_4
XFILLER_100_533 VDD VSS sg13g2_decap_8
XFILLER_74_907 VDD VSS sg13g2_fill_1
X_09785_ _14374_/D _09884_/A0 _14374_/Q _09798_/S VDD VSS sg13g2_mux2_1
XFILLER_61_1070 VDD VSS sg13g2_decap_8
X_14479__2085 _14479_/RESET_B VDD VSS sg13g2_tiehi
XFILLER_65_39 VDD VSS sg13g2_decap_8
XFILLER_67_981 VDD VSS sg13g2_fill_1
XFILLER_2_1115 VDD VSS sg13g2_decap_8
X_08736_ _08736_/Y _08751_/A1 _08751_/A2 _15198_/Q VDD VSS sg13g2_o21ai_1
XFILLER_22_1065 VDD VSS sg13g2_decap_8
XFILLER_113_1182 VDD VSS sg13g2_decap_8
X_08667_ _15247_/D _08685_/A1 _08666_/X _08661_/X VDD VSS sg13g2_o21ai_1
X_15193__3158 _15193_/RESET_B VDD VSS sg13g2_tiehi
XFILLER_81_450 VDD VSS sg13g2_fill_1
XFILLER_57_1128 VDD VSS sg13g2_decap_8
XFILLER_54_686 VDD VSS sg13g2_fill_2
X_07618_ _09011_/B _14901_/Q VDD VSS sg13g2_inv_1
X_08598_ _08599_/C _08635_/A2 _08635_/A3 _08620_/A3 _08598_/A3 _08598_/S0 _08598_/S1
+ VDD VSS sg13g2_mux4_1
XFILLER_109_1229 VDD VSS sg13g2_decap_8
XFILLER_14_21 VDD VSS sg13g2_decap_8
XFILLER_22_561 VDD VSS sg13g2_fill_2
XFILLER_10_723 VDD VSS sg13g2_fill_1
X_10560_ _10561_/D _14868_/Q _14867_/Q _14866_/Q _14865_/Q VDD VSS sg13g2_nand4_1
XFILLER_14_98 VDD VSS sg13g2_decap_8
XFILLER_127_408 VDD VSS sg13g2_decap_8
X_09219_ _13830_/D _10082_/A0 _13830_/Q _09236_/S VDD VSS sg13g2_mux2_1
X_10491_ _10493_/A _10513_/D _10498_/D _10496_/B VDD VSS sg13g2_o21ai_1
XFILLER_154_238 VDD VSS sg13g2_decap_8
X_12230_ _12231_/B _12272_/A _12204_/A _12274_/A VDD VSS sg13g2_o21ai_1
XFILLER_30_42 VDD VSS sg13g2_fill_2
XFILLER_151_901 VDD VSS sg13g2_decap_8
XFILLER_107_143 VDD VSS sg13g2_fill_2
XFILLER_135_463 VDD VSS sg13g2_decap_8
XFILLER_155_1205 VDD VSS sg13g2_decap_8
XFILLER_146_42 VDD VSS sg13g2_decap_8
X_12161_ _12161_/Y _12157_/Y _12158_/Y _12160_/Y _12159_/Y _12172_/B VDD VSS sg13g2_a221oi_1
X_13929__2635 _13929_/RESET_B VDD VSS sg13g2_tiehi
XFILLER_151_956 VDD VSS sg13g2_fill_1
X_14689__1875 _14689_/RESET_B VDD VSS sg13g2_tiehi
X_11112_ _14949_/D _11111_/Y _11110_/Y _11102_/Y VDD VSS sg13g2_o21ai_1
XFILLER_2_955 VDD VSS sg13g2_decap_4
XFILLER_150_455 VDD VSS sg13g2_decap_8
X_12092_ _12092_/Y _12092_/A _12092_/B _12092_/C VDD VSS sg13g2_nand3_1
XFILLER_104_850 VDD VSS sg13g2_decap_8
XFILLER_104_872 VDD VSS sg13g2_fill_1
X_11043_ _11044_/B _11043_/A _11043_/B _11078_/D VDD VSS sg13g2_nand3_1
XFILLER_49_414 VDD VSS sg13g2_decap_4
XFILLER_77_723 VDD VSS sg13g2_decap_8
XFILLER_103_393 VDD VSS sg13g2_fill_2
X_14309__2255 _14309_/RESET_B VDD VSS sg13g2_tiehi
X_14802_ _14802_/Q clkload80/A _14802_/D _14802_/RESET_B VDD VSS sg13g2_dfrbpq_1
XFILLER_58_981 VDD VSS sg13g2_decap_4
XFILLER_18_834 VDD VSS sg13g2_decap_8
X_12994_ _13010_/A _12994_/A _13058_/D VDD VSS sg13g2_nand2_1
X_14733_ _14733_/Q clkload55/A _14733_/D _14733_/RESET_B VDD VSS sg13g2_dfrbpq_1
XFILLER_55_50 VDD VSS sg13g2_decap_8
X_11945_ _11946_/A _13968_/Q _14000_/Q _14032_/Q _14064_/Q _11951_/A _11970_/C VDD
+ VSS sg13g2_mux4_1
XFILLER_55_72 VDD VSS sg13g2_fill_1
XFILLER_44_152 VDD VSS sg13g2_fill_1
XFILLER_32_303 VDD VSS sg13g2_decap_8
X_14664_ _14664_/Q clkload27/A _14664_/D _14664_/RESET_B VDD VSS sg13g2_dfrbpq_1
XFILLER_44_174 VDD VSS sg13g2_decap_8
X_11876_ _11876_/Y _11873_/Y _11875_/X _11224_/A VDD VSS sg13g2_o21ai_1
X_14524__2040 _14524_/RESET_B VDD VSS sg13g2_tiehi
X_13615_ _13723_/D _13615_/A VDD VSS sg13g2_buf_1
X_10827_ _10831_/A _12347_/B _10827_/B VDD VSS sg13g2_nand2b_1
X_14595_ _14595_/Q clkload1/A _14595_/D _14595_/RESET_B VDD VSS sg13g2_dfrbpq_1
XFILLER_38_1083 VDD VSS sg13g2_decap_4
XFILLER_9_521 VDD VSS sg13g2_fill_2
X_13546_ _13546_/Y _13545_/A _12936_/B _08383_/B _13546_/B2 VDD VSS sg13g2_a22oi_1
XFILLER_41_892 VDD VSS sg13g2_decap_8
XFILLER_71_71 VDD VSS sg13g2_decap_8
XFILLER_13_594 VDD VSS sg13g2_decap_8
X_10758_ _11086_/B _14948_/Q _10757_/A _10757_/Y VDD VSS sg13g2_a21oi_1
X_14778__3320 _14778_/RESET_B VDD VSS sg13g2_tiehi
XFILLER_146_717 VDD VSS sg13g2_fill_2
XFILLER_9_576 VDD VSS sg13g2_decap_8
X_13477_ _15179_/D hold3409/X _15179_/Q _13479_/S VDD VSS sg13g2_mux2_1
X_10689_ _10689_/Y _14899_/Q _10929_/B VDD VSS sg13g2_nand2_1
Xmax_cap1543 output58/A _16882_/A VDD VSS sg13g2_buf_4
X_15216_ _15216_/Q clkload66/A _15216_/D _15216_/RESET_B VDD VSS sg13g2_dfrbpq_1
Xmax_cap1554 _16871_/A _13709_/Q VDD VSS sg13g2_buf_8
X_12428_ _12428_/X _12426_/X _12427_/X _12636_/S VDD VSS sg13g2_mux2_1
X_15125__3094 _15125_/RESET_B VDD VSS sg13g2_tiehi
X_15079__3220 _15079_/RESET_B VDD VSS sg13g2_tiehi
XFILLER_126_452 VDD VSS sg13g2_decap_4
X_15202__3355 _15202_/RESET_B VDD VSS sg13g2_tiehi
X_15147_ _15147_/Q _15148_/CLK _15147_/D _15147_/RESET_B VDD VSS sg13g2_dfrbpq_1
X_12359_ _12359_/Y _15119_/Q _12348_/A _12679_/A2 _15123_/Q _12638_/A2 VDD VSS sg13g2_a221oi_1
XFILLER_141_411 VDD VSS sg13g2_decap_8
XFILLER_114_636 VDD VSS sg13g2_decap_8
X_15078_ _15078_/Q clkload69/A _15078_/D _15078_/RESET_B VDD VSS sg13g2_dfrbpq_1
XFILLER_87_509 VDD VSS sg13g2_fill_2
X_14029_ _14029_/Q _14669_/CLK _14029_/D _14029_/RESET_B VDD VSS sg13g2_dfrbpq_1
XFILLER_136_1160 VDD VSS sg13g2_decap_8
XFILLER_132_1002 VDD VSS sg13g2_fill_2
XFILLER_110_820 VDD VSS sg13g2_decap_8
X_13783__2781 _13783_/RESET_B VDD VSS sg13g2_tiehi
XFILLER_45_1087 VDD VSS sg13g2_fill_2
XFILLER_95_542 VDD VSS sg13g2_decap_8
XFILLER_95_575 VDD VSS sg13g2_decap_8
XFILLER_95_586 VDD VSS sg13g2_fill_2
X_14734__1830 _14734_/RESET_B VDD VSS sg13g2_tiehi
X_09570_ _14168_/D _09902_/A0 _14168_/Q wire653/X VDD VSS sg13g2_mux2_1
XFILLER_48_480 VDD VSS sg13g2_fill_2
X_08521_ _08521_/X _08279_/A _08362_/X _08457_/X _08597_/C _08597_/B _08329_/B VDD
+ VSS sg13g2_mux4_1
XFILLER_35_130 VDD VSS sg13g2_fill_1
XFILLER_35_141 VDD VSS sg13g2_decap_8
XFILLER_36_686 VDD VSS sg13g2_fill_2
XFILLER_51_612 VDD VSS sg13g2_decap_8
XFILLER_64_995 VDD VSS sg13g2_decap_4
XFILLER_36_697 VDD VSS sg13g2_decap_8
X_08452_ _08461_/A _08452_/A _08452_/B _08452_/C _08452_/D VDD VSS sg13g2_nand4_1
XFILLER_35_185 VDD VSS sg13g2_decap_8
XFILLER_24_859 VDD VSS sg13g2_fill_2
XFILLER_90_280 VDD VSS sg13g2_decap_4
X_08383_ _08412_/B _08383_/A _08383_/B VDD VSS sg13g2_nor2_1
XFILLER_143_1131 VDD VSS sg13g2_decap_8
XFILLER_17_1134 VDD VSS sg13g2_decap_8
XFILLER_56_1183 VDD VSS sg13g2_decap_4
XFILLER_143_1142 VDD VSS sg13g2_fill_1
XFILLER_56_1194 VDD VSS sg13g2_fill_2
XFILLER_91_1074 VDD VSS sg13g2_decap_4
XFILLER_91_1096 VDD VSS sg13g2_decap_8
XFILLER_149_566 VDD VSS sg13g2_decap_8
XFILLER_52_1058 VDD VSS sg13g2_fill_1
XFILLER_104_1137 VDD VSS sg13g2_decap_8
X_09004_ _09006_/B _14900_/Q _08993_/X _14901_/Q VDD VSS sg13g2_a21oi_1
XFILLER_105_614 VDD VSS sg13g2_decap_8
XFILLER_132_400 VDD VSS sg13g2_decap_8
XFILLER_117_485 VDD VSS sg13g2_decap_8
XFILLER_132_422 VDD VSS sg13g2_decap_4
Xfanout511 _09199_/S _09196_/S VDD VSS sg13g2_buf_1
XFILLER_59_701 VDD VSS sg13g2_decap_4
XFILLER_63_1121 VDD VSS sg13g2_decap_8
Xfanout1509 _13168_/A _14918_/Q VDD VSS sg13g2_buf_1
Xfanout522 _09650_/A0 _09914_/A1 VDD VSS sg13g2_buf_1
XFILLER_63_1132 VDD VSS sg13g2_fill_1
XFILLER_99_881 VDD VSS sg13g2_decap_8
X_09906_ _14491_/D _14491_/Q _09906_/A1 _09907_/S VDD VSS sg13g2_mux2_1
Xfanout533 _09447_/A0 wire537/X VDD VSS sg13g2_buf_1
XFILLER_76_16 VDD VSS sg13g2_fill_1
Xfanout544 _09038_/S _09127_/S VDD VSS sg13g2_buf_1
XFILLER_115_1233 VDD VSS sg13g2_decap_4
XFILLER_24_1127 VDD VSS sg13g2_decap_8
X_09837_ _14425_/D _10135_/A0 _14425_/Q _09838_/S VDD VSS sg13g2_mux2_1
XFILLER_47_918 VDD VSS sg13g2_decap_8
XFILLER_150_1157 VDD VSS sg13g2_decap_8
XFILLER_98_1228 VDD VSS sg13g2_decap_8
X_09768_ _14358_/D _14358_/Q _09900_/A0 _09770_/S VDD VSS sg13g2_mux2_1
XFILLER_73_225 VDD VSS sg13g2_decap_8
XFILLER_132_77 VDD VSS sg13g2_decap_8
X_08719_ _15192_/D hold3439/X _15192_/Q _10205_/S VDD VSS sg13g2_mux2_1
XFILLER_55_962 VDD VSS sg13g2_fill_1
X_09699_ _14291_/D _09930_/A1 _14291_/Q wire456/X VDD VSS sg13g2_mux2_1
XFILLER_27_675 VDD VSS sg13g2_fill_2
XFILLER_26_152 VDD VSS sg13g2_decap_8
XFILLER_148_1042 VDD VSS sg13g2_decap_8
X_11730_ _11730_/Y _11733_/A1 _14122_/Q VDD VSS sg13g2_nand2b_1
XFILLER_42_623 VDD VSS sg13g2_decap_8
XFILLER_82_792 VDD VSS sg13g2_decap_8
XFILLER_148_1064 VDD VSS sg13g2_fill_1
XFILLER_25_42 VDD VSS sg13g2_decap_8
XFILLER_15_859 VDD VSS sg13g2_fill_2
XFILLER_41_133 VDD VSS sg13g2_decap_8
XFILLER_35_1201 VDD VSS sg13g2_decap_8
X_11661_ _11773_/B _11661_/A _13680_/Q VDD VSS sg13g2_xnor2_1
XFILLER_23_870 VDD VSS sg13g2_decap_8
X_13400_ _13400_/Y _13440_/A _13425_/A _15088_/Q VDD VSS sg13g2_nand3_1
X_10612_ _10614_/B _14880_/Q _14879_/Q VDD VSS sg13g2_nand2_1
X_14380_ _14380_/Q clkload54/A _14380_/D _14380_/RESET_B VDD VSS sg13g2_dfrbpq_1
X_11592_ _11593_/B _11570_/A _13683_/Q _11571_/Y VDD VSS sg13g2_a21oi_1
XFILLER_128_706 VDD VSS sg13g2_decap_8
XFILLER_31_1109 VDD VSS sg13g2_fill_2
X_13331_ _15173_/D _13502_/B VDD VSS sg13g2_inv_1
XFILLER_6_502 VDD VSS sg13g2_fill_2
X_10543_ _10544_/B _14863_/Q _13273_/A _10543_/C _10543_/D VDD VSS sg13g2_nand4_1
XFILLER_41_85 VDD VSS sg13g2_decap_8
X_13262_ _13262_/Y _14797_/Q _13275_/A2 _13262_/B1 VDD VSS sg13g2_o21ai_1
X_10474_ _10474_/Y _10504_/C _10492_/C _10496_/B VDD VSS sg13g2_o21ai_1
XFILLER_109_964 VDD VSS sg13g2_decap_8
X_15001_ _15001_/Q _15001_/CLK _15001_/D _15001_/RESET_B VDD VSS sg13g2_dfrbpq_1
X_12213_ _12213_/X _14135_/Q _14167_/Q _14199_/Q _14231_/Q _12213_/S0 _12169_/C VDD
+ VSS sg13g2_mux4_1
X_13193_ _13196_/A _14792_/Q _13193_/B VDD VSS sg13g2_nand2_1
XFILLER_124_956 VDD VSS sg13g2_fill_2
XFILLER_68_1076 VDD VSS sg13g2_decap_8
XFILLER_68_1087 VDD VSS sg13g2_fill_1
X_12144_ _12144_/Y _12292_/A _12144_/B VDD VSS sg13g2_nor2_1
XFILLER_69_509 VDD VSS sg13g2_fill_2
XFILLER_111_617 VDD VSS sg13g2_decap_4
X_12075_ _12077_/B _12075_/A _12075_/B VDD VSS sg13g2_nor2_1
XFILLER_89_380 VDD VSS sg13g2_decap_4
XFILLER_104_680 VDD VSS sg13g2_decap_8
XFILLER_49_222 VDD VSS sg13g2_decap_8
XFILLER_104_691 VDD VSS sg13g2_fill_2
XFILLER_2_35 VDD VSS sg13g2_decap_8
X_11026_ _11029_/A _11022_/Y _11064_/B _11025_/Y VDD VSS sg13g2_o21ai_1
XFILLER_38_918 VDD VSS sg13g2_decap_8
X_16883_ _16883_/X _16883_/A VDD VSS sg13g2_buf_1
XFILLER_92_534 VDD VSS sg13g2_decap_8
XFILLER_79_1150 VDD VSS sg13g2_fill_1
X_12977_ _12977_/Y _14810_/Q _13068_/B _12963_/B _14874_/Q _13193_/B VDD VSS sg13g2_a221oi_1
XFILLER_18_664 VDD VSS sg13g2_decap_8
XFILLER_45_450 VDD VSS sg13g2_decap_8
XFILLER_79_1172 VDD VSS sg13g2_fill_1
XFILLER_17_163 VDD VSS sg13g2_decap_8
XFILLER_73_781 VDD VSS sg13g2_decap_8
X_14716_ _14716_/Q clkload75/A _14716_/D _14716_/RESET_B VDD VSS sg13g2_dfrbpq_1
XFILLER_33_623 VDD VSS sg13g2_fill_2
X_11928_ _11928_/X _11920_/X _11921_/X _11923_/X _11922_/X _11928_/S0 _12076_/S1 VDD
+ VSS sg13g2_mux4_1
X_14647_ _14647_/Q clkload3/A _14647_/D _14647_/RESET_B VDD VSS sg13g2_dfrbpq_1
X_14911__3107 _14911_/RESET_B VDD VSS sg13g2_tiehi
X_11859_ wire301/A _11330_/S _11857_/X _11858_/Y VDD VSS sg13g2_o21ai_1
XFILLER_21_818 VDD VSS sg13g2_fill_2
XFILLER_82_92 VDD VSS sg13g2_decap_8
XFILLER_127_1159 VDD VSS sg13g2_decap_8
XFILLER_14_870 VDD VSS sg13g2_decap_8
XFILLER_14_881 VDD VSS sg13g2_fill_2
X_14578_ _14578_/Q _14706_/CLK _14578_/D _14578_/RESET_B VDD VSS sg13g2_dfrbpq_1
XFILLER_146_503 VDD VSS sg13g2_decap_8
X_13529_ _13529_/X _13529_/A _13537_/B VDD VSS sg13g2_and2_1
XFILLER_118_205 VDD VSS sg13g2_decap_8
XFILLER_118_216 VDD VSS sg13g2_fill_2
XFILLER_12_1031 VDD VSS sg13g2_decap_4
XFILLER_12_1053 VDD VSS sg13g2_decap_8
XFILLER_127_761 VDD VSS sg13g2_decap_4
XFILLER_103_1181 VDD VSS sg13g2_fill_1
Xoutput103 mem_axi_rready _07658_/X VDD VSS sg13g2_buf_1
Xmax_cap1395 _08055_/S0 _08005_/S0 VDD VSS sg13g2_buf_4
Xoutput114 mem_axi_wdata[19] _15151_/Q VDD VSS sg13g2_buf_1
XFILLER_99_100 VDD VSS sg13g2_fill_1
XFILLER_154_580 VDD VSS sg13g2_fill_1
Xoutput125 mem_axi_wdata[29] _15161_/Q VDD VSS sg13g2_buf_1
XFILLER_86_1154 VDD VSS sg13g2_decap_8
XFILLER_114_411 VDD VSS sg13g2_decap_4
XFILLER_126_271 VDD VSS sg13g2_decap_8
Xoutput136 mem_axi_wstrb[0] _15164_/Q VDD VSS sg13g2_buf_1
XFILLER_99_122 VDD VSS sg13g2_decap_8
XFILLER_126_282 VDD VSS sg13g2_fill_1
XFILLER_86_1165 VDD VSS sg13g2_fill_1
XFILLER_115_956 VDD VSS sg13g2_decap_8
XFILLER_126_293 VDD VSS sg13g2_decap_8
XFILLER_49_0 VDD VSS sg13g2_decap_8
XFILLER_86_1176 VDD VSS sg13g2_decap_8
X_14035__2529 _14035_/RESET_B VDD VSS sg13g2_tiehi
XFILLER_86_1187 VDD VSS sg13g2_fill_1
XFILLER_142_764 VDD VSS sg13g2_fill_2
XFILLER_47_1149 VDD VSS sg13g2_decap_8
XFILLER_86_1198 VDD VSS sg13g2_decap_4
XFILLER_88_818 VDD VSS sg13g2_decap_8
XFILLER_99_177 VDD VSS sg13g2_decap_8
X_07952_ _07952_/Y _15009_/Q _07821_/B VDD VSS sg13g2_nor2b_1
XFILLER_102_639 VDD VSS sg13g2_decap_8
XFILLER_29_907 VDD VSS sg13g2_decap_8
X_07883_ _08073_/C _07884_/A _08023_/B VDD VSS sg13g2_nand2_1
X_09622_ _14218_/D _09888_/A0 _14218_/Q _09622_/S VDD VSS sg13g2_mux2_1
XFILLER_68_586 VDD VSS sg13g2_decap_8
X_14250__2314 _14250_/RESET_B VDD VSS sg13g2_tiehi
XFILLER_23_1182 VDD VSS sg13g2_decap_8
X_09553_ _14151_/D _10083_/A0 _14151_/Q _09553_/S VDD VSS sg13g2_mux2_1
XFILLER_83_567 VDD VSS sg13g2_fill_1
XFILLER_83_578 VDD VSS sg13g2_fill_2
XFILLER_102_14 VDD VSS sg13g2_decap_8
XFILLER_58_1212 VDD VSS sg13g2_decap_8
XFILLER_93_1103 VDD VSS sg13g2_fill_2
X_08504_ _08504_/Y _15009_/Q _07819_/B _08229_/B VDD VSS sg13g2_a21oi_1
X_09484_ _14084_/D _10080_/A0 _14084_/Q _09490_/S VDD VSS sg13g2_mux2_1
XFILLER_54_1109 VDD VSS sg13g2_fill_1
X_08435_ _08435_/Y _08435_/A _08442_/B VDD VSS sg13g2_nand2_1
X_14988__2984 _14988_/RESET_B VDD VSS sg13g2_tiehi
XFILLER_51_486 VDD VSS sg13g2_decap_8
XFILLER_23_188 VDD VSS sg13g2_fill_2
X_08366_ _08366_/X _08414_/D _08414_/A _08414_/B _08366_/D VDD VSS sg13g2_or4_1
Xwire208 wire208/X wire208/A VDD VSS sg13g2_buf_2
X_08297_ _08297_/Y _08369_/B _08294_/Y _08296_/Y _08295_/Y VDD VSS sg13g2_a22oi_1
XFILLER_127_7 VDD VSS sg13g2_decap_8
XFILLER_109_238 VDD VSS sg13g2_fill_1
X_15056__2892 _15056_/RESET_B VDD VSS sg13g2_tiehi
XFILLER_3_505 VDD VSS sg13g2_decap_8
XFILLER_106_923 VDD VSS sg13g2_fill_1
XFILLER_30_1186 VDD VSS sg13g2_decap_8
XFILLER_11_77 VDD VSS sg13g2_decap_8
X_10190_ _14752_/D _15195_/D _14752_/Q _13653_/S VDD VSS sg13g2_mux2_1
XFILLER_127_77 VDD VSS sg13g2_decap_8
XFILLER_121_937 VDD VSS sg13g2_fill_1
XFILLER_78_328 VDD VSS sg13g2_decap_8
XFILLER_121_948 VDD VSS sg13g2_fill_1
Xfanout1306 _10105_/C _15066_/Q VDD VSS sg13g2_buf_1
Xfanout1317 _09147_/B _09155_/A1 VDD VSS sg13g2_buf_1
Xfanout330 _09587_/S wire337/X VDD VSS sg13g2_buf_1
XFILLER_8_1132 VDD VSS sg13g2_decap_8
Xfanout1328 _08977_/C _15058_/Q VDD VSS sg13g2_buf_1
XFILLER_143_21 VDD VSS sg13g2_decap_8
Xfanout1339 _13555_/A _15007_/Q VDD VSS sg13g2_buf_1
XFILLER_87_840 VDD VSS sg13g2_fill_1
XFILLER_28_1082 VDD VSS sg13g2_decap_8
Xfanout352 _09616_/A0 _10080_/A0 VDD VSS sg13g2_buf_1
Xwire1401 _13517_/A wire1401/A VDD VSS sg13g2_buf_8
Xfanout363 _10074_/A0 _10141_/A1 VDD VSS sg13g2_buf_1
XFILLER_4_1007 VDD VSS sg13g2_decap_8
XFILLER_59_586 VDD VSS sg13g2_decap_8
X_12900_ _12902_/B _12900_/A _12900_/B _12900_/C input18/X VDD VSS sg13g2_nand4_1
Xfanout396 _10160_/S _10157_/S VDD VSS sg13g2_buf_1
XFILLER_19_428 VDD VSS sg13g2_decap_8
XFILLER_59_597 VDD VSS sg13g2_fill_2
X_13880_ _13880_/Q _15001_/CLK _13880_/D _13880_/RESET_B VDD VSS sg13g2_dfrbpq_1
XFILLER_47_748 VDD VSS sg13g2_fill_2
XFILLER_100_171 VDD VSS sg13g2_decap_8
XFILLER_74_556 VDD VSS sg13g2_decap_8
X_12831_ _12831_/Y _14769_/Q _12918_/A2 _13297_/A0 VDD VSS sg13g2_o21ai_1
X_13879__2685 _13879_/RESET_B VDD VSS sg13g2_tiehi
XFILLER_43_910 VDD VSS sg13g2_fill_2
XFILLER_43_921 VDD VSS sg13g2_fill_1
XFILLER_15_623 VDD VSS sg13g2_decap_8
XFILLER_27_483 VDD VSS sg13g2_decap_8
X_12762_ _12762_/X _12760_/X _12761_/X _12762_/S VDD VSS sg13g2_mux2_1
X_15201__3354 _15201_/RESET_B VDD VSS sg13g2_tiehi
X_14501_ _14501_/Q clkload3/A _14501_/D _14501_/RESET_B VDD VSS sg13g2_dfrbpq_1
XFILLER_153_0 VDD VSS sg13g2_decap_8
X_11713_ _11713_/X _13961_/Q _13993_/Q _14025_/Q _14057_/Q _11714_/S0 _11714_/S1 VDD
+ VSS sg13g2_mux4_1
X_12693_ wire371/A _13189_/B _12749_/A2 _12692_/X _12749_/B2 _12749_/C1 VDD VSS sg13g2_a221oi_1
XFILLER_30_615 VDD VSS sg13g2_fill_2
X_14432_ _14432_/Q clkload9/A _14432_/D _14432_/RESET_B VDD VSS sg13g2_dfrbpq_1
XFILLER_52_40 VDD VSS sg13g2_decap_8
X_11644_ _11644_/X _14695_/Q _14727_/Q _13767_/Q _13799_/Q _11648_/S0 _12067_/S1 VDD
+ VSS sg13g2_mux4_1
XFILLER_128_503 VDD VSS sg13g2_fill_1
XFILLER_7_800 VDD VSS sg13g2_decap_4
X_14363_ _14363_/Q _14776_/CLK _14363_/D _14363_/RESET_B VDD VSS sg13g2_dfrbpq_1
Xinput16 input16/X input16/A VDD VSS sg13g2_buf_1
X_11575_ _11575_/X _13829_/Q _13861_/Q _13893_/Q _13925_/Q _11580_/S0 _11580_/S1 VDD
+ VSS sg13g2_mux4_1
Xwire731 wire731/X wire731/A VDD VSS sg13g2_buf_2
Xinput27 input27/X input27/A VDD VSS sg13g2_buf_1
XFILLER_155_322 VDD VSS sg13g2_decap_8
Xwire742 wire742/X wire742/A VDD VSS sg13g2_buf_1
XFILLER_10_372 VDD VSS sg13g2_decap_8
Xinput38 input38/X rst_ni VDD VSS sg13g2_buf_1
X_13314_ _13314_/X _15061_/Q _13356_/B _13316_/C VDD VSS sg13g2_and3_1
XFILLER_116_709 VDD VSS sg13g2_fill_2
X_10526_ _14857_/D _10564_/D _10531_/D _10525_/Y VDD VSS sg13g2_a21oi_1
XFILLER_122_1067 VDD VSS sg13g2_decap_4
X_14294_ _14294_/Q clkload33/A _14294_/D _14294_/RESET_B VDD VSS sg13g2_dfrbpq_1
X_13245_ _13245_/X _13245_/A _13665_/Q _13246_/C VDD VSS sg13g2_and3_1
X_10457_ _10460_/C _14841_/Q _10462_/D _14842_/Q VDD VSS sg13g2_a21oi_1
XFILLER_136_591 VDD VSS sg13g2_decap_8
X_14474__2090 _14474_/RESET_B VDD VSS sg13g2_tiehi
XFILLER_124_753 VDD VSS sg13g2_fill_2
XFILLER_42_7 VDD VSS sg13g2_decap_8
X_13176_ wire182/A _13176_/A _13176_/B _13176_/C VDD VSS sg13g2_nand3_1
X_10388_ _10388_/Y _14820_/Q _10386_/C _10626_/B VDD VSS sg13g2_o21ai_1
XFILLER_112_926 VDD VSS sg13g2_decap_8
X_12127_ _12155_/A _12128_/A _13667_/Q VDD VSS sg13g2_nand2_1
XFILLER_46_1160 VDD VSS sg13g2_fill_2
XFILLER_96_136 VDD VSS sg13g2_fill_1
XFILLER_81_1051 VDD VSS sg13g2_decap_8
XFILLER_96_147 VDD VSS sg13g2_decap_8
XFILLER_96_158 VDD VSS sg13g2_fill_1
X_12058_ _12058_/Y _12012_/A _12008_/Y _12010_/B VDD VSS sg13g2_o21ai_1
X_11009_ _11010_/C _11009_/A _11009_/B _11009_/C _11009_/D VDD VSS sg13g2_nand4_1
X_13692__2873 _13692_/RESET_B VDD VSS sg13g2_tiehi
XFILLER_42_1068 VDD VSS sg13g2_decap_8
X_16866_ _16866_/X _16866_/A VDD VSS sg13g2_buf_1
XFILLER_92_353 VDD VSS sg13g2_fill_1
X_13709__2855 _13709_/RESET_B VDD VSS sg13g2_tiehi
XFILLER_19_995 VDD VSS sg13g2_decap_8
XFILLER_46_770 VDD VSS sg13g2_decap_8
X_08220_ _08220_/X _08219_/A _14996_/Q _08689_/B1 VDD VSS sg13g2_a21o_1
XFILLER_53_1131 VDD VSS sg13g2_fill_1
X_13924__2640 _13924_/RESET_B VDD VSS sg13g2_tiehi
XFILLER_119_503 VDD VSS sg13g2_fill_2
X_14684__1880 _14684_/RESET_B VDD VSS sg13g2_tiehi
X_08151_ _08151_/X _07912_/B _08171_/A1 _07893_/B _08063_/B _08402_/A _07626_/A VDD
+ VSS sg13g2_mux4_1
XFILLER_14_1148 VDD VSS sg13g2_decap_8
X_08082_ _08082_/X _08081_/X _08079_/X _08599_/B VDD VSS sg13g2_mux2_1
XFILLER_88_1227 VDD VSS sg13g2_decap_8
XFILLER_134_506 VDD VSS sg13g2_fill_2
X_14304__2260 _14304_/RESET_B VDD VSS sg13g2_tiehi
XFILLER_115_753 VDD VSS sg13g2_decap_8
Xhold3403 _10213_/B input37/X VDD VSS sg13g2_dlygate4sd3_1
Xhold3414 input6/A mem_axi_rdata[11] VDD VSS sg13g2_dlygate4sd3_1
Xhold3425 hold3425/X _10211_/Y VDD VSS sg13g2_dlygate4sd3_1
XFILLER_130_712 VDD VSS sg13g2_fill_2
Xhold3436 input10/A mem_axi_rdata[15] VDD VSS sg13g2_dlygate4sd3_1
XFILLER_138_1085 VDD VSS sg13g2_decap_8
XFILLER_103_948 VDD VSS sg13g2_fill_2
X_14888__3153 _14888_/RESET_B VDD VSS sg13g2_tiehi
X_08984_ _13758_/D _13758_/Q _10141_/A1 _09084_/S VDD VSS sg13g2_mux2_1
Xhold3447 hold3447/X input14/X VDD VSS sg13g2_dlygate4sd3_1
XFILLER_25_1200 VDD VSS sg13g2_decap_8
Xhold3458 input25/A mem_axi_rdata[29] VDD VSS sg13g2_dlygate4sd3_1
Xhold3469 _13630_/A _13738_/Q VDD VSS sg13g2_dlygate4sd3_1
XFILLER_130_767 VDD VSS sg13g2_fill_1
X_07935_ _07935_/Y _08414_/D _07934_/Y _07933_/Y VDD VSS sg13g2_a21oi_1
XFILLER_111_970 VDD VSS sg13g2_fill_1
XFILLER_68_372 VDD VSS sg13g2_fill_1
XFILLER_29_737 VDD VSS sg13g2_decap_8
XFILLER_56_523 VDD VSS sg13g2_fill_1
XFILLER_60_1157 VDD VSS sg13g2_decap_8
X_07866_ _07866_/Y _07969_/A _08666_/A _08650_/A _07867_/D VDD VSS sg13g2_nor4_1
XFILLER_112_1236 VDD VSS sg13g2_fill_1
XFILLER_28_236 VDD VSS sg13g2_fill_2
XFILLER_83_320 VDD VSS sg13g2_decap_8
XFILLER_113_35 VDD VSS sg13g2_decap_8
XFILLER_84_865 VDD VSS sg13g2_decap_8
X_09605_ _14202_/D _14202_/Q _09970_/A1 _09605_/S VDD VSS sg13g2_mux2_1
XFILLER_44_718 VDD VSS sg13g2_decap_8
XFILLER_71_504 VDD VSS sg13g2_fill_1
X_07797_ _07797_/X _07797_/A _07797_/B _07797_/C _07797_/D VDD VSS sg13g2_or4_1
XFILLER_83_375 VDD VSS sg13g2_decap_8
XFILLER_113_79 VDD VSS sg13g2_fill_1
X_09536_ _14135_/D _09967_/A1 _14135_/Q _09536_/S VDD VSS sg13g2_mux2_1
XFILLER_25_976 VDD VSS sg13g2_decap_8
X_09467_ _14068_/D _10063_/A0 _14068_/Q _09467_/S VDD VSS sg13g2_mux2_1
XFILLER_19_1037 VDD VSS sg13g2_decap_8
XFILLER_12_615 VDD VSS sg13g2_fill_2
X_08418_ _08419_/A _08418_/A _08418_/B VDD VSS sg13g2_and2_1
X_09398_ _14001_/D _09994_/A0 _14001_/Q _09398_/S VDD VSS sg13g2_mux2_1
XFILLER_138_801 VDD VSS sg13g2_decap_4
XFILLER_32_1204 VDD VSS sg13g2_decap_8
X_08349_ _08353_/A _08414_/A _08366_/D _08348_/Y VDD VSS sg13g2_o21ai_1
XFILLER_22_21 VDD VSS sg13g2_decap_8
XFILLER_137_333 VDD VSS sg13g2_fill_2
XFILLER_138_21 VDD VSS sg13g2_decap_8
X_11360_ _11360_/Y _11357_/Y _11359_/Y _12000_/A VDD VSS sg13g2_a21oi_1
XFILLER_152_303 VDD VSS sg13g2_decap_8
X_10311_ _10342_/C _10311_/A _10311_/B _10311_/C _10327_/C VDD VSS sg13g2_and4_1
XFILLER_98_14 VDD VSS sg13g2_decap_8
XFILLER_137_399 VDD VSS sg13g2_decap_8
XFILLER_125_539 VDD VSS sg13g2_decap_4
X_11291_ _11292_/B _12825_/B _12836_/B VDD VSS sg13g2_xnor2_1
X_13030_ _13030_/Y _14781_/Q _13123_/A2 _13123_/B1 VDD VSS sg13g2_o21ai_1
XFILLER_140_509 VDD VSS sg13g2_fill_2
XFILLER_65_1013 VDD VSS sg13g2_fill_2
X_10242_ _14775_/D _14775_/Q wire763/X _10241_/Y VDD VSS sg13g2_a21oi_1
XFILLER_3_368 VDD VSS sg13g2_decap_8
XFILLER_3_379 VDD VSS sg13g2_decap_4
XFILLER_65_1046 VDD VSS sg13g2_fill_2
XFILLER_154_42 VDD VSS sg13g2_decap_8
Xfanout1103 _12729_/S1 fanout1104/X VDD VSS sg13g2_buf_1
X_10173_ _10173_/Y _10185_/B _10173_/B _10178_/A VDD VSS sg13g2_nand3_1
XFILLER_121_745 VDD VSS sg13g2_decap_8
XFILLER_156_1196 VDD VSS sg13g2_decap_8
Xfanout1114 _12754_/S1 _12758_/S1 VDD VSS sg13g2_buf_1
XFILLER_152_1038 VDD VSS sg13g2_fill_2
Xfanout1125 _12647_/S1 fanout1128/X VDD VSS sg13g2_buf_1
Xfanout1136 _12785_/S1 _12620_/S1 VDD VSS sg13g2_buf_1
Xfanout160 _09902_/A0 _09935_/A1 VDD VSS sg13g2_buf_1
X_14981_ _14981_/Q _15046_/CLK _14981_/D _14981_/RESET_B VDD VSS sg13g2_dfrbpq_1
Xfanout1158 _12630_/S0 _12686_/S0 VDD VSS sg13g2_buf_1
XFILLER_120_266 VDD VSS sg13g2_decap_8
Xfanout171 _10132_/A0 _09138_/X VDD VSS sg13g2_buf_1
XFILLER_19_203 VDD VSS sg13g2_fill_2
XFILLER_47_523 VDD VSS sg13g2_fill_1
X_13932_ _13932_/Q clkload54/A _13932_/D _13932_/RESET_B VDD VSS sg13g2_dfrbpq_1
Xfanout193 _09994_/A0 _10093_/A0 VDD VSS sg13g2_buf_1
XFILLER_101_491 VDD VSS sg13g2_decap_4
XFILLER_47_556 VDD VSS sg13g2_decap_8
XFILLER_35_707 VDD VSS sg13g2_fill_2
X_13863_ _13863_/Q _14725_/CLK _13863_/D _13863_/RESET_B VDD VSS sg13g2_dfrbpq_1
XFILLER_90_824 VDD VSS sg13g2_fill_2
X_12814_ _12814_/Y _12900_/B input12/X _12884_/C VDD VSS sg13g2_nand3_1
X_13794_ _13794_/Q clkload22/A _13794_/D _13794_/RESET_B VDD VSS sg13g2_dfrbpq_1
XFILLER_37_1104 VDD VSS sg13g2_decap_8
XFILLER_128_1221 VDD VSS sg13g2_decap_8
X_14346__2218 _14346_/RESET_B VDD VSS sg13g2_tiehi
XFILLER_43_762 VDD VSS sg13g2_fill_2
X_12745_ _12745_/X _14263_/Q _14295_/Q _14327_/Q _14359_/Q _12745_/S0 _12745_/S1 VDD
+ VSS sg13g2_mux4_1
X_13669__2919 _13669_/RESET_B VDD VSS sg13g2_tiehi
XFILLER_31_924 VDD VSS sg13g2_decap_4
XFILLER_70_570 VDD VSS sg13g2_fill_1
XFILLER_70_581 VDD VSS sg13g2_fill_1
X_12676_ _12676_/X _12673_/X _12672_/X _12671_/X _12670_/X _12719_/S0 _12720_/S VDD
+ VSS sg13g2_mux4_1
XFILLER_129_812 VDD VSS sg13g2_fill_1
X_14415_ _14415_/Q clkload12/A _14415_/D _14415_/RESET_B VDD VSS sg13g2_dfrbpq_1
X_11627_ _11627_/Y _11622_/X _12075_/A _12118_/C VDD VSS sg13g2_a21oi_1
XFILLER_8_56 VDD VSS sg13g2_decap_8
XFILLER_11_670 VDD VSS sg13g2_decap_8
X_14346_ _14346_/Q _14506_/CLK _14346_/D _14346_/RESET_B VDD VSS sg13g2_dfrbpq_1
X_11558_ _11559_/B _11547_/Y _11549_/X _11747_/A VDD VSS sg13g2_o21ai_1
X_14561__2003 _14561_/RESET_B VDD VSS sg13g2_tiehi
Xwire561 wire561/X wire561/A VDD VSS sg13g2_buf_2
XFILLER_144_826 VDD VSS sg13g2_fill_2
Xmax_cap316 _10069_/S fanout315/X VDD VSS sg13g2_buf_4
X_10509_ _10509_/Y _10512_/A _10509_/B _10509_/C _10509_/D VDD VSS sg13g2_nor4_1
XFILLER_143_314 VDD VSS sg13g2_fill_1
XFILLER_128_388 VDD VSS sg13g2_decap_8
X_14277_ _14277_/Q _14405_/CLK _14277_/D _14277_/RESET_B VDD VSS sg13g2_dfrbpq_1
XFILLER_13_1181 VDD VSS sg13g2_decap_8
X_11489_ _11489_/X _14370_/Q _14402_/Q _14466_/Q _14498_/Q _11489_/S0 _11493_/S1 VDD
+ VSS sg13g2_mux4_1
XFILLER_100_1140 VDD VSS sg13g2_fill_1
X_13228_ _13228_/Y _13228_/A _13228_/B _13228_/C VDD VSS sg13g2_nand3_1
XFILLER_48_1233 VDD VSS sg13g2_decap_4
XFILLER_100_1173 VDD VSS sg13g2_fill_1
XFILLER_124_561 VDD VSS sg13g2_decap_8
XFILLER_152_892 VDD VSS sg13g2_decap_8
XFILLER_135_1214 VDD VSS sg13g2_fill_2
XFILLER_98_946 VDD VSS sg13g2_decap_8
X_13159_ _13159_/Y _13174_/A _13158_/B _13170_/D VDD VSS sg13g2_a21oi_1
XFILLER_135_1236 VDD VSS sg13g2_fill_1
XFILLER_85_607 VDD VSS sg13g2_decap_8
XFILLER_84_128 VDD VSS sg13g2_decap_8
X_07720_ _15217_/D _13343_/B _11288_/A _13345_/B VDD VSS sg13g2_or3_1
Xfanout1670 _12162_/S0 fanout1672/X VDD VSS sg13g2_buf_1
XFILLER_84_139 VDD VSS sg13g2_fill_1
Xfanout1692 _11759_/A fanout1705/X VDD VSS sg13g2_buf_1
X_07651_ _11023_/A _15118_/Q VDD VSS sg13g2_inv_1
XFILLER_38_589 VDD VSS sg13g2_fill_1
XFILLER_65_386 VDD VSS sg13g2_decap_8
XFILLER_93_695 VDD VSS sg13g2_fill_1
XFILLER_20_1163 VDD VSS sg13g2_decap_8
XFILLER_0_1235 VDD VSS sg13g2_fill_2
X_09321_ _13928_/D _09787_/A0 _13928_/Q _09337_/S VDD VSS sg13g2_mux2_1
XFILLER_80_356 VDD VSS sg13g2_decap_8
XFILLER_55_1215 VDD VSS sg13g2_decap_8
X_14761__3340 _14761_/RESET_B VDD VSS sg13g2_tiehi
XFILLER_21_423 VDD VSS sg13g2_decap_8
X_09252_ _13861_/D _13861_/Q _10148_/A1 _09270_/S VDD VSS sg13g2_mux2_1
X_08203_ _08247_/A _08203_/A _08203_/B VDD VSS sg13g2_nor2_1
X_09183_ _13799_/D _13799_/Q _10150_/A1 _09199_/S VDD VSS sg13g2_mux2_1
XFILLER_119_311 VDD VSS sg13g2_fill_1
XFILLER_105_1040 VDD VSS sg13g2_decap_8
XFILLER_105_1051 VDD VSS sg13g2_fill_1
XFILLER_147_642 VDD VSS sg13g2_decap_8
XFILLER_147_653 VDD VSS sg13g2_fill_1
X_08134_ _08134_/Y _08030_/Y _08132_/X _08397_/A VDD VSS sg13g2_o21ai_1
XFILLER_105_1084 VDD VSS sg13g2_fill_1
XFILLER_119_388 VDD VSS sg13g2_fill_2
XFILLER_49_1008 VDD VSS sg13g2_decap_8
X_08065_ _08066_/A _07888_/B _07768_/A _07910_/B _08219_/A _08099_/S0 _08048_/A VDD
+ VSS sg13g2_mux4_1
XFILLER_108_35 VDD VSS sg13g2_fill_2
X_15200__3353 _15200_/RESET_B VDD VSS sg13g2_tiehi
XFILLER_108_68 VDD VSS sg13g2_decap_8
Xmax_cap883 _08514_/B _08401_/Y VDD VSS sg13g2_buf_2
XFILLER_103_723 VDD VSS sg13g2_decap_8
XFILLER_62_1208 VDD VSS sg13g2_fill_2
XFILLER_89_957 VDD VSS sg13g2_fill_1
XFILLER_102_244 VDD VSS sg13g2_decap_8
XFILLER_88_467 VDD VSS sg13g2_decap_8
X_08967_ _08967_/Y _09141_/A _08977_/C VDD VSS sg13g2_nand2_1
XFILLER_29_501 VDD VSS sg13g2_decap_8
XFILLER_102_277 VDD VSS sg13g2_decap_8
Xpicorv32_macro mem_axi_araddr[0] VDD VSS sg13g2_tielo
XFILLER_102_288 VDD VSS sg13g2_fill_2
X_07918_ _07918_/Y _07893_/Y _07916_/Y _07917_/B VDD VSS sg13g2_a21oi_1
XFILLER_25_1074 VDD VSS sg13g2_decap_8
X_08898_ _08898_/Y _08954_/S _14942_/Q VDD VSS sg13g2_nand2_1
XFILLER_124_78 VDD VSS sg13g2_decap_8
XFILLER_5_1157 VDD VSS sg13g2_decap_8
XFILLER_112_1033 VDD VSS sg13g2_decap_8
X_07849_ _07849_/X _15016_/Q _07849_/B VDD VSS sg13g2_and2_1
XFILLER_17_21 VDD VSS sg13g2_decap_8
Xclkbuf_leaf_3_clk_i clkload4/A clkbuf_leaf_5_clk_i/A VDD VSS sg13g2_buf_8
XFILLER_16_217 VDD VSS sg13g2_decap_8
XFILLER_83_183 VDD VSS sg13g2_decap_8
XFILLER_112_1099 VDD VSS sg13g2_fill_2
XFILLER_44_548 VDD VSS sg13g2_fill_2
X_10860_ _10860_/Y _10797_/C _10870_/A _10939_/B1 VDD VSS sg13g2_o21ai_1
XFILLER_17_98 VDD VSS sg13g2_fill_2
X_09519_ _14118_/D _09653_/A0 _14118_/Q _09520_/S VDD VSS sg13g2_mux2_1
XFILLER_140_77 VDD VSS sg13g2_decap_8
X_10791_ _14924_/D _11168_/B1 _11199_/B _10790_/Y VDD VSS sg13g2_o21ai_1
XFILLER_24_272 VDD VSS sg13g2_decap_4
XFILLER_40_721 VDD VSS sg13g2_fill_1
X_12530_ _12530_/X _13960_/Q _13992_/Q _14024_/Q _14056_/Q _12534_/S0 _12534_/S1 VDD
+ VSS sg13g2_mux4_1
XFILLER_13_957 VDD VSS sg13g2_decap_8
XFILLER_12_445 VDD VSS sg13g2_decap_8
XFILLER_33_64 VDD VSS sg13g2_decap_8
XFILLER_149_42 VDD VSS sg13g2_decap_8
X_12461_ _12461_/X _14371_/Q _14403_/Q _14467_/Q _14499_/Q _12546_/S0 _12546_/S1 VDD
+ VSS sg13g2_mux4_1
X_14030__2534 _14030_/RESET_B VDD VSS sg13g2_tiehi
X_14200_ _14200_/Q clkload32/A _14200_/D _14200_/RESET_B VDD VSS sg13g2_dfrbpq_1
XFILLER_71_1094 VDD VSS sg13g2_decap_8
X_11412_ _11413_/A _14239_/Q _14271_/Q _14303_/Q _14335_/Q _11828_/S0 _11828_/S1 VDD
+ VSS sg13g2_mux4_1
X_15180_ _15180_/Q clkload72/A _15180_/D _15180_/RESET_B VDD VSS sg13g2_dfrbpq_1
X_12392_ _12392_/X _13726_/Q _14078_/Q _14430_/Q _14526_/Q _12393_/S0 _12617_/S1 VDD
+ VSS sg13g2_mux4_1
XFILLER_153_601 VDD VSS sg13g2_fill_2
XFILLER_125_303 VDD VSS sg13g2_decap_4
XFILLER_4_600 VDD VSS sg13g2_fill_2
X_14131_ _14131_/Q clkload10/A _14131_/D _14131_/RESET_B VDD VSS sg13g2_dfrbpq_1
XFILLER_116_0 VDD VSS sg13g2_decap_8
X_11343_ _11343_/Y _11353_/S _13854_/Q _11374_/C VDD VSS sg13g2_a21oi_1
XFILLER_152_133 VDD VSS sg13g2_decap_8
XFILLER_4_644 VDD VSS sg13g2_fill_2
X_14062_ _14062_/Q clkload60/A _14062_/D _14062_/RESET_B VDD VSS sg13g2_dfrbpq_1
X_11274_ _11274_/Y _11270_/Y _11271_/Y _11273_/Y _11272_/Y _11283_/B VDD VSS sg13g2_a221oi_1
XFILLER_134_870 VDD VSS sg13g2_fill_2
XFILLER_3_154 VDD VSS sg13g2_decap_8
XFILLER_140_317 VDD VSS sg13g2_decap_8
XFILLER_152_188 VDD VSS sg13g2_decap_8
X_13013_ _13013_/Y _14876_/Q _13028_/B VDD VSS sg13g2_nand2_1
X_10225_ _10234_/D _14767_/Q _14768_/Q _14769_/Q _14770_/Q VDD VSS sg13g2_and4_1
X_10156_ _14733_/D _14733_/Q _10156_/A1 _10160_/S VDD VSS sg13g2_mux2_1
XFILLER_88_990 VDD VSS sg13g2_decap_8
XFILLER_121_597 VDD VSS sg13g2_decap_8
X_14964_ _14964_/Q _15229_/CLK _14964_/D _14964_/RESET_B VDD VSS sg13g2_dfrbpq_1
XFILLER_43_1174 VDD VSS sg13g2_decap_4
X_10087_ _14667_/D _10087_/A0 _14667_/Q _10101_/S VDD VSS sg13g2_mux2_1
XFILLER_130_1144 VDD VSS sg13g2_decap_8
X_13915_ _13915_/Q clkload76/A _13915_/D _13915_/RESET_B VDD VSS sg13g2_dfrbpq_1
X_14895_ _14895_/Q clkload62/A _14895_/D _14895_/RESET_B VDD VSS sg13g2_dfrbpq_1
XFILLER_130_1177 VDD VSS sg13g2_fill_1
XFILLER_35_537 VDD VSS sg13g2_decap_4
XFILLER_63_846 VDD VSS sg13g2_fill_2
X_13846_ _13846_/Q clkload24/A _13846_/D _13846_/RESET_B VDD VSS sg13g2_dfrbpq_1
X_14872__3185 _14872_/RESET_B VDD VSS sg13g2_tiehi
XFILLER_63_879 VDD VSS sg13g2_decap_8
XFILLER_90_687 VDD VSS sg13g2_decap_8
X_13777_ _13777_/Q _14737_/CLK _13777_/D _13777_/RESET_B VDD VSS sg13g2_dfrbpq_1
X_10989_ _10989_/Y _10995_/B _15116_/Q VDD VSS sg13g2_nand2b_1
X_12728_ _12728_/X _14582_/Q _14614_/Q _14646_/Q _14678_/Q _12729_/S0 _12729_/S1 VDD
+ VSS sg13g2_mux4_1
XFILLER_128_1084 VDD VSS sg13g2_fill_1
XFILLER_148_428 VDD VSS sg13g2_decap_8
X_12659_ _12659_/X _14705_/Q _14737_/Q _13777_/Q _13809_/Q _12659_/S0 _12659_/S1 VDD
+ VSS sg13g2_mux4_1
XFILLER_129_620 VDD VSS sg13g2_fill_2
XFILLER_30_275 VDD VSS sg13g2_decap_4
XFILLER_117_826 VDD VSS sg13g2_fill_1
XFILLER_8_994 VDD VSS sg13g2_decap_8
XFILLER_7_471 VDD VSS sg13g2_decap_8
XFILLER_50_1189 VDD VSS sg13g2_decap_8
Xwire380 wire380/X wire380/A VDD VSS sg13g2_buf_2
X_14329_ _14329_/Q clkload42/A _14329_/D _14329_/RESET_B VDD VSS sg13g2_dfrbpq_1
XFILLER_144_656 VDD VSS sg13g2_fill_1
XFILLER_143_122 VDD VSS sg13g2_decap_4
XFILLER_143_177 VDD VSS sg13g2_decap_4
XFILLER_98_732 VDD VSS sg13g2_decap_8
XFILLER_125_892 VDD VSS sg13g2_decap_8
Xfanout907 _12638_/A2 _12679_/C1 VDD VSS sg13g2_buf_1
X_09870_ _14457_/D _14457_/Q _10068_/A0 _09870_/S VDD VSS sg13g2_mux2_1
Xfanout918 _13180_/C1 _13248_/B VDD VSS sg13g2_buf_1
XFILLER_31_0 VDD VSS sg13g2_decap_8
Xclkbuf_5_7__f_clk_i clkbuf_5_7__f_clk_i/X clkbuf_4_3_0_clk_i/X VDD VSS sg13g2_buf_16
Xfanout929 _10886_/B1 _13279_/D VDD VSS sg13g2_buf_1
X_13874__2690 _13874_/RESET_B VDD VSS sg13g2_tiehi
X_08821_ _08821_/Y _13279_/B _15121_/Q _08727_/D _15178_/Q _08825_/C1 VDD VSS sg13g2_a221oi_1
XFILLER_58_618 VDD VSS sg13g2_fill_2
XFILLER_98_787 VDD VSS sg13g2_fill_2
XFILLER_135_1066 VDD VSS sg13g2_fill_2
XFILLER_86_938 VDD VSS sg13g2_fill_2
X_15065__3266 _15065_/RESET_B VDD VSS sg13g2_tiehi
XFILLER_85_437 VDD VSS sg13g2_fill_2
XFILLER_100_737 VDD VSS sg13g2_decap_8
XFILLER_135_1099 VDD VSS sg13g2_decap_8
X_08752_ _08752_/Y _13189_/B _08752_/B VDD VSS sg13g2_nor2_1
XFILLER_66_640 VDD VSS sg13g2_fill_1
X_07703_ _07703_/Y _10670_/A _13302_/C VDD VSS sg13g2_nand2_1
X_08683_ _08684_/B _08649_/S _08697_/A _08682_/Y VDD VSS sg13g2_o21ai_1
XFILLER_66_673 VDD VSS sg13g2_decap_8
X_07634_ _07909_/B _11454_/A VDD VSS sg13g2_inv_1
XFILLER_53_334 VDD VSS sg13g2_decap_8
XFILLER_0_1043 VDD VSS sg13g2_decap_8
XFILLER_41_507 VDD VSS sg13g2_decap_4
XFILLER_0_90 VDD VSS sg13g2_fill_1
XFILLER_53_378 VDD VSS sg13g2_fill_1
XFILLER_59_1181 VDD VSS sg13g2_fill_1
XFILLER_110_14 VDD VSS sg13g2_decap_4
XFILLER_0_1087 VDD VSS sg13g2_decap_8
X_09304_ _13912_/D _13912_/Q _10100_/A0 wire496/X VDD VSS sg13g2_mux2_1
XFILLER_22_721 VDD VSS sg13g2_fill_1
XFILLER_0_1098 VDD VSS sg13g2_fill_1
XFILLER_16_1007 VDD VSS sg13g2_fill_2
XFILLER_16_1018 VDD VSS sg13g2_fill_1
XFILLER_21_242 VDD VSS sg13g2_fill_1
X_09235_ _13846_/D _10132_/A0 _13846_/Q _09235_/S VDD VSS sg13g2_mux2_1
XFILLER_22_776 VDD VSS sg13g2_decap_8
X_09166_ wire153/A _09162_/A _09165_/Y _09162_/Y VDD VSS sg13g2_a21oi_1
X_08117_ _08117_/Y _07904_/B _08116_/Y _08039_/A VDD VSS sg13g2_a21oi_1
XFILLER_135_634 VDD VSS sg13g2_decap_4
X_09097_ _09097_/X _09097_/A _09097_/B _09136_/B VDD VSS sg13g2_or3_1
XFILLER_79_27 VDD VSS sg13g2_fill_1
XFILLER_107_347 VDD VSS sg13g2_fill_2
XFILLER_107_358 VDD VSS sg13g2_fill_1
XFILLER_134_155 VDD VSS sg13g2_decap_8
X_08048_ _08048_/Y _08048_/A _08048_/B VDD VSS sg13g2_nand2_1
Xmax_cap680 _09398_/S _09377_/S VDD VSS sg13g2_buf_4
XFILLER_153_1100 VDD VSS sg13g2_decap_8
XFILLER_27_1103 VDD VSS sg13g2_decap_8
XFILLER_0_102 VDD VSS sg13g2_decap_4
XFILLER_150_659 VDD VSS sg13g2_decap_8
XFILLER_131_851 VDD VSS sg13g2_fill_1
XFILLER_7_1208 VDD VSS sg13g2_decap_8
X_10010_ _14592_/D _10076_/A0 _14592_/Q _10033_/S VDD VSS sg13g2_mux2_1
X_13704__2860 _13704_/RESET_B VDD VSS sg13g2_tiehi
XFILLER_135_77 VDD VSS sg13g2_fill_1
XFILLER_131_873 VDD VSS sg13g2_fill_2
X_09999_ _14582_/D _10098_/A0 _14582_/Q _09999_/S VDD VSS sg13g2_mux2_1
XFILLER_95_37 VDD VSS sg13g2_fill_1
XFILLER_153_1177 VDD VSS sg13g2_decap_8
XFILLER_95_48 VDD VSS sg13g2_decap_4
XFILLER_88_286 VDD VSS sg13g2_fill_2
XFILLER_28_42 VDD VSS sg13g2_decap_8
XFILLER_151_21 VDD VSS sg13g2_decap_8
XFILLER_45_802 VDD VSS sg13g2_decap_4
X_14048__2516 _14048_/RESET_B VDD VSS sg13g2_tiehi
X_11961_ _11961_/Y _11801_/S _14512_/Q _12023_/B VDD VSS sg13g2_a21oi_1
XFILLER_91_429 VDD VSS sg13g2_decap_8
XFILLER_44_301 VDD VSS sg13g2_decap_8
X_13700_ _13700_/Q clkload16/A _13700_/D _13700_/RESET_B VDD VSS sg13g2_dfrbpq_1
X_10912_ _10912_/Y _10797_/C _10936_/D _10939_/B1 VDD VSS sg13g2_o21ai_1
XFILLER_72_632 VDD VSS sg13g2_decap_8
X_14680_ _14680_/Q clkload36/A _14680_/D _14680_/RESET_B VDD VSS sg13g2_dfrbpq_1
XFILLER_151_98 VDD VSS sg13g2_decap_8
XFILLER_45_868 VDD VSS sg13g2_decap_4
X_11892_ _11892_/Y _11889_/Y _11891_/X _11224_/A VDD VSS sg13g2_o21ai_1
XFILLER_71_142 VDD VSS sg13g2_decap_4
X_13631_ _13739_/D _13631_/A VDD VSS sg13g2_buf_1
X_10843_ _10843_/Y _10841_/Y _10843_/B _10843_/C VDD VSS sg13g2_nand3b_1
XFILLER_72_698 VDD VSS sg13g2_decap_4
XFILLER_60_849 VDD VSS sg13g2_decap_8
XFILLER_73_1123 VDD VSS sg13g2_decap_8
X_13562_ _15152_/D _15152_/Q _13561_/X _13568_/S VDD VSS sg13g2_mux2_1
X_10774_ _10774_/Y _13199_/A _11170_/B VDD VSS sg13g2_nand2_1
X_14263__2301 _14263_/RESET_B VDD VSS sg13g2_tiehi
XFILLER_13_776 VDD VSS sg13g2_decap_8
X_12513_ _15000_/D _12513_/A _12513_/B VDD VSS sg13g2_nor2_1
XFILLER_40_562 VDD VSS sg13g2_decap_8
X_13493_ _13493_/Y _13412_/B _13412_/C _15126_/Q VDD VSS sg13g2_o21ai_1
XFILLER_8_246 VDD VSS sg13g2_decap_8
Xmax_cap1725 _11852_/S0 _11415_/S VDD VSS sg13g2_buf_4
X_12444_ _12457_/A _10213_/A _07737_/B _14996_/Q VDD VSS sg13g2_a21oi_1
X_15232_ _15232_/Q clkload38/A _15232_/D _15232_/RESET_B VDD VSS sg13g2_dfrbpq_1
XFILLER_154_910 VDD VSS sg13g2_decap_8
XFILLER_60_84 VDD VSS sg13g2_decap_8
X_15163_ _15163_/Q clkload29/A _15163_/D _15163_/RESET_B VDD VSS sg13g2_dfrbpq_1
X_12375_ _12375_/X _14557_/Q _14589_/Q _14621_/Q _14653_/Q _12378_/S0 _12411_/S1 VDD
+ VSS sg13g2_mux4_1
X_14114_ _14114_/Q clkload6/A _14114_/D _14114_/RESET_B VDD VSS sg13g2_dfrbpq_1
XFILLER_153_453 VDD VSS sg13g2_decap_8
X_11326_ _11326_/Y _11326_/A _11326_/B VDD VSS sg13g2_nand2_1
XFILLER_5_35 VDD VSS sg13g2_decap_8
XFILLER_5_964 VDD VSS sg13g2_decap_8
X_14296__2268 _14296_/RESET_B VDD VSS sg13g2_tiehi
XFILLER_125_144 VDD VSS sg13g2_decap_8
X_15094_ _15094_/Q clkload67/A _15094_/D _15094_/RESET_B VDD VSS sg13g2_dfrbpq_1
XFILLER_119_1017 VDD VSS sg13g2_decap_4
X_14045_ _14045_/Q _14525_/CLK _14045_/D _14045_/RESET_B VDD VSS sg13g2_dfrbpq_1
XFILLER_113_339 VDD VSS sg13g2_fill_2
X_11257_ _11257_/X _13724_/Q _14076_/Q _14428_/Q _14524_/Q _11257_/S0 _11282_/S1 VDD
+ VSS sg13g2_mux4_1
Xclkbuf_leaf_104_clk_i clkload36/A clkbuf_5_14__f_clk_i/X VDD VSS sg13g2_buf_8
XFILLER_140_136 VDD VSS sg13g2_decap_8
XFILLER_45_1225 VDD VSS sg13g2_decap_8
XFILLER_79_231 VDD VSS sg13g2_decap_8
XFILLER_45_1236 VDD VSS sg13g2_fill_1
XFILLER_69_93 VDD VSS sg13g2_decap_8
XFILLER_95_702 VDD VSS sg13g2_fill_2
X_10208_ wire847/A _14765_/Q _14749_/Q VDD VSS sg13g2_nand2b_1
XFILLER_122_862 VDD VSS sg13g2_fill_1
XFILLER_121_350 VDD VSS sg13g2_fill_1
X_11188_ _11188_/Y _11186_/B _11187_/Y _11186_/Y _11197_/B _11151_/A VDD VSS sg13g2_a221oi_1
XFILLER_132_1217 VDD VSS sg13g2_decap_8
XFILLER_68_949 VDD VSS sg13g2_decap_8
XFILLER_79_286 VDD VSS sg13g2_decap_8
XFILLER_94_212 VDD VSS sg13g2_decap_8
XFILLER_95_735 VDD VSS sg13g2_decap_8
XFILLER_121_372 VDD VSS sg13g2_fill_2
X_10139_ _14716_/D _14716_/Q _10139_/A1 _10157_/S VDD VSS sg13g2_mux2_1
XFILLER_95_779 VDD VSS sg13g2_decap_8
Xclkbuf_leaf_119_clk_i clkload22/A clkbuf_5_8__f_clk_i/X VDD VSS sg13g2_buf_8
XFILLER_82_418 VDD VSS sg13g2_fill_2
XFILLER_85_70 VDD VSS sg13g2_decap_8
X_14947_ _14947_/Q clkload19/A _14947_/D _14947_/RESET_B VDD VSS sg13g2_dfrbpq_1
XFILLER_78_1012 VDD VSS sg13g2_decap_8
XFILLER_48_695 VDD VSS sg13g2_fill_1
XFILLER_36_846 VDD VSS sg13g2_fill_2
XFILLER_91_952 VDD VSS sg13g2_decap_8
X_14878_ _14878_/Q clkload83/A _14878_/D _14878_/RESET_B VDD VSS sg13g2_dfrbpq_1
XFILLER_35_378 VDD VSS sg13g2_decap_4
X_13829_ _13829_/Q _14725_/CLK _13829_/D _13829_/RESET_B VDD VSS sg13g2_dfrbpq_1
XFILLER_23_529 VDD VSS sg13g2_decap_8
XFILLER_62_197 VDD VSS sg13g2_decap_8
XFILLER_91_1234 VDD VSS sg13g2_fill_2
XFILLER_31_540 VDD VSS sg13g2_decap_4
XFILLER_149_726 VDD VSS sg13g2_decap_8
XFILLER_31_562 VDD VSS sg13g2_fill_2
X_13746__2818 _13746_/RESET_B VDD VSS sg13g2_tiehi
X_09020_ _13764_/D _13764_/Q _10147_/A1 _09153_/S VDD VSS sg13g2_mux2_1
XFILLER_136_409 VDD VSS sg13g2_decap_8
XFILLER_145_921 VDD VSS sg13g2_decap_8
XFILLER_15_1073 VDD VSS sg13g2_decap_8
XFILLER_106_1190 VDD VSS sg13g2_fill_2
XFILLER_8_780 VDD VSS sg13g2_decap_8
XFILLER_117_645 VDD VSS sg13g2_decap_4
XFILLER_102_1065 VDD VSS sg13g2_fill_1
XFILLER_145_976 VDD VSS sg13g2_decap_8
XFILLER_116_133 VDD VSS sg13g2_decap_4
X_14126__2438 _14126_/RESET_B VDD VSS sg13g2_tiehi
X_13961__2603 _13961_/RESET_B VDD VSS sg13g2_tiehi
XFILLER_144_486 VDD VSS sg13g2_fill_2
X_09922_ _14507_/D _14507_/Q _09922_/A1 _09936_/S VDD VSS sg13g2_mux2_1
Xfanout704 _10142_/A1 _09910_/A1 VDD VSS sg13g2_buf_1
Xfanout715 _08395_/A _08685_/A1 VDD VSS sg13g2_buf_1
Xfanout726 _10206_/S _13655_/S VDD VSS sg13g2_buf_1
Xfanout737 _13593_/B _13570_/S VDD VSS sg13g2_buf_1
X_09853_ _14440_/D _14440_/Q _10084_/A0 _09855_/S VDD VSS sg13g2_mux2_1
XFILLER_59_938 VDD VSS sg13g2_fill_1
Xfanout748 _12416_/B1 _12791_/A2 VDD VSS sg13g2_buf_1
XFILLER_105_14 VDD VSS sg13g2_decap_8
XFILLER_140_681 VDD VSS sg13g2_fill_1
X_08804_ _08805_/B _13686_/Q _08807_/B VDD VSS sg13g2_nor2_1
X_09784_ _14373_/D _09916_/A1 _14373_/Q _09801_/S VDD VSS sg13g2_mux2_1
X_14341__2223 _14341_/RESET_B VDD VSS sg13g2_tiehi
XFILLER_26_1191 VDD VSS sg13g2_decap_8
X_14953__3023 _14953_/RESET_B VDD VSS sg13g2_tiehi
XFILLER_39_662 VDD VSS sg13g2_fill_2
X_08735_ _13663_/D _08753_/A1 _08733_/Y _08734_/Y VDD VSS sg13g2_a21oi_1
XFILLER_22_1044 VDD VSS sg13g2_decap_8
XFILLER_73_429 VDD VSS sg13g2_fill_1
XFILLER_27_835 VDD VSS sg13g2_fill_2
XFILLER_26_312 VDD VSS sg13g2_fill_1
XFILLER_66_481 VDD VSS sg13g2_fill_2
X_08666_ _08666_/X _08666_/A _08666_/B VDD VSS sg13g2_xor2_1
XFILLER_27_879 VDD VSS sg13g2_fill_1
XFILLER_121_35 VDD VSS sg13g2_decap_8
XFILLER_148_1235 VDD VSS sg13g2_fill_2
XFILLER_14_507 VDD VSS sg13g2_decap_8
Xclkbuf_leaf_83_clk_i _15209_/CLK clkbuf_leaf_83_clk_i/A VDD VSS sg13g2_buf_8
XFILLER_121_46 VDD VSS sg13g2_fill_1
X_07617_ _09011_/A _14902_/Q VDD VSS sg13g2_inv_1
XFILLER_82_985 VDD VSS sg13g2_fill_2
XFILLER_14_518 VDD VSS sg13g2_fill_1
XFILLER_82_996 VDD VSS sg13g2_decap_8
X_08597_ _08600_/C _08597_/A _08597_/B _08597_/C VDD VSS sg13g2_nor3_1
XFILLER_81_484 VDD VSS sg13g2_fill_1
XFILLER_121_68 VDD VSS sg13g2_decap_8
XFILLER_81_28 VDD VSS sg13g2_fill_2
XFILLER_22_540 VDD VSS sg13g2_decap_8
XFILLER_14_77 VDD VSS sg13g2_decap_8
Xclkbuf_leaf_98_clk_i _15148_/CLK clkbuf_leaf_99_clk_i/A VDD VSS sg13g2_buf_8
X_09218_ _13829_/D _10148_/A1 _13829_/Q _09236_/S VDD VSS sg13g2_mux2_1
X_10490_ _14850_/D _10490_/A _10490_/B _10498_/D VDD VSS sg13g2_nor3_1
XFILLER_154_217 VDD VSS sg13g2_decap_8
XFILLER_148_781 VDD VSS sg13g2_fill_2
XFILLER_6_739 VDD VSS sg13g2_decap_8
XFILLER_30_21 VDD VSS sg13g2_decap_8
X_09149_ _09151_/B _09157_/C _09157_/D _14923_/Q VDD VSS sg13g2_a21o_1
XFILLER_107_111 VDD VSS sg13g2_decap_4
XFILLER_68_1225 VDD VSS sg13g2_decap_8
XFILLER_146_21 VDD VSS sg13g2_decap_8
XFILLER_68_1236 VDD VSS sg13g2_fill_1
Xclkbuf_leaf_21_clk_i clkload49/A clkbuf_leaf_49_clk_i/A VDD VSS sg13g2_buf_8
X_12160_ _12160_/Y _12168_/A _14230_/Q _12233_/B VDD VSS sg13g2_a21oi_1
XFILLER_151_924 VDD VSS sg13g2_fill_1
XFILLER_136_998 VDD VSS sg13g2_decap_8
XFILLER_122_103 VDD VSS sg13g2_decap_8
X_11111_ _11111_/Y _11109_/B _10764_/X _11183_/B1 VDD VSS sg13g2_o21ai_1
XFILLER_1_422 VDD VSS sg13g2_decap_8
X_12091_ _12092_/B _12091_/A _12091_/B _12091_/C VDD VSS sg13g2_nand3_1
XFILLER_7_1005 VDD VSS sg13g2_decap_8
X_11042_ _11078_/D _11042_/A _11042_/B _11042_/C _11042_/D VDD VSS sg13g2_nand4_1
XFILLER_118_1050 VDD VSS sg13g2_decap_8
XFILLER_104_884 VDD VSS sg13g2_decap_8
XFILLER_131_670 VDD VSS sg13g2_fill_2
XFILLER_1_488 VDD VSS sg13g2_decap_8
XFILLER_76_201 VDD VSS sg13g2_decap_4
XFILLER_103_372 VDD VSS sg13g2_decap_8
Xclkbuf_leaf_36_clk_i clkload55/A clkbuf_leaf_38_clk_i/A VDD VSS sg13g2_buf_8
XFILLER_118_1083 VDD VSS sg13g2_fill_2
XFILLER_130_180 VDD VSS sg13g2_decap_8
XFILLER_49_459 VDD VSS sg13g2_decap_8
XFILLER_130_191 VDD VSS sg13g2_fill_2
X_14801_ _14801_/Q clkload80/A _14801_/D _14801_/RESET_B VDD VSS sg13g2_dfrbpq_1
XFILLER_18_813 VDD VSS sg13g2_decap_8
XFILLER_91_204 VDD VSS sg13g2_decap_4
XFILLER_92_727 VDD VSS sg13g2_fill_1
XFILLER_40_1155 VDD VSS sg13g2_decap_8
X_12993_ _12995_/C _13058_/D _12993_/B _12993_/C VDD VSS sg13g2_nand3b_1
XFILLER_40_1166 VDD VSS sg13g2_fill_2
XFILLER_57_481 VDD VSS sg13g2_decap_4
XFILLER_45_632 VDD VSS sg13g2_fill_1
XFILLER_57_492 VDD VSS sg13g2_fill_2
XFILLER_91_237 VDD VSS sg13g2_fill_2
X_14732_ _14732_/Q clkload51/A _14732_/D _14732_/RESET_B VDD VSS sg13g2_dfrbpq_1
XFILLER_44_120 VDD VSS sg13g2_decap_4
X_11944_ _11944_/Y _11940_/Y _11941_/Y _11943_/Y _11942_/Y _12036_/B VDD VSS sg13g2_a221oi_1
XFILLER_73_963 VDD VSS sg13g2_decap_4
XFILLER_17_356 VDD VSS sg13g2_decap_8
XFILLER_75_1218 VDD VSS sg13g2_decap_8
XFILLER_55_84 VDD VSS sg13g2_decap_8
X_11875_ _11875_/X _11875_/A _11875_/B VDD VSS sg13g2_and2_1
X_14663_ _14663_/Q clkload5/A _14663_/D _14663_/RESET_B VDD VSS sg13g2_dfrbpq_1
XFILLER_72_495 VDD VSS sg13g2_fill_1
X_10826_ _10841_/A _12347_/B _10851_/D VDD VSS sg13g2_nor2_1
X_13614_ _15168_/D _08842_/S _16854_/A wire555/X VDD VSS sg13g2_a21o_1
X_14594_ _14594_/Q _14722_/CLK _14594_/D _14594_/RESET_B VDD VSS sg13g2_dfrbpq_1
XFILLER_38_1062 VDD VSS sg13g2_decap_8
XFILLER_13_551 VDD VSS sg13g2_fill_1
X_13545_ _13545_/X _13545_/A _13563_/C VDD VSS sg13g2_and2_1
XFILLER_13_573 VDD VSS sg13g2_decap_8
X_10757_ _10757_/Y _10757_/A _10757_/B VDD VSS sg13g2_nor2_1
XFILLER_125_1076 VDD VSS sg13g2_fill_2
XFILLER_72_7 VDD VSS sg13g2_decap_8
X_15090__3190 _15090_/RESET_B VDD VSS sg13g2_tiehi
X_13476_ _15112_/D _15178_/D _15112_/Q _13656_/S VDD VSS sg13g2_mux2_1
X_10688_ _10851_/C _08992_/B _10691_/S _08852_/Y VDD VSS sg13g2_a21o_1
Xmax_cap1544 output57/A _16881_/A VDD VSS sg13g2_buf_4
XFILLER_12_1235 VDD VSS sg13g2_fill_2
X_12427_ _12427_/X _12425_/X _12424_/X _12421_/X _12420_/X wire1081/A _12692_/S VDD
+ VSS sg13g2_mux4_1
X_15215_ _15215_/Q clkload66/A _15215_/D _15215_/RESET_B VDD VSS sg13g2_dfrbpq_1
Xmax_cap1555 _16870_/A _13708_/Q VDD VSS sg13g2_buf_8
X_15146_ _15146_/Q clkload26/A _15146_/D _15146_/RESET_B VDD VSS sg13g2_dfrbpq_1
XFILLER_5_761 VDD VSS sg13g2_decap_8
X_12358_ _12358_/Y _15217_/Q _12358_/B VDD VSS sg13g2_nand2b_1
XFILLER_126_464 VDD VSS sg13g2_fill_1
XFILLER_142_935 VDD VSS sg13g2_decap_8
X_11309_ _11309_/Y _11310_/A1 _14429_/Q VDD VSS sg13g2_nand2b_1
XFILLER_5_794 VDD VSS sg13g2_fill_2
XFILLER_153_294 VDD VSS sg13g2_decap_8
X_15077_ _15077_/Q clkload66/A _15077_/D _15077_/RESET_B VDD VSS sg13g2_dfrbpq_1
X_12289_ _12289_/X _12283_/X _12284_/X _12287_/X _12288_/X _12290_/S0 _12290_/S1 VDD
+ VSS sg13g2_mux4_1
Xclkbuf_5_25__f_clk_i clkbuf_leaf_84_clk_i/A clkbuf_4_12_0_clk_i/X VDD VSS sg13g2_buf_16
XFILLER_4_293 VDD VSS sg13g2_decap_8
X_14028_ _14028_/Q _14714_/CLK _14028_/D _14028_/RESET_B VDD VSS sg13g2_dfrbpq_1
XFILLER_136_1183 VDD VSS sg13g2_fill_2
XFILLER_68_746 VDD VSS sg13g2_fill_1
XFILLER_122_692 VDD VSS sg13g2_decap_8
XFILLER_136_1194 VDD VSS sg13g2_decap_8
XFILLER_67_234 VDD VSS sg13g2_fill_1
XFILLER_68_779 VDD VSS sg13g2_decap_4
XFILLER_132_1069 VDD VSS sg13g2_decap_8
XFILLER_110_876 VDD VSS sg13g2_decap_8
XFILLER_67_278 VDD VSS sg13g2_fill_1
XFILLER_110_898 VDD VSS sg13g2_fill_1
X_08520_ _08520_/X _08457_/X _08597_/C _08597_/B VDD VSS sg13g2_mux2_1
XFILLER_64_941 VDD VSS sg13g2_decap_8
XFILLER_82_248 VDD VSS sg13g2_fill_2
XFILLER_36_654 VDD VSS sg13g2_fill_1
XFILLER_64_974 VDD VSS sg13g2_decap_8
X_08451_ _08462_/B _08034_/A _08087_/X _08518_/B1 VDD VSS sg13g2_o21ai_1
XFILLER_1_1160 VDD VSS sg13g2_decap_8
XFILLER_23_315 VDD VSS sg13g2_decap_4
XFILLER_1_1182 VDD VSS sg13g2_decap_8
XFILLER_1_1193 VDD VSS sg13g2_fill_2
X_08382_ _08382_/X _08383_/A _08383_/B VDD VSS sg13g2_and2_1
XFILLER_50_134 VDD VSS sg13g2_decap_8
XFILLER_23_359 VDD VSS sg13g2_decap_8
XFILLER_50_145 VDD VSS sg13g2_fill_2
XFILLER_51_668 VDD VSS sg13g2_decap_4
XFILLER_17_1113 VDD VSS sg13g2_decap_8
XFILLER_91_1053 VDD VSS sg13g2_fill_1
XFILLER_149_545 VDD VSS sg13g2_decap_8
XFILLER_104_1116 VDD VSS sg13g2_decap_8
XFILLER_31_392 VDD VSS sg13g2_fill_2
XFILLER_118_921 VDD VSS sg13g2_decap_8
X_09003_ _09003_/X _15028_/Q _15225_/Q _09034_/S VDD VSS sg13g2_mux2_1
XFILLER_118_932 VDD VSS sg13g2_fill_1
X_14359__2205 _14359_/RESET_B VDD VSS sg13g2_tiehi
XFILLER_3_709 VDD VSS sg13g2_decap_8
XFILLER_2_219 VDD VSS sg13g2_decap_8
XFILLER_105_637 VDD VSS sg13g2_fill_1
XFILLER_28_1220 VDD VSS sg13g2_decap_8
XFILLER_120_607 VDD VSS sg13g2_decap_8
XFILLER_99_871 VDD VSS sg13g2_fill_1
X_09905_ _09905_/X _09905_/A _10105_/C _10037_/A _10070_/B VDD VSS sg13g2_and4_1
Xfanout523 _09914_/A1 wire524/X VDD VSS sg13g2_buf_1
Xfanout534 _09911_/A1 _09680_/A0 VDD VSS sg13g2_buf_1
XFILLER_115_1212 VDD VSS sg13g2_decap_8
XFILLER_24_1106 VDD VSS sg13g2_decap_8
XFILLER_59_746 VDD VSS sg13g2_fill_1
Xfanout556 _13435_/B _13444_/B VDD VSS sg13g2_buf_1
X_15160__3022 _15160_/RESET_B VDD VSS sg13g2_tiehi
X_09836_ _14424_/D _09836_/A0 _14424_/Q wire618/X VDD VSS sg13g2_mux2_1
XFILLER_100_320 VDD VSS sg13g2_fill_2
XFILLER_112_180 VDD VSS sg13g2_decap_4
XFILLER_59_768 VDD VSS sg13g2_decap_8
XFILLER_98_1207 VDD VSS sg13g2_decap_8
Xfanout589 _10136_/S _10124_/S VDD VSS sg13g2_buf_1
X_09767_ _14357_/D _14357_/Q _09899_/A0 wire444/X VDD VSS sg13g2_mux2_1
XFILLER_6_1082 VDD VSS sg13g2_decap_8
XFILLER_74_749 VDD VSS sg13g2_decap_8
XFILLER_132_56 VDD VSS sg13g2_decap_8
XFILLER_55_941 VDD VSS sg13g2_decap_4
X_08718_ _15212_/D _15191_/D _15121_/Q _13653_/S VDD VSS sg13g2_mux2_1
X_09698_ _14290_/D _09698_/A0 _14290_/Q _09705_/S VDD VSS sg13g2_mux2_1
XFILLER_42_602 VDD VSS sg13g2_decap_8
X_08649_ _08650_/B _08662_/B _08647_/Y _08649_/S VDD VSS sg13g2_mux2_1
XFILLER_25_21 VDD VSS sg13g2_decap_8
XFILLER_109_1005 VDD VSS sg13g2_fill_1
XFILLER_81_281 VDD VSS sg13g2_decap_4
XFILLER_26_197 VDD VSS sg13g2_decap_4
X_14917__3095 _14917_/RESET_B VDD VSS sg13g2_tiehi
X_11660_ _11771_/A _11661_/A _13680_/Q VDD VSS sg13g2_nor2_1
XFILLER_42_668 VDD VSS sg13g2_decap_8
XFILLER_70_999 VDD VSS sg13g2_fill_1
X_10611_ _14879_/D _10611_/A _10630_/C _10611_/C VDD VSS sg13g2_and3_1
XFILLER_25_98 VDD VSS sg13g2_decap_8
XFILLER_41_167 VDD VSS sg13g2_fill_2
XFILLER_70_1104 VDD VSS sg13g2_decap_4
X_11591_ _11636_/C _11591_/A _13682_/Q VDD VSS sg13g2_xor2_1
X_13330_ _13502_/B input30/X _13336_/S _13329_/Y VDD VSS sg13g2_o21ai_1
X_10542_ _10544_/A _13273_/A _10538_/Y _14863_/Q VDD VSS sg13g2_a21o_1
XFILLER_109_921 VDD VSS sg13g2_decap_8
XFILLER_10_576 VDD VSS sg13g2_decap_4
XFILLER_109_932 VDD VSS sg13g2_fill_2
X_13261_ _13261_/Y _14829_/Q _13206_/B _13249_/B _14893_/Q _13274_/C1 VDD VSS sg13g2_a221oi_1
X_10473_ _10484_/D _10504_/C _14845_/Q _14844_/Q _10473_/D VDD VSS sg13g2_and4_1
XFILLER_6_558 VDD VSS sg13g2_fill_2
X_12212_ _12212_/X _13751_/Q _14103_/Q _14455_/Q _14551_/Q _12215_/S0 _12215_/S1 VDD
+ VSS sg13g2_mux4_1
X_15000_ _15000_/Q clkload40/A _15000_/D _15000_/RESET_B VDD VSS sg13g2_dfrbpq_1
XFILLER_68_1022 VDD VSS sg13g2_decap_4
XFILLER_109_998 VDD VSS sg13g2_decap_8
X_13192_ _13192_/X input21/X _12914_/A _13252_/B1 VDD VSS sg13g2_a21o_1
XFILLER_123_412 VDD VSS sg13g2_decap_8
X_12143_ _12144_/B _12291_/A _12143_/B VDD VSS sg13g2_nor2_1
XFILLER_9_0 VDD VSS sg13g2_decap_8
XFILLER_124_979 VDD VSS sg13g2_decap_4
XFILLER_155_1058 VDD VSS sg13g2_decap_4
XFILLER_151_776 VDD VSS sg13g2_decap_4
XFILLER_1_230 VDD VSS sg13g2_decap_8
XFILLER_1_241 VDD VSS sg13g2_fill_2
X_12074_ _12075_/B _12071_/X _12070_/X _12067_/X _12066_/X _12092_/C _12076_/S1 VDD
+ VSS sg13g2_mux4_1
X_15067__3258 _15067_/RESET_B VDD VSS sg13g2_tiehi
XFILLER_49_201 VDD VSS sg13g2_fill_2
XFILLER_132_990 VDD VSS sg13g2_fill_2
XFILLER_2_14 VDD VSS sg13g2_decap_8
XFILLER_42_1217 VDD VSS sg13g2_decap_8
X_11025_ _11025_/Y _11022_/Y _11064_/B _11043_/A VDD VSS sg13g2_a21oi_1
X_16882_ _16882_/X _16882_/A VDD VSS sg13g2_buf_1
X_15128__3088 _15128_/RESET_B VDD VSS sg13g2_tiehi
XFILLER_18_643 VDD VSS sg13g2_decap_8
X_12976_ _12976_/Y _14842_/Q _13150_/B VDD VSS sg13g2_nand2_1
XFILLER_92_579 VDD VSS sg13g2_decap_4
XFILLER_46_974 VDD VSS sg13g2_decap_8
XFILLER_61_911 VDD VSS sg13g2_decap_8
X_14715_ _14715_/Q clkload76/A _14715_/D _14715_/RESET_B VDD VSS sg13g2_dfrbpq_1
X_14437__2127 _14437_/RESET_B VDD VSS sg13g2_tiehi
XFILLER_75_1026 VDD VSS sg13g2_decap_8
X_11927_ _11929_/B _12075_/A _11927_/B VDD VSS sg13g2_nor2_1
X_14646_ _14646_/Q _14678_/CLK _14646_/D _14646_/RESET_B VDD VSS sg13g2_dfrbpq_1
X_11858_ _11858_/Y _12292_/A _11858_/B VDD VSS sg13g2_nor2_1
XFILLER_33_679 VDD VSS sg13g2_decap_8
X_10809_ _10809_/Y _10935_/A _10809_/B VDD VSS sg13g2_nor2_1
X_11789_ _11789_/X _11781_/X _11782_/X _11785_/X _11786_/X _12027_/C _12290_/S1 VDD
+ VSS sg13g2_mux4_1
X_14577_ _14577_/Q clkload45/A _14577_/D _14577_/RESET_B VDD VSS sg13g2_dfrbpq_1
X_13528_ _15142_/D _13539_/B _13526_/Y _13527_/Y VDD VSS sg13g2_a21oi_1
XFILLER_12_1010 VDD VSS sg13g2_decap_8
XFILLER_118_228 VDD VSS sg13g2_decap_8
X_13459_ _13459_/Y _15196_/Q _15200_/Q _13459_/C wire808/X VDD VSS sg13g2_nand4_1
Xoutput104 mem_axi_wdata[0] _15132_/Q VDD VSS sg13g2_buf_1
Xoutput115 mem_axi_wdata[1] _15133_/Q VDD VSS sg13g2_buf_1
XFILLER_86_1133 VDD VSS sg13g2_fill_2
XFILLER_103_1193 VDD VSS sg13g2_decap_8
XFILLER_142_721 VDD VSS sg13g2_fill_1
Xoutput126 mem_axi_wdata[2] _15134_/Q VDD VSS sg13g2_buf_1
XFILLER_47_1106 VDD VSS sg13g2_decap_8
Xoutput137 mem_axi_wstrb[1] _15165_/Q VDD VSS sg13g2_buf_1
X_15129_ _15129_/Q clkload72/A _15129_/D _15129_/RESET_B VDD VSS sg13g2_dfrbpq_1
XFILLER_141_231 VDD VSS sg13g2_decap_4
X_13678__2901 _13678_/RESET_B VDD VSS sg13g2_tiehi
X_14043__2521 _14043_/RESET_B VDD VSS sg13g2_tiehi
XFILLER_130_916 VDD VSS sg13g2_decap_8
XFILLER_102_618 VDD VSS sg13g2_decap_8
X_13696__2868 _13696_/RESET_B VDD VSS sg13g2_tiehi
X_07951_ _07951_/Y _15010_/Q _07818_/B VDD VSS sg13g2_nor2b_1
XFILLER_142_798 VDD VSS sg13g2_decap_8
XFILLER_130_949 VDD VSS sg13g2_decap_4
XFILLER_96_830 VDD VSS sg13g2_decap_8
XFILLER_96_841 VDD VSS sg13g2_fill_1
X_07882_ _07882_/Y _08079_/S _13609_/A VDD VSS sg13g2_nor2_1
X_14647__1917 _14647_/RESET_B VDD VSS sg13g2_tiehi
X_09621_ _14217_/D _09621_/A0 _14217_/Q _09635_/S VDD VSS sg13g2_mux2_1
XFILLER_83_513 VDD VSS sg13g2_decap_8
XFILLER_110_684 VDD VSS sg13g2_fill_1
XFILLER_23_1161 VDD VSS sg13g2_decap_8
XFILLER_37_930 VDD VSS sg13g2_decap_8
X_09552_ _14150_/D _09653_/A0 _14150_/Q _09553_/S VDD VSS sg13g2_mux2_1
X_14076__2488 _14076_/RESET_B VDD VSS sg13g2_tiehi
XFILLER_110_1142 VDD VSS sg13g2_decap_8
XFILLER_71_719 VDD VSS sg13g2_fill_2
XFILLER_110_1153 VDD VSS sg13g2_fill_1
X_08503_ _08503_/Y _07819_/B _07636_/Y _08497_/A VDD VSS sg13g2_o21ai_1
X_09483_ _14083_/D _10079_/A0 _14083_/Q _09503_/S VDD VSS sg13g2_mux2_1
XFILLER_52_933 VDD VSS sg13g2_decap_8
XFILLER_23_112 VDD VSS sg13g2_decap_8
XFILLER_24_646 VDD VSS sg13g2_fill_2
XFILLER_145_1216 VDD VSS sg13g2_decap_8
XFILLER_23_123 VDD VSS sg13g2_fill_2
XFILLER_19_1219 VDD VSS sg13g2_decap_8
X_08434_ _08442_/B _08574_/B wire233/X VDD VSS sg13g2_nand2b_1
X_15015__2957 _15015_/RESET_B VDD VSS sg13g2_tiehi
X_08365_ _08411_/C _07782_/A _15002_/Q _07786_/A _08351_/B VDD VSS sg13g2_a22oi_1
X_14291__2273 _14291_/RESET_B VDD VSS sg13g2_tiehi
Xwire209 wire209/X wire209/A VDD VSS sg13g2_buf_2
XFILLER_137_515 VDD VSS sg13g2_fill_1
X_08296_ _08296_/Y _08276_/A _14999_/Q _08369_/B VDD VSS sg13g2_a21oi_1
XFILLER_137_559 VDD VSS sg13g2_decap_8
XFILLER_30_1165 VDD VSS sg13g2_decap_8
XFILLER_11_56 VDD VSS sg13g2_decap_8
XFILLER_105_412 VDD VSS sg13g2_decap_8
XFILLER_65_1206 VDD VSS sg13g2_fill_1
XFILLER_127_56 VDD VSS sg13g2_decap_8
XFILLER_2_7 VDD VSS sg13g2_decap_8
XFILLER_78_307 VDD VSS sg13g2_decap_8
X_14515__2049 _14515_/RESET_B VDD VSS sg13g2_tiehi
Xfanout1307 _10037_/A _10070_/A VDD VSS sg13g2_buf_1
XFILLER_8_1111 VDD VSS sg13g2_decap_8
Xfanout320 wire321/A wire326/X VDD VSS sg13g2_buf_1
XFILLER_59_521 VDD VSS sg13g2_fill_2
Xfanout1318 _09161_/S _09155_/A1 VDD VSS sg13g2_buf_1
Xfanout1329 _13465_/A1 _13412_/B VDD VSS sg13g2_buf_1
Xfanout342 _09413_/S _09431_/S VDD VSS sg13g2_buf_1
Xfanout353 _10080_/A0 _09019_/Y VDD VSS sg13g2_buf_1
XFILLER_120_459 VDD VSS sg13g2_decap_8
Xfanout364 _10141_/A1 _08983_/X VDD VSS sg13g2_buf_1
XFILLER_28_1094 VDD VSS sg13g2_decap_8
XFILLER_59_565 VDD VSS sg13g2_decap_8
XFILLER_8_1188 VDD VSS sg13g2_decap_8
Xfanout386 _10954_/C _10965_/A VDD VSS sg13g2_buf_1
X_14769__3329 _14769_/RESET_B VDD VSS sg13g2_tiehi
Xfanout397 _10157_/S wire398/A VDD VSS sg13g2_buf_1
X_09819_ _14407_/D _09918_/A1 _14407_/Q _09835_/S VDD VSS sg13g2_mux2_1
XFILLER_74_513 VDD VSS sg13g2_decap_8
XFILLER_74_524 VDD VSS sg13g2_fill_1
X_14805__3293 _14805_/RESET_B VDD VSS sg13g2_tiehi
X_12830_ _12830_/Y _14801_/Q _12851_/B _13260_/B _14833_/Q _13180_/C1 VDD VSS sg13g2_a221oi_1
X_13741__2823 _13741_/RESET_B VDD VSS sg13g2_tiehi
XFILLER_55_771 VDD VSS sg13g2_fill_1
XFILLER_55_782 VDD VSS sg13g2_decap_8
X_12761_ _12761_/X _12759_/X _12758_/X _12755_/X _12754_/X _12761_/S0 _12734_/S VDD
+ VSS sg13g2_mux4_1
XFILLER_14_112 VDD VSS sg13g2_decap_8
XFILLER_70_730 VDD VSS sg13g2_fill_1
XFILLER_82_590 VDD VSS sg13g2_fill_1
X_14500_ _14500_/Q _15160_/CLK _14500_/D _14500_/RESET_B VDD VSS sg13g2_dfrbpq_1
X_11712_ _11712_/X _14121_/Q _14153_/Q _14185_/Q _14217_/Q _11714_/S0 _11714_/S1 VDD
+ VSS sg13g2_mux4_1
X_12692_ _12692_/X _12691_/X _12690_/X _12692_/S VDD VSS sg13g2_mux2_1
XFILLER_43_999 VDD VSS sg13g2_fill_2
XFILLER_146_0 VDD VSS sg13g2_decap_8
X_14431_ _14431_/Q clkload56/A _14431_/D _14431_/RESET_B VDD VSS sg13g2_dfrbpq_1
X_11643_ _11643_/Y _11643_/A _11643_/B VDD VSS sg13g2_xnor2_1
XFILLER_70_796 VDD VSS sg13g2_decap_4
XFILLER_74_1070 VDD VSS sg13g2_decap_8
X_14121__2443 _14121_/RESET_B VDD VSS sg13g2_tiehi
XFILLER_35_1054 VDD VSS sg13g2_fill_1
X_11574_ _11574_/X _13733_/Q _14085_/Q _14437_/Q _14533_/Q _11578_/S0 _11580_/S1 VDD
+ VSS sg13g2_mux4_1
X_14362_ _14362_/Q clkload47/A _14362_/D _14362_/RESET_B VDD VSS sg13g2_dfrbpq_1
XFILLER_122_1024 VDD VSS sg13g2_decap_8
XFILLER_155_301 VDD VSS sg13g2_decap_8
XFILLER_7_812 VDD VSS sg13g2_decap_8
Xinput17 input17/X input17/A VDD VSS sg13g2_buf_1
XFILLER_7_823 VDD VSS sg13g2_fill_2
Xwire732 wire732/X wire732/A VDD VSS sg13g2_buf_2
Xinput28 input28/X input28/A VDD VSS sg13g2_buf_1
XFILLER_35_1098 VDD VSS sg13g2_decap_8
X_13313_ _13316_/C _07691_/Y _07677_/B _13312_/Y VDD VSS sg13g2_a21oi_1
X_10525_ _10525_/Y _10564_/D _10531_/D _10557_/C VDD VSS sg13g2_o21ai_1
X_14293_ _14293_/Q clkload14/A _14293_/D _14293_/RESET_B VDD VSS sg13g2_dfrbpq_1
X_14725__1839 _14725_/RESET_B VDD VSS sg13g2_tiehi
Xwire765 wire765/X wire765/A VDD VSS sg13g2_buf_1
Xmax_cap509 _09264_/S _09261_/S VDD VSS sg13g2_buf_4
X_13244_ _13247_/B _13232_/A _13244_/B _13246_/C VDD VSS sg13g2_nand3b_1
X_10456_ _14841_/D _14841_/Q _10453_/X _10455_/Y VDD VSS sg13g2_a21oi_1
XFILLER_124_721 VDD VSS sg13g2_fill_2
X_13175_ _13176_/C _14917_/Q _13670_/Q _13145_/A _13169_/Y _13174_/Y VDD VSS sg13g2_a221oi_1
X_10387_ _10387_/X _14818_/Q _14819_/Q _14820_/Q _10396_/C VDD VSS sg13g2_and4_1
XFILLER_123_231 VDD VSS sg13g2_decap_4
XFILLER_112_905 VDD VSS sg13g2_fill_1
XFILLER_69_307 VDD VSS sg13g2_decap_8
X_12126_ _12149_/A _12126_/A _12128_/A VDD VSS sg13g2_nand2_1
XFILLER_69_318 VDD VSS sg13g2_fill_1
XFILLER_124_798 VDD VSS sg13g2_decap_4
XFILLER_35_7 VDD VSS sg13g2_decap_8
XFILLER_2_572 VDD VSS sg13g2_decap_4
XFILLER_111_448 VDD VSS sg13g2_decap_8
X_12057_ _12062_/A _11778_/A _11778_/B _12056_/X VDD VSS sg13g2_o21ai_1
XFILLER_78_852 VDD VSS sg13g2_decap_8
XFILLER_38_705 VDD VSS sg13g2_fill_2
XFILLER_133_1164 VDD VSS sg13g2_fill_2
XFILLER_77_93 VDD VSS sg13g2_fill_2
X_11008_ _11010_/B _10974_/Y _10989_/Y _10988_/Y VDD VSS sg13g2_a21o_1
XFILLER_65_513 VDD VSS sg13g2_fill_2
X_16865_ _16865_/X _16865_/A VDD VSS sg13g2_buf_1
XFILLER_93_844 VDD VSS sg13g2_decap_8
XFILLER_93_855 VDD VSS sg13g2_fill_1
XFILLER_19_974 VDD VSS sg13g2_decap_8
XFILLER_46_760 VDD VSS sg13g2_fill_1
XFILLER_92_387 VDD VSS sg13g2_fill_2
XFILLER_34_933 VDD VSS sg13g2_decap_8
X_12959_ _12959_/X _12959_/A1 _13684_/Q _12945_/Y VDD VSS sg13g2_a21o_1
XFILLER_34_977 VDD VSS sg13g2_decap_4
X_14629_ _14629_/Q clkload5/A _14629_/D _14629_/RESET_B VDD VSS sg13g2_dfrbpq_1
XFILLER_60_273 VDD VSS sg13g2_decap_8
XFILLER_53_1154 VDD VSS sg13g2_decap_4
X_08150_ _08150_/X _08013_/X _08146_/A _08241_/B _08011_/X _08167_/A _08332_/A1 VDD
+ VSS sg13g2_mux4_1
XFILLER_105_1222 VDD VSS sg13g2_decap_8
XFILLER_14_1127 VDD VSS sg13g2_decap_8
XFILLER_147_846 VDD VSS sg13g2_decap_8
XFILLER_140_1146 VDD VSS sg13g2_decap_8
X_08081_ _08081_/X _08635_/A2 _08012_/B _08686_/A3 _08653_/B _08046_/B _13521_/A VDD
+ VSS sg13g2_mux4_1
XFILLER_140_1179 VDD VSS sg13g2_decap_8
XFILLER_61_0 VDD VSS sg13g2_decap_8
Xmax_cap1171 _12755_/S0 _12759_/S0 VDD VSS sg13g2_buf_4
XFILLER_115_710 VDD VSS sg13g2_decap_8
XFILLER_127_581 VDD VSS sg13g2_fill_1
Xmax_cap1193 _12675_/S0 _12674_/S0 VDD VSS sg13g2_buf_4
XFILLER_115_732 VDD VSS sg13g2_decap_8
XFILLER_138_1042 VDD VSS sg13g2_decap_4
Xhold3404 hold3404/X _10214_/Y VDD VSS sg13g2_dlygate4sd3_1
XFILLER_142_562 VDD VSS sg13g2_decap_8
Xhold3415 hold3415/X input6/X VDD VSS sg13g2_dlygate4sd3_1
XFILLER_88_616 VDD VSS sg13g2_fill_2
XFILLER_103_927 VDD VSS sg13g2_decap_8
Xhold3426 input15/A mem_axi_rdata[1] VDD VSS sg13g2_dlygate4sd3_1
Xhold3437 hold3437/X input10/X VDD VSS sg13g2_dlygate4sd3_1
Xhold3448 input12/A mem_axi_rdata[17] VDD VSS sg13g2_dlygate4sd3_1
X_08983_ _08983_/X _08988_/A _08980_/X _08982_/Y VDD VSS sg13g2_a21o_1
XFILLER_88_649 VDD VSS sg13g2_decap_8
Xhold3459 input31/A mem_axi_rdata[5] VDD VSS sg13g2_dlygate4sd3_1
XFILLER_69_852 VDD VSS sg13g2_decap_8
X_07934_ _07934_/Y _08351_/B _07786_/A VDD VSS sg13g2_nor2b_1
XFILLER_102_459 VDD VSS sg13g2_fill_1
XFILLER_151_1231 VDD VSS sg13g2_decap_4
XFILLER_69_863 VDD VSS sg13g2_fill_1
XFILLER_69_896 VDD VSS sg13g2_fill_2
XFILLER_84_822 VDD VSS sg13g2_fill_2
X_07865_ _07867_/D _08641_/A _08641_/B _08641_/C _08641_/D VDD VSS sg13g2_nand4_1
XFILLER_113_14 VDD VSS sg13g2_decap_8
XFILLER_95_181 VDD VSS sg13g2_decap_4
X_09604_ _14201_/D _14201_/Q _10101_/A0 _09604_/S VDD VSS sg13g2_mux2_1
XFILLER_56_568 VDD VSS sg13g2_fill_1
XFILLER_84_877 VDD VSS sg13g2_decap_8
X_07796_ _07796_/Y _07796_/A _07796_/B _07797_/D VDD VSS sg13g2_nor3_1
X_09535_ _14134_/D _10165_/A1 _14134_/Q _09537_/S VDD VSS sg13g2_mux2_1
XFILLER_71_538 VDD VSS sg13g2_decap_8
XFILLER_25_955 VDD VSS sg13g2_decap_8
XFILLER_36_281 VDD VSS sg13g2_fill_2
XFILLER_36_292 VDD VSS sg13g2_decap_8
XFILLER_52_741 VDD VSS sg13g2_decap_8
XFILLER_19_1016 VDD VSS sg13g2_decap_8
X_09466_ _14067_/D _09963_/A1 _14067_/Q _09467_/S VDD VSS sg13g2_mux2_1
XFILLER_40_903 VDD VSS sg13g2_fill_2
XFILLER_149_1193 VDD VSS sg13g2_decap_8
X_08417_ _08417_/Y _08418_/B _08417_/B VDD VSS sg13g2_nand2_1
XFILLER_51_284 VDD VSS sg13g2_decap_8
X_09397_ _14000_/D _09562_/A0 _14000_/Q _09398_/S VDD VSS sg13g2_mux2_1
XFILLER_71_1232 VDD VSS sg13g2_decap_4
X_15092__3182 _15092_/RESET_B VDD VSS sg13g2_tiehi
X_08348_ _08348_/Y _07786_/A _08351_/B _08369_/B VDD VSS sg13g2_a21oi_1
XFILLER_138_835 VDD VSS sg13g2_decap_8
X_08279_ _08279_/X _08279_/A _08488_/A VDD VSS sg13g2_and2_1
XFILLER_138_879 VDD VSS sg13g2_decap_8
XFILLER_137_356 VDD VSS sg13g2_decap_8
XFILLER_22_77 VDD VSS sg13g2_decap_8
X_10310_ _10327_/C _14796_/Q _14797_/Q VDD VSS sg13g2_and2_1
XFILLER_22_88 VDD VSS sg13g2_fill_2
XFILLER_125_518 VDD VSS sg13g2_decap_8
XFILLER_138_77 VDD VSS sg13g2_decap_4
XFILLER_4_826 VDD VSS sg13g2_fill_2
X_11290_ _11338_/A _12844_/B _12836_/B VDD VSS sg13g2_nor2_1
XFILLER_3_314 VDD VSS sg13g2_decap_8
XFILLER_3_325 VDD VSS sg13g2_fill_1
X_10241_ _10241_/Y _14775_/Q wire763/X _10337_/C VDD VSS sg13g2_o21ai_1
X_13759__2805 _13759_/RESET_B VDD VSS sg13g2_tiehi
XFILLER_3_347 VDD VSS sg13g2_decap_8
XFILLER_156_1142 VDD VSS sg13g2_fill_2
XFILLER_154_21 VDD VSS sg13g2_decap_8
X_10172_ _10185_/B _13281_/B _10177_/B _10172_/C _13600_/A VDD VSS sg13g2_or4_1
XFILLER_121_724 VDD VSS sg13g2_decap_8
XFILLER_156_1175 VDD VSS sg13g2_fill_1
XFILLER_117_1126 VDD VSS sg13g2_fill_2
Xfanout1104 fanout1104/X fanout1120/X VDD VSS sg13g2_buf_1
XFILLER_65_1069 VDD VSS sg13g2_decap_8
Xfanout1115 _12534_/S1 _12480_/S1 VDD VSS sg13g2_buf_1
XFILLER_78_137 VDD VSS sg13g2_decap_8
XFILLER_78_148 VDD VSS sg13g2_fill_1
Xfanout1126 _12787_/S1 fanout1128/X VDD VSS sg13g2_buf_1
XFILLER_120_234 VDD VSS sg13g2_fill_1
XFILLER_94_608 VDD VSS sg13g2_fill_1
XFILLER_120_245 VDD VSS sg13g2_decap_8
Xfanout1137 _12617_/S1 _12620_/S1 VDD VSS sg13g2_buf_1
X_14980_ _14980_/Q clkload48/A _14980_/D _14980_/RESET_B VDD VSS sg13g2_dfrbpq_1
XFILLER_154_98 VDD VSS sg13g2_decap_8
Xfanout1148 _12550_/S0 _12729_/S0 VDD VSS sg13g2_buf_1
Xfanout150 _10102_/A0 wire153/X VDD VSS sg13g2_buf_1
Xfanout161 _09935_/A1 _09152_/Y VDD VSS sg13g2_buf_1
Xfanout172 _09900_/A0 _09138_/X VDD VSS sg13g2_buf_1
XFILLER_87_671 VDD VSS sg13g2_fill_2
Xfanout183 _09963_/A1 _10062_/A0 VDD VSS sg13g2_buf_1
X_13931_ _13931_/Q clkload50/A _13931_/D _13931_/RESET_B VDD VSS sg13g2_dfrbpq_1
Xfanout194 _10093_/A0 _10160_/A1 VDD VSS sg13g2_buf_1
X_14139__2425 _14139_/RESET_B VDD VSS sg13g2_tiehi
XFILLER_75_844 VDD VSS sg13g2_decap_8
XFILLER_75_855 VDD VSS sg13g2_fill_2
XFILLER_47_74 VDD VSS sg13g2_fill_2
X_13862_ _13862_/Q clkload17/A _13862_/D _13862_/RESET_B VDD VSS sg13g2_dfrbpq_1
XFILLER_62_505 VDD VSS sg13g2_fill_1
X_13662__2933 _13662_/RESET_B VDD VSS sg13g2_tiehi
XFILLER_74_376 VDD VSS sg13g2_fill_2
XFILLER_62_527 VDD VSS sg13g2_decap_8
XFILLER_90_836 VDD VSS sg13g2_fill_1
X_12813_ _12813_/X _12866_/A _12825_/B _12899_/C input21/X VDD VSS sg13g2_and4_1
X_13793_ _13793_/Q _14465_/CLK _13793_/D _13793_/RESET_B VDD VSS sg13g2_dfrbpq_1
XFILLER_128_1200 VDD VSS sg13g2_decap_4
XFILLER_43_741 VDD VSS sg13g2_decap_8
XFILLER_76_1143 VDD VSS sg13g2_decap_8
X_12744_ _12744_/X _14391_/Q _14423_/Q _14487_/Q _14519_/Q _12745_/S0 _12745_/S1 VDD
+ VSS sg13g2_mux4_1
XFILLER_76_1176 VDD VSS sg13g2_fill_2
X_14354__2210 _14354_/RESET_B VDD VSS sg13g2_tiehi
XFILLER_37_1149 VDD VSS sg13g2_decap_8
XFILLER_97_9 VDD VSS sg13g2_fill_1
X_12675_ _12675_/X _13970_/Q _14002_/Q _14034_/Q _14066_/Q _12675_/S0 _12675_/S1 VDD
+ VSS sg13g2_mux4_1
XFILLER_31_969 VDD VSS sg13g2_decap_8
XFILLER_8_35 VDD VSS sg13g2_decap_8
X_14414_ _14414_/Q _14494_/CLK _14414_/D _14414_/RESET_B VDD VSS sg13g2_dfrbpq_1
X_11626_ _11626_/Y _11606_/Y _11608_/X _12192_/A VDD VSS sg13g2_o21ai_1
X_14345_ _14345_/Q _14633_/CLK _14345_/D _14345_/RESET_B VDD VSS sg13g2_dfrbpq_1
X_11557_ _11557_/Y _11533_/Y _11535_/Y _11747_/A VDD VSS sg13g2_a21oi_1
XFILLER_129_879 VDD VSS sg13g2_decap_8
Xwire562 wire562/X wire562/A VDD VSS sg13g2_buf_2
XFILLER_13_1160 VDD VSS sg13g2_decap_8
XFILLER_7_675 VDD VSS sg13g2_decap_4
Xmax_cap306 _10936_/A _10897_/Y VDD VSS sg13g2_buf_1
X_10508_ _10509_/D _10513_/D _14850_/Q _10508_/C VDD VSS sg13g2_nand3_1
X_14387__2177 _14387_/RESET_B VDD VSS sg13g2_tiehi
Xwire584 wire584/X wire584/A VDD VSS sg13g2_buf_2
X_14276_ _14276_/Q _15001_/CLK _14276_/D _14276_/RESET_B VDD VSS sg13g2_dfrbpq_1
X_11488_ _11488_/X _14242_/Q _14274_/Q _14306_/Q _14338_/Q _11493_/S0 _11493_/S1 VDD
+ VSS sg13g2_mux4_1
XFILLER_6_163 VDD VSS sg13g2_decap_8
XFILLER_109_570 VDD VSS sg13g2_fill_2
XFILLER_155_186 VDD VSS sg13g2_decap_8
Xmax_cap339 _09437_/S _09421_/S VDD VSS sg13g2_buf_4
XFILLER_143_337 VDD VSS sg13g2_fill_1
XFILLER_143_348 VDD VSS sg13g2_decap_8
X_13227_ _13228_/C _14921_/Q _13666_/Q _13199_/X VDD VSS sg13g2_o21ai_1
X_10439_ _10459_/B _14836_/Q _14835_/Q _14834_/Q _14833_/Q VDD VSS sg13g2_nand4_1
XFILLER_124_540 VDD VSS sg13g2_decap_8
XFILLER_152_871 VDD VSS sg13g2_decap_8
XFILLER_98_936 VDD VSS sg13g2_decap_4
XFILLER_151_370 VDD VSS sg13g2_decap_4
X_13158_ _13160_/C _13174_/A _13158_/B _13170_/D VDD VSS sg13g2_nand3_1
XFILLER_83_1169 VDD VSS sg13g2_fill_2
X_12109_ _12109_/Y _12235_/A _13844_/Q VDD VSS sg13g2_nand2b_1
X_13089_ _13112_/A _14912_/Q _13675_/Q VDD VSS sg13g2_xnor2_1
XFILLER_97_479 VDD VSS sg13g2_decap_8
X_14858__3213 _14858_/RESET_B VDD VSS sg13g2_tiehi
XFILLER_84_118 VDD VSS sg13g2_fill_2
XFILLER_38_524 VDD VSS sg13g2_decap_4
XFILLER_120_790 VDD VSS sg13g2_decap_8
Xfanout1682 _12090_/A _11621_/S0 VDD VSS sg13g2_buf_1
Xfanout1693 _12186_/A _12250_/A1 VDD VSS sg13g2_buf_1
X_07650_ _10818_/A _15122_/Q VDD VSS sg13g2_inv_1
XFILLER_19_760 VDD VSS sg13g2_fill_1
XFILLER_65_365 VDD VSS sg13g2_fill_1
XFILLER_20_1142 VDD VSS sg13g2_decap_8
XFILLER_19_782 VDD VSS sg13g2_decap_8
XFILLER_18_270 VDD VSS sg13g2_decap_8
X_09320_ _13927_/D _10150_/A1 _13927_/Q _09333_/S VDD VSS sg13g2_mux2_1
XFILLER_80_379 VDD VSS sg13g2_fill_1
XFILLER_90_1107 VDD VSS sg13g2_fill_1
XFILLER_22_925 VDD VSS sg13g2_fill_1
X_09251_ _13860_/D _13860_/Q _09915_/A1 _09271_/S VDD VSS sg13g2_mux2_1
XFILLER_90_1129 VDD VSS sg13g2_decap_4
X_13837__2727 _13837_/RESET_B VDD VSS sg13g2_tiehi
X_14597__1967 _14597_/RESET_B VDD VSS sg13g2_tiehi
X_08202_ _08211_/D _08110_/C _08198_/X _08201_/Y VDD VSS sg13g2_o21ai_1
XFILLER_138_109 VDD VSS sg13g2_decap_8
XFILLER_21_457 VDD VSS sg13g2_fill_1
X_09182_ _13798_/D _13798_/Q _10082_/A0 _09199_/S VDD VSS sg13g2_mux2_1
XFILLER_147_610 VDD VSS sg13g2_decap_8
XFILLER_105_1030 VDD VSS sg13g2_fill_2
XFILLER_18_1093 VDD VSS sg13g2_decap_8
X_08133_ _08133_/X _07893_/B _07910_/B _07912_/B _08235_/A3 _08402_/A _07626_/A VDD
+ VSS sg13g2_mux4_1
XFILLER_147_665 VDD VSS sg13g2_fill_2
XFILLER_119_356 VDD VSS sg13g2_decap_8
XFILLER_135_816 VDD VSS sg13g2_fill_1
XFILLER_88_1036 VDD VSS sg13g2_fill_2
X_08064_ _08064_/X _08063_/B _07893_/B _07879_/A _07870_/A _08402_/A _08023_/A VDD
+ VSS sg13g2_mux4_1
X_14217__2347 _14217_/RESET_B VDD VSS sg13g2_tiehi
XFILLER_108_14 VDD VSS sg13g2_decap_8
XFILLER_134_337 VDD VSS sg13g2_fill_2
XFILLER_88_1069 VDD VSS sg13g2_fill_2
XFILLER_108_47 VDD VSS sg13g2_decap_8
XFILLER_103_702 VDD VSS sg13g2_decap_8
XFILLER_1_829 VDD VSS sg13g2_fill_2
Xmax_cap884 _08242_/A _08050_/Y VDD VSS sg13g2_buf_2
Xmax_cap895 _08275_/B _08001_/B VDD VSS sg13g2_buf_2
XFILLER_88_424 VDD VSS sg13g2_fill_2
XFILLER_89_947 VDD VSS sg13g2_fill_2
XFILLER_0_328 VDD VSS sg13g2_fill_1
XFILLER_89_969 VDD VSS sg13g2_decap_8
XFILLER_142_392 VDD VSS sg13g2_decap_8
XFILLER_130_554 VDD VSS sg13g2_decap_4
X_08966_ _09097_/A _08966_/A _08977_/C VDD VSS sg13g2_nor2b_1
X_14432__2132 _14432_/RESET_B VDD VSS sg13g2_tiehi
XFILLER_124_35 VDD VSS sg13g2_fill_1
XFILLER_130_587 VDD VSS sg13g2_fill_2
XFILLER_25_1053 VDD VSS sg13g2_decap_8
X_07917_ _08160_/C _07917_/A _07917_/B _07917_/C VDD VSS sg13g2_nor3_1
XFILLER_5_1136 VDD VSS sg13g2_decap_8
XFILLER_68_170 VDD VSS sg13g2_fill_1
XFILLER_151_1072 VDD VSS sg13g2_decap_4
XFILLER_68_181 VDD VSS sg13g2_fill_2
XFILLER_84_630 VDD VSS sg13g2_decap_4
X_08897_ _08897_/Y _08966_/A _08959_/B _15038_/Q VDD VSS sg13g2_nand3_1
XFILLER_84_28 VDD VSS sg13g2_decap_8
XFILLER_84_652 VDD VSS sg13g2_decap_8
X_07848_ _08643_/C _15016_/Q _07849_/B VDD VSS sg13g2_or2_1
XFILLER_56_354 VDD VSS sg13g2_fill_2
X_07779_ _07779_/Y _08318_/C _08318_/D VDD VSS sg13g2_nor2_1
XFILLER_17_77 VDD VSS sg13g2_decap_8
XFILLER_140_56 VDD VSS sg13g2_decap_8
X_14465__2099 _14465_/RESET_B VDD VSS sg13g2_tiehi
X_09518_ _14117_/D _10081_/A0 _14117_/Q _09520_/S VDD VSS sg13g2_mux2_1
X_10790_ _10790_/Y _14924_/Q _11196_/B VDD VSS sg13g2_nand2_1
XFILLER_71_368 VDD VSS sg13g2_fill_2
XFILLER_52_560 VDD VSS sg13g2_fill_2
XFILLER_33_21 VDD VSS sg13g2_decap_8
X_09449_ _14050_/D _09649_/A0 _14050_/Q _09470_/S VDD VSS sg13g2_mux2_1
XFILLER_12_424 VDD VSS sg13g2_decap_8
XFILLER_52_593 VDD VSS sg13g2_decap_8
XFILLER_149_21 VDD VSS sg13g2_decap_8
XFILLER_12_457 VDD VSS sg13g2_decap_8
X_12460_ _12460_/X _14691_/Q _14723_/Q _13763_/Q _13795_/Q _12464_/S0 _12546_/S1 VDD
+ VSS sg13g2_mux4_1
XFILLER_123_1130 VDD VSS sg13g2_fill_2
XFILLER_8_439 VDD VSS sg13g2_decap_8
XFILLER_32_1024 VDD VSS sg13g2_decap_8
X_11411_ _11411_/Y _11407_/Y _11408_/Y _11410_/Y _11409_/Y _11822_/B VDD VSS sg13g2_a221oi_1
XFILLER_21_991 VDD VSS sg13g2_decap_8
X_12391_ _12391_/X _14558_/Q _14590_/Q _14622_/Q _14654_/Q _12393_/S0 _12617_/S1 VDD
+ VSS sg13g2_mux4_1
XFILLER_138_665 VDD VSS sg13g2_decap_8
XFILLER_32_1057 VDD VSS sg13g2_fill_2
XFILLER_149_98 VDD VSS sg13g2_decap_8
XFILLER_138_676 VDD VSS sg13g2_fill_1
X_11342_ _11342_/Y _11353_/S _13822_/Q VDD VSS sg13g2_nand2b_1
XFILLER_32_1079 VDD VSS sg13g2_decap_8
X_14130_ _14130_/Q _14738_/CLK _14130_/D _14130_/RESET_B VDD VSS sg13g2_dfrbpq_1
XFILLER_138_698 VDD VSS sg13g2_fill_2
XFILLER_137_175 VDD VSS sg13g2_fill_2
XFILLER_67_1109 VDD VSS sg13g2_fill_2
XFILLER_152_112 VDD VSS sg13g2_decap_8
X_14642__1922 _14642_/RESET_B VDD VSS sg13g2_tiehi
X_11273_ _11273_/Y _11275_/S0 _14492_/Q _11894_/B VDD VSS sg13g2_a21oi_1
X_14061_ _14061_/Q _14669_/CLK _14061_/D _14061_/RESET_B VDD VSS sg13g2_dfrbpq_1
X_14969__3003 _14969_/RESET_B VDD VSS sg13g2_tiehi
XFILLER_109_0 VDD VSS sg13g2_decap_8
XFILLER_3_133 VDD VSS sg13g2_decap_8
XFILLER_152_167 VDD VSS sg13g2_decap_8
XFILLER_4_678 VDD VSS sg13g2_fill_1
XFILLER_79_402 VDD VSS sg13g2_decap_4
XFILLER_4_689 VDD VSS sg13g2_decap_8
X_13012_ _13012_/Y _13012_/A _13026_/C VDD VSS sg13g2_nor2_1
XFILLER_106_573 VDD VSS sg13g2_decap_8
X_10224_ _10227_/C _14769_/Q _10219_/X _14770_/Q VDD VSS sg13g2_a21oi_1
X_14071__2493 _14071_/RESET_B VDD VSS sg13g2_tiehi
XFILLER_79_446 VDD VSS sg13g2_fill_2
XFILLER_0_840 VDD VSS sg13g2_fill_1
XFILLER_121_554 VDD VSS sg13g2_fill_2
X_10155_ _14732_/D _14732_/Q _10155_/A1 _10160_/S VDD VSS sg13g2_mux2_1
XFILLER_0_873 VDD VSS sg13g2_fill_1
XFILLER_0_884 VDD VSS sg13g2_fill_1
X_13915__2649 _13915_/RESET_B VDD VSS sg13g2_tiehi
X_10086_ _14666_/D _10086_/A0 _14666_/Q _10096_/S VDD VSS sg13g2_mux2_1
X_14963_ _14963_/Q _15229_/CLK _14963_/D _14963_/RESET_B VDD VSS sg13g2_dfrbpq_1
X_14675__1889 _14675_/RESET_B VDD VSS sg13g2_tiehi
XFILLER_48_855 VDD VSS sg13g2_decap_8
XFILLER_130_1123 VDD VSS sg13g2_decap_8
X_15010__2962 _15010_/RESET_B VDD VSS sg13g2_tiehi
X_13914_ _13914_/Q clkload47/A _13914_/D _13914_/RESET_B VDD VSS sg13g2_dfrbpq_1
Xwire1073 wire1073/X _12595_/S VDD VSS sg13g2_buf_4
XFILLER_75_674 VDD VSS sg13g2_fill_2
X_14894_ _14894_/Q clkload70/A _14894_/D _14894_/RESET_B VDD VSS sg13g2_dfrbpq_1
XFILLER_114_90 VDD VSS sg13g2_decap_8
XFILLER_63_836 VDD VSS sg13g2_decap_4
XFILLER_130_1189 VDD VSS sg13g2_decap_8
X_13845_ _13845_/Q clkload15/A _13845_/D _13845_/RESET_B VDD VSS sg13g2_dfrbpq_1
X_13776_ _13776_/Q clkload42/A _13776_/D _13776_/RESET_B VDD VSS sg13g2_dfrbpq_1
X_10988_ _10988_/Y _15116_/Q _10995_/B VDD VSS sg13g2_nor2b_1
X_12727_ _12727_/X _13974_/Q _14006_/Q _14038_/Q _14070_/Q _12727_/S0 _12742_/S1 VDD
+ VSS sg13g2_mux4_1
XFILLER_128_1096 VDD VSS sg13g2_decap_8
XFILLER_90_82 VDD VSS sg13g2_fill_2
X_12658_ _12658_/X _13841_/Q _13873_/Q _13905_/Q _13937_/Q _12659_/S0 _12659_/S1 VDD
+ VSS sg13g2_mux4_1
X_11609_ _11609_/Y _11597_/A _14374_/Q VDD VSS sg13g2_nand2b_1
XFILLER_129_654 VDD VSS sg13g2_fill_2
XFILLER_117_805 VDD VSS sg13g2_fill_2
X_12589_ _12589_/X _14572_/Q _14604_/Q _14636_/Q _14668_/Q _12592_/S0 _12592_/S1 VDD
+ VSS sg13g2_mux4_1
X_14510__2054 _14510_/RESET_B VDD VSS sg13g2_tiehi
XFILLER_11_1119 VDD VSS sg13g2_decap_8
XFILLER_8_973 VDD VSS sg13g2_decap_8
XFILLER_50_1168 VDD VSS sg13g2_decap_8
X_14328_ _14328_/Q clkload24/A _14328_/D _14328_/RESET_B VDD VSS sg13g2_dfrbpq_1
Xwire370 wire370/X wire370/A VDD VSS sg13g2_buf_2
XFILLER_156_495 VDD VSS sg13g2_decap_4
X_14259_ _14259_/Q clkload13/A _14259_/D _14259_/RESET_B VDD VSS sg13g2_dfrbpq_1
XFILLER_143_156 VDD VSS sg13g2_fill_1
XFILLER_48_1020 VDD VSS sg13g2_decap_8
XFILLER_99_91 VDD VSS sg13g2_decap_8
XFILLER_48_1031 VDD VSS sg13g2_fill_2
XFILLER_135_1001 VDD VSS sg13g2_fill_1
Xfanout908 _13282_/A1 _12679_/C1 VDD VSS sg13g2_buf_1
XFILLER_98_755 VDD VSS sg13g2_fill_1
Xfanout919 _13274_/C1 _13248_/B VDD VSS sg13g2_buf_1
XFILLER_135_1045 VDD VSS sg13g2_fill_1
X_08820_ _08820_/Y _13482_/A _15191_/Q VDD VSS sg13g2_nand2_1
XFILLER_61_1220 VDD VSS sg13g2_decap_8
XFILLER_24_0 VDD VSS sg13g2_decap_8
X_08751_ _08751_/Y _08751_/A1 _08751_/A2 _15193_/Q VDD VSS sg13g2_o21ai_1
XFILLER_22_1226 VDD VSS sg13g2_decap_8
XFILLER_94_950 VDD VSS sg13g2_decap_8
Xfanout1490 _07879_/A _08171_/A1 VDD VSS sg13g2_buf_1
X_07702_ _07702_/X _13308_/B _10671_/B VDD VSS sg13g2_and2_1
X_15108__3130 _15108_/RESET_B VDD VSS sg13g2_tiehi
X_08682_ _08682_/Y _08678_/Y _08647_/Y _08681_/Y VDD VSS sg13g2_o21ai_1
XFILLER_65_140 VDD VSS sg13g2_decap_8
XFILLER_93_471 VDD VSS sg13g2_decap_8
XFILLER_54_836 VDD VSS sg13g2_decap_4
XFILLER_81_622 VDD VSS sg13g2_decap_8
X_07633_ _08203_/B _14995_/Q VDD VSS sg13g2_inv_1
XFILLER_0_1055 VDD VSS sg13g2_decap_8
XFILLER_0_1066 VDD VSS sg13g2_fill_1
X_14720__1844 _14720_/RESET_B VDD VSS sg13g2_tiehi
X_09303_ _13911_/D _13911_/Q _10166_/A1 _09303_/S VDD VSS sg13g2_mux2_1
XFILLER_59_1193 VDD VSS sg13g2_decap_8
XFILLER_22_733 VDD VSS sg13g2_decap_8
XFILLER_146_1174 VDD VSS sg13g2_fill_2
XFILLER_55_1068 VDD VSS sg13g2_decap_8
X_09234_ _13845_/D _10131_/A0 _13845_/Q _09239_/S VDD VSS sg13g2_mux2_1
XFILLER_142_1049 VDD VSS sg13g2_fill_1
XFILLER_148_941 VDD VSS sg13g2_fill_2
X_09165_ _09165_/Y _09157_/C _09164_/X _14925_/Q _09158_/C VDD VSS sg13g2_a22oi_1
XFILLER_147_440 VDD VSS sg13g2_fill_2
X_08116_ _08116_/Y _08183_/A _07916_/Y _08115_/Y VDD VSS sg13g2_a21oi_1
XFILLER_107_304 VDD VSS sg13g2_decap_4
XFILLER_119_35 VDD VSS sg13g2_decap_8
X_09096_ _09136_/B _14915_/Q _09103_/C _09103_/D VDD VSS sg13g2_and3_1
XFILLER_107_337 VDD VSS sg13g2_fill_2
XFILLER_134_134 VDD VSS sg13g2_decap_8
X_08047_ _08047_/Y _08046_/B _08686_/A2 _08046_/Y VDD VSS sg13g2_o21ai_1
XFILLER_102_7 VDD VSS sg13g2_decap_8
XFILLER_116_860 VDD VSS sg13g2_fill_1
XFILLER_89_711 VDD VSS sg13g2_fill_1
XFILLER_116_893 VDD VSS sg13g2_decap_4
XFILLER_122_329 VDD VSS sg13g2_decap_4
Xmax_cap692 _09236_/S _09235_/S VDD VSS sg13g2_buf_4
XFILLER_118_1221 VDD VSS sg13g2_decap_8
XFILLER_135_56 VDD VSS sg13g2_decap_8
XFILLER_49_608 VDD VSS sg13g2_fill_2
XFILLER_153_1156 VDD VSS sg13g2_decap_8
XFILLER_27_1159 VDD VSS sg13g2_decap_8
XFILLER_88_265 VDD VSS sg13g2_decap_8
X_09998_ _14581_/D _10064_/A0 _14581_/Q _10002_/S VDD VSS sg13g2_mux2_1
XFILLER_28_21 VDD VSS sg13g2_decap_8
XFILLER_76_449 VDD VSS sg13g2_fill_1
X_08949_ _08949_/Y _08954_/S _14955_/Q VDD VSS sg13g2_nand2_1
XFILLER_57_641 VDD VSS sg13g2_fill_2
XFILLER_91_408 VDD VSS sg13g2_decap_8
X_11960_ _11960_/Y _11801_/S _14480_/Q VDD VSS sg13g2_nand2b_1
XFILLER_57_674 VDD VSS sg13g2_fill_1
XFILLER_17_516 VDD VSS sg13g2_decap_8
XFILLER_57_696 VDD VSS sg13g2_decap_8
XFILLER_151_77 VDD VSS sg13g2_decap_8
X_10911_ _10911_/Y _10910_/Y _10908_/Y _10907_/Y _10924_/B1 _11207_/A2 VDD VSS sg13g2_a221oi_1
XFILLER_71_121 VDD VSS sg13g2_decap_8
X_11891_ _11891_/X _11891_/A _12317_/B VDD VSS sg13g2_and2_1
X_13630_ _13738_/D _13630_/A VDD VSS sg13g2_buf_1
X_10842_ _10843_/B _10841_/A _10841_/C _10841_/B VDD VSS sg13g2_o21ai_1
XFILLER_44_42 VDD VSS sg13g2_fill_2
XFILLER_44_379 VDD VSS sg13g2_decap_8
XFILLER_73_1102 VDD VSS sg13g2_decap_8
XFILLER_38_1233 VDD VSS sg13g2_decap_4
X_14842__3245 _14842_/RESET_B VDD VSS sg13g2_tiehi
XFILLER_13_722 VDD VSS sg13g2_fill_2
X_13561_ _13561_/X _13561_/A0 _15009_/Q _13561_/S VDD VSS sg13g2_mux2_1
X_10773_ _11164_/A _14951_/Q _08943_/A _10772_/X VDD VSS sg13g2_a21oi_1
XFILLER_73_1146 VDD VSS sg13g2_fill_2
X_12512_ _12513_/B _13682_/Q _12763_/A2 _12511_/X _12763_/B2 _07737_/Y VDD VSS sg13g2_a221oi_1
XFILLER_12_254 VDD VSS sg13g2_fill_2
X_14089__2475 _14089_/RESET_B VDD VSS sg13g2_tiehi
XFILLER_12_265 VDD VSS sg13g2_fill_1
X_13492_ _15125_/D _13492_/A VDD VSS sg13g2_inv_1
XFILLER_9_748 VDD VSS sg13g2_fill_2
XFILLER_100_70 VDD VSS sg13g2_decap_4
XFILLER_8_225 VDD VSS sg13g2_decap_4
X_15231_ _15231_/Q clkload37/A _15231_/D _15231_/RESET_B VDD VSS sg13g2_dfrbpq_1
XFILLER_138_440 VDD VSS sg13g2_fill_2
X_12443_ _14995_/D _08203_/B _12498_/C1 _12442_/Y VDD VSS sg13g2_a21oi_1
XFILLER_60_63 VDD VSS sg13g2_decap_8
X_14875__3179 _14875_/RESET_B VDD VSS sg13g2_tiehi
X_15162_ _15162_/Q clkload29/A _15162_/D _15162_/RESET_B VDD VSS sg13g2_dfrbpq_1
X_12374_ _14990_/D _13553_/A1 _12638_/A2 _12373_/Y _12372_/Y VDD VSS sg13g2_a22oi_1
XFILLER_126_646 VDD VSS sg13g2_decap_8
XFILLER_153_432 VDD VSS sg13g2_decap_8
XFILLER_5_14 VDD VSS sg13g2_decap_8
XFILLER_5_943 VDD VSS sg13g2_decap_8
X_15028__2944 _15028_/RESET_B VDD VSS sg13g2_tiehi
X_14113_ _14113_/Q clkload23/A _14113_/D _14113_/RESET_B VDD VSS sg13g2_dfrbpq_1
X_11325_ _11326_/A _11328_/S0 _14205_/Q _11416_/B VDD VSS sg13g2_a21oi_1
X_15093_ _15093_/Q clkload67/A _15093_/D _15093_/RESET_B VDD VSS sg13g2_dfrbpq_1
XFILLER_99_519 VDD VSS sg13g2_fill_1
X_11256_ _11256_/Y _11251_/Y _11252_/Y _11283_/B VDD VSS sg13g2_a21oi_1
XFILLER_141_638 VDD VSS sg13g2_decap_8
X_14044_ _14044_/Q clkload60/A _14044_/D _14044_/RESET_B VDD VSS sg13g2_dfrbpq_1
XFILLER_10_1185 VDD VSS sg13g2_decap_8
XFILLER_122_830 VDD VSS sg13g2_fill_2
X_10207_ _10207_/Y hold3406/X _07661_/Y _14762_/Q VDD VSS sg13g2_a21oi_1
X_14752__3349 _14752_/RESET_B VDD VSS sg13g2_tiehi
X_11187_ _11187_/Y _11171_/B _11181_/A _11197_/B VDD VSS sg13g2_a21oi_1
XFILLER_79_265 VDD VSS sg13g2_fill_1
XFILLER_95_714 VDD VSS sg13g2_decap_8
XFILLER_79_276 VDD VSS sg13g2_fill_2
X_10138_ _14715_/D _14715_/Q _10138_/A1 _10157_/S VDD VSS sg13g2_mux2_1
XFILLER_0_692 VDD VSS sg13g2_decap_8
X_14946_ _14946_/Q clkload19/A _14946_/D _14946_/RESET_B VDD VSS sg13g2_dfrbpq_1
X_10069_ _14650_/D _10069_/A0 _14650_/Q _10069_/S VDD VSS sg13g2_mux2_1
XFILLER_48_674 VDD VSS sg13g2_decap_8
XFILLER_36_825 VDD VSS sg13g2_decap_8
XFILLER_35_302 VDD VSS sg13g2_fill_2
X_14528__2036 _14528_/RESET_B VDD VSS sg13g2_tiehi
X_14877_ _14877_/Q clkload78/A _14877_/D _14877_/RESET_B VDD VSS sg13g2_dfrbpq_1
XFILLER_63_644 VDD VSS sg13g2_decap_4
XFILLER_91_975 VDD VSS sg13g2_fill_1
X_13828_ _13828_/Q clkload30/A _13828_/D _13828_/RESET_B VDD VSS sg13g2_dfrbpq_1
XFILLER_62_176 VDD VSS sg13g2_decap_8
X_13759_ _13759_/Q clkload52/A _13759_/D _13759_/RESET_B VDD VSS sg13g2_dfrbpq_1
X_14818__3280 _14818_/RESET_B VDD VSS sg13g2_tiehi
XFILLER_52_1219 VDD VSS sg13g2_fill_1
X_13754__2810 _13754_/RESET_B VDD VSS sg13g2_tiehi
XFILLER_15_1052 VDD VSS sg13g2_decap_8
XFILLER_89_1120 VDD VSS sg13g2_fill_2
XFILLER_129_473 VDD VSS sg13g2_decap_8
XFILLER_145_966 VDD VSS sg13g2_decap_4
Xclkbuf_leaf_2_clk_i clkload3/A clkbuf_leaf_5_clk_i/A VDD VSS sg13g2_buf_8
XFILLER_89_1197 VDD VSS sg13g2_fill_1
XFILLER_117_679 VDD VSS sg13g2_fill_1
XFILLER_137_1107 VDD VSS sg13g2_fill_2
X_14134__2430 _14134_/RESET_B VDD VSS sg13g2_tiehi
XFILLER_104_307 VDD VSS sg13g2_fill_1
X_09921_ _14506_/D _14506_/Q _09921_/A1 wire423/X VDD VSS sg13g2_mux2_1
X_13787__2777 _13787_/RESET_B VDD VSS sg13g2_tiehi
Xfanout705 _09910_/A1 _08989_/X VDD VSS sg13g2_buf_1
Xfanout716 _08039_/A _08685_/A1 VDD VSS sg13g2_buf_1
X_09852_ _14439_/D _14439_/Q _10017_/A0 _09852_/S VDD VSS sg13g2_mux2_1
Xfanout727 _13655_/S _07989_/Y VDD VSS sg13g2_buf_1
XFILLER_112_340 VDD VSS sg13g2_decap_8
Xfanout738 _13570_/S _13590_/B VDD VSS sg13g2_buf_1
X_14738__1826 _14738_/RESET_B VDD VSS sg13g2_tiehi
XFILLER_112_351 VDD VSS sg13g2_fill_1
Xfanout749 _12791_/A2 _12429_/A2 VDD VSS sg13g2_buf_1
XFILLER_58_427 VDD VSS sg13g2_fill_2
X_08803_ _08805_/A _10885_/A1 _14753_/Q _08727_/X _15196_/Q _08809_/C1 VDD VSS sg13g2_a221oi_1
XFILLER_98_596 VDD VSS sg13g2_decap_8
X_09783_ _14372_/D _09915_/A1 _14372_/Q wire629/X VDD VSS sg13g2_mux2_1
XFILLER_26_1170 VDD VSS sg13g2_decap_8
XFILLER_61_1050 VDD VSS sg13g2_decap_8
XFILLER_86_769 VDD VSS sg13g2_fill_2
XFILLER_22_1023 VDD VSS sg13g2_decap_8
X_14167__2397 _14167_/RESET_B VDD VSS sg13g2_tiehi
X_08734_ _08734_/Y _13663_/Q _08752_/B VDD VSS sg13g2_nor2_1
XFILLER_85_268 VDD VSS sg13g2_decap_8
XFILLER_100_579 VDD VSS sg13g2_decap_8
XFILLER_113_1151 VDD VSS sg13g2_fill_1
XFILLER_54_600 VDD VSS sg13g2_fill_1
XFILLER_27_825 VDD VSS sg13g2_fill_1
XFILLER_26_324 VDD VSS sg13g2_fill_2
X_08665_ _08666_/B _08663_/X _08662_/Y _08678_/B _08664_/Y VDD VSS sg13g2_a22oi_1
XFILLER_66_493 VDD VSS sg13g2_decap_8
XFILLER_121_14 VDD VSS sg13g2_decap_8
XFILLER_148_1214 VDD VSS sg13g2_decap_8
XFILLER_53_143 VDD VSS sg13g2_fill_2
XFILLER_54_666 VDD VSS sg13g2_decap_8
XFILLER_57_1119 VDD VSS sg13g2_fill_1
X_07616_ _07616_/Y _14944_/Q VDD VSS sg13g2_inv_1
XFILLER_26_379 VDD VSS sg13g2_decap_8
X_08596_ wire142/A _08596_/A _08596_/B _08596_/C _08596_/D VDD VSS sg13g2_nand4_1
X_14382__2182 _14382_/RESET_B VDD VSS sg13g2_tiehi
XFILLER_22_563 VDD VSS sg13g2_fill_1
XFILLER_14_56 VDD VSS sg13g2_decap_8
X_09217_ _13828_/D _09915_/A1 _13828_/Q _09223_/S VDD VSS sg13g2_mux2_1
XFILLER_6_707 VDD VSS sg13g2_fill_1
XFILLER_108_602 VDD VSS sg13g2_fill_2
X_09148_ _09148_/Y _09147_/B _15050_/Q _09147_/Y VDD VSS sg13g2_o21ai_1
XFILLER_136_944 VDD VSS sg13g2_fill_2
XFILLER_33_1196 VDD VSS sg13g2_fill_1
XFILLER_68_1204 VDD VSS sg13g2_decap_4
X_14974__2998 _14974_/RESET_B VDD VSS sg13g2_tiehi
XFILLER_108_646 VDD VSS sg13g2_decap_8
XFILLER_30_44 VDD VSS sg13g2_fill_1
XFILLER_108_657 VDD VSS sg13g2_fill_1
XFILLER_120_1166 VDD VSS sg13g2_decap_8
X_09079_ _09079_/Y _09100_/B _15040_/Q _09078_/Y VDD VSS sg13g2_o21ai_1
XFILLER_107_145 VDD VSS sg13g2_fill_1
XFILLER_2_913 VDD VSS sg13g2_fill_2
XFILLER_100_4 VDD VSS sg13g2_fill_1
XFILLER_107_167 VDD VSS sg13g2_decap_8
X_11110_ _11110_/Y _11106_/Y _11104_/Y _11109_/Y VDD VSS sg13g2_a21oi_1
XFILLER_1_401 VDD VSS sg13g2_decap_8
XFILLER_2_924 VDD VSS sg13g2_fill_1
XFILLER_135_498 VDD VSS sg13g2_decap_8
X_12090_ _12091_/B _12090_/A _14228_/Q VDD VSS sg13g2_nand2_1
XFILLER_146_77 VDD VSS sg13g2_fill_2
X_11041_ _11068_/A _11052_/A _11052_/B wire239/X VDD VSS sg13g2_nor3_1
XFILLER_77_703 VDD VSS sg13g2_decap_8
XFILLER_39_42 VDD VSS sg13g2_decap_8
XFILLER_103_351 VDD VSS sg13g2_decap_8
XFILLER_104_896 VDD VSS sg13g2_fill_1
XFILLER_40_1101 VDD VSS sg13g2_fill_1
XFILLER_92_706 VDD VSS sg13g2_fill_1
X_14800_ _14800_/Q clkload80/A _14800_/D _14800_/RESET_B VDD VSS sg13g2_dfrbpq_1
X_13832__2732 _13832_/RESET_B VDD VSS sg13g2_tiehi
X_12992_ _12994_/A _12993_/B _12993_/C VDD VSS sg13g2_nand2_1
X_14592__1972 _14592_/RESET_B VDD VSS sg13g2_tiehi
XFILLER_29_173 VDD VSS sg13g2_fill_1
X_14731_ _14731_/Q _14731_/CLK _14731_/D _14731_/RESET_B VDD VSS sg13g2_dfrbpq_1
X_11943_ _11943_/Y _11969_/A _14224_/Q _12023_/B VDD VSS sg13g2_a21oi_1
XFILLER_17_335 VDD VSS sg13g2_decap_8
XFILLER_40_1189 VDD VSS sg13g2_fill_1
XFILLER_45_655 VDD VSS sg13g2_fill_2
X_14662_ _14662_/Q _14662_/CLK _14662_/D _14662_/RESET_B VDD VSS sg13g2_dfrbpq_1
X_11874_ _11875_/A _14702_/Q _14734_/Q _13774_/Q _13806_/Q _11882_/S0 _11374_/C VDD
+ VSS sg13g2_mux4_1
X_13613_ wire555/A _13613_/A _13613_/B _13613_/C _13613_/D VDD VSS sg13g2_nor4_1
XFILLER_38_1041 VDD VSS sg13g2_decap_8
X_10825_ _14928_/D _14928_/Q _10800_/B _10824_/Y VDD VSS sg13g2_a21o_1
X_14593_ _14593_/Q clkload20/A _14593_/D _14593_/RESET_B VDD VSS sg13g2_dfrbpq_1
X_14212__2352 _14212_/RESET_B VDD VSS sg13g2_tiehi
X_13865__2699 _13865_/RESET_B VDD VSS sg13g2_tiehi
X_13544_ _15146_/D _13560_/S _13542_/Y _13543_/Y VDD VSS sg13g2_a21oi_1
XFILLER_41_872 VDD VSS sg13g2_decap_8
X_10756_ _14916_/D _10756_/A VDD VSS sg13g2_inv_1
XFILLER_9_534 VDD VSS sg13g2_fill_2
XFILLER_146_719 VDD VSS sg13g2_fill_1
X_13475_ _15178_/D hold3413/X _15178_/Q _13479_/S VDD VSS sg13g2_mux2_1
XFILLER_145_207 VDD VSS sg13g2_decap_8
X_10687_ _10876_/A _08992_/B _10691_/S _08852_/Y VDD VSS sg13g2_a21oi_1
XFILLER_12_1214 VDD VSS sg13g2_decap_8
X_15214_ _15214_/Q _15214_/CLK _15214_/D _15214_/RESET_B VDD VSS sg13g2_dfrbpq_1
X_12426_ _12426_/X _12423_/X _12422_/X _12419_/X _12418_/X _12747_/S1 _12553_/S VDD
+ VSS sg13g2_mux4_1
Xmax_cap1545 output56/A _16880_/A VDD VSS sg13g2_buf_4
XFILLER_126_410 VDD VSS sg13g2_fill_1
XFILLER_65_7 VDD VSS sg13g2_decap_8
Xmax_cap1556 _16869_/A _13707_/Q VDD VSS sg13g2_buf_8
Xmax_cap1578 _12076_/S1 _11446_/A VDD VSS sg13g2_buf_4
XFILLER_142_903 VDD VSS sg13g2_fill_1
X_15145_ _15145_/Q _15148_/CLK _15145_/D _15145_/RESET_B VDD VSS sg13g2_dfrbpq_1
XFILLER_127_977 VDD VSS sg13g2_decap_8
X_12357_ _12358_/B _12348_/A _15126_/Q VDD VSS sg13g2_nand2b_1
XFILLER_153_273 VDD VSS sg13g2_decap_8
XFILLER_113_104 VDD VSS sg13g2_decap_8
X_11308_ _11308_/Y _11310_/A1 _14077_/Q _11391_/B VDD VSS sg13g2_a21oi_1
XFILLER_142_947 VDD VSS sg13g2_decap_8
XFILLER_4_261 VDD VSS sg13g2_decap_8
X_15076_ _15076_/Q clkload66/A _15076_/D _15076_/RESET_B VDD VSS sg13g2_dfrbpq_1
XFILLER_114_649 VDD VSS sg13g2_fill_2
X_12288_ _12288_/X _14265_/Q _14297_/Q _14329_/Q _14361_/Q _12288_/S0 _12288_/S1 VDD
+ VSS sg13g2_mux4_1
XFILLER_107_690 VDD VSS sg13g2_decap_8
XFILLER_45_1023 VDD VSS sg13g2_fill_1
X_14027_ _14027_/Q _14667_/CLK _14027_/D _14027_/RESET_B VDD VSS sg13g2_dfrbpq_1
X_11239_ _11239_/Y _12866_/A _15123_/Q _07684_/B VDD VSS sg13g2_o21ai_1
XFILLER_122_671 VDD VSS sg13g2_decap_8
XFILLER_132_1004 VDD VSS sg13g2_fill_1
XFILLER_132_1037 VDD VSS sg13g2_decap_8
XFILLER_45_1089 VDD VSS sg13g2_fill_1
XFILLER_110_855 VDD VSS sg13g2_decap_8
XFILLER_132_1048 VDD VSS sg13g2_decap_8
XFILLER_49_972 VDD VSS sg13g2_decap_8
XFILLER_55_408 VDD VSS sg13g2_fill_1
XFILLER_82_205 VDD VSS sg13g2_decap_4
XFILLER_83_728 VDD VSS sg13g2_decap_8
XFILLER_48_471 VDD VSS sg13g2_decap_4
X_14929_ _14929_/Q clkload63/A _14929_/D _14929_/RESET_B VDD VSS sg13g2_dfrbpq_1
X_15051__2908 _15051_/RESET_B VDD VSS sg13g2_tiehi
XFILLER_35_121 VDD VSS sg13g2_decap_8
XFILLER_91_761 VDD VSS sg13g2_fill_1
X_08450_ _08462_/A _07948_/A _08448_/Y _08449_/Y VDD VSS sg13g2_o21ai_1
XFILLER_91_772 VDD VSS sg13g2_fill_1
X_08381_ _08381_/Y _08381_/A _08688_/D _08688_/A _08688_/B VDD VSS sg13g2_nand4_1
XFILLER_51_647 VDD VSS sg13g2_decap_4
XFILLER_56_1152 VDD VSS sg13g2_fill_2
XFILLER_108_1220 VDD VSS sg13g2_decap_8
XFILLER_32_850 VDD VSS sg13g2_decap_8
XFILLER_91_0 VDD VSS sg13g2_decap_8
XFILLER_149_524 VDD VSS sg13g2_decap_8
XFILLER_50_179 VDD VSS sg13g2_decap_8
X_14956__3017 _14956_/RESET_B VDD VSS sg13g2_tiehi
XFILLER_56_1196 VDD VSS sg13g2_fill_1
XFILLER_17_1169 VDD VSS sg13g2_decap_8
XFILLER_118_900 VDD VSS sg13g2_decap_8
XFILLER_136_207 VDD VSS sg13g2_decap_8
X_09002_ _13761_/D _13761_/Q _10144_/A1 _09153_/S VDD VSS sg13g2_mux2_1
XFILLER_118_944 VDD VSS sg13g2_decap_8
XFILLER_133_914 VDD VSS sg13g2_fill_1
X_13910__2654 _13910_/RESET_B VDD VSS sg13g2_tiehi
XFILLER_118_999 VDD VSS sg13g2_decap_8
X_14670__1894 _14670_/RESET_B VDD VSS sg13g2_tiehi
XFILLER_145_785 VDD VSS sg13g2_decap_8
XFILLER_133_925 VDD VSS sg13g2_decap_8
XFILLER_104_126 VDD VSS sg13g2_fill_2
XFILLER_116_14 VDD VSS sg13g2_decap_8
Xfanout502 _09270_/S _09271_/S VDD VSS sg13g2_buf_1
X_09904_ _14490_/D _10136_/A0 _14490_/Q _09904_/S VDD VSS sg13g2_mux2_1
Xfanout513 _09196_/S wire519/X VDD VSS sg13g2_buf_1
XFILLER_59_714 VDD VSS sg13g2_decap_8
XFILLER_141_980 VDD VSS sg13g2_fill_2
Xfanout535 _10143_/A1 _09680_/A0 VDD VSS sg13g2_buf_1
Xfanout546 _09127_/S wire552/X VDD VSS sg13g2_buf_1
XFILLER_98_382 VDD VSS sg13g2_decap_8
X_09835_ _14423_/D _09934_/A1 _14423_/Q _09835_/S VDD VSS sg13g2_mux2_1
XFILLER_58_224 VDD VSS sg13g2_decap_8
XFILLER_98_393 VDD VSS sg13g2_fill_1
XFILLER_74_706 VDD VSS sg13g2_fill_2
XFILLER_6_1061 VDD VSS sg13g2_decap_8
X_09766_ _14356_/D _14356_/Q _09898_/A0 _09766_/S VDD VSS sg13g2_mux2_1
XFILLER_74_728 VDD VSS sg13g2_decap_8
XFILLER_100_376 VDD VSS sg13g2_decap_4
XFILLER_132_35 VDD VSS sg13g2_decap_8
X_08717_ _15191_/D input18/X _15191_/Q _13340_/S VDD VSS sg13g2_mux2_1
XFILLER_55_953 VDD VSS sg13g2_decap_8
X_09697_ _14289_/D _09730_/A0 _14289_/Q _09706_/S VDD VSS sg13g2_mux2_1
XFILLER_92_39 VDD VSS sg13g2_fill_2
XFILLER_55_986 VDD VSS sg13g2_decap_4
X_08648_ _08662_/B _07867_/D _07960_/Y _07969_/D VDD VSS sg13g2_o21ai_1
XFILLER_55_997 VDD VSS sg13g2_decap_8
XFILLER_82_772 VDD VSS sg13g2_decap_8
XFILLER_26_176 VDD VSS sg13g2_fill_2
XFILLER_70_934 VDD VSS sg13g2_decap_8
XFILLER_74_1230 VDD VSS sg13g2_decap_8
X_08579_ _08579_/Y _08641_/D _08578_/Y _08395_/A VDD VSS sg13g2_a21oi_1
XFILLER_25_77 VDD VSS sg13g2_decap_8
Xclkbuf_leaf_103_clk_i clkload31/A clkbuf_5_12__f_clk_i/X VDD VSS sg13g2_buf_8
XFILLER_70_989 VDD VSS sg13g2_fill_2
X_10610_ _10611_/A _14879_/Q _14878_/Q _14877_/Q _10610_/D VDD VSS sg13g2_nand4_1
XFILLER_35_1236 VDD VSS sg13g2_fill_1
X_11590_ _11590_/Y _11591_/A _13682_/Q VDD VSS sg13g2_nor2_1
XFILLER_70_1138 VDD VSS sg13g2_decap_4
XFILLER_122_1217 VDD VSS sg13g2_decap_8
XFILLER_41_21 VDD VSS sg13g2_fill_2
X_10541_ _14862_/D _13273_/A _10547_/D _10540_/Y VDD VSS sg13g2_a21oi_1
Xwire947 wire947/X wire947/A VDD VSS sg13g2_buf_2
X_13260_ _13260_/Y _14861_/Q _13260_/B VDD VSS sg13g2_nand2_1
X_10472_ _14845_/D _10492_/C _10490_/A _10472_/C VDD VSS sg13g2_nor3_1
XFILLER_109_944 VDD VSS sg13g2_fill_2
Xclkbuf_leaf_118_clk_i clkload21/A clkbuf_5_8__f_clk_i/X VDD VSS sg13g2_buf_8
XFILLER_68_1001 VDD VSS sg13g2_decap_4
X_12211_ _12211_/X _14583_/Q _14615_/Q _14647_/Q _14679_/Q _12215_/S0 _12215_/S1 VDD
+ VSS sg13g2_mux4_1
XFILLER_109_977 VDD VSS sg13g2_decap_8
X_13191_ _13191_/Y _13191_/A _13202_/A _13191_/C _13247_/D VDD VSS sg13g2_nand4_1
XFILLER_124_914 VDD VSS sg13g2_decap_8
XFILLER_124_925 VDD VSS sg13g2_fill_2
XFILLER_108_487 VDD VSS sg13g2_decap_4
XFILLER_151_733 VDD VSS sg13g2_decap_8
X_12142_ _12143_/B _12133_/X _12134_/X _12139_/X _12140_/X _12290_/S0 _12290_/S1 VDD
+ VSS sg13g2_mux4_1
XFILLER_155_1026 VDD VSS sg13g2_fill_1
XFILLER_29_1029 VDD VSS sg13g2_decap_8
XFILLER_151_755 VDD VSS sg13g2_decap_8
XFILLER_97_809 VDD VSS sg13g2_fill_1
XFILLER_150_232 VDD VSS sg13g2_decap_4
XFILLER_150_254 VDD VSS sg13g2_fill_2
X_12073_ _12073_/X _14707_/Q _14739_/Q _13779_/Q _13811_/Q _12073_/S0 _12073_/S1 VDD
+ VSS sg13g2_mux4_1
XFILLER_96_319 VDD VSS sg13g2_fill_2
XFILLER_1_286 VDD VSS sg13g2_fill_2
X_11024_ _11064_/B _15118_/Q _11052_/A VDD VSS sg13g2_xnor2_1
XFILLER_103_170 VDD VSS sg13g2_fill_1
X_16881_ _16881_/X _16881_/A VDD VSS sg13g2_buf_1
XFILLER_89_393 VDD VSS sg13g2_decap_4
XFILLER_103_192 VDD VSS sg13g2_fill_2
XFILLER_49_257 VDD VSS sg13g2_fill_2
XFILLER_92_514 VDD VSS sg13g2_fill_1
XFILLER_64_238 VDD VSS sg13g2_decap_4
X_12975_ _12975_/X _12988_/D _12975_/B VDD VSS sg13g2_xor2_1
XFILLER_73_750 VDD VSS sg13g2_fill_1
XFILLER_92_569 VDD VSS sg13g2_fill_2
XFILLER_61_901 VDD VSS sg13g2_decap_4
X_14714_ _14714_/Q _14714_/CLK _14714_/D _14714_/RESET_B VDD VSS sg13g2_dfrbpq_1
X_11926_ _11927_/B _11918_/X _11919_/X _11924_/X _11925_/X _11928_/S0 _12076_/S1 VDD
+ VSS sg13g2_mux4_1
XFILLER_33_625 VDD VSS sg13g2_fill_1
XFILLER_18_699 VDD VSS sg13g2_decap_8
XFILLER_33_636 VDD VSS sg13g2_fill_1
XFILLER_60_422 VDD VSS sg13g2_fill_2
XFILLER_127_1117 VDD VSS sg13g2_decap_8
X_14645_ _14645_/Q clkload43/A _14645_/D _14645_/RESET_B VDD VSS sg13g2_dfrbpq_1
X_11857_ _11857_/X _11849_/X _11850_/X _11853_/X _11854_/X _11422_/B _11424_/B VDD
+ VSS sg13g2_mux4_1
XFILLER_60_455 VDD VSS sg13g2_fill_1
XFILLER_60_466 VDD VSS sg13g2_decap_8
X_10808_ _10809_/B _12346_/A _10807_/B _10807_/C VDD VSS sg13g2_a21oi_1
XFILLER_32_179 VDD VSS sg13g2_fill_1
X_14576_ _14576_/Q clkload50/A _14576_/D _14576_/RESET_B VDD VSS sg13g2_dfrbpq_1
X_11788_ _11788_/X _13963_/Q _13995_/Q _14027_/Q _14059_/Q _12286_/S0 _12286_/S1 VDD
+ VSS sg13g2_mux4_1
X_13527_ _13527_/Y _15142_/Q _13539_/B VDD VSS sg13g2_nor2_1
X_10739_ _11052_/B _07616_/Y _09079_/Y _10788_/S VDD VSS sg13g2_mux2_1
XFILLER_119_719 VDD VSS sg13g2_decap_8
XFILLER_9_375 VDD VSS sg13g2_decap_8
X_14478__2086 _14478_/RESET_B VDD VSS sg13g2_tiehi
XFILLER_16_1191 VDD VSS sg13g2_decap_8
X_13458_ _13458_/Y _13465_/A1 _08723_/B _12851_/B VDD VSS sg13g2_o21ai_1
X_12409_ _12409_/X _13727_/Q _14079_/Q _14431_/Q _14527_/Q _12604_/S0 _12604_/S1 VDD
+ VSS sg13g2_mux4_1
Xmax_cap1375 _08559_/S1 _08235_/S0 VDD VSS sg13g2_buf_4
Xoutput105 mem_axi_wdata[10] _15142_/Q VDD VSS sg13g2_buf_1
X_13389_ _13389_/Y _13401_/C _13389_/B _13438_/B _13391_/C VDD VSS sg13g2_nor4_1
XFILLER_12_1088 VDD VSS sg13g2_decap_8
Xoutput116 mem_axi_wdata[20] _15152_/Q VDD VSS sg13g2_buf_1
Xoutput127 mem_axi_wdata[30] _15162_/Q VDD VSS sg13g2_buf_1
XFILLER_141_210 VDD VSS sg13g2_decap_8
Xoutput138 mem_axi_wstrb[2] _15166_/Q VDD VSS sg13g2_buf_1
X_15128_ _15128_/Q clkload72/A _15128_/D _15128_/RESET_B VDD VSS sg13g2_dfrbpq_1
XFILLER_114_435 VDD VSS sg13g2_fill_1
Xclkbuf_leaf_82_clk_i _15200_/CLK clkbuf_leaf_82_clk_i/A VDD VSS sg13g2_buf_8
XFILLER_114_446 VDD VSS sg13g2_decap_8
XFILLER_99_157 VDD VSS sg13g2_decap_8
XFILLER_142_777 VDD VSS sg13g2_decap_8
X_07950_ _07950_/Y _07950_/A _07950_/B _07950_/C VDD VSS sg13g2_nand3_1
X_15059_ _15059_/Q _15250_/CLK _15059_/D _15059_/RESET_B VDD VSS sg13g2_dfrbpq_1
XFILLER_96_820 VDD VSS sg13g2_decap_4
XFILLER_101_107 VDD VSS sg13g2_decap_4
XFILLER_68_544 VDD VSS sg13g2_decap_8
X_07881_ _08073_/A _08079_/S _13609_/A VDD VSS sg13g2_nand2_1
XFILLER_96_853 VDD VSS sg13g2_decap_4
XFILLER_110_630 VDD VSS sg13g2_decap_8
XFILLER_122_490 VDD VSS sg13g2_decap_8
X_09620_ _14216_/D _09655_/A0 _14216_/Q _09622_/S VDD VSS sg13g2_mux2_1
Xclkbuf_leaf_97_clk_i _14465_/CLK clkbuf_leaf_97_clk_i/A VDD VSS sg13g2_buf_8
XFILLER_95_363 VDD VSS sg13g2_decap_8
XFILLER_23_1140 VDD VSS sg13g2_decap_8
XFILLER_3_1223 VDD VSS sg13g2_decap_8
XFILLER_55_227 VDD VSS sg13g2_decap_8
XFILLER_49_791 VDD VSS sg13g2_decap_8
X_09551_ _14149_/D _09850_/A1 _14149_/Q _09553_/S VDD VSS sg13g2_mux2_1
X_14084__2480 _14084_/RESET_B VDD VSS sg13g2_tiehi
XFILLER_37_964 VDD VSS sg13g2_decap_4
XFILLER_48_290 VDD VSS sg13g2_decap_8
XFILLER_36_452 VDD VSS sg13g2_fill_1
X_08502_ _08502_/Y _07636_/Y _07819_/B wire233/X _07829_/B _07950_/Y VDD VSS sg13g2_a221oi_1
X_09482_ _14082_/D _10078_/A0 _14082_/Q _09490_/S VDD VSS sg13g2_mux2_1
XFILLER_51_400 VDD VSS sg13g2_fill_2
Xclkbuf_leaf_20_clk_i clkload46/A clkbuf_leaf_52_clk_i/A VDD VSS sg13g2_buf_8
XFILLER_91_580 VDD VSS sg13g2_decap_8
XFILLER_36_496 VDD VSS sg13g2_decap_8
XFILLER_91_591 VDD VSS sg13g2_fill_1
X_08433_ _08441_/A _07799_/X _08541_/A _08432_/Y _07798_/X _08431_/X VDD VSS sg13g2_a221oi_1
X_13928__2636 _13928_/RESET_B VDD VSS sg13g2_tiehi
XFILLER_52_967 VDD VSS sg13g2_decap_8
XFILLER_24_669 VDD VSS sg13g2_decap_8
X_15163__3016 _15163_/RESET_B VDD VSS sg13g2_tiehi
X_14688__1876 _14688_/RESET_B VDD VSS sg13g2_tiehi
XFILLER_149_310 VDD VSS sg13g2_decap_8
X_08364_ _08373_/B _08637_/B _08363_/X _08361_/Y VDD VSS sg13g2_a21oi_1
XFILLER_149_321 VDD VSS sg13g2_fill_2
Xclkbuf_leaf_35_clk_i _14669_/CLK clkbuf_leaf_38_clk_i/A VDD VSS sg13g2_buf_8
XFILLER_31_190 VDD VSS sg13g2_decap_8
X_08295_ _08295_/Y _08276_/A _08276_/B _08289_/Y VDD VSS sg13g2_o21ai_1
XFILLER_137_527 VDD VSS sg13g2_fill_2
XFILLER_30_1111 VDD VSS sg13g2_decap_8
X_14308__2256 _14308_/RESET_B VDD VSS sg13g2_tiehi
XFILLER_30_1144 VDD VSS sg13g2_decap_8
XFILLER_11_35 VDD VSS sg13g2_decap_8
XFILLER_145_560 VDD VSS sg13g2_fill_2
XFILLER_127_35 VDD VSS sg13g2_decap_8
XFILLER_106_958 VDD VSS sg13g2_decap_8
XFILLER_117_295 VDD VSS sg13g2_fill_2
XFILLER_79_809 VDD VSS sg13g2_decap_8
XFILLER_105_457 VDD VSS sg13g2_fill_2
X_14523__2041 _14523_/RESET_B VDD VSS sg13g2_tiehi
XFILLER_114_980 VDD VSS sg13g2_decap_8
Xfanout1308 _10137_/A _09806_/A VDD VSS sg13g2_buf_1
Xfanout1319 _09100_/B _09155_/A1 VDD VSS sg13g2_buf_1
XFILLER_99_680 VDD VSS sg13g2_decap_4
Xfanout332 _09578_/S _09605_/S VDD VSS sg13g2_buf_1
XFILLER_28_1073 VDD VSS sg13g2_decap_4
XFILLER_59_533 VDD VSS sg13g2_decap_8
XFILLER_101_630 VDD VSS sg13g2_decap_8
Xfanout354 _10147_/A1 _09019_/Y VDD VSS sg13g2_buf_1
XFILLER_101_641 VDD VSS sg13g2_fill_2
XFILLER_154_1092 VDD VSS sg13g2_decap_8
XFILLER_8_1167 VDD VSS sg13g2_decap_8
XFILLER_143_56 VDD VSS sg13g2_decap_8
XFILLER_143_67 VDD VSS sg13g2_fill_1
X_09818_ _14406_/D _09884_/A0 _14406_/Q _09831_/S VDD VSS sg13g2_mux2_1
XFILLER_74_503 VDD VSS sg13g2_fill_1
XFILLER_87_886 VDD VSS sg13g2_fill_1
X_14777__3321 _14777_/RESET_B VDD VSS sg13g2_tiehi
XFILLER_46_216 VDD VSS sg13g2_decap_8
XFILLER_101_696 VDD VSS sg13g2_decap_4
XFILLER_115_1087 VDD VSS sg13g2_decap_8
XFILLER_28_931 VDD VSS sg13g2_decap_8
XFILLER_28_953 VDD VSS sg13g2_fill_1
X_09749_ _14339_/D _14339_/Q _09914_/A1 _09765_/S VDD VSS sg13g2_mux2_1
XFILLER_36_21 VDD VSS sg13g2_fill_1
X_12760_ _12760_/X _12757_/X _12756_/X _12753_/X _12752_/X _12760_/S0 _12734_/S VDD
+ VSS sg13g2_mux4_1
X_11711_ _11711_/X _14697_/Q _14729_/Q _13769_/Q _13801_/Q _11711_/S0 _11714_/S1 VDD
+ VSS sg13g2_mux4_1
X_12691_ _12691_/X _12683_/X _12687_/X _12682_/X _12686_/X _12691_/S0 wire1081/X VDD
+ VSS sg13g2_mux4_1
X_14430_ _14430_/Q clkload59/A _14430_/D _14430_/RESET_B VDD VSS sg13g2_dfrbpq_1
XFILLER_30_617 VDD VSS sg13g2_fill_1
X_11642_ _11663_/B _11643_/B _11643_/A VDD VSS sg13g2_nand2_1
XFILLER_39_1191 VDD VSS sg13g2_decap_4
XFILLER_35_1033 VDD VSS sg13g2_decap_8
XFILLER_42_499 VDD VSS sg13g2_decap_8
XFILLER_126_1161 VDD VSS sg13g2_fill_2
XFILLER_139_0 VDD VSS sg13g2_decap_8
Xwire700 wire700/X wire700/A VDD VSS sg13g2_buf_8
X_14361_ _14361_/Q clkload42/A _14361_/D _14361_/RESET_B VDD VSS sg13g2_dfrbpq_1
XFILLER_122_1003 VDD VSS sg13g2_decap_8
X_11573_ _11573_/X _14565_/Q _14597_/Q _14629_/Q _14661_/Q _11578_/S0 _11580_/S1 VDD
+ VSS sg13g2_mux4_1
XFILLER_156_825 VDD VSS sg13g2_fill_2
X_13782__2782 _13782_/RESET_B VDD VSS sg13g2_tiehi
XFILLER_35_1077 VDD VSS sg13g2_fill_2
Xinput18 input18/X input18/A VDD VSS sg13g2_buf_1
X_13312_ _13312_/Y _13312_/A _10670_/A VDD VSS sg13g2_nor2b_1
Xinput29 input29/X input29/A VDD VSS sg13g2_buf_1
X_10524_ _10543_/C _10538_/A _10538_/B _10567_/A VDD VSS sg13g2_nor3_1
XFILLER_6_323 VDD VSS sg13g2_decap_4
X_14292_ _14292_/Q _14726_/CLK _14292_/D _14292_/RESET_B VDD VSS sg13g2_dfrbpq_1
XFILLER_156_869 VDD VSS sg13g2_fill_2
X_14733__1831 _14733_/RESET_B VDD VSS sg13g2_tiehi
XFILLER_155_368 VDD VSS sg13g2_fill_2
XFILLER_7_879 VDD VSS sg13g2_fill_2
XFILLER_6_356 VDD VSS sg13g2_decap_8
X_13243_ _13243_/Y _13244_/B _13246_/C VDD VSS sg13g2_nand2_1
XFILLER_108_240 VDD VSS sg13g2_fill_2
X_10455_ _10455_/Y _14841_/Q _10462_/D _10295_/C VDD VSS sg13g2_o21ai_1
XFILLER_123_210 VDD VSS sg13g2_decap_8
X_13174_ _13174_/Y _13174_/A _13174_/B VDD VSS sg13g2_nor2_1
X_10386_ _14819_/D _10602_/A _10386_/B _10386_/C VDD VSS sg13g2_nor3_1
X_14940__3049 _14940_/RESET_B VDD VSS sg13g2_tiehi
XFILLER_124_755 VDD VSS sg13g2_fill_1
X_12125_ _14982_/D _12125_/A _12125_/B VDD VSS sg13g2_nor2_1
XFILLER_124_788 VDD VSS sg13g2_decap_4
XFILLER_117_90 VDD VSS sg13g2_decap_8
X_12056_ _12056_/X _12056_/A _12056_/B _12056_/C VDD VSS sg13g2_and3_1
XFILLER_28_7 VDD VSS sg13g2_decap_8
XFILLER_104_490 VDD VSS sg13g2_decap_8
XFILLER_78_875 VDD VSS sg13g2_fill_2
X_11007_ _11010_/A _11007_/A _11007_/B VDD VSS sg13g2_or2_1
XFILLER_120_972 VDD VSS sg13g2_fill_1
XFILLER_42_1048 VDD VSS sg13g2_decap_8
X_16864_ _16864_/X _16864_/A VDD VSS sg13g2_buf_1
XFILLER_19_953 VDD VSS sg13g2_decap_8
XFILLER_92_344 VDD VSS sg13g2_decap_8
XFILLER_80_506 VDD VSS sg13g2_decap_8
X_12958_ _12961_/C _12959_/A1 _12942_/B _12945_/Y VDD VSS sg13g2_a21oi_1
XFILLER_18_485 VDD VSS sg13g2_fill_1
XFILLER_80_539 VDD VSS sg13g2_fill_1
XFILLER_73_591 VDD VSS sg13g2_decap_4
X_11909_ _11913_/A _11864_/Y _11908_/Y _11907_/X VDD VSS sg13g2_o21ai_1
X_12889_ _12889_/Y _12874_/A _12877_/C _12872_/X VDD VSS sg13g2_a21oi_1
XFILLER_21_606 VDD VSS sg13g2_decap_8
X_14628_ _14628_/Q clkload36/A _14628_/D _14628_/RESET_B VDD VSS sg13g2_dfrbpq_1
XFILLER_61_786 VDD VSS sg13g2_decap_4
XFILLER_105_1201 VDD VSS sg13g2_decap_8
XFILLER_14_1106 VDD VSS sg13g2_decap_8
X_14559_ _14559_/Q clkload55/A _14559_/D _14559_/RESET_B VDD VSS sg13g2_dfrbpq_1
XFILLER_119_505 VDD VSS sg13g2_fill_1
XFILLER_140_1125 VDD VSS sg13g2_decap_8
XFILLER_9_150 VDD VSS sg13g2_decap_8
X_08080_ _08080_/Y _08048_/A _07972_/B _08079_/S VDD VSS sg13g2_a21oi_1
XFILLER_9_194 VDD VSS sg13g2_fill_2
XFILLER_134_508 VDD VSS sg13g2_fill_1
Xmax_cap1183 _12715_/S0 _12770_/S0 VDD VSS sg13g2_buf_4
XFILLER_54_0 VDD VSS sg13g2_decap_8
XFILLER_115_722 VDD VSS sg13g2_decap_4
Xhold3405 input2/A mem_axi_awready VDD VSS sg13g2_dlygate4sd3_1
Xhold3416 input33/A mem_axi_rdata[7] VDD VSS sg13g2_dlygate4sd3_1
XFILLER_88_628 VDD VSS sg13g2_decap_4
Xhold3427 hold3427/X input15/X VDD VSS sg13g2_dlygate4sd3_1
XFILLER_87_105 VDD VSS sg13g2_fill_1
X_08982_ _08982_/Y _10681_/A _10674_/A _08981_/Y VDD VSS sg13g2_a21oi_1
Xhold3438 input19/A mem_axi_rdata[23] VDD VSS sg13g2_dlygate4sd3_1
Xhold3449 hold3449/X input12/X VDD VSS sg13g2_dlygate4sd3_1
XFILLER_102_427 VDD VSS sg13g2_fill_1
XFILLER_69_831 VDD VSS sg13g2_decap_8
XFILLER_114_298 VDD VSS sg13g2_decap_8
XFILLER_151_1210 VDD VSS sg13g2_decap_8
X_07933_ _07933_/Y _15002_/Q _07782_/A VDD VSS sg13g2_nor2b_1
XFILLER_87_149 VDD VSS sg13g2_decap_8
XFILLER_25_1235 VDD VSS sg13g2_fill_2
XFILLER_111_961 VDD VSS sg13g2_decap_8
XFILLER_68_363 VDD VSS sg13g2_decap_8
X_07864_ _07864_/Y _08608_/A _08608_/B _08641_/C VDD VSS sg13g2_o21ai_1
XFILLER_29_728 VDD VSS sg13g2_fill_1
XFILLER_28_205 VDD VSS sg13g2_decap_8
XFILLER_3_91 VDD VSS sg13g2_decap_8
XFILLER_56_514 VDD VSS sg13g2_decap_8
XFILLER_95_160 VDD VSS sg13g2_decap_8
XFILLER_96_694 VDD VSS sg13g2_decap_8
X_09603_ _14200_/D _14200_/Q _09902_/A0 wire337/X VDD VSS sg13g2_mux2_1
XFILLER_28_238 VDD VSS sg13g2_fill_1
XFILLER_3_1020 VDD VSS sg13g2_fill_2
XFILLER_95_193 VDD VSS sg13g2_decap_8
XFILLER_83_344 VDD VSS sg13g2_decap_4
X_07795_ _07797_/D _07795_/A _08414_/C VDD VSS sg13g2_nand2_1
XFILLER_37_750 VDD VSS sg13g2_decap_8
XFILLER_58_1000 VDD VSS sg13g2_fill_2
X_09534_ _14133_/D _10064_/A0 _14133_/Q _09538_/S VDD VSS sg13g2_mux2_1
XFILLER_36_260 VDD VSS sg13g2_decap_8
XFILLER_3_1097 VDD VSS sg13g2_decap_8
XFILLER_64_591 VDD VSS sg13g2_decap_4
X_09465_ _14066_/D _09962_/A1 _14066_/Q _09472_/S VDD VSS sg13g2_mux2_1
XFILLER_145_1025 VDD VSS sg13g2_decap_8
XFILLER_145_1036 VDD VSS sg13g2_fill_1
X_08416_ _08575_/A _08418_/B _08417_/B VDD VSS sg13g2_and2_1
XFILLER_12_617 VDD VSS sg13g2_fill_1
XFILLER_58_1099 VDD VSS sg13g2_decap_8
XFILLER_71_1200 VDD VSS sg13g2_decap_8
XFILLER_11_105 VDD VSS sg13g2_fill_2
X_09396_ _13999_/D _09992_/A0 _13999_/Q _09406_/S VDD VSS sg13g2_mux2_1
XFILLER_138_814 VDD VSS sg13g2_fill_2
X_08347_ _08347_/Y _08359_/B2 _08336_/Y _08341_/Y _08637_/B _08346_/Y VDD VSS sg13g2_a221oi_1
XFILLER_132_7 VDD VSS sg13g2_decap_8
XFILLER_7_109 VDD VSS sg13g2_fill_1
XFILLER_137_335 VDD VSS sg13g2_fill_1
XFILLER_22_56 VDD VSS sg13g2_decap_8
X_08278_ _08279_/A _08337_/A3 _08327_/A3 _08300_/A3 _08278_/A3 _08457_/S0 _08598_/S1
+ VDD VSS sg13g2_mux4_1
XFILLER_138_56 VDD VSS sg13g2_decap_8
XFILLER_4_805 VDD VSS sg13g2_decap_4
XFILLER_118_560 VDD VSS sg13g2_decap_4
XFILLER_146_891 VDD VSS sg13g2_fill_1
XFILLER_4_849 VDD VSS sg13g2_decap_8
XFILLER_98_49 VDD VSS sg13g2_fill_1
X_10240_ _10250_/D _14775_/Q wire762/X VDD VSS sg13g2_and2_1
XFILLER_69_1162 VDD VSS sg13g2_fill_1
XFILLER_69_1184 VDD VSS sg13g2_decap_8
X_10171_ _10178_/A _15054_/Q _13281_/B _10177_/B _10171_/D VDD VSS sg13g2_or4_1
XFILLER_65_1048 VDD VSS sg13g2_fill_1
Xfanout1105 _12685_/S1 _12740_/S1 VDD VSS sg13g2_buf_1
Xfanout1116 _12536_/S1 _12480_/S1 VDD VSS sg13g2_buf_1
XFILLER_154_77 VDD VSS sg13g2_decap_8
Xfanout1127 _12675_/S1 fanout1128/X VDD VSS sg13g2_buf_1
Xfanout1138 _12620_/S1 _12782_/S1 VDD VSS sg13g2_buf_1
Xfanout151 _09970_/A1 _10069_/A0 VDD VSS sg13g2_buf_1
Xfanout162 _10100_/A0 _10167_/A1 VDD VSS sg13g2_buf_1
X_13930_ _13930_/Q clkload21/A _13930_/D _13930_/RESET_B VDD VSS sg13g2_dfrbpq_1
XFILLER_102_972 VDD VSS sg13g2_decap_4
Xfanout173 _10064_/A0 _10097_/A0 VDD VSS sg13g2_buf_1
Xfanout184 _10062_/A0 _10162_/A1 VDD VSS sg13g2_buf_1
Xfanout195 _09730_/A0 _10160_/A1 VDD VSS sg13g2_buf_1
XFILLER_19_249 VDD VSS sg13g2_fill_1
X_13861_ _13861_/Q clkload3/A _13861_/D _13861_/RESET_B VDD VSS sg13g2_dfrbpq_1
XFILLER_35_709 VDD VSS sg13g2_fill_1
XFILLER_47_86 VDD VSS sg13g2_decap_8
XFILLER_75_889 VDD VSS sg13g2_decap_8
XFILLER_90_826 VDD VSS sg13g2_fill_1
X_12812_ _15021_/D _13319_/A _12812_/B VDD VSS sg13g2_nor2_1
X_13792_ _13792_/Q _14917_/CLK _13792_/D _13792_/RESET_B VDD VSS sg13g2_dfrbpq_1
XFILLER_28_794 VDD VSS sg13g2_decap_8
XFILLER_76_1122 VDD VSS sg13g2_decap_8
XFILLER_16_956 VDD VSS sg13g2_fill_2
X_12743_ _12743_/X _13975_/Q _14007_/Q _14039_/Q _14071_/Q _12743_/S0 _12743_/S1 VDD
+ VSS sg13g2_mux4_1
XFILLER_76_1166 VDD VSS sg13g2_fill_2
XFILLER_31_915 VDD VSS sg13g2_decap_4
X_12674_ _12674_/X _14130_/Q _14162_/Q _14194_/Q _14226_/Q _12674_/S0 _12675_/S1 VDD
+ VSS sg13g2_mux4_1
XFILLER_31_948 VDD VSS sg13g2_decap_8
XFILLER_42_285 VDD VSS sg13g2_fill_2
XFILLER_8_14 VDD VSS sg13g2_decap_8
X_14413_ _14413_/Q _14509_/CLK _14413_/D _14413_/RESET_B VDD VSS sg13g2_dfrbpq_1
X_11625_ _11625_/Y _11623_/Y _11625_/B _12118_/C VDD VSS sg13g2_nand3b_1
XFILLER_156_611 VDD VSS sg13g2_decap_8
X_14344_ _14344_/Q clkload30/A _14344_/D _14344_/RESET_B VDD VSS sg13g2_dfrbpq_1
XFILLER_128_324 VDD VSS sg13g2_fill_2
X_11556_ _11556_/X _11696_/B _11555_/X _11554_/Y VDD VSS sg13g2_a21o_1
Xwire552 wire552/X wire552/A VDD VSS sg13g2_buf_2
Xwire563 wire563/X wire563/A VDD VSS sg13g2_buf_2
XFILLER_7_654 VDD VSS sg13g2_decap_8
XFILLER_128_368 VDD VSS sg13g2_fill_2
XFILLER_155_154 VDD VSS sg13g2_fill_1
X_10507_ _10509_/C _14852_/Q _14845_/Q wire760/X _10507_/D VDD VSS sg13g2_nand4_1
XFILLER_6_142 VDD VSS sg13g2_decap_4
XFILLER_155_165 VDD VSS sg13g2_decap_8
X_14275_ _14275_/Q _14405_/CLK _14275_/D _14275_/RESET_B VDD VSS sg13g2_dfrbpq_1
XFILLER_137_880 VDD VSS sg13g2_decap_8
X_11487_ _11487_/X _14690_/Q _14722_/Q _13762_/Q _13794_/Q _11711_/S0 _11493_/S1 VDD
+ VSS sg13g2_mux4_1
Xmax_cap318 _09901_/S _09900_/S VDD VSS sg13g2_buf_4
XFILLER_137_891 VDD VSS sg13g2_fill_2
X_13226_ _13228_/B _13202_/B _13226_/B VDD VSS sg13g2_nand2b_1
X_10438_ _10441_/A _14835_/Q _10443_/D _14836_/Q VDD VSS sg13g2_a21o_1
XFILLER_100_1164 VDD VSS sg13g2_decap_8
XFILLER_98_915 VDD VSS sg13g2_decap_8
X_13157_ _13170_/D _14917_/Q _13670_/Q VDD VSS sg13g2_xnor2_1
X_10369_ _10369_/Y _10400_/A _10400_/B _10400_/C VDD VSS sg13g2_nor3_1
XFILLER_135_1227 VDD VSS sg13g2_decap_8
X_12108_ _12108_/X _12108_/A _12108_/B VDD VSS sg13g2_and2_1
XFILLER_69_138 VDD VSS sg13g2_fill_2
X_14987__2985 _14987_/RESET_B VDD VSS sg13g2_tiehi
X_13088_ _13088_/X _13088_/A _13675_/Q VDD VSS sg13g2_and2_1
X_12039_ _12039_/Y _12040_/A1 _14194_/Q VDD VSS sg13g2_nand2b_1
XFILLER_111_279 VDD VSS sg13g2_decap_4
Xfanout1650 fanout1650/X _13658_/Q VDD VSS sg13g2_buf_1
Xfanout1661 _11580_/S0 _11715_/S0 VDD VSS sg13g2_buf_1
Xfanout1672 fanout1672/X fanout1688/X VDD VSS sg13g2_buf_1
X_14884__3161 _14884_/RESET_B VDD VSS sg13g2_tiehi
Xfanout1683 _12098_/A1 _11621_/S0 VDD VSS sg13g2_buf_1
Xfanout1694 _12252_/S0 _12250_/A1 VDD VSS sg13g2_buf_1
XFILLER_65_333 VDD VSS sg13g2_decap_4
XFILLER_20_1121 VDD VSS sg13g2_decap_8
XFILLER_0_1215 VDD VSS sg13g2_decap_8
XFILLER_0_1226 VDD VSS sg13g2_fill_1
XFILLER_81_859 VDD VSS sg13g2_decap_8
XFILLER_94_1222 VDD VSS sg13g2_decap_8
XFILLER_20_1198 VDD VSS sg13g2_decap_8
X_09250_ _13859_/D _13859_/Q _10079_/A0 _09269_/S VDD VSS sg13g2_mux2_1
X_08201_ _08201_/Y _08201_/A _08201_/B _08201_/C _08201_/D VDD VSS sg13g2_nor4_1
X_09181_ _13797_/D _13797_/Q _10148_/A1 _09199_/S VDD VSS sg13g2_mux2_1
XFILLER_18_1072 VDD VSS sg13g2_decap_8
XFILLER_30_981 VDD VSS sg13g2_decap_8
X_08132_ _08132_/X _08278_/A3 _08258_/C _07768_/A _08276_/A _08559_/S1 wire1387/X
+ VDD VSS sg13g2_mux4_1
XFILLER_105_1064 VDD VSS sg13g2_decap_8
XFILLER_88_1015 VDD VSS sg13g2_decap_8
XFILLER_88_1026 VDD VSS sg13g2_fill_2
X_08063_ _08063_/Y _08063_/A _08063_/B VDD VSS sg13g2_nand2_1
XFILLER_128_880 VDD VSS sg13g2_decap_4
X_13878__2686 _13878_/RESET_B VDD VSS sg13g2_tiehi
XFILLER_108_37 VDD VSS sg13g2_fill_1
XFILLER_143_861 VDD VSS sg13g2_decap_8
XFILLER_143_872 VDD VSS sg13g2_fill_1
XFILLER_0_307 VDD VSS sg13g2_fill_2
X_15095__3176 _15095_/RESET_B VDD VSS sg13g2_tiehi
XFILLER_115_574 VDD VSS sg13g2_fill_2
XFILLER_143_894 VDD VSS sg13g2_fill_2
XFILLER_130_533 VDD VSS sg13g2_decap_8
X_08965_ _08965_/Y _10137_/A _10004_/B _10137_/B _09707_/C VDD VSS sg13g2_nor4_2
XFILLER_76_609 VDD VSS sg13g2_decap_8
XFILLER_124_14 VDD VSS sg13g2_decap_8
XFILLER_25_1032 VDD VSS sg13g2_decap_8
XFILLER_57_801 VDD VSS sg13g2_decap_8
XFILLER_64_1081 VDD VSS sg13g2_fill_1
XFILLER_5_1115 VDD VSS sg13g2_decap_8
X_07916_ _07916_/Y _07914_/Y _07904_/C _07878_/Y VDD VSS sg13g2_o21ai_1
X_08896_ _13707_/D _13707_/Q _08895_/X _08926_/S VDD VSS sg13g2_mux2_1
X_07847_ _07847_/Y _08678_/B _08678_/C _08678_/A VDD VSS sg13g2_a21oi_1
XFILLER_17_709 VDD VSS sg13g2_fill_2
XFILLER_72_804 VDD VSS sg13g2_decap_8
XFILLER_17_56 VDD VSS sg13g2_decap_8
X_07778_ _07778_/X _11570_/A _08276_/B VDD VSS sg13g2_xor2_1
XFILLER_56_399 VDD VSS sg13g2_decap_8
XFILLER_71_325 VDD VSS sg13g2_decap_8
XFILLER_140_35 VDD VSS sg13g2_decap_8
XFILLER_25_720 VDD VSS sg13g2_decap_8
X_09517_ _14116_/D _09616_/A0 _14116_/Q _09533_/S VDD VSS sg13g2_mux2_1
X_14473__2091 _14473_/RESET_B VDD VSS sg13g2_tiehi
XFILLER_12_403 VDD VSS sg13g2_decap_8
X_09448_ _14049_/D _09613_/A0 _14049_/Q _09457_/S VDD VSS sg13g2_mux2_1
XFILLER_71_1030 VDD VSS sg13g2_decap_8
X_09379_ _13982_/D _09744_/A1 _13982_/Q _09398_/S VDD VSS sg13g2_mux2_1
XFILLER_32_1003 VDD VSS sg13g2_decap_8
XFILLER_21_970 VDD VSS sg13g2_decap_8
X_11410_ _11410_/Y _11814_/S0 _14495_/Q _11416_/B VDD VSS sg13g2_a21oi_1
XFILLER_36_1194 VDD VSS sg13g2_decap_8
XFILLER_71_1074 VDD VSS sg13g2_fill_2
X_13665__2927 _13665_/RESET_B VDD VSS sg13g2_tiehi
X_12390_ _12390_/X _13822_/Q _13854_/Q _13886_/Q _13918_/Q _12393_/S0 _12617_/S1 VDD
+ VSS sg13g2_mux4_1
XFILLER_149_77 VDD VSS sg13g2_decap_8
XFILLER_123_1153 VDD VSS sg13g2_decap_8
X_11341_ _14959_/D _11335_/A _11248_/B _11340_/Y VDD VSS sg13g2_a21o_1
XFILLER_4_602 VDD VSS sg13g2_fill_1
XFILLER_119_880 VDD VSS sg13g2_fill_1
XFILLER_3_112 VDD VSS sg13g2_decap_8
X_14060_ _14060_/Q _14714_/CLK _14060_/D _14060_/RESET_B VDD VSS sg13g2_dfrbpq_1
X_11272_ _11272_/Y _11275_/S0 _14460_/Q VDD VSS sg13g2_nand2b_1
XFILLER_4_646 VDD VSS sg13g2_fill_1
X_13708__2856 _13708_/RESET_B VDD VSS sg13g2_tiehi
X_13011_ _13012_/A _13009_/A _13010_/B _13247_/D VDD VSS sg13g2_o21ai_1
XFILLER_134_872 VDD VSS sg13g2_fill_1
X_10223_ _14769_/D _14769_/Q _10219_/X _10222_/Y VDD VSS sg13g2_a21oi_1
XFILLER_3_189 VDD VSS sg13g2_decap_4
XFILLER_95_907 VDD VSS sg13g2_decap_8
X_10154_ _14731_/D _14731_/Q _10154_/A1 _10160_/S VDD VSS sg13g2_mux2_1
XFILLER_82_1170 VDD VSS sg13g2_decap_4
XFILLER_48_823 VDD VSS sg13g2_fill_2
X_14962_ _14962_/Q clkload40/A _14962_/D _14962_/RESET_B VDD VSS sg13g2_dfrbpq_1
X_10085_ _14665_/D _10085_/A0 _14665_/Q _10099_/S VDD VSS sg13g2_mux2_1
XFILLER_43_1154 VDD VSS sg13g2_decap_8
XFILLER_130_1102 VDD VSS sg13g2_decap_8
X_13923__2641 _13923_/RESET_B VDD VSS sg13g2_tiehi
XFILLER_59_171 VDD VSS sg13g2_fill_1
X_14683__1881 _14683_/RESET_B VDD VSS sg13g2_tiehi
XFILLER_87_491 VDD VSS sg13g2_decap_4
XFILLER_75_653 VDD VSS sg13g2_decap_8
X_13913_ _13913_/Q clkload15/A _13913_/D _13913_/RESET_B VDD VSS sg13g2_dfrbpq_1
X_14893_ _14893_/Q clkload70/A _14893_/D _14893_/RESET_B VDD VSS sg13g2_dfrbpq_1
XFILLER_78_1217 VDD VSS sg13g2_decap_8
XFILLER_63_815 VDD VSS sg13g2_fill_2
XFILLER_90_601 VDD VSS sg13g2_decap_8
Xwire1096 wire1096/X wire1096/A VDD VSS sg13g2_buf_8
X_13844_ _13844_/Q clkload32/A _13844_/D _13844_/RESET_B VDD VSS sg13g2_dfrbpq_1
XFILLER_62_314 VDD VSS sg13g2_decap_8
X_13775_ _13775_/Q clkload14/A _13775_/D _13775_/RESET_B VDD VSS sg13g2_dfrbpq_1
X_10987_ _10987_/Y _10987_/A _11074_/B VDD VSS sg13g2_nand2_1
XFILLER_90_678 VDD VSS sg13g2_decap_4
XFILLER_128_1031 VDD VSS sg13g2_fill_1
X_14303__2261 _14303_/RESET_B VDD VSS sg13g2_tiehi
X_12726_ _12726_/X _14134_/Q _14166_/Q _14198_/Q _14230_/Q _12727_/S0 _12742_/S1 VDD
+ VSS sg13g2_mux4_1
X_12657_ _12657_/X _13969_/Q _14001_/Q _14033_/Q _14065_/Q _12657_/S0 _12659_/S1 VDD
+ VSS sg13g2_mux4_1
Xclkbuf_5_19__f_clk_i clkbuf_leaf_49_clk_i/A clkbuf_4_9_0_clk_i/X VDD VSS sg13g2_buf_16
XFILLER_129_622 VDD VSS sg13g2_fill_1
XFILLER_15_1234 VDD VSS sg13g2_fill_2
XFILLER_129_633 VDD VSS sg13g2_decap_8
X_11608_ _11608_/X _11608_/A _12108_/B VDD VSS sg13g2_and2_1
XFILLER_50_1147 VDD VSS sg13g2_decap_8
X_12588_ _12588_/X _14252_/Q _14284_/Q _14316_/Q _14348_/Q _12588_/S0 _12592_/S1 VDD
+ VSS sg13g2_mux4_1
X_15058__2886 _15058_/RESET_B VDD VSS sg13g2_tiehi
XFILLER_128_143 VDD VSS sg13g2_decap_8
XFILLER_102_1226 VDD VSS sg13g2_decap_8
XFILLER_117_817 VDD VSS sg13g2_decap_8
XFILLER_156_463 VDD VSS sg13g2_decap_8
X_14327_ _14327_/Q clkload7/A _14327_/D _14327_/RESET_B VDD VSS sg13g2_dfrbpq_1
XFILLER_156_474 VDD VSS sg13g2_fill_1
X_11539_ _11539_/Y _12259_/S0 _14660_/Q _11739_/B VDD VSS sg13g2_a21oi_1
Xwire371 wire371/X wire371/A VDD VSS sg13g2_buf_1
XFILLER_116_316 VDD VSS sg13g2_decap_4
X_14258_ _14258_/Q _14738_/CLK _14258_/D _14258_/RESET_B VDD VSS sg13g2_dfrbpq_1
XFILLER_99_70 VDD VSS sg13g2_decap_8
X_14764__3335 _14764_/RESET_B VDD VSS sg13g2_tiehi
XFILLER_87_1070 VDD VSS sg13g2_fill_2
XFILLER_98_712 VDD VSS sg13g2_decap_4
X_13209_ wire560/A _13206_/Y _13207_/Y _13208_/Y VDD VSS sg13g2_a21oi_1
XFILLER_140_820 VDD VSS sg13g2_fill_2
X_14189_ _14189_/Q _14669_/CLK _14189_/D _14189_/RESET_B VDD VSS sg13g2_dfrbpq_1
XFILLER_48_1065 VDD VSS sg13g2_decap_8
Xfanout909 _12679_/C1 _07737_/Y VDD VSS sg13g2_buf_1
XFILLER_86_918 VDD VSS sg13g2_fill_2
XFILLER_97_255 VDD VSS sg13g2_decap_8
XFILLER_140_897 VDD VSS sg13g2_decap_8
XFILLER_57_119 VDD VSS sg13g2_decap_8
X_08750_ _13668_/D _08753_/A1 _08748_/Y _08749_/Y VDD VSS sg13g2_a21oi_1
XFILLER_97_288 VDD VSS sg13g2_decap_8
XFILLER_22_1205 VDD VSS sg13g2_decap_8
XFILLER_85_439 VDD VSS sg13g2_fill_1
XFILLER_39_845 VDD VSS sg13g2_fill_2
XFILLER_66_631 VDD VSS sg13g2_decap_8
XFILLER_17_0 VDD VSS sg13g2_decap_8
XFILLER_39_856 VDD VSS sg13g2_decap_4
X_07701_ _07705_/C _15085_/Q _07701_/B VDD VSS sg13g2_nand2_1
Xfanout1480 _08235_/A3 _11461_/A VDD VSS sg13g2_buf_1
X_08681_ _08681_/Y _08698_/B _08681_/B VDD VSS sg13g2_nor2_1
XFILLER_38_344 VDD VSS sg13g2_fill_2
Xfanout1491 _08171_/A1 _11335_/A VDD VSS sg13g2_buf_1
XFILLER_94_973 VDD VSS sg13g2_decap_8
XFILLER_94_984 VDD VSS sg13g2_fill_1
X_07632_ _08203_/A _07888_/B VDD VSS sg13g2_inv_1
XFILLER_4_1181 VDD VSS sg13g2_decap_8
XFILLER_80_111 VDD VSS sg13g2_fill_1
XFILLER_0_1023 VDD VSS sg13g2_decap_8
XFILLER_0_70 VDD VSS sg13g2_decap_4
XFILLER_0_1034 VDD VSS sg13g2_fill_1
XFILLER_80_133 VDD VSS sg13g2_fill_2
XFILLER_94_1030 VDD VSS sg13g2_decap_4
XFILLER_53_369 VDD VSS sg13g2_decap_8
XFILLER_59_1172 VDD VSS sg13g2_decap_8
XFILLER_146_1131 VDD VSS sg13g2_decap_8
X_09302_ _13910_/D _13910_/Q _10132_/A0 _09302_/S VDD VSS sg13g2_mux2_1
XFILLER_0_1078 VDD VSS sg13g2_decap_4
XFILLER_22_712 VDD VSS sg13g2_decap_8
XFILLER_55_1025 VDD VSS sg13g2_decap_8
X_09233_ _13844_/D _10163_/A1 _13844_/Q wire700/X VDD VSS sg13g2_mux2_1
XFILLER_142_1028 VDD VSS sg13g2_decap_8
XFILLER_107_1148 VDD VSS sg13g2_decap_8
X_09164_ _09164_/X _14923_/Q _13245_/A _09164_/C _09164_/D VDD VSS sg13g2_and4_1
XFILLER_148_964 VDD VSS sg13g2_decap_8
XFILLER_119_14 VDD VSS sg13g2_decap_8
X_08115_ _08115_/Y _08183_/A _08115_/B VDD VSS sg13g2_nor2_1
XFILLER_147_474 VDD VSS sg13g2_decap_4
X_09095_ _09097_/B _09103_/C _09103_/D _14915_/Q VDD VSS sg13g2_a21oi_1
XFILLER_79_18 VDD VSS sg13g2_decap_8
X_08046_ _08046_/Y _08686_/A1 _08046_/B VDD VSS sg13g2_nand2b_1
XFILLER_107_349 VDD VSS sg13g2_fill_1
XFILLER_31_1091 VDD VSS sg13g2_fill_1
XFILLER_118_1200 VDD VSS sg13g2_decap_8
XFILLER_135_35 VDD VSS sg13g2_decap_8
X_14345__2219 _14345_/RESET_B VDD VSS sg13g2_tiehi
XFILLER_1_649 VDD VSS sg13g2_decap_8
XFILLER_153_1135 VDD VSS sg13g2_decap_8
XFILLER_27_1138 VDD VSS sg13g2_decap_8
X_09997_ _14580_/D _10063_/A0 _14580_/Q wire613/X VDD VSS sg13g2_mux2_1
XFILLER_89_778 VDD VSS sg13g2_decap_8
XFILLER_0_159 VDD VSS sg13g2_decap_8
XFILLER_130_352 VDD VSS sg13g2_decap_4
XFILLER_103_577 VDD VSS sg13g2_decap_4
XFILLER_131_886 VDD VSS sg13g2_decap_8
XFILLER_131_897 VDD VSS sg13g2_fill_2
XFILLER_29_300 VDD VSS sg13g2_decap_8
X_08948_ _08948_/Y _10793_/A _08959_/B _15051_/Q VDD VSS sg13g2_nand3_1
XFILLER_88_288 VDD VSS sg13g2_fill_1
XFILLER_103_599 VDD VSS sg13g2_fill_1
XFILLER_29_311 VDD VSS sg13g2_fill_1
XFILLER_9_1092 VDD VSS sg13g2_decap_8
X_08879_ _08879_/X _08878_/X _11635_/A _08882_/S VDD VSS sg13g2_mux2_1
XFILLER_85_973 VDD VSS sg13g2_fill_2
XFILLER_151_56 VDD VSS sg13g2_decap_8
XFILLER_29_366 VDD VSS sg13g2_decap_8
X_14560__2004 _14560_/RESET_B VDD VSS sg13g2_tiehi
XFILLER_45_826 VDD VSS sg13g2_fill_1
X_10910_ _10910_/Y _10897_/Y _10936_/D _10924_/B1 VDD VSS sg13g2_a21oi_1
XFILLER_17_528 VDD VSS sg13g2_decap_8
X_11890_ _11891_/A _14254_/Q _14286_/Q _14318_/Q _14350_/Q _11890_/S0 _11890_/S1 VDD
+ VSS sg13g2_mux4_1
XFILLER_44_21 VDD VSS sg13g2_decap_8
XFILLER_44_358 VDD VSS sg13g2_decap_8
X_10841_ _10841_/Y _10841_/A _10841_/B _10841_/C VDD VSS sg13g2_nor3_1
XFILLER_60_818 VDD VSS sg13g2_decap_8
XFILLER_38_1212 VDD VSS sg13g2_decap_8
XFILLER_44_54 VDD VSS sg13g2_decap_4
XFILLER_53_881 VDD VSS sg13g2_decap_8
X_13560_ _15151_/D _15151_/Q _13559_/Y _13560_/S VDD VSS sg13g2_mux2_1
XFILLER_53_892 VDD VSS sg13g2_fill_2
X_10772_ _10772_/X _10772_/A _10793_/B _10793_/A VDD VSS sg13g2_and3_1
XFILLER_12_233 VDD VSS sg13g2_decap_8
XFILLER_9_705 VDD VSS sg13g2_decap_8
X_12511_ _12511_/X _12510_/X _12509_/X _12692_/S VDD VSS sg13g2_mux2_1
X_13491_ _13492_/A _15125_/Q _13490_/B _13414_/Y _15129_/Q _13490_/Y VDD VSS sg13g2_a221oi_1
X_15230_ _15230_/Q clkload37/A _15230_/D _15230_/RESET_B VDD VSS sg13g2_dfrbpq_1
XFILLER_12_288 VDD VSS sg13g2_decap_8
X_12442_ _12442_/Y _13687_/Q _12763_/A2 _12441_/X _12763_/B2 _12498_/C1 VDD VSS sg13g2_a221oi_1
XFILLER_60_42 VDD VSS sg13g2_decap_8
XFILLER_12_299 VDD VSS sg13g2_fill_2
XFILLER_121_0 VDD VSS sg13g2_decap_8
X_15161_ _15161_/Q clkload29/A _15161_/D _15161_/RESET_B VDD VSS sg13g2_dfrbpq_1
X_12373_ _12373_/Y _15120_/Q _12348_/A _12416_/B1 _12836_/B _12638_/A2 VDD VSS sg13g2_a221oi_1
XFILLER_153_411 VDD VSS sg13g2_decap_8
XFILLER_154_945 VDD VSS sg13g2_fill_2
X_14112_ _14112_/Q clkload9/A _14112_/D _14112_/RESET_B VDD VSS sg13g2_dfrbpq_1
X_11324_ _11326_/B _11328_/S0 _14173_/Q VDD VSS sg13g2_nand2b_1
XFILLER_4_421 VDD VSS sg13g2_decap_8
X_15092_ _15092_/Q clkload68/A _15092_/D _15092_/RESET_B VDD VSS sg13g2_dfrbpq_1
XFILLER_126_669 VDD VSS sg13g2_decap_8
XFILLER_4_454 VDD VSS sg13g2_decap_8
XFILLER_107_861 VDD VSS sg13g2_fill_1
XFILLER_141_617 VDD VSS sg13g2_decap_8
XFILLER_10_1164 VDD VSS sg13g2_decap_8
XFILLER_153_488 VDD VSS sg13g2_decap_8
X_14043_ _14043_/Q clkload60/A _14043_/D _14043_/RESET_B VDD VSS sg13g2_dfrbpq_1
X_11255_ _11255_/Y _11255_/A _11255_/B VDD VSS sg13g2_nand2_1
XFILLER_45_1205 VDD VSS sg13g2_fill_1
XFILLER_69_62 VDD VSS sg13g2_decap_8
X_10206_ _14761_/D _15200_/D _10206_/A1 _10206_/S VDD VSS sg13g2_mux2_1
X_11186_ _11186_/Y _11186_/A _11186_/B VDD VSS sg13g2_nand2_1
XFILLER_95_704 VDD VSS sg13g2_fill_1
X_14760__3341 _14760_/RESET_B VDD VSS sg13g2_tiehi
XFILLER_80_1129 VDD VSS sg13g2_decap_8
XFILLER_0_671 VDD VSS sg13g2_decap_8
XFILLER_121_374 VDD VSS sg13g2_fill_1
X_10137_ wire398/A _10137_/A _10137_/B _10137_/C VDD VSS sg13g2_nor3_2
XFILLER_94_236 VDD VSS sg13g2_decap_8
XFILLER_10_7 VDD VSS sg13g2_decap_8
XFILLER_76_962 VDD VSS sg13g2_decap_8
XFILLER_36_804 VDD VSS sg13g2_decap_8
XFILLER_47_130 VDD VSS sg13g2_decap_8
X_14945_ _14945_/Q clkload19/A _14945_/D _14945_/RESET_B VDD VSS sg13g2_dfrbpq_1
X_10068_ _14649_/D _10068_/A0 _14649_/Q _10068_/S VDD VSS sg13g2_mux2_1
XFILLER_76_995 VDD VSS sg13g2_decap_8
XFILLER_91_921 VDD VSS sg13g2_decap_8
XFILLER_36_848 VDD VSS sg13g2_fill_1
X_14876_ _14876_/Q clkload78/A _14876_/D _14876_/RESET_B VDD VSS sg13g2_dfrbpq_1
XFILLER_78_1069 VDD VSS sg13g2_decap_8
X_13827_ _13827_/Q clkload1/A _13827_/D _13827_/RESET_B VDD VSS sg13g2_dfrbpq_1
XFILLER_91_987 VDD VSS sg13g2_decap_8
X_15076__3230 _15076_/RESET_B VDD VSS sg13g2_tiehi
X_13758_ _13758_/Q clkload59/A _13758_/D _13758_/RESET_B VDD VSS sg13g2_dfrbpq_1
XFILLER_16_594 VDD VSS sg13g2_fill_2
XFILLER_91_1236 VDD VSS sg13g2_fill_1
X_12709_ _12722_/A _12709_/A1 _12751_/A2 _15015_/Q VDD VSS sg13g2_a21oi_1
XFILLER_31_564 VDD VSS sg13g2_fill_1
X_13689_ _13689_/Q _15250_/CLK _13689_/D _13689_/RESET_B VDD VSS sg13g2_dfrbpq_1
XFILLER_148_227 VDD VSS sg13g2_fill_2
XFILLER_141_1061 VDD VSS sg13g2_decap_8
XFILLER_106_1192 VDD VSS sg13g2_fill_1
XFILLER_156_271 VDD VSS sg13g2_decap_8
XFILLER_102_1045 VDD VSS sg13g2_fill_1
XFILLER_156_282 VDD VSS sg13g2_fill_1
XFILLER_89_1165 VDD VSS sg13g2_fill_2
XFILLER_89_1176 VDD VSS sg13g2_decap_8
XFILLER_85_1018 VDD VSS sg13g2_decap_8
X_09920_ _14505_/D _14505_/Q _09920_/A1 _09934_/S VDD VSS sg13g2_mux2_1
XFILLER_144_488 VDD VSS sg13g2_fill_1
XFILLER_125_680 VDD VSS sg13g2_fill_1
Xfanout706 _08892_/S _08935_/S VDD VSS sg13g2_buf_1
X_09851_ _14438_/D _14438_/Q _10149_/A1 _09852_/S VDD VSS sg13g2_mux2_1
Xfanout717 _08685_/A1 _08001_/Y VDD VSS sg13g2_buf_1
Xfanout728 _11241_/A _07672_/X VDD VSS sg13g2_buf_1
XFILLER_113_875 VDD VSS sg13g2_decap_8
XFILLER_140_661 VDD VSS sg13g2_decap_8
Xfanout739 _13590_/B _13551_/S VDD VSS sg13g2_buf_1
XFILLER_86_715 VDD VSS sg13g2_fill_2
XFILLER_140_672 VDD VSS sg13g2_decap_8
X_08802_ _13685_/D _08802_/A _08802_/B VDD VSS sg13g2_nor2_1
XFILLER_100_503 VDD VSS sg13g2_decap_8
XFILLER_113_886 VDD VSS sg13g2_fill_2
X_09782_ _14371_/D _09914_/A1 _14371_/Q _09801_/S VDD VSS sg13g2_mux2_1
XFILLER_22_1002 VDD VSS sg13g2_decap_8
XFILLER_100_547 VDD VSS sg13g2_fill_2
X_08733_ _08733_/Y _08751_/A1 _08751_/A2 _15199_/Q VDD VSS sg13g2_o21ai_1
XFILLER_39_664 VDD VSS sg13g2_fill_1
XFILLER_61_1084 VDD VSS sg13g2_decap_8
XFILLER_2_1129 VDD VSS sg13g2_decap_8
XFILLER_96_1114 VDD VSS sg13g2_decap_8
X_08664_ _08664_/Y _08647_/Y _08678_/C _08698_/B VDD VSS sg13g2_a21oi_1
XFILLER_66_483 VDD VSS sg13g2_fill_1
XFILLER_22_1079 VDD VSS sg13g2_decap_8
XFILLER_53_111 VDD VSS sg13g2_fill_2
XFILLER_96_1136 VDD VSS sg13g2_decap_8
X_07615_ _07615_/Y _14945_/Q VDD VSS sg13g2_inv_1
XFILLER_42_818 VDD VSS sg13g2_decap_8
X_08595_ _08596_/D _08637_/B _08592_/X _08590_/Y VDD VSS sg13g2_a21oi_1
XFILLER_41_306 VDD VSS sg13g2_decap_8
XFILLER_53_166 VDD VSS sg13g2_fill_2
XFILLER_14_35 VDD VSS sg13g2_decap_8
XFILLER_22_575 VDD VSS sg13g2_decap_8
X_09216_ _13827_/D _10079_/A0 _13827_/Q _09236_/S VDD VSS sg13g2_mux2_1
XFILLER_33_1131 VDD VSS sg13g2_decap_8
XFILLER_22_597 VDD VSS sg13g2_decap_8
XFILLER_136_912 VDD VSS sg13g2_decap_4
X_09147_ _09147_/Y _15247_/Q _09147_/B VDD VSS sg13g2_nand2b_1
XFILLER_120_1123 VDD VSS sg13g2_decap_8
XFILLER_108_625 VDD VSS sg13g2_decap_8
XFILLER_120_1134 VDD VSS sg13g2_fill_2
XFILLER_5_229 VDD VSS sg13g2_decap_8
X_14982__2990 _14982_/RESET_B VDD VSS sg13g2_tiehi
XFILLER_120_1145 VDD VSS sg13g2_decap_8
XFILLER_136_967 VDD VSS sg13g2_decap_4
X_14845__3239 _14845_/RESET_B VDD VSS sg13g2_tiehi
X_09078_ _09078_/Y _15237_/Q _09085_/B VDD VSS sg13g2_nand2b_1
XFILLER_108_669 VDD VSS sg13g2_decap_8
XFILLER_151_915 VDD VSS sg13g2_decap_8
XFILLER_135_477 VDD VSS sg13g2_decap_8
XFILLER_155_1219 VDD VSS sg13g2_decap_8
XFILLER_146_56 VDD VSS sg13g2_decap_8
X_08029_ _08029_/Y _08200_/A _08199_/B VDD VSS sg13g2_nor2_1
XFILLER_104_831 VDD VSS sg13g2_fill_1
XFILLER_116_691 VDD VSS sg13g2_decap_8
X_11040_ _11042_/C _11040_/A _11052_/B VDD VSS sg13g2_nor2_1
XFILLER_39_21 VDD VSS sg13g2_decap_8
XFILLER_1_457 VDD VSS sg13g2_fill_2
XFILLER_131_672 VDD VSS sg13g2_fill_1
XFILLER_39_65 VDD VSS sg13g2_fill_1
XFILLER_77_737 VDD VSS sg13g2_decap_8
XFILLER_118_1085 VDD VSS sg13g2_fill_1
XFILLER_77_759 VDD VSS sg13g2_decap_8
XFILLER_39_87 VDD VSS sg13g2_decap_8
XFILLER_40_1124 VDD VSS sg13g2_decap_8
X_12991_ _12993_/C _14905_/Q _13682_/Q _12959_/X _12987_/Y _12990_/X VDD VSS sg13g2_a221oi_1
XFILLER_92_718 VDD VSS sg13g2_decap_8
XFILLER_17_303 VDD VSS sg13g2_decap_8
X_14730_ _14730_/Q clkload22/A _14730_/D _14730_/RESET_B VDD VSS sg13g2_dfrbpq_1
X_11942_ _11942_/Y _11969_/A _14192_/Q VDD VSS sg13g2_nand2b_1
XFILLER_18_848 VDD VSS sg13g2_decap_8
X_14929__3071 _14929_/RESET_B VDD VSS sg13g2_tiehi
XFILLER_91_239 VDD VSS sg13g2_fill_1
X_14661_ _14661_/Q clkload5/A _14661_/D _14661_/RESET_B VDD VSS sg13g2_dfrbpq_1
X_11873_ _11873_/Y _11869_/Y _11870_/Y _11872_/Y _11871_/Y _11875_/B VDD VSS sg13g2_a221oi_1
XFILLER_73_998 VDD VSS sg13g2_decap_4
XFILLER_26_870 VDD VSS sg13g2_fill_1
X_14609__1955 _14609_/RESET_B VDD VSS sg13g2_tiehi
X_13612_ _13613_/D _15054_/Q _08832_/D _13508_/C VDD VSS sg13g2_o21ai_1
X_10824_ _10824_/Y _10818_/B _10801_/Y _10823_/Y _10815_/Y _10886_/B1 VDD VSS sg13g2_a221oi_1
X_14592_ _14592_/Q clkload9/A _14592_/D _14592_/RESET_B VDD VSS sg13g2_dfrbpq_1
XFILLER_125_1001 VDD VSS sg13g2_fill_1
XFILLER_13_542 VDD VSS sg13g2_decap_8
X_13543_ _13543_/Y _15146_/Q _13560_/S VDD VSS sg13g2_nor2_1
X_10755_ _10756_/A _13142_/A _11084_/B _11082_/B1 _10754_/X VDD VSS sg13g2_a22oi_1
X_13873__2691 _13873_/RESET_B VDD VSS sg13g2_tiehi
XFILLER_40_361 VDD VSS sg13g2_fill_2
X_13474_ _15111_/D _15177_/D _15111_/Q _13656_/S VDD VSS sg13g2_mux2_1
X_10686_ _14898_/D _10886_/B1 _10827_/B _10685_/Y VDD VSS sg13g2_o21ai_1
XFILLER_139_772 VDD VSS sg13g2_fill_1
X_15213_ _15213_/Q clkload72/A _15213_/D _15213_/RESET_B VDD VSS sg13g2_dfrbpq_1
X_12425_ _12425_/X _14688_/Q _14720_/Q _13760_/Q _13792_/Q _12425_/S0 _12703_/S1 VDD
+ VSS sg13g2_mux4_1
Xmax_cap1546 output55/A _16879_/A VDD VSS sg13g2_buf_4
XFILLER_127_956 VDD VSS sg13g2_decap_8
X_15144_ _15144_/Q _15148_/CLK _15144_/D _15144_/RESET_B VDD VSS sg13g2_dfrbpq_1
X_12356_ _12356_/Y _12415_/A _12356_/B VDD VSS sg13g2_nand2_1
XFILLER_153_252 VDD VSS sg13g2_decap_8
XFILLER_58_7 VDD VSS sg13g2_decap_8
X_15097__3168 _15097_/RESET_B VDD VSS sg13g2_tiehi
X_11307_ _11307_/Y _11310_/A1 _13725_/Q VDD VSS sg13g2_nand2b_1
X_15075_ _15075_/Q clkload71/A _15075_/D _15075_/RESET_B VDD VSS sg13g2_dfrbpq_1
XFILLER_141_425 VDD VSS sg13g2_decap_8
X_12287_ _12287_/X _14393_/Q _14425_/Q _14489_/Q _14521_/Q _12287_/S0 _12287_/S1 VDD
+ VSS sg13g2_mux4_1
XFILLER_141_447 VDD VSS sg13g2_fill_1
XFILLER_45_1002 VDD VSS sg13g2_decap_8
X_14026_ _14026_/Q clkload25/A _14026_/D _14026_/RESET_B VDD VSS sg13g2_dfrbpq_1
X_11238_ _11292_/A _12866_/A _15123_/Q VDD VSS sg13g2_nand2_1
XFILLER_122_650 VDD VSS sg13g2_fill_2
XFILLER_68_715 VDD VSS sg13g2_decap_8
XFILLER_95_512 VDD VSS sg13g2_decap_8
XFILLER_136_1174 VDD VSS sg13g2_decap_4
XFILLER_68_737 VDD VSS sg13g2_decap_8
XFILLER_121_160 VDD VSS sg13g2_decap_8
XFILLER_136_1185 VDD VSS sg13g2_fill_1
XFILLER_132_1016 VDD VSS sg13g2_decap_8
X_11169_ _14953_/D _11168_/X _11167_/Y _11156_/Y VDD VSS sg13g2_o21ai_1
XFILLER_67_225 VDD VSS sg13g2_decap_8
XFILLER_110_834 VDD VSS sg13g2_decap_8
XFILLER_0_490 VDD VSS sg13g2_fill_1
XFILLER_83_707 VDD VSS sg13g2_decap_8
XFILLER_76_770 VDD VSS sg13g2_decap_8
X_14928_ _14928_/Q clkload63/A _14928_/D _14928_/RESET_B VDD VSS sg13g2_dfrbpq_1
XFILLER_91_740 VDD VSS sg13g2_fill_1
XFILLER_35_155 VDD VSS sg13g2_fill_2
X_14859_ _14859_/Q clkload79/A _14859_/D _14859_/RESET_B VDD VSS sg13g2_dfrbpq_1
XFILLER_91_784 VDD VSS sg13g2_decap_8
XFILLER_51_626 VDD VSS sg13g2_decap_8
X_08380_ _08380_/Y _08621_/A _08378_/Y _08379_/Y VDD VSS sg13g2_o21ai_1
XFILLER_35_199 VDD VSS sg13g2_decap_4
XFILLER_149_503 VDD VSS sg13g2_decap_8
XFILLER_143_1101 VDD VSS sg13g2_fill_1
XFILLER_50_158 VDD VSS sg13g2_decap_8
XFILLER_52_1006 VDD VSS sg13g2_fill_1
XFILLER_32_873 VDD VSS sg13g2_decap_8
XFILLER_32_884 VDD VSS sg13g2_fill_1
X_13703__2861 _13703_/RESET_B VDD VSS sg13g2_tiehi
XFILLER_17_1148 VDD VSS sg13g2_decap_8
XFILLER_143_1156 VDD VSS sg13g2_decap_4
XFILLER_84_0 VDD VSS sg13g2_decap_8
XFILLER_143_1178 VDD VSS sg13g2_fill_1
XFILLER_31_394 VDD VSS sg13g2_fill_1
X_09001_ _09001_/X _09137_/A _08998_/X _09000_/Y VDD VSS sg13g2_a21o_1
X_14047__2517 _14047_/RESET_B VDD VSS sg13g2_tiehi
Xclkbuf_4_13_0_clk_i clkbuf_4_13_0_clk_i/X clkbuf_0_clk_i/X VDD VSS sg13g2_buf_8
XFILLER_133_937 VDD VSS sg13g2_decap_8
XFILLER_105_628 VDD VSS sg13g2_decap_8
XFILLER_104_105 VDD VSS sg13g2_decap_8
XFILLER_6_91 VDD VSS sg13g2_decap_8
XFILLER_104_138 VDD VSS sg13g2_decap_8
X_09903_ _14489_/D _10135_/A0 _14489_/Q _09903_/S VDD VSS sg13g2_mux2_1
XFILLER_104_149 VDD VSS sg13g2_fill_2
XFILLER_99_862 VDD VSS sg13g2_fill_1
XFILLER_141_970 VDD VSS sg13g2_fill_2
XFILLER_98_361 VDD VSS sg13g2_decap_8
XFILLER_63_1146 VDD VSS sg13g2_decap_8
Xfanout536 _09680_/A0 wire537/X VDD VSS sg13g2_buf_1
X_09834_ _14422_/D _09900_/A0 _14422_/Q _09834_/S VDD VSS sg13g2_mux2_1
XFILLER_113_683 VDD VSS sg13g2_decap_4
X_14262__2302 _14262_/RESET_B VDD VSS sg13g2_tiehi
XFILLER_100_311 VDD VSS sg13g2_fill_1
Xfanout569 _12749_/B2 _12429_/B2 VDD VSS sg13g2_buf_1
XFILLER_6_1040 VDD VSS sg13g2_decap_8
XFILLER_46_409 VDD VSS sg13g2_fill_2
X_09765_ _14355_/D _14355_/Q _09930_/A1 _09765_/S VDD VSS sg13g2_mux2_1
XFILLER_132_14 VDD VSS sg13g2_decap_8
XFILLER_39_450 VDD VSS sg13g2_decap_8
XFILLER_86_578 VDD VSS sg13g2_decap_8
X_08716_ _15211_/D _15190_/D _12346_/A _13654_/S VDD VSS sg13g2_mux2_1
XFILLER_100_399 VDD VSS sg13g2_fill_1
XFILLER_73_239 VDD VSS sg13g2_decap_8
X_09696_ _14288_/D _09696_/A0 _14288_/Q _09706_/S VDD VSS sg13g2_mux2_1
XFILLER_26_133 VDD VSS sg13g2_fill_1
XFILLER_82_751 VDD VSS sg13g2_decap_8
X_08647_ _08647_/Y _08576_/Y _08641_/Y _08646_/Y VDD VSS sg13g2_a21oi_1
XFILLER_70_924 VDD VSS sg13g2_decap_4
X_14295__2269 _14295_/RESET_B VDD VSS sg13g2_tiehi
XFILLER_42_637 VDD VSS sg13g2_fill_1
XFILLER_25_56 VDD VSS sg13g2_decap_8
X_08578_ _08578_/Y _08612_/S _08576_/Y _08577_/Y VDD VSS sg13g2_a21oi_1
XFILLER_70_968 VDD VSS sg13g2_decap_8
XFILLER_41_147 VDD VSS sg13g2_decap_8
XFILLER_35_1215 VDD VSS sg13g2_decap_8
XFILLER_41_158 VDD VSS sg13g2_fill_1
XFILLER_23_884 VDD VSS sg13g2_decap_8
XFILLER_22_361 VDD VSS sg13g2_decap_8
XFILLER_22_372 VDD VSS sg13g2_fill_1
XFILLER_22_383 VDD VSS sg13g2_decap_8
X_10540_ _10540_/Y _13273_/A _10547_/D _13356_/B VDD VSS sg13g2_o21ai_1
X_10471_ _10492_/C _14845_/Q _14844_/Q _14843_/Q _10471_/D VDD VSS sg13g2_and4_1
XFILLER_109_934 VDD VSS sg13g2_fill_1
X_12210_ _12217_/B _12219_/S _12210_/B VDD VSS sg13g2_nor2_1
XFILLER_41_99 VDD VSS sg13g2_decap_8
X_13190_ _13191_/C _14918_/Q _13669_/Q _13225_/B VDD VSS sg13g2_nand3_1
XFILLER_135_252 VDD VSS sg13g2_decap_4
X_12141_ _12141_/X _12135_/X _12136_/X _12138_/X _12137_/X _12290_/S0 _12290_/S1 VDD
+ VSS sg13g2_mux4_1
XFILLER_124_937 VDD VSS sg13g2_decap_8
XFILLER_123_447 VDD VSS sg13g2_fill_2
XFILLER_1_221 VDD VSS sg13g2_decap_4
X_12072_ _12072_/X _13843_/Q _13875_/Q _13907_/Q _13939_/Q _12072_/S0 _12072_/S1 VDD
+ VSS sg13g2_mux4_1
XFILLER_1_254 VDD VSS sg13g2_fill_2
X_14809__3289 _14809_/RESET_B VDD VSS sg13g2_tiehi
X_11023_ _11023_/Y _11023_/A _11052_/A VDD VSS sg13g2_nor2_1
XFILLER_77_523 VDD VSS sg13g2_fill_2
X_16880_ _16880_/X _16880_/A VDD VSS sg13g2_buf_1
XFILLER_49_236 VDD VSS sg13g2_decap_8
XFILLER_2_49 VDD VSS sg13g2_decap_8
XFILLER_77_556 VDD VSS sg13g2_fill_2
X_13745__2819 _13745_/RESET_B VDD VSS sg13g2_tiehi
X_15136__3070 _15136_/RESET_B VDD VSS sg13g2_tiehi
XFILLER_64_206 VDD VSS sg13g2_fill_2
XFILLER_66_63 VDD VSS sg13g2_decap_8
XFILLER_17_100 VDD VSS sg13g2_fill_1
XFILLER_58_792 VDD VSS sg13g2_decap_8
XFILLER_46_943 VDD VSS sg13g2_decap_4
X_12974_ _12975_/B _12957_/A _13683_/Q _12960_/Y VDD VSS sg13g2_a21oi_1
XFILLER_92_548 VDD VSS sg13g2_decap_4
X_14713_ _14713_/Q _14745_/CLK _14713_/D _14713_/RESET_B VDD VSS sg13g2_dfrbpq_1
XFILLER_18_678 VDD VSS sg13g2_decap_8
XFILLER_45_464 VDD VSS sg13g2_fill_1
X_11925_ _11925_/X _13967_/Q _13999_/Q _14031_/Q _14063_/Q _11925_/S0 _12073_/S1 VDD
+ VSS sg13g2_mux4_1
Xclkbuf_leaf_1_clk_i _14405_/CLK clkbuf_leaf_1_clk_i/A VDD VSS sg13g2_buf_8
X_14125__2439 _14125_/RESET_B VDD VSS sg13g2_tiehi
XFILLER_73_795 VDD VSS sg13g2_decap_8
X_13960__2604 _13960_/RESET_B VDD VSS sg13g2_tiehi
X_11856_ _11858_/B _12000_/A _11856_/B VDD VSS sg13g2_nor2_1
X_14644_ _14644_/Q clkload16/A _14644_/D _14644_/RESET_B VDD VSS sg13g2_dfrbpq_1
XFILLER_61_968 VDD VSS sg13g2_decap_8
X_10807_ _10807_/Y _12346_/A _10807_/B _10807_/C VDD VSS sg13g2_nand3_1
X_14575_ _14575_/Q clkload11/A _14575_/D _14575_/RESET_B VDD VSS sg13g2_dfrbpq_1
XFILLER_13_350 VDD VSS sg13g2_decap_8
X_11787_ _11787_/X _14123_/Q _14155_/Q _14187_/Q _14219_/Q _11787_/S0 _12286_/S1 VDD
+ VSS sg13g2_mux4_1
XFILLER_41_681 VDD VSS sg13g2_fill_1
X_13526_ _13526_/Y _13525_/A _12936_/B _08276_/B _13546_/B2 VDD VSS sg13g2_a22oi_1
X_10738_ _14912_/D _09204_/C _11040_/A _10737_/Y VDD VSS sg13g2_o21ai_1
XFILLER_40_180 VDD VSS sg13g2_decap_8
XFILLER_9_354 VDD VSS sg13g2_decap_8
X_14340__2224 _14340_/RESET_B VDD VSS sg13g2_tiehi
X_13457_ _15105_/D _13449_/X _13456_/X _13446_/Y VDD VSS sg13g2_o21ai_1
X_10669_ _10807_/B _14926_/Q _08971_/X _10669_/S VDD VSS sg13g2_mux2_1
XFILLER_103_1151 VDD VSS sg13g2_fill_1
X_12408_ _12408_/X _14559_/Q _14591_/Q _14623_/Q _14655_/Q _12604_/S0 _12604_/S1 VDD
+ VSS sg13g2_mux4_1
XFILLER_12_1067 VDD VSS sg13g2_decap_8
X_13388_ _13391_/C _15127_/Q _13507_/B VDD VSS sg13g2_nand2_1
Xoutput106 mem_axi_wdata[11] _15143_/Q VDD VSS sg13g2_buf_1
XFILLER_115_926 VDD VSS sg13g2_decap_4
Xoutput117 mem_axi_wdata[21] _15153_/Q VDD VSS sg13g2_buf_1
XFILLER_5_560 VDD VSS sg13g2_decap_8
Xoutput128 mem_axi_wdata[31] _15163_/Q VDD VSS sg13g2_buf_1
X_12339_ _12340_/A _11868_/A _12338_/Y _12298_/B VDD VSS sg13g2_o21ai_1
X_15127_ _15127_/Q clkload72/A _15127_/D _15127_/RESET_B VDD VSS sg13g2_dfrbpq_1
Xoutput139 mem_axi_wstrb[3] _15167_/Q VDD VSS sg13g2_buf_1
XFILLER_99_136 VDD VSS sg13g2_decap_8
X_15058_ _15058_/Q _15209_/CLK _15058_/D _15058_/RESET_B VDD VSS sg13g2_dfrbpq_1
X_14009_ _14009_/Q _14745_/CLK _14009_/D _14009_/RESET_B VDD VSS sg13g2_dfrbpq_1
X_07880_ _08090_/B _07884_/A _08023_/B VDD VSS sg13g2_nor2_1
XFILLER_83_504 VDD VSS sg13g2_fill_1
XFILLER_96_887 VDD VSS sg13g2_decap_8
XFILLER_3_1202 VDD VSS sg13g2_decap_8
X_09550_ _14148_/D _09616_/A0 _14148_/Q _09566_/S VDD VSS sg13g2_mux2_1
XFILLER_23_1196 VDD VSS sg13g2_decap_8
X_08501_ _15238_/D _08501_/A _08501_/B _08501_/C _08501_/D VDD VSS sg13g2_nand4_1
X_09481_ _14081_/D _10077_/A0 _14081_/Q _09490_/S VDD VSS sg13g2_mux2_1
XFILLER_102_28 VDD VSS sg13g2_fill_2
XFILLER_58_1226 VDD VSS sg13g2_decap_8
XFILLER_110_1166 VDD VSS sg13g2_fill_1
XFILLER_37_998 VDD VSS sg13g2_decap_8
XFILLER_64_795 VDD VSS sg13g2_decap_8
XFILLER_52_946 VDD VSS sg13g2_decap_4
X_08432_ _08432_/Y _07799_/X _08001_/A _08542_/A2 VDD VSS sg13g2_o21ai_1
X_08363_ _08363_/X _08207_/X _08362_/X _08452_/A _08279_/A _08363_/S0 _08560_/B VDD
+ VSS sg13g2_mux4_1
XFILLER_149_344 VDD VSS sg13g2_decap_8
X_08294_ _08294_/Y _07778_/X _08286_/Y _07777_/Y VDD VSS sg13g2_o21ai_1
XFILLER_108_1073 VDD VSS sg13g2_fill_1
XFILLER_118_731 VDD VSS sg13g2_fill_2
XFILLER_11_14 VDD VSS sg13g2_decap_8
X_13969__2595 _13969_/RESET_B VDD VSS sg13g2_tiehi
XFILLER_127_14 VDD VSS sg13g2_decap_8
XFILLER_3_519 VDD VSS sg13g2_decap_8
XFILLER_117_274 VDD VSS sg13g2_decap_8
XFILLER_121_907 VDD VSS sg13g2_fill_1
Xfanout311 _10061_/S _10060_/S VDD VSS sg13g2_buf_1
Xfanout1309 _10070_/A _09806_/A VDD VSS sg13g2_buf_1
XFILLER_28_1052 VDD VSS sg13g2_decap_8
Xfanout322 _09877_/S _09904_/S VDD VSS sg13g2_buf_1
XFILLER_59_523 VDD VSS sg13g2_fill_1
XFILLER_119_1180 VDD VSS sg13g2_decap_8
Xfanout344 _09410_/S _09440_/S VDD VSS sg13g2_buf_1
XFILLER_8_1146 VDD VSS sg13g2_decap_8
XFILLER_143_35 VDD VSS sg13g2_decap_8
Xfanout355 _09915_/A1 _09019_/Y VDD VSS sg13g2_buf_1
XFILLER_113_491 VDD VSS sg13g2_fill_1
X_09817_ _14405_/D _09916_/A1 _14405_/Q _09834_/S VDD VSS sg13g2_mux2_1
XFILLER_41_1230 VDD VSS sg13g2_decap_8
Xfanout399 _10083_/S _10096_/S VDD VSS sg13g2_buf_1
X_09748_ _14338_/D _14338_/Q _09880_/A0 _09766_/S VDD VSS sg13g2_mux2_1
XFILLER_100_185 VDD VSS sg13g2_decap_4
XFILLER_27_453 VDD VSS sg13g2_fill_2
X_09679_ _14271_/D _09877_/A0 _14271_/Q _09679_/S VDD VSS sg13g2_mux2_1
XFILLER_28_998 VDD VSS sg13g2_decap_8
X_15078__3222 _15078_/RESET_B VDD VSS sg13g2_tiehi
X_15124__3096 _15124_/RESET_B VDD VSS sg13g2_tiehi
XFILLER_82_570 VDD VSS sg13g2_fill_2
X_11710_ _11710_/X _13833_/Q _13865_/Q _13897_/Q _13929_/Q _11710_/S0 _11714_/S1 VDD
+ VSS sg13g2_mux4_1
XFILLER_42_412 VDD VSS sg13g2_decap_8
XFILLER_27_497 VDD VSS sg13g2_decap_8
XFILLER_36_99 VDD VSS sg13g2_decap_8
X_12690_ _12690_/X _12685_/X _12689_/X _12684_/X _12688_/X _12691_/S0 wire1081/X VDD
+ VSS sg13g2_mux4_1
XFILLER_43_968 VDD VSS sg13g2_decap_4
XFILLER_70_765 VDD VSS sg13g2_fill_2
X_11641_ _11643_/B _11506_/B _11776_/A _11774_/A VDD VSS sg13g2_a21o_1
XFILLER_52_21 VDD VSS sg13g2_decap_8
XFILLER_52_54 VDD VSS sg13g2_decap_4
X_14360_ _14360_/Q clkload24/A _14360_/D _14360_/RESET_B VDD VSS sg13g2_dfrbpq_1
X_11572_ _11572_/X _11572_/A _11638_/C VDD VSS sg13g2_xor2_1
XFILLER_11_865 VDD VSS sg13g2_decap_8
X_13311_ _15060_/D _08977_/A _13308_/Y _07987_/Y _13310_/Y _13306_/A VDD VSS sg13g2_a221oi_1
Xinput19 input19/X input19/A VDD VSS sg13g2_buf_1
XFILLER_7_825 VDD VSS sg13g2_fill_1
X_10523_ _10567_/A _10564_/D _14856_/Q _14855_/Q VDD VSS sg13g2_nand3_1
X_14291_ _14291_/Q clkload13/A _14291_/D _14291_/RESET_B VDD VSS sg13g2_dfrbpq_1
XFILLER_155_336 VDD VSS sg13g2_fill_2
XFILLER_155_347 VDD VSS sg13g2_decap_8
XFILLER_10_386 VDD VSS sg13g2_decap_4
XFILLER_7_858 VDD VSS sg13g2_decap_8
X_13242_ _13247_/A _13242_/A _13242_/B VDD VSS sg13g2_nand2_1
X_10454_ _14840_/D _14840_/Q _10450_/C _10452_/Y VDD VSS sg13g2_a21oi_1
XFILLER_124_712 VDD VSS sg13g2_decap_4
X_13173_ _13176_/B _13066_/A wire234/X _13172_/X VDD VSS sg13g2_o21ai_1
X_10385_ _10386_/C _14818_/Q _14819_/Q _10385_/C _10396_/C VDD VSS sg13g2_and4_1
X_12124_ _12125_/B _12086_/X _12156_/A _12123_/Y VDD VSS sg13g2_a21oi_1
XFILLER_97_607 VDD VSS sg13g2_fill_2
X_15239__3392 _15239_/RESET_B VDD VSS sg13g2_tiehi
XFILLER_123_266 VDD VSS sg13g2_fill_2
XFILLER_133_1100 VDD VSS sg13g2_fill_2
XFILLER_78_832 VDD VSS sg13g2_decap_8
X_12055_ _12056_/C _12055_/A _12055_/B _12055_/C _12055_/D VDD VSS sg13g2_nor4_1
XFILLER_78_843 VDD VSS sg13g2_fill_2
XFILLER_81_1065 VDD VSS sg13g2_decap_4
XFILLER_133_1144 VDD VSS sg13g2_fill_2
XFILLER_42_1027 VDD VSS sg13g2_decap_8
XFILLER_46_1196 VDD VSS sg13g2_decap_8
X_11006_ _11012_/C _10893_/A _10893_/B _11005_/X VDD VSS sg13g2_a21oi_1
XFILLER_133_1155 VDD VSS sg13g2_fill_1
X_16863_ _16863_/X _16863_/A VDD VSS sg13g2_buf_1
XFILLER_38_718 VDD VSS sg13g2_fill_1
XFILLER_77_95 VDD VSS sg13g2_fill_1
XFILLER_93_813 VDD VSS sg13g2_fill_2
XFILLER_65_515 VDD VSS sg13g2_fill_1
XFILLER_19_932 VDD VSS sg13g2_decap_8
XFILLER_92_323 VDD VSS sg13g2_decap_4
XFILLER_46_740 VDD VSS sg13g2_decap_4
X_14358__2206 _14358_/RESET_B VDD VSS sg13g2_tiehi
XFILLER_34_913 VDD VSS sg13g2_fill_2
X_12957_ _12988_/C _12957_/A _13683_/Q VDD VSS sg13g2_xnor2_1
XFILLER_46_784 VDD VSS sg13g2_decap_8
X_11908_ _11908_/Y _11843_/A _13675_/Q _13674_/Q _11865_/A VDD VSS sg13g2_a22oi_1
XFILLER_60_231 VDD VSS sg13g2_decap_8
X_12888_ _15026_/D _12878_/Y _12887_/Y _12984_/A VDD VSS sg13g2_a21oi_1
XFILLER_60_242 VDD VSS sg13g2_fill_1
X_14627_ _14627_/Q clkload2/A _14627_/D _14627_/RESET_B VDD VSS sg13g2_dfrbpq_1
X_11839_ _14974_/D _11839_/A _11839_/B VDD VSS sg13g2_nor2_1
XFILLER_92_1183 VDD VSS sg13g2_decap_8
X_14558_ _14558_/Q clkload59/A _14558_/D _14558_/RESET_B VDD VSS sg13g2_dfrbpq_1
XFILLER_119_528 VDD VSS sg13g2_decap_8
X_13509_ _15132_/D _15132_/Q _13517_/A _13547_/B VDD VSS sg13g2_mux2_1
XFILLER_119_539 VDD VSS sg13g2_fill_2
X_14489_ _14489_/Q clkload42/A _14489_/D _14489_/RESET_B VDD VSS sg13g2_dfrbpq_1
Xmax_cap1151 _12450_/S0 _12452_/S0 VDD VSS sg13g2_buf_4
Xhold3406 hold3406/X input2/X VDD VSS sg13g2_dlygate4sd3_1
XFILLER_47_0 VDD VSS sg13g2_decap_8
Xhold3417 hold3417/X input33/X VDD VSS sg13g2_dlygate4sd3_1
X_08981_ _08981_/Y _10681_/A _10674_/A _09024_/A VDD VSS sg13g2_o21ai_1
XFILLER_88_618 VDD VSS sg13g2_fill_1
Xhold3428 input4/A mem_axi_rdata[0] VDD VSS sg13g2_dlygate4sd3_1
XFILLER_142_586 VDD VSS sg13g2_decap_8
Xhold3439 hold3439/X input19/X VDD VSS sg13g2_dlygate4sd3_1
X_07932_ _07932_/Y _08286_/A _08286_/B VDD VSS sg13g2_nor2_1
XFILLER_138_1099 VDD VSS sg13g2_decap_8
XFILLER_25_1214 VDD VSS sg13g2_decap_8
Xclkbuf_leaf_102_clk_i clkload23/A clkbuf_5_9__f_clk_i/X VDD VSS sg13g2_buf_8
XFILLER_111_940 VDD VSS sg13g2_decap_8
XFILLER_3_70 VDD VSS sg13g2_decap_8
XFILLER_96_662 VDD VSS sg13g2_decap_4
X_14604__1960 _14604_/RESET_B VDD VSS sg13g2_tiehi
X_07863_ _08641_/D _08608_/A _08608_/B VDD VSS sg13g2_or2_1
XFILLER_84_824 VDD VSS sg13g2_fill_1
XFILLER_84_835 VDD VSS sg13g2_fill_2
X_09602_ _14199_/D _14199_/Q _10033_/A0 wire329/X VDD VSS sg13g2_mux2_1
X_07794_ _08414_/C _07794_/A _08383_/B VDD VSS sg13g2_xnor2_1
XFILLER_56_559 VDD VSS sg13g2_decap_8
XFILLER_113_49 VDD VSS sg13g2_decap_8
XFILLER_83_356 VDD VSS sg13g2_fill_2
Xclkbuf_leaf_117_clk_i clkload25/A clkbuf_5_9__f_clk_i/X VDD VSS sg13g2_buf_8
XFILLER_3_1054 VDD VSS sg13g2_decap_8
X_09533_ _14132_/D _10063_/A0 _14132_/Q _09533_/S VDD VSS sg13g2_mux2_1
XFILLER_3_1065 VDD VSS sg13g2_fill_1
XFILLER_71_518 VDD VSS sg13g2_decap_8
XFILLER_25_913 VDD VSS sg13g2_fill_2
XFILLER_3_1076 VDD VSS sg13g2_decap_8
XFILLER_36_250 VDD VSS sg13g2_fill_2
XFILLER_37_795 VDD VSS sg13g2_decap_8
XFILLER_58_1034 VDD VSS sg13g2_fill_2
XFILLER_36_283 VDD VSS sg13g2_fill_1
X_09464_ _14065_/D _09994_/A0 _14065_/Q wire671/X VDD VSS sg13g2_mux2_1
XFILLER_145_1004 VDD VSS sg13g2_decap_8
XFILLER_24_434 VDD VSS sg13g2_fill_1
XFILLER_51_220 VDD VSS sg13g2_decap_8
XFILLER_51_231 VDD VSS sg13g2_fill_1
XFILLER_58_1067 VDD VSS sg13g2_fill_1
XFILLER_40_905 VDD VSS sg13g2_fill_1
X_08415_ _08417_/B _08415_/A _08415_/B VDD VSS sg13g2_nand2_1
XFILLER_52_776 VDD VSS sg13g2_decap_8
X_09395_ _13998_/D _09892_/A0 _13998_/Q _09398_/S VDD VSS sg13g2_mux2_1
XFILLER_40_949 VDD VSS sg13g2_decap_8
X_08346_ _08346_/Y _08346_/A _08346_/B _08346_/C VDD VSS sg13g2_nand3_1
XFILLER_20_640 VDD VSS sg13g2_fill_2
XFILLER_32_1218 VDD VSS sg13g2_decap_8
XFILLER_22_35 VDD VSS sg13g2_decap_8
XFILLER_149_185 VDD VSS sg13g2_decap_8
X_08277_ _08277_/Y _08318_/D _08565_/A2 _08674_/B1 _08276_/X _08275_/Y VDD VSS sg13g2_a221oi_1
XFILLER_125_7 VDD VSS sg13g2_decap_8
XFILLER_138_35 VDD VSS sg13g2_decap_8
XFILLER_152_317 VDD VSS sg13g2_decap_8
XFILLER_146_870 VDD VSS sg13g2_decap_8
XFILLER_98_28 VDD VSS sg13g2_decap_8
XFILLER_106_712 VDD VSS sg13g2_fill_1
X_14436__2128 _14436_/RESET_B VDD VSS sg13g2_tiehi
X_10170_ _10185_/A _13613_/B _13613_/C _13508_/C VDD VSS sg13g2_nand3_1
XFILLER_152_1008 VDD VSS sg13g2_decap_8
XFILLER_154_56 VDD VSS sg13g2_decap_8
Xfanout1106 _12689_/S1 _12686_/S1 VDD VSS sg13g2_buf_1
X_14910__3109 _14910_/RESET_B VDD VSS sg13g2_tiehi
Xfanout1117 _12757_/S1 _12480_/S1 VDD VSS sg13g2_buf_1
XFILLER_59_320 VDD VSS sg13g2_fill_2
XFILLER_121_759 VDD VSS sg13g2_decap_8
Xfanout1128 fanout1128/X fanout1135/X VDD VSS sg13g2_buf_1
Xfanout1139 _12366_/S1 _12351_/S1 VDD VSS sg13g2_buf_1
XFILLER_87_651 VDD VSS sg13g2_decap_8
Xfanout152 _10069_/A0 wire153/X VDD VSS sg13g2_buf_1
Xfanout163 _10167_/A1 _09152_/Y VDD VSS sg13g2_buf_1
XFILLER_47_21 VDD VSS sg13g2_decap_8
XFILLER_47_504 VDD VSS sg13g2_decap_8
Xfanout174 _10097_/A0 _09131_/X VDD VSS sg13g2_buf_1
Xfanout185 _09930_/A1 _10162_/A1 VDD VSS sg13g2_buf_1
XFILLER_47_54 VDD VSS sg13g2_fill_2
Xfanout196 _09928_/A1 _10160_/A1 VDD VSS sg13g2_buf_1
XFILLER_59_397 VDD VSS sg13g2_decap_4
XFILLER_86_183 VDD VSS sg13g2_fill_2
X_13860_ _13860_/Q _15160_/CLK _13860_/D _13860_/RESET_B VDD VSS sg13g2_dfrbpq_1
XFILLER_74_367 VDD VSS sg13g2_decap_4
X_12811_ _12812_/B _12808_/A _15123_/Q _12805_/Y _11236_/A _12810_/Y VDD VSS sg13g2_a221oi_1
XFILLER_41_1093 VDD VSS sg13g2_decap_8
XFILLER_74_378 VDD VSS sg13g2_fill_1
XFILLER_76_1101 VDD VSS sg13g2_decap_4
X_13791_ _13791_/Q clkload52/A _13791_/D _13791_/RESET_B VDD VSS sg13g2_dfrbpq_1
XFILLER_16_924 VDD VSS sg13g2_decap_4
XFILLER_76_1112 VDD VSS sg13g2_fill_2
XFILLER_103_60 VDD VSS sg13g2_decap_8
XFILLER_55_581 VDD VSS sg13g2_fill_2
XFILLER_83_890 VDD VSS sg13g2_decap_8
XFILLER_15_423 VDD VSS sg13g2_fill_2
X_12742_ _12742_/X _14135_/Q _14167_/Q _14199_/Q _14231_/Q _12742_/S0 _12742_/S1 VDD
+ VSS sg13g2_mux4_1
XFILLER_37_1118 VDD VSS sg13g2_decap_4
XFILLER_128_1235 VDD VSS sg13g2_fill_2
XFILLER_151_0 VDD VSS sg13g2_decap_8
XFILLER_76_1178 VDD VSS sg13g2_fill_1
Xclkbuf_leaf_81_clk_i clkload68/A clkbuf_leaf_82_clk_i/A VDD VSS sg13g2_buf_8
X_12673_ _12673_/X _13746_/Q _14098_/Q _14450_/Q _14546_/Q _12675_/S0 _12675_/S1 VDD
+ VSS sg13g2_mux4_1
X_14042__2522 _14042_/RESET_B VDD VSS sg13g2_tiehi
X_13695__2869 _13695_/RESET_B VDD VSS sg13g2_tiehi
X_11624_ _11625_/B _11613_/Y _11615_/X _12075_/A VDD VSS sg13g2_o21ai_1
X_14412_ _14412_/Q clkload58/A _14412_/D _14412_/RESET_B VDD VSS sg13g2_dfrbpq_1
XFILLER_156_623 VDD VSS sg13g2_decap_8
XFILLER_156_634 VDD VSS sg13g2_fill_1
X_11555_ _11555_/X _14692_/Q _14724_/Q _13764_/Q _13796_/Q _11555_/S0 _11555_/S1 VDD
+ VSS sg13g2_mux4_1
X_14646__1918 _14646_/RESET_B VDD VSS sg13g2_tiehi
X_14343_ _14343_/Q _14725_/CLK _14343_/D _14343_/RESET_B VDD VSS sg13g2_dfrbpq_1
Xclkbuf_leaf_96_clk_i clkload30/A clkbuf_leaf_97_clk_i/A VDD VSS sg13g2_buf_8
XFILLER_7_633 VDD VSS sg13g2_decap_8
XFILLER_155_133 VDD VSS sg13g2_decap_8
Xwire564 wire564/X wire564/A VDD VSS sg13g2_buf_2
XFILLER_10_183 VDD VSS sg13g2_decap_8
X_10506_ _10575_/C _10538_/A _10654_/A VDD VSS sg13g2_nor2_1
X_14274_ _14274_/Q clkload22/A _14274_/D _14274_/RESET_B VDD VSS sg13g2_dfrbpq_1
X_11486_ _11486_/X _13826_/Q _13858_/Q _13890_/Q _13922_/Q _11711_/S0 _11714_/S1 VDD
+ VSS sg13g2_mux4_1
Xmax_cap308 _10066_/S _10062_/S VDD VSS sg13g2_buf_4
X_14075__2489 _14075_/RESET_B VDD VSS sg13g2_tiehi
X_13225_ _13225_/X _13225_/A _13225_/B _13226_/B VDD VSS sg13g2_and3_1
XFILLER_13_1195 VDD VSS sg13g2_decap_8
X_10437_ _14835_/D _14835_/Q _10443_/D _10436_/Y VDD VSS sg13g2_a21oi_1
XFILLER_136_380 VDD VSS sg13g2_fill_2
XFILLER_83_1105 VDD VSS sg13g2_decap_8
XFILLER_40_7 VDD VSS sg13g2_decap_8
X_13156_ _13174_/B _14917_/Q _13670_/Q VDD VSS sg13g2_nor2_1
X_10368_ _10391_/C _10400_/A _10397_/B _10395_/A _10400_/C VDD VSS sg13g2_nor4_1
XFILLER_88_72 VDD VSS sg13g2_decap_8
XFILLER_124_575 VDD VSS sg13g2_decap_4
XFILLER_97_426 VDD VSS sg13g2_decap_8
X_12107_ _12108_/A _14260_/Q _14292_/Q _14324_/Q _14356_/Q _12107_/S0 _12091_/C VDD
+ VSS sg13g2_mux4_1
XFILLER_111_214 VDD VSS sg13g2_decap_8
X_15014__2958 _15014_/RESET_B VDD VSS sg13g2_tiehi
X_13087_ _15038_/D _13266_/A _13087_/B VDD VSS sg13g2_nor2_1
X_10299_ _10299_/Y _10299_/A _10299_/B _10299_/C VDD VSS sg13g2_nor3_1
XFILLER_111_258 VDD VSS sg13g2_decap_8
X_12038_ _12038_/Y _12040_/A1 _14162_/Q _12038_/B1 VDD VSS sg13g2_a21oi_1
Xfanout1640 _12026_/C _12038_/B1 VDD VSS sg13g2_buf_1
X_14290__2274 _14290_/RESET_B VDD VSS sg13g2_tiehi
Xfanout1651 _12307_/C _11890_/S1 VDD VSS sg13g2_buf_1
XFILLER_77_161 VDD VSS sg13g2_decap_4
Xclkbuf_leaf_34_clk_i clkload45/A clkbuf_leaf_34_clk_i/A VDD VSS sg13g2_buf_8
Xfanout1673 _11648_/S0 _12207_/S0 VDD VSS sg13g2_buf_1
XFILLER_78_695 VDD VSS sg13g2_fill_2
XFILLER_93_621 VDD VSS sg13g2_fill_1
Xfanout1684 _11621_/S0 fanout1688/X VDD VSS sg13g2_buf_1
XFILLER_77_183 VDD VSS sg13g2_decap_8
XFILLER_93_632 VDD VSS sg13g2_fill_1
Xfanout1695 _11531_/A _12250_/A1 VDD VSS sg13g2_buf_1
XFILLER_20_1100 VDD VSS sg13g2_decap_8
XFILLER_92_120 VDD VSS sg13g2_decap_8
XFILLER_66_879 VDD VSS sg13g2_fill_1
XFILLER_92_142 VDD VSS sg13g2_fill_2
XFILLER_81_816 VDD VSS sg13g2_decap_4
XFILLER_53_518 VDD VSS sg13g2_fill_2
XFILLER_81_838 VDD VSS sg13g2_decap_8
X_13989_ _13989_/Q clkload0/A _13989_/D _13989_/RESET_B VDD VSS sg13g2_dfrbpq_1
XFILLER_46_581 VDD VSS sg13g2_decap_8
XFILLER_20_1177 VDD VSS sg13g2_decap_8
Xclkbuf_leaf_49_clk_i _14714_/CLK clkbuf_leaf_49_clk_i/A VDD VSS sg13g2_buf_8
XFILLER_55_1229 VDD VSS sg13g2_decap_8
X_08200_ _08201_/D _08200_/A _08200_/B _08200_/C VDD VSS sg13g2_nor3_1
XFILLER_21_437 VDD VSS sg13g2_decap_8
X_09180_ _13796_/D _13796_/Q _10147_/A1 _09200_/S VDD VSS sg13g2_mux2_1
XFILLER_18_1051 VDD VSS sg13g2_decap_8
XFILLER_30_960 VDD VSS sg13g2_fill_1
X_08131_ _08131_/Y _08488_/A _08128_/X _08130_/Y VDD VSS sg13g2_o21ai_1
XFILLER_146_111 VDD VSS sg13g2_decap_8
X_08062_ _08256_/A _08328_/S _08059_/X _08061_/Y VDD VSS sg13g2_o21ai_1
X_14804__3294 _14804_/RESET_B VDD VSS sg13g2_tiehi
XFILLER_134_339 VDD VSS sg13g2_fill_1
X_13740__2824 _13740_/RESET_B VDD VSS sg13g2_tiehi
XFILLER_142_350 VDD VSS sg13g2_fill_1
XFILLER_115_586 VDD VSS sg13g2_decap_8
XFILLER_130_512 VDD VSS sg13g2_decap_8
X_08964_ _09839_/D _09707_/B _09441_/C _09641_/A VDD VSS sg13g2_nand3b_1
XFILLER_25_1011 VDD VSS sg13g2_decap_8
XFILLER_102_258 VDD VSS sg13g2_decap_8
X_14120__2444 _14120_/RESET_B VDD VSS sg13g2_tiehi
X_07915_ _07917_/C _07884_/Y _07900_/Y _07914_/Y VDD VSS sg13g2_a21oi_1
XFILLER_116_1150 VDD VSS sg13g2_decap_8
X_08895_ _08895_/X _08894_/X _11770_/A _08955_/S VDD VSS sg13g2_mux2_1
XFILLER_97_982 VDD VSS sg13g2_decap_4
XFILLER_99_1101 VDD VSS sg13g2_decap_4
XFILLER_130_589 VDD VSS sg13g2_fill_1
XFILLER_56_301 VDD VSS sg13g2_decap_8
XFILLER_97_993 VDD VSS sg13g2_decap_4
XFILLER_29_537 VDD VSS sg13g2_fill_1
X_07846_ _08650_/A _08678_/B _08678_/C VDD VSS sg13g2_and2_1
XFILLER_25_1088 VDD VSS sg13g2_decap_8
XFILLER_68_183 VDD VSS sg13g2_fill_1
XFILLER_56_334 VDD VSS sg13g2_fill_2
XFILLER_57_868 VDD VSS sg13g2_decap_8
XFILLER_56_356 VDD VSS sg13g2_fill_1
XFILLER_57_879 VDD VSS sg13g2_fill_1
XFILLER_17_35 VDD VSS sg13g2_decap_8
XFILLER_140_14 VDD VSS sg13g2_decap_8
X_07777_ _07777_/Y _08276_/B _11570_/A VDD VSS sg13g2_nand2b_1
XFILLER_99_1189 VDD VSS sg13g2_fill_1
XFILLER_84_698 VDD VSS sg13g2_decap_4
X_09516_ _14115_/D _09650_/A0 _14115_/Q _09520_/S VDD VSS sg13g2_mux2_1
X_09447_ _14048_/D _09447_/A0 _14048_/Q _09454_/S VDD VSS sg13g2_mux2_1
X_15238__3391 _15238_/RESET_B VDD VSS sg13g2_tiehi
X_09378_ _13981_/D _09609_/A0 _13981_/Q _09380_/S VDD VSS sg13g2_mux2_1
XFILLER_33_78 VDD VSS sg13g2_decap_8
XFILLER_149_56 VDD VSS sg13g2_decap_8
X_08329_ _08329_/Y _08329_/A _08329_/B VDD VSS sg13g2_nand2_1
XFILLER_123_1132 VDD VSS sg13g2_fill_1
X_13691__2875 _13691_/RESET_B VDD VSS sg13g2_tiehi
XFILLER_126_807 VDD VSS sg13g2_decap_8
X_11340_ _11340_/Y _07684_/B _11339_/Y wire256/X _11333_/Y _11248_/B VDD VSS sg13g2_a221oi_1
XFILLER_119_870 VDD VSS sg13g2_decap_4
XFILLER_119_892 VDD VSS sg13g2_fill_2
X_11271_ _11271_/Y _11275_/S0 _14396_/Q _11262_/B VDD VSS sg13g2_a21oi_1
XFILLER_152_147 VDD VSS sg13g2_decap_8
XFILLER_134_851 VDD VSS sg13g2_fill_1
X_13010_ _13026_/C _13010_/A _13010_/B VDD VSS sg13g2_nor2_1
X_10222_ _10222_/Y _14769_/Q _10219_/X _10337_/C VDD VSS sg13g2_o21ai_1
XFILLER_106_597 VDD VSS sg13g2_decap_8
X_10153_ _14730_/D _14730_/Q _10153_/A1 _10167_/S VDD VSS sg13g2_mux2_1
XFILLER_79_448 VDD VSS sg13g2_fill_1
XFILLER_0_831 VDD VSS sg13g2_decap_8
XFILLER_121_545 VDD VSS sg13g2_fill_1
XFILLER_95_919 VDD VSS sg13g2_decap_4
XFILLER_43_1133 VDD VSS sg13g2_decap_8
X_10084_ _14664_/D _10084_/A0 _14664_/Q _10084_/S VDD VSS sg13g2_mux2_1
XFILLER_48_813 VDD VSS sg13g2_fill_2
X_14961_ _14961_/Q clkload41/A _14961_/D _14961_/RESET_B VDD VSS sg13g2_dfrbpq_1
XFILLER_82_1193 VDD VSS sg13g2_decap_8
XFILLER_48_846 VDD VSS sg13g2_decap_4
X_13912_ _13912_/Q clkload36/A _13912_/D _13912_/RESET_B VDD VSS sg13g2_dfrbpq_1
XFILLER_43_1188 VDD VSS sg13g2_decap_4
X_14892_ _14892_/Q clkload70/A _14892_/D _14892_/RESET_B VDD VSS sg13g2_dfrbpq_1
XFILLER_35_507 VDD VSS sg13g2_fill_2
XFILLER_130_1158 VDD VSS sg13g2_decap_8
XFILLER_75_676 VDD VSS sg13g2_fill_1
X_14854__3221 _14854_/RESET_B VDD VSS sg13g2_tiehi
X_13843_ _13843_/Q clkload12/A _13843_/D _13843_/RESET_B VDD VSS sg13g2_dfrbpq_1
X_13774_ _13774_/Q _14763_/CLK _13774_/D _13774_/RESET_B VDD VSS sg13g2_dfrbpq_1
X_10986_ _14940_/D _10985_/X _10984_/Y _10973_/Y VDD VSS sg13g2_o21ai_1
XFILLER_128_1010 VDD VSS sg13g2_decap_8
XFILLER_16_765 VDD VSS sg13g2_decap_4
X_12725_ _12725_/X _14390_/Q _14422_/Q _14486_/Q _14518_/Q _12755_/S0 _12759_/S1 VDD
+ VSS sg13g2_mux4_1
XFILLER_31_713 VDD VSS sg13g2_decap_8
XFILLER_71_893 VDD VSS sg13g2_decap_8
XFILLER_128_1054 VDD VSS sg13g2_decap_4
X_14887__3155 _14887_/RESET_B VDD VSS sg13g2_tiehi
X_12656_ _12656_/X _14129_/Q _14161_/Q _14193_/Q _14225_/Q _12657_/S0 _12659_/S1 VDD
+ VSS sg13g2_mux4_1
XFILLER_31_779 VDD VSS sg13g2_decap_8
XFILLER_15_1213 VDD VSS sg13g2_decap_8
XFILLER_88_7 VDD VSS sg13g2_decap_8
XFILLER_141_1232 VDD VSS sg13g2_decap_4
XFILLER_12_982 VDD VSS sg13g2_decap_8
X_11607_ _11608_/A _13734_/Q _14086_/Q _14438_/Q _14534_/Q _12206_/S0 _12091_/C VDD
+ VSS sg13g2_mux4_1
X_12587_ _12587_/X _14380_/Q _14412_/Q _14476_/Q _14508_/Q _12588_/S0 _12592_/S1 VDD
+ VSS sg13g2_mux4_1
XFILLER_156_431 VDD VSS sg13g2_decap_8
XFILLER_102_1205 VDD VSS sg13g2_decap_8
XFILLER_156_442 VDD VSS sg13g2_fill_1
XFILLER_7_441 VDD VSS sg13g2_decap_8
X_14326_ _14326_/Q clkload33/A _14326_/D _14326_/RESET_B VDD VSS sg13g2_dfrbpq_1
X_11538_ _11538_/Y _12259_/S0 _14628_/Q VDD VSS sg13g2_nand2b_1
XFILLER_7_452 VDD VSS sg13g2_fill_1
Xwire372 wire372/X wire372/A VDD VSS sg13g2_buf_2
XFILLER_156_486 VDD VSS sg13g2_decap_4
XFILLER_128_177 VDD VSS sg13g2_decap_8
XFILLER_7_485 VDD VSS sg13g2_decap_8
X_11469_ _11469_/X _14369_/Q _14401_/Q _14465_/Q _14497_/Q _11686_/S0 _11693_/C VDD
+ VSS sg13g2_mux4_1
X_14257_ _14257_/Q _14737_/CLK _14257_/D _14257_/RESET_B VDD VSS sg13g2_dfrbpq_1
XFILLER_143_147 VDD VSS sg13g2_decap_8
XFILLER_125_862 VDD VSS sg13g2_fill_2
X_13208_ _13208_/Y _14793_/Q _13236_/A2 _13262_/B1 VDD VSS sg13g2_o21ai_1
X_14188_ _14188_/Q _14714_/CLK _14188_/D _14188_/RESET_B VDD VSS sg13g2_dfrbpq_1
XFILLER_152_681 VDD VSS sg13g2_decap_8
XFILLER_139_1183 VDD VSS sg13g2_decap_4
XFILLER_112_523 VDD VSS sg13g2_decap_8
XFILLER_3_680 VDD VSS sg13g2_fill_2
X_13139_ _13139_/Y _13139_/A _13139_/B VDD VSS sg13g2_nand2_1
XFILLER_2_190 VDD VSS sg13g2_decap_4
XFILLER_61_1211 VDD VSS sg13g2_decap_4
XFILLER_140_887 VDD VSS sg13g2_fill_1
XFILLER_97_267 VDD VSS sg13g2_decap_8
XFILLER_85_418 VDD VSS sg13g2_decap_8
XFILLER_66_610 VDD VSS sg13g2_decap_8
XFILLER_38_312 VDD VSS sg13g2_decap_4
X_07700_ _15202_/D _07700_/A _07700_/B _07700_/C VDD VSS sg13g2_nand3_1
Xfanout1470 _11526_/A _08327_/A3 VDD VSS sg13g2_buf_1
XFILLER_78_492 VDD VSS sg13g2_fill_2
X_08680_ _08681_/B _08678_/C _08654_/A _07841_/Y VDD VSS sg13g2_o21ai_1
Xfanout1481 _11461_/A _14963_/Q VDD VSS sg13g2_buf_1
Xfanout1492 _11335_/A _14959_/Q VDD VSS sg13g2_buf_1
X_07631_ _07631_/Y _08200_/B VDD VSS sg13g2_inv_1
XFILLER_4_1160 VDD VSS sg13g2_decap_8
XFILLER_26_529 VDD VSS sg13g2_decap_8
XFILLER_0_1002 VDD VSS sg13g2_fill_1
XFILLER_55_1004 VDD VSS sg13g2_decap_8
X_09301_ _13909_/D _13909_/Q _10131_/A0 _09306_/S VDD VSS sg13g2_mux2_1
X_13758__2806 _13758_/RESET_B VDD VSS sg13g2_tiehi
XFILLER_94_1086 VDD VSS sg13g2_decap_8
XFILLER_107_1105 VDD VSS sg13g2_decap_8
XFILLER_55_1048 VDD VSS sg13g2_fill_1
XFILLER_61_381 VDD VSS sg13g2_decap_8
XFILLER_142_1007 VDD VSS sg13g2_fill_2
X_09232_ _13843_/D _09332_/A0 _13843_/Q _09232_/S VDD VSS sg13g2_mux2_1
XFILLER_10_919 VDD VSS sg13g2_decap_8
XFILLER_148_943 VDD VSS sg13g2_fill_1
X_09163_ _09164_/D _14925_/Q _14924_/Q VDD VSS sg13g2_nor2b_1
XFILLER_9_91 VDD VSS sg13g2_decap_8
XFILLER_147_442 VDD VSS sg13g2_fill_1
XFILLER_148_976 VDD VSS sg13g2_decap_8
X_08114_ _08115_/B _07879_/A _08200_/B _08113_/Y VDD VSS sg13g2_a21oi_1
X_14138__2426 _14138_/RESET_B VDD VSS sg13g2_tiehi
X_09094_ _10747_/B _09100_/B _15042_/Q _09093_/Y VDD VSS sg13g2_o21ai_1
XFILLER_134_114 VDD VSS sg13g2_fill_2
X_08045_ _08045_/Y _08199_/B _08044_/X _08043_/Y VDD VSS sg13g2_o21ai_1
XFILLER_116_851 VDD VSS sg13g2_decap_8
XFILLER_66_1111 VDD VSS sg13g2_fill_1
XFILLER_89_702 VDD VSS sg13g2_fill_1
XFILLER_134_169 VDD VSS sg13g2_decap_8
Xmax_cap661 _09539_/S _09527_/S VDD VSS sg13g2_buf_4
XFILLER_135_14 VDD VSS sg13g2_decap_8
XFILLER_66_1144 VDD VSS sg13g2_decap_8
XFILLER_103_501 VDD VSS sg13g2_decap_4
XFILLER_1_628 VDD VSS sg13g2_decap_8
Xmax_cap683 _09370_/S _09371_/S VDD VSS sg13g2_buf_4
Xmax_cap694 _09223_/S _09232_/S VDD VSS sg13g2_buf_4
XFILLER_115_372 VDD VSS sg13g2_fill_2
XFILLER_153_1114 VDD VSS sg13g2_decap_8
XFILLER_27_1117 VDD VSS sg13g2_decap_8
XFILLER_0_127 VDD VSS sg13g2_decap_8
XFILLER_66_1177 VDD VSS sg13g2_decap_8
XFILLER_88_234 VDD VSS sg13g2_decap_8
X_14353__2211 _14353_/RESET_B VDD VSS sg13g2_tiehi
XFILLER_0_138 VDD VSS sg13g2_fill_1
XFILLER_103_545 VDD VSS sg13g2_decap_4
XFILLER_130_331 VDD VSS sg13g2_decap_8
X_09996_ _14579_/D _10062_/A0 _14579_/Q _09996_/S VDD VSS sg13g2_mux2_1
XFILLER_77_919 VDD VSS sg13g2_decap_4
XFILLER_103_556 VDD VSS sg13g2_fill_2
XFILLER_48_109 VDD VSS sg13g2_fill_1
X_08947_ _13720_/D _08956_/S _08945_/Y _08946_/Y VDD VSS sg13g2_a21oi_1
XFILLER_9_1071 VDD VSS sg13g2_decap_8
XFILLER_85_941 VDD VSS sg13g2_fill_1
XFILLER_130_397 VDD VSS sg13g2_decap_8
X_08878_ _08878_/X _15033_/Q _08877_/A _08877_/Y VDD VSS sg13g2_a21o_1
XFILLER_84_440 VDD VSS sg13g2_fill_2
XFILLER_151_35 VDD VSS sg13g2_decap_8
X_07829_ _07906_/B _07829_/A _07829_/B VDD VSS sg13g2_and2_1
XFILLER_44_315 VDD VSS sg13g2_fill_1
XFILLER_56_175 VDD VSS sg13g2_fill_2
XFILLER_44_337 VDD VSS sg13g2_decap_8
X_14386__2178 _14386_/RESET_B VDD VSS sg13g2_tiehi
X_10840_ _10841_/C _10851_/D _12347_/B _10821_/C _10821_/A _10818_/Y VDD VSS sg13g2_a221oi_1
XFILLER_53_860 VDD VSS sg13g2_decap_8
X_10771_ _14919_/D _11168_/B1 _10768_/Y _10770_/Y VDD VSS sg13g2_o21ai_1
XFILLER_13_735 VDD VSS sg13g2_decap_8
XFILLER_12_212 VDD VSS sg13g2_decap_8
X_12510_ _12510_/X _12506_/X _12505_/X _12504_/X _12503_/X _12705_/S0 _12691_/S0 VDD
+ VSS sg13g2_mux4_1
XFILLER_13_757 VDD VSS sg13g2_decap_8
X_13490_ _13490_/Y _15198_/Q _13490_/B _13490_/C _13490_/D VDD VSS sg13g2_nor4_1
X_12441_ _12441_/X _12439_/X _12440_/X _12483_/S VDD VSS sg13g2_mux2_1
XFILLER_40_576 VDD VSS sg13g2_decap_4
XFILLER_60_21 VDD VSS sg13g2_decap_8
XFILLER_139_965 VDD VSS sg13g2_fill_1
XFILLER_21_790 VDD VSS sg13g2_fill_1
X_15160_ _15160_/Q _15160_/CLK _15160_/D _15160_/RESET_B VDD VSS sg13g2_dfrbpq_1
X_12372_ _12372_/Y _12415_/A _12372_/B VDD VSS sg13g2_nand2_1
XFILLER_154_924 VDD VSS sg13g2_decap_8
XFILLER_139_998 VDD VSS sg13g2_fill_1
XFILLER_60_98 VDD VSS sg13g2_fill_2
X_11323_ _11323_/Y _11328_/S0 _14141_/Q _11328_/S1 VDD VSS sg13g2_a21oi_1
X_14111_ _14111_/Q clkload56/A _14111_/D _14111_/RESET_B VDD VSS sg13g2_dfrbpq_1
XFILLER_114_0 VDD VSS sg13g2_decap_8
XFILLER_125_114 VDD VSS sg13g2_decap_8
X_15091_ _15091_/Q clkload66/A _15091_/D _15091_/RESET_B VDD VSS sg13g2_dfrbpq_1
XFILLER_125_125 VDD VSS sg13g2_fill_2
XFILLER_10_1143 VDD VSS sg13g2_decap_8
XFILLER_153_467 VDD VSS sg13g2_decap_8
XFILLER_5_49 VDD VSS sg13g2_decap_8
XFILLER_5_978 VDD VSS sg13g2_decap_8
X_11254_ _11255_/A _11257_/S0 _14652_/Q _11894_/B VDD VSS sg13g2_a21oi_1
XFILLER_109_81 VDD VSS sg13g2_decap_8
X_14042_ _14042_/Q _15040_/CLK _14042_/D _14042_/RESET_B VDD VSS sg13g2_dfrbpq_1
XFILLER_106_372 VDD VSS sg13g2_fill_2
X_10205_ _15200_/D input28/X _13448_/B _10205_/S VDD VSS sg13g2_mux2_1
XFILLER_122_832 VDD VSS sg13g2_fill_1
XFILLER_122_843 VDD VSS sg13g2_decap_8
X_11185_ _11197_/B _11185_/A _11185_/B VDD VSS sg13g2_xnor2_1
XFILLER_68_919 VDD VSS sg13g2_decap_8
X_13836__2728 _13836_/RESET_B VDD VSS sg13g2_tiehi
X_14596__1968 _14596_/RESET_B VDD VSS sg13g2_tiehi
XFILLER_0_650 VDD VSS sg13g2_fill_1
X_10136_ _14714_/D _10136_/A0 _14714_/Q _10136_/S VDD VSS sg13g2_mux2_1
XFILLER_94_226 VDD VSS sg13g2_decap_4
XFILLER_95_749 VDD VSS sg13g2_decap_8
XFILLER_76_941 VDD VSS sg13g2_decap_8
X_10067_ _14648_/D _10167_/A1 _14648_/Q _10067_/S VDD VSS sg13g2_mux2_1
X_14944_ _14944_/Q clkload61/A _14944_/D _14944_/RESET_B VDD VSS sg13g2_dfrbpq_1
XFILLER_76_974 VDD VSS sg13g2_decap_8
XFILLER_91_900 VDD VSS sg13g2_decap_8
XFILLER_75_473 VDD VSS sg13g2_decap_8
X_14875_ _14875_/Q clkload78/A _14875_/D _14875_/RESET_B VDD VSS sg13g2_dfrbpq_1
XFILLER_75_484 VDD VSS sg13g2_fill_2
XFILLER_78_1026 VDD VSS sg13g2_fill_1
XFILLER_62_112 VDD VSS sg13g2_decap_8
XFILLER_90_421 VDD VSS sg13g2_fill_2
X_14216__2348 _14216_/RESET_B VDD VSS sg13g2_tiehi
XFILLER_35_348 VDD VSS sg13g2_decap_4
X_13826_ _13826_/Q _14722_/CLK _13826_/D _13826_/RESET_B VDD VSS sg13g2_dfrbpq_1
XFILLER_91_966 VDD VSS sg13g2_decap_8
XFILLER_63_679 VDD VSS sg13g2_decap_8
X_13757_ _13757_/Q clkload53/A _13757_/D _13757_/RESET_B VDD VSS sg13g2_dfrbpq_1
X_10969_ _10969_/Y _10969_/A _10969_/B VDD VSS sg13g2_nand2_1
X_12708_ _15014_/D _12708_/A wire370/X VDD VSS sg13g2_nor2_1
X_13688_ _13688_/Q clkload63/A _13688_/D _13688_/RESET_B VDD VSS sg13g2_dfrbpq_1
X_14431__2133 _14431_/RESET_B VDD VSS sg13g2_tiehi
X_12639_ _12652_/A _12709_/A1 _12779_/A2 _15010_/Q VDD VSS sg13g2_a21oi_1
XFILLER_106_1160 VDD VSS sg13g2_decap_8
XFILLER_106_1171 VDD VSS sg13g2_fill_1
XFILLER_89_1122 VDD VSS sg13g2_fill_1
XFILLER_156_250 VDD VSS sg13g2_fill_1
XFILLER_145_935 VDD VSS sg13g2_fill_2
XFILLER_15_1087 VDD VSS sg13g2_decap_8
XFILLER_117_637 VDD VSS sg13g2_decap_4
XFILLER_156_294 VDD VSS sg13g2_decap_4
X_14309_ _14309_/Q _14405_/CLK _14309_/D _14309_/RESET_B VDD VSS sg13g2_dfrbpq_1
XFILLER_144_456 VDD VSS sg13g2_decap_8
XFILLER_116_147 VDD VSS sg13g2_decap_8
XFILLER_137_1109 VDD VSS sg13g2_fill_1
XFILLER_131_106 VDD VSS sg13g2_decap_8
X_09850_ _14437_/D _14437_/Q _09850_/A1 _09852_/S VDD VSS sg13g2_mux2_1
Xfanout707 _08935_/S _08941_/S VDD VSS sg13g2_buf_1
XFILLER_59_908 VDD VSS sg13g2_fill_2
Xfanout718 _08588_/B _08000_/X VDD VSS sg13g2_buf_1
XFILLER_86_705 VDD VSS sg13g2_fill_2
X_08801_ _08802_/B _13685_/Q _08807_/B VDD VSS sg13g2_nor2_1
X_15237__3390 _15237_/RESET_B VDD VSS sg13g2_tiehi
XFILLER_98_576 VDD VSS sg13g2_fill_2
XFILLER_113_898 VDD VSS sg13g2_decap_8
X_09781_ _14370_/D _09880_/A0 _14370_/Q _09801_/S VDD VSS sg13g2_mux2_1
XFILLER_58_429 VDD VSS sg13g2_fill_1
XFILLER_105_28 VDD VSS sg13g2_decap_8
XFILLER_140_695 VDD VSS sg13g2_fill_2
XFILLER_6_1222 VDD VSS sg13g2_decap_8
XFILLER_39_621 VDD VSS sg13g2_fill_2
XFILLER_85_237 VDD VSS sg13g2_fill_2
XFILLER_113_1120 VDD VSS sg13g2_fill_2
X_08732_ _13662_/D _08753_/A1 _08730_/Y _08731_/Y VDD VSS sg13g2_a21oi_1
XFILLER_2_1108 VDD VSS sg13g2_decap_8
X_08663_ _08663_/X _08663_/A _08698_/B VDD VSS sg13g2_and2_1
XFILLER_22_1058 VDD VSS sg13g2_decap_8
XFILLER_53_123 VDD VSS sg13g2_decap_4
X_07614_ _07614_/Y _14955_/Q VDD VSS sg13g2_inv_1
X_08594_ _08596_/C _08306_/A _07858_/X _07857_/X _08593_/Y VDD VSS sg13g2_a22oi_1
X_14641__1923 _14641_/RESET_B VDD VSS sg13g2_tiehi
XFILLER_35_860 VDD VSS sg13g2_fill_2
X_14968__3004 _14968_/RESET_B VDD VSS sg13g2_tiehi
XFILLER_62_690 VDD VSS sg13g2_decap_8
XFILLER_14_14 VDD VSS sg13g2_decap_8
X_14070__2494 _14070_/RESET_B VDD VSS sg13g2_tiehi
XFILLER_22_554 VDD VSS sg13g2_decap_8
XFILLER_33_1110 VDD VSS sg13g2_decap_4
XFILLER_10_716 VDD VSS sg13g2_decap_8
XFILLER_139_239 VDD VSS sg13g2_decap_4
X_09215_ _13826_/D _10145_/A1 _13826_/Q _09235_/S VDD VSS sg13g2_mux2_1
X_09146_ _13783_/D _13783_/Q _10033_/A0 _09146_/S VDD VSS sg13g2_mux2_1
XFILLER_147_250 VDD VSS sg13g2_fill_2
XFILLER_30_35 VDD VSS sg13g2_decap_8
X_09077_ _13773_/D _13773_/Q _10156_/A1 _09106_/S VDD VSS sg13g2_mux2_1
XFILLER_135_456 VDD VSS sg13g2_decap_8
XFILLER_146_35 VDD VSS sg13g2_decap_8
X_08028_ _08031_/C _07912_/B _07910_/B _07888_/B _08219_/A _08327_/S0 _08099_/S0 VDD
+ VSS sg13g2_mux4_1
XFILLER_150_404 VDD VSS sg13g2_fill_2
X_14871__3187 _14871_/RESET_B VDD VSS sg13g2_tiehi
XFILLER_146_79 VDD VSS sg13g2_fill_1
XFILLER_116_681 VDD VSS sg13g2_fill_2
XFILLER_118_1020 VDD VSS sg13g2_fill_2
XFILLER_150_448 VDD VSS sg13g2_decap_8
Xmax_cap491 _09330_/S _09311_/S VDD VSS sg13g2_buf_4
XFILLER_1_436 VDD VSS sg13g2_decap_8
XFILLER_104_843 VDD VSS sg13g2_decap_8
XFILLER_1_447 VDD VSS sg13g2_fill_2
X_09979_ _14562_/D _10078_/A0 _14562_/Q _09996_/S VDD VSS sg13g2_mux2_1
XFILLER_103_386 VDD VSS sg13g2_decap_8
X_12990_ _12990_/X _12990_/A _13683_/Q _14904_/Q VDD VSS sg13g2_and3_1
XFILLER_58_974 VDD VSS sg13g2_decap_8
XFILLER_18_827 VDD VSS sg13g2_decap_8
XFILLER_55_21 VDD VSS sg13g2_decap_8
X_11941_ _11941_/Y _11969_/A _14160_/Q _11970_/C VDD VSS sg13g2_a21oi_1
XFILLER_55_32 VDD VSS sg13g2_fill_1
XFILLER_55_43 VDD VSS sg13g2_decap_8
XFILLER_45_657 VDD VSS sg13g2_fill_1
X_14660_ _14660_/Q clkload36/A _14660_/D _14660_/RESET_B VDD VSS sg13g2_dfrbpq_1
X_11872_ _11872_/Y _11896_/A _13934_/Q _11894_/B VDD VSS sg13g2_a21oi_1
XFILLER_44_167 VDD VSS sg13g2_decap_8
X_13611_ _15167_/D _13610_/Y _10173_/B _13608_/Y VDD VSS sg13g2_a21oi_1
X_10823_ _10823_/Y _10823_/A _10843_/C _10823_/C VDD VSS sg13g2_nand3_1
X_14591_ _14591_/Q clkload55/A _14591_/D _14591_/RESET_B VDD VSS sg13g2_dfrbpq_1
XFILLER_13_521 VDD VSS sg13g2_decap_8
XFILLER_77_1092 VDD VSS sg13g2_decap_8
XFILLER_53_690 VDD VSS sg13g2_decap_8
X_13542_ _13542_/Y _14995_/Q _13537_/B _15003_/Q _13546_/B2 VDD VSS sg13g2_a22oi_1
XFILLER_38_1076 VDD VSS sg13g2_decap_8
XFILLER_40_340 VDD VSS sg13g2_decap_8
X_10754_ _10754_/X _14947_/Q _10752_/A _10752_/Y VDD VSS sg13g2_a21o_1
XFILLER_13_565 VDD VSS sg13g2_fill_2
XFILLER_9_514 VDD VSS sg13g2_decap_8
XFILLER_38_1087 VDD VSS sg13g2_fill_1
XFILLER_71_53 VDD VSS sg13g2_fill_1
XFILLER_41_885 VDD VSS sg13g2_decap_8
XFILLER_71_64 VDD VSS sg13g2_decap_8
XFILLER_13_587 VDD VSS sg13g2_decap_8
XFILLER_9_536 VDD VSS sg13g2_fill_1
XFILLER_139_740 VDD VSS sg13g2_decap_8
X_10685_ _10685_/Y _12859_/A _10800_/B VDD VSS sg13g2_nand2_1
X_13473_ _15177_/D hold3411/X _15177_/Q _13479_/S VDD VSS sg13g2_mux2_1
XFILLER_125_1068 VDD VSS sg13g2_fill_1
XFILLER_51_1232 VDD VSS sg13g2_decap_4
XFILLER_71_97 VDD VSS sg13g2_fill_2
XFILLER_9_569 VDD VSS sg13g2_decap_8
X_15212_ _15212_/Q _15212_/CLK _15212_/D _15212_/RESET_B VDD VSS sg13g2_dfrbpq_1
X_12424_ _12424_/X _13824_/Q _13856_/Q _13888_/Q _13920_/Q _12424_/S0 _12508_/S1 VDD
+ VSS sg13g2_mux4_1
Xmax_cap1547 output54/A _16878_/A VDD VSS sg13g2_buf_4
Xmax_cap1558 output43/A _16867_/A VDD VSS sg13g2_buf_4
X_15143_ _15143_/Q clkload26/A _15143_/D _15143_/RESET_B VDD VSS sg13g2_dfrbpq_1
X_12355_ _12356_/B _12353_/X _12354_/X _12355_/S VDD VSS sg13g2_mux2_1
XFILLER_153_231 VDD VSS sg13g2_decap_8
X_11306_ _11306_/Y _11302_/Y _11303_/Y _11305_/Y _11304_/Y _11395_/B VDD VSS sg13g2_a221oi_1
XFILLER_5_775 VDD VSS sg13g2_fill_2
X_12286_ _12286_/X _13977_/Q _14009_/Q _14041_/Q _14073_/Q _12286_/S0 _12286_/S1 VDD
+ VSS sg13g2_mux4_1
X_15074_ _15074_/Q clkload70/A _15074_/D _15074_/RESET_B VDD VSS sg13g2_dfrbpq_1
XFILLER_49_1150 VDD VSS sg13g2_decap_4
X_14025_ _14025_/Q _14633_/CLK _14025_/D _14025_/RESET_B VDD VSS sg13g2_dfrbpq_1
XFILLER_113_139 VDD VSS sg13g2_decap_4
X_11237_ _11237_/Y _11378_/S _11231_/X _11236_/Y VDD VSS sg13g2_o21ai_1
XFILLER_45_1036 VDD VSS sg13g2_decap_8
XFILLER_110_813 VDD VSS sg13g2_decap_8
X_11168_ _11168_/X _11164_/C _11192_/B1 _11168_/B1 VDD VSS sg13g2_a21o_1
XFILLER_95_535 VDD VSS sg13g2_fill_2
X_10119_ _14697_/D _10152_/A1 _14697_/Q _10133_/S VDD VSS sg13g2_mux2_1
X_11099_ _11099_/Y _11098_/Y _11096_/Y _11095_/Y _11099_/B2 _11192_/B1 VDD VSS sg13g2_a221oi_1
XFILLER_95_568 VDD VSS sg13g2_decap_8
X_14449__2115 _14449_/RESET_B VDD VSS sg13g2_tiehi
X_14927_ _14927_/Q clkload63/A _14927_/D _14927_/RESET_B VDD VSS sg13g2_dfrbpq_1
XFILLER_35_112 VDD VSS sg13g2_decap_4
XFILLER_91_752 VDD VSS sg13g2_decap_8
X_14858_ _14858_/Q clkload79/A _14858_/D _14858_/RESET_B VDD VSS sg13g2_dfrbpq_1
XFILLER_24_819 VDD VSS sg13g2_fill_2
XFILLER_63_465 VDD VSS sg13g2_fill_2
XFILLER_64_988 VDD VSS sg13g2_decap_8
XFILLER_64_999 VDD VSS sg13g2_fill_1
XFILLER_56_1110 VDD VSS sg13g2_fill_2
XFILLER_35_178 VDD VSS sg13g2_decap_8
XFILLER_1_1174 VDD VSS sg13g2_decap_4
X_13809_ _13809_/Q _14737_/CLK _13809_/D _13809_/RESET_B VDD VSS sg13g2_dfrbpq_1
X_14789_ _14789_/Q clkload82/A _14789_/D _14789_/RESET_B VDD VSS sg13g2_dfrbpq_1
XFILLER_56_1143 VDD VSS sg13g2_decap_4
XFILLER_143_1124 VDD VSS sg13g2_decap_8
XFILLER_17_1127 VDD VSS sg13g2_decap_8
XFILLER_56_1187 VDD VSS sg13g2_fill_2
XFILLER_91_1078 VDD VSS sg13g2_fill_1
XFILLER_149_559 VDD VSS sg13g2_decap_8
X_09000_ _09000_/Y _14900_/Q _08993_/X _08999_/Y VDD VSS sg13g2_a21oi_1
XFILLER_77_0 VDD VSS sg13g2_decap_8
XFILLER_145_743 VDD VSS sg13g2_fill_1
XFILLER_118_968 VDD VSS sg13g2_fill_2
XFILLER_105_607 VDD VSS sg13g2_decap_8
XFILLER_6_70 VDD VSS sg13g2_decap_8
XFILLER_117_478 VDD VSS sg13g2_decap_8
XFILLER_132_415 VDD VSS sg13g2_decap_8
X_09902_ _14488_/D _09902_/A0 _14488_/Q wire321/X VDD VSS sg13g2_mux2_1
X_14659__1905 _14659_/RESET_B VDD VSS sg13g2_tiehi
XFILLER_28_1234 VDD VSS sg13g2_fill_2
XFILLER_63_1114 VDD VSS sg13g2_decap_8
Xfanout504 _09266_/S _09271_/S VDD VSS sg13g2_buf_1
XFILLER_59_705 VDD VSS sg13g2_fill_1
XFILLER_98_340 VDD VSS sg13g2_decap_8
Xfanout515 _09202_/S _09190_/S VDD VSS sg13g2_buf_1
XFILLER_116_49 VDD VSS sg13g2_fill_2
Xfanout526 _10078_/A0 _09913_/A1 VDD VSS sg13g2_buf_1
XFILLER_141_982 VDD VSS sg13g2_fill_1
X_09833_ _14421_/D _09899_/A0 _14421_/Q _09838_/S VDD VSS sg13g2_mux2_1
Xfanout548 _09167_/S _09084_/S VDD VSS sg13g2_buf_1
XFILLER_115_1226 VDD VSS sg13g2_decap_8
XFILLER_140_481 VDD VSS sg13g2_decap_8
Xfanout559 _13470_/A2 _13353_/Y VDD VSS sg13g2_buf_1
X_14088__2476 _14088_/RESET_B VDD VSS sg13g2_tiehi
X_09764_ _14354_/D _14354_/Q _09830_/A0 wire444/X VDD VSS sg13g2_mux2_1
XFILLER_67_771 VDD VSS sg13g2_decap_8
X_08715_ _15190_/D input17/X _15190_/Q _13336_/S VDD VSS sg13g2_mux2_1
XFILLER_6_1096 VDD VSS sg13g2_decap_8
X_09695_ _14287_/D _09926_/A1 _14287_/Q _09705_/S VDD VSS sg13g2_mux2_1
XFILLER_26_112 VDD VSS sg13g2_decap_8
XFILLER_54_432 VDD VSS sg13g2_decap_8
X_08646_ _08646_/Y _08646_/A _08646_/B _08646_/C VDD VSS sg13g2_nand3_1
XFILLER_26_145 VDD VSS sg13g2_decap_8
X_15027__2945 _15027_/RESET_B VDD VSS sg13g2_tiehi
XFILLER_148_1035 VDD VSS sg13g2_decap_8
XFILLER_42_616 VDD VSS sg13g2_decap_8
XFILLER_82_785 VDD VSS sg13g2_decap_8
XFILLER_26_178 VDD VSS sg13g2_fill_1
XFILLER_25_35 VDD VSS sg13g2_decap_8
XFILLER_54_487 VDD VSS sg13g2_fill_2
XFILLER_155_7 VDD VSS sg13g2_decap_8
X_08577_ _08577_/Y _08612_/S _08577_/B VDD VSS sg13g2_nor2_1
Xclkbuf_5_0__f_clk_i clkbuf_leaf_1_clk_i/A clkbuf_4_0_0_clk_i/X VDD VSS sg13g2_buf_16
XFILLER_23_863 VDD VSS sg13g2_decap_8
XFILLER_41_23 VDD VSS sg13g2_fill_1
XFILLER_155_529 VDD VSS sg13g2_decap_4
X_10470_ _10477_/C _14845_/Q _10511_/C _14843_/Q _10471_/D VDD VSS sg13g2_and4_1
XFILLER_148_581 VDD VSS sg13g2_fill_1
XFILLER_41_78 VDD VSS sg13g2_fill_2
X_09129_ _09129_/Y _13199_/A _09157_/C _09158_/A VDD VSS sg13g2_o21ai_1
X_14527__2037 _14527_/RESET_B VDD VSS sg13g2_tiehi
X_12140_ _12140_/X _13973_/Q _14005_/Q _14037_/Q _14069_/Q _12285_/S0 _12285_/S1 VDD
+ VSS sg13g2_mux4_1
XFILLER_2_712 VDD VSS sg13g2_decap_8
XFILLER_68_1069 VDD VSS sg13g2_decap_8
X_12071_ _12071_/X _13747_/Q _14099_/Q _14451_/Q _14547_/Q _12073_/S0 _12073_/S1 VDD
+ VSS sg13g2_mux4_1
X_11022_ _11022_/Y _11022_/A _11022_/B VDD VSS sg13g2_nand2_1
XFILLER_104_673 VDD VSS sg13g2_decap_8
XFILLER_89_373 VDD VSS sg13g2_decap_8
X_14817__3281 _14817_/RESET_B VDD VSS sg13g2_tiehi
XFILLER_103_161 VDD VSS sg13g2_decap_4
XFILLER_131_470 VDD VSS sg13g2_fill_2
XFILLER_1_288 VDD VSS sg13g2_fill_1
XFILLER_2_28 VDD VSS sg13g2_decap_8
XFILLER_103_194 VDD VSS sg13g2_fill_1
XFILLER_65_708 VDD VSS sg13g2_fill_2
X_13753__2811 _13753_/RESET_B VDD VSS sg13g2_tiehi
XFILLER_66_42 VDD VSS sg13g2_decap_8
XFILLER_92_527 VDD VSS sg13g2_decap_8
X_12973_ _12988_/D _14905_/Q _13682_/Q VDD VSS sg13g2_xnor2_1
XFILLER_131_1072 VDD VSS sg13g2_decap_8
XFILLER_18_657 VDD VSS sg13g2_decap_8
X_14712_ _14712_/Q clkload38/A _14712_/D _14712_/RESET_B VDD VSS sg13g2_dfrbpq_1
XFILLER_45_443 VDD VSS sg13g2_decap_8
X_11924_ _11924_/X _14127_/Q _14159_/Q _14191_/Q _14223_/Q _12073_/S0 _12073_/S1 VDD
+ VSS sg13g2_mux4_1
XFILLER_45_476 VDD VSS sg13g2_fill_1
XFILLER_61_925 VDD VSS sg13g2_decap_4
X_14643_ _14643_/Q clkload11/A _14643_/D _14643_/RESET_B VDD VSS sg13g2_dfrbpq_1
X_11855_ _11856_/B _11847_/X _11848_/X _11851_/X _11852_/X _11422_/B _11424_/B VDD
+ VSS sg13g2_mux4_1
XFILLER_60_424 VDD VSS sg13g2_fill_1
X_14133__2431 _14133_/RESET_B VDD VSS sg13g2_tiehi
XFILLER_32_126 VDD VSS sg13g2_decap_4
XFILLER_60_435 VDD VSS sg13g2_fill_2
XFILLER_14_841 VDD VSS sg13g2_decap_4
X_13786__2778 _13786_/RESET_B VDD VSS sg13g2_tiehi
XFILLER_82_85 VDD VSS sg13g2_decap_8
X_10806_ _10807_/C _15121_/Q _10813_/A VDD VSS sg13g2_xnor2_1
X_14574_ _14574_/Q _14670_/CLK _14574_/D _14574_/RESET_B VDD VSS sg13g2_dfrbpq_1
X_11786_ _11786_/X _14379_/Q _14411_/Q _14475_/Q _14507_/Q _12288_/S0 _12288_/S1 VDD
+ VSS sg13g2_mux4_1
X_13525_ _13525_/X _13525_/A _13537_/B VDD VSS sg13g2_and2_1
X_14737__1827 _14737_/RESET_B VDD VSS sg13g2_tiehi
X_10737_ _10737_/Y _13088_/A _11084_/B VDD VSS sg13g2_nand2_1
XFILLER_9_344 VDD VSS sg13g2_fill_1
XFILLER_16_1160 VDD VSS sg13g2_decap_8
XFILLER_70_7 VDD VSS sg13g2_decap_8
X_13456_ _13456_/X _15190_/Q _15191_/Q _15192_/Q _13463_/D VDD VSS sg13g2_or4_1
X_10668_ _10802_/A _15060_/Q _08977_/C _14926_/Q VDD VSS sg13g2_a21oi_1
XFILLER_12_1024 VDD VSS sg13g2_decap_8
XFILLER_51_1073 VDD VSS sg13g2_fill_2
X_14166__2398 _14166_/RESET_B VDD VSS sg13g2_tiehi
X_14952__3025 _14952_/RESET_B VDD VSS sg13g2_tiehi
X_12407_ _12407_/X _14239_/Q _14271_/Q _14303_/Q _14335_/Q _12592_/S0 _12592_/S1 VDD
+ VSS sg13g2_mux4_1
XFILLER_12_1046 VDD VSS sg13g2_decap_8
XFILLER_127_754 VDD VSS sg13g2_decap_8
X_10599_ _14876_/D _10602_/A _10599_/B _10610_/D VDD VSS sg13g2_nor3_1
X_13387_ _15082_/D _13367_/Y _13378_/C _13386_/Y VDD VSS sg13g2_o21ai_1
XFILLER_127_765 VDD VSS sg13g2_fill_1
Xoutput107 mem_axi_wdata[12] _15144_/Q VDD VSS sg13g2_buf_1
Xoutput118 mem_axi_wdata[22] _15154_/Q VDD VSS sg13g2_buf_1
Xmax_cap1399 _08686_/S0 _08215_/S0 VDD VSS sg13g2_buf_4
X_15126_ _15126_/Q clkload71/A _15126_/D _15126_/RESET_B VDD VSS sg13g2_dfrbpq_1
Xoutput129 mem_axi_wdata[3] _15135_/Q VDD VSS sg13g2_buf_1
XFILLER_86_1147 VDD VSS sg13g2_decap_8
X_12338_ _12338_/Y _14925_/Q _12338_/A2 _12334_/Y _12337_/Y VDD VSS sg13g2_a22oi_1
XFILLER_114_415 VDD VSS sg13g2_fill_2
XFILLER_5_572 VDD VSS sg13g2_decap_4
XFILLER_115_949 VDD VSS sg13g2_decap_8
XFILLER_142_757 VDD VSS sg13g2_decap_8
X_15057_ _15057_/Q _15209_/CLK _15057_/D _15057_/RESET_B VDD VSS sg13g2_dfrbpq_1
X_12269_ _12270_/B _12231_/X _12269_/A2 _12268_/Y VDD VSS sg13g2_a21oi_1
X_14008_ _14008_/Q _14506_/CLK _14008_/D _14008_/RESET_B VDD VSS sg13g2_dfrbpq_1
XFILLER_123_982 VDD VSS sg13g2_decap_8
X_14381__2183 _14381_/RESET_B VDD VSS sg13g2_tiehi
XFILLER_68_579 VDD VSS sg13g2_decap_8
XFILLER_62_1191 VDD VSS sg13g2_fill_1
XFILLER_49_782 VDD VSS sg13g2_decap_4
XFILLER_110_698 VDD VSS sg13g2_fill_1
XFILLER_23_1175 VDD VSS sg13g2_decap_8
XFILLER_37_944 VDD VSS sg13g2_decap_4
XFILLER_48_270 VDD VSS sg13g2_decap_8
X_08500_ _08501_/B _08527_/B _08498_/Y _08499_/Y VDD VSS sg13g2_a21o_1
XFILLER_58_1205 VDD VSS sg13g2_decap_8
X_14973__2999 _14973_/RESET_B VDD VSS sg13g2_tiehi
X_09480_ _14080_/D _09977_/A0 _14080_/Q _09503_/S VDD VSS sg13g2_mux2_1
XFILLER_51_413 VDD VSS sg13g2_fill_2
X_08431_ _08431_/X _08431_/A _08452_/B _08452_/C _08452_/D VDD VSS sg13g2_and4_1
XFILLER_63_284 VDD VSS sg13g2_decap_4
XFILLER_51_435 VDD VSS sg13g2_fill_2
X_08362_ _08362_/X _07790_/A _08405_/A1 _08376_/A3 _07775_/A _08457_/S0 _08598_/S1
+ VDD VSS sg13g2_mux4_1
X_08293_ _15228_/D _08293_/A _08293_/B VDD VSS sg13g2_nand2_1
XFILLER_20_855 VDD VSS sg13g2_decap_4
XFILLER_108_1096 VDD VSS sg13g2_decap_4
XFILLER_20_877 VDD VSS sg13g2_decap_4
X_13831__2733 _13831_/RESET_B VDD VSS sg13g2_tiehi
X_14591__1973 _14591_/RESET_B VDD VSS sg13g2_tiehi
XFILLER_30_1179 VDD VSS sg13g2_decap_8
XFILLER_118_787 VDD VSS sg13g2_decap_4
XFILLER_132_212 VDD VSS sg13g2_decap_8
XFILLER_105_426 VDD VSS sg13g2_decap_8
XFILLER_117_297 VDD VSS sg13g2_fill_1
XFILLER_133_757 VDD VSS sg13g2_fill_2
XFILLER_105_459 VDD VSS sg13g2_fill_1
XFILLER_28_1031 VDD VSS sg13g2_fill_2
Xfanout334 _09593_/S wire337/A VDD VSS sg13g2_buf_1
X_14211__2353 _14211_/RESET_B VDD VSS sg13g2_tiehi
XFILLER_8_1125 VDD VSS sg13g2_decap_8
XFILLER_87_833 VDD VSS sg13g2_decap_8
XFILLER_143_14 VDD VSS sg13g2_decap_8
Xfanout356 _10077_/A0 _09001_/X VDD VSS sg13g2_buf_1
X_09816_ _14404_/D _09915_/A1 _14404_/Q wire618/X VDD VSS sg13g2_mux2_1
XFILLER_59_579 VDD VSS sg13g2_decap_8
XFILLER_86_376 VDD VSS sg13g2_fill_2
X_09747_ _14337_/D _14337_/Q _09747_/A1 _09770_/S VDD VSS sg13g2_mux2_1
XFILLER_74_549 VDD VSS sg13g2_decap_8
XFILLER_55_730 VDD VSS sg13g2_fill_1
XFILLER_27_432 VDD VSS sg13g2_decap_8
XFILLER_55_741 VDD VSS sg13g2_decap_8
X_09678_ _14270_/D _09744_/A1 _14270_/Q _09694_/S VDD VSS sg13g2_mux2_1
XFILLER_55_796 VDD VSS sg13g2_decap_4
X_08629_ _08629_/Y _08641_/B _08611_/Y _07966_/Y VDD VSS sg13g2_a21oi_1
XFILLER_14_126 VDD VSS sg13g2_fill_1
XFILLER_39_1160 VDD VSS sg13g2_decap_8
X_11640_ _11774_/A _11638_/X _11639_/Y _11590_/Y VDD VSS sg13g2_a21oi_1
XFILLER_35_1002 VDD VSS sg13g2_fill_2
XFILLER_39_1171 VDD VSS sg13g2_fill_1
X_15139__3064 _15139_/RESET_B VDD VSS sg13g2_tiehi
X_11571_ _11571_/Y _11638_/A _11638_/C _11571_/C VDD VSS sg13g2_nor3_1
XFILLER_126_1163 VDD VSS sg13g2_fill_1
XFILLER_156_805 VDD VSS sg13g2_fill_2
XFILLER_156_827 VDD VSS sg13g2_fill_1
XFILLER_22_192 VDD VSS sg13g2_decap_8
XFILLER_35_1079 VDD VSS sg13g2_fill_1
X_13310_ _13310_/Y _15071_/Q _13305_/B _13307_/Y _13279_/B _13308_/Y VDD VSS sg13g2_a221oi_1
X_15216__3369 _15216_/RESET_B VDD VSS sg13g2_tiehi
XFILLER_122_1038 VDD VSS sg13g2_fill_2
X_10522_ _14856_/D _10595_/B _10522_/B _10531_/D VDD VSS sg13g2_nor3_1
XFILLER_155_315 VDD VSS sg13g2_decap_8
XFILLER_6_303 VDD VSS sg13g2_fill_2
X_14290_ _14290_/Q _14738_/CLK _14290_/D _14290_/RESET_B VDD VSS sg13g2_dfrbpq_1
XFILLER_109_732 VDD VSS sg13g2_fill_1
X_10453_ _10453_/X _14840_/Q _14839_/Q _10453_/C wire760/X VDD VSS sg13g2_and4_1
X_13241_ _13242_/B _13245_/A _13665_/Q _13246_/C VDD VSS sg13g2_a21oi_1
XFILLER_136_551 VDD VSS sg13g2_decap_8
X_10384_ _10398_/D _14818_/Q _14819_/Q _10396_/C VDD VSS sg13g2_and3_1
X_13172_ _13172_/X _13172_/A _13172_/B _13172_/C _13172_/D VDD VSS sg13g2_and4_1
XFILLER_7_0 VDD VSS sg13g2_decap_8
X_12123_ _12123_/Y _12156_/A _12122_/Y _12227_/B VDD VSS sg13g2_o21ai_1
XFILLER_112_919 VDD VSS sg13g2_decap_8
XFILLER_78_811 VDD VSS sg13g2_decap_8
X_12054_ _12054_/Y _12055_/C _12055_/D VDD VSS sg13g2_nor2_1
XFILLER_117_81 VDD VSS sg13g2_decap_4
XFILLER_96_129 VDD VSS sg13g2_decap_8
XFILLER_81_1044 VDD VSS sg13g2_decap_8
XFILLER_133_1134 VDD VSS sg13g2_fill_2
X_11005_ _11005_/X _11005_/A _11007_/A VDD VSS sg13g2_or2_1
X_16862_ _16862_/X _16862_/A VDD VSS sg13g2_buf_1
XFILLER_78_877 VDD VSS sg13g2_fill_1
XFILLER_92_302 VDD VSS sg13g2_decap_8
Xfanout890 _08306_/A fanout894/X VDD VSS sg13g2_buf_1
XFILLER_58_590 VDD VSS sg13g2_decap_8
X_12956_ _15030_/D _12956_/A _13005_/C VDD VSS sg13g2_and2_1
XFILLER_19_988 VDD VSS sg13g2_decap_8
XFILLER_45_262 VDD VSS sg13g2_fill_2
XFILLER_34_947 VDD VSS sg13g2_fill_1
X_11907_ _11907_/X _11907_/A _11907_/B _11910_/B _11910_/C VDD VSS sg13g2_or4_1
XFILLER_61_733 VDD VSS sg13g2_decap_4
XFILLER_33_435 VDD VSS sg13g2_decap_4
XFILLER_61_744 VDD VSS sg13g2_fill_1
X_12887_ _12887_/Y _12886_/Y _13035_/A2 _12882_/Y VDD VSS sg13g2_a21oi_1
X_14626_ _14626_/Q _14722_/CLK _14626_/D _14626_/RESET_B VDD VSS sg13g2_dfrbpq_1
XFILLER_92_1140 VDD VSS sg13g2_decap_8
X_11838_ _11839_/B _11800_/Y _12051_/A1 _11837_/Y VDD VSS sg13g2_a21oi_1
XFILLER_18_1233 VDD VSS sg13g2_decap_4
XFILLER_53_1124 VDD VSS sg13g2_decap_8
XFILLER_42_991 VDD VSS sg13g2_decap_8
X_14557_ _14557_/Q clkload52/A _14557_/D _14557_/RESET_B VDD VSS sg13g2_dfrbpq_1
XFILLER_60_298 VDD VSS sg13g2_decap_8
X_11769_ _14972_/D _11729_/Y _11768_/Y _11724_/Y VDD VSS sg13g2_a21oi_1
X_14399__2165 _14399_/RESET_B VDD VSS sg13g2_tiehi
XFILLER_13_192 VDD VSS sg13g2_decap_4
XFILLER_105_1236 VDD VSS sg13g2_fill_1
XFILLER_119_518 VDD VSS sg13g2_decap_4
XFILLER_146_304 VDD VSS sg13g2_decap_4
X_13508_ _13508_/X _13613_/A _13508_/B _13508_/C VDD VSS sg13g2_and3_1
X_14488_ _14488_/Q clkload32/A _14488_/D _14488_/RESET_B VDD VSS sg13g2_dfrbpq_1
X_13439_ _15101_/D _13435_/B _13438_/Y _13437_/Y VDD VSS sg13g2_o21ai_1
Xmax_cap1163 _12745_/S0 _12699_/S0 VDD VSS sg13g2_buf_4
Xmax_cap1174 _12534_/S0 _12529_/S0 VDD VSS sg13g2_buf_4
XFILLER_155_882 VDD VSS sg13g2_decap_8
Xmax_cap1185 _12772_/S0 _12769_/S0 VDD VSS sg13g2_buf_4
Xmax_cap1196 _12657_/S0 _12659_/S0 VDD VSS sg13g2_buf_4
XFILLER_115_746 VDD VSS sg13g2_decap_8
X_15109_ _15109_/Q clkload71/A _15109_/D _15109_/RESET_B VDD VSS sg13g2_dfrbpq_1
Xhold3407 _10209_/C _10207_/Y VDD VSS sg13g2_dlygate4sd3_1
X_08980_ _08980_/X _15024_/Q _15221_/Q _09085_/B VDD VSS sg13g2_mux2_1
XFILLER_114_256 VDD VSS sg13g2_fill_2
XFILLER_69_800 VDD VSS sg13g2_decap_8
Xhold3418 _15176_/D _13471_/X VDD VSS sg13g2_dlygate4sd3_1
Xhold3429 hold3429/X input4/X VDD VSS sg13g2_dlygate4sd3_1
XFILLER_64_1231 VDD VSS sg13g2_decap_4
X_14916__3097 _14916_/RESET_B VDD VSS sg13g2_tiehi
X_07931_ _08286_/B _14998_/Q _11526_/A VDD VSS sg13g2_nor2b_1
XFILLER_111_930 VDD VSS sg13g2_fill_1
X_07862_ _07862_/Y _08608_/A _08608_/B VDD VSS sg13g2_nor2_1
X_09601_ _14198_/D _14198_/Q _10165_/A1 wire337/X VDD VSS sg13g2_mux2_1
XFILLER_83_313 VDD VSS sg13g2_decap_8
XFILLER_28_229 VDD VSS sg13g2_decap_8
XFILLER_7_1180 VDD VSS sg13g2_decap_8
XFILLER_113_28 VDD VSS sg13g2_decap_8
X_07793_ _07793_/Y _08383_/B _07794_/A VDD VSS sg13g2_nor2b_1
XFILLER_84_858 VDD VSS sg13g2_fill_2
X_09532_ _14131_/D _09963_/A1 _14131_/Q _09533_/S VDD VSS sg13g2_mux2_1
XFILLER_83_368 VDD VSS sg13g2_decap_8
XFILLER_58_1002 VDD VSS sg13g2_fill_1
XFILLER_25_925 VDD VSS sg13g2_fill_2
X_13849__2715 _13849_/RESET_B VDD VSS sg13g2_tiehi
X_09463_ _14064_/D _09696_/A0 _14064_/Q wire671/X VDD VSS sg13g2_mux2_1
XFILLER_25_969 VDD VSS sg13g2_decap_8
XFILLER_58_1057 VDD VSS sg13g2_fill_1
XFILLER_52_755 VDD VSS sg13g2_decap_4
X_08414_ _08415_/B _08414_/A _08414_/B _08414_/C _08414_/D VDD VSS sg13g2_nor4_1
X_09394_ _13997_/D _09693_/A0 _13997_/Q _09398_/S VDD VSS sg13g2_mux2_1
XFILLER_11_107 VDD VSS sg13g2_fill_1
XFILLER_51_298 VDD VSS sg13g2_fill_2
X_08345_ _08346_/B _08597_/A _08177_/X _08344_/Y VDD VSS sg13g2_o21ai_1
XFILLER_22_14 VDD VSS sg13g2_decap_8
X_14229__2335 _14229_/RESET_B VDD VSS sg13g2_tiehi
X_08276_ _08276_/X _08276_/A _08276_/B VDD VSS sg13g2_or2_1
XFILLER_138_14 VDD VSS sg13g2_decap_8
XFILLER_118_7 VDD VSS sg13g2_decap_8
XFILLER_69_1142 VDD VSS sg13g2_decap_8
XFILLER_106_724 VDD VSS sg13g2_fill_1
XFILLER_105_212 VDD VSS sg13g2_decap_8
XFILLER_145_392 VDD VSS sg13g2_fill_1
Xclkbuf_leaf_0_clk_i clkload0/A clkbuf_leaf_1_clk_i/A VDD VSS sg13g2_buf_8
XFILLER_0_7 VDD VSS sg13g2_decap_4
XFILLER_79_608 VDD VSS sg13g2_decap_8
X_14444__2120 _14444_/RESET_B VDD VSS sg13g2_tiehi
XFILLER_65_1039 VDD VSS sg13g2_fill_1
XFILLER_154_35 VDD VSS sg13g2_decap_8
XFILLER_121_738 VDD VSS sg13g2_decap_8
XFILLER_156_1189 VDD VSS sg13g2_decap_8
Xfanout1107 _12686_/S1 _12740_/S1 VDD VSS sg13g2_buf_1
Xfanout1118 _12480_/S1 _12758_/S1 VDD VSS sg13g2_buf_1
Xfanout1129 _12659_/S1 _12661_/S1 VDD VSS sg13g2_buf_1
XFILLER_120_259 VDD VSS sg13g2_decap_8
Xfanout164 _09967_/A1 _10033_/A0 VDD VSS sg13g2_buf_1
XFILLER_86_140 VDD VSS sg13g2_fill_1
Xfanout175 _09899_/A0 _10131_/A0 VDD VSS sg13g2_buf_1
Xfanout186 _09332_/A0 _10162_/A1 VDD VSS sg13g2_buf_1
XFILLER_86_162 VDD VSS sg13g2_decap_8
Xfanout197 _10160_/A1 wire198/X VDD VSS sg13g2_buf_1
XFILLER_101_495 VDD VSS sg13g2_fill_2
XFILLER_75_869 VDD VSS sg13g2_fill_2
X_14477__2087 _14477_/RESET_B VDD VSS sg13g2_tiehi
X_12810_ _12810_/Y _12806_/Y _12807_/Y _12809_/Y VDD VSS sg13g2_a21oi_1
X_13790_ _13790_/Q _14763_/CLK _13790_/D _13790_/RESET_B VDD VSS sg13g2_dfrbpq_1
XFILLER_27_240 VDD VSS sg13g2_fill_1
XFILLER_27_262 VDD VSS sg13g2_decap_8
X_12741_ _12741_/X _14711_/Q _14743_/Q _13783_/Q _13815_/Q _12742_/S0 _12742_/S1 VDD
+ VSS sg13g2_mux4_1
XFILLER_103_94 VDD VSS sg13g2_decap_4
XFILLER_128_1214 VDD VSS sg13g2_decap_8
XFILLER_16_969 VDD VSS sg13g2_decap_4
XFILLER_43_755 VDD VSS sg13g2_decap_8
XFILLER_76_1157 VDD VSS sg13g2_fill_1
XFILLER_31_928 VDD VSS sg13g2_fill_2
X_12672_ _12672_/X _14578_/Q _14610_/Q _14642_/Q _14674_/Q _12675_/S0 _12675_/S1 VDD
+ VSS sg13g2_mux4_1
X_13677__2903 _13677_/RESET_B VDD VSS sg13g2_tiehi
XFILLER_24_980 VDD VSS sg13g2_decap_8
XFILLER_144_0 VDD VSS sg13g2_decap_8
XFILLER_42_287 VDD VSS sg13g2_fill_1
X_14411_ _14411_/Q _14731_/CLK _14411_/D _14411_/RESET_B VDD VSS sg13g2_dfrbpq_1
X_11623_ _11623_/Y _11599_/Y _11601_/Y _12075_/A VDD VSS sg13g2_a21oi_1
XFILLER_129_805 VDD VSS sg13g2_decap_8
XFILLER_11_641 VDD VSS sg13g2_decap_8
XFILLER_8_49 VDD VSS sg13g2_decap_8
XFILLER_11_652 VDD VSS sg13g2_fill_1
X_14342_ _14342_/Q clkload17/A _14342_/D _14342_/RESET_B VDD VSS sg13g2_dfrbpq_1
Xwire510 wire510/X wire510/A VDD VSS sg13g2_buf_2
X_11554_ _11554_/Y _11550_/Y _11551_/Y _11553_/Y _11552_/Y _11696_/B VDD VSS sg13g2_a221oi_1
XFILLER_11_663 VDD VSS sg13g2_decap_8
XFILLER_7_612 VDD VSS sg13g2_decap_8
XFILLER_155_112 VDD VSS sg13g2_decap_8
X_14654__1910 _14654_/RESET_B VDD VSS sg13g2_tiehi
XFILLER_10_151 VDD VSS sg13g2_fill_1
XFILLER_128_326 VDD VSS sg13g2_fill_1
XFILLER_156_646 VDD VSS sg13g2_fill_2
Xwire543 wire543/X wire543/A VDD VSS sg13g2_buf_2
X_10505_ _10654_/A wire760/X _10505_/B _10505_/C _10505_/D VDD VSS sg13g2_nand4_1
Xwire554 wire554/X wire554/A VDD VSS sg13g2_buf_2
X_14273_ _14273_/Q clkload27/A _14273_/D _14273_/RESET_B VDD VSS sg13g2_dfrbpq_1
Xwire565 wire565/X wire565/A VDD VSS sg13g2_buf_2
X_11485_ _11485_/Y _11485_/A _11485_/B VDD VSS sg13g2_xnor2_1
XFILLER_13_1174 VDD VSS sg13g2_decap_8
X_13224_ _13226_/B _13224_/A _13215_/A VDD VSS sg13g2_nor2b_1
XFILLER_100_1133 VDD VSS sg13g2_decap_8
X_14083__2481 _14083_/RESET_B VDD VSS sg13g2_tiehi
XFILLER_6_177 VDD VSS sg13g2_decap_4
X_10436_ _10436_/Y _14835_/Q _10443_/D _13302_/C VDD VSS sg13g2_o21ai_1
XFILLER_12_91 VDD VSS sg13g2_decap_8
XFILLER_48_1226 VDD VSS sg13g2_decap_8
X_13155_ _15043_/D _13155_/A _13155_/B VDD VSS sg13g2_nor2_1
XFILLER_124_554 VDD VSS sg13g2_decap_8
X_10367_ _10400_/C _14812_/Q _14813_/Q _14814_/Q VDD VSS sg13g2_nand3_1
XFILLER_152_885 VDD VSS sg13g2_decap_8
XFILLER_112_716 VDD VSS sg13g2_decap_8
XFILLER_2_361 VDD VSS sg13g2_decap_8
X_12106_ _12106_/Y _12102_/Y _12103_/Y _12105_/Y _12104_/Y _11615_/B VDD VSS sg13g2_a221oi_1
X_13927__2637 _13927_/RESET_B VDD VSS sg13g2_tiehi
X_14687__1877 _14687_/RESET_B VDD VSS sg13g2_tiehi
XFILLER_33_7 VDD VSS sg13g2_decap_8
XFILLER_151_395 VDD VSS sg13g2_decap_4
X_10298_ _10299_/C _14791_/Q _14792_/Q _14793_/Q _10298_/D VDD VSS sg13g2_nand4_1
X_13086_ _13087_/B _13265_/A1 _13081_/X wire564/X _13140_/B2 _13080_/Y VDD VSS sg13g2_a221oi_1
X_15022__2950 _15022_/RESET_B VDD VSS sg13g2_tiehi
Xfanout1630 _11686_/S1 _11555_/S1 VDD VSS sg13g2_buf_1
X_12037_ _12037_/Y _12040_/A1 _14130_/Q VDD VSS sg13g2_nand2b_1
Xfanout1641 _11970_/C _12038_/B1 VDD VSS sg13g2_buf_1
Xfanout1652 _11374_/C _11890_/S1 VDD VSS sg13g2_buf_1
XFILLER_93_600 VDD VSS sg13g2_fill_1
Xfanout1663 _12215_/S0 _11715_/S0 VDD VSS sg13g2_buf_1
Xfanout1685 _11597_/A _12100_/S0 VDD VSS sg13g2_buf_1
Xfanout1696 _12250_/A1 fanout1705/X VDD VSS sg13g2_buf_1
X_14307__2257 _14307_/RESET_B VDD VSS sg13g2_tiehi
XFILLER_0_1206 VDD VSS sg13g2_decap_4
X_13988_ _13988_/Q clkload31/A _13988_/D _13988_/RESET_B VDD VSS sg13g2_dfrbpq_1
XFILLER_46_560 VDD VSS sg13g2_decap_8
XFILLER_65_379 VDD VSS sg13g2_decap_8
XFILLER_93_688 VDD VSS sg13g2_decap_8
XFILLER_20_1156 VDD VSS sg13g2_decap_8
XFILLER_18_284 VDD VSS sg13g2_fill_2
X_12939_ _12939_/Y _12934_/Y _12938_/Y _12933_/Y VDD VSS sg13g2_o21ai_1
XFILLER_34_744 VDD VSS sg13g2_decap_4
XFILLER_80_349 VDD VSS sg13g2_decap_8
XFILLER_55_1208 VDD VSS sg13g2_decap_8
XFILLER_34_766 VDD VSS sg13g2_fill_1
XFILLER_34_788 VDD VSS sg13g2_fill_2
XFILLER_21_416 VDD VSS sg13g2_decap_8
XFILLER_18_1030 VDD VSS sg13g2_decap_8
XFILLER_15_980 VDD VSS sg13g2_decap_8
X_14609_ _14609_/Q clkload45/A _14609_/D _14609_/RESET_B VDD VSS sg13g2_dfrbpq_1
X_14522__2042 _14522_/RESET_B VDD VSS sg13g2_tiehi
X_08130_ _08130_/Y _08129_/X _08488_/A VDD VSS sg13g2_nand2b_1
XFILLER_147_635 VDD VSS sg13g2_decap_8
XFILLER_144_1093 VDD VSS sg13g2_decap_8
X_14776__3322 _14776_/RESET_B VDD VSS sg13g2_tiehi
XFILLER_31_1230 VDD VSS sg13g2_decap_8
X_08061_ _08061_/Y _08060_/X _08328_/S VDD VSS sg13g2_nand2b_1
XFILLER_134_318 VDD VSS sg13g2_fill_2
XFILLER_115_510 VDD VSS sg13g2_decap_4
XFILLER_108_28 VDD VSS sg13g2_decap_8
XFILLER_103_716 VDD VSS sg13g2_fill_2
XFILLER_115_576 VDD VSS sg13g2_fill_1
X_08963_ _10037_/B _09707_/B _09707_/C VDD VSS sg13g2_nor2_1
X_07914_ _07914_/Y _08105_/A _08200_/B _07913_/Y VDD VSS sg13g2_o21ai_1
XFILLER_97_961 VDD VSS sg13g2_fill_2
XFILLER_69_663 VDD VSS sg13g2_decap_4
X_08894_ _08894_/X _15037_/Q _10788_/S _08893_/Y VDD VSS sg13g2_a21o_1
XFILLER_151_1053 VDD VSS sg13g2_fill_1
XFILLER_111_782 VDD VSS sg13g2_decap_8
XFILLER_25_1067 VDD VSS sg13g2_decap_8
X_07845_ _08678_/C _15017_/Q _07972_/B VDD VSS sg13g2_nand2_1
X_15215__3368 _15215_/RESET_B VDD VSS sg13g2_tiehi
X_13781__2783 _13781_/RESET_B VDD VSS sg13g2_tiehi
XFILLER_112_1026 VDD VSS sg13g2_decap_8
XFILLER_151_1086 VDD VSS sg13g2_fill_1
XFILLER_17_14 VDD VSS sg13g2_decap_8
X_07776_ _07776_/Y _08276_/B _08276_/A VDD VSS sg13g2_nor2b_1
X_14732__1832 _14732_/RESET_B VDD VSS sg13g2_tiehi
X_09515_ _14114_/D _09649_/A0 _14114_/Q _09536_/S VDD VSS sg13g2_mux2_1
XFILLER_24_210 VDD VSS sg13g2_decap_8
X_09446_ _14047_/D _09646_/A0 _14047_/Q _09446_/S VDD VSS sg13g2_mux2_1
XFILLER_24_265 VDD VSS sg13g2_decap_8
XFILLER_80_883 VDD VSS sg13g2_decap_4
XFILLER_33_35 VDD VSS sg13g2_fill_1
XFILLER_12_438 VDD VSS sg13g2_decap_8
X_09377_ _13980_/D _10105_/A _13980_/Q _09377_/S VDD VSS sg13g2_mux2_1
XFILLER_33_57 VDD VSS sg13g2_decap_8
XFILLER_149_35 VDD VSS sg13g2_decap_8
X_08328_ _08329_/A _08235_/X _08327_/X _08328_/S VDD VSS sg13g2_mux2_1
XFILLER_137_101 VDD VSS sg13g2_decap_4
XFILLER_71_1076 VDD VSS sg13g2_fill_1
XFILLER_138_646 VDD VSS sg13g2_decap_4
XFILLER_32_1038 VDD VSS sg13g2_decap_4
XFILLER_71_1087 VDD VSS sg13g2_decap_8
X_08259_ _08259_/Y _08315_/A _08654_/B _08258_/Y VDD VSS sg13g2_o21ai_1
XFILLER_123_1199 VDD VSS sg13g2_decap_8
XFILLER_125_307 VDD VSS sg13g2_fill_2
XFILLER_153_638 VDD VSS sg13g2_decap_4
X_11270_ _11270_/Y _11275_/S0 _14364_/Q VDD VSS sg13g2_nand2b_1
XFILLER_152_126 VDD VSS sg13g2_decap_8
XFILLER_4_637 VDD VSS sg13g2_decap_8
XFILLER_106_532 VDD VSS sg13g2_fill_2
X_10221_ _14768_/D _14767_/Q _14768_/Q _10220_/Y VDD VSS sg13g2_a21oi_1
XFILLER_133_340 VDD VSS sg13g2_decap_4
XFILLER_3_147 VDD VSS sg13g2_decap_8
XFILLER_106_587 VDD VSS sg13g2_decap_4
XFILLER_0_810 VDD VSS sg13g2_fill_1
X_10152_ _14729_/D _14729_/Q _10152_/A1 _10166_/S VDD VSS sg13g2_mux2_1
XFILLER_58_21 VDD VSS sg13g2_decap_8
XFILLER_43_1112 VDD VSS sg13g2_decap_8
XFILLER_88_950 VDD VSS sg13g2_fill_2
X_10083_ _14663_/D _10083_/A0 _14663_/Q _10083_/S VDD VSS sg13g2_mux2_1
X_14960_ _14960_/Q _15200_/CLK _14960_/D _14960_/RESET_B VDD VSS sg13g2_dfrbpq_1
XFILLER_48_825 VDD VSS sg13g2_fill_1
XFILLER_0_898 VDD VSS sg13g2_decap_8
X_13911_ _13911_/Q clkload4/A _13911_/D _13911_/RESET_B VDD VSS sg13g2_dfrbpq_1
XFILLER_101_270 VDD VSS sg13g2_decap_8
XFILLER_101_281 VDD VSS sg13g2_fill_2
X_14891_ _14891_/Q clkload70/A _14891_/D _14891_/RESET_B VDD VSS sg13g2_dfrbpq_1
XFILLER_130_1137 VDD VSS sg13g2_decap_8
XFILLER_47_346 VDD VSS sg13g2_fill_2
XFILLER_74_132 VDD VSS sg13g2_decap_8
XFILLER_74_143 VDD VSS sg13g2_fill_2
XFILLER_63_817 VDD VSS sg13g2_fill_1
X_13842_ _13842_/Q _14916_/CLK _13842_/D _13842_/RESET_B VDD VSS sg13g2_dfrbpq_1
XFILLER_47_379 VDD VSS sg13g2_decap_4
XFILLER_56_891 VDD VSS sg13g2_fill_1
X_13773_ _13773_/Q clkload55/A _13773_/D _13773_/RESET_B VDD VSS sg13g2_dfrbpq_1
X_10985_ _10985_/X wire385/A _11045_/A2 _10985_/B1 VDD VSS sg13g2_a21o_1
XFILLER_74_97 VDD VSS sg13g2_decap_8
X_12724_ _12724_/X _14262_/Q _14294_/Q _14326_/Q _14358_/Q _12755_/S0 _12759_/S1 VDD
+ VSS sg13g2_mux4_1
XFILLER_128_1066 VDD VSS sg13g2_decap_4
XFILLER_90_41 VDD VSS sg13g2_decap_8
X_12655_ _12655_/X _13745_/Q _14097_/Q _14449_/Q _14545_/Q _12657_/S0 _12659_/S1 VDD
+ VSS sg13g2_mux4_1
Xclkbuf_leaf_101_clk_i clkload20/A clkbuf_5_8__f_clk_i/X VDD VSS sg13g2_buf_8
XFILLER_129_613 VDD VSS sg13g2_decap_8
XFILLER_12_961 VDD VSS sg13g2_decap_8
X_11606_ _11606_/Y _11602_/Y _11603_/Y _11605_/Y _11604_/Y _12108_/B VDD VSS sg13g2_a221oi_1
XFILLER_156_410 VDD VSS sg13g2_fill_1
XFILLER_30_268 VDD VSS sg13g2_decap_8
XFILLER_15_1236 VDD VSS sg13g2_fill_1
XFILLER_30_279 VDD VSS sg13g2_fill_2
X_12586_ _12586_/X _13964_/Q _13996_/Q _14028_/Q _14060_/Q _12647_/S0 _12647_/S1 VDD
+ VSS sg13g2_mux4_1
X_14325_ _14325_/Q clkload14/A _14325_/D _14325_/RESET_B VDD VSS sg13g2_dfrbpq_1
XFILLER_156_454 VDD VSS sg13g2_decap_4
X_11537_ _11537_/Y _12259_/S0 _14596_/Q _12259_/S1 VDD VSS sg13g2_a21oi_1
XFILLER_8_987 VDD VSS sg13g2_decap_8
XFILLER_7_464 VDD VSS sg13g2_decap_8
Xwire373 wire373/X wire373/A VDD VSS sg13g2_buf_2
X_14256_ _14256_/Q clkload49/A _14256_/D _14256_/RESET_B VDD VSS sg13g2_dfrbpq_1
XFILLER_143_126 VDD VSS sg13g2_fill_1
Xclkbuf_leaf_116_clk_i _14506_/CLK clkbuf_5_9__f_clk_i/X VDD VSS sg13g2_buf_8
X_11468_ _11468_/X _14241_/Q _14273_/Q _14305_/Q _14337_/Q _11670_/S0 _11693_/C VDD
+ VSS sg13g2_mux4_1
X_13207_ _13207_/Y _14857_/Q _13234_/B _13249_/B _14889_/Q _13274_/C1 VDD VSS sg13g2_a221oi_1
X_10419_ _10421_/B _14828_/Q _14829_/Q _10422_/D VDD VSS sg13g2_nand3_1
X_14187_ _14187_/Q _14667_/CLK _14187_/D _14187_/RESET_B VDD VSS sg13g2_dfrbpq_1
X_11399_ _11401_/A _11400_/A _14623_/Q VDD VSS sg13g2_nand2b_1
XFILLER_139_1162 VDD VSS sg13g2_decap_8
XFILLER_98_725 VDD VSS sg13g2_decap_8
X_13138_ _13139_/B _14852_/Q _13150_/B _13193_/B _14788_/Q VDD VSS sg13g2_a22oi_1
XFILLER_135_1026 VDD VSS sg13g2_fill_1
Xclkbuf_5_28__f_clk_i clkbuf_leaf_67_clk_i/A clkbuf_4_14_0_clk_i/X VDD VSS sg13g2_buf_16
X_13069_ _13069_/Y _14847_/Q _13094_/B1 _13162_/B1 _14879_/Q _13082_/B VDD VSS sg13g2_a221oi_1
XFILLER_61_1234 VDD VSS sg13g2_fill_2
XFILLER_78_471 VDD VSS sg13g2_decap_8
Xfanout1460 _11661_/A _14970_/Q VDD VSS sg13g2_buf_1
Xfanout1471 _08258_/C _08327_/A3 VDD VSS sg13g2_buf_1
XFILLER_94_942 VDD VSS sg13g2_fill_2
Xfanout1482 _07910_/B _11454_/A VDD VSS sg13g2_buf_1
XFILLER_38_346 VDD VSS sg13g2_fill_1
XFILLER_66_655 VDD VSS sg13g2_decap_8
Xfanout1493 _08023_/B _08063_/B VDD VSS sg13g2_buf_1
XFILLER_94_964 VDD VSS sg13g2_decap_4
XFILLER_66_666 VDD VSS sg13g2_decap_8
X_07630_ _08105_/A _07879_/A VDD VSS sg13g2_inv_1
XFILLER_65_154 VDD VSS sg13g2_decap_8
XFILLER_94_997 VDD VSS sg13g2_decap_4
XFILLER_93_485 VDD VSS sg13g2_decap_4
XFILLER_0_1014 VDD VSS sg13g2_decap_4
XFILLER_53_327 VDD VSS sg13g2_decap_8
XFILLER_111_1070 VDD VSS sg13g2_fill_1
XFILLER_80_135 VDD VSS sg13g2_fill_1
X_09300_ _13908_/D _13908_/Q _10030_/A0 _09302_/S VDD VSS sg13g2_mux2_1
XFILLER_110_18 VDD VSS sg13g2_fill_1
XFILLER_61_360 VDD VSS sg13g2_fill_1
X_09231_ _13842_/D _09698_/A0 _13842_/Q _09239_/S VDD VSS sg13g2_mux2_1
XFILLER_21_235 VDD VSS sg13g2_decap_8
XFILLER_22_769 VDD VSS sg13g2_decap_8
XFILLER_9_70 VDD VSS sg13g2_decap_8
X_09162_ _09162_/Y _09162_/A _10793_/C VDD VSS sg13g2_nor2_1
X_15165__2898 _15165_/RESET_B VDD VSS sg13g2_tiehi
X_08113_ _08113_/Y _13553_/A1 _13609_/A _08105_/A _08110_/B _08090_/C VDD VSS sg13g2_a221oi_1
X_09093_ _09093_/Y _15239_/Q _09100_/B VDD VSS sg13g2_nand2b_1
X_13799__2765 _13799_/RESET_B VDD VSS sg13g2_tiehi
X_08044_ _08044_/X _07815_/B _08591_/A3 _08541_/B _07861_/B _08055_/S0 _08044_/S1
+ VDD VSS sg13g2_mux4_1
XFILLER_134_126 VDD VSS sg13g2_decap_4
XFILLER_31_1082 VDD VSS sg13g2_fill_1
XFILLER_134_148 VDD VSS sg13g2_decap_8
XFILLER_89_725 VDD VSS sg13g2_fill_1
XFILLER_0_106 VDD VSS sg13g2_fill_1
Xclkbuf_leaf_80_clk_i clkload67/A clkbuf_leaf_82_clk_i/A VDD VSS sg13g2_buf_8
XFILLER_118_1235 VDD VSS sg13g2_fill_2
X_09995_ _14578_/D _10161_/A1 _14578_/Q _10002_/S VDD VSS sg13g2_mux2_1
X_14179__2385 _14179_/RESET_B VDD VSS sg13g2_tiehi
XFILLER_9_1050 VDD VSS sg13g2_decap_8
X_08946_ _08946_/Y _08835_/A _08835_/B output58/A VDD VSS sg13g2_a21oi_1
XFILLER_88_279 VDD VSS sg13g2_decap_8
XFILLER_69_471 VDD VSS sg13g2_decap_8
XFILLER_28_35 VDD VSS sg13g2_decap_8
XFILLER_151_14 VDD VSS sg13g2_decap_8
X_08877_ _08877_/Y _08877_/A _14937_/Q VDD VSS sg13g2_nor2b_1
XFILLER_45_806 VDD VSS sg13g2_fill_1
Xclkbuf_leaf_95_clk_i _15160_/CLK clkbuf_leaf_97_clk_i/A VDD VSS sg13g2_buf_8
XFILLER_45_817 VDD VSS sg13g2_fill_1
X_07828_ _07829_/B _08574_/A _08574_/B _07828_/C VDD VSS sg13g2_nor3_1
XFILLER_85_997 VDD VSS sg13g2_decap_8
XFILLER_72_625 VDD VSS sg13g2_decap_8
XFILLER_38_891 VDD VSS sg13g2_fill_2
X_14394__2170 _14394_/RESET_B VDD VSS sg13g2_tiehi
XFILLER_71_135 VDD VSS sg13g2_decap_8
X_07759_ _07759_/Y _13281_/C _07755_/Y _07758_/Y VDD VSS sg13g2_a21oi_1
XFILLER_71_157 VDD VSS sg13g2_decap_4
X_10770_ _10770_/Y _14919_/Q _11196_/B VDD VSS sg13g2_nand2_1
XFILLER_73_1116 VDD VSS sg13g2_decap_8
X_09429_ _14031_/D _10091_/A0 _14031_/Q _09439_/S VDD VSS sg13g2_mux2_1
XFILLER_40_555 VDD VSS sg13g2_decap_8
XFILLER_138_410 VDD VSS sg13g2_fill_2
X_12440_ _12440_/X _12434_/X _12438_/X _12433_/X _12437_/X _12567_/S _12566_/S0 VDD
+ VSS sg13g2_mux4_1
X_14986__2986 _14986_/RESET_B VDD VSS sg13g2_tiehi
XFILLER_139_955 VDD VSS sg13g2_fill_1
XFILLER_8_239 VDD VSS sg13g2_decap_8
X_14857__3215 _14857_/RESET_B VDD VSS sg13g2_tiehi
XFILLER_154_903 VDD VSS sg13g2_decap_8
X_12371_ _12372_/B _12370_/X _12369_/X _12371_/S VDD VSS sg13g2_mux2_1
Xclkbuf_leaf_33_clk_i clkload44/A clkbuf_leaf_34_clk_i/A VDD VSS sg13g2_buf_8
XFILLER_60_77 VDD VSS sg13g2_decap_8
XFILLER_138_476 VDD VSS sg13g2_fill_2
X_14110_ _14110_/Q _14494_/CLK _14110_/D _14110_/RESET_B VDD VSS sg13g2_dfrbpq_1
X_11322_ _11322_/Y _11328_/S0 _14109_/Q VDD VSS sg13g2_nand2b_1
XFILLER_10_1122 VDD VSS sg13g2_decap_8
X_15090_ _15090_/Q clkload66/A _15090_/D _15090_/RESET_B VDD VSS sg13g2_dfrbpq_1
XFILLER_153_446 VDD VSS sg13g2_decap_8
XFILLER_5_28 VDD VSS sg13g2_decap_8
XFILLER_5_957 VDD VSS sg13g2_decap_8
XFILLER_125_137 VDD VSS sg13g2_decap_8
XFILLER_109_60 VDD VSS sg13g2_decap_4
X_14041_ _14041_/Q _14745_/CLK _14041_/D _14041_/RESET_B VDD VSS sg13g2_dfrbpq_1
XFILLER_107_0 VDD VSS sg13g2_decap_8
X_11253_ _11255_/B _11257_/S0 _14620_/Q VDD VSS sg13g2_nand2b_1
XFILLER_10_1199 VDD VSS sg13g2_decap_8
X_10204_ _14759_/D _15183_/D _14759_/Q _13651_/S VDD VSS sg13g2_mux2_1
Xclkbuf_leaf_48_clk_i clkload54/A clkbuf_leaf_48_clk_i/A VDD VSS sg13g2_buf_8
XFILLER_45_1218 VDD VSS sg13g2_decap_8
XFILLER_79_224 VDD VSS sg13g2_decap_8
X_11184_ _14954_/D _11183_/Y _11182_/Y _11170_/Y VDD VSS sg13g2_o21ai_1
XFILLER_69_86 VDD VSS sg13g2_decap_8
XFILLER_122_877 VDD VSS sg13g2_decap_4
X_10135_ _14713_/D _10135_/A0 _14713_/Q _10135_/S VDD VSS sg13g2_mux2_1
X_14009__2555 _14009_/RESET_B VDD VSS sg13g2_tiehi
XFILLER_0_662 VDD VSS sg13g2_fill_1
X_13844__2720 _13844_/RESET_B VDD VSS sg13g2_tiehi
XFILLER_94_205 VDD VSS sg13g2_decap_8
XFILLER_95_728 VDD VSS sg13g2_decap_8
XFILLER_121_365 VDD VSS sg13g2_decap_8
XFILLER_125_81 VDD VSS sg13g2_decap_4
X_10066_ _14647_/D _10099_/A0 _14647_/Q _10066_/S VDD VSS sg13g2_mux2_1
X_14943_ _14943_/Q clkload48/A _14943_/D _14943_/RESET_B VDD VSS sg13g2_dfrbpq_1
XFILLER_134_1081 VDD VSS sg13g2_decap_4
XFILLER_102_590 VDD VSS sg13g2_decap_8
XFILLER_85_63 VDD VSS sg13g2_decap_8
X_14874_ _14874_/Q clkload78/A _14874_/D _14874_/RESET_B VDD VSS sg13g2_dfrbpq_1
XFILLER_36_839 VDD VSS sg13g2_decap_8
X_13825_ _13825_/Q _14465_/CLK _13825_/D _13825_/RESET_B VDD VSS sg13g2_dfrbpq_1
X_14224__2340 _14224_/RESET_B VDD VSS sg13g2_tiehi
XFILLER_141_91 VDD VSS sg13g2_decap_8
X_13877__2687 _13877_/RESET_B VDD VSS sg13g2_tiehi
X_13756_ _13756_/Q clkload77/A _13756_/D _13756_/RESET_B VDD VSS sg13g2_dfrbpq_1
XFILLER_16_574 VDD VSS sg13g2_fill_2
X_10968_ _10969_/A _10967_/B _11015_/A _10966_/Y VDD VSS sg13g2_o21ai_1
XFILLER_43_371 VDD VSS sg13g2_decap_8
XFILLER_16_596 VDD VSS sg13g2_fill_1
X_12707_ wire370/A _13668_/Q _12749_/A2 _12706_/X _12749_/B2 _12749_/C1 VDD VSS sg13g2_a221oi_1
XFILLER_31_533 VDD VSS sg13g2_decap_8
X_13687_ _13687_/Q clkload39/A _13687_/D _13687_/RESET_B VDD VSS sg13g2_dfrbpq_1
XFILLER_31_555 VDD VSS sg13g2_decap_8
X_10899_ _10899_/Y _10897_/Y _10898_/X _10797_/C VDD VSS sg13g2_o21ai_1
X_12638_ _15009_/D _07636_/Y _12638_/A2 _12637_/Y VDD VSS sg13g2_a21oi_1
XFILLER_19_1191 VDD VSS sg13g2_decap_8
XFILLER_141_1030 VDD VSS sg13g2_fill_1
XFILLER_79_4 VDD VSS sg13g2_decap_8
XFILLER_15_1066 VDD VSS sg13g2_decap_8
X_12569_ _15004_/D _12569_/A _12569_/B VDD VSS sg13g2_nor2_1
XFILLER_106_1183 VDD VSS sg13g2_decap_8
XFILLER_156_262 VDD VSS sg13g2_decap_4
X_15214__3367 _15214_/RESET_B VDD VSS sg13g2_tiehi
XFILLER_8_773 VDD VSS sg13g2_decap_8
XFILLER_7_250 VDD VSS sg13g2_decap_8
XFILLER_145_947 VDD VSS sg13g2_fill_1
X_14308_ _14308_/Q _15001_/CLK _14308_/D _14308_/RESET_B VDD VSS sg13g2_dfrbpq_1
XFILLER_89_1167 VDD VSS sg13g2_fill_1
XFILLER_117_649 VDD VSS sg13g2_fill_1
XFILLER_85_1009 VDD VSS sg13g2_decap_4
X_14239_ _14239_/Q _14509_/CLK _14239_/D _14239_/RESET_B VDD VSS sg13g2_dfrbpq_1
XFILLER_132_619 VDD VSS sg13g2_decap_4
XFILLER_113_811 VDD VSS sg13g2_fill_1
X_14472__2092 _14472_/RESET_B VDD VSS sg13g2_tiehi
Xfanout708 _08926_/S _08956_/S VDD VSS sg13g2_buf_1
Xfanout719 _13653_/S _13655_/S VDD VSS sg13g2_buf_1
XFILLER_140_641 VDD VSS sg13g2_decap_8
XFILLER_124_192 VDD VSS sg13g2_decap_8
X_08800_ _08802_/A _10924_/B1 _14754_/Q _08727_/X _15197_/Q _08809_/C1 VDD VSS sg13g2_a221oi_1
XFILLER_86_717 VDD VSS sg13g2_fill_1
X_09780_ _14369_/D _09912_/A1 _14369_/Q wire629/X VDD VSS sg13g2_mux2_1
XFILLER_6_1201 VDD VSS sg13g2_decap_8
XFILLER_22_0 VDD VSS sg13g2_decap_8
XFILLER_112_387 VDD VSS sg13g2_decap_4
X_08731_ _08731_/Y _13662_/Q _08752_/B VDD VSS sg13g2_nor2_1
XFILLER_100_549 VDD VSS sg13g2_fill_1
XFILLER_26_1184 VDD VSS sg13g2_decap_8
XFILLER_61_1064 VDD VSS sg13g2_fill_2
XFILLER_94_750 VDD VSS sg13g2_decap_8
XFILLER_22_1037 VDD VSS sg13g2_decap_8
XFILLER_82_901 VDD VSS sg13g2_decap_8
Xfanout1290 _11099_/B2 _08779_/A1 VDD VSS sg13g2_buf_1
X_08662_ _08662_/Y _08650_/A _08662_/B VDD VSS sg13g2_nand2b_1
XFILLER_66_463 VDD VSS sg13g2_decap_8
XFILLER_82_912 VDD VSS sg13g2_fill_2
XFILLER_113_1165 VDD VSS sg13g2_decap_4
XFILLER_38_165 VDD VSS sg13g2_fill_2
XFILLER_66_474 VDD VSS sg13g2_decap_8
XFILLER_54_625 VDD VSS sg13g2_fill_2
XFILLER_26_338 VDD VSS sg13g2_decap_8
X_07613_ _08977_/A _08966_/A VDD VSS sg13g2_inv_1
XFILLER_121_28 VDD VSS sg13g2_decap_8
XFILLER_148_1228 VDD VSS sg13g2_decap_8
X_08593_ _08593_/Y _07858_/X _08689_/B1 _08654_/B VDD VSS sg13g2_o21ai_1
X_13707__2857 _13707_/RESET_B VDD VSS sg13g2_tiehi
XFILLER_53_168 VDD VSS sg13g2_fill_1
XFILLER_53_179 VDD VSS sg13g2_fill_2
XFILLER_35_894 VDD VSS sg13g2_fill_2
XFILLER_34_382 VDD VSS sg13g2_fill_2
XFILLER_22_533 VDD VSS sg13g2_decap_8
X_09214_ _13825_/D _09747_/A1 _13825_/Q _09223_/S VDD VSS sg13g2_mux2_1
XFILLER_33_1155 VDD VSS sg13g2_fill_1
X_09145_ _09145_/Y _09145_/A _09145_/B VDD VSS sg13g2_nand2_1
XFILLER_120_1103 VDD VSS sg13g2_fill_2
XFILLER_148_774 VDD VSS sg13g2_decap_8
X_13922__2642 _13922_/RESET_B VDD VSS sg13g2_tiehi
X_14682__1882 _14682_/RESET_B VDD VSS sg13g2_tiehi
XFILLER_30_14 VDD VSS sg13g2_decap_8
XFILLER_107_115 VDD VSS sg13g2_fill_1
X_09076_ wire231/A _09090_/A _10735_/B _09075_/X VDD VSS sg13g2_o21ai_1
XFILLER_146_14 VDD VSS sg13g2_decap_8
XFILLER_2_905 VDD VSS sg13g2_decap_4
X_08027_ _08027_/Y _13561_/A0 _08027_/B VDD VSS sg13g2_nand2b_1
XFILLER_1_415 VDD VSS sg13g2_fill_2
XFILLER_89_522 VDD VSS sg13g2_fill_1
XFILLER_115_170 VDD VSS sg13g2_decap_4
X_14302__2262 _14302_/RESET_B VDD VSS sg13g2_tiehi
XFILLER_118_1043 VDD VSS sg13g2_decap_8
XFILLER_77_717 VDD VSS sg13g2_fill_2
XFILLER_104_877 VDD VSS sg13g2_decap_8
X_09978_ _14561_/D _10077_/A0 _14561_/Q _09987_/S VDD VSS sg13g2_mux2_1
XFILLER_76_205 VDD VSS sg13g2_fill_2
XFILLER_103_365 VDD VSS sg13g2_decap_8
XFILLER_118_1076 VDD VSS sg13g2_decap_8
XFILLER_89_599 VDD VSS sg13g2_decap_4
XFILLER_118_1098 VDD VSS sg13g2_fill_2
XFILLER_130_173 VDD VSS sg13g2_decap_8
X_08929_ _13715_/D _16877_/A _08928_/X _08935_/S VDD VSS sg13g2_mux2_1
XFILLER_76_238 VDD VSS sg13g2_fill_1
XFILLER_18_806 VDD VSS sg13g2_decap_8
XFILLER_40_1148 VDD VSS sg13g2_decap_8
XFILLER_57_463 VDD VSS sg13g2_fill_1
XFILLER_91_208 VDD VSS sg13g2_fill_2
X_11940_ _11940_/Y _11969_/A _14128_/Q VDD VSS sg13g2_nand2b_1
XFILLER_57_474 VDD VSS sg13g2_decap_8
XFILLER_45_625 VDD VSS sg13g2_decap_8
XFILLER_57_485 VDD VSS sg13g2_fill_1
XFILLER_85_794 VDD VSS sg13g2_fill_1
XFILLER_44_113 VDD VSS sg13g2_decap_8
XFILLER_45_636 VDD VSS sg13g2_decap_4
XFILLER_84_282 VDD VSS sg13g2_decap_4
XFILLER_73_956 VDD VSS sg13g2_decap_8
X_11871_ _11871_/Y _11896_/A _13902_/Q VDD VSS sg13g2_nand2b_1
XFILLER_17_349 VDD VSS sg13g2_decap_8
XFILLER_73_967 VDD VSS sg13g2_fill_2
XFILLER_55_77 VDD VSS sg13g2_decap_8
X_13610_ _13610_/Y _13609_/Y _13600_/Y _08830_/X VDD VSS sg13g2_o21ai_1
X_10822_ _10823_/A _10821_/A _10821_/B _10821_/C VDD VSS sg13g2_a21o_1
X_14590_ _14590_/Q clkload59/A _14590_/D _14590_/RESET_B VDD VSS sg13g2_dfrbpq_1
XFILLER_13_500 VDD VSS sg13g2_decap_8
X_13541_ _13541_/X _14995_/Q _13563_/C VDD VSS sg13g2_and2_1
XFILLER_38_1055 VDD VSS sg13g2_fill_2
XFILLER_71_21 VDD VSS sg13g2_decap_8
X_10753_ _11097_/A _14947_/Q _10752_/A _10752_/Y VDD VSS sg13g2_a21oi_1
X_13472_ _15110_/D _15176_/D _15110_/Q _13652_/S VDD VSS sg13g2_mux2_1
X_10684_ _10851_/D _08985_/X _08848_/A _08848_/Y VDD VSS sg13g2_a21o_1
X_15211_ _15211_/Q clkload72/A _15211_/D _15211_/RESET_B VDD VSS sg13g2_dfrbpq_1
X_12423_ _12423_/X _13728_/Q _14080_/Q _14432_/Q _14528_/Q _12742_/S0 _12742_/S1 VDD
+ VSS sg13g2_mux4_1
XFILLER_154_700 VDD VSS sg13g2_fill_1
XFILLER_12_1228 VDD VSS sg13g2_decap_8
XFILLER_138_273 VDD VSS sg13g2_fill_2
Xmax_cap1548 output53/A _16877_/A VDD VSS sg13g2_buf_4
X_15142_ _15142_/Q _15148_/CLK _15142_/D _15142_/RESET_B VDD VSS sg13g2_dfrbpq_1
X_15107__3132 _15107_/RESET_B VDD VSS sg13g2_tiehi
XFILLER_153_210 VDD VSS sg13g2_decap_8
X_12354_ _12354_/X _12342_/X _12343_/X _12352_/X _12351_/X _12369_/S0 _12371_/S VDD
+ VSS sg13g2_mux4_1
X_11305_ _11305_/Y _11310_/A1 _14653_/Q _11416_/B VDD VSS sg13g2_a21oi_1
X_15073_ _15073_/Q clkload70/A _15073_/D _15073_/RESET_B VDD VSS sg13g2_dfrbpq_1
X_12285_ _12285_/X _14137_/Q _14169_/Q _14201_/Q _14233_/Q _12285_/S0 _12285_/S1 VDD
+ VSS sg13g2_mux4_1
XFILLER_5_787 VDD VSS sg13g2_decap_8
XFILLER_153_287 VDD VSS sg13g2_decap_8
X_14024_ _14024_/Q clkload20/A _14024_/D _14024_/RESET_B VDD VSS sg13g2_dfrbpq_1
XFILLER_4_286 VDD VSS sg13g2_decap_8
X_11236_ _11236_/Y _11236_/A _11236_/B _12001_/A _11236_/D VDD VSS sg13g2_nor4_1
XFILLER_106_192 VDD VSS sg13g2_decap_4
XFILLER_84_1075 VDD VSS sg13g2_decap_4
XFILLER_122_652 VDD VSS sg13g2_fill_1
XFILLER_45_1048 VDD VSS sg13g2_decap_8
X_11167_ _11167_/Y _11161_/X _11158_/Y _11166_/Y VDD VSS sg13g2_a21oi_1
XFILLER_122_685 VDD VSS sg13g2_decap_8
XFILLER_1_982 VDD VSS sg13g2_decap_8
XFILLER_67_216 VDD VSS sg13g2_fill_1
XFILLER_0_470 VDD VSS sg13g2_decap_4
X_10118_ _14696_/D _10151_/A1 _14696_/Q _10134_/S VDD VSS sg13g2_mux2_1
X_11098_ _11098_/Y wire211/A _10759_/X _11099_/B2 VDD VSS sg13g2_a21oi_1
XFILLER_110_869 VDD VSS sg13g2_decap_8
X_10049_ _14630_/D _10149_/A1 _14630_/Q _10066_/S VDD VSS sg13g2_mux2_1
XFILLER_64_923 VDD VSS sg13g2_fill_1
X_14926_ _14926_/Q clkload62/A _14926_/D _14926_/RESET_B VDD VSS sg13g2_dfrbpq_1
XFILLER_64_934 VDD VSS sg13g2_decap_8
XFILLER_91_720 VDD VSS sg13g2_decap_8
XFILLER_91_731 VDD VSS sg13g2_fill_1
XFILLER_64_967 VDD VSS sg13g2_decap_8
X_14857_ _14857_/Q clkload79/A _14857_/D _14857_/RESET_B VDD VSS sg13g2_dfrbpq_1
XFILLER_35_157 VDD VSS sg13g2_fill_1
XFILLER_1_1153 VDD VSS sg13g2_decap_8
XFILLER_23_308 VDD VSS sg13g2_decap_8
XFILLER_23_319 VDD VSS sg13g2_fill_2
X_13808_ _13808_/Q clkload49/A _13808_/D _13808_/RESET_B VDD VSS sg13g2_dfrbpq_1
X_14788_ _14788_/Q clkload82/A _14788_/D _14788_/RESET_B VDD VSS sg13g2_dfrbpq_1
X_14749__1813 _14749_/RESET_B VDD VSS sg13g2_tiehi
XFILLER_50_127 VDD VSS sg13g2_decap_8
XFILLER_44_691 VDD VSS sg13g2_decap_8
XFILLER_17_1106 VDD VSS sg13g2_decap_8
XFILLER_16_393 VDD VSS sg13g2_decap_8
X_13739_ _13739_/Q _14667_/CLK _13739_/D _13739_/RESET_B VDD VSS sg13g2_dfrbpq_1
XFILLER_108_1234 VDD VSS sg13g2_fill_2
XFILLER_149_538 VDD VSS sg13g2_decap_8
XFILLER_104_1109 VDD VSS sg13g2_decap_8
XFILLER_118_914 VDD VSS sg13g2_decap_8
X_09901_ _14487_/D _09934_/A1 _14487_/Q _09901_/S VDD VSS sg13g2_mux2_1
XFILLER_144_298 VDD VSS sg13g2_decap_8
XFILLER_28_1213 VDD VSS sg13g2_decap_8
XFILLER_99_853 VDD VSS sg13g2_decap_4
XFILLER_116_28 VDD VSS sg13g2_decap_8
XFILLER_125_490 VDD VSS sg13g2_decap_8
XFILLER_154_1232 VDD VSS sg13g2_decap_4
Xfanout505 _09271_/S wire510/X VDD VSS sg13g2_buf_1
X_14841__3247 _14841_/RESET_B VDD VSS sg13g2_tiehi
XFILLER_113_652 VDD VSS sg13g2_decap_4
Xfanout527 _10145_/A1 _09913_/A1 VDD VSS sg13g2_buf_1
X_09832_ _14420_/D _09898_/A0 _14420_/Q _09835_/S VDD VSS sg13g2_mux2_1
XFILLER_112_140 VDD VSS sg13g2_decap_4
XFILLER_115_1205 VDD VSS sg13g2_decap_8
Xfanout538 _09609_/A0 fanout542/X VDD VSS sg13g2_buf_1
XFILLER_59_728 VDD VSS sg13g2_decap_8
XFILLER_140_460 VDD VSS sg13g2_decap_8
XFILLER_112_184 VDD VSS sg13g2_fill_1
X_09763_ _14353_/D _14353_/Q _09928_/A1 _09772_/S VDD VSS sg13g2_mux2_1
XFILLER_39_430 VDD VSS sg13g2_fill_2
XFILLER_55_901 VDD VSS sg13g2_decap_4
X_08714_ _15210_/D _15189_/D _15119_/Q _13653_/S VDD VSS sg13g2_mux2_1
XFILLER_6_1075 VDD VSS sg13g2_decap_8
XFILLER_54_400 VDD VSS sg13g2_decap_8
X_09694_ _14286_/D _09925_/A1 _14286_/Q _09694_/S VDD VSS sg13g2_mux2_1
XFILLER_132_49 VDD VSS sg13g2_decap_8
XFILLER_55_934 VDD VSS sg13g2_decap_8
XFILLER_82_731 VDD VSS sg13g2_decap_8
X_08645_ _08645_/X _08646_/A _08646_/B _08646_/C VDD VSS sg13g2_and3_1
XFILLER_25_14 VDD VSS sg13g2_decap_8
XFILLER_81_252 VDD VSS sg13g2_fill_2
XFILLER_54_477 VDD VSS sg13g2_decap_4
XFILLER_74_1200 VDD VSS sg13g2_decap_8
X_08576_ _08576_/Y wire232/A wire365/X _08573_/Y VDD VSS sg13g2_o21ai_1
XFILLER_81_285 VDD VSS sg13g2_fill_1
XFILLER_148_7 VDD VSS sg13g2_decap_8
XFILLER_70_1108 VDD VSS sg13g2_fill_1
Xclkbuf_4_7_0_clk_i clkbuf_4_7_0_clk_i/X clkbuf_0_clk_i/X VDD VSS sg13g2_buf_8
XFILLER_50_694 VDD VSS sg13g2_fill_2
XFILLER_109_914 VDD VSS sg13g2_fill_2
X_09128_ _10772_/A _15047_/Q _15244_/Q _09161_/S VDD VSS sg13g2_mux2_1
XFILLER_109_958 VDD VSS sg13g2_fill_1
XFILLER_68_1015 VDD VSS sg13g2_decap_8
XFILLER_136_777 VDD VSS sg13g2_fill_2
X_09059_ _13770_/D _13770_/Q _10153_/A1 _09153_/S VDD VSS sg13g2_mux2_1
XFILLER_68_1048 VDD VSS sg13g2_decap_4
XFILLER_123_405 VDD VSS sg13g2_decap_8
XFILLER_135_287 VDD VSS sg13g2_decap_4
XFILLER_151_747 VDD VSS sg13g2_fill_2
X_12070_ _12070_/X _14579_/Q _14611_/Q _14643_/Q _14675_/Q _12073_/S0 _12073_/S1 VDD
+ VSS sg13g2_mux4_1
XFILLER_123_449 VDD VSS sg13g2_fill_1
XFILLER_151_769 VDD VSS sg13g2_decap_8
XFILLER_81_1204 VDD VSS sg13g2_fill_2
XFILLER_89_352 VDD VSS sg13g2_fill_2
X_11021_ _11021_/X _14943_/Q _11084_/B VDD VSS sg13g2_and2_1
XFILLER_1_256 VDD VSS sg13g2_fill_1
XFILLER_132_983 VDD VSS sg13g2_decap_8
XFILLER_66_21 VDD VSS sg13g2_decap_8
XFILLER_77_558 VDD VSS sg13g2_fill_1
XFILLER_64_208 VDD VSS sg13g2_fill_1
XFILLER_131_1051 VDD VSS sg13g2_decap_8
X_12972_ _12990_/A _14905_/Q _13682_/Q VDD VSS sg13g2_or2_1
XFILLER_64_219 VDD VSS sg13g2_fill_1
XFILLER_66_98 VDD VSS sg13g2_decap_8
XFILLER_73_731 VDD VSS sg13g2_decap_8
X_15213__3366 _15213_/RESET_B VDD VSS sg13g2_tiehi
X_14711_ _14711_/Q clkload3/A _14711_/D _14711_/RESET_B VDD VSS sg13g2_dfrbpq_1
X_11923_ _11923_/X _14383_/Q _14415_/Q _14479_/Q _14511_/Q _12072_/S0 _12072_/S1 VDD
+ VSS sg13g2_mux4_1
XFILLER_79_1144 VDD VSS sg13g2_fill_2
XFILLER_46_967 VDD VSS sg13g2_decap_8
XFILLER_46_989 VDD VSS sg13g2_fill_2
XFILLER_72_241 VDD VSS sg13g2_decap_4
XFILLER_72_263 VDD VSS sg13g2_fill_1
X_14642_ _14642_/Q _14738_/CLK _14642_/D _14642_/RESET_B VDD VSS sg13g2_dfrbpq_1
X_11854_ _11854_/X _14253_/Q _14285_/Q _14317_/Q _14349_/Q _11992_/S0 _11997_/S1 VDD
+ VSS sg13g2_mux4_1
XFILLER_72_285 VDD VSS sg13g2_fill_1
X_10805_ _10805_/Y _15121_/Q _10805_/B _10805_/C VDD VSS sg13g2_nor3_1
X_14573_ _14573_/Q _14669_/CLK _14573_/D _14573_/RESET_B VDD VSS sg13g2_dfrbpq_1
X_13794__2770 _13794_/RESET_B VDD VSS sg13g2_tiehi
XFILLER_25_190 VDD VSS sg13g2_fill_2
X_11785_ _11785_/X _14251_/Q _14283_/Q _14315_/Q _14347_/Q _11787_/S0 _12286_/S1 VDD
+ VSS sg13g2_mux4_1
X_13524_ _15141_/D _13560_/S _13522_/Y _13523_/Y VDD VSS sg13g2_a21oi_1
X_10736_ _10736_/Y _14943_/Q _10735_/A _10735_/Y VDD VSS sg13g2_a21oi_1
XFILLER_15_91 VDD VSS sg13g2_decap_8
X_13455_ _13463_/D _13455_/A _13455_/B _13455_/C _13455_/D VDD VSS sg13g2_or4_1
XFILLER_139_560 VDD VSS sg13g2_fill_2
XFILLER_12_1003 VDD VSS sg13g2_decap_8
XFILLER_51_1052 VDD VSS sg13g2_decap_8
X_10667_ _14894_/D _13507_/A _10667_/B _10667_/C VDD VSS sg13g2_nor3_1
XFILLER_9_389 VDD VSS sg13g2_decap_4
XFILLER_127_722 VDD VSS sg13g2_fill_2
X_12406_ _12406_/X _14367_/Q _14399_/Q _14463_/Q _14495_/Q _12411_/S0 _12411_/S1 VDD
+ VSS sg13g2_mux4_1
X_14174__2390 _14174_/RESET_B VDD VSS sg13g2_tiehi
XFILLER_63_7 VDD VSS sg13g2_fill_2
X_13386_ _13386_/Y _13465_/A1 _08723_/B _15082_/Q VDD VSS sg13g2_o21ai_1
X_10598_ _10607_/D _14876_/Q _14875_/Q VDD VSS sg13g2_and2_1
XFILLER_115_906 VDD VSS sg13g2_fill_1
Xmax_cap1389 _08327_/S0 _08427_/S0 VDD VSS sg13g2_buf_4
XFILLER_86_1126 VDD VSS sg13g2_decap_8
X_15125_ _15125_/Q clkload68/A _15125_/D _15125_/RESET_B VDD VSS sg13g2_dfrbpq_1
XFILLER_103_1186 VDD VSS sg13g2_decap_8
Xoutput108 mem_axi_wdata[13] _15145_/Q VDD VSS sg13g2_buf_1
X_12337_ _12337_/Y _12335_/Y _12336_/Y _12001_/A VDD VSS sg13g2_a21oi_1
Xoutput119 mem_axi_wdata[23] _15155_/Q VDD VSS sg13g2_buf_1
XFILLER_141_224 VDD VSS sg13g2_decap_8
X_15056_ _15056_/Q _15209_/CLK _15056_/D _15056_/RESET_B VDD VSS sg13g2_dfrbpq_1
XFILLER_141_235 VDD VSS sg13g2_fill_2
X_12268_ _12268_/Y _12156_/A _12267_/Y _12227_/B VDD VSS sg13g2_o21ai_1
XFILLER_130_909 VDD VSS sg13g2_decap_8
XFILLER_123_961 VDD VSS sg13g2_decap_8
X_14007_ _14007_/Q _14505_/CLK _14007_/D _14007_/RESET_B VDD VSS sg13g2_dfrbpq_1
X_11219_ _11219_/X _11218_/X _11282_/S1 _11283_/B VDD VSS sg13g2_a21o_1
X_12199_ _12200_/A _12155_/A _12151_/Y _12153_/B VDD VSS sg13g2_o21ai_1
Xoutput90 mem_axi_awaddr[29] _16882_/X VDD VSS sg13g2_buf_1
XFILLER_68_558 VDD VSS sg13g2_decap_4
XFILLER_110_644 VDD VSS sg13g2_fill_1
XFILLER_37_923 VDD VSS sg13g2_fill_2
XFILLER_23_1154 VDD VSS sg13g2_decap_8
XFILLER_36_411 VDD VSS sg13g2_fill_2
XFILLER_64_731 VDD VSS sg13g2_decap_8
XFILLER_110_1135 VDD VSS sg13g2_decap_8
X_14909_ _14909_/Q _15248_/CLK _14909_/D _14909_/RESET_B VDD VSS sg13g2_dfrbpq_1
X_14981__2991 _14981_/RESET_B VDD VSS sg13g2_tiehi
XFILLER_64_753 VDD VSS sg13g2_decap_4
X_08430_ _08441_/D _08484_/B _08428_/X _08429_/Y VDD VSS sg13g2_o21ai_1
XFILLER_24_639 VDD VSS sg13g2_decap_8
XFILLER_145_1209 VDD VSS sg13g2_decap_8
X_08361_ _08361_/Y _08244_/B _08195_/Y _08360_/Y VDD VSS sg13g2_a21oi_1
XFILLER_51_458 VDD VSS sg13g2_fill_1
X_08292_ _08293_/A _07778_/X _08290_/X _08291_/Y VDD VSS sg13g2_o21ai_1
XFILLER_108_1064 VDD VSS sg13g2_fill_1
XFILLER_118_733 VDD VSS sg13g2_fill_1
X_14004__2560 _14004_/RESET_B VDD VSS sg13g2_tiehi
XFILLER_117_232 VDD VSS sg13g2_decap_4
XFILLER_30_1158 VDD VSS sg13g2_decap_8
XFILLER_11_49 VDD VSS sg13g2_decap_8
XFILLER_133_725 VDD VSS sg13g2_fill_1
XFILLER_127_49 VDD VSS sg13g2_decap_8
XFILLER_133_747 VDD VSS sg13g2_decap_4
X_14608__1956 _14608_/RESET_B VDD VSS sg13g2_tiehi
XFILLER_8_1104 VDD VSS sg13g2_decap_8
XFILLER_87_812 VDD VSS sg13g2_decap_8
Xfanout313 _10057_/S fanout315/X VDD VSS sg13g2_buf_1
Xfanout324 _09874_/S wire327/A VDD VSS sg13g2_buf_1
Xfanout346 _09440_/S _09408_/Y VDD VSS sg13g2_buf_1
Xfanout357 _09613_/A0 _09001_/X VDD VSS sg13g2_buf_1
X_09815_ _14403_/D _09914_/A1 _14403_/Q _09834_/S VDD VSS sg13g2_mux2_1
XFILLER_87_856 VDD VSS sg13g2_fill_2
XFILLER_59_558 VDD VSS sg13g2_fill_2
X_13872__2692 _13872_/RESET_B VDD VSS sg13g2_tiehi
XFILLER_101_655 VDD VSS sg13g2_decap_4
XFILLER_100_143 VDD VSS sg13g2_fill_1
X_09746_ _14336_/D _14336_/Q _10143_/A1 wire444/X VDD VSS sg13g2_mux2_1
X_09677_ _14269_/D _09908_/A1 _14269_/Q _09679_/S VDD VSS sg13g2_mux2_1
XFILLER_27_466 VDD VSS sg13g2_decap_8
XFILLER_15_617 VDD VSS sg13g2_fill_2
X_08628_ _08628_/Y _07855_/A _08610_/Y _08627_/Y VDD VSS sg13g2_o21ai_1
XFILLER_70_712 VDD VSS sg13g2_decap_8
XFILLER_14_105 VDD VSS sg13g2_decap_8
X_08559_ _08560_/C _07861_/B _08598_/A3 _08591_/A3 _07815_/B wire1387/X _08559_/S1
+ VDD VSS sg13g2_mux4_1
XFILLER_74_1063 VDD VSS sg13g2_decap_8
X_11570_ _11638_/C _11570_/A _13683_/Q VDD VSS sg13g2_xnor2_1
XFILLER_35_1047 VDD VSS sg13g2_decap_8
XFILLER_22_171 VDD VSS sg13g2_decap_8
XFILLER_122_1017 VDD VSS sg13g2_decap_8
X_10521_ _10531_/D _14856_/Q _14855_/Q _10521_/C wire388/X VDD VSS sg13g2_and4_1
X_13240_ _13246_/C _14923_/Q _13664_/Q VDD VSS sg13g2_xor2_1
X_10452_ _10452_/Y _14840_/Q _10450_/C _10295_/C VDD VSS sg13g2_o21ai_1
XFILLER_109_744 VDD VSS sg13g2_decap_4
XFILLER_148_390 VDD VSS sg13g2_decap_8
X_13171_ _13176_/A _13171_/A _13172_/D VDD VSS sg13g2_nand2_1
X_10383_ _10386_/B _10378_/D _10380_/X _14819_/Q VDD VSS sg13g2_a21oi_1
X_12122_ _12122_/Y _14919_/Q _12267_/A2 _12118_/Y _12121_/Y VDD VSS sg13g2_a22oi_1
XFILLER_123_224 VDD VSS sg13g2_decap_8
XFILLER_11_1091 VDD VSS sg13g2_decap_8
XFILLER_97_609 VDD VSS sg13g2_fill_1
XFILLER_2_565 VDD VSS sg13g2_decap_8
XFILLER_85_1181 VDD VSS sg13g2_fill_1
XFILLER_85_1192 VDD VSS sg13g2_fill_1
X_12053_ _14980_/D _12053_/A _12053_/B VDD VSS sg13g2_nor2_1
XFILLER_151_599 VDD VSS sg13g2_decap_8
XFILLER_89_160 VDD VSS sg13g2_fill_1
X_11004_ _11007_/A _11004_/A _11004_/B _11009_/D _11009_/C VDD VSS sg13g2_nand4_1
XFILLER_77_322 VDD VSS sg13g2_decap_8
X_16861_ _16861_/X _16861_/A VDD VSS sg13g2_buf_1
X_13702__2862 _13702_/RESET_B VDD VSS sg13g2_tiehi
X_14955__3019 _14955_/RESET_B VDD VSS sg13g2_tiehi
XFILLER_77_86 VDD VSS sg13g2_decap_8
Xfanout880 _13427_/A _13490_/B VDD VSS sg13g2_buf_1
XFILLER_19_912 VDD VSS sg13g2_fill_2
Xfanout891 _08692_/A fanout894/X VDD VSS sg13g2_buf_1
XFILLER_18_400 VDD VSS sg13g2_fill_1
XFILLER_93_837 VDD VSS sg13g2_decap_8
XFILLER_133_81 VDD VSS sg13g2_decap_8
XFILLER_19_967 VDD VSS sg13g2_decap_8
X_12955_ _12956_/A _12945_/Y _12946_/Y _12954_/Y VDD VSS sg13g2_o21ai_1
XFILLER_45_230 VDD VSS sg13g2_decap_8
X_14046__2518 _14046_/RESET_B VDD VSS sg13g2_tiehi
XFILLER_34_915 VDD VSS sg13g2_fill_1
XFILLER_45_252 VDD VSS sg13g2_fill_2
X_11906_ _14976_/D _11868_/Y _11905_/Y _11863_/Y VDD VSS sg13g2_a21oi_1
XFILLER_93_96 VDD VSS sg13g2_fill_1
X_12886_ _12886_/Y _12914_/A _12884_/Y _12885_/Y VDD VSS sg13g2_o21ai_1
X_14625_ _14625_/Q clkload28/A _14625_/D _14625_/RESET_B VDD VSS sg13g2_dfrbpq_1
X_11837_ _11837_/Y _12051_/A1 _11836_/Y _12298_/B VDD VSS sg13g2_o21ai_1
XFILLER_18_1212 VDD VSS sg13g2_decap_8
XFILLER_60_255 VDD VSS sg13g2_decap_8
XFILLER_60_266 VDD VSS sg13g2_decap_8
X_14556_ _14556_/Q clkload75/A _14556_/D _14556_/RESET_B VDD VSS sg13g2_dfrbpq_1
X_11768_ _11768_/Y _11767_/X _11664_/A _12147_/B1 VDD VSS sg13g2_a21oi_1
XFILLER_41_480 VDD VSS sg13g2_decap_8
XFILLER_53_1147 VDD VSS sg13g2_decap_8
XFILLER_105_1215 VDD VSS sg13g2_decap_8
XFILLER_53_1158 VDD VSS sg13g2_fill_2
X_14261__2303 _14261_/RESET_B VDD VSS sg13g2_tiehi
X_10719_ _14907_/D _10985_/B1 _10954_/C _10718_/Y VDD VSS sg13g2_o21ai_1
X_13507_ _15131_/D _13507_/A _13507_/B _13507_/C VDD VSS sg13g2_nor3_1
XFILLER_147_839 VDD VSS sg13g2_decap_8
X_14487_ _14487_/Q clkload4/A _14487_/D _14487_/RESET_B VDD VSS sg13g2_dfrbpq_1
XFILLER_140_1139 VDD VSS sg13g2_decap_8
X_11699_ _11699_/Y _11698_/Y _11688_/Y _11680_/Y _11672_/Y _11477_/A VDD VSS sg13g2_a221oi_1
X_13438_ _13438_/Y _13600_/C _13438_/B _15130_/Q _13438_/D VDD VSS sg13g2_nand4_1
Xmax_cap1153 _12742_/S0 _12727_/S0 VDD VSS sg13g2_buf_4
XFILLER_155_861 VDD VSS sg13g2_decap_8
X_13369_ _13369_/Y _13440_/A _13440_/B _15076_/Q VDD VSS sg13g2_nand3_1
XFILLER_127_574 VDD VSS sg13g2_decap_8
XFILLER_6_882 VDD VSS sg13g2_decap_8
XFILLER_142_522 VDD VSS sg13g2_decap_8
XFILLER_142_533 VDD VSS sg13g2_fill_2
XFILLER_138_1035 VDD VSS sg13g2_decap_8
X_15108_ _15108_/Q clkload80/A _15108_/D _15108_/RESET_B VDD VSS sg13g2_dfrbpq_1
X_14999__2973 _14999_/RESET_B VDD VSS sg13g2_tiehi
Xhold3408 input5/A mem_axi_rdata[10] VDD VSS sg13g2_dlygate4sd3_1
XFILLER_88_609 VDD VSS sg13g2_decap_8
Xhold3419 input29/A mem_axi_rdata[3] VDD VSS sg13g2_dlygate4sd3_1
XFILLER_138_1079 VDD VSS sg13g2_fill_2
X_07930_ _08286_/A _07930_/A _08318_/B VDD VSS sg13g2_nor2_1
X_15039_ _15039_/Q _15040_/CLK _15039_/D _15039_/RESET_B VDD VSS sg13g2_dfrbpq_1
XFILLER_123_780 VDD VSS sg13g2_decap_8
XFILLER_69_845 VDD VSS sg13g2_decap_8
XFILLER_151_1224 VDD VSS sg13g2_decap_8
XFILLER_96_642 VDD VSS sg13g2_decap_8
XFILLER_151_1235 VDD VSS sg13g2_fill_2
X_07861_ _08608_/B _15013_/Q _07861_/B VDD VSS sg13g2_and2_1
XFILLER_69_889 VDD VSS sg13g2_decap_8
X_09600_ _14197_/D _14197_/Q _10097_/A0 _09604_/S VDD VSS sg13g2_mux2_1
XFILLER_84_837 VDD VSS sg13g2_fill_1
X_07792_ _07795_/A _08391_/B _08412_/A VDD VSS sg13g2_nand2b_1
XFILLER_95_174 VDD VSS sg13g2_decap_8
XFILLER_110_496 VDD VSS sg13g2_decap_8
X_09531_ _14130_/D _09962_/A1 _14130_/Q _09538_/S VDD VSS sg13g2_mux2_1
XFILLER_36_230 VDD VSS sg13g2_decap_8
XFILLER_36_241 VDD VSS sg13g2_fill_1
XFILLER_64_550 VDD VSS sg13g2_fill_1
XFILLER_97_1063 VDD VSS sg13g2_decap_8
X_09462_ _14063_/D _10091_/A0 _14063_/Q _09472_/S VDD VSS sg13g2_mux2_1
XFILLER_97_1074 VDD VSS sg13g2_decap_8
XFILLER_36_274 VDD VSS sg13g2_decap_8
XFILLER_58_1036 VDD VSS sg13g2_fill_1
XFILLER_19_1009 VDD VSS sg13g2_decap_8
X_08413_ _08418_/B _08383_/A _08383_/B _08415_/A _08411_/Y _08412_/Y VDD VSS sg13g2_a221oi_1
XFILLER_149_1186 VDD VSS sg13g2_decap_8
X_09393_ _13996_/D _09956_/A1 _13996_/Q _09406_/S VDD VSS sg13g2_mux2_1
XFILLER_33_970 VDD VSS sg13g2_fill_1
XFILLER_51_277 VDD VSS sg13g2_decap_8
XFILLER_11_119 VDD VSS sg13g2_decap_4
X_08344_ _08344_/Y _08168_/Y _08344_/A2 _08027_/Y VDD VSS sg13g2_a21oi_1
XFILLER_71_1225 VDD VSS sg13g2_decap_8
XFILLER_71_1236 VDD VSS sg13g2_fill_1
XFILLER_32_491 VDD VSS sg13g2_decap_8
XFILLER_149_154 VDD VSS sg13g2_decap_4
XFILLER_137_305 VDD VSS sg13g2_fill_1
X_08275_ _08275_/Y _08275_/A _08275_/B VDD VSS sg13g2_nor2_1
XFILLER_118_530 VDD VSS sg13g2_decap_8
XFILLER_4_819 VDD VSS sg13g2_decap_8
XFILLER_3_307 VDD VSS sg13g2_decap_8
X_15212__3365 _15212_/RESET_B VDD VSS sg13g2_tiehi
XFILLER_69_1176 VDD VSS sg13g2_fill_2
XFILLER_154_14 VDD VSS sg13g2_decap_8
XFILLER_69_1198 VDD VSS sg13g2_decap_4
XFILLER_156_1157 VDD VSS sg13g2_fill_2
XFILLER_121_717 VDD VSS sg13g2_decap_8
Xfanout1108 _12740_/S1 fanout1120/X VDD VSS sg13g2_buf_1
XFILLER_102_920 VDD VSS sg13g2_fill_1
XFILLER_120_227 VDD VSS sg13g2_fill_1
Xfanout1119 _12758_/S1 fanout1120/X VDD VSS sg13g2_buf_1
XFILLER_114_791 VDD VSS sg13g2_decap_8
Xfanout154 _10068_/A0 _10101_/A0 VDD VSS sg13g2_buf_1
Xfanout165 _10033_/A0 _10099_/A0 VDD VSS sg13g2_buf_1
XFILLER_59_366 VDD VSS sg13g2_decap_8
Xfanout176 _10131_/A0 _09131_/X VDD VSS sg13g2_buf_1
XFILLER_75_826 VDD VSS sg13g2_fill_2
XFILLER_47_528 VDD VSS sg13g2_fill_1
Xfanout187 _10162_/A1 _09118_/Y VDD VSS sg13g2_buf_1
XFILLER_75_837 VDD VSS sg13g2_decap_8
XFILLER_47_56 VDD VSS sg13g2_fill_1
XFILLER_41_1051 VDD VSS sg13g2_decap_8
XFILLER_90_807 VDD VSS sg13g2_fill_2
X_09729_ _14320_/D _09927_/A1 _14320_/Q _09729_/S VDD VSS sg13g2_mux2_1
XFILLER_76_1114 VDD VSS sg13g2_fill_1
X_12740_ _12740_/X _13847_/Q _13879_/Q _13911_/Q _13943_/Q _12740_/S0 _12740_/S1 VDD
+ VSS sg13g2_mux4_1
XFILLER_15_425 VDD VSS sg13g2_fill_1
XFILLER_43_734 VDD VSS sg13g2_fill_2
XFILLER_76_1136 VDD VSS sg13g2_decap_8
X_12671_ _12671_/X _14706_/Q _14738_/Q _13778_/Q _13810_/Q _12675_/S0 _12675_/S1 VDD
+ VSS sg13g2_mux4_1
X_14410_ _14410_/Q _14506_/CLK _14410_/D _14410_/RESET_B VDD VSS sg13g2_dfrbpq_1
X_11622_ _11622_/X _12108_/B _11621_/X _11620_/Y VDD VSS sg13g2_a21o_1
XFILLER_30_428 VDD VSS sg13g2_fill_2
XFILLER_8_28 VDD VSS sg13g2_decap_8
XFILLER_137_0 VDD VSS sg13g2_decap_8
X_14341_ _14341_/Q _14405_/CLK _14341_/D _14341_/RESET_B VDD VSS sg13g2_dfrbpq_1
X_11553_ _11553_/Y _11553_/A1 _13924_/Q _11690_/B VDD VSS sg13g2_a21oi_1
X_10504_ _10505_/D _14854_/Q _14853_/Q _10504_/C _14845_/Q VDD VSS sg13g2_and4_1
XFILLER_6_112 VDD VSS sg13g2_fill_2
X_14272_ _14272_/Q _14917_/CLK _14272_/D _14272_/RESET_B VDD VSS sg13g2_dfrbpq_1
Xwire555 wire555/X wire555/A VDD VSS sg13g2_buf_1
X_11484_ _11485_/B _11461_/A _13687_/Q _11463_/Y VDD VSS sg13g2_a21oi_1
XFILLER_13_1153 VDD VSS sg13g2_decap_8
Xwire566 wire566/X wire566/A VDD VSS sg13g2_buf_2
XFILLER_7_668 VDD VSS sg13g2_decap_8
Xwire577 wire577/X wire577/A VDD VSS sg13g2_buf_2
XFILLER_7_679 VDD VSS sg13g2_fill_1
X_13223_ _15048_/D _13216_/Y wire207/X _13239_/A VDD VSS sg13g2_a21oi_1
XFILLER_155_179 VDD VSS sg13g2_decap_8
XFILLER_12_70 VDD VSS sg13g2_decap_8
X_10435_ _14834_/D _13306_/A _10435_/B _10443_/D VDD VSS sg13g2_nor3_1
XFILLER_100_1145 VDD VSS sg13g2_fill_2
XFILLER_136_393 VDD VSS sg13g2_decap_4
XFILLER_98_907 VDD VSS sg13g2_decap_4
X_13154_ _13155_/B _13222_/A1 _13149_/X _13148_/Y _13160_/B wire562/X VDD VSS sg13g2_a221oi_1
X_10366_ _10370_/C _14814_/Q _10365_/B VDD VSS sg13g2_nor2b_1
XFILLER_152_864 VDD VSS sg13g2_decap_8
XFILLER_98_929 VDD VSS sg13g2_decap_8
XFILLER_151_363 VDD VSS sg13g2_decap_8
XFILLER_2_340 VDD VSS sg13g2_decap_8
X_12105_ _12105_/Y _12090_/A _14516_/Q _12233_/B VDD VSS sg13g2_a21oi_1
XFILLER_151_374 VDD VSS sg13g2_fill_1
X_13085_ wire564/A _13085_/A _13085_/B _13085_/C VDD VSS sg13g2_nand3_1
X_15162__3018 _15162_/RESET_B VDD VSS sg13g2_tiehi
X_10297_ _10311_/B _10297_/A _10297_/B _10297_/C VDD VSS sg13g2_nor3_1
Xfanout1620 _12072_/S1 _12207_/S1 VDD VSS sg13g2_buf_1
X_12036_ _12036_/X _12036_/A _12036_/B VDD VSS sg13g2_and2_1
Xfanout1631 _12259_/S1 _11555_/S1 VDD VSS sg13g2_buf_1
XFILLER_26_7 VDD VSS sg13g2_decap_8
Xfanout1642 _11805_/C _12038_/B1 VDD VSS sg13g2_buf_1
Xfanout1653 _11897_/C _11890_/S1 VDD VSS sg13g2_buf_1
XFILLER_120_761 VDD VSS sg13g2_decap_8
Xfanout1664 _11715_/S0 fanout1672/X VDD VSS sg13g2_buf_1
XFILLER_38_528 VDD VSS sg13g2_fill_1
Xfanout1675 _11925_/S0 _12207_/S0 VDD VSS sg13g2_buf_1
XFILLER_120_783 VDD VSS sg13g2_decap_8
Xfanout1686 _11614_/S0 _12100_/S0 VDD VSS sg13g2_buf_1
Xfanout1697 _11692_/A _11695_/S0 VDD VSS sg13g2_buf_1
XFILLER_92_144 VDD VSS sg13g2_fill_1
XFILLER_20_1135 VDD VSS sg13g2_decap_8
X_13987_ _13987_/Q clkload2/A _13987_/D _13987_/RESET_B VDD VSS sg13g2_dfrbpq_1
XFILLER_19_775 VDD VSS sg13g2_decap_8
XFILLER_94_1203 VDD VSS sg13g2_fill_1
XFILLER_18_263 VDD VSS sg13g2_decap_8
X_15055__2896 _15055_/RESET_B VDD VSS sg13g2_tiehi
X_13968__2596 _13968_/RESET_B VDD VSS sg13g2_tiehi
XFILLER_33_200 VDD VSS sg13g2_fill_1
X_14899__3131 _14899_/RESET_B VDD VSS sg13g2_tiehi
XFILLER_92_199 VDD VSS sg13g2_decap_8
X_12938_ _12938_/Y input20/X _12795_/Y _12937_/Y VDD VSS sg13g2_o21ai_1
XFILLER_94_1236 VDD VSS sg13g2_fill_1
XFILLER_61_531 VDD VSS sg13g2_decap_4
X_12869_ _12869_/Y _12914_/A _12867_/Y _12868_/Y VDD VSS sg13g2_o21ai_1
XFILLER_61_597 VDD VSS sg13g2_decap_8
X_14608_ _14608_/Q clkload50/A _14608_/D _14608_/RESET_B VDD VSS sg13g2_dfrbpq_1
XFILLER_57_1091 VDD VSS sg13g2_decap_8
XFILLER_147_603 VDD VSS sg13g2_decap_8
XFILLER_18_1086 VDD VSS sg13g2_decap_8
X_14539_ _14539_/Q _14667_/CLK _14539_/D _14539_/RESET_B VDD VSS sg13g2_dfrbpq_1
XFILLER_30_995 VDD VSS sg13g2_decap_8
XFILLER_147_658 VDD VSS sg13g2_decap_8
X_08060_ _08060_/X _08258_/C _08276_/A _08306_/C _08376_/A3 _08327_/S0 _08099_/S0
+ VDD VSS sg13g2_mux4_1
XFILLER_119_349 VDD VSS sg13g2_decap_8
XFILLER_52_0 VDD VSS sg13g2_decap_8
XFILLER_88_417 VDD VSS sg13g2_decap_8
X_08962_ _09707_/C _09641_/A _09441_/C VDD VSS sg13g2_nand2_1
XFILLER_142_385 VDD VSS sg13g2_decap_8
XFILLER_9_1232 VDD VSS sg13g2_decap_4
XFILLER_102_227 VDD VSS sg13g2_decap_8
XFILLER_69_631 VDD VSS sg13g2_decap_8
XFILLER_130_547 VDD VSS sg13g2_decap_8
XFILLER_64_1062 VDD VSS sg13g2_fill_1
X_07913_ _07913_/Y _08079_/S _08023_/B VDD VSS sg13g2_nand2_1
XFILLER_116_1130 VDD VSS sg13g2_fill_2
XFILLER_130_558 VDD VSS sg13g2_fill_2
XFILLER_29_1193 VDD VSS sg13g2_decap_8
X_08893_ _08893_/Y _10788_/S _14941_/Q VDD VSS sg13g2_nor2b_1
XFILLER_124_28 VDD VSS sg13g2_decap_8
XFILLER_151_1032 VDD VSS sg13g2_decap_8
XFILLER_25_1046 VDD VSS sg13g2_decap_8
XFILLER_69_675 VDD VSS sg13g2_decap_4
XFILLER_5_1129 VDD VSS sg13g2_decap_8
XFILLER_68_163 VDD VSS sg13g2_decap_8
XFILLER_99_1114 VDD VSS sg13g2_fill_2
XFILLER_112_1005 VDD VSS sg13g2_decap_4
XFILLER_151_1065 VDD VSS sg13g2_decap_8
X_07844_ _07844_/X _15017_/Q _07972_/B VDD VSS sg13g2_and2_1
XFILLER_84_623 VDD VSS sg13g2_decap_8
XFILLER_151_1076 VDD VSS sg13g2_fill_1
XFILLER_56_336 VDD VSS sg13g2_fill_1
XFILLER_84_645 VDD VSS sg13g2_decap_8
X_07775_ _08318_/C _07775_/A _08306_/B VDD VSS sg13g2_xor2_1
XFILLER_72_818 VDD VSS sg13g2_decap_8
X_09514_ _14113_/D _09613_/A0 _14113_/Q _09523_/S VDD VSS sg13g2_mux2_1
XFILLER_140_49 VDD VSS sg13g2_decap_8
XFILLER_52_531 VDD VSS sg13g2_fill_1
X_09445_ _14046_/D _09744_/A1 _14046_/Q wire671/X VDD VSS sg13g2_mux2_1
XFILLER_13_918 VDD VSS sg13g2_decap_4
XFILLER_52_553 VDD VSS sg13g2_decap_8
XFILLER_80_862 VDD VSS sg13g2_decap_8
XFILLER_33_14 VDD VSS sg13g2_decap_8
XFILLER_12_417 VDD VSS sg13g2_decap_8
XFILLER_36_1120 VDD VSS sg13g2_fill_1
X_09376_ _13979_/D _09741_/A1 _13979_/Q _09377_/S VDD VSS sg13g2_mux2_1
XFILLER_149_14 VDD VSS sg13g2_decap_8
X_08327_ _08327_/X _08376_/A3 _08306_/C _08337_/A3 _08327_/A3 _08327_/S0 _08559_/S1
+ VDD VSS sg13g2_mux4_1
XFILLER_123_1123 VDD VSS sg13g2_decap_8
XFILLER_130_7 VDD VSS sg13g2_decap_8
XFILLER_32_1017 VDD VSS sg13g2_decap_8
XFILLER_21_984 VDD VSS sg13g2_decap_8
XFILLER_138_658 VDD VSS sg13g2_decap_8
X_08258_ _08258_/Y _08306_/A _14998_/Q _08258_/C VDD VSS sg13g2_nand3_1
X_15184__3200 _15184_/RESET_B VDD VSS sg13g2_tiehi
XFILLER_152_105 VDD VSS sg13g2_decap_8
X_08189_ _08190_/B _07909_/B _07910_/A _08188_/Y VDD VSS sg13g2_a21oi_1
XFILLER_119_894 VDD VSS sg13g2_fill_1
X_14357__2207 _14357_/RESET_B VDD VSS sg13g2_tiehi
XFILLER_3_126 VDD VSS sg13g2_decap_8
X_10220_ _10220_/Y _14767_/Q _14768_/Q _10337_/C VDD VSS sg13g2_o21ai_1
XFILLER_106_566 VDD VSS sg13g2_decap_8
XFILLER_79_406 VDD VSS sg13g2_fill_1
X_10151_ _14728_/D _14728_/Q _10151_/A1 _10167_/S VDD VSS sg13g2_mux2_1
XFILLER_0_822 VDD VSS sg13g2_decap_4
XFILLER_0_866 VDD VSS sg13g2_decap_8
X_10082_ _14662_/D _10082_/A0 _14662_/Q _10083_/S VDD VSS sg13g2_mux2_1
XFILLER_59_141 VDD VSS sg13g2_fill_1
X_13910_ _13910_/Q clkload25/A _13910_/D _13910_/RESET_B VDD VSS sg13g2_dfrbpq_1
XFILLER_130_1116 VDD VSS sg13g2_decap_8
X_14890_ _14890_/Q clkload79/A _14890_/D _14890_/RESET_B VDD VSS sg13g2_dfrbpq_1
XFILLER_75_667 VDD VSS sg13g2_decap_8
Xwire1077 _12734_/S wire1077/A VDD VSS sg13g2_buf_4
X_13841_ _13841_/Q _14737_/CLK _13841_/D _13841_/RESET_B VDD VSS sg13g2_dfrbpq_1
XFILLER_35_509 VDD VSS sg13g2_fill_1
XFILLER_63_829 VDD VSS sg13g2_decap_8
XFILLER_75_689 VDD VSS sg13g2_fill_1
X_13772_ _13772_/Q clkload51/A _13772_/D _13772_/RESET_B VDD VSS sg13g2_dfrbpq_1
XFILLER_28_594 VDD VSS sg13g2_decap_8
XFILLER_43_520 VDD VSS sg13g2_decap_8
X_10984_ _10984_/Y _10984_/A _10981_/Y VDD VSS sg13g2_nor2b_1
XFILLER_74_76 VDD VSS sg13g2_fill_2
X_12723_ _12736_/A _07625_/A _12751_/A2 _15016_/Q VDD VSS sg13g2_a21oi_1
XFILLER_54_1220 VDD VSS sg13g2_decap_8
XFILLER_70_372 VDD VSS sg13g2_decap_8
X_12654_ _12654_/X _14577_/Q _14609_/Q _14641_/Q _14673_/Q _12657_/S0 _12659_/S1 VDD
+ VSS sg13g2_mux4_1
XFILLER_128_1089 VDD VSS sg13g2_decap_8
X_11605_ _11605_/Y _11597_/A _14662_/Q _12088_/B VDD VSS sg13g2_a21oi_1
X_12585_ _12585_/X _14124_/Q _14156_/Q _14188_/Q _14220_/Q _12647_/S0 _12647_/S1 VDD
+ VSS sg13g2_mux4_1
X_14603__1961 _14603_/RESET_B VDD VSS sg13g2_tiehi
XFILLER_156_422 VDD VSS sg13g2_decap_4
XFILLER_11_461 VDD VSS sg13g2_fill_1
XFILLER_8_944 VDD VSS sg13g2_fill_2
XFILLER_129_647 VDD VSS sg13g2_decap_8
X_11536_ _11536_/Y _12259_/S0 _14564_/Q VDD VSS sg13g2_nand2b_1
X_14324_ _14324_/Q _14726_/CLK _14324_/D _14324_/RESET_B VDD VSS sg13g2_dfrbpq_1
XFILLER_23_91 VDD VSS sg13g2_decap_8
XFILLER_128_157 VDD VSS sg13g2_fill_2
Xwire374 wire374/X wire374/A VDD VSS sg13g2_buf_2
XFILLER_139_91 VDD VSS sg13g2_decap_8
X_14255_ _14255_/Q clkload14/A _14255_/D _14255_/RESET_B VDD VSS sg13g2_dfrbpq_1
XFILLER_156_499 VDD VSS sg13g2_fill_1
XFILLER_144_639 VDD VSS sg13g2_decap_4
X_11467_ _11467_/X _13953_/Q _13985_/Q _14017_/Q _14049_/Q _11741_/A _11760_/C VDD
+ VSS sg13g2_mux4_1
Xwire385 wire385/X wire385/A VDD VSS sg13g2_buf_2
X_13206_ _13206_/Y _14825_/Q _13206_/B VDD VSS sg13g2_nand2_1
XFILLER_99_84 VDD VSS sg13g2_decap_8
X_10418_ _10420_/A _14828_/Q _10422_/D _14829_/Q VDD VSS sg13g2_a21o_1
X_14186_ _14186_/Q clkload23/A _14186_/D _14186_/RESET_B VDD VSS sg13g2_dfrbpq_1
XFILLER_125_864 VDD VSS sg13g2_fill_1
X_11398_ _11398_/Y _11400_/A _14591_/Q _11419_/C VDD VSS sg13g2_a21oi_1
X_13137_ _13139_/A _14820_/Q _13068_/B _13180_/B1 _14884_/Q VDD VSS sg13g2_a22oi_1
X_10349_ _10350_/B _14809_/Q _10352_/C VDD VSS sg13g2_nand2_1
XFILLER_151_171 VDD VSS sg13g2_decap_4
XFILLER_139_1196 VDD VSS sg13g2_fill_2
X_13068_ _13068_/Y _14815_/Q _13068_/B VDD VSS sg13g2_nand2_1
XFILLER_79_973 VDD VSS sg13g2_fill_2
Xfanout1450 _07946_/B _11770_/A VDD VSS sg13g2_buf_1
X_12019_ _12019_/Y _12019_/A _12019_/B _12027_/C VDD VSS sg13g2_nand3_1
XFILLER_94_921 VDD VSS sg13g2_decap_8
Xfanout1461 _07786_/A _11635_/A VDD VSS sg13g2_buf_1
XFILLER_22_1219 VDD VSS sg13g2_decap_8
Xfanout1472 _08327_/A3 _14966_/Q VDD VSS sg13g2_buf_1
Xfanout1483 _11454_/A _14962_/Q VDD VSS sg13g2_buf_1
XFILLER_65_133 VDD VSS sg13g2_decap_8
Xfanout1494 _08063_/B _13602_/A VDD VSS sg13g2_buf_1
XFILLER_93_464 VDD VSS sg13g2_decap_8
XFILLER_19_550 VDD VSS sg13g2_fill_1
XFILLER_54_829 VDD VSS sg13g2_decap_8
XFILLER_81_615 VDD VSS sg13g2_decap_8
XFILLER_19_572 VDD VSS sg13g2_fill_2
XFILLER_4_1195 VDD VSS sg13g2_decap_8
X_15211__3364 _15211_/RESET_B VDD VSS sg13g2_tiehi
XFILLER_146_1101 VDD VSS sg13g2_decap_8
XFILLER_46_391 VDD VSS sg13g2_decap_4
XFILLER_62_851 VDD VSS sg13g2_fill_1
XFILLER_0_95 VDD VSS sg13g2_decap_8
XFILLER_94_1055 VDD VSS sg13g2_fill_1
X_14435__2129 _14435_/RESET_B VDD VSS sg13g2_tiehi
XFILLER_59_1186 VDD VSS sg13g2_decap_8
XFILLER_146_1145 VDD VSS sg13g2_decap_8
XFILLER_22_726 VDD VSS sg13g2_decap_8
XFILLER_21_203 VDD VSS sg13g2_fill_2
X_09230_ _13841_/D _09730_/A0 _13841_/Q _09230_/S VDD VSS sg13g2_mux2_1
XFILLER_148_912 VDD VSS sg13g2_fill_2
X_09161_ _10793_/C _15052_/Q _15249_/Q _09161_/S VDD VSS sg13g2_mux2_1
XFILLER_119_113 VDD VSS sg13g2_decap_4
X_08112_ _15220_/D _08112_/A _08112_/B _08112_/C _08112_/D VDD VSS sg13g2_nand4_1
X_09092_ _13775_/D _13775_/Q _09893_/A0 _09160_/S VDD VSS sg13g2_mux2_1
XFILLER_119_28 VDD VSS sg13g2_decap_8
XFILLER_107_308 VDD VSS sg13g2_fill_1
X_08043_ _08043_/Y _08042_/X _08199_/B VDD VSS sg13g2_nand2b_1
XFILLER_134_116 VDD VSS sg13g2_fill_1
XFILLER_127_190 VDD VSS sg13g2_fill_2
Xmax_cap663 _09537_/S fanout662/X VDD VSS sg13g2_buf_8
Xmax_cap674 _09404_/S _09388_/S VDD VSS sg13g2_buf_4
XFILLER_116_886 VDD VSS sg13g2_decap_8
Xmax_cap685 _09368_/S _09358_/S VDD VSS sg13g2_buf_4
XFILLER_116_897 VDD VSS sg13g2_fill_1
XFILLER_118_1214 VDD VSS sg13g2_decap_8
XFILLER_115_374 VDD VSS sg13g2_fill_1
XFILLER_142_171 VDD VSS sg13g2_fill_1
XFILLER_0_118 VDD VSS sg13g2_decap_4
Xmax_cap696 _09239_/S _09212_/S VDD VSS sg13g2_buf_4
X_09994_ _14577_/D _09994_/A0 _14577_/Q _10003_/S VDD VSS sg13g2_mux2_1
XFILLER_131_834 VDD VSS sg13g2_fill_2
XFILLER_135_49 VDD VSS sg13g2_decap_8
X_14041__2523 _14041_/RESET_B VDD VSS sg13g2_tiehi
XFILLER_103_558 VDD VSS sg13g2_fill_1
XFILLER_153_1149 VDD VSS sg13g2_decap_8
XFILLER_88_258 VDD VSS sg13g2_decap_8
X_08945_ _08945_/Y _12229_/A _08945_/A2 _08944_/Y VDD VSS sg13g2_a21oi_1
XFILLER_76_409 VDD VSS sg13g2_fill_2
XFILLER_85_910 VDD VSS sg13g2_decap_8
XFILLER_28_14 VDD VSS sg13g2_decap_8
XFILLER_85_921 VDD VSS sg13g2_decap_8
XFILLER_85_932 VDD VSS sg13g2_fill_2
X_08876_ _13702_/D _13702_/Q _08875_/X _08892_/S VDD VSS sg13g2_mux2_1
XFILLER_97_792 VDD VSS sg13g2_decap_8
XFILLER_57_634 VDD VSS sg13g2_decap_8
XFILLER_69_494 VDD VSS sg13g2_fill_2
XFILLER_96_291 VDD VSS sg13g2_fill_1
X_14645__1919 _14645_/RESET_B VDD VSS sg13g2_tiehi
X_07827_ _08574_/B _15005_/Q _07946_/B VDD VSS sg13g2_xor2_1
XFILLER_17_509 VDD VSS sg13g2_decap_8
XFILLER_57_689 VDD VSS sg13g2_decap_8
XFILLER_56_188 VDD VSS sg13g2_decap_8
X_07758_ _07758_/Y wire911/X _12638_/A2 _07757_/Y VDD VSS sg13g2_o21ai_1
XFILLER_44_35 VDD VSS sg13g2_decap_8
XFILLER_38_1226 VDD VSS sg13g2_decap_8
X_07689_ _07690_/A _13302_/C _13281_/C VDD VSS sg13g2_nand2_1
XFILLER_13_715 VDD VSS sg13g2_decap_8
X_09428_ _14030_/D _09892_/A0 _14030_/Q _09431_/S VDD VSS sg13g2_mux2_1
XFILLER_125_1207 VDD VSS sg13g2_fill_2
XFILLER_12_247 VDD VSS sg13g2_decap_8
XFILLER_9_719 VDD VSS sg13g2_decap_4
X_15013__2959 _15013_/RESET_B VDD VSS sg13g2_tiehi
XFILLER_8_207 VDD VSS sg13g2_decap_4
X_09359_ _13963_/D _10021_/A0 _13963_/Q _09373_/S VDD VSS sg13g2_mux2_1
Xmax_cap1708 _12285_/S0 _12139_/S0 VDD VSS sg13g2_buf_4
XFILLER_21_781 VDD VSS sg13g2_decap_8
X_12370_ _12370_/X _12366_/X _12365_/X _12364_/X _12363_/X wire1096/A _12788_/S1 VDD
+ VSS sg13g2_mux4_1
XFILLER_60_56 VDD VSS sg13g2_decap_8
X_14883__3163 _14883_/RESET_B VDD VSS sg13g2_tiehi
X_11321_ _11321_/Y _11319_/Y _11318_/Y _11395_/B _11320_/X VDD VSS sg13g2_a22oi_1
XFILLER_10_1101 VDD VSS sg13g2_decap_8
XFILLER_153_425 VDD VSS sg13g2_decap_8
X_14040_ _14040_/Q _14506_/CLK _14040_/D _14040_/RESET_B VDD VSS sg13g2_dfrbpq_1
XFILLER_4_435 VDD VSS sg13g2_decap_4
X_11252_ _11252_/Y _11257_/S0 _14588_/Q _11282_/S1 VDD VSS sg13g2_a21oi_1
XFILLER_69_21 VDD VSS sg13g2_decap_8
XFILLER_10_1178 VDD VSS sg13g2_decap_8
X_10203_ _15183_/D hold3441/X _15183_/Q _13479_/S VDD VSS sg13g2_mux2_1
XFILLER_122_823 VDD VSS sg13g2_decap_8
X_11183_ _11183_/Y _11109_/B _11181_/A _11183_/B1 VDD VSS sg13g2_o21ai_1
XFILLER_133_193 VDD VSS sg13g2_fill_2
X_10134_ _14712_/D _10167_/A1 _14712_/Q _10134_/S VDD VSS sg13g2_mux2_1
XFILLER_48_601 VDD VSS sg13g2_decap_8
XFILLER_48_612 VDD VSS sg13g2_fill_2
X_10065_ _14646_/D _10098_/A0 _14646_/Q _10067_/S VDD VSS sg13g2_mux2_1
XFILLER_47_100 VDD VSS sg13g2_fill_2
X_14942_ _14942_/Q clkload61/A _14942_/D _14942_/RESET_B VDD VSS sg13g2_dfrbpq_1
XFILLER_134_1071 VDD VSS sg13g2_fill_1
XFILLER_85_42 VDD VSS sg13g2_decap_8
XFILLER_134_1093 VDD VSS sg13g2_decap_8
XFILLER_48_667 VDD VSS sg13g2_decap_8
XFILLER_36_818 VDD VSS sg13g2_decap_8
XFILLER_47_144 VDD VSS sg13g2_decap_4
X_14873_ _14873_/Q _14873_/CLK _14873_/D _14873_/RESET_B VDD VSS sg13g2_dfrbpq_1
XFILLER_63_604 VDD VSS sg13g2_fill_2
XFILLER_91_935 VDD VSS sg13g2_fill_2
XFILLER_29_881 VDD VSS sg13g2_decap_8
X_14803__3295 _14803_/RESET_B VDD VSS sg13g2_tiehi
X_13824_ _13824_/Q _14917_/CLK _13824_/D _13824_/RESET_B VDD VSS sg13g2_dfrbpq_1
XFILLER_90_423 VDD VSS sg13g2_fill_1
XFILLER_18_91 VDD VSS sg13g2_fill_2
XFILLER_141_70 VDD VSS sg13g2_decap_8
X_15104__3140 _15104_/RESET_B VDD VSS sg13g2_tiehi
X_13755_ _13755_/Q clkload76/A _13755_/D _13755_/RESET_B VDD VSS sg13g2_dfrbpq_1
X_10967_ _10995_/C _10967_/A _10967_/B VDD VSS sg13g2_nand2_1
XFILLER_16_586 VDD VSS sg13g2_fill_2
X_12706_ _12706_/X _12705_/X _12704_/X _12706_/S VDD VSS sg13g2_mux2_1
X_15094__3178 _15094_/RESET_B VDD VSS sg13g2_tiehi
XFILLER_149_709 VDD VSS sg13g2_fill_2
XFILLER_93_7 VDD VSS sg13g2_decap_8
X_13686_ _13686_/Q clkload39/A _13686_/D _13686_/RESET_B VDD VSS sg13g2_dfrbpq_1
X_10898_ _10898_/X _10923_/D _10923_/A _10924_/B1 VDD VSS sg13g2_a21o_1
XFILLER_19_1170 VDD VSS sg13g2_decap_8
XFILLER_15_1001 VDD VSS sg13g2_decap_8
X_12637_ _12637_/Y _13673_/Q _12791_/A2 _12636_/X _12415_/A _12791_/C1 VDD VSS sg13g2_a221oi_1
XFILLER_12_781 VDD VSS sg13g2_decap_8
XFILLER_129_433 VDD VSS sg13g2_fill_1
XFILLER_156_230 VDD VSS sg13g2_decap_4
XFILLER_12_792 VDD VSS sg13g2_fill_1
X_12568_ _12569_/B _13678_/Q _12749_/A2 _12567_/X _12749_/B2 _12749_/C1 VDD VSS sg13g2_a221oi_1
XFILLER_11_280 VDD VSS sg13g2_fill_2
XFILLER_141_1075 VDD VSS sg13g2_fill_2
XFILLER_89_1135 VDD VSS sg13g2_fill_2
XFILLER_145_937 VDD VSS sg13g2_fill_1
X_14307_ _14307_/Q _14405_/CLK _14307_/D _14307_/RESET_B VDD VSS sg13g2_dfrbpq_1
X_11519_ wire304/A _12221_/B1 _11517_/X _11518_/Y VDD VSS sg13g2_o21ai_1
XFILLER_145_959 VDD VSS sg13g2_decap_8
X_12499_ _14999_/D _12499_/A _12499_/B VDD VSS sg13g2_nor2_1
Xwire182 wire182/X wire182/A VDD VSS sg13g2_buf_2
X_14238_ _14238_/Q clkload58/A _14238_/D _14238_/RESET_B VDD VSS sg13g2_dfrbpq_1
XFILLER_113_801 VDD VSS sg13g2_fill_2
X_14169_ _14169_/Q _14745_/CLK _14169_/D _14169_/RESET_B VDD VSS sg13g2_dfrbpq_1
XFILLER_98_534 VDD VSS sg13g2_fill_1
XFILLER_152_491 VDD VSS sg13g2_fill_2
Xfanout709 _08956_/S _08941_/S VDD VSS sg13g2_buf_1
XFILLER_112_333 VDD VSS sg13g2_decap_8
XFILLER_85_206 VDD VSS sg13g2_decap_4
XFILLER_86_729 VDD VSS sg13g2_decap_8
XFILLER_100_517 VDD VSS sg13g2_fill_2
X_08730_ _08730_/Y _08751_/A1 _08751_/A2 _13448_/B VDD VSS sg13g2_o21ai_1
XFILLER_26_1163 VDD VSS sg13g2_decap_8
XFILLER_39_623 VDD VSS sg13g2_fill_1
XFILLER_61_1043 VDD VSS sg13g2_decap_8
XFILLER_67_932 VDD VSS sg13g2_fill_1
XFILLER_22_1016 VDD VSS sg13g2_decap_8
XFILLER_152_1182 VDD VSS sg13g2_decap_8
XFILLER_15_0 VDD VSS sg13g2_decap_8
X_13664__2929 _13664_/RESET_B VDD VSS sg13g2_tiehi
XFILLER_66_442 VDD VSS sg13g2_fill_2
Xfanout1280 _13180_/A2 _15106_/Q VDD VSS sg13g2_buf_1
XFILLER_27_807 VDD VSS sg13g2_decap_4
X_08661_ _08661_/X _08661_/A _08661_/B _08661_/C _08661_/D VDD VSS sg13g2_and4_1
Xfanout1291 _08779_/A1 fanout1298/X VDD VSS sg13g2_buf_1
XFILLER_27_818 VDD VSS sg13g2_decap_8
XFILLER_61_1098 VDD VSS sg13g2_fill_1
X_07612_ _07612_/Y _08698_/B VDD VSS sg13g2_inv_1
XFILLER_26_317 VDD VSS sg13g2_decap_8
XFILLER_148_1207 VDD VSS sg13g2_decap_8
X_08592_ _08592_/X _08337_/X _08427_/X _08510_/X _08591_/X _08511_/S _08544_/C VDD
+ VSS sg13g2_mux4_1
XFILLER_35_840 VDD VSS sg13g2_fill_1
XFILLER_35_862 VDD VSS sg13g2_fill_1
XFILLER_50_810 VDD VSS sg13g2_fill_2
XFILLER_22_512 VDD VSS sg13g2_decap_8
XFILLER_50_843 VDD VSS sg13g2_fill_2
XFILLER_61_191 VDD VSS sg13g2_decap_4
X_09213_ _13824_/D _09911_/A1 _13824_/Q _09236_/S VDD VSS sg13g2_mux2_1
XFILLER_14_49 VDD VSS sg13g2_decap_8
X_14059__2505 _14059_/RESET_B VDD VSS sg13g2_tiehi
X_09144_ _09145_/B _13245_/A _09137_/C _09143_/Y VDD VSS sg13g2_o21ai_1
XFILLER_136_926 VDD VSS sg13g2_decap_8
XFILLER_136_937 VDD VSS sg13g2_decap_8
XFILLER_33_1189 VDD VSS sg13g2_decap_8
XFILLER_107_105 VDD VSS sg13g2_fill_1
X_09075_ _09075_/X _13088_/A _09103_/C _09074_/Y VDD VSS sg13g2_a21o_1
XFILLER_108_639 VDD VSS sg13g2_decap_8
XFILLER_120_1159 VDD VSS sg13g2_decap_8
XFILLER_135_447 VDD VSS sg13g2_decap_4
X_08026_ _08026_/Y _08463_/A _08201_/B VDD VSS sg13g2_nor2_1
XFILLER_150_406 VDD VSS sg13g2_fill_1
XFILLER_104_812 VDD VSS sg13g2_decap_8
Xmax_cap460 _09705_/S _09679_/S VDD VSS sg13g2_buf_4
XFILLER_2_939 VDD VSS sg13g2_fill_2
XFILLER_103_300 VDD VSS sg13g2_decap_8
Xmax_cap493 _09303_/S _09302_/S VDD VSS sg13g2_buf_4
XFILLER_89_567 VDD VSS sg13g2_decap_4
XFILLER_39_35 VDD VSS sg13g2_decap_8
X_09977_ _14560_/D _09977_/A0 _14560_/Q _09999_/S VDD VSS sg13g2_mux2_1
Xclkbuf_4_3_0_clk_i clkbuf_4_3_0_clk_i/X clkbuf_0_clk_i/X VDD VSS sg13g2_buf_8
Xclkbuf_leaf_100_clk_i clkload28/A clkbuf_leaf_99_clk_i/A VDD VSS sg13g2_buf_8
X_08928_ _08928_/X _08927_/X _12061_/A _08940_/S VDD VSS sg13g2_mux2_1
XFILLER_131_1222 VDD VSS sg13g2_decap_8
X_15039__2932 _15039_/RESET_B VDD VSS sg13g2_tiehi
XFILLER_45_604 VDD VSS sg13g2_decap_4
X_08859_ _08859_/X _15028_/Q _14932_/Q _08862_/S VDD VSS sg13g2_mux2_1
X_15057__2888 _15057_/RESET_B VDD VSS sg13g2_tiehi
XFILLER_17_317 VDD VSS sg13g2_fill_2
XFILLER_17_328 VDD VSS sg13g2_decap_8
X_11870_ _11870_/Y _11896_/A _13870_/Q _11374_/C VDD VSS sg13g2_a21oi_1
XFILLER_72_456 VDD VSS sg13g2_fill_1
Xclkbuf_leaf_115_clk_i clkload24/A clkbuf_5_9__f_clk_i/X VDD VSS sg13g2_buf_8
X_10821_ _10823_/C _10821_/A _10821_/B _10821_/C VDD VSS sg13g2_nand3_1
XFILLER_38_1001 VDD VSS sg13g2_fill_1
X_14763__3337 _14763_/RESET_B VDD VSS sg13g2_tiehi
XFILLER_25_350 VDD VSS sg13g2_decap_8
XFILLER_60_629 VDD VSS sg13g2_fill_2
X_13540_ _15145_/D _13539_/B _13538_/Y _13539_/Y VDD VSS sg13g2_a21oi_1
X_10752_ _10752_/Y _10752_/A _10752_/B VDD VSS sg13g2_nor2_1
XFILLER_125_1015 VDD VSS sg13g2_fill_2
XFILLER_13_556 VDD VSS sg13g2_decap_4
XFILLER_13_567 VDD VSS sg13g2_fill_1
X_13471_ _13471_/X hold3417/X _15176_/Q _13471_/S VDD VSS sg13g2_mux2_1
XFILLER_9_527 VDD VSS sg13g2_decap_8
X_10683_ _10827_/B _08985_/X _08848_/A _08848_/Y VDD VSS sg13g2_a21oi_1
XFILLER_125_1059 VDD VSS sg13g2_decap_4
X_12422_ _12422_/X _14560_/Q _14592_/Q _14624_/Q _14656_/Q _12742_/S0 _12742_/S1 VDD
+ VSS sg13g2_mux4_1
XFILLER_71_99 VDD VSS sg13g2_fill_1
X_15210_ _15210_/Q _15212_/CLK _15210_/D _15210_/RESET_B VDD VSS sg13g2_dfrbpq_1
XFILLER_12_1207 VDD VSS sg13g2_decap_8
X_12353_ _12353_/X _12345_/X _12350_/X _12344_/X _12349_/X _12371_/S _12369_/S0 VDD
+ VSS sg13g2_mux4_1
X_15141_ _15141_/Q clkload26/A _15141_/D _15141_/RESET_B VDD VSS sg13g2_dfrbpq_1
Xmax_cap1549 _16876_/A _13714_/Q VDD VSS sg13g2_buf_4
X_11304_ _11304_/Y _11310_/A1 _14621_/Q VDD VSS sg13g2_nand2b_1
X_15072_ _15072_/Q clkload70/A _15072_/D _15072_/RESET_B VDD VSS sg13g2_dfrbpq_1
XFILLER_142_918 VDD VSS sg13g2_decap_8
X_12284_ _12284_/X _14713_/Q _14745_/Q _13785_/Q _13817_/Q _12288_/S0 _12288_/S1 VDD
+ VSS sg13g2_mux4_1
XFILLER_154_789 VDD VSS sg13g2_fill_2
XFILLER_153_266 VDD VSS sg13g2_decap_8
XFILLER_4_254 VDD VSS sg13g2_decap_8
X_15210__3363 _15210_/RESET_B VDD VSS sg13g2_tiehi
X_14023_ _14023_/Q clkload5/A _14023_/D _14023_/RESET_B VDD VSS sg13g2_dfrbpq_1
XFILLER_20_70 VDD VSS sg13g2_decap_8
X_11235_ _11235_/X _11232_/Y _11233_/Y _15217_/Q VDD VSS sg13g2_a21o_1
XFILLER_136_1111 VDD VSS sg13g2_fill_2
X_13757__2807 _13757_/RESET_B VDD VSS sg13g2_tiehi
XFILLER_45_1016 VDD VSS sg13g2_decap_8
XFILLER_136_70 VDD VSS sg13g2_decap_8
XFILLER_136_1144 VDD VSS sg13g2_decap_4
XFILLER_136_81 VDD VSS sg13g2_fill_2
X_11166_ _11166_/Y _11162_/Y _11165_/X _11109_/B VDD VSS sg13g2_o21ai_1
XFILLER_68_729 VDD VSS sg13g2_fill_1
XFILLER_95_526 VDD VSS sg13g2_decap_4
X_10117_ _14695_/D _10117_/A0 _14695_/Q _10129_/S VDD VSS sg13g2_mux2_1
XFILLER_110_848 VDD VSS sg13g2_decap_8
X_11097_ _11097_/Y _11097_/A _11115_/A _11097_/C VDD VSS sg13g2_nor3_1
XFILLER_49_965 VDD VSS sg13g2_fill_2
X_10048_ _14629_/D _10081_/A0 _14629_/Q _10062_/S VDD VSS sg13g2_mux2_1
X_14925_ _14925_/Q clkload35/A _14925_/D _14925_/RESET_B VDD VSS sg13g2_dfrbpq_1
XFILLER_29_90 VDD VSS sg13g2_fill_1
XFILLER_82_209 VDD VSS sg13g2_fill_2
X_14137__2427 _14137_/RESET_B VDD VSS sg13g2_tiehi
XFILLER_152_91 VDD VSS sg13g2_decap_8
XFILLER_64_957 VDD VSS sg13g2_decap_4
XFILLER_90_220 VDD VSS sg13g2_decap_8
X_14856_ _14856_/Q _14873_/CLK _14856_/D _14856_/RESET_B VDD VSS sg13g2_dfrbpq_1
XFILLER_1_1132 VDD VSS sg13g2_decap_8
XFILLER_90_231 VDD VSS sg13g2_fill_1
XFILLER_21_1082 VDD VSS sg13g2_decap_8
XFILLER_63_467 VDD VSS sg13g2_fill_1
X_13807_ _13807_/Q clkload14/A _13807_/D _13807_/RESET_B VDD VSS sg13g2_dfrbpq_1
X_14787_ _14787_/Q clkload82/A _14787_/D _14787_/RESET_B VDD VSS sg13g2_dfrbpq_1
XFILLER_91_798 VDD VSS sg13g2_decap_4
XFILLER_56_1123 VDD VSS sg13g2_decap_8
X_11999_ _12000_/B _11997_/X _11996_/X _11991_/X _11990_/X _11953_/C _11424_/B VDD
+ VSS sg13g2_mux4_1
XFILLER_1_1198 VDD VSS sg13g2_decap_8
XFILLER_32_843 VDD VSS sg13g2_decap_8
X_13738_ _13738_/Q clkload21/A _13738_/D _13738_/RESET_B VDD VSS sg13g2_dfrbpq_1
XFILLER_108_1213 VDD VSS sg13g2_decap_8
XFILLER_149_517 VDD VSS sg13g2_fill_2
X_14352__2212 _14352_/RESET_B VDD VSS sg13g2_tiehi
XFILLER_143_1148 VDD VSS sg13g2_fill_2
X_13669_ _13669_/Q _15214_/CLK _13669_/D _13669_/RESET_B VDD VSS sg13g2_dfrbpq_1
XFILLER_129_252 VDD VSS sg13g2_decap_4
XFILLER_8_560 VDD VSS sg13g2_fill_2
XFILLER_118_937 VDD VSS sg13g2_decap_8
Xclkbuf_leaf_94_clk_i clkload26/A clkbuf_leaf_99_clk_i/A VDD VSS sg13g2_buf_8
X_14385__2179 _14385_/RESET_B VDD VSS sg13g2_tiehi
X_09900_ _14486_/D _09900_/A0 _14486_/Q _09900_/S VDD VSS sg13g2_mux2_1
XFILLER_104_119 VDD VSS sg13g2_decap_8
XFILLER_99_832 VDD VSS sg13g2_decap_8
XFILLER_154_1211 VDD VSS sg13g2_decap_8
Xfanout506 _09273_/S _09264_/S VDD VSS sg13g2_buf_1
XFILLER_28_1236 VDD VSS sg13g2_fill_1
X_09831_ _14419_/D _09930_/A1 _14419_/Q _09831_/S VDD VSS sg13g2_mux2_1
Xfanout517 _09193_/S _09190_/S VDD VSS sg13g2_buf_1
Xfanout528 _09649_/A0 _09880_/A0 VDD VSS sg13g2_buf_1
Xfanout539 _09908_/A1 fanout542/X VDD VSS sg13g2_buf_1
XFILLER_86_515 VDD VSS sg13g2_decap_4
XFILLER_98_375 VDD VSS sg13g2_decap_8
XFILLER_141_995 VDD VSS sg13g2_decap_8
Xclkbuf_5_12__f_clk_i clkbuf_5_12__f_clk_i/X clkbuf_4_6_0_clk_i/X VDD VSS sg13g2_buf_16
XFILLER_6_1021 VDD VSS sg13g2_decap_4
X_09762_ _14352_/D _14352_/Q _09927_/A1 _09772_/S VDD VSS sg13g2_mux2_1
XFILLER_112_196 VDD VSS sg13g2_decap_8
XFILLER_6_1054 VDD VSS sg13g2_decap_8
X_08713_ _15189_/D input16/X _15189_/Q _13340_/S VDD VSS sg13g2_mux2_1
X_09693_ _14285_/D _09693_/A0 _14285_/Q _09706_/S VDD VSS sg13g2_mux2_1
XFILLER_132_28 VDD VSS sg13g2_decap_8
XFILLER_27_604 VDD VSS sg13g2_decap_8
Xclkbuf_leaf_32_clk_i _14737_/CLK clkbuf_leaf_34_clk_i/A VDD VSS sg13g2_buf_8
X_08644_ _08646_/C _15016_/Q _08012_/B _07855_/B VDD VSS sg13g2_o21ai_1
XFILLER_66_294 VDD VSS sg13g2_fill_2
XFILLER_82_765 VDD VSS sg13g2_decap_8
X_08575_ _08575_/Y _08575_/A wire365/X _08575_/C VDD VSS sg13g2_nor3_1
XFILLER_26_169 VDD VSS sg13g2_decap_8
XFILLER_23_810 VDD VSS sg13g2_decap_8
XFILLER_74_1223 VDD VSS sg13g2_decap_8
Xclkbuf_leaf_47_clk_i clkload58/A clkbuf_leaf_60_clk_i/A VDD VSS sg13g2_buf_8
XFILLER_35_1229 VDD VSS sg13g2_decap_8
XFILLER_50_662 VDD VSS sg13g2_decap_8
XFILLER_23_898 VDD VSS sg13g2_decap_8
X_13835__2729 _13835_/RESET_B VDD VSS sg13g2_tiehi
X_14595__1969 _14595_/RESET_B VDD VSS sg13g2_tiehi
XFILLER_41_14 VDD VSS sg13g2_decap_8
XFILLER_22_397 VDD VSS sg13g2_decap_8
XFILLER_124_1070 VDD VSS sg13g2_decap_4
XFILLER_148_572 VDD VSS sg13g2_decap_4
XFILLER_136_712 VDD VSS sg13g2_fill_1
X_09127_ _13780_/D _13780_/Q _10163_/A1 _09127_/S VDD VSS sg13g2_mux2_1
XFILLER_136_734 VDD VSS sg13g2_fill_1
XFILLER_68_1005 VDD VSS sg13g2_fill_2
XFILLER_124_907 VDD VSS sg13g2_decap_8
X_09058_ _09058_/Y _09158_/A _10725_/B _09057_/X VDD VSS sg13g2_o21ai_1
XFILLER_68_1038 VDD VSS sg13g2_decap_4
X_14215__2349 _14215_/RESET_B VDD VSS sg13g2_tiehi
X_08009_ _08009_/X _08673_/B _08048_/B _08046_/B VDD VSS sg13g2_mux2_1
XFILLER_150_247 VDD VSS sg13g2_decap_8
XFILLER_89_331 VDD VSS sg13g2_decap_8
XFILLER_104_642 VDD VSS sg13g2_decap_4
X_11020_ _14942_/D _11019_/Y _11018_/Y _11001_/Y VDD VSS sg13g2_o21ai_1
XFILLER_132_962 VDD VSS sg13g2_decap_8
XFILLER_1_268 VDD VSS sg13g2_decap_8
XFILLER_1_279 VDD VSS sg13g2_decap_8
XFILLER_77_537 VDD VSS sg13g2_decap_8
XFILLER_89_397 VDD VSS sg13g2_fill_2
XFILLER_103_185 VDD VSS sg13g2_decap_8
XFILLER_58_740 VDD VSS sg13g2_decap_8
X_14430__2134 _14430_/RESET_B VDD VSS sg13g2_tiehi
XFILLER_92_507 VDD VSS sg13g2_decap_8
XFILLER_58_773 VDD VSS sg13g2_fill_2
X_12971_ _15031_/D _12962_/Y _12970_/Y _12984_/A VDD VSS sg13g2_a21oi_1
XFILLER_100_870 VDD VSS sg13g2_decap_8
X_14710_ _14710_/Q _14710_/CLK _14710_/D _14710_/RESET_B VDD VSS sg13g2_dfrbpq_1
X_11922_ _11922_/X _14255_/Q _14287_/Q _14319_/Q _14351_/Q _11922_/S0 _12072_/S1 VDD
+ VSS sg13g2_mux4_1
XFILLER_57_294 VDD VSS sg13g2_decap_8
XFILLER_61_905 VDD VSS sg13g2_fill_2
XFILLER_122_72 VDD VSS sg13g2_decap_8
X_14641_ _14641_/Q clkload44/A _14641_/D _14641_/RESET_B VDD VSS sg13g2_dfrbpq_1
X_11853_ _11853_/X _14381_/Q _14413_/Q _14477_/Q _14509_/Q _11995_/S0 _11995_/S1 VDD
+ VSS sg13g2_mux4_1
XFILLER_60_415 VDD VSS sg13g2_decap_8
X_10804_ _10804_/Y _10805_/B _10805_/C _15121_/Q VDD VSS sg13g2_o21ai_1
XFILLER_60_448 VDD VSS sg13g2_decap_8
X_11784_ _11784_/X _13739_/Q _14091_/Q _14443_/Q _14539_/Q _12286_/S0 _12286_/S1 VDD
+ VSS sg13g2_mux4_1
X_14572_ _14572_/Q clkload51/A _14572_/D _14572_/RESET_B VDD VSS sg13g2_dfrbpq_1
XFILLER_15_70 VDD VSS sg13g2_decap_8
X_13523_ _13523_/Y _15141_/Q _13560_/S VDD VSS sg13g2_nor2_1
X_10735_ _10735_/Y _10735_/A _10735_/B VDD VSS sg13g2_nor2_1
X_10666_ _10667_/C _14894_/Q _14893_/Q _14892_/Q _10666_/D VDD VSS sg13g2_and4_1
X_13454_ _13455_/D _15169_/Q _15170_/Q _13454_/C _13454_/D VDD VSS sg13g2_nand4_1
XFILLER_9_368 VDD VSS sg13g2_decap_8
XFILLER_16_1184 VDD VSS sg13g2_decap_8
XFILLER_139_583 VDD VSS sg13g2_fill_1
X_12405_ _12405_/X _13951_/Q _13983_/Q _14015_/Q _14047_/Q _12659_/S0 _12659_/S1 VDD
+ VSS sg13g2_mux4_1
X_13385_ _15081_/D _13435_/A _13378_/C _13384_/Y VDD VSS sg13g2_o21ai_1
XFILLER_154_531 VDD VSS sg13g2_fill_2
X_10597_ _10610_/D _14876_/Q _14875_/Q _14874_/Q _10597_/D VDD VSS sg13g2_and4_1
XFILLER_126_222 VDD VSS sg13g2_decap_8
X_15124_ _15124_/Q _15212_/CLK _15124_/D _15124_/RESET_B VDD VSS sg13g2_dfrbpq_1
Xoutput109 mem_axi_wdata[14] _15146_/Q VDD VSS sg13g2_buf_1
X_12336_ _12336_/Y _12331_/X _12291_/A _12336_/B1 VDD VSS sg13g2_a21oi_1
XFILLER_56_7 VDD VSS sg13g2_decap_8
XFILLER_108_992 VDD VSS sg13g2_decap_8
X_12267_ _12267_/Y _14923_/Q _12267_/A2 _12263_/Y _12266_/Y VDD VSS sg13g2_a22oi_1
X_15055_ _15055_/Q _15209_/CLK _15055_/D _15055_/RESET_B VDD VSS sg13g2_dfrbpq_1
X_14640__1924 _14640_/RESET_B VDD VSS sg13g2_tiehi
X_14967__3005 _14967_/RESET_B VDD VSS sg13g2_tiehi
XFILLER_141_247 VDD VSS sg13g2_fill_1
X_11218_ _11218_/X _14619_/Q _14651_/Q _11277_/S VDD VSS sg13g2_mux2_1
X_14006_ _14006_/Q _14710_/CLK _14006_/D _14006_/RESET_B VDD VSS sg13g2_dfrbpq_1
X_12198_ _12200_/B _12198_/A _12198_/B _12198_/C _12198_/D VDD VSS sg13g2_nor4_1
XFILLER_96_813 VDD VSS sg13g2_decap_8
Xoutput80 mem_axi_awaddr[19] _16872_/X VDD VSS sg13g2_buf_1
XFILLER_96_824 VDD VSS sg13g2_fill_1
Xoutput91 mem_axi_awaddr[2] _16855_/X VDD VSS sg13g2_buf_1
XFILLER_96_846 VDD VSS sg13g2_decap_8
XFILLER_110_623 VDD VSS sg13g2_decap_8
X_11149_ _11151_/B _11150_/B _11150_/A VDD VSS sg13g2_nor2_1
XFILLER_1_791 VDD VSS sg13g2_decap_8
XFILLER_49_740 VDD VSS sg13g2_fill_1
XFILLER_23_1133 VDD VSS sg13g2_decap_8
XFILLER_37_902 VDD VSS sg13g2_fill_1
XFILLER_3_1216 VDD VSS sg13g2_decap_8
X_14908_ _14908_/Q clkload35/A _14908_/D _14908_/RESET_B VDD VSS sg13g2_dfrbpq_1
XFILLER_97_1234 VDD VSS sg13g2_fill_2
XFILLER_64_743 VDD VSS sg13g2_fill_2
XFILLER_37_968 VDD VSS sg13g2_fill_1
XFILLER_91_540 VDD VSS sg13g2_fill_2
X_14839_ _14839_/Q clkload81/A _14839_/D _14839_/RESET_B VDD VSS sg13g2_dfrbpq_1
XFILLER_36_478 VDD VSS sg13g2_decap_8
XFILLER_91_573 VDD VSS sg13g2_decap_8
XFILLER_36_489 VDD VSS sg13g2_decap_8
XFILLER_17_670 VDD VSS sg13g2_fill_2
X_08360_ _08360_/Y _08244_/B _08198_/X _08397_/A VDD VSS sg13g2_o21ai_1
XFILLER_149_303 VDD VSS sg13g2_decap_8
X_08291_ _08291_/Y _08290_/X _07778_/X _08395_/A VDD VSS sg13g2_a21oi_1
XFILLER_60_982 VDD VSS sg13g2_fill_1
XFILLER_31_150 VDD VSS sg13g2_fill_1
XFILLER_32_695 VDD VSS sg13g2_fill_2
XFILLER_82_0 VDD VSS sg13g2_decap_8
XFILLER_149_358 VDD VSS sg13g2_decap_4
XFILLER_31_183 VDD VSS sg13g2_decap_8
XFILLER_30_1104 VDD VSS sg13g2_decap_8
XFILLER_121_1221 VDD VSS sg13g2_decap_8
XFILLER_11_28 VDD VSS sg13g2_decap_8
X_14928__3073 _14928_/RESET_B VDD VSS sg13g2_tiehi
XFILLER_127_28 VDD VSS sg13g2_decap_8
XFILLER_117_288 VDD VSS sg13g2_decap_8
XFILLER_133_759 VDD VSS sg13g2_fill_1
XFILLER_132_247 VDD VSS sg13g2_decap_4
XFILLER_28_1033 VDD VSS sg13g2_fill_1
XFILLER_99_673 VDD VSS sg13g2_decap_8
XFILLER_114_973 VDD VSS sg13g2_decap_8
XFILLER_99_684 VDD VSS sg13g2_fill_2
Xfanout336 wire337/A _09573_/X VDD VSS sg13g2_buf_1
XFILLER_28_1066 VDD VSS sg13g2_decap_8
XFILLER_101_623 VDD VSS sg13g2_decap_8
X_09814_ _14402_/D _09880_/A0 _14402_/Q _09834_/S VDD VSS sg13g2_mux2_1
Xfanout347 _10081_/A0 _10115_/A0 VDD VSS sg13g2_buf_1
XFILLER_154_1085 VDD VSS sg13g2_decap_8
Xfanout358 _09747_/A1 _10144_/A1 VDD VSS sg13g2_buf_1
XFILLER_98_194 VDD VSS sg13g2_decap_8
XFILLER_143_49 VDD VSS sg13g2_decap_8
XFILLER_100_122 VDD VSS sg13g2_decap_8
X_09745_ _14335_/D _14335_/Q _09877_/A0 wire444/A VDD VSS sg13g2_mux2_1
XFILLER_28_924 VDD VSS sg13g2_decap_8
XFILLER_101_689 VDD VSS sg13g2_decap_8
XFILLER_67_570 VDD VSS sg13g2_fill_2
XFILLER_36_14 VDD VSS sg13g2_decap_8
XFILLER_55_721 VDD VSS sg13g2_decap_8
XFILLER_67_581 VDD VSS sg13g2_decap_4
X_09676_ _14268_/D _09907_/A1 _14268_/Q _09694_/S VDD VSS sg13g2_mux2_1
XFILLER_54_220 VDD VSS sg13g2_fill_1
XFILLER_54_253 VDD VSS sg13g2_decap_4
X_08627_ _08627_/Y _15015_/Q _07853_/B _08584_/A VDD VSS sg13g2_a21oi_1
XFILLER_43_938 VDD VSS sg13g2_decap_4
X_08558_ _08581_/C _08201_/A _08243_/Y _08557_/Y VDD VSS sg13g2_o21ai_1
XFILLER_74_1042 VDD VSS sg13g2_decap_8
XFILLER_23_662 VDD VSS sg13g2_decap_8
XFILLER_39_1184 VDD VSS sg13g2_decap_8
XFILLER_39_1195 VDD VSS sg13g2_fill_1
X_08489_ _08489_/Y _08560_/B _08406_/A _08621_/A VDD VSS sg13g2_a21oi_1
XFILLER_156_807 VDD VSS sg13g2_fill_1
X_10520_ _10522_/B _14855_/Q _10579_/B _14856_/Q VDD VSS sg13g2_a21oi_1
XFILLER_10_334 VDD VSS sg13g2_fill_1
XFILLER_11_879 VDD VSS sg13g2_decap_4
X_10451_ _10462_/D _14840_/Q _14839_/Q _10521_/C wire760/X VDD VSS sg13g2_and4_1
XFILLER_136_520 VDD VSS sg13g2_decap_4
XFILLER_6_327 VDD VSS sg13g2_fill_1
XFILLER_6_349 VDD VSS sg13g2_decap_8
X_14448__2116 _14448_/RESET_B VDD VSS sg13g2_tiehi
X_13170_ _13172_/D _13170_/A _13170_/B _13170_/C _13170_/D VDD VSS sg13g2_nor4_1
X_10382_ _14818_/D _10378_/D _10380_/X _10381_/Y VDD VSS sg13g2_a21oi_1
XFILLER_123_203 VDD VSS sg13g2_decap_8
XFILLER_11_1070 VDD VSS sg13g2_decap_8
X_12121_ _12121_/Y _12119_/Y _12120_/Y _11477_/A VDD VSS sg13g2_a21oi_1
XFILLER_108_288 VDD VSS sg13g2_decap_4
XFILLER_2_522 VDD VSS sg13g2_decap_8
XFILLER_105_951 VDD VSS sg13g2_decap_4
XFILLER_46_1122 VDD VSS sg13g2_decap_4
X_12052_ _12053_/B _12011_/X _12013_/Y _12051_/Y VDD VSS sg13g2_a21oi_1
XFILLER_77_21 VDD VSS sg13g2_decap_8
X_11003_ _11064_/A _15117_/Q _11042_/D VDD VSS sg13g2_xor2_1
XFILLER_104_483 VDD VSS sg13g2_decap_8
X_16860_ _16860_/X _16860_/A VDD VSS sg13g2_buf_1
XFILLER_120_943 VDD VSS sg13g2_fill_1
XFILLER_120_954 VDD VSS sg13g2_fill_1
XFILLER_120_965 VDD VSS sg13g2_decap_8
XFILLER_131_291 VDD VSS sg13g2_decap_8
Xfanout870 _08955_/S _08945_/A2 VDD VSS sg13g2_buf_1
Xfanout881 _13490_/B _08724_/Y VDD VSS sg13g2_buf_1
Xfanout892 _08541_/A fanout894/X VDD VSS sg13g2_buf_1
XFILLER_133_60 VDD VSS sg13g2_decap_8
XFILLER_19_946 VDD VSS sg13g2_decap_8
XFILLER_92_337 VDD VSS sg13g2_decap_8
X_12954_ _12954_/Y _12953_/Y _13035_/A2 _12950_/Y VDD VSS sg13g2_a21oi_1
XFILLER_18_456 VDD VSS sg13g2_decap_4
XFILLER_73_551 VDD VSS sg13g2_decap_8
X_14054__2510 _14054_/RESET_B VDD VSS sg13g2_tiehi
X_11905_ _11905_/Y _11904_/X _12301_/B1 _12271_/A VDD VSS sg13g2_a21oi_1
XFILLER_45_264 VDD VSS sg13g2_fill_1
XFILLER_46_798 VDD VSS sg13g2_fill_2
XFILLER_73_584 VDD VSS sg13g2_decap_8
X_12885_ _12885_/Y input31/X _12841_/B _12803_/X input8/X _12883_/X VDD VSS sg13g2_a221oi_1
XFILLER_45_286 VDD VSS sg13g2_fill_2
X_14624_ _14624_/Q _14710_/CLK _14624_/D _14624_/RESET_B VDD VSS sg13g2_dfrbpq_1
X_11836_ _11836_/Y _14911_/Q _11792_/B _11832_/Y _11835_/Y VDD VSS sg13g2_a22oi_1
XFILLER_26_91 VDD VSS sg13g2_decap_8
XFILLER_14_640 VDD VSS sg13g2_decap_8
XFILLER_61_779 VDD VSS sg13g2_decap_8
X_14658__1906 _14658_/RESET_B VDD VSS sg13g2_tiehi
X_14555_ _14555_/Q clkload75/A _14555_/D _14555_/RESET_B VDD VSS sg13g2_dfrbpq_1
X_11767_ _11767_/X _14909_/Q _12267_/A2 wire270/X VDD VSS sg13g2_a21o_1
XFILLER_13_161 VDD VSS sg13g2_decap_4
XFILLER_92_1197 VDD VSS sg13g2_decap_8
X_13506_ _13507_/C _13506_/A _07721_/B VDD VSS sg13g2_nor2b_1
XFILLER_140_1118 VDD VSS sg13g2_decap_8
X_10718_ _10718_/Y _14907_/Q _10973_/B VDD VSS sg13g2_nand2_1
X_14486_ _14486_/Q clkload24/A _14486_/D _14486_/RESET_B VDD VSS sg13g2_dfrbpq_1
X_11698_ _11698_/Y _11698_/A _12263_/C VDD VSS sg13g2_nor2b_1
X_14087__2477 _14087_/RESET_B VDD VSS sg13g2_tiehi
XFILLER_146_339 VDD VSS sg13g2_decap_4
XFILLER_9_187 VDD VSS sg13g2_decap_8
X_13437_ _13437_/Y _13440_/A _13440_/B _15101_/Q VDD VSS sg13g2_nand3_1
X_10649_ _10652_/B _14874_/Q _14873_/Q _14872_/Q _14871_/Q VDD VSS sg13g2_nand4_1
Xmax_cap1165 _12508_/S0 _12424_/S0 VDD VSS sg13g2_buf_4
Xmax_cap1176 _12535_/S0 _12536_/S0 VDD VSS sg13g2_buf_4
X_13368_ _15075_/D _13374_/A1 _13367_/Y _13366_/Y VDD VSS sg13g2_o21ai_1
Xmax_cap1187 _12578_/S0 _12771_/S0 VDD VSS sg13g2_buf_2
XFILLER_154_361 VDD VSS sg13g2_fill_2
Xmax_cap1198 _12603_/S0 _12604_/S0 VDD VSS sg13g2_buf_4
X_15026__2946 _15026_/RESET_B VDD VSS sg13g2_tiehi
X_15107_ _15107_/Q clkload80/A _15107_/D _15107_/RESET_B VDD VSS sg13g2_dfrbpq_1
X_12319_ _12319_/Y _12328_/A1 _14426_/Q _12319_/B1 VDD VSS sg13g2_a21oi_1
XFILLER_5_393 VDD VSS sg13g2_decap_8
X_13299_ _13299_/Y _07988_/D _13298_/X _13297_/X VDD VSS sg13g2_a21oi_1
Xhold3409 hold3409/X input5/X VDD VSS sg13g2_dlygate4sd3_1
XFILLER_114_258 VDD VSS sg13g2_fill_1
X_15038_ _15038_/Q clkload65/A _15038_/D _15038_/RESET_B VDD VSS sg13g2_dfrbpq_1
XFILLER_69_824 VDD VSS sg13g2_decap_8
XFILLER_111_910 VDD VSS sg13g2_decap_8
XFILLER_151_1203 VDD VSS sg13g2_decap_8
XFILLER_96_621 VDD VSS sg13g2_decap_8
XFILLER_25_1228 VDD VSS sg13g2_decap_8
X_07860_ _08608_/A _15013_/Q _07861_/B VDD VSS sg13g2_nor2_1
XFILLER_111_954 VDD VSS sg13g2_decap_8
XFILLER_60_1119 VDD VSS sg13g2_fill_1
XFILLER_3_84 VDD VSS sg13g2_decap_8
XFILLER_56_507 VDD VSS sg13g2_decap_8
XFILLER_110_453 VDD VSS sg13g2_decap_4
XFILLER_95_153 VDD VSS sg13g2_decap_8
X_07791_ _08415_/A _08391_/B _08412_/A VDD VSS sg13g2_nor2b_1
XFILLER_96_687 VDD VSS sg13g2_decap_8
XFILLER_111_998 VDD VSS sg13g2_fill_1
XFILLER_37_710 VDD VSS sg13g2_decap_8
XFILLER_49_570 VDD VSS sg13g2_fill_1
XFILLER_3_1013 VDD VSS sg13g2_decap_8
XFILLER_83_337 VDD VSS sg13g2_decap_8
X_09530_ _14129_/D _10093_/A0 _14129_/Q _09539_/S VDD VSS sg13g2_mux2_1
XFILLER_37_743 VDD VSS sg13g2_decap_8
XFILLER_149_1110 VDD VSS sg13g2_fill_1
X_09461_ _14062_/D _09892_/A0 _14062_/Q wire671/X VDD VSS sg13g2_mux2_1
XFILLER_58_1015 VDD VSS sg13g2_fill_2
XFILLER_25_927 VDD VSS sg13g2_fill_1
XFILLER_52_713 VDD VSS sg13g2_fill_1
XFILLER_64_584 VDD VSS sg13g2_decap_8
X_14526__2038 _14526_/RESET_B VDD VSS sg13g2_tiehi
X_08412_ _08412_/Y _08412_/A _08412_/B VDD VSS sg13g2_nor2_1
XFILLER_145_1018 VDD VSS sg13g2_decap_8
X_09392_ _13995_/D _10021_/A0 _13995_/Q _09406_/S VDD VSS sg13g2_mux2_1
X_08343_ _08346_/C _08306_/A _07784_/B _08565_/A2 _07796_/A VDD VSS sg13g2_a22oi_1
X_14816__3282 _14816_/RESET_B VDD VSS sg13g2_tiehi
X_08274_ _08275_/A _08276_/A _08276_/B VDD VSS sg13g2_nand2_1
XFILLER_34_1070 VDD VSS sg13g2_fill_2
XFILLER_22_49 VDD VSS sg13g2_decap_8
X_13752__2812 _13752_/RESET_B VDD VSS sg13g2_tiehi
X_15135__3072 _15135_/RESET_B VDD VSS sg13g2_tiehi
XFILLER_138_49 VDD VSS sg13g2_decap_8
XFILLER_121_1062 VDD VSS sg13g2_fill_2
XFILLER_146_884 VDD VSS sg13g2_decap_8
XFILLER_133_545 VDD VSS sg13g2_fill_1
XFILLER_117_1109 VDD VSS sg13g2_fill_1
X_14132__2432 _14132_/RESET_B VDD VSS sg13g2_tiehi
XFILLER_133_589 VDD VSS sg13g2_decap_4
X_13785__2779 _13785_/RESET_B VDD VSS sg13g2_tiehi
Xfanout1109 _12745_/S1 _12703_/S1 VDD VSS sg13g2_buf_1
XFILLER_101_420 VDD VSS sg13g2_decap_8
XFILLER_102_943 VDD VSS sg13g2_fill_2
XFILLER_101_431 VDD VSS sg13g2_fill_1
XFILLER_86_131 VDD VSS sg13g2_decap_8
Xfanout155 _10101_/A0 wire158/X VDD VSS sg13g2_buf_1
XFILLER_101_442 VDD VSS sg13g2_decap_8
XFILLER_102_965 VDD VSS sg13g2_decap_8
Xfanout166 _10166_/A1 _10099_/A0 VDD VSS sg13g2_buf_1
XFILLER_102_976 VDD VSS sg13g2_fill_2
X_14736__1828 _14736_/RESET_B VDD VSS sg13g2_tiehi
Xfanout177 _09898_/A0 _10096_/A0 VDD VSS sg13g2_buf_1
XFILLER_101_453 VDD VSS sg13g2_fill_1
XFILLER_47_35 VDD VSS sg13g2_decap_4
Xfanout188 _10161_/A1 _09698_/A0 VDD VSS sg13g2_buf_1
XFILLER_74_315 VDD VSS sg13g2_decap_4
Xfanout199 _09992_/A0 _10091_/A0 VDD VSS sg13g2_buf_1
XFILLER_87_698 VDD VSS sg13g2_decap_8
X_07989_ _07989_/Y _10172_/C _10177_/A _13283_/A VDD VSS sg13g2_nand3_1
X_09728_ _14319_/D _09926_/A1 _14319_/Q _09739_/S VDD VSS sg13g2_mux2_1
XFILLER_28_754 VDD VSS sg13g2_fill_2
XFILLER_27_231 VDD VSS sg13g2_decap_8
X_14165__2399 _14165_/RESET_B VDD VSS sg13g2_tiehi
X_09659_ _14252_/D _09824_/A0 _14252_/Q _09673_/S VDD VSS sg13g2_mux2_1
XFILLER_103_74 VDD VSS sg13g2_fill_2
XFILLER_55_595 VDD VSS sg13g2_decap_4
XFILLER_70_521 VDD VSS sg13g2_fill_2
XFILLER_31_908 VDD VSS sg13g2_decap_8
XFILLER_43_768 VDD VSS sg13g2_fill_1
X_12670_ _12670_/X _13842_/Q _13874_/Q _13906_/Q _13938_/Q _12674_/S0 _12675_/S1 VDD
+ VSS sg13g2_mux4_1
XFILLER_31_919 VDD VSS sg13g2_fill_1
X_11621_ _11621_/X _14694_/Q _14726_/Q _13766_/Q _13798_/Q _11621_/S0 _12091_/C VDD
+ VSS sg13g2_mux4_1
X_14380__2184 _14380_/RESET_B VDD VSS sg13g2_tiehi
X_14340_ _14340_/Q _15001_/CLK _14340_/D _14340_/RESET_B VDD VSS sg13g2_dfrbpq_1
X_11552_ _11552_/Y _11553_/A1 _13892_/Q VDD VSS sg13g2_nand2b_1
X_10503_ _10507_/D _14854_/Q _14853_/Q VDD VSS sg13g2_and2_1
XFILLER_13_1132 VDD VSS sg13g2_decap_8
X_11483_ _11485_/A _11483_/A _13686_/Q VDD VSS sg13g2_xnor2_1
X_14271_ _14271_/Q _14509_/CLK _14271_/D _14271_/RESET_B VDD VSS sg13g2_dfrbpq_1
XFILLER_7_647 VDD VSS sg13g2_decap_8
XFILLER_155_147 VDD VSS sg13g2_decap_8
Xwire567 wire567/X wire567/A VDD VSS sg13g2_buf_2
XFILLER_155_158 VDD VSS sg13g2_decap_8
XFILLER_6_146 VDD VSS sg13g2_fill_1
X_13222_ wire207/A _13222_/A1 _13217_/X _13221_/Y VDD VSS sg13g2_a21oi_1
X_10434_ _10443_/D _14834_/Q _14833_/Q _10434_/C VDD VSS sg13g2_and3_1
XFILLER_137_873 VDD VSS sg13g2_decap_8
XFILLER_136_350 VDD VSS sg13g2_decap_4
XFILLER_6_157 VDD VSS sg13g2_fill_2
XFILLER_48_1206 VDD VSS sg13g2_decap_4
X_13153_ wire562/A _13150_/Y _13151_/Y _13152_/Y VDD VSS sg13g2_a21oi_1
X_10365_ _14813_/D _10365_/A _10365_/B _10496_/B VDD VSS sg13g2_and3_1
XFILLER_83_1119 VDD VSS sg13g2_decap_8
XFILLER_151_342 VDD VSS sg13g2_decap_4
X_12104_ _12104_/Y _12090_/A _14484_/Q VDD VSS sg13g2_nand2b_1
X_13084_ _13085_/C _13084_/A _13150_/B VDD VSS sg13g2_nand2_1
X_10296_ _10297_/C _14788_/Q _14789_/Q _14791_/Q _14792_/Q VDD VSS sg13g2_nand4_1
XFILLER_111_228 VDD VSS sg13g2_fill_2
Xfanout1610 _11580_/S1 fanout1617/X VDD VSS sg13g2_buf_1
X_12035_ _12036_/A _14258_/Q _14290_/Q _14322_/Q _14354_/Q _12040_/A1 _12026_/C VDD
+ VSS sg13g2_mux4_1
XFILLER_105_792 VDD VSS sg13g2_decap_8
XFILLER_137_1080 VDD VSS sg13g2_decap_8
Xfanout1621 _12207_/S1 fanout1634/X VDD VSS sg13g2_buf_1
XFILLER_120_740 VDD VSS sg13g2_decap_8
Xfanout1632 _11555_/S1 _12236_/C VDD VSS sg13g2_buf_1
XFILLER_144_70 VDD VSS sg13g2_decap_8
XFILLER_78_665 VDD VSS sg13g2_decap_8
Xfanout1643 _12038_/B1 fanout1650/X VDD VSS sg13g2_buf_1
Xfanout1654 _11890_/S1 _12319_/B1 VDD VSS sg13g2_buf_1
Xfanout1665 _11711_/S0 fanout1672/X VDD VSS sg13g2_buf_1
XFILLER_19_7 VDD VSS sg13g2_decap_8
Xfanout1687 _12100_/S0 fanout1688/X VDD VSS sg13g2_buf_1
Xfanout1698 _11670_/S0 _11695_/S0 VDD VSS sg13g2_buf_1
XFILLER_65_337 VDD VSS sg13g2_fill_1
XFILLER_77_197 VDD VSS sg13g2_decap_8
XFILLER_20_1114 VDD VSS sg13g2_decap_8
X_13986_ _13986_/Q clkload6/A _13986_/D _13986_/RESET_B VDD VSS sg13g2_dfrbpq_1
XFILLER_18_242 VDD VSS sg13g2_decap_8
X_13830__2734 _13830_/RESET_B VDD VSS sg13g2_tiehi
X_14590__1974 _14590_/RESET_B VDD VSS sg13g2_tiehi
X_12937_ _12937_/Y _12937_/A _12936_/Y VDD VSS sg13g2_nor2b_1
XFILLER_74_893 VDD VSS sg13g2_fill_1
XFILLER_18_286 VDD VSS sg13g2_fill_1
XFILLER_46_595 VDD VSS sg13g2_fill_2
XFILLER_18_297 VDD VSS sg13g2_decap_8
XFILLER_73_381 VDD VSS sg13g2_fill_2
X_12868_ _12868_/Y input30/X _12841_/B _12803_/X input7/X _12866_/X VDD VSS sg13g2_a221oi_1
XFILLER_57_1070 VDD VSS sg13g2_decap_8
X_14607_ _14607_/Q _14671_/CLK _14607_/D _14607_/RESET_B VDD VSS sg13g2_dfrbpq_1
X_11819_ _11819_/Y _12303_/S _14508_/Q _12304_/B VDD VSS sg13g2_a21oi_1
X_12799_ _12799_/X _12799_/A _12844_/C VDD VSS sg13g2_and2_1
XFILLER_144_1051 VDD VSS sg13g2_fill_1
X_14210__2354 _14210_/RESET_B VDD VSS sg13g2_tiehi
XFILLER_18_1065 VDD VSS sg13g2_decap_8
X_14538_ _14538_/Q clkload21/A _14538_/D _14538_/RESET_B VDD VSS sg13g2_dfrbpq_1
XFILLER_144_1073 VDD VSS sg13g2_fill_2
XFILLER_30_974 VDD VSS sg13g2_decap_8
XFILLER_105_1057 VDD VSS sg13g2_fill_2
XFILLER_146_125 VDD VSS sg13g2_fill_2
X_14469_ _14469_/Q clkload3/A _14469_/D _14469_/RESET_B VDD VSS sg13g2_dfrbpq_1
XFILLER_88_1008 VDD VSS sg13g2_decap_8
XFILLER_128_840 VDD VSS sg13g2_fill_1
XFILLER_128_851 VDD VSS sg13g2_fill_1
XFILLER_128_873 VDD VSS sg13g2_decap_8
XFILLER_143_810 VDD VSS sg13g2_decap_8
XFILLER_128_884 VDD VSS sg13g2_fill_1
XFILLER_143_821 VDD VSS sg13g2_fill_1
Xmax_cap845 _10459_/D _10512_/A VDD VSS sg13g2_buf_1
XFILLER_143_854 VDD VSS sg13g2_decap_8
XFILLER_89_908 VDD VSS sg13g2_fill_2
X_15123__3098 _15123_/RESET_B VDD VSS sg13g2_tiehi
XFILLER_45_0 VDD VSS sg13g2_decap_8
XFILLER_103_718 VDD VSS sg13g2_fill_1
X_08961_ _09641_/D _08966_/A _08959_/B _11082_/B1 VDD VSS sg13g2_o21ai_1
XFILLER_9_1211 VDD VSS sg13g2_decap_8
X_15249__2880 _15249_/RESET_B VDD VSS sg13g2_tiehi
XFILLER_130_526 VDD VSS sg13g2_decap_8
XFILLER_29_1172 VDD VSS sg13g2_decap_8
X_07912_ _07912_/Y _08429_/A _07912_/B VDD VSS sg13g2_nand2b_1
XFILLER_155_1191 VDD VSS sg13g2_decap_8
XFILLER_25_1025 VDD VSS sg13g2_decap_8
X_08892_ _13706_/D _13706_/Q _08891_/X _08892_/S VDD VSS sg13g2_mux2_1
XFILLER_97_963 VDD VSS sg13g2_fill_1
XFILLER_5_1108 VDD VSS sg13g2_decap_8
XFILLER_68_142 VDD VSS sg13g2_decap_8
XFILLER_116_1164 VDD VSS sg13g2_decap_8
X_07843_ _08678_/B _15017_/Q _07972_/B VDD VSS sg13g2_or2_1
XFILLER_56_315 VDD VSS sg13g2_fill_2
XFILLER_99_1126 VDD VSS sg13g2_fill_2
XFILLER_56_326 VDD VSS sg13g2_fill_1
XFILLER_68_197 VDD VSS sg13g2_decap_8
X_07774_ _08315_/B _07775_/A _08306_/B VDD VSS sg13g2_xnor2_1
XFILLER_37_551 VDD VSS sg13g2_fill_2
X_09513_ _14112_/D _09977_/A0 _14112_/Q _09536_/S VDD VSS sg13g2_mux2_1
XFILLER_17_49 VDD VSS sg13g2_decap_8
XFILLER_65_871 VDD VSS sg13g2_decap_8
XFILLER_140_28 VDD VSS sg13g2_decap_8
XFILLER_25_713 VDD VSS sg13g2_decap_8
XFILLER_65_882 VDD VSS sg13g2_fill_1
XFILLER_64_370 VDD VSS sg13g2_decap_8
X_09444_ _14045_/D _09609_/A0 _14045_/Q _09446_/S VDD VSS sg13g2_mux2_1
XFILLER_40_705 VDD VSS sg13g2_decap_8
X_09375_ _09375_/Y _09707_/B _09375_/B _09441_/D VDD VSS sg13g2_nand3_1
XFILLER_36_1154 VDD VSS sg13g2_decap_4
X_08326_ _08335_/B _08414_/B _08306_/A _07796_/B _08565_/A2 _08325_/Y VDD VSS sg13g2_a221oi_1
XFILLER_21_963 VDD VSS sg13g2_decap_8
XFILLER_138_626 VDD VSS sg13g2_decap_4
XFILLER_71_1067 VDD VSS sg13g2_decap_8
XFILLER_36_1187 VDD VSS sg13g2_decap_8
X_13673__2911 _13673_/RESET_B VDD VSS sg13g2_tiehi
X_14962__3010 _14962_/RESET_B VDD VSS sg13g2_tiehi
X_08257_ _08257_/Y _08045_/Y _08344_/A2 _08027_/Y VDD VSS sg13g2_a21oi_1
XFILLER_123_7 VDD VSS sg13g2_decap_8
X_08188_ _08188_/Y _08188_/A _08188_/B _08188_/C VDD VSS sg13g2_nor3_1
XFILLER_118_361 VDD VSS sg13g2_fill_2
XFILLER_3_105 VDD VSS sg13g2_decap_8
XFILLER_145_191 VDD VSS sg13g2_decap_4
X_10150_ _14727_/D _14727_/Q _10150_/A1 _10150_/S VDD VSS sg13g2_mux2_1
X_10081_ _14661_/D _10081_/A0 _14661_/Q _10083_/S VDD VSS sg13g2_mux2_1
XFILLER_88_952 VDD VSS sg13g2_fill_1
XFILLER_82_1163 VDD VSS sg13g2_decap_8
XFILLER_82_1174 VDD VSS sg13g2_fill_1
XFILLER_102_762 VDD VSS sg13g2_decap_8
XFILLER_43_1147 VDD VSS sg13g2_decap_8
XFILLER_102_773 VDD VSS sg13g2_fill_1
XFILLER_47_315 VDD VSS sg13g2_decap_4
X_14398__2166 _14398_/RESET_B VDD VSS sg13g2_tiehi
XFILLER_75_646 VDD VSS sg13g2_decap_8
X_13840_ _13840_/Q clkload42/A _13840_/D _13840_/RESET_B VDD VSS sg13g2_dfrbpq_1
XFILLER_74_33 VDD VSS sg13g2_fill_1
XFILLER_28_573 VDD VSS sg13g2_fill_1
X_13771_ _13771_/Q clkload44/A _13771_/D _13771_/RESET_B VDD VSS sg13g2_dfrbpq_1
X_10983_ _10984_/A _11099_/B2 _10982_/X _10969_/B VDD VSS sg13g2_o21ai_1
XFILLER_71_830 VDD VSS sg13g2_fill_2
XFILLER_15_223 VDD VSS sg13g2_decap_4
X_12722_ _15015_/D _12722_/A wire369/X VDD VSS sg13g2_nor2_1
XFILLER_128_1024 VDD VSS sg13g2_decap_8
XFILLER_43_565 VDD VSS sg13g2_fill_1
XFILLER_130_72 VDD VSS sg13g2_fill_1
X_12653_ _12666_/A _10671_/B _12779_/A2 hold3509/X VDD VSS sg13g2_a21oi_1
X_11604_ _11604_/Y _11597_/A _14630_/Q VDD VSS sg13g2_nand2b_1
XFILLER_15_1227 VDD VSS sg13g2_decap_8
X_12584_ _12597_/A _10671_/B _13293_/C _15006_/Q VDD VSS sg13g2_a21oi_1
XFILLER_23_70 VDD VSS sg13g2_decap_8
XFILLER_12_996 VDD VSS sg13g2_decap_8
X_14323_ _14323_/Q clkload10/A _14323_/D _14323_/RESET_B VDD VSS sg13g2_dfrbpq_1
X_11535_ _11535_/Y _11535_/A _11763_/B VDD VSS sg13g2_nand2_1
XFILLER_102_1219 VDD VSS sg13g2_decap_8
XFILLER_139_70 VDD VSS sg13g2_decap_8
XFILLER_116_309 VDD VSS sg13g2_decap_8
Xwire375 wire375/X wire375/A VDD VSS sg13g2_buf_2
X_14254_ _14254_/Q clkload57/A _14254_/D _14254_/RESET_B VDD VSS sg13g2_dfrbpq_1
X_11466_ _11466_/X _14113_/Q _14145_/Q _14177_/Q _14209_/Q _11466_/S0 _11693_/C VDD
+ VSS sg13g2_mux4_1
XFILLER_104_1090 VDD VSS sg13g2_fill_1
XFILLER_7_499 VDD VSS sg13g2_decap_8
X_13205_ _13205_/X input22/X _13264_/A2 _13264_/B1 VDD VSS sg13g2_a21o_1
XFILLER_48_1003 VDD VSS sg13g2_decap_8
X_10417_ _14828_/D _14828_/Q _10415_/A _10416_/Y VDD VSS sg13g2_a21oi_1
X_11397_ _11397_/Y _11852_/S0 _14559_/Q VDD VSS sg13g2_nand2b_1
X_14185_ _14185_/Q _14678_/CLK _14185_/D _14185_/RESET_B VDD VSS sg13g2_dfrbpq_1
XFILLER_98_705 VDD VSS sg13g2_decap_8
XFILLER_139_1153 VDD VSS sg13g2_decap_4
X_13848__2716 _13848_/RESET_B VDD VSS sg13g2_tiehi
XFILLER_98_716 VDD VSS sg13g2_fill_1
X_13136_ _13136_/X input17/X _13149_/A2 _13264_/B1 VDD VSS sg13g2_a21o_1
XFILLER_124_364 VDD VSS sg13g2_decap_8
X_10348_ _10350_/A _14809_/Q _10352_/C VDD VSS sg13g2_or2_1
XFILLER_135_1017 VDD VSS sg13g2_fill_1
XFILLER_124_386 VDD VSS sg13g2_fill_2
XFILLER_155_91 VDD VSS sg13g2_decap_8
X_10279_ _14787_/D _10468_/A _10279_/B _10311_/A VDD VSS sg13g2_nor3_1
X_13067_ _13067_/Y _13066_/Y _13160_/B _13067_/C VDD VSS sg13g2_nand3b_1
XFILLER_94_900 VDD VSS sg13g2_decap_8
XFILLER_61_1236 VDD VSS sg13g2_fill_1
Xfanout1440 _08471_/B _11865_/A VDD VSS sg13g2_buf_1
X_12018_ _12019_/B _12018_/A _12018_/B _12026_/C VDD VSS sg13g2_nand3_1
X_15091__3186 _15091_/RESET_B VDD VSS sg13g2_tiehi
XFILLER_39_838 VDD VSS sg13g2_fill_2
Xfanout1451 _11770_/A _14973_/Q VDD VSS sg13g2_buf_1
Xfanout1462 _08376_/A3 _11635_/A VDD VSS sg13g2_buf_1
XFILLER_65_101 VDD VSS sg13g2_decap_8
XFILLER_66_624 VDD VSS sg13g2_decap_8
Xfanout1473 _11502_/A _08300_/A3 VDD VSS sg13g2_buf_1
X_14228__2336 _14228_/RESET_B VDD VSS sg13g2_tiehi
XFILLER_94_944 VDD VSS sg13g2_fill_1
Xfanout1484 _07912_/B _11428_/A VDD VSS sg13g2_buf_1
Xfanout1495 _12825_/B _12900_/C VDD VSS sg13g2_buf_1
XFILLER_0_41 VDD VSS sg13g2_fill_2
XFILLER_4_1174 VDD VSS sg13g2_decap_8
XFILLER_47_871 VDD VSS sg13g2_fill_2
XFILLER_94_1001 VDD VSS sg13g2_fill_2
XFILLER_93_498 VDD VSS sg13g2_decap_8
X_13969_ _13969_/Q clkload44/A _13969_/D _13969_/RESET_B VDD VSS sg13g2_dfrbpq_1
XFILLER_0_63 VDD VSS sg13g2_decap_8
XFILLER_80_126 VDD VSS sg13g2_decap_8
XFILLER_0_74 VDD VSS sg13g2_fill_1
XFILLER_59_1143 VDD VSS sg13g2_fill_1
XFILLER_74_690 VDD VSS sg13g2_decap_8
XFILLER_94_1034 VDD VSS sg13g2_fill_2
XFILLER_59_1165 VDD VSS sg13g2_decap_8
XFILLER_146_1124 VDD VSS sg13g2_decap_8
XFILLER_22_705 VDD VSS sg13g2_decap_8
XFILLER_55_1018 VDD VSS sg13g2_decap_8
X_14443__2121 _14443_/RESET_B VDD VSS sg13g2_tiehi
XFILLER_62_896 VDD VSS sg13g2_fill_1
XFILLER_146_1168 VDD VSS sg13g2_fill_1
XFILLER_61_395 VDD VSS sg13g2_fill_1
X_09160_ _13785_/D _13785_/Q _09705_/A0 _09160_/S VDD VSS sg13g2_mux2_1
XFILLER_147_401 VDD VSS sg13g2_fill_1
XFILLER_147_412 VDD VSS sg13g2_decap_8
X_08111_ _08112_/A _08381_/A _08087_/X _08098_/Y _08104_/Y _08093_/Y VDD VSS sg13g2_a221oi_1
XFILLER_148_957 VDD VSS sg13g2_decap_8
X_09091_ _09091_/Y _09159_/A1 _09086_/Y _09090_/Y VDD VSS sg13g2_o21ai_1
XFILLER_147_467 VDD VSS sg13g2_decap_8
X_08042_ _08042_/X _07798_/B _07949_/C _07801_/B _07820_/B _08055_/S0 _08044_/S1 VDD
+ VSS sg13g2_mux4_1
XFILLER_147_478 VDD VSS sg13g2_fill_1
XFILLER_31_1051 VDD VSS sg13g2_decap_4
X_14476__2088 _14476_/RESET_B VDD VSS sg13g2_tiehi
Xmax_cap620 _09838_/S _09810_/S VDD VSS sg13g2_buf_4
Xmax_cap631 _09805_/S _09778_/S VDD VSS sg13g2_buf_4
XFILLER_115_342 VDD VSS sg13g2_fill_2
XFILLER_135_28 VDD VSS sg13g2_decap_8
XFILLER_89_738 VDD VSS sg13g2_decap_8
X_09993_ _14576_/D _10092_/A0 _14576_/Q _10002_/S VDD VSS sg13g2_mux2_1
XFILLER_130_301 VDD VSS sg13g2_fill_2
XFILLER_153_1128 VDD VSS sg13g2_decap_8
X_08944_ _08944_/Y _08942_/Y _08943_/Y _08945_/A2 VDD VSS sg13g2_a21oi_1
XFILLER_130_345 VDD VSS sg13g2_decap_8
XFILLER_131_879 VDD VSS sg13g2_decap_8
XFILLER_130_356 VDD VSS sg13g2_fill_1
XFILLER_9_1085 VDD VSS sg13g2_decap_8
XFILLER_56_101 VDD VSS sg13g2_fill_1
X_08875_ _08875_/X _08874_/X _11591_/A _08882_/S VDD VSS sg13g2_mux2_1
XFILLER_111_570 VDD VSS sg13g2_decap_8
XFILLER_56_112 VDD VSS sg13g2_decap_8
XFILLER_56_123 VDD VSS sg13g2_fill_2
X_14653__1911 _14653_/RESET_B VDD VSS sg13g2_tiehi
X_07826_ _07826_/X _15005_/Q _07946_/B VDD VSS sg13g2_and2_1
XFILLER_151_49 VDD VSS sg13g2_decap_8
XFILLER_42_1191 VDD VSS sg13g2_decap_4
XFILLER_84_476 VDD VSS sg13g2_decap_4
X_07757_ _07757_/Y _07751_/Y _13308_/B _13305_/B VDD VSS sg13g2_a21oi_1
XFILLER_44_14 VDD VSS sg13g2_decap_8
X_14082__2482 _14082_/RESET_B VDD VSS sg13g2_tiehi
X_07688_ _07696_/A _07697_/A _12997_/B VDD VSS sg13g2_nand2_1
XFILLER_44_58 VDD VSS sg13g2_fill_1
XFILLER_53_874 VDD VSS sg13g2_decap_8
XFILLER_25_576 VDD VSS sg13g2_fill_1
X_09427_ _14029_/D _09693_/A0 _14029_/Q _09431_/S VDD VSS sg13g2_mux2_1
XFILLER_80_693 VDD VSS sg13g2_decap_8
XFILLER_12_226 VDD VSS sg13g2_decap_8
X_13926__2638 _13926_/RESET_B VDD VSS sg13g2_tiehi
X_14686__1878 _14686_/RESET_B VDD VSS sg13g2_tiehi
X_09358_ _13962_/D _09789_/A0 _13962_/Q _09358_/S VDD VSS sg13g2_mux2_1
X_15021__2951 _15021_/RESET_B VDD VSS sg13g2_tiehi
XFILLER_138_412 VDD VSS sg13g2_fill_1
X_08309_ _08312_/B _08599_/A _08122_/Y _08308_/X VDD VSS sg13g2_a21oi_1
XFILLER_60_35 VDD VSS sg13g2_decap_8
XFILLER_100_97 VDD VSS sg13g2_decap_4
X_09289_ _13897_/D _13897_/Q _10152_/A1 _09303_/S VDD VSS sg13g2_mux2_1
XFILLER_153_404 VDD VSS sg13g2_decap_8
X_11320_ _11320_/X _14237_/Q _14269_/Q _14301_/Q _14333_/Q _11826_/A1 _11828_/S1 VDD
+ VSS sg13g2_mux4_1
XFILLER_154_938 VDD VSS sg13g2_decap_8
X_14306__2258 _14306_/RESET_B VDD VSS sg13g2_tiehi
X_11251_ _11251_/Y _11277_/S _14556_/Q VDD VSS sg13g2_nand2b_1
XFILLER_10_1157 VDD VSS sg13g2_decap_8
XFILLER_134_662 VDD VSS sg13g2_decap_8
X_10202_ _14758_/D _15182_/D _14758_/Q _13502_/A VDD VSS sg13g2_mux2_1
XFILLER_109_95 VDD VSS sg13g2_decap_8
XFILLER_134_673 VDD VSS sg13g2_fill_1
X_11182_ _11182_/Y _11181_/X _11151_/A _11179_/X _11177_/X _11192_/B1 VDD VSS sg13g2_a221oi_1
X_10133_ _14711_/D _10166_/A1 _14711_/Q _10133_/S VDD VSS sg13g2_mux2_1
X_14521__2043 _14521_/RESET_B VDD VSS sg13g2_tiehi
X_14941_ _14941_/Q clkload34/A _14941_/D _14941_/RESET_B VDD VSS sg13g2_dfrbpq_1
XFILLER_85_21 VDD VSS sg13g2_decap_8
X_10064_ _14645_/D _10064_/A0 _14645_/Q _10068_/S VDD VSS sg13g2_mux2_1
XFILLER_121_389 VDD VSS sg13g2_decap_4
XFILLER_47_123 VDD VSS sg13g2_decap_8
XFILLER_76_955 VDD VSS sg13g2_fill_2
X_14872_ _14872_/Q clkload78/A _14872_/D _14872_/RESET_B VDD VSS sg13g2_dfrbpq_1
XFILLER_76_988 VDD VSS sg13g2_decap_8
XFILLER_91_914 VDD VSS sg13g2_decap_8
X_14775__3323 _14775_/RESET_B VDD VSS sg13g2_tiehi
X_13823_ _13823_/Q clkload56/A _13823_/D _13823_/RESET_B VDD VSS sg13g2_dfrbpq_1
XFILLER_18_70 VDD VSS sg13g2_decap_8
XFILLER_29_893 VDD VSS sg13g2_decap_8
XFILLER_62_126 VDD VSS sg13g2_decap_4
XFILLER_16_543 VDD VSS sg13g2_decap_4
XFILLER_62_159 VDD VSS sg13g2_fill_2
X_13754_ _13754_/Q clkload58/A _13754_/D _13754_/RESET_B VDD VSS sg13g2_dfrbpq_1
X_10966_ _10966_/Y _10952_/Y _10967_/B _11099_/B2 VDD VSS sg13g2_a21oi_1
XFILLER_71_660 VDD VSS sg13g2_decap_8
X_12705_ _12705_/X _12703_/X _12702_/X _12697_/X _12696_/X _12705_/S0 _12762_/S VDD
+ VSS sg13g2_mux4_1
X_13685_ _13685_/Q clkload39/A _13685_/D _13685_/RESET_B VDD VSS sg13g2_dfrbpq_1
X_10897_ _10897_/Y wire584/X _10897_/B _10923_/A _10897_/D VDD VSS sg13g2_nor4_1
XFILLER_54_1051 VDD VSS sg13g2_fill_2
X_12636_ _12636_/X _12634_/X _12635_/X _12636_/S VDD VSS sg13g2_mux2_1
XFILLER_86_7 VDD VSS sg13g2_decap_8
XFILLER_141_1054 VDD VSS sg13g2_decap_8
X_12567_ _12567_/X _12566_/X _12565_/X _12567_/S VDD VSS sg13g2_mux2_1
XFILLER_102_1005 VDD VSS sg13g2_decap_4
X_13780__2784 _13780_/RESET_B VDD VSS sg13g2_tiehi
X_14306_ _14306_/Q clkload25/A _14306_/D _14306_/RESET_B VDD VSS sg13g2_dfrbpq_1
X_11518_ _11518_/Y _12221_/B1 _11516_/Y _12223_/A VDD VSS sg13g2_a21oi_1
XFILLER_141_1098 VDD VSS sg13g2_decap_8
X_12498_ _12499_/B _13683_/Q _12763_/A2 _12497_/X _12763_/B2 _12498_/C1 VDD VSS sg13g2_a221oi_1
X_14237_ _14237_/Q _14525_/CLK _14237_/D _14237_/RESET_B VDD VSS sg13g2_dfrbpq_1
XFILLER_7_296 VDD VSS sg13g2_decap_8
X_14731__1833 _14731_/RESET_B VDD VSS sg13g2_tiehi
X_11449_ _11449_/X _11441_/X _11440_/X _11435_/X _11434_/X _12219_/S _12221_/B1 VDD
+ VSS sg13g2_mux4_1
XFILLER_153_982 VDD VSS sg13g2_decap_8
XFILLER_125_673 VDD VSS sg13g2_decap_8
X_14168_ _14168_/Q clkload32/A _14168_/D _14168_/RESET_B VDD VSS sg13g2_dfrbpq_1
XFILLER_112_301 VDD VSS sg13g2_decap_8
XFILLER_3_491 VDD VSS sg13g2_decap_8
X_13119_ _13132_/A _13170_/A _13120_/A VDD VSS sg13g2_nor2_1
XFILLER_98_568 VDD VSS sg13g2_fill_2
XFILLER_113_868 VDD VSS sg13g2_decap_8
X_14099_ _14099_/Q clkload11/A _14099_/D _14099_/RESET_B VDD VSS sg13g2_dfrbpq_1
XFILLER_26_1142 VDD VSS sg13g2_decap_8
XFILLER_79_771 VDD VSS sg13g2_fill_1
XFILLER_152_1161 VDD VSS sg13g2_decap_8
XFILLER_6_1236 VDD VSS sg13g2_fill_1
XFILLER_113_1112 VDD VSS sg13g2_fill_2
XFILLER_121_890 VDD VSS sg13g2_decap_8
Xfanout1270 _13234_/B _13273_/B VDD VSS sg13g2_buf_1
XFILLER_61_1077 VDD VSS sg13g2_decap_8
X_08660_ _08661_/D _08666_/A _08674_/A2 _08341_/Y _08452_/B _08654_/Y VDD VSS sg13g2_a221oi_1
Xfanout1281 _08369_/B _08584_/A VDD VSS sg13g2_buf_1
Xfanout1292 _10924_/B1 _10895_/B1 VDD VSS sg13g2_buf_1
XFILLER_96_1107 VDD VSS sg13g2_decap_8
XFILLER_38_167 VDD VSS sg13g2_fill_1
XFILLER_82_925 VDD VSS sg13g2_fill_1
X_13690__2877 _13690_/RESET_B VDD VSS sg13g2_tiehi
XFILLER_54_627 VDD VSS sg13g2_fill_1
XFILLER_82_936 VDD VSS sg13g2_fill_2
XFILLER_93_262 VDD VSS sg13g2_decap_8
XFILLER_94_796 VDD VSS sg13g2_fill_1
XFILLER_96_1129 VDD VSS sg13g2_decap_8
XFILLER_113_1189 VDD VSS sg13g2_fill_2
XFILLER_54_638 VDD VSS sg13g2_fill_1
X_08591_ _08591_/X _08635_/A3 _08620_/A3 _08598_/A3 _08591_/A3 _08598_/S0 _08669_/B1
+ VDD VSS sg13g2_mux4_1
XFILLER_81_446 VDD VSS sg13g2_decap_4
XFILLER_35_852 VDD VSS sg13g2_decap_4
XFILLER_62_660 VDD VSS sg13g2_fill_2
XFILLER_35_896 VDD VSS sg13g2_fill_1
XFILLER_50_822 VDD VSS sg13g2_decap_8
XFILLER_34_384 VDD VSS sg13g2_fill_1
XFILLER_61_170 VDD VSS sg13g2_decap_8
XFILLER_14_28 VDD VSS sg13g2_decap_8
X_09212_ _13823_/D _10142_/A1 _13823_/Q _09212_/S VDD VSS sg13g2_mux2_1
XFILLER_148_710 VDD VSS sg13g2_decap_8
XFILLER_22_568 VDD VSS sg13g2_decap_8
XFILLER_148_721 VDD VSS sg13g2_fill_2
X_09143_ _09143_/Y _10793_/B _09141_/A _09157_/D _09157_/C VDD VSS sg13g2_a22oi_1
XFILLER_72_1195 VDD VSS sg13g2_decap_8
XFILLER_136_905 VDD VSS sg13g2_decap_8
XFILLER_136_916 VDD VSS sg13g2_fill_1
XFILLER_120_1116 VDD VSS sg13g2_decap_8
XFILLER_108_618 VDD VSS sg13g2_fill_2
X_09074_ _09074_/Y _13088_/A _09103_/C _09090_/A VDD VSS sg13g2_o21ai_1
X_14853__3223 _14853_/RESET_B VDD VSS sg13g2_tiehi
X_08025_ _08032_/C _08140_/B _08025_/B _08025_/C VDD VSS sg13g2_nor3_1
XFILLER_151_908 VDD VSS sg13g2_decap_8
XFILLER_146_49 VDD VSS sg13g2_decap_8
XFILLER_144_971 VDD VSS sg13g2_decap_8
XFILLER_144_993 VDD VSS sg13g2_decap_8
Xmax_cap472 _09636_/S fanout471/X VDD VSS sg13g2_buf_8
XFILLER_1_417 VDD VSS sg13g2_fill_1
XFILLER_115_150 VDD VSS sg13g2_fill_2
XFILLER_89_535 VDD VSS sg13g2_fill_2
XFILLER_39_14 VDD VSS sg13g2_decap_8
XFILLER_104_857 VDD VSS sg13g2_fill_2
XFILLER_131_654 VDD VSS sg13g2_decap_4
X_09976_ _14559_/D _10075_/A0 _14559_/Q _09976_/S VDD VSS sg13g2_mux2_1
XFILLER_130_153 VDD VSS sg13g2_fill_2
X_14886__3157 _14886_/RESET_B VDD VSS sg13g2_tiehi
XFILLER_131_1201 VDD VSS sg13g2_decap_4
X_08927_ _08927_/X _15045_/Q _14949_/Q _10767_/A VDD VSS sg13g2_mux2_1
XFILLER_40_1117 VDD VSS sg13g2_decap_8
XFILLER_29_145 VDD VSS sg13g2_fill_1
XFILLER_57_454 VDD VSS sg13g2_fill_1
X_08858_ _13697_/D _13697_/Q _08857_/X _08935_/S VDD VSS sg13g2_mux2_1
XFILLER_73_914 VDD VSS sg13g2_fill_2
XFILLER_72_402 VDD VSS sg13g2_fill_2
X_07809_ _08553_/A _15012_/Q _08541_/B VDD VSS sg13g2_xor2_1
XFILLER_57_498 VDD VSS sg13g2_decap_8
XFILLER_55_57 VDD VSS sg13g2_decap_8
X_08789_ _13681_/D _08728_/Y _08788_/Y _08787_/Y VDD VSS sg13g2_a21oi_1
XFILLER_55_68 VDD VSS sg13g2_decap_4
XFILLER_44_148 VDD VSS sg13g2_decap_4
X_10820_ _10821_/C _10803_/Y _10805_/Y _10804_/Y VDD VSS sg13g2_o21ai_1
XFILLER_77_1062 VDD VSS sg13g2_fill_2
X_10751_ _14915_/D _09204_/C _11078_/B _10750_/Y VDD VSS sg13g2_o21ai_1
XFILLER_13_535 VDD VSS sg13g2_decap_8
XFILLER_40_310 VDD VSS sg13g2_decap_8
XFILLER_41_844 VDD VSS sg13g2_fill_1
XFILLER_25_395 VDD VSS sg13g2_fill_1
X_13470_ _15109_/D _15109_/Q _13470_/A2 _13469_/X VDD VSS sg13g2_a21o_1
XFILLER_40_354 VDD VSS sg13g2_decap_8
X_10682_ _14897_/D _10886_/B1 _10818_/B _10681_/Y VDD VSS sg13g2_o21ai_1
XFILLER_51_1213 VDD VSS sg13g2_fill_2
XFILLER_41_899 VDD VSS sg13g2_decap_4
XFILLER_71_78 VDD VSS sg13g2_fill_2
X_12421_ _12421_/X _14240_/Q _14272_/Q _14304_/Q _14336_/Q _12424_/S0 _12508_/S1 VDD
+ VSS sg13g2_mux4_1
X_14539__2025 _14539_/RESET_B VDD VSS sg13g2_tiehi
X_15140_ _15140_/Q clkload28/A _15140_/D _15140_/RESET_B VDD VSS sg13g2_dfrbpq_1
X_12352_ _12352_/X _14235_/Q _14267_/Q _14299_/Q _14331_/Q _12615_/S0 _12785_/S1 VDD
+ VSS sg13g2_mux4_1
XFILLER_138_275 VDD VSS sg13g2_fill_1
XFILLER_127_949 VDD VSS sg13g2_decap_8
XFILLER_112_0 VDD VSS sg13g2_decap_8
X_11303_ _11303_/Y _11310_/A1 _14589_/Q _11391_/B VDD VSS sg13g2_a21oi_1
X_15071_ _15071_/Q clkload72/A _15071_/D _15071_/RESET_B VDD VSS sg13g2_dfrbpq_1
XFILLER_153_245 VDD VSS sg13g2_decap_8
X_12283_ _12283_/X _13849_/Q _13881_/Q _13913_/Q _13945_/Q _12287_/S0 _12287_/S1 VDD
+ VSS sg13g2_mux4_1
XFILLER_135_960 VDD VSS sg13g2_fill_1
XFILLER_141_418 VDD VSS sg13g2_decap_8
X_14022_ _14022_/Q _14662_/CLK _14022_/D _14022_/RESET_B VDD VSS sg13g2_dfrbpq_1
XFILLER_101_1082 VDD VSS sg13g2_fill_2
XFILLER_107_673 VDD VSS sg13g2_decap_4
X_11234_ _11234_/Y _11232_/Y _11233_/Y _15217_/Q VDD VSS sg13g2_a21oi_2
XFILLER_101_1093 VDD VSS sg13g2_decap_4
XFILLER_150_930 VDD VSS sg13g2_fill_1
XFILLER_134_492 VDD VSS sg13g2_decap_8
XFILLER_122_643 VDD VSS sg13g2_decap_8
XFILLER_49_1197 VDD VSS sg13g2_decap_8
X_11165_ _11165_/X _11179_/B _11181_/B VDD VSS sg13g2_or2_1
XFILLER_136_93 VDD VSS sg13g2_decap_8
XFILLER_95_505 VDD VSS sg13g2_decap_8
XFILLER_136_1167 VDD VSS sg13g2_decap_8
XFILLER_49_900 VDD VSS sg13g2_fill_2
XFILLER_136_1178 VDD VSS sg13g2_fill_1
XFILLER_110_827 VDD VSS sg13g2_decap_8
X_10116_ _14694_/D _10149_/A1 _14694_/Q _10129_/S VDD VSS sg13g2_mux2_1
X_11096_ _11096_/Y _11097_/A _11097_/C _11086_/B VDD VSS sg13g2_o21ai_1
XFILLER_96_75 VDD VSS sg13g2_decap_4
XFILLER_48_432 VDD VSS sg13g2_fill_2
X_10047_ _14628_/D _10080_/A0 _14628_/Q _10067_/S VDD VSS sg13g2_mux2_1
X_14924_ _14924_/Q clkload35/A _14924_/D _14924_/RESET_B VDD VSS sg13g2_dfrbpq_1
XFILLER_76_763 VDD VSS sg13g2_decap_8
XFILLER_152_70 VDD VSS sg13g2_decap_8
XFILLER_36_616 VDD VSS sg13g2_fill_2
XFILLER_1_1111 VDD VSS sg13g2_decap_8
X_14855_ _14855_/Q _14873_/CLK _14855_/D _14855_/RESET_B VDD VSS sg13g2_dfrbpq_1
XFILLER_21_1061 VDD VSS sg13g2_decap_8
X_13798__2766 _13798_/RESET_B VDD VSS sg13g2_tiehi
X_13806_ _13806_/Q _14763_/CLK _13806_/D _13806_/RESET_B VDD VSS sg13g2_dfrbpq_1
XFILLER_35_148 VDD VSS sg13g2_decap_8
XFILLER_91_777 VDD VSS sg13g2_decap_8
X_14786_ _14786_/Q clkload77/A _14786_/D _14786_/RESET_B VDD VSS sg13g2_dfrbpq_1
XFILLER_51_619 VDD VSS sg13g2_decap_8
X_11998_ _11998_/X _11994_/X _11995_/X _11993_/X _11992_/X _11953_/C _11424_/B VDD
+ VSS sg13g2_mux4_1
XFILLER_147_1230 VDD VSS sg13g2_decap_8
X_13737_ _13737_/Q _14722_/CLK _13737_/D _13737_/RESET_B VDD VSS sg13g2_dfrbpq_1
X_10949_ _10949_/Y _10893_/X _11005_/A _11007_/B VDD VSS sg13g2_o21ai_1
XFILLER_108_1236 VDD VSS sg13g2_fill_1
XFILLER_143_1138 VDD VSS sg13g2_decap_4
X_13668_ _13668_/Q _15214_/CLK _13668_/D _13668_/RESET_B VDD VSS sg13g2_dfrbpq_1
X_14178__2386 _14178_/RESET_B VDD VSS sg13g2_tiehi
X_12619_ _12619_/X _13838_/Q _13870_/Q _13902_/Q _13934_/Q _12620_/S0 _12620_/S1 VDD
+ VSS sg13g2_mux4_1
X_13599_ _13599_/Y _13600_/A _10173_/B _15165_/Q VDD VSS sg13g2_a21oi_1
XFILLER_144_212 VDD VSS sg13g2_decap_8
XFILLER_32_1190 VDD VSS sg13g2_decap_8
XFILLER_6_84 VDD VSS sg13g2_decap_8
X_14393__2171 _14393_/RESET_B VDD VSS sg13g2_tiehi
XFILLER_144_278 VDD VSS sg13g2_fill_1
XFILLER_98_310 VDD VSS sg13g2_decap_8
XFILLER_98_321 VDD VSS sg13g2_fill_2
XFILLER_141_941 VDD VSS sg13g2_decap_8
X_09830_ _14418_/D _09830_/A0 _14418_/Q _09838_/S VDD VSS sg13g2_mux2_1
Xfanout518 _09190_/S wire519/A VDD VSS sg13g2_buf_1
XFILLER_63_1128 VDD VSS sg13g2_decap_4
Xfanout529 _09880_/A0 _09913_/A1 VDD VSS sg13g2_buf_1
XFILLER_98_354 VDD VSS sg13g2_decap_8
XFILLER_99_888 VDD VSS sg13g2_decap_8
XFILLER_101_816 VDD VSS sg13g2_decap_8
XFILLER_113_676 VDD VSS sg13g2_decap_8
XFILLER_100_304 VDD VSS sg13g2_fill_1
XFILLER_113_687 VDD VSS sg13g2_fill_1
X_09761_ _14351_/D _14351_/Q _09926_/A1 wire444/X VDD VSS sg13g2_mux2_1
XFILLER_140_495 VDD VSS sg13g2_decap_8
XFILLER_6_1033 VDD VSS sg13g2_decap_8
X_14985__2987 _14985_/RESET_B VDD VSS sg13g2_tiehi
X_08712_ _13661_/D _15188_/D _14760_/Q _13651_/S VDD VSS sg13g2_mux2_1
XFILLER_67_752 VDD VSS sg13g2_fill_2
X_09692_ _14284_/D _09824_/A0 _14284_/Q _09706_/S VDD VSS sg13g2_mux2_1
XFILLER_67_785 VDD VSS sg13g2_decap_4
X_08643_ _08646_/B _08643_/A _08646_/A _08643_/C _08643_/D VDD VSS sg13g2_nand4_1
XFILLER_27_638 VDD VSS sg13g2_fill_2
XFILLER_81_210 VDD VSS sg13g2_decap_8
XFILLER_26_126 VDD VSS sg13g2_decap_8
XFILLER_54_446 VDD VSS sg13g2_decap_4
XFILLER_70_917 VDD VSS sg13g2_decap_8
X_08574_ wire365/A _08574_/A _08574_/B _08574_/C _08574_/D VDD VSS sg13g2_nand4_1
XFILLER_70_928 VDD VSS sg13g2_fill_2
XFILLER_82_799 VDD VSS sg13g2_decap_8
XFILLER_25_49 VDD VSS sg13g2_decap_8
XFILLER_23_833 VDD VSS sg13g2_fill_1
XFILLER_23_844 VDD VSS sg13g2_fill_1
XFILLER_35_1208 VDD VSS sg13g2_decap_8
XFILLER_23_877 VDD VSS sg13g2_decap_8
X_14008__2556 _14008_/RESET_B VDD VSS sg13g2_tiehi
X_13843__2721 _13843_/RESET_B VDD VSS sg13g2_tiehi
XFILLER_148_540 VDD VSS sg13g2_fill_1
X_09126_ _09126_/Y _09158_/A _10767_/B _09125_/X VDD VSS sg13g2_o21ai_1
XFILLER_135_212 VDD VSS sg13g2_decap_8
XFILLER_135_245 VDD VSS sg13g2_decap_8
X_09057_ _09057_/X _09137_/A _09057_/B _09089_/C VDD VSS sg13g2_or3_1
XFILLER_135_256 VDD VSS sg13g2_fill_2
X_08008_ _08008_/Y _08200_/A _08008_/B VDD VSS sg13g2_nor2_1
X_14223__2341 _14223_/RESET_B VDD VSS sg13g2_tiehi
XFILLER_1_214 VDD VSS sg13g2_decap_8
X_13876__2688 _13876_/RESET_B VDD VSS sg13g2_tiehi
XFILLER_104_621 VDD VSS sg13g2_decap_8
XFILLER_132_941 VDD VSS sg13g2_fill_1
XFILLER_1_225 VDD VSS sg13g2_fill_1
XFILLER_1_247 VDD VSS sg13g2_decap_8
XFILLER_89_354 VDD VSS sg13g2_fill_1
XFILLER_103_142 VDD VSS sg13g2_decap_8
XFILLER_49_207 VDD VSS sg13g2_fill_1
XFILLER_104_687 VDD VSS sg13g2_decap_4
XFILLER_49_229 VDD VSS sg13g2_decap_8
X_09959_ _14543_/D _14543_/Q _09992_/A0 _09964_/S VDD VSS sg13g2_mux2_1
XFILLER_77_549 VDD VSS sg13g2_decap_8
XFILLER_46_903 VDD VSS sg13g2_decap_4
XFILLER_66_56 VDD VSS sg13g2_decap_8
X_12970_ _12970_/Y _12969_/Y _13035_/A2 _12966_/Y VDD VSS sg13g2_a21oi_1
XFILLER_131_1031 VDD VSS sg13g2_fill_1
XFILLER_46_936 VDD VSS sg13g2_decap_8
XFILLER_73_711 VDD VSS sg13g2_fill_2
X_11921_ _11921_/X _14703_/Q _14735_/Q _13775_/Q _13807_/Q _12139_/S0 _12285_/S1 VDD
+ VSS sg13g2_mux4_1
XFILLER_46_947 VDD VSS sg13g2_fill_1
XFILLER_57_284 VDD VSS sg13g2_decap_4
XFILLER_85_593 VDD VSS sg13g2_decap_8
XFILLER_72_221 VDD VSS sg13g2_fill_2
XFILLER_79_1168 VDD VSS sg13g2_decap_4
XFILLER_45_457 VDD VSS sg13g2_decap_8
XFILLER_73_766 VDD VSS sg13g2_fill_2
X_14640_ _14640_/Q clkload50/A _14640_/D _14640_/RESET_B VDD VSS sg13g2_dfrbpq_1
X_11852_ _11852_/X _13965_/Q _13997_/Q _14029_/Q _14061_/Q _11852_/S0 _11419_/C VDD
+ VSS sg13g2_mux4_1
XFILLER_73_788 VDD VSS sg13g2_decap_8
XFILLER_26_671 VDD VSS sg13g2_fill_2
X_10803_ _10803_/Y _10675_/A _08971_/X _10802_/Y VDD VSS sg13g2_o21ai_1
X_14571_ _14571_/Q _14667_/CLK _14571_/D _14571_/RESET_B VDD VSS sg13g2_dfrbpq_1
X_11783_ _11783_/X _14571_/Q _14603_/Q _14635_/Q _14667_/Q _12286_/S0 _12286_/S1 VDD
+ VSS sg13g2_mux4_1
XFILLER_13_321 VDD VSS sg13g2_fill_1
XFILLER_53_490 VDD VSS sg13g2_fill_1
X_14471__2093 _14471_/RESET_B VDD VSS sg13g2_tiehi
X_13522_ _13522_/Y _13521_/A _12936_/B _14998_/Q _13546_/B2 VDD VSS sg13g2_a22oi_1
XFILLER_13_343 VDD VSS sg13g2_decap_8
XFILLER_82_99 VDD VSS sg13g2_fill_2
XFILLER_14_877 VDD VSS sg13g2_decap_4
X_10734_ _14911_/D _10734_/A VDD VSS sg13g2_inv_1
XFILLER_40_140 VDD VSS sg13g2_decap_8
XFILLER_40_151 VDD VSS sg13g2_fill_2
X_13453_ _13454_/D _15186_/Q _15187_/Q _15188_/Q _15171_/Q VDD VSS sg13g2_nor4_1
XFILLER_51_1032 VDD VSS sg13g2_decap_8
X_10665_ _10667_/B _14893_/Q _10661_/C hold3525/X VDD VSS sg13g2_a21oi_1
XFILLER_139_562 VDD VSS sg13g2_fill_1
X_12404_ _12404_/X _14111_/Q _14143_/Q _14175_/Q _14207_/Q _12411_/S0 _12411_/S1 VDD
+ VSS sg13g2_mux4_1
XFILLER_154_510 VDD VSS sg13g2_decap_8
X_13384_ _13384_/Y _13465_/A1 _08723_/B _15081_/Q VDD VSS sg13g2_o21ai_1
X_10596_ _10599_/B _14875_/Q _10607_/C _14876_/Q VDD VSS sg13g2_a21oi_1
X_15123_ _15123_/Q _15250_/CLK _15123_/D _15123_/RESET_B VDD VSS sg13g2_dfrbpq_1
X_12335_ _12335_/Y _12315_/Y _12317_/X _11378_/S VDD VSS sg13g2_o21ai_1
XFILLER_147_70 VDD VSS sg13g2_decap_8
XFILLER_108_971 VDD VSS sg13g2_decap_8
XFILLER_126_278 VDD VSS sg13g2_decap_4
X_15054_ _15054_/Q _15209_/CLK _15054_/D _15054_/RESET_B VDD VSS sg13g2_dfrbpq_1
X_12266_ _12266_/Y _12264_/Y _12265_/Y _11477_/A VDD VSS sg13g2_a21oi_1
XFILLER_99_129 VDD VSS sg13g2_decap_8
XFILLER_49_7 VDD VSS sg13g2_decap_4
XFILLER_107_481 VDD VSS sg13g2_fill_1
X_13706__2858 _13706_/RESET_B VDD VSS sg13g2_tiehi
X_14005_ _14005_/Q clkload43/A _14005_/D _14005_/RESET_B VDD VSS sg13g2_dfrbpq_1
X_11217_ _11217_/X _14555_/Q _14587_/Q _11277_/S VDD VSS sg13g2_mux2_1
Xoutput70 mem_axi_arvalid _07659_/Y VDD VSS sg13g2_buf_1
X_12197_ _12197_/Y _12197_/A _12197_/B _12198_/B _12198_/D VDD VSS sg13g2_nor4_1
XFILLER_68_516 VDD VSS sg13g2_fill_1
Xoutput81 mem_axi_awaddr[20] _16873_/X VDD VSS sg13g2_buf_1
XFILLER_95_302 VDD VSS sg13g2_fill_2
XFILLER_123_996 VDD VSS sg13g2_decap_8
Xoutput92 mem_axi_awaddr[30] _16883_/X VDD VSS sg13g2_buf_1
X_11148_ _11150_/A _11171_/B _11147_/Y _11173_/B _11128_/A VDD VSS sg13g2_a22oi_1
XFILLER_23_1112 VDD VSS sg13g2_decap_8
XFILLER_48_240 VDD VSS sg13g2_fill_1
X_11079_ _11079_/Y _11097_/A _11097_/C VDD VSS sg13g2_xnor2_1
XFILLER_37_925 VDD VSS sg13g2_fill_1
X_13921__2643 _13921_/RESET_B VDD VSS sg13g2_tiehi
X_14907_ _14907_/Q clkload38/A _14907_/D _14907_/RESET_B VDD VSS sg13g2_dfrbpq_1
X_14681__1883 _14681_/RESET_B VDD VSS sg13g2_tiehi
XFILLER_23_1189 VDD VSS sg13g2_decap_8
XFILLER_48_284 VDD VSS sg13g2_fill_2
XFILLER_58_1219 VDD VSS sg13g2_decap_8
XFILLER_64_777 VDD VSS sg13g2_decap_8
XFILLER_64_788 VDD VSS sg13g2_decap_8
X_14838_ _14838_/Q _14873_/CLK _14838_/D _14838_/RESET_B VDD VSS sg13g2_dfrbpq_1
X_14870__3189 _14870_/RESET_B VDD VSS sg13g2_tiehi
X_14769_ _14769_/Q clkload80/A _14769_/D _14769_/RESET_B VDD VSS sg13g2_dfrbpq_1
XFILLER_147_1060 VDD VSS sg13g2_decap_8
X_14301__2263 _14301_/RESET_B VDD VSS sg13g2_tiehi
X_08290_ _08290_/X _08286_/Y _08289_/Y _08612_/S VDD VSS sg13g2_mux2_1
XFILLER_149_337 VDD VSS sg13g2_decap_8
XFILLER_31_162 VDD VSS sg13g2_decap_8
XFILLER_121_1200 VDD VSS sg13g2_decap_8
XFILLER_118_702 VDD VSS sg13g2_fill_2
XFILLER_75_0 VDD VSS sg13g2_decap_8
XFILLER_132_226 VDD VSS sg13g2_decap_8
Xclkbuf_leaf_114_clk_i _14710_/CLK clkbuf_5_12__f_clk_i/X VDD VSS sg13g2_buf_8
XFILLER_28_1012 VDD VSS sg13g2_decap_8
XFILLER_114_952 VDD VSS sg13g2_fill_2
Xfanout315 fanout315/X _10037_/Y VDD VSS sg13g2_buf_1
XFILLER_28_1045 VDD VSS sg13g2_decap_8
XFILLER_101_602 VDD VSS sg13g2_decap_8
XFILLER_119_1173 VDD VSS sg13g2_decap_8
X_09813_ _14401_/D _09912_/A1 _14401_/Q wire618/X VDD VSS sg13g2_mux2_1
XFILLER_114_996 VDD VSS sg13g2_fill_2
Xfanout348 _09850_/A1 _10115_/A0 VDD VSS sg13g2_buf_1
XFILLER_8_1139 VDD VSS sg13g2_decap_8
XFILLER_143_28 VDD VSS sg13g2_decap_8
XFILLER_87_858 VDD VSS sg13g2_fill_1
XFILLER_28_1089 VDD VSS sg13g2_fill_1
Xfanout359 _09912_/A1 _10144_/A1 VDD VSS sg13g2_buf_1
XFILLER_86_357 VDD VSS sg13g2_fill_1
XFILLER_41_1223 VDD VSS sg13g2_decap_8
XFILLER_101_668 VDD VSS sg13g2_decap_4
X_09744_ _14334_/D _14334_/Q _09744_/A1 _09760_/S VDD VSS sg13g2_mux2_1
XFILLER_39_251 VDD VSS sg13g2_decap_8
XFILLER_100_178 VDD VSS sg13g2_decap_8
X_09675_ _14267_/D _09741_/A1 _14267_/Q _09694_/S VDD VSS sg13g2_mux2_1
XFILLER_67_593 VDD VSS sg13g2_decap_4
XFILLER_28_958 VDD VSS sg13g2_fill_2
XFILLER_27_446 VDD VSS sg13g2_decap_8
XFILLER_43_917 VDD VSS sg13g2_decap_4
X_08626_ _08633_/B _08688_/C _08616_/Y _08625_/Y VDD VSS sg13g2_a21oi_1
XFILLER_82_563 VDD VSS sg13g2_fill_2
XFILLER_42_405 VDD VSS sg13g2_decap_8
XFILLER_36_991 VDD VSS sg13g2_fill_2
XFILLER_74_1010 VDD VSS sg13g2_decap_4
X_08557_ _08557_/Y _08401_/Y _08237_/Y _08397_/Y VDD VSS sg13g2_o21ai_1
XFILLER_153_7 VDD VSS sg13g2_decap_8
XFILLER_70_758 VDD VSS sg13g2_decap_8
XFILLER_23_641 VDD VSS sg13g2_decap_8
XFILLER_52_14 VDD VSS sg13g2_decap_8
XFILLER_51_961 VDD VSS sg13g2_decap_8
XFILLER_35_1016 VDD VSS sg13g2_decap_4
X_08488_ _08488_/Y _08488_/A _08488_/B VDD VSS sg13g2_nand2_1
XFILLER_52_47 VDD VSS sg13g2_decap_8
XFILLER_52_58 VDD VSS sg13g2_fill_1
XFILLER_11_858 VDD VSS sg13g2_decap_8
XFILLER_155_329 VDD VSS sg13g2_decap_8
X_10450_ _14839_/D _10468_/A _10450_/B _10450_/C VDD VSS sg13g2_nor3_1
XFILLER_10_379 VDD VSS sg13g2_decap_8
X_09109_ _09109_/Y _10760_/A _09150_/B _09159_/A1 VDD VSS sg13g2_o21ai_1
X_10381_ _10381_/Y _14818_/Q _10379_/A _10626_/B VDD VSS sg13g2_o21ai_1
XFILLER_108_256 VDD VSS sg13g2_decap_4
XFILLER_124_716 VDD VSS sg13g2_fill_1
XFILLER_2_501 VDD VSS sg13g2_decap_8
X_12120_ _12120_/Y _12115_/X _12174_/A _12118_/C VDD VSS sg13g2_a21oi_1
XFILLER_136_598 VDD VSS sg13g2_fill_2
XFILLER_46_1101 VDD VSS sg13g2_fill_1
XFILLER_85_1172 VDD VSS sg13g2_fill_2
X_12051_ _12051_/Y _12051_/A1 _12050_/Y _12298_/B VDD VSS sg13g2_o21ai_1
XFILLER_89_151 VDD VSS sg13g2_decap_8
XFILLER_78_825 VDD VSS sg13g2_decap_8
XFILLER_46_1156 VDD VSS sg13g2_decap_4
X_11002_ _11022_/A _11002_/A _15117_/Q VDD VSS sg13g2_nand2_1
XFILLER_46_1167 VDD VSS sg13g2_fill_2
XFILLER_46_1178 VDD VSS sg13g2_fill_1
XFILLER_81_1058 VDD VSS sg13g2_decap_8
XFILLER_131_270 VDD VSS sg13g2_decap_8
XFILLER_46_1189 VDD VSS sg13g2_decap_8
XFILLER_81_1069 VDD VSS sg13g2_fill_2
XFILLER_89_195 VDD VSS sg13g2_decap_4
X_14489__2075 _14489_/RESET_B VDD VSS sg13g2_tiehi
Xfanout860 _10675_/A _08838_/Y VDD VSS sg13g2_buf_1
Xfanout871 _08945_/A2 _08831_/Y VDD VSS sg13g2_buf_1
XFILLER_19_914 VDD VSS sg13g2_fill_1
Xfanout893 _08456_/A fanout894/X VDD VSS sg13g2_buf_1
XFILLER_19_925 VDD VSS sg13g2_decap_8
XFILLER_92_316 VDD VSS sg13g2_decap_8
XFILLER_92_327 VDD VSS sg13g2_fill_2
XFILLER_93_21 VDD VSS sg13g2_decap_8
X_12953_ _12953_/Y _12951_/Y _12952_/Y _12933_/Y VDD VSS sg13g2_o21ai_1
XFILLER_18_435 VDD VSS sg13g2_fill_1
XFILLER_34_906 VDD VSS sg13g2_decap_8
XFILLER_93_54 VDD VSS sg13g2_decap_4
Xclkbuf_leaf_93_clk_i clkload29/A clkbuf_leaf_97_clk_i/A VDD VSS sg13g2_buf_8
X_11904_ _11904_/X _14913_/Q _11792_/B wire269/X VDD VSS sg13g2_a21o_1
XFILLER_46_777 VDD VSS sg13g2_decap_8
X_12884_ _12884_/Y _12900_/B input17/X _12884_/C VDD VSS sg13g2_nand3_1
X_14623_ _14623_/Q clkload56/A _14623_/D _14623_/RESET_B VDD VSS sg13g2_dfrbpq_1
XFILLER_26_70 VDD VSS sg13g2_decap_8
XFILLER_60_224 VDD VSS sg13g2_decap_8
X_11835_ _11835_/Y _11833_/Y _11834_/Y _12292_/A VDD VSS sg13g2_a21oi_1
XFILLER_92_1154 VDD VSS sg13g2_fill_2
X_14554_ _14554_/Q clkload57/A _14554_/D _14554_/RESET_B VDD VSS sg13g2_dfrbpq_1
XFILLER_144_1233 VDD VSS sg13g2_decap_4
X_11766_ wire270/A _11765_/Y _11755_/Y _11747_/Y _11737_/Y _11477_/A VDD VSS sg13g2_a221oi_1
XFILLER_92_1176 VDD VSS sg13g2_decap_8
X_13505_ _15130_/D _15130_/Q _13499_/A _13504_/Y VDD VSS sg13g2_a21o_1
X_10717_ _10965_/A _14938_/Q _10725_/A _10716_/Y VDD VSS sg13g2_a21oi_1
XFILLER_147_819 VDD VSS sg13g2_fill_2
X_14485_ _14485_/Q _14706_/CLK _14485_/D _14485_/RESET_B VDD VSS sg13g2_dfrbpq_1
X_11697_ _11698_/A _11694_/Y _11696_/Y _12265_/A2 VDD VSS sg13g2_a21oi_1
X_13436_ _15100_/D _15100_/Q _13470_/A2 _13435_/Y VDD VSS sg13g2_a21o_1
X_10648_ _10653_/C _14884_/Q _14883_/Q _14880_/Q _14879_/Q VDD VSS sg13g2_and4_1
Xmax_cap1144 _12494_/S0 _12492_/S0 VDD VSS sg13g2_buf_4
XFILLER_6_840 VDD VSS sg13g2_fill_1
Xclkbuf_leaf_31_clk_i clkload50/A clkbuf_leaf_49_clk_i/A VDD VSS sg13g2_buf_8
X_13367_ _13367_/Y _13438_/B _13438_/D VDD VSS sg13g2_nand2_1
X_10579_ _10580_/A _14871_/Q _10579_/B _10579_/C _10583_/D VDD VSS sg13g2_and4_1
X_13939__2625 _13939_/RESET_B VDD VSS sg13g2_tiehi
XFILLER_155_896 VDD VSS sg13g2_decap_8
X_15106_ _15106_/Q clkload80/A _15106_/D _15106_/RESET_B VDD VSS sg13g2_dfrbpq_1
X_14699__1865 _14699_/RESET_B VDD VSS sg13g2_tiehi
X_12318_ _12318_/Y _12328_/A1 _14394_/Q VDD VSS sg13g2_nand2b_1
X_13298_ _13298_/X _13499_/C _13298_/B VDD VSS sg13g2_and2_1
XFILLER_108_790 VDD VSS sg13g2_decap_4
XFILLER_114_226 VDD VSS sg13g2_fill_2
X_15037_ _15037_/Q clkload61/A _15037_/D _15037_/RESET_B VDD VSS sg13g2_dfrbpq_1
XFILLER_130_708 VDD VSS sg13g2_decap_4
X_12249_ _12249_/Y _12250_/A1 _14488_/Q VDD VSS sg13g2_nand2b_1
XFILLER_142_579 VDD VSS sg13g2_decap_8
XFILLER_68_302 VDD VSS sg13g2_decap_4
XFILLER_25_1207 VDD VSS sg13g2_decap_8
Xclkbuf_leaf_46_clk_i clkload57/A clkbuf_leaf_60_clk_i/A VDD VSS sg13g2_buf_8
XFILLER_3_63 VDD VSS sg13g2_decap_8
XFILLER_69_869 VDD VSS sg13g2_fill_1
X_14319__2245 _14319_/RESET_B VDD VSS sg13g2_tiehi
XFILLER_95_132 VDD VSS sg13g2_decap_8
XFILLER_96_666 VDD VSS sg13g2_fill_2
X_07790_ _08412_/A _07790_/A _15003_/Q VDD VSS sg13g2_nand2_1
XFILLER_110_476 VDD VSS sg13g2_fill_1
XFILLER_77_880 VDD VSS sg13g2_fill_2
XFILLER_7_1194 VDD VSS sg13g2_decap_8
XFILLER_36_210 VDD VSS sg13g2_decap_8
XFILLER_49_593 VDD VSS sg13g2_fill_1
XFILLER_25_906 VDD VSS sg13g2_decap_8
X_09460_ _14061_/D _09693_/A0 _14061_/Q wire671/X VDD VSS sg13g2_mux2_1
XFILLER_3_1069 VDD VSS sg13g2_decap_8
X_08411_ _08411_/Y _08411_/A _08414_/C _08411_/C VDD VSS sg13g2_nor3_1
XFILLER_51_213 VDD VSS sg13g2_decap_8
X_14534__2030 _14534_/RESET_B VDD VSS sg13g2_tiehi
X_09391_ _13994_/D _09789_/A0 _13994_/Q _09391_/S VDD VSS sg13g2_mux2_1
XFILLER_52_769 VDD VSS sg13g2_decap_8
X_08342_ _08346_/A _08405_/A1 _15002_/Q _08674_/B1 VDD VSS sg13g2_o21ai_1
XFILLER_149_112 VDD VSS sg13g2_decap_8
XFILLER_33_983 VDD VSS sg13g2_fill_1
X_14788__3310 _14788_/RESET_B VDD VSS sg13g2_tiehi
XFILLER_20_611 VDD VSS sg13g2_fill_2
XFILLER_60_780 VDD VSS sg13g2_fill_2
X_08273_ _08273_/Y _08603_/B VDD VSS sg13g2_inv_1
XFILLER_22_28 VDD VSS sg13g2_decap_8
XFILLER_138_28 VDD VSS sg13g2_decap_8
XFILLER_34_1093 VDD VSS sg13g2_decap_8
XFILLER_106_705 VDD VSS sg13g2_decap_8
XFILLER_146_896 VDD VSS sg13g2_decap_8
XFILLER_65_1009 VDD VSS sg13g2_decap_4
XFILLER_69_1178 VDD VSS sg13g2_fill_1
XFILLER_105_226 VDD VSS sg13g2_fill_2
XFILLER_156_1159 VDD VSS sg13g2_fill_1
XFILLER_154_49 VDD VSS sg13g2_decap_8
X_13793__2771 _13793_/RESET_B VDD VSS sg13g2_tiehi
XFILLER_114_782 VDD VSS sg13g2_decap_4
XFILLER_86_110 VDD VSS sg13g2_decap_8
XFILLER_113_270 VDD VSS sg13g2_fill_1
XFILLER_87_644 VDD VSS sg13g2_decap_8
XFILLER_113_281 VDD VSS sg13g2_decap_4
Xfanout156 _09705_/A0 _10135_/A0 VDD VSS sg13g2_buf_1
XFILLER_47_14 VDD VSS sg13g2_decap_8
Xfanout167 _09934_/A1 _10099_/A0 VDD VSS sg13g2_buf_1
X_14744__1820 _14744_/RESET_B VDD VSS sg13g2_tiehi
XFILLER_47_519 VDD VSS sg13g2_decap_4
Xfanout178 _10063_/A0 _10096_/A0 VDD VSS sg13g2_buf_1
XFILLER_75_828 VDD VSS sg13g2_fill_1
Xfanout189 _09962_/A1 _09698_/A0 VDD VSS sg13g2_buf_1
X_07988_ _07988_/Y _13048_/B _13289_/C _13320_/C _07988_/D VDD VSS sg13g2_nor4_1
XFILLER_47_47 VDD VSS sg13g2_decap_8
XFILLER_86_176 VDD VSS sg13g2_decap_8
X_09727_ _14318_/D _09925_/A1 _14318_/Q _09727_/S VDD VSS sg13g2_mux2_1
XFILLER_27_210 VDD VSS sg13g2_decap_4
X_14951__3027 _14951_/RESET_B VDD VSS sg13g2_tiehi
XFILLER_90_809 VDD VSS sg13g2_fill_1
XFILLER_41_1086 VDD VSS sg13g2_decap_8
X_14173__2391 _14173_/RESET_B VDD VSS sg13g2_tiehi
XFILLER_76_1105 VDD VSS sg13g2_fill_2
XFILLER_103_42 VDD VSS sg13g2_decap_4
XFILLER_16_928 VDD VSS sg13g2_fill_1
X_09658_ _14251_/D _09691_/A0 _14251_/Q wire641/X VDD VSS sg13g2_mux2_1
XFILLER_83_883 VDD VSS sg13g2_fill_2
XFILLER_42_202 VDD VSS sg13g2_fill_2
XFILLER_43_736 VDD VSS sg13g2_fill_1
X_08609_ _08643_/A _07857_/X _08608_/B _07858_/X VDD VSS sg13g2_a21o_1
X_09589_ _14186_/D _14186_/Q _09888_/A0 _09599_/S VDD VSS sg13g2_mux2_1
XFILLER_128_1228 VDD VSS sg13g2_decap_8
XFILLER_70_555 VDD VSS sg13g2_fill_1
X_11620_ _11620_/Y _11616_/Y _11617_/Y _11619_/Y _11618_/Y _12108_/B VDD VSS sg13g2_a221oi_1
XFILLER_24_994 VDD VSS sg13g2_decap_8
XFILLER_51_780 VDD VSS sg13g2_decap_8
X_11551_ _11551_/Y _11555_/S0 _13860_/Q _11555_/S1 VDD VSS sg13g2_a21oi_1
X_10502_ _10505_/C _10502_/A _10502_/B _10502_/C VDD VSS sg13g2_nor3_1
Xwire524 wire524/X wire525/X VDD VSS sg13g2_buf_2
XFILLER_13_1111 VDD VSS sg13g2_decap_8
XFILLER_11_677 VDD VSS sg13g2_decap_4
XFILLER_7_626 VDD VSS sg13g2_decap_8
X_14270_ _14270_/Q clkload58/A _14270_/D _14270_/RESET_B VDD VSS sg13g2_dfrbpq_1
XFILLER_155_126 VDD VSS sg13g2_decap_8
X_11482_ _11777_/A _11483_/A _13686_/Q VDD VSS sg13g2_nor2_1
XFILLER_6_114 VDD VSS sg13g2_fill_1
Xwire568 wire568/X wire568/A VDD VSS sg13g2_buf_2
X_13221_ _13221_/Y _13218_/Y _13219_/Y _13220_/Y VDD VSS sg13g2_a21oi_1
X_10433_ _10435_/B _14833_/Q _10434_/C _14834_/Q VDD VSS sg13g2_a21oi_1
XFILLER_13_1188 VDD VSS sg13g2_decap_8
XFILLER_136_373 VDD VSS sg13g2_decap_8
XFILLER_100_1147 VDD VSS sg13g2_fill_1
X_13152_ _13152_/Y _14789_/Q _13220_/A2 _13262_/B1 VDD VSS sg13g2_o21ai_1
X_14980__2992 _14980_/RESET_B VDD VSS sg13g2_tiehi
X_10364_ _10365_/B _14812_/Q _14813_/Q _10364_/C VDD VSS sg13g2_nand3_1
X_12103_ _12103_/Y _12090_/A _14420_/Q _12114_/S1 VDD VSS sg13g2_a21oi_1
XFILLER_5_0 VDD VSS sg13g2_decap_8
XFILLER_124_568 VDD VSS sg13g2_decap_8
X_13083_ _13085_/B _14816_/Q _13068_/B _13028_/B _14880_/Q VDD VSS sg13g2_a22oi_1
X_10295_ _14792_/D _10295_/A _10295_/B _10295_/C VDD VSS sg13g2_and3_1
XFILLER_152_899 VDD VSS sg13g2_decap_8
XFILLER_111_207 VDD VSS sg13g2_decap_8
X_12034_ _12034_/Y _12030_/Y _12031_/Y _12033_/Y _12032_/Y _12036_/B VDD VSS sg13g2_a221oi_1
Xfanout1611 _12215_/S1 fanout1617/X VDD VSS sg13g2_buf_1
XFILLER_2_397 VDD VSS sg13g2_decap_8
Xfanout1622 _12091_/C _12100_/S1 VDD VSS sg13g2_buf_1
Xfanout1633 _12236_/C fanout1634/X VDD VSS sg13g2_buf_1
XFILLER_77_132 VDD VSS sg13g2_decap_8
Xfanout1644 _11997_/S1 _11995_/S1 VDD VSS sg13g2_buf_1
XFILLER_144_82 VDD VSS sg13g2_decap_8
Xfanout1655 _11282_/S1 _11226_/S1 VDD VSS sg13g2_buf_1
XFILLER_77_154 VDD VSS sg13g2_decap_8
XFILLER_77_176 VDD VSS sg13g2_decap_8
Xfanout1677 _11922_/S0 _12207_/S0 VDD VSS sg13g2_buf_1
Xfanout690 _09374_/S _09342_/Y VDD VSS sg13g2_buf_1
XFILLER_59_880 VDD VSS sg13g2_fill_2
Xfanout1688 fanout1688/X fanout1753/X VDD VSS sg13g2_buf_1
Xfanout1699 _11686_/S0 _11695_/S0 VDD VSS sg13g2_buf_1
XFILLER_111_1221 VDD VSS sg13g2_decap_8
X_13985_ _13985_/Q clkload20/A _13985_/D _13985_/RESET_B VDD VSS sg13g2_dfrbpq_1
XFILLER_92_135 VDD VSS sg13g2_decap_8
XFILLER_18_221 VDD VSS sg13g2_decap_8
XFILLER_81_809 VDD VSS sg13g2_decap_8
XFILLER_46_552 VDD VSS sg13g2_decap_4
X_12936_ _12936_/Y _13589_/A2 _12936_/B VDD VSS sg13g2_nand2b_1
X_14003__2561 _14003_/RESET_B VDD VSS sg13g2_tiehi
XFILLER_74_872 VDD VSS sg13g2_decap_8
XFILLER_46_574 VDD VSS sg13g2_decap_8
XFILLER_61_511 VDD VSS sg13g2_fill_1
XFILLER_73_371 VDD VSS sg13g2_fill_2
XFILLER_2_1080 VDD VSS sg13g2_decap_8
XFILLER_33_235 VDD VSS sg13g2_fill_2
X_12867_ _12867_/Y _12900_/B input16/X _12884_/C VDD VSS sg13g2_nand3_1
XFILLER_15_950 VDD VSS sg13g2_fill_2
X_14607__1957 _14607_/RESET_B VDD VSS sg13g2_tiehi
X_14606_ _14606_/Q _14670_/CLK _14606_/D _14606_/RESET_B VDD VSS sg13g2_dfrbpq_1
X_11818_ _11818_/Y _11826_/A1 _14476_/Q VDD VSS sg13g2_nand2b_1
X_12798_ _12798_/Y _12911_/B _12801_/B _12794_/X VDD VSS sg13g2_o21ai_1
XFILLER_18_1044 VDD VSS sg13g2_decap_8
XFILLER_15_994 VDD VSS sg13g2_decap_8
XFILLER_30_942 VDD VSS sg13g2_decap_8
X_14537_ _14537_/Q _14722_/CLK _14537_/D _14537_/RESET_B VDD VSS sg13g2_dfrbpq_1
X_11749_ _11749_/Y _11531_/A _14410_/Q _12187_/C VDD VSS sg13g2_a21oi_1
XFILLER_147_627 VDD VSS sg13g2_decap_4
X_13871__2693 _13871_/RESET_B VDD VSS sg13g2_tiehi
XFILLER_105_1047 VDD VSS sg13g2_decap_4
XFILLER_147_649 VDD VSS sg13g2_decap_4
X_14468_ _14468_/Q clkload30/A _14468_/D _14468_/RESET_B VDD VSS sg13g2_dfrbpq_1
X_13419_ _13419_/Y _13412_/B _13412_/C _15094_/Q VDD VSS sg13g2_o21ai_1
X_14399_ _14399_/Q clkload56/A _14399_/D _14399_/RESET_B VDD VSS sg13g2_dfrbpq_1
XFILLER_142_310 VDD VSS sg13g2_fill_2
XFILLER_127_395 VDD VSS sg13g2_decap_8
XFILLER_142_343 VDD VSS sg13g2_decap_8
X_08960_ _09441_/C _09204_/C _09204_/D VDD VSS sg13g2_nor2_1
XFILLER_130_505 VDD VSS sg13g2_decap_8
XFILLER_29_1151 VDD VSS sg13g2_decap_8
XFILLER_64_1031 VDD VSS sg13g2_fill_2
XFILLER_38_0 VDD VSS sg13g2_decap_8
X_07911_ _07911_/Y _08463_/A _07870_/A VDD VSS sg13g2_nor2b_1
XFILLER_97_931 VDD VSS sg13g2_decap_8
XFILLER_155_1170 VDD VSS sg13g2_decap_8
XFILLER_25_1004 VDD VSS sg13g2_decap_8
X_08891_ _08891_/X _08890_/X _11726_/A _08940_/S VDD VSS sg13g2_mux2_1
XFILLER_96_430 VDD VSS sg13g2_fill_1
XFILLER_116_1132 VDD VSS sg13g2_fill_1
X_15138__3066 _15138_/RESET_B VDD VSS sg13g2_tiehi
X_07842_ _08678_/A _08654_/A _07841_/Y VDD VSS sg13g2_nor2b_1
XFILLER_29_508 VDD VSS sg13g2_fill_2
XFILLER_97_986 VDD VSS sg13g2_fill_2
XFILLER_111_796 VDD VSS sg13g2_fill_2
X_07773_ _07773_/Y _08306_/B _07775_/A VDD VSS sg13g2_nor2b_1
XFILLER_49_390 VDD VSS sg13g2_decap_4
XFILLER_17_28 VDD VSS sg13g2_decap_8
XFILLER_83_146 VDD VSS sg13g2_fill_2
X_09512_ _14111_/D _09646_/A0 _14111_/Q _09512_/S VDD VSS sg13g2_mux2_1
XFILLER_37_585 VDD VSS sg13g2_fill_2
X_09443_ _14044_/D _10105_/A _14044_/Q wire671/A VDD VSS sg13g2_mux2_1
XFILLER_64_382 VDD VSS sg13g2_decap_8
X_09374_ _13978_/D _10102_/A0 _13978_/Q _09374_/S VDD VSS sg13g2_mux2_1
X_08325_ _08325_/Y _08414_/A _08654_/B VDD VSS sg13g2_nor2_1
XFILLER_21_942 VDD VSS sg13g2_decap_8
XFILLER_123_1103 VDD VSS sg13g2_fill_1
XFILLER_149_49 VDD VSS sg13g2_decap_8
X_13701__2863 _13701_/RESET_B VDD VSS sg13g2_tiehi
X_08256_ _08256_/Y _08256_/A _08329_/B VDD VSS sg13g2_nand2_1
XFILLER_119_863 VDD VSS sg13g2_decap_8
X_08187_ _15223_/D _08187_/A _08187_/B _08187_/C VDD VSS sg13g2_nand3_1
XFILLER_119_874 VDD VSS sg13g2_fill_2
XFILLER_116_7 VDD VSS sg13g2_decap_8
XFILLER_119_885 VDD VSS sg13g2_decap_8
X_14045__2519 _14045_/RESET_B VDD VSS sg13g2_tiehi
XFILLER_133_332 VDD VSS sg13g2_fill_1
XFILLER_82_1120 VDD VSS sg13g2_decap_8
X_10080_ _14660_/D _10080_/A0 _14660_/Q _10084_/S VDD VSS sg13g2_mux2_1
XFILLER_102_730 VDD VSS sg13g2_decap_4
XFILLER_43_1126 VDD VSS sg13g2_decap_8
XFILLER_82_1186 VDD VSS sg13g2_decap_8
XFILLER_88_997 VDD VSS sg13g2_decap_4
X_14260__2304 _14260_/RESET_B VDD VSS sg13g2_tiehi
XFILLER_48_839 VDD VSS sg13g2_decap_8
X_13770_ _13770_/Q clkload21/A _13770_/D _13770_/RESET_B VDD VSS sg13g2_dfrbpq_1
XFILLER_56_883 VDD VSS sg13g2_fill_1
X_10982_ _10982_/X wire385/X _11042_/A VDD VSS sg13g2_xor2_1
XFILLER_74_78 VDD VSS sg13g2_fill_1
X_12721_ wire369/A _13667_/Q _12749_/A2 _12720_/X _12749_/B2 _12749_/C1 VDD VSS sg13g2_a221oi_1
XFILLER_83_691 VDD VSS sg13g2_fill_1
XFILLER_128_1003 VDD VSS sg13g2_decap_8
XFILLER_16_769 VDD VSS sg13g2_fill_1
X_14998__2974 _14998_/RESET_B VDD VSS sg13g2_tiehi
XFILLER_71_886 VDD VSS sg13g2_decap_8
X_12652_ _15010_/D _12652_/A wire374/X VDD VSS sg13g2_nor2_1
XFILLER_128_1047 VDD VSS sg13g2_decap_8
XFILLER_142_0 VDD VSS sg13g2_decap_8
XFILLER_24_791 VDD VSS sg13g2_fill_1
XFILLER_12_931 VDD VSS sg13g2_decap_8
X_11603_ _11603_/Y _11597_/A _14598_/Q _11598_/C VDD VSS sg13g2_a21oi_1
XFILLER_90_55 VDD VSS sg13g2_fill_2
X_14915__3099 _14915_/RESET_B VDD VSS sg13g2_tiehi
XFILLER_15_1206 VDD VSS sg13g2_decap_8
X_12583_ _15005_/D _12583_/A wire378/X VDD VSS sg13g2_nor2_1
XFILLER_141_1225 VDD VSS sg13g2_decap_8
XFILLER_141_1236 VDD VSS sg13g2_fill_1
XFILLER_12_975 VDD VSS sg13g2_decap_8
X_14322_ _14322_/Q clkload46/A _14322_/D _14322_/RESET_B VDD VSS sg13g2_dfrbpq_1
X_11534_ _11535_/A _13956_/Q _13988_/Q _14020_/Q _14052_/Q _11531_/A _12248_/B1 VDD
+ VSS sg13g2_mux4_1
Xwire321 wire321/X wire321/A VDD VSS sg13g2_buf_4
X_14253_ _14253_/Q clkload45/A _14253_/D _14253_/RESET_B VDD VSS sg13g2_dfrbpq_1
Xwire365 wire365/X wire365/A VDD VSS sg13g2_buf_2
XFILLER_156_479 VDD VSS sg13g2_decap_8
X_11465_ _11465_/Y _11463_/Y _11465_/B VDD VSS sg13g2_nand2b_1
Xwire376 wire376/X wire376/A VDD VSS sg13g2_buf_2
XFILLER_104_1080 VDD VSS sg13g2_fill_1
XFILLER_109_351 VDD VSS sg13g2_decap_8
XFILLER_7_478 VDD VSS sg13g2_decap_8
XFILLER_87_1020 VDD VSS sg13g2_decap_8
X_13204_ _13204_/Y _13224_/A _13204_/B VDD VSS sg13g2_xnor2_1
Xwire398 wire398/X wire398/A VDD VSS sg13g2_buf_2
X_10416_ _10416_/Y _14828_/Q _10415_/A _13363_/B VDD VSS sg13g2_o21ai_1
X_14184_ _14184_/Q clkload36/A _14184_/D _14184_/RESET_B VDD VSS sg13g2_dfrbpq_1
X_11396_ _11396_/Y _11392_/Y _11393_/X _11395_/Y VDD VSS sg13g2_o21ai_1
XFILLER_125_855 VDD VSS sg13g2_decap_8
XFILLER_139_1132 VDD VSS sg13g2_decap_8
X_13135_ _13135_/Y _13170_/B _13131_/Y _13134_/Y VDD VSS sg13g2_a21oi_1
XFILLER_151_140 VDD VSS sg13g2_decap_8
X_10347_ _14808_/D _10352_/C _10347_/B _10347_/C VDD VSS sg13g2_nor3_1
XFILLER_152_674 VDD VSS sg13g2_decap_8
XFILLER_139_1176 VDD VSS sg13g2_decap_8
XFILLER_125_899 VDD VSS sg13g2_decap_8
XFILLER_3_673 VDD VSS sg13g2_decap_8
XFILLER_98_739 VDD VSS sg13g2_decap_4
XFILLER_155_70 VDD VSS sg13g2_decap_8
XFILLER_139_1187 VDD VSS sg13g2_fill_2
XFILLER_140_847 VDD VSS sg13g2_fill_2
XFILLER_139_1198 VDD VSS sg13g2_fill_1
XFILLER_2_161 VDD VSS sg13g2_decap_8
XFILLER_31_7 VDD VSS sg13g2_decap_8
X_13066_ _13066_/Y _13066_/A _13172_/A wire234/X VDD VSS sg13g2_nor3_1
X_10278_ _10311_/A _14784_/Q _14785_/Q _10278_/C _10305_/B VDD VSS sg13g2_and4_1
XFILLER_105_590 VDD VSS sg13g2_fill_1
XFILLER_2_194 VDD VSS sg13g2_fill_1
XFILLER_61_1215 VDD VSS sg13g2_fill_1
XFILLER_79_975 VDD VSS sg13g2_fill_1
XFILLER_39_817 VDD VSS sg13g2_fill_2
Xfanout1430 _08591_/A3 _11983_/A VDD VSS sg13g2_buf_1
X_12017_ _12018_/B _12017_/A _13938_/Q VDD VSS sg13g2_nand2_1
X_15073__3242 _15073_/RESET_B VDD VSS sg13g2_tiehi
XFILLER_66_603 VDD VSS sg13g2_decap_8
Xfanout1441 _11865_/A _14976_/Q VDD VSS sg13g2_buf_1
Xfanout1452 _08383_/A _07794_/A VDD VSS sg13g2_buf_1
XFILLER_38_316 VDD VSS sg13g2_fill_1
Xfanout1463 _11635_/A _14969_/Q VDD VSS sg13g2_buf_1
XFILLER_78_485 VDD VSS sg13g2_decap_8
XFILLER_93_411 VDD VSS sg13g2_fill_2
Xfanout1474 _07768_/A _08300_/A3 VDD VSS sg13g2_buf_1
Xfanout1485 _07870_/A _11428_/A VDD VSS sg13g2_buf_1
XFILLER_120_593 VDD VSS sg13g2_decap_8
Xfanout1496 _12884_/C _12900_/C VDD VSS sg13g2_buf_1
X_13889__2675 _13889_/RESET_B VDD VSS sg13g2_tiehi
XFILLER_4_1153 VDD VSS sg13g2_decap_8
XFILLER_24_1092 VDD VSS sg13g2_decap_8
X_13968_ _13968_/Q clkload49/A _13968_/D _13968_/RESET_B VDD VSS sg13g2_dfrbpq_1
XFILLER_47_894 VDD VSS sg13g2_decap_4
XFILLER_59_1133 VDD VSS sg13g2_decap_4
XFILLER_98_1193 VDD VSS sg13g2_decap_8
XFILLER_0_86 VDD VSS sg13g2_decap_4
X_12919_ wire568/A _12916_/Y _12917_/Y _12918_/Y VDD VSS sg13g2_a21oi_1
X_13899_ _13899_/Q clkload50/A _13899_/D _13899_/RESET_B VDD VSS sg13g2_dfrbpq_1
XFILLER_94_1079 VDD VSS sg13g2_decap_8
XFILLER_21_205 VDD VSS sg13g2_fill_1
X_14269__2295 _14269_/RESET_B VDD VSS sg13g2_tiehi
X_08110_ _08112_/B _08110_/A _08110_/B _08110_/C _08110_/D VDD VSS sg13g2_nand4_1
XFILLER_9_84 VDD VSS sg13g2_decap_8
X_09090_ _09090_/Y _09090_/A _09090_/B _09090_/C VDD VSS sg13g2_nand3_1
XFILLER_31_1030 VDD VSS sg13g2_decap_8
X_08041_ _15218_/D _08003_/Y _08040_/Y _08002_/Y VDD VSS sg13g2_a21oi_1
X_14484__2080 _14484_/RESET_B VDD VSS sg13g2_tiehi
XFILLER_116_844 VDD VSS sg13g2_decap_8
Xmax_cap665 _09470_/S _09454_/S VDD VSS sg13g2_buf_4
Xmax_cap676 _09403_/S _09391_/S VDD VSS sg13g2_buf_4
X_09992_ _14575_/D _09992_/A0 _14575_/Q _09996_/S VDD VSS sg13g2_mux2_1
XFILLER_103_505 VDD VSS sg13g2_fill_2
XFILLER_153_1107 VDD VSS sg13g2_decap_8
Xmax_cap687 _09373_/S _09347_/S VDD VSS sg13g2_buf_4
Xmax_cap698 _09230_/S _09227_/S VDD VSS sg13g2_buf_4
XFILLER_131_836 VDD VSS sg13g2_fill_1
XFILLER_103_538 VDD VSS sg13g2_decap_8
X_08943_ _08943_/Y _08943_/A _14954_/Q VDD VSS sg13g2_nand2_1
XFILLER_103_549 VDD VSS sg13g2_fill_2
X_13676__2905 _13676_/RESET_B VDD VSS sg13g2_tiehi
XFILLER_130_324 VDD VSS sg13g2_fill_2
XFILLER_9_1064 VDD VSS sg13g2_decap_8
X_08874_ _08874_/X _15032_/Q _08877_/A _08873_/Y VDD VSS sg13g2_a21o_1
XFILLER_96_282 VDD VSS sg13g2_decap_8
XFILLER_28_49 VDD VSS sg13g2_fill_1
X_07825_ _08436_/B _15005_/Q _07825_/B VDD VSS sg13g2_or2_1
XFILLER_151_28 VDD VSS sg13g2_decap_8
XFILLER_56_135 VDD VSS sg13g2_fill_2
X_13719__2845 _13719_/RESET_B VDD VSS sg13g2_tiehi
XFILLER_38_872 VDD VSS sg13g2_decap_8
XFILLER_44_308 VDD VSS sg13g2_decap_8
X_07756_ _13305_/B _13499_/C _13308_/A VDD VSS sg13g2_nor2b_1
XFILLER_77_1233 VDD VSS sg13g2_decap_4
X_07687_ _07697_/A _07687_/A _07687_/B _07687_/C VDD VSS sg13g2_or3_1
X_09426_ _14028_/D _09956_/A1 _14028_/Q _09439_/S VDD VSS sg13g2_mux2_1
XFILLER_13_728 VDD VSS sg13g2_decap_8
XFILLER_12_205 VDD VSS sg13g2_decap_8
XFILLER_125_1209 VDD VSS sg13g2_fill_1
XFILLER_40_536 VDD VSS sg13g2_decap_4
X_13934__2630 _13934_/RESET_B VDD VSS sg13g2_tiehi
X_09357_ _13961_/D _09621_/A0 _13961_/Q _09370_/S VDD VSS sg13g2_mux2_1
X_14694__1870 _14694_/RESET_B VDD VSS sg13g2_tiehi
Xclkbuf_5_3__f_clk_i clkbuf_5_3__f_clk_i/X clkbuf_4_1_0_clk_i/X VDD VSS sg13g2_buf_16
XFILLER_40_569 VDD VSS sg13g2_decap_8
XFILLER_127_1080 VDD VSS sg13g2_decap_8
XFILLER_60_14 VDD VSS sg13g2_decap_8
X_08308_ _08308_/X _08131_/Y _08363_/S0 _08027_/Y VDD VSS sg13g2_a21o_1
X_09288_ _13896_/D _13896_/Q _09787_/A0 wire496/X VDD VSS sg13g2_mux2_1
XFILLER_154_917 VDD VSS sg13g2_decap_8
X_08239_ _08239_/Y _08265_/B _08306_/A _08318_/A _08565_/A2 _08238_/Y VDD VSS sg13g2_a221oi_1
XFILLER_107_822 VDD VSS sg13g2_fill_2
X_14314__2250 _14314_/RESET_B VDD VSS sg13g2_tiehi
XFILLER_10_1136 VDD VSS sg13g2_decap_8
X_11250_ _14957_/D _11248_/Y _11237_/Y _11249_/Y VDD VSS sg13g2_a21oi_1
X_13967__2597 _13967_/RESET_B VDD VSS sg13g2_tiehi
XFILLER_109_74 VDD VSS sg13g2_decap_8
XFILLER_69_34 VDD VSS sg13g2_fill_2
X_10201_ _15182_/D hold3443/X _10201_/A1 _10205_/S VDD VSS sg13g2_mux2_1
X_11181_ _11181_/X _11181_/A _11181_/B VDD VSS sg13g2_xor2_1
XFILLER_107_899 VDD VSS sg13g2_decap_8
XFILLER_133_173 VDD VSS sg13g2_decap_4
X_10132_ _14710_/D _10132_/A0 _14710_/Q _10132_/S VDD VSS sg13g2_mux2_1
XFILLER_79_238 VDD VSS sg13g2_decap_8
XFILLER_133_195 VDD VSS sg13g2_fill_1
X_10063_ _14644_/D _10063_/A0 _14644_/Q _10063_/S VDD VSS sg13g2_mux2_1
X_14940_ _14940_/Q clkload35/A _14940_/D _14940_/RESET_B VDD VSS sg13g2_dfrbpq_1
XFILLER_94_219 VDD VSS sg13g2_decap_8
XFILLER_48_625 VDD VSS sg13g2_decap_4
XFILLER_76_934 VDD VSS sg13g2_decap_8
XFILLER_87_282 VDD VSS sg13g2_fill_2
X_14871_ _14871_/Q clkload78/A _14871_/D _14871_/RESET_B VDD VSS sg13g2_dfrbpq_1
XFILLER_85_77 VDD VSS sg13g2_fill_2
XFILLER_63_606 VDD VSS sg13g2_fill_1
XFILLER_78_1019 VDD VSS sg13g2_decap_8
X_13822_ _13822_/Q clkload59/A _13822_/D _13822_/RESET_B VDD VSS sg13g2_dfrbpq_1
XFILLER_90_403 VDD VSS sg13g2_fill_1
XFILLER_90_414 VDD VSS sg13g2_decap_8
XFILLER_91_937 VDD VSS sg13g2_fill_1
XFILLER_28_371 VDD VSS sg13g2_decap_4
XFILLER_91_959 VDD VSS sg13g2_decap_8
XFILLER_18_93 VDD VSS sg13g2_fill_1
X_13753_ _13753_/Q clkload43/A _13753_/D _13753_/RESET_B VDD VSS sg13g2_dfrbpq_1
X_10965_ _11042_/A _10965_/A _10965_/B _10965_/C VDD VSS sg13g2_nor3_1
X_12704_ _12704_/X _12700_/X _12701_/X _12699_/X _12698_/X _12733_/S0 _12762_/S VDD
+ VSS sg13g2_mux4_1
XFILLER_16_588 VDD VSS sg13g2_fill_1
X_13684_ _13684_/Q clkload39/A _13684_/D _13684_/RESET_B VDD VSS sg13g2_dfrbpq_1
XFILLER_43_385 VDD VSS sg13g2_fill_1
X_10896_ _10896_/Y _10948_/A _10893_/X _10895_/Y VDD VSS sg13g2_a21oi_1
XFILLER_70_193 VDD VSS sg13g2_fill_1
X_12635_ _12635_/X _12633_/X _12632_/X _12629_/X _12628_/X wire1081/X _12635_/S1 VDD
+ VSS sg13g2_mux4_1
XFILLER_15_1036 VDD VSS sg13g2_fill_2
X_12566_ _12566_/X _12562_/X _12561_/X _12558_/X _12557_/X _12566_/S0 _12706_/S VDD
+ VSS sg13g2_mux4_1
XFILLER_106_1153 VDD VSS sg13g2_decap_8
XFILLER_141_1077 VDD VSS sg13g2_fill_1
X_14305_ _14305_/Q _14465_/CLK _14305_/D _14305_/RESET_B VDD VSS sg13g2_dfrbpq_1
X_11517_ _11517_/X _11507_/X _11508_/X _11511_/X _11512_/X wire964/X _12217_/A VDD
+ VSS sg13g2_mux4_1
XFILLER_145_928 VDD VSS sg13g2_decap_8
XFILLER_89_1137 VDD VSS sg13g2_fill_1
XFILLER_106_1197 VDD VSS sg13g2_decap_8
X_12497_ _12497_/X _12495_/X _12496_/X _12497_/S VDD VSS sg13g2_mux2_1
XFILLER_8_787 VDD VSS sg13g2_fill_2
XFILLER_156_287 VDD VSS sg13g2_decap_8
XFILLER_156_298 VDD VSS sg13g2_fill_1
X_14236_ _14236_/Q _14776_/CLK _14236_/D _14236_/RESET_B VDD VSS sg13g2_dfrbpq_1
XFILLER_50_91 VDD VSS sg13g2_fill_1
X_11448_ _11448_/X _11448_/A _12075_/A _11448_/C VDD VSS sg13g2_and3_1
XFILLER_125_652 VDD VSS sg13g2_decap_8
X_14167_ _14167_/Q clkload9/A _14167_/D _14167_/RESET_B VDD VSS sg13g2_dfrbpq_1
XFILLER_152_460 VDD VSS sg13g2_decap_4
X_11379_ _11379_/Y _12334_/C _11378_/X _12001_/A VDD VSS sg13g2_a21oi_1
XFILLER_124_151 VDD VSS sg13g2_decap_8
XFILLER_124_162 VDD VSS sg13g2_fill_2
XFILLER_4_993 VDD VSS sg13g2_decap_8
X_13118_ _13170_/A _14914_/Q _13673_/Q VDD VSS sg13g2_xnor2_1
X_14098_ _14098_/Q _14706_/CLK _14098_/D _14098_/RESET_B VDD VSS sg13g2_dfrbpq_1
XFILLER_98_558 VDD VSS sg13g2_fill_2
XFILLER_140_655 VDD VSS sg13g2_fill_2
XFILLER_26_1121 VDD VSS sg13g2_decap_8
XFILLER_65_1170 VDD VSS sg13g2_fill_1
XFILLER_152_1140 VDD VSS sg13g2_decap_8
XFILLER_6_1215 VDD VSS sg13g2_decap_8
XFILLER_65_1192 VDD VSS sg13g2_fill_1
XFILLER_100_519 VDD VSS sg13g2_fill_1
X_13049_ _13049_/X _15062_/Q _15061_/Q VDD VSS sg13g2_or2_1
XFILLER_67_945 VDD VSS sg13g2_decap_4
Xfanout1260 _13481_/A _15127_/Q VDD VSS sg13g2_buf_1
Xfanout1271 _13150_/B _12930_/B1 VDD VSS sg13g2_buf_1
XFILLER_26_1198 VDD VSS sg13g2_decap_8
Xfanout1282 _08584_/A _08698_/B VDD VSS sg13g2_buf_1
XFILLER_66_444 VDD VSS sg13g2_fill_1
Xfanout1293 _10885_/A1 _10895_/B1 VDD VSS sg13g2_buf_1
XFILLER_93_252 VDD VSS sg13g2_decap_4
X_08590_ _08590_/Y _08625_/A _08590_/B VDD VSS sg13g2_nor2_1
XFILLER_93_285 VDD VSS sg13g2_fill_1
XFILLER_53_127 VDD VSS sg13g2_fill_2
XFILLER_93_296 VDD VSS sg13g2_decap_8
X_14356__2208 _14356_/RESET_B VDD VSS sg13g2_tiehi
XFILLER_50_812 VDD VSS sg13g2_fill_1
XFILLER_62_683 VDD VSS sg13g2_decap_8
X_09211_ _13822_/D _10074_/A0 _13822_/Q _09230_/S VDD VSS sg13g2_mux2_1
XFILLER_50_845 VDD VSS sg13g2_fill_1
XFILLER_22_547 VDD VSS sg13g2_decap_8
XFILLER_33_1103 VDD VSS sg13g2_decap_8
XFILLER_124_1220 VDD VSS sg13g2_decap_8
XFILLER_33_1114 VDD VSS sg13g2_fill_1
X_09142_ _09157_/D _13245_/A _14921_/Q _13199_/A VDD VSS sg13g2_and3_1
X_09073_ _10735_/B _09100_/B _15039_/Q _09072_/Y VDD VSS sg13g2_o21ai_1
XFILLER_30_28 VDD VSS sg13g2_decap_8
X_08024_ _08025_/C _13601_/A _08063_/B _08171_/A1 _08142_/C _07626_/A _07884_/A VDD
+ VSS sg13g2_mux4_1
XFILLER_146_28 VDD VSS sg13g2_decap_8
XFILLER_116_630 VDD VSS sg13g2_decap_4
Xmax_cap440 _09765_/S _09766_/S VDD VSS sg13g2_buf_4
XFILLER_116_663 VDD VSS sg13g2_fill_2
XFILLER_1_429 VDD VSS sg13g2_decap_8
Xmax_cap484 _09336_/S _09335_/S VDD VSS sg13g2_buf_4
XFILLER_104_836 VDD VSS sg13g2_decap_8
XFILLER_118_1013 VDD VSS sg13g2_decap_8
X_09975_ _14558_/D _10074_/A0 _14558_/Q _10003_/S VDD VSS sg13g2_mux2_1
XFILLER_118_1057 VDD VSS sg13g2_decap_4
X_08926_ _13714_/D _16876_/A _08925_/X _08926_/S VDD VSS sg13g2_mux2_1
XFILLER_103_379 VDD VSS sg13g2_fill_2
XFILLER_97_580 VDD VSS sg13g2_decap_8
XFILLER_130_187 VDD VSS sg13g2_decap_4
XFILLER_97_591 VDD VSS sg13g2_fill_1
X_14602__1962 _14602_/RESET_B VDD VSS sg13g2_tiehi
XFILLER_58_967 VDD VSS sg13g2_decap_8
X_08857_ _08857_/X _08856_/X _11461_/A _08882_/S VDD VSS sg13g2_mux2_1
XFILLER_84_230 VDD VSS sg13g2_fill_1
XFILLER_55_14 VDD VSS sg13g2_decap_8
X_07808_ _07808_/Y _15012_/Q _08541_/B VDD VSS sg13g2_nor2_1
XFILLER_17_319 VDD VSS sg13g2_fill_1
X_08788_ _08788_/Y _13345_/B _14757_/Q _10199_/A1 _07719_/X VDD VSS sg13g2_a22oi_1
XFILLER_84_296 VDD VSS sg13g2_decap_4
X_07739_ _15209_/D _13284_/B _07738_/Y _07714_/Y VDD VSS sg13g2_o21ai_1
X_10750_ _10750_/Y _14915_/Q _11084_/B VDD VSS sg13g2_nand2_1
XFILLER_13_514 VDD VSS sg13g2_decap_8
XFILLER_53_683 VDD VSS sg13g2_decap_8
X_09409_ _14011_/D _09741_/A1 _14011_/Q _09410_/S VDD VSS sg13g2_mux2_1
XFILLER_38_1069 VDD VSS sg13g2_decap_8
XFILLER_71_35 VDD VSS sg13g2_decap_4
XFILLER_125_1017 VDD VSS sg13g2_fill_1
XFILLER_40_333 VDD VSS sg13g2_decap_8
XFILLER_9_507 VDD VSS sg13g2_decap_8
X_10681_ _10681_/Y _10681_/A _10800_/B VDD VSS sg13g2_nand2_1
X_12420_ _12420_/X _14368_/Q _14400_/Q _14464_/Q _14496_/Q _12424_/S0 _12508_/S1 VDD
+ VSS sg13g2_mux4_1
XFILLER_51_1236 VDD VSS sg13g2_fill_1
X_12351_ _12351_/X _14363_/Q _14395_/Q _14459_/Q _14491_/Q _12351_/S0 _12351_/S1 VDD
+ VSS sg13g2_mux4_1
X_11302_ _11302_/Y _11310_/A1 _14557_/Q VDD VSS sg13g2_nand2b_1
XFILLER_153_224 VDD VSS sg13g2_decap_8
X_15070_ _15070_/Q clkload65/A _15070_/D _15070_/RESET_B VDD VSS sg13g2_dfrbpq_1
X_12282_ _12282_/X _13753_/Q _14105_/Q _14457_/Q _14553_/Q _12285_/S0 _12285_/S1 VDD
+ VSS sg13g2_mux4_1
XFILLER_49_1110 VDD VSS sg13g2_decap_8
XFILLER_5_768 VDD VSS sg13g2_decap_8
X_14021_ _14021_/Q clkload0/A _14021_/D _14021_/RESET_B VDD VSS sg13g2_dfrbpq_1
XFILLER_105_0 VDD VSS sg13g2_decap_8
XFILLER_107_652 VDD VSS sg13g2_decap_8
X_11233_ _11233_/Y _15117_/Q _15118_/Q _14760_/Q VDD VSS sg13g2_nor3_1
XFILLER_49_1143 VDD VSS sg13g2_decap_8
XFILLER_49_1154 VDD VSS sg13g2_fill_1
XFILLER_136_1113 VDD VSS sg13g2_fill_1
XFILLER_134_471 VDD VSS sg13g2_decap_8
XFILLER_49_1165 VDD VSS sg13g2_decap_8
XFILLER_150_942 VDD VSS sg13g2_decap_8
X_11164_ _11181_/B _11164_/A _11164_/B _11164_/C _11190_/C VDD VSS sg13g2_nor4_1
XFILLER_45_1029 VDD VSS sg13g2_decap_8
XFILLER_68_709 VDD VSS sg13g2_fill_2
XFILLER_110_806 VDD VSS sg13g2_decap_8
X_10115_ _14693_/D _10115_/A0 _14693_/Q _10129_/S VDD VSS sg13g2_mux2_1
X_11095_ _11095_/Y _11095_/A _11095_/B VDD VSS sg13g2_nor2_1
XFILLER_122_699 VDD VSS sg13g2_fill_2
XFILLER_1_996 VDD VSS sg13g2_fill_2
XFILLER_0_495 VDD VSS sg13g2_decap_8
X_10046_ _14627_/D _10146_/A1 _14627_/Q _10066_/S VDD VSS sg13g2_mux2_1
X_14923_ _14923_/Q _15248_/CLK _14923_/D _14923_/RESET_B VDD VSS sg13g2_dfrbpq_1
XFILLER_91_701 VDD VSS sg13g2_decap_8
X_14854_ _14854_/Q _14854_/CLK _14854_/D _14854_/RESET_B VDD VSS sg13g2_dfrbpq_1
XFILLER_21_1040 VDD VSS sg13g2_decap_8
XFILLER_90_200 VDD VSS sg13g2_decap_8
XFILLER_35_116 VDD VSS sg13g2_fill_1
XFILLER_64_948 VDD VSS sg13g2_fill_2
XFILLER_91_745 VDD VSS sg13g2_decap_8
X_13805_ _13805_/Q clkload55/A _13805_/D _13805_/RESET_B VDD VSS sg13g2_dfrbpq_1
XFILLER_63_458 VDD VSS sg13g2_decap_8
X_14785_ _14785_/Q clkload81/A _14785_/D _14785_/RESET_B VDD VSS sg13g2_dfrbpq_1
X_11997_ _11997_/X _13745_/Q _14097_/Q _14449_/Q _14545_/Q _11997_/S0 _11997_/S1 VDD
+ VSS sg13g2_mux4_1
XFILLER_1_1167 VDD VSS sg13g2_decap_8
XFILLER_95_1152 VDD VSS sg13g2_decap_4
XFILLER_32_801 VDD VSS sg13g2_decap_8
XFILLER_1_1178 VDD VSS sg13g2_fill_1
XFILLER_44_661 VDD VSS sg13g2_decap_8
XFILLER_1_1189 VDD VSS sg13g2_decap_4
X_13736_ _13736_/Q clkload28/A _13736_/D _13736_/RESET_B VDD VSS sg13g2_dfrbpq_1
XFILLER_56_1136 VDD VSS sg13g2_decap_8
X_10948_ _11005_/A _10948_/A _10948_/B _10948_/C _10948_/D VDD VSS sg13g2_or4_1
XFILLER_31_311 VDD VSS sg13g2_fill_1
XFILLER_71_480 VDD VSS sg13g2_fill_2
XFILLER_43_193 VDD VSS sg13g2_fill_1
XFILLER_91_1049 VDD VSS sg13g2_decap_4
XFILLER_149_519 VDD VSS sg13g2_fill_1
X_10879_ _10879_/Y _14754_/Q wire584/X VDD VSS sg13g2_nand2b_1
X_13667_ _13667_/Q _15214_/CLK _13667_/D _13667_/RESET_B VDD VSS sg13g2_dfrbpq_1
X_14040__2524 _14040_/RESET_B VDD VSS sg13g2_tiehi
XFILLER_31_377 VDD VSS sg13g2_fill_1
X_12618_ _12618_/X _13742_/Q _14094_/Q _14446_/Q _14542_/Q _12620_/S0 _12620_/S1 VDD
+ VSS sg13g2_mux4_1
X_13598_ _15164_/D _13597_/Y _13508_/C _13595_/Y VDD VSS sg13g2_a21oi_1
X_15171__1814 _15171_/RESET_B VDD VSS sg13g2_tiehi
XFILLER_8_540 VDD VSS sg13g2_decap_8
XFILLER_8_551 VDD VSS sg13g2_fill_1
X_12549_ _12549_/X _14121_/Q _14153_/Q _14185_/Q _14217_/Q _12550_/S0 _12550_/S1 VDD
+ VSS sg13g2_mux4_1
XFILLER_118_928 VDD VSS sg13g2_decap_4
XFILLER_8_573 VDD VSS sg13g2_decap_4
XFILLER_8_595 VDD VSS sg13g2_decap_4
XANTENNA_1 _15166_/Q VDD VSS sg13g2_antennanp
XFILLER_6_63 VDD VSS sg13g2_decap_8
XFILLER_126_961 VDD VSS sg13g2_fill_1
XFILLER_67_1232 VDD VSS sg13g2_decap_4
X_14219_ _14219_/Q _14667_/CLK _14219_/D _14219_/RESET_B VDD VSS sg13g2_dfrbpq_1
X_15199_ _15199_/Q _15214_/CLK _15199_/D _15199_/RESET_B VDD VSS sg13g2_dfrbpq_1
XFILLER_141_920 VDD VSS sg13g2_decap_8
XFILLER_28_1227 VDD VSS sg13g2_decap_8
XFILLER_63_1107 VDD VSS sg13g2_decap_8
XFILLER_98_333 VDD VSS sg13g2_decap_8
Xfanout508 _09261_/S wire510/A VDD VSS sg13g2_buf_1
XFILLER_140_430 VDD VSS sg13g2_fill_2
XFILLER_99_867 VDD VSS sg13g2_decap_4
XFILLER_112_154 VDD VSS sg13g2_decap_4
XFILLER_115_1219 VDD VSS sg13g2_decap_8
X_09760_ _14350_/D _14350_/Q _09925_/A1 _09760_/S VDD VSS sg13g2_mux2_1
XFILLER_140_474 VDD VSS sg13g2_decap_8
XFILLER_100_316 VDD VSS sg13g2_decap_4
XFILLER_20_0 VDD VSS sg13g2_decap_8
XFILLER_79_591 VDD VSS sg13g2_fill_1
X_08711_ _15188_/D hold3447/X _15188_/Q _13333_/S VDD VSS sg13g2_mux2_1
X_09691_ _14283_/D _09691_/A0 _14283_/Q _09705_/S VDD VSS sg13g2_mux2_1
XFILLER_67_764 VDD VSS sg13g2_decap_8
X_14856__3217 _14856_/RESET_B VDD VSS sg13g2_tiehi
XFILLER_82_701 VDD VSS sg13g2_fill_2
X_08642_ _08642_/Y _08573_/A _08575_/Y _08641_/Y VDD VSS sg13g2_o21ai_1
XFILLER_6_1089 VDD VSS sg13g2_decap_8
XFILLER_26_105 VDD VSS sg13g2_decap_8
XFILLER_39_499 VDD VSS sg13g2_fill_2
XFILLER_54_425 VDD VSS sg13g2_decap_8
XFILLER_66_296 VDD VSS sg13g2_fill_1
XFILLER_26_138 VDD VSS sg13g2_decap_8
XFILLER_148_1028 VDD VSS sg13g2_decap_8
X_08573_ _08573_/Y _08573_/A VDD VSS sg13g2_inv_1
XFILLER_25_28 VDD VSS sg13g2_decap_8
XFILLER_63_992 VDD VSS sg13g2_decap_8
XFILLER_62_491 VDD VSS sg13g2_fill_2
XFILLER_23_856 VDD VSS sg13g2_decap_8
Xclkbuf_5_21__f_clk_i clkbuf_leaf_38_clk_i/A clkbuf_4_10_0_clk_i/X VDD VSS sg13g2_buf_16
X_09125_ _09125_/X _09137_/A _09125_/B _09157_/C VDD VSS sg13g2_or3_1
XFILLER_108_405 VDD VSS sg13g2_decap_4
XFILLER_11_1231 VDD VSS sg13g2_decap_4
X_09056_ _09089_/C _14909_/Q _14908_/Q _09056_/C VDD VSS sg13g2_and3_1
X_14802__3296 _14802_/RESET_B VDD VSS sg13g2_tiehi
XFILLER_2_705 VDD VSS sg13g2_decap_8
X_08007_ _08008_/B _08005_/X _08146_/A _08213_/S VDD VSS sg13g2_mux2_1
XFILLER_123_419 VDD VSS sg13g2_fill_2
XFILLER_132_920 VDD VSS sg13g2_decap_8
XFILLER_9_7 VDD VSS sg13g2_decap_8
X_13884__2680 _13884_/RESET_B VDD VSS sg13g2_tiehi
XFILLER_1_237 VDD VSS sg13g2_decap_4
XFILLER_103_121 VDD VSS sg13g2_decap_8
X_15075__3234 _15075_/RESET_B VDD VSS sg13g2_tiehi
XFILLER_104_666 VDD VSS sg13g2_decap_8
XFILLER_77_506 VDD VSS sg13g2_fill_2
XFILLER_131_452 VDD VSS sg13g2_decap_8
XFILLER_103_165 VDD VSS sg13g2_fill_1
X_09958_ _14542_/D _14542_/Q _09991_/A0 _09961_/S VDD VSS sg13g2_mux2_1
XFILLER_66_35 VDD VSS sg13g2_decap_8
X_08909_ _08909_/Y _11865_/A _08925_/S _08908_/Y VDD VSS sg13g2_a21oi_1
X_09889_ _14475_/D _09922_/A1 _14475_/Q _09903_/S VDD VSS sg13g2_mux2_1
XFILLER_85_561 VDD VSS sg13g2_fill_1
XFILLER_100_861 VDD VSS sg13g2_fill_1
XFILLER_131_1065 VDD VSS sg13g2_decap_8
X_11920_ _11920_/X _13839_/Q _13871_/Q _13903_/Q _13935_/Q _12072_/S0 _12072_/S1 VDD
+ VSS sg13g2_mux4_1
X_11851_ _11851_/X _14125_/Q _14157_/Q _14189_/Q _14221_/Q _11852_/S0 _11419_/C VDD
+ VSS sg13g2_mux4_1
XFILLER_61_918 VDD VSS sg13g2_decap_8
XFILLER_45_469 VDD VSS sg13g2_decap_8
XFILLER_54_970 VDD VSS sg13g2_fill_2
XFILLER_122_85 VDD VSS sg13g2_decap_8
X_10802_ _10802_/Y _10802_/A _12346_/A VDD VSS sg13g2_nor2b_1
XFILLER_122_96 VDD VSS sg13g2_decap_8
X_14570_ _14570_/Q clkload21/A _14570_/D _14570_/RESET_B VDD VSS sg13g2_dfrbpq_1
XFILLER_54_981 VDD VSS sg13g2_fill_1
X_11782_ _11782_/X _13835_/Q _13867_/Q _13899_/Q _13931_/Q _12288_/S0 _12288_/S1 VDD
+ VSS sg13g2_mux4_1
X_13521_ _13521_/X _13521_/A _13537_/B VDD VSS sg13g2_and2_1
X_10733_ _10734_/A _14911_/Q _11074_/B _11082_/B1 _11002_/A VDD VSS sg13g2_a22oi_1
XFILLER_55_1180 VDD VSS sg13g2_decap_8
X_13452_ _13454_/C _15184_/Q _15185_/Q VDD VSS sg13g2_nor2_1
X_10664_ _14893_/D _10664_/A _13507_/A _10664_/C VDD VSS sg13g2_nor3_1
XFILLER_90_1071 VDD VSS sg13g2_decap_8
XFILLER_16_1153 VDD VSS sg13g2_decap_8
XFILLER_142_1161 VDD VSS sg13g2_fill_1
XFILLER_40_196 VDD VSS sg13g2_decap_8
X_12403_ _12403_/Y _13499_/B _12403_/A2 _13561_/A0 VDD VSS sg13g2_a21oi_1
XFILLER_12_1017 VDD VSS sg13g2_decap_8
XFILLER_51_1066 VDD VSS sg13g2_decap_8
X_13383_ _15080_/D _13378_/C _13455_/A _13380_/Y VDD VSS sg13g2_o21ai_1
X_10595_ _14875_/D _10595_/A _10595_/B _10595_/C VDD VSS sg13g2_nor3_1
XFILLER_12_1039 VDD VSS sg13g2_decap_8
XFILLER_127_747 VDD VSS sg13g2_decap_8
X_15122_ _15122_/Q _15250_/CLK _15122_/D _15122_/RESET_B VDD VSS sg13g2_dfrbpq_1
X_12334_ _12334_/Y _12332_/Y _12334_/B _12334_/C VDD VSS sg13g2_nand3b_1
X_15053_ _15053_/Q _15209_/CLK _15053_/D _15053_/RESET_B VDD VSS sg13g2_dfrbpq_1
X_12265_ _12265_/Y _12260_/X _12265_/A2 _12265_/B1 VDD VSS sg13g2_a21oi_1
X_14004_ _14004_/Q clkload16/A _14004_/D _14004_/RESET_B VDD VSS sg13g2_dfrbpq_1
X_11216_ _11224_/B _11216_/A _11216_/B VDD VSS sg13g2_nor2_1
X_13714__2850 _13714_/RESET_B VDD VSS sg13g2_tiehi
X_12196_ _14984_/D _12156_/Y _12195_/Y _12150_/Y VDD VSS sg13g2_a21oi_1
Xoutput60 mem_axi_araddr[30] _13721_/Q VDD VSS sg13g2_buf_1
XFILLER_123_975 VDD VSS sg13g2_decap_8
Xoutput71 mem_axi_awaddr[10] _16863_/X VDD VSS sg13g2_buf_1
Xoutput82 mem_axi_awaddr[21] _16874_/X VDD VSS sg13g2_buf_1
Xoutput93 mem_axi_awaddr[31] _16884_/X VDD VSS sg13g2_buf_1
X_11147_ _11147_/Y _11147_/A _11163_/A VDD VSS sg13g2_nand2_1
XFILLER_96_837 VDD VSS sg13g2_decap_4
X_11078_ wire211/A _11078_/A _11078_/B _11097_/A _11078_/D VDD VSS sg13g2_nor4_1
X_14058__2506 _14058_/RESET_B VDD VSS sg13g2_tiehi
XFILLER_49_775 VDD VSS sg13g2_decap_8
XFILLER_49_786 VDD VSS sg13g2_fill_1
XFILLER_37_937 VDD VSS sg13g2_decap_8
XFILLER_48_263 VDD VSS sg13g2_decap_8
X_14906_ _14906_/Q clkload35/A _14906_/D _14906_/RESET_B VDD VSS sg13g2_dfrbpq_1
XFILLER_64_712 VDD VSS sg13g2_decap_8
X_10029_ _14611_/D _10062_/A0 _14611_/Q _10029_/S VDD VSS sg13g2_mux2_1
XFILLER_23_1168 VDD VSS sg13g2_decap_8
XFILLER_37_948 VDD VSS sg13g2_fill_1
XFILLER_91_520 VDD VSS sg13g2_decap_8
XFILLER_97_1236 VDD VSS sg13g2_fill_1
XFILLER_110_1149 VDD VSS sg13g2_decap_4
X_14837_ _14837_/Q _14873_/CLK _14837_/D _14837_/RESET_B VDD VSS sg13g2_dfrbpq_1
XFILLER_51_406 VDD VSS sg13g2_decap_8
XFILLER_63_266 VDD VSS sg13g2_fill_2
XFILLER_17_672 VDD VSS sg13g2_fill_1
XFILLER_23_119 VDD VSS sg13g2_decap_4
XFILLER_63_288 VDD VSS sg13g2_fill_1
X_14768_ _14768_/Q clkload74/A _14768_/D _14768_/RESET_B VDD VSS sg13g2_dfrbpq_1
XFILLER_108_1001 VDD VSS sg13g2_fill_1
X_13719_ _16881_/A _15046_/CLK _13719_/D _13719_/RESET_B VDD VSS sg13g2_dfrbpq_1
XFILLER_60_962 VDD VSS sg13g2_decap_8
X_14699_ _14699_/Q clkload44/A _14699_/D _14699_/RESET_B VDD VSS sg13g2_dfrbpq_1
XFILLER_34_1220 VDD VSS sg13g2_decap_8
XFILLER_108_1089 VDD VSS sg13g2_decap_8
XFILLER_68_0 VDD VSS sg13g2_decap_8
XFILLER_132_205 VDD VSS sg13g2_decap_8
XFILLER_105_419 VDD VSS sg13g2_decap_8
XFILLER_99_631 VDD VSS sg13g2_fill_2
XFILLER_119_1130 VDD VSS sg13g2_fill_2
XFILLER_28_1024 VDD VSS sg13g2_decap_8
XFILLER_67_1095 VDD VSS sg13g2_decap_8
XFILLER_8_1118 VDD VSS sg13g2_decap_8
XFILLER_87_826 VDD VSS sg13g2_decap_8
X_09812_ _14400_/D _09911_/A1 _14400_/Q _09831_/S VDD VSS sg13g2_mux2_1
Xfanout338 _09421_/S _09436_/S VDD VSS sg13g2_buf_1
Xfanout349 _09916_/A1 _10115_/A0 VDD VSS sg13g2_buf_1
XFILLER_87_848 VDD VSS sg13g2_fill_2
XFILLER_41_1202 VDD VSS sg13g2_decap_8
XFILLER_140_293 VDD VSS sg13g2_decap_8
X_09743_ _14333_/D _14333_/Q _09908_/A1 wire444/A VDD VSS sg13g2_mux2_1
XFILLER_27_403 VDD VSS sg13g2_fill_1
X_09674_ _09674_/X _10137_/C _09740_/B VDD VSS sg13g2_or2_1
XFILLER_27_425 VDD VSS sg13g2_decap_8
X_15106__3134 _15106_/RESET_B VDD VSS sg13g2_tiehi
X_08625_ _08625_/Y _08625_/A _08625_/B VDD VSS sg13g2_nor2_1
XFILLER_82_553 VDD VSS sg13g2_fill_2
XFILLER_54_266 VDD VSS sg13g2_fill_2
XFILLER_70_726 VDD VSS sg13g2_decap_4
XFILLER_14_119 VDD VSS sg13g2_decap_8
X_08556_ _15241_/D _08555_/Y _08553_/Y _08545_/X VDD VSS sg13g2_o21ai_1
XFILLER_39_1153 VDD VSS sg13g2_decap_8
X_13756__2808 _13756_/RESET_B VDD VSS sg13g2_tiehi
X_08487_ _08488_/B _07820_/B _07801_/B _07949_/C _07798_/B wire1387/X _08559_/S1 VDD
+ VSS sg13g2_mux4_1
XFILLER_146_7 VDD VSS sg13g2_decap_8
XFILLER_11_815 VDD VSS sg13g2_decap_4
XFILLER_22_185 VDD VSS sg13g2_decap_8
XFILLER_10_325 VDD VSS sg13g2_fill_1
XFILLER_155_308 VDD VSS sg13g2_decap_8
XFILLER_109_725 VDD VSS sg13g2_decap_8
X_09108_ _10757_/B _09100_/B _15044_/Q _09107_/Y VDD VSS sg13g2_o21ai_1
X_10380_ _10380_/X _14815_/Q _14816_/Q _14817_/Q _14818_/Q VDD VSS sg13g2_and4_1
XFILLER_136_544 VDD VSS sg13g2_decap_8
X_14136__2428 _14136_/RESET_B VDD VSS sg13g2_tiehi
X_09039_ _09039_/Y _15231_/Q _09039_/B VDD VSS sg13g2_nand2b_1
X_12050_ _12050_/Y _10760_/A _11792_/B _12046_/Y _12049_/Y VDD VSS sg13g2_a22oi_1
XFILLER_78_804 VDD VSS sg13g2_decap_8
X_14748__1815 _14748_/RESET_B VDD VSS sg13g2_tiehi
XFILLER_105_964 VDD VSS sg13g2_decap_4
XFILLER_117_74 VDD VSS sg13g2_decap_8
X_11001_ _11001_/Y _11001_/A _11074_/B VDD VSS sg13g2_nand2_1
XFILLER_81_1037 VDD VSS sg13g2_decap_8
XFILLER_117_85 VDD VSS sg13g2_fill_1
X_14351__2213 _14351_/RESET_B VDD VSS sg13g2_tiehi
XFILLER_78_859 VDD VSS sg13g2_fill_2
Xfanout850 _08988_/A _09097_/A VDD VSS sg13g2_buf_1
Xfanout861 _10694_/S fanout866/X VDD VSS sg13g2_buf_1
Xfanout872 _08882_/S _08871_/S VDD VSS sg13g2_buf_1
XFILLER_46_701 VDD VSS sg13g2_decap_8
Xfanout894 fanout894/X _07996_/X VDD VSS sg13g2_buf_1
XFILLER_86_881 VDD VSS sg13g2_fill_2
XFILLER_58_583 VDD VSS sg13g2_decap_8
X_12952_ _12952_/Y input21/X _12795_/Y _12937_/Y VDD VSS sg13g2_o21ai_1
X_11903_ wire269/A _11902_/Y _11892_/Y _11884_/Y _11876_/Y _12001_/A VDD VSS sg13g2_a221oi_1
X_12883_ _12883_/X _12899_/A _12884_/C _12899_/C input25/X VDD VSS sg13g2_and4_1
X_14622_ _14622_/Q clkload59/A _14622_/D _14622_/RESET_B VDD VSS sg13g2_dfrbpq_1
XFILLER_33_428 VDD VSS sg13g2_decap_8
XFILLER_61_737 VDD VSS sg13g2_fill_2
XFILLER_92_1100 VDD VSS sg13g2_decap_8
XFILLER_45_288 VDD VSS sg13g2_fill_1
X_11834_ _11834_/Y _11829_/X _12333_/B1 _11832_/C VDD VSS sg13g2_a21oi_1
XFILLER_33_439 VDD VSS sg13g2_fill_1
XFILLER_45_299 VDD VSS sg13g2_fill_1
XFILLER_92_1133 VDD VSS sg13g2_decap_8
XFILLER_144_1212 VDD VSS sg13g2_decap_8
XFILLER_18_1226 VDD VSS sg13g2_decap_8
X_11765_ _11765_/Y _11765_/A _11765_/B VDD VSS sg13g2_nor2_1
XFILLER_42_962 VDD VSS sg13g2_decap_4
X_14553_ _14553_/Q _14745_/CLK _14553_/D _14553_/RESET_B VDD VSS sg13g2_dfrbpq_1
XFILLER_41_450 VDD VSS sg13g2_decap_4
XFILLER_53_1117 VDD VSS sg13g2_decap_8
X_14840__3249 _14840_/RESET_B VDD VSS sg13g2_tiehi
XFILLER_42_984 VDD VSS sg13g2_decap_8
X_10716_ _10716_/Y _10725_/A _10716_/B VDD VSS sg13g2_nor2_1
X_13504_ _13504_/Y _13504_/A _15174_/D VDD VSS sg13g2_nor2b_1
X_11696_ _11696_/Y _11696_/A _11696_/B VDD VSS sg13g2_nand2_1
XFILLER_41_494 VDD VSS sg13g2_decap_8
X_14484_ _14484_/Q clkload8/A _14484_/D _14484_/RESET_B VDD VSS sg13g2_dfrbpq_1
XFILLER_105_1229 VDD VSS sg13g2_decap_8
XFILLER_13_196 VDD VSS sg13g2_fill_1
XFILLER_146_308 VDD VSS sg13g2_fill_2
X_13435_ _13435_/Y _13435_/A _13435_/B _13444_/C VDD VSS sg13g2_nor3_1
XFILLER_127_500 VDD VSS sg13g2_decap_8
X_10647_ _10653_/B _15205_/Q _14870_/Q _12895_/A _10647_/D VDD VSS sg13g2_and4_1
XFILLER_42_81 VDD VSS sg13g2_decap_8
XFILLER_155_842 VDD VSS sg13g2_fill_1
XFILLER_61_7 VDD VSS sg13g2_decap_8
X_13366_ _13366_/Y _13440_/A _13440_/B _15075_/Q VDD VSS sg13g2_nand3_1
Xmax_cap1167 _12703_/S0 _12425_/S0 VDD VSS sg13g2_buf_4
X_10578_ _10580_/C _10591_/C _10583_/D _14871_/Q VDD VSS sg13g2_a21oi_1
XFILLER_155_875 VDD VSS sg13g2_decap_8
Xmax_cap1178 _12752_/S0 _12757_/S0 VDD VSS sg13g2_buf_4
X_15105_ _15105_/Q clkload80/A _15105_/D _15105_/RESET_B VDD VSS sg13g2_dfrbpq_1
X_12317_ _12317_/X _12317_/A _12317_/B VDD VSS sg13g2_and2_1
XFILLER_6_896 VDD VSS sg13g2_decap_4
X_13297_ _13297_/X _13297_/A0 wire911/X _13300_/C VDD VSS sg13g2_mux2_1
XFILLER_115_739 VDD VSS sg13g2_decap_8
XFILLER_138_1027 VDD VSS sg13g2_fill_2
XFILLER_64_1202 VDD VSS sg13g2_fill_2
X_12248_ _12248_/Y _11531_/A _14424_/Q _12248_/B1 VDD VSS sg13g2_a21oi_1
X_15036_ _15036_/Q _15248_/CLK _15036_/D _15036_/RESET_B VDD VSS sg13g2_dfrbpq_1
XFILLER_107_290 VDD VSS sg13g2_decap_8
XFILLER_64_1224 VDD VSS sg13g2_decap_8
XFILLER_64_1235 VDD VSS sg13g2_fill_2
X_14924__3081 _14924_/RESET_B VDD VSS sg13g2_tiehi
XFILLER_123_761 VDD VSS sg13g2_decap_8
XFILLER_111_923 VDD VSS sg13g2_decap_8
X_12179_ _12179_/Y _12175_/Y _12176_/Y _12178_/Y _12177_/Y _11763_/B VDD VSS sg13g2_a221oi_1
XFILLER_3_42 VDD VSS sg13g2_decap_8
XFILLER_122_260 VDD VSS sg13g2_fill_2
XFILLER_122_271 VDD VSS sg13g2_decap_8
XFILLER_150_591 VDD VSS sg13g2_decap_4
XFILLER_69_859 VDD VSS sg13g2_decap_4
XFILLER_96_656 VDD VSS sg13g2_fill_1
XFILLER_83_306 VDD VSS sg13g2_decap_8
XFILLER_110_466 VDD VSS sg13g2_fill_2
XFILLER_7_1173 VDD VSS sg13g2_decap_8
XFILLER_114_1082 VDD VSS sg13g2_decap_8
XFILLER_149_1101 VDD VSS sg13g2_decap_8
XFILLER_58_1017 VDD VSS sg13g2_fill_1
X_08410_ _08410_/X _08410_/A _08410_/B _08410_/C _08410_/D VDD VSS sg13g2_and4_1
XFILLER_18_981 VDD VSS sg13g2_decap_8
X_09390_ _13993_/D _09621_/A0 _13993_/Q _09404_/S VDD VSS sg13g2_mux2_1
XFILLER_97_1099 VDD VSS sg13g2_decap_4
XFILLER_36_299 VDD VSS sg13g2_decap_4
XFILLER_52_748 VDD VSS sg13g2_decap_8
X_08341_ _08341_/Y _08621_/A _08339_/Y _08340_/Y VDD VSS sg13g2_o21ai_1
XFILLER_32_472 VDD VSS sg13g2_decap_8
X_08272_ _08603_/B _08599_/A _08082_/X _08688_/B VDD VSS sg13g2_o21ai_1
XFILLER_121_1042 VDD VSS sg13g2_fill_1
XFILLER_146_853 VDD VSS sg13g2_fill_2
XFILLER_69_1135 VDD VSS sg13g2_decap_8
XFILLER_106_717 VDD VSS sg13g2_decap_8
XFILLER_105_205 VDD VSS sg13g2_decap_8
Xmax_cap1690 _11741_/A _11466_/S0 VDD VSS sg13g2_buf_4
XFILLER_106_739 VDD VSS sg13g2_fill_2
XFILLER_154_28 VDD VSS sg13g2_decap_8
Xfanout157 _10135_/A0 wire158/X VDD VSS sg13g2_buf_1
Xfanout168 _10099_/A0 _09145_/Y VDD VSS sg13g2_buf_1
XFILLER_87_667 VDD VSS sg13g2_decap_4
Xfanout179 _10096_/A0 _09126_/Y VDD VSS sg13g2_buf_1
XFILLER_86_155 VDD VSS sg13g2_decap_8
X_07987_ _07987_/Y wire145/X _13308_/A _13506_/A _13290_/A VDD VSS sg13g2_nand4_1
X_09726_ _14317_/D _09924_/A1 _14317_/Q _09738_/S VDD VSS sg13g2_mux2_1
XFILLER_41_1065 VDD VSS sg13g2_decap_4
XFILLER_103_21 VDD VSS sg13g2_decap_8
XFILLER_28_756 VDD VSS sg13g2_fill_1
XFILLER_16_907 VDD VSS sg13g2_fill_2
XFILLER_27_255 VDD VSS sg13g2_decap_8
X_09657_ _14250_/D _09789_/A0 _14250_/Q wire639/X VDD VSS sg13g2_mux2_1
X_08608_ _08608_/Y _08608_/A _08608_/B _08641_/C VDD VSS sg13g2_nor3_1
X_09588_ _14185_/D _14185_/Q _09621_/A0 wire329/X VDD VSS sg13g2_mux2_1
XFILLER_43_748 VDD VSS sg13g2_decap_8
XFILLER_103_98 VDD VSS sg13g2_fill_2
X_08539_ _08539_/Y _08378_/Y _08621_/A _08539_/B1 VDD VSS sg13g2_a21oi_1
X_14966__3006 _14966_/RESET_B VDD VSS sg13g2_tiehi
XFILLER_24_973 VDD VSS sg13g2_decap_8
X_11550_ _11550_/Y _11555_/S0 _13828_/Q VDD VSS sg13g2_nand2b_1
XFILLER_11_634 VDD VSS sg13g2_decap_8
X_10501_ _10502_/C _14852_/Q _10513_/D _14850_/Q _14849_/Q VDD VSS sg13g2_nand4_1
XFILLER_155_105 VDD VSS sg13g2_decap_8
XFILLER_156_639 VDD VSS sg13g2_decap_8
Xwire525 wire525/X wire525/A VDD VSS sg13g2_buf_2
X_11481_ _14963_/D _11461_/A _11701_/C1 _11480_/Y VDD VSS sg13g2_a21o_1
XFILLER_109_500 VDD VSS sg13g2_fill_2
X_13220_ _13220_/Y _14794_/Q _13220_/A2 _13262_/B1 VDD VSS sg13g2_o21ai_1
XFILLER_137_842 VDD VSS sg13g2_decap_4
X_10432_ _14833_/D _14833_/Q _10434_/C _10431_/Y VDD VSS sg13g2_a21oi_1
XFILLER_13_1167 VDD VSS sg13g2_decap_8
X_13151_ _13151_/Y _14821_/Q _13068_/B _13180_/B1 _14885_/Q _13248_/B VDD VSS sg13g2_a221oi_1
XFILLER_12_84 VDD VSS sg13g2_decap_8
X_10363_ _10365_/A _14812_/Q _10359_/Y _14813_/Q VDD VSS sg13g2_a21o_1
XFILLER_3_822 VDD VSS sg13g2_decap_8
XFILLER_109_599 VDD VSS sg13g2_decap_8
XFILLER_48_1219 VDD VSS sg13g2_decap_8
XFILLER_2_310 VDD VSS sg13g2_decap_8
X_12102_ _12102_/Y _12090_/A _14388_/Q VDD VSS sg13g2_nand2b_1
XFILLER_124_547 VDD VSS sg13g2_decap_8
XFILLER_2_321 VDD VSS sg13g2_fill_1
X_13082_ _13085_/A _14784_/Q _13082_/B VDD VSS sg13g2_nand2_1
XFILLER_112_709 VDD VSS sg13g2_decap_8
X_10294_ _10295_/B _14791_/Q _14792_/Q _10294_/C VDD VSS sg13g2_nand3_1
XFILLER_152_878 VDD VSS sg13g2_decap_8
XFILLER_2_354 VDD VSS sg13g2_decap_8
X_12033_ _12033_/Y _12017_/A _14514_/Q _12328_/B1 VDD VSS sg13g2_a21oi_1
XFILLER_151_388 VDD VSS sg13g2_decap_8
Xfanout1601 _12219_/S _12308_/C VDD VSS sg13g2_buf_1
Xfanout1612 _11715_/S1 fanout1617/X VDD VSS sg13g2_buf_1
XFILLER_120_720 VDD VSS sg13g2_decap_8
Xfanout1623 _12114_/S1 _12100_/S1 VDD VSS sg13g2_buf_1
Xfanout1634 fanout1634/X _13658_/Q VDD VSS sg13g2_buf_1
Xfanout1645 _11419_/C _11995_/S1 VDD VSS sg13g2_buf_1
Xfanout1656 _11262_/B _11226_/S1 VDD VSS sg13g2_buf_1
Xfanout1667 _11489_/S0 fanout1672/X VDD VSS sg13g2_buf_1
XFILLER_111_1200 VDD VSS sg13g2_decap_8
Xfanout1689 _11466_/S0 _11759_/A VDD VSS sg13g2_buf_1
Xfanout691 _09235_/S _09232_/S VDD VSS sg13g2_buf_1
XFILLER_120_797 VDD VSS sg13g2_decap_4
XFILLER_18_200 VDD VSS sg13g2_fill_2
X_13984_ _13984_/Q _14726_/CLK _13984_/D _13984_/RESET_B VDD VSS sg13g2_dfrbpq_1
XFILLER_74_840 VDD VSS sg13g2_decap_8
XFILLER_20_1149 VDD VSS sg13g2_decap_8
X_12935_ _12937_/A _15061_/Q _15062_/Q VDD VSS sg13g2_nor2b_1
XFILLER_18_277 VDD VSS sg13g2_decap_8
XFILLER_46_597 VDD VSS sg13g2_fill_1
XFILLER_73_383 VDD VSS sg13g2_fill_1
X_12866_ _12866_/X _12866_/A _12900_/C _12899_/C _12866_/D VDD VSS sg13g2_and4_1
Xclkbuf_leaf_113_clk_i clkload8/A clkbuf_5_3__f_clk_i/X VDD VSS sg13g2_buf_8
X_14605_ _14605_/Q _14669_/CLK _14605_/D _14605_/RESET_B VDD VSS sg13g2_dfrbpq_1
X_11817_ _11817_/Y _12303_/S _14412_/Q _11828_/S1 VDD VSS sg13g2_a21oi_1
XFILLER_18_1023 VDD VSS sg13g2_decap_8
X_12797_ _12900_/B _12997_/B _12899_/A VDD VSS sg13g2_nand2b_1
XFILLER_144_1031 VDD VSS sg13g2_decap_8
X_14536_ _14536_/Q clkload28/A _14536_/D _14536_/RESET_B VDD VSS sg13g2_dfrbpq_1
XFILLER_42_792 VDD VSS sg13g2_decap_8
X_11748_ _11748_/Y _12186_/A _14378_/Q VDD VSS sg13g2_nand2b_1
XFILLER_147_617 VDD VSS sg13g2_fill_1
XFILLER_105_1026 VDD VSS sg13g2_decap_4
XFILLER_144_1086 VDD VSS sg13g2_decap_8
X_14467_ _14467_/Q _14505_/CLK _14467_/D _14467_/RESET_B VDD VSS sg13g2_dfrbpq_1
XFILLER_31_1223 VDD VSS sg13g2_decap_8
X_11679_ _11679_/X _11696_/B _11678_/X _11677_/Y VDD VSS sg13g2_a21o_1
X_15070__3250 _15070_/RESET_B VDD VSS sg13g2_tiehi
X_13418_ _15093_/D _13435_/B _13490_/D _13416_/Y VDD VSS sg13g2_o21ai_1
X_14398_ _14398_/Q _14494_/CLK _14398_/D _14398_/RESET_B VDD VSS sg13g2_dfrbpq_1
Xmax_cap803 _08397_/A _08026_/Y VDD VSS sg13g2_buf_2
XFILLER_6_671 VDD VSS sg13g2_fill_1
XFILLER_115_514 VDD VSS sg13g2_fill_2
X_13349_ _15070_/D _13351_/C _13348_/Y _13345_/Y VDD VSS sg13g2_o21ai_1
XFILLER_154_182 VDD VSS sg13g2_decap_8
XFILLER_6_693 VDD VSS sg13g2_decap_8
X_15077__3226 _15077_/RESET_B VDD VSS sg13g2_tiehi
X_15131__3080 _15131_/RESET_B VDD VSS sg13g2_tiehi
XFILLER_103_709 VDD VSS sg13g2_decap_8
XFILLER_68_1190 VDD VSS sg13g2_decap_8
X_07910_ _07910_/Y _07910_/A _07910_/B VDD VSS sg13g2_nand2_1
X_15019_ _15019_/Q clkload68/A _15019_/D _15019_/RESET_B VDD VSS sg13g2_dfrbpq_1
XFILLER_142_399 VDD VSS sg13g2_fill_2
X_08890_ _08890_/X _15036_/Q _14940_/Q _10725_/A VDD VSS sg13g2_mux2_1
XFILLER_68_100 VDD VSS sg13g2_fill_1
XFILLER_97_943 VDD VSS sg13g2_fill_2
XFILLER_69_645 VDD VSS sg13g2_fill_2
XFILLER_111_742 VDD VSS sg13g2_decap_8
XFILLER_116_1144 VDD VSS sg13g2_fill_2
X_07841_ _07841_/Y _15018_/Q _08653_/B VDD VSS sg13g2_nand2_1
XFILLER_97_976 VDD VSS sg13g2_fill_1
XFILLER_111_753 VDD VSS sg13g2_fill_2
XFILLER_151_1046 VDD VSS sg13g2_decap_8
XFILLER_111_775 VDD VSS sg13g2_decap_8
XFILLER_99_1128 VDD VSS sg13g2_fill_1
XFILLER_112_1019 VDD VSS sg13g2_decap_8
X_07772_ _07797_/A _08318_/A _08318_/B VDD VSS sg13g2_or2_1
XFILLER_37_520 VDD VSS sg13g2_decap_8
XFILLER_84_659 VDD VSS sg13g2_fill_2
X_09511_ _14110_/D _09909_/A1 _14110_/Q _09527_/S VDD VSS sg13g2_mux2_1
XFILLER_37_553 VDD VSS sg13g2_fill_1
X_14447__2117 _14447_/RESET_B VDD VSS sg13g2_tiehi
XFILLER_80_810 VDD VSS sg13g2_decap_8
X_09442_ _14043_/D _09574_/A1 _14043_/Q wire671/A VDD VSS sg13g2_mux2_1
X_09373_ _13977_/D _10068_/A0 _13977_/Q _09373_/S VDD VSS sg13g2_mux2_1
XFILLER_33_28 VDD VSS sg13g2_decap_8
X_08324_ _08335_/A _07796_/B _08322_/Y _08323_/Y VDD VSS sg13g2_a21o_1
XFILLER_71_1014 VDD VSS sg13g2_fill_2
XFILLER_149_28 VDD VSS sg13g2_decap_8
XFILLER_137_105 VDD VSS sg13g2_fill_2
X_08255_ _08590_/B _08431_/A _08234_/Y _08617_/A _08426_/B VDD VSS sg13g2_a22oi_1
XFILLER_123_1137 VDD VSS sg13g2_fill_2
XFILLER_138_639 VDD VSS sg13g2_fill_2
XFILLER_21_998 VDD VSS sg13g2_decap_8
X_08186_ _08187_/A _07876_/Y _08184_/Y _08185_/Y VDD VSS sg13g2_o21ai_1
XFILLER_118_352 VDD VSS sg13g2_decap_4
XFILLER_118_363 VDD VSS sg13g2_fill_1
XFILLER_152_119 VDD VSS sg13g2_decap_8
XFILLER_106_525 VDD VSS sg13g2_decap_8
Xclkbuf_leaf_92_clk_i clkload41/A clkbuf_leaf_92_clk_i/A VDD VSS sg13g2_buf_8
XFILLER_109_7 VDD VSS sg13g2_decap_8
XFILLER_118_396 VDD VSS sg13g2_decap_8
X_14053__2511 _14053_/RESET_B VDD VSS sg13g2_tiehi
XFILLER_58_14 VDD VSS sg13g2_decap_8
XFILLER_88_932 VDD VSS sg13g2_decap_8
X_14657__1907 _14657_/RESET_B VDD VSS sg13g2_tiehi
XFILLER_87_453 VDD VSS sg13g2_fill_2
XFILLER_75_604 VDD VSS sg13g2_fill_1
XFILLER_87_486 VDD VSS sg13g2_fill_1
XFILLER_101_263 VDD VSS sg13g2_decap_8
X_14086__2478 _14086_/RESET_B VDD VSS sg13g2_tiehi
XFILLER_59_199 VDD VSS sg13g2_fill_2
XFILLER_74_125 VDD VSS sg13g2_fill_2
XFILLER_101_296 VDD VSS sg13g2_fill_2
XFILLER_114_64 VDD VSS sg13g2_decap_4
XFILLER_56_851 VDD VSS sg13g2_decap_8
X_09709_ _14300_/D _09907_/A1 _14300_/Q _09727_/S VDD VSS sg13g2_mux2_1
X_10981_ _10981_/Y _11009_/D _10978_/Y _10980_/Y VDD VSS sg13g2_o21ai_1
XFILLER_114_97 VDD VSS sg13g2_decap_8
Xclkbuf_leaf_30_clk_i _14731_/CLK clkbuf_leaf_30_clk_i/A VDD VSS sg13g2_buf_8
XFILLER_55_372 VDD VSS sg13g2_decap_8
XFILLER_55_383 VDD VSS sg13g2_fill_1
X_12720_ _12720_/X _12718_/X _12719_/X _12720_/S VDD VSS sg13g2_mux2_1
XFILLER_82_191 VDD VSS sg13g2_decap_8
X_15025__2947 _15025_/RESET_B VDD VSS sg13g2_tiehi
XFILLER_128_1037 VDD VSS sg13g2_fill_1
X_12651_ wire374/A _13672_/Q _12679_/A2 _12650_/X _12679_/B2 _12791_/C1 VDD VSS sg13g2_a221oi_1
XFILLER_70_386 VDD VSS sg13g2_fill_2
XFILLER_90_34 VDD VSS sg13g2_decap_8
XFILLER_54_1234 VDD VSS sg13g2_fill_2
X_11602_ _11602_/Y _11597_/A _14566_/Q VDD VSS sg13g2_nand2b_1
X_12582_ wire378/A _13064_/B _12679_/A2 _12581_/X _12679_/B2 _12791_/C1 VDD VSS sg13g2_a221oi_1
Xclkbuf_leaf_45_clk_i _14494_/CLK clkbuf_leaf_60_clk_i/A VDD VSS sg13g2_buf_8
XFILLER_12_954 VDD VSS sg13g2_decap_8
XFILLER_90_78 VDD VSS sg13g2_decap_4
XFILLER_135_0 VDD VSS sg13g2_decap_8
Xwire300 wire300/X wire300/A VDD VSS sg13g2_buf_2
X_14321_ _14321_/Q _14737_/CLK _14321_/D _14321_/RESET_B VDD VSS sg13g2_dfrbpq_1
X_11533_ _11533_/Y _11533_/A _11533_/B _11761_/C VDD VSS sg13g2_nand3_1
XFILLER_156_447 VDD VSS sg13g2_decap_8
XFILLER_156_458 VDD VSS sg13g2_fill_1
X_11464_ _11465_/B _11463_/A _11463_/C _11463_/B VDD VSS sg13g2_o21ai_1
X_14252_ _14252_/Q clkload54/A _14252_/D _14252_/RESET_B VDD VSS sg13g2_dfrbpq_1
XFILLER_7_457 VDD VSS sg13g2_decap_8
Xwire366 wire366/X wire366/A VDD VSS sg13g2_buf_1
Xwire377 wire377/X wire377/A VDD VSS sg13g2_buf_1
XFILLER_99_43 VDD VSS sg13g2_decap_4
Xwire388 wire388/X wire388/A VDD VSS sg13g2_buf_1
X_13203_ _13203_/Y _13202_/A _13202_/B _13224_/A VDD VSS sg13g2_a21oi_1
X_10415_ _14827_/D _10415_/A _10655_/B _10415_/C VDD VSS sg13g2_nor3_1
X_11395_ _11395_/Y _11395_/A _11395_/B VDD VSS sg13g2_nand2_1
XFILLER_139_1111 VDD VSS sg13g2_decap_8
X_14183_ _14183_/Q _14725_/CLK _14183_/D _14183_/RESET_B VDD VSS sg13g2_dfrbpq_1
XFILLER_109_396 VDD VSS sg13g2_decap_8
XFILLER_48_1027 VDD VSS sg13g2_decap_4
XFILLER_99_98 VDD VSS sg13g2_fill_2
X_10346_ _10352_/C _10359_/A _10346_/B VDD VSS sg13g2_nor2_1
XFILLER_3_641 VDD VSS sg13g2_decap_8
XFILLER_48_1038 VDD VSS sg13g2_fill_1
X_13134_ _13134_/Y _13146_/B _13146_/C _13160_/B VDD VSS sg13g2_nand3_1
X_14525__2039 _14525_/RESET_B VDD VSS sg13g2_tiehi
XFILLER_2_140 VDD VSS sg13g2_decap_8
X_13065_ _13067_/C _13066_/A wire234/X _13172_/A VDD VSS sg13g2_o21ai_1
XFILLER_124_388 VDD VSS sg13g2_fill_1
X_10277_ _10305_/B _14786_/Q _14787_/Q VDD VSS sg13g2_and2_1
Xfanout1420 _07859_/B _08635_/A3 VDD VSS sg13g2_buf_1
X_12016_ _12018_/A _12017_/A _13906_/Q VDD VSS sg13g2_nand2b_1
X_14779__3319 _14779_/RESET_B VDD VSS sg13g2_tiehi
XFILLER_61_1227 VDD VSS sg13g2_decap_8
Xfanout1431 _11983_/A _14979_/Q VDD VSS sg13g2_buf_1
XFILLER_24_7 VDD VSS sg13g2_decap_8
Xfanout1442 _07949_/C _07804_/B VDD VSS sg13g2_buf_1
XFILLER_78_464 VDD VSS sg13g2_decap_8
X_14815__3283 _14815_/RESET_B VDD VSS sg13g2_tiehi
Xfanout1453 _07794_/A _11726_/A VDD VSS sg13g2_buf_1
Xfanout1464 _08306_/C _07775_/A VDD VSS sg13g2_buf_1
XFILLER_94_935 VDD VSS sg13g2_decap_8
XFILLER_120_572 VDD VSS sg13g2_fill_1
Xfanout1475 _08300_/A3 _14965_/Q VDD VSS sg13g2_buf_1
XFILLER_66_648 VDD VSS sg13g2_decap_8
Xfanout1486 _11428_/A _14961_/Q VDD VSS sg13g2_buf_1
XFILLER_94_957 VDD VSS sg13g2_decap_8
XFILLER_94_968 VDD VSS sg13g2_fill_1
X_13751__2813 _13751_/RESET_B VDD VSS sg13g2_tiehi
XFILLER_24_1071 VDD VSS sg13g2_decap_8
XFILLER_4_1132 VDD VSS sg13g2_decap_8
XFILLER_93_445 VDD VSS sg13g2_decap_4
Xfanout1497 _12900_/C _12997_/A VDD VSS sg13g2_buf_1
XFILLER_65_147 VDD VSS sg13g2_decap_8
XFILLER_81_607 VDD VSS sg13g2_fill_2
XFILLER_0_1007 VDD VSS sg13g2_decap_8
X_13967_ _13967_/Q _14671_/CLK _13967_/D _13967_/RESET_B VDD VSS sg13g2_dfrbpq_1
XFILLER_93_478 VDD VSS sg13g2_decap_8
XFILLER_0_1018 VDD VSS sg13g2_fill_1
XFILLER_81_629 VDD VSS sg13g2_fill_2
XFILLER_111_1063 VDD VSS sg13g2_decap_8
XFILLER_0_54 VDD VSS sg13g2_decap_4
X_12918_ _12918_/Y _14774_/Q _12918_/A2 _12978_/B1 VDD VSS sg13g2_o21ai_1
XFILLER_146_1115 VDD VSS sg13g2_decap_4
X_13898_ _13898_/Q clkload21/A _13898_/D _13898_/RESET_B VDD VSS sg13g2_dfrbpq_1
XFILLER_73_191 VDD VSS sg13g2_decap_8
XFILLER_61_342 VDD VSS sg13g2_decap_8
XFILLER_62_876 VDD VSS sg13g2_decap_4
XFILLER_94_1069 VDD VSS sg13g2_fill_1
X_12849_ _12849_/Y _12848_/X _12846_/Y _13271_/C VDD VSS sg13g2_o21ai_1
X_14131__2433 _14131_/RESET_B VDD VSS sg13g2_tiehi
XFILLER_21_228 VDD VSS sg13g2_decap_8
XFILLER_9_63 VDD VSS sg13g2_decap_8
X_14519_ _14519_/Q _14726_/CLK _14519_/D _14519_/RESET_B VDD VSS sg13g2_dfrbpq_1
X_14735__1829 _14735_/RESET_B VDD VSS sg13g2_tiehi
X_08040_ _08040_/Y _08381_/A _08016_/Y _08021_/Y _08032_/Y _08039_/Y VDD VSS sg13g2_a221oi_1
XFILLER_156_970 VDD VSS sg13g2_fill_2
Xmax_cap611 _10003_/S _09991_/S VDD VSS sg13g2_buf_4
XFILLER_115_300 VDD VSS sg13g2_decap_8
XFILLER_7_991 VDD VSS sg13g2_decap_8
XFILLER_50_0 VDD VSS sg13g2_decap_8
Xmax_cap655 _09536_/S _09520_/S VDD VSS sg13g2_buf_4
XFILLER_89_707 VDD VSS sg13g2_decap_4
XFILLER_115_344 VDD VSS sg13g2_fill_1
X_09991_ _14574_/D _09991_/A0 _14574_/Q _09991_/S VDD VSS sg13g2_mux2_1
XFILLER_118_1228 VDD VSS sg13g2_decap_8
XFILLER_9_1010 VDD VSS sg13g2_fill_1
X_08942_ _08942_/Y _10793_/A _10793_/B _15050_/Q VDD VSS sg13g2_nand3_1
XFILLER_9_1043 VDD VSS sg13g2_decap_8
X_08873_ _08873_/Y _08877_/A _14936_/Q VDD VSS sg13g2_nor2b_1
XFILLER_28_28 VDD VSS sg13g2_decap_8
X_07824_ _07829_/A _08553_/A _07954_/B _08527_/A _08527_/B VDD VSS sg13g2_nor4_1
XFILLER_111_594 VDD VSS sg13g2_decap_4
XFILLER_42_1160 VDD VSS sg13g2_decap_8
XFILLER_72_618 VDD VSS sg13g2_decap_8
X_07755_ _07755_/Y _11241_/C _12301_/B1 _13320_/C VDD VSS sg13g2_o21ai_1
XFILLER_38_884 VDD VSS sg13g2_decap_8
XFILLER_77_1212 VDD VSS sg13g2_decap_8
XFILLER_93_990 VDD VSS sg13g2_decap_8
XFILLER_71_128 VDD VSS sg13g2_decap_8
XFILLER_37_394 VDD VSS sg13g2_fill_2
X_07686_ _07687_/C _13308_/B _07684_/B _07684_/Y VDD VSS sg13g2_o21ai_1
XFILLER_73_1109 VDD VSS sg13g2_decap_8
XFILLER_80_651 VDD VSS sg13g2_decap_4
X_09425_ _14027_/D _10021_/A0 _14027_/Q _09439_/S VDD VSS sg13g2_mux2_1
XFILLER_139_904 VDD VSS sg13g2_decap_8
X_09356_ _13960_/D _10084_/A0 _13960_/Q _09358_/S VDD VSS sg13g2_mux2_1
XFILLER_40_548 VDD VSS sg13g2_decap_8
X_08307_ _08312_/A _08303_/Y _08305_/Y _08306_/Y VDD VSS sg13g2_o21ai_1
XFILLER_139_948 VDD VSS sg13g2_decap_8
X_09287_ _13895_/D _13895_/Q _10150_/A1 _09299_/S VDD VSS sg13g2_mux2_1
X_08238_ _08238_/Y _08265_/A _08654_/B VDD VSS sg13g2_nor2_1
XFILLER_10_1115 VDD VSS sg13g2_decap_8
XFILLER_153_439 VDD VSS sg13g2_decap_8
X_08169_ _08169_/Y _08599_/B _08052_/Y _08688_/A VDD VSS sg13g2_o21ai_1
XFILLER_109_53 VDD VSS sg13g2_decap_8
X_10200_ _14757_/D _15181_/D _14757_/Q _13502_/A VDD VSS sg13g2_mux2_1
X_11180_ _11190_/A _11180_/A _11181_/A _11180_/C VDD VSS sg13g2_nand3_1
X_14898__3133 _14898_/RESET_B VDD VSS sg13g2_tiehi
XFILLER_79_217 VDD VSS sg13g2_decap_8
X_10131_ _14709_/D _10131_/A0 _14709_/Q _10135_/S VDD VSS sg13g2_mux2_1
XFILLER_69_79 VDD VSS sg13g2_decap_8
XFILLER_106_399 VDD VSS sg13g2_decap_4
XFILLER_0_633 VDD VSS sg13g2_fill_2
XFILLER_121_336 VDD VSS sg13g2_fill_1
XFILLER_0_655 VDD VSS sg13g2_decap_8
X_10062_ _14643_/D _10062_/A0 _14643_/Q _10062_/S VDD VSS sg13g2_mux2_1
XFILLER_76_902 VDD VSS sg13g2_fill_2
XFILLER_87_261 VDD VSS sg13g2_decap_8
XFILLER_125_85 VDD VSS sg13g2_fill_2
XFILLER_102_583 VDD VSS sg13g2_decap_8
XFILLER_76_957 VDD VSS sg13g2_fill_1
XFILLER_85_56 VDD VSS sg13g2_decap_8
X_14870_ _14870_/Q _14873_/CLK _14870_/D _14870_/RESET_B VDD VSS sg13g2_dfrbpq_1
XFILLER_21_1222 VDD VSS sg13g2_decap_8
X_13821_ _13821_/Q clkload53/A _13821_/D _13821_/RESET_B VDD VSS sg13g2_dfrbpq_1
X_13752_ _13752_/Q clkload31/A _13752_/D _13752_/RESET_B VDD VSS sg13g2_dfrbpq_1
X_10964_ _10964_/Y _11004_/B _10964_/B VDD VSS sg13g2_xnor2_1
XFILLER_141_84 VDD VSS sg13g2_decap_8
X_12703_ _12703_/X _13748_/Q _14100_/Q _14452_/Q _14548_/Q _12703_/S0 _12703_/S1 VDD
+ VSS sg13g2_mux4_1
XFILLER_43_364 VDD VSS sg13g2_decap_8
X_13683_ _13683_/Q clkload34/A _13683_/D _13683_/RESET_B VDD VSS sg13g2_dfrbpq_1
X_10895_ _10895_/Y _10948_/A _10893_/X _10895_/B1 VDD VSS sg13g2_o21ai_1
XFILLER_31_526 VDD VSS sg13g2_decap_8
XFILLER_70_172 VDD VSS sg13g2_fill_2
XFILLER_31_548 VDD VSS sg13g2_decap_8
X_12634_ _12634_/X _12631_/X _12630_/X _12627_/X _12626_/X wire1081/X _12635_/S1 VDD
+ VSS sg13g2_mux4_1
XFILLER_54_1053 VDD VSS sg13g2_fill_1
XFILLER_145_1181 VDD VSS sg13g2_fill_1
XFILLER_19_1184 VDD VSS sg13g2_decap_8
XFILLER_141_1023 VDD VSS sg13g2_decap_8
X_12565_ _12565_/X _12564_/X _12563_/X _12560_/X _12559_/X _12566_/S0 _12706_/S VDD
+ VSS sg13g2_mux4_1
XFILLER_15_1059 VDD VSS sg13g2_decap_8
X_14304_ _14304_/Q _14917_/CLK _14304_/D _14304_/RESET_B VDD VSS sg13g2_dfrbpq_1
XFILLER_106_1176 VDD VSS sg13g2_decap_8
X_11516_ _11516_/Y _11516_/A VDD VSS sg13g2_inv_1
XFILLER_7_232 VDD VSS sg13g2_decap_4
XFILLER_156_255 VDD VSS sg13g2_decap_8
XFILLER_156_266 VDD VSS sg13g2_fill_1
X_12496_ _12496_/X _12494_/X _12493_/X _12490_/X _12489_/X _12746_/S1 _12748_/S VDD
+ VSS sg13g2_mux4_1
X_14235_ _14235_/Q _15188_/CLK _14235_/D _14235_/RESET_B VDD VSS sg13g2_dfrbpq_1
X_11447_ _11448_/A _12092_/C _11444_/X _11446_/Y VDD VSS sg13g2_o21ai_1
X_11378_ _11378_/X _11369_/Y _11377_/Y _11378_/S VDD VSS sg13g2_mux2_1
X_14166_ _14166_/Q _14710_/CLK _14166_/D _14166_/RESET_B VDD VSS sg13g2_dfrbpq_1
XFILLER_4_972 VDD VSS sg13g2_decap_8
X_13117_ _13120_/A _13078_/A _13113_/X _13171_/A VDD VSS sg13g2_a21oi_1
X_10329_ _10331_/A _10405_/C _10345_/C _14803_/Q VDD VSS sg13g2_a21o_1
XFILLER_124_185 VDD VSS sg13g2_decap_8
XFILLER_26_1100 VDD VSS sg13g2_decap_8
XFILLER_113_859 VDD VSS sg13g2_fill_1
X_14097_ _14097_/Q clkload45/A _14097_/D _14097_/RESET_B VDD VSS sg13g2_dfrbpq_1
XFILLER_112_347 VDD VSS sg13g2_decap_4
XFILLER_61_1013 VDD VSS sg13g2_fill_2
XFILLER_67_913 VDD VSS sg13g2_decap_8
X_13048_ _13048_/X _13048_/A _13048_/B VDD VSS sg13g2_and2_1
X_14149__2415 _14149_/RESET_B VDD VSS sg13g2_tiehi
XFILLER_113_1103 VDD VSS sg13g2_fill_1
XFILLER_79_795 VDD VSS sg13g2_decap_8
Xfanout1250 _13429_/A _13381_/B VDD VSS sg13g2_buf_1
XFILLER_26_1177 VDD VSS sg13g2_decap_8
XFILLER_61_1057 VDD VSS sg13g2_fill_2
Xfanout1261 _12348_/A _15125_/Q VDD VSS sg13g2_buf_1
Xfanout1272 _13094_/B1 _12930_/B1 VDD VSS sg13g2_buf_1
XFILLER_152_1196 VDD VSS sg13g2_decap_8
Xfanout1283 _08698_/B _13427_/C VDD VSS sg13g2_buf_1
X_14961__3011 _14961_/RESET_B VDD VSS sg13g2_tiehi
XFILLER_93_231 VDD VSS sg13g2_decap_8
XFILLER_66_456 VDD VSS sg13g2_decap_8
Xfanout1294 _10843_/C _10895_/B1 VDD VSS sg13g2_buf_1
XFILLER_113_1158 VDD VSS sg13g2_decap_8
XFILLER_54_618 VDD VSS sg13g2_fill_2
XFILLER_82_938 VDD VSS sg13g2_fill_1
X_14999_ _14999_/Q clkload37/A _14999_/D _14999_/RESET_B VDD VSS sg13g2_dfrbpq_1
XFILLER_35_821 VDD VSS sg13g2_decap_8
XFILLER_35_832 VDD VSS sg13g2_fill_2
XFILLER_62_640 VDD VSS sg13g2_decap_8
X_14364__2200 _14364_/RESET_B VDD VSS sg13g2_tiehi
XFILLER_62_662 VDD VSS sg13g2_fill_1
XFILLER_90_971 VDD VSS sg13g2_decap_8
XFILLER_22_526 VDD VSS sg13g2_decap_8
X_09210_ _13821_/D _10140_/A1 _13821_/Q _09212_/S VDD VSS sg13g2_mux2_1
XFILLER_98_0 VDD VSS sg13g2_decap_8
XFILLER_72_1131 VDD VSS sg13g2_fill_2
XFILLER_124_1210 VDD VSS sg13g2_fill_1
X_09141_ _09145_/A _09141_/A _10781_/A _10793_/B VDD VSS sg13g2_nand3_1
XFILLER_33_1148 VDD VSS sg13g2_decap_8
X_09072_ _09072_/Y _15236_/Q _13305_/A VDD VSS sg13g2_nand2b_1
X_14397__2167 _14397_/RESET_B VDD VSS sg13g2_tiehi
XFILLER_147_277 VDD VSS sg13g2_fill_2
X_08023_ _08023_/Y _08023_/A _08023_/B VDD VSS sg13g2_nand2_1
Xmax_cap452 _09738_/S _09729_/S VDD VSS sg13g2_buf_4
XFILLER_1_408 VDD VSS sg13g2_decap_8
XFILLER_143_461 VDD VSS sg13g2_decap_4
XFILLER_115_152 VDD VSS sg13g2_fill_1
Xmax_cap474 _09503_/S _09495_/S VDD VSS sg13g2_buf_4
XFILLER_115_163 VDD VSS sg13g2_decap_8
XFILLER_115_174 VDD VSS sg13g2_fill_1
X_09974_ _14557_/D _10107_/A0 _14557_/Q _09976_/S VDD VSS sg13g2_mux2_1
XFILLER_118_1036 VDD VSS sg13g2_decap_8
XFILLER_130_122 VDD VSS sg13g2_decap_8
XFILLER_103_358 VDD VSS sg13g2_decap_8
XFILLER_39_49 VDD VSS sg13g2_fill_2
X_08925_ _08925_/X _08924_/X _12009_/A _08925_/S VDD VSS sg13g2_mux2_1
XFILLER_130_155 VDD VSS sg13g2_fill_1
XFILLER_69_250 VDD VSS sg13g2_decap_8
XFILLER_69_261 VDD VSS sg13g2_fill_1
XFILLER_112_870 VDD VSS sg13g2_fill_1
XFILLER_130_166 VDD VSS sg13g2_decap_8
XFILLER_131_1236 VDD VSS sg13g2_fill_1
X_08856_ _08856_/X _15027_/Q _14931_/Q _08862_/S VDD VSS sg13g2_mux2_1
XFILLER_84_242 VDD VSS sg13g2_decap_4
X_07807_ _07828_/C _07950_/A _07949_/B _07807_/C _08476_/A VDD VSS sg13g2_nand4_1
XFILLER_45_618 VDD VSS sg13g2_decap_8
XFILLER_73_927 VDD VSS sg13g2_fill_2
XFILLER_84_275 VDD VSS sg13g2_decap_8
X_08787_ _08787_/Y _13681_/Q _08787_/B VDD VSS sg13g2_nor2_1
XFILLER_26_821 VDD VSS sg13g2_fill_2
XFILLER_77_1020 VDD VSS sg13g2_decap_4
X_07738_ _07738_/Y _10177_/A _13300_/C _07754_/B VDD VSS sg13g2_nand3_1
XFILLER_53_640 VDD VSS sg13g2_decap_4
XFILLER_111_21 VDD VSS sg13g2_decap_4
XFILLER_129_1132 VDD VSS sg13g2_fill_1
XFILLER_25_364 VDD VSS sg13g2_decap_4
X_13847__2717 _13847_/RESET_B VDD VSS sg13g2_tiehi
X_07669_ _10172_/C _13508_/B _10205_/S _10171_/D VDD VSS sg13g2_o21ai_1
XFILLER_38_1048 VDD VSS sg13g2_decap_8
XFILLER_71_14 VDD VSS sg13g2_decap_8
X_09408_ _09408_/Y _10037_/B _09441_/D VDD VSS sg13g2_nand2_1
X_10680_ _10844_/B _08980_/X _08848_/A _08844_/Y VDD VSS sg13g2_a21o_1
XFILLER_52_194 VDD VSS sg13g2_fill_2
XFILLER_41_879 VDD VSS sg13g2_fill_2
XFILLER_40_367 VDD VSS sg13g2_fill_2
XFILLER_138_211 VDD VSS sg13g2_fill_2
X_09339_ _13946_/D _10169_/A1 _13946_/Q _09339_/S VDD VSS sg13g2_mux2_1
XFILLER_21_592 VDD VSS sg13g2_decap_8
X_12350_ _12350_/X _14683_/Q _14715_/Q _13755_/Q _13787_/Q _12365_/S0 _12366_/S1 VDD
+ VSS sg13g2_mux4_1
XFILLER_139_778 VDD VSS sg13g2_fill_2
X_14227__2337 _14227_/RESET_B VDD VSS sg13g2_tiehi
XFILLER_153_203 VDD VSS sg13g2_decap_8
X_11301_ _11301_/Y _11300_/X _11395_/B _11299_/Y VDD VSS sg13g2_a21oi_1
XFILLER_154_748 VDD VSS sg13g2_decap_4
X_12281_ _12281_/X _14585_/Q _14617_/Q _14649_/Q _14681_/Q _12286_/S0 _12286_/S1 VDD
+ VSS sg13g2_mux4_1
XFILLER_14_1092 VDD VSS sg13g2_decap_8
XFILLER_4_235 VDD VSS sg13g2_fill_2
X_14020_ _14020_/Q clkload31/A _14020_/D _14020_/RESET_B VDD VSS sg13g2_dfrbpq_1
X_11232_ _11232_/Y _15115_/Q _15116_/Q VDD VSS sg13g2_nor2_1
XFILLER_4_268 VDD VSS sg13g2_decap_4
XFILLER_122_601 VDD VSS sg13g2_fill_1
XFILLER_20_84 VDD VSS sg13g2_decap_4
XFILLER_107_697 VDD VSS sg13g2_decap_4
X_11163_ _11180_/A _11163_/A _11164_/C VDD VSS sg13g2_nor2_1
XFILLER_136_1136 VDD VSS sg13g2_fill_2
XFILLER_84_1068 VDD VSS sg13g2_decap_8
XFILLER_106_185 VDD VSS sg13g2_decap_8
X_14442__2122 _14442_/RESET_B VDD VSS sg13g2_tiehi
X_10114_ _14692_/D _10147_/A1 _14692_/Q _10134_/S VDD VSS sg13g2_mux2_1
XFILLER_122_678 VDD VSS sg13g2_decap_8
XFILLER_1_975 VDD VSS sg13g2_decap_8
X_11094_ _11095_/B _11118_/C _11094_/B VDD VSS sg13g2_nor2_1
XFILLER_0_463 VDD VSS sg13g2_decap_8
XFILLER_103_881 VDD VSS sg13g2_fill_1
XFILLER_0_474 VDD VSS sg13g2_fill_1
XFILLER_88_581 VDD VSS sg13g2_fill_2
X_10045_ _14626_/D _10078_/A0 _14626_/Q _10067_/S VDD VSS sg13g2_mux2_1
X_14922_ _14922_/Q _15046_/CLK _14922_/D _14922_/RESET_B VDD VSS sg13g2_dfrbpq_1
XFILLER_29_60 VDD VSS sg13g2_decap_8
XFILLER_49_979 VDD VSS sg13g2_decap_8
XFILLER_64_916 VDD VSS sg13g2_decap_8
X_14853_ _14853_/Q _14854_/CLK _14853_/D _14853_/RESET_B VDD VSS sg13g2_dfrbpq_1
XFILLER_36_618 VDD VSS sg13g2_fill_1
XFILLER_29_681 VDD VSS sg13g2_fill_1
XFILLER_63_426 VDD VSS sg13g2_fill_1
XFILLER_75_286 VDD VSS sg13g2_fill_2
XFILLER_35_128 VDD VSS sg13g2_fill_2
XFILLER_17_832 VDD VSS sg13g2_fill_1
XFILLER_75_297 VDD VSS sg13g2_decap_4
X_13804_ _13804_/Q _14525_/CLK _13804_/D _13804_/RESET_B VDD VSS sg13g2_dfrbpq_1
X_14475__2089 _14475_/RESET_B VDD VSS sg13g2_tiehi
XFILLER_112_1180 VDD VSS sg13g2_decap_8
X_14784_ _14784_/Q clkload82/A _14784_/D _14784_/RESET_B VDD VSS sg13g2_dfrbpq_1
XFILLER_1_1146 VDD VSS sg13g2_decap_8
XFILLER_95_1131 VDD VSS sg13g2_fill_2
X_11996_ _11996_/X _14577_/Q _14609_/Q _14641_/Q _14673_/Q _11997_/S0 _11997_/S1 VDD
+ VSS sg13g2_mux4_1
XFILLER_21_1096 VDD VSS sg13g2_decap_8
X_13735_ _13735_/Q clkload10/A _13735_/D _13735_/RESET_B VDD VSS sg13g2_dfrbpq_1
X_10947_ _11007_/B _10932_/B _10946_/Y _10945_/Y _10944_/Y VDD VSS sg13g2_a22oi_1
XFILLER_95_1175 VDD VSS sg13g2_fill_2
XFILLER_91_1017 VDD VSS sg13g2_fill_2
XFILLER_32_835 VDD VSS sg13g2_fill_2
XFILLER_16_386 VDD VSS sg13g2_decap_8
XFILLER_95_1197 VDD VSS sg13g2_fill_1
XFILLER_32_857 VDD VSS sg13g2_fill_2
XFILLER_108_1227 VDD VSS sg13g2_decap_8
X_13666_ _13666_/Q _15214_/CLK _13666_/D _13666_/RESET_B VDD VSS sg13g2_dfrbpq_1
XFILLER_91_7 VDD VSS sg13g2_decap_4
X_10878_ _10878_/Y _10923_/D _10878_/B VDD VSS sg13g2_nand2_1
X_12617_ _12617_/X _14574_/Q _14606_/Q _14638_/Q _14670_/Q _12617_/S0 _12617_/S1 VDD
+ VSS sg13g2_mux4_1
X_13597_ _13597_/Y _12841_/B _13596_/Y _08830_/X VDD VSS sg13g2_o21ai_1
XFILLER_118_907 VDD VSS sg13g2_decap_8
XFILLER_12_592 VDD VSS sg13g2_decap_8
X_12548_ _12548_/X _13737_/Q _14089_/Q _14441_/Q _14537_/Q _12548_/S0 _12550_/S1 VDD
+ VSS sg13g2_mux4_1
XFILLER_117_406 VDD VSS sg13g2_decap_8
X_14652__1912 _14652_/RESET_B VDD VSS sg13g2_tiehi
XFILLER_144_236 VDD VSS sg13g2_fill_1
X_12479_ _12479_/X _13828_/Q _13860_/Q _13892_/Q _13924_/Q _12480_/S0 _12480_/S1 VDD
+ VSS sg13g2_mux4_1
XANTENNA_2 _16862_/A VDD VSS sg13g2_antennanp
XFILLER_6_42 VDD VSS sg13g2_decap_8
X_14218_ _14218_/Q clkload23/A _14218_/D _14218_/RESET_B VDD VSS sg13g2_dfrbpq_1
XFILLER_99_802 VDD VSS sg13g2_decap_8
XFILLER_125_450 VDD VSS sg13g2_fill_2
XFILLER_126_973 VDD VSS sg13g2_decap_4
X_15198_ _15198_/Q _15200_/CLK _15198_/D _15198_/RESET_B VDD VSS sg13g2_dfrbpq_1
XFILLER_99_824 VDD VSS sg13g2_fill_1
X_14081__2483 _14081_/RESET_B VDD VSS sg13g2_tiehi
XFILLER_28_1206 VDD VSS sg13g2_decap_8
XFILLER_99_846 VDD VSS sg13g2_decap_8
XFILLER_125_483 VDD VSS sg13g2_decap_8
XFILLER_154_1225 VDD VSS sg13g2_decap_8
X_14149_ _14149_/Q clkload0/A _14149_/D _14149_/RESET_B VDD VSS sg13g2_dfrbpq_1
XFILLER_4_791 VDD VSS sg13g2_decap_8
XFILLER_154_1236 VDD VSS sg13g2_fill_1
XFILLER_113_645 VDD VSS sg13g2_decap_8
XFILLER_113_656 VDD VSS sg13g2_fill_1
XFILLER_112_133 VDD VSS sg13g2_decap_8
X_13925__2639 _13925_/RESET_B VDD VSS sg13g2_tiehi
XFILLER_98_389 VDD VSS sg13g2_decap_4
X_14685__1879 _14685_/RESET_B VDD VSS sg13g2_tiehi
XFILLER_79_581 VDD VSS sg13g2_decap_4
XFILLER_67_732 VDD VSS sg13g2_decap_8
X_15020__2952 _15020_/RESET_B VDD VSS sg13g2_tiehi
X_08710_ _13660_/D _15187_/D _15118_/Q _13651_/S VDD VSS sg13g2_mux2_1
X_09690_ _14282_/D _09789_/A0 _14282_/Q wire458/X VDD VSS sg13g2_mux2_1
XFILLER_67_754 VDD VSS sg13g2_fill_1
XFILLER_94_540 VDD VSS sg13g2_fill_2
XFILLER_13_0 VDD VSS sg13g2_decap_8
XFILLER_55_905 VDD VSS sg13g2_fill_2
Xfanout1080 wire1081/A _12705_/S0 VDD VSS sg13g2_buf_1
XFILLER_6_1068 VDD VSS sg13g2_decap_8
X_08641_ _08641_/Y _08641_/A _08641_/B _08641_/C _08641_/D VDD VSS sg13g2_nor4_1
Xfanout1091 _12593_/S0 wire1096/X VDD VSS sg13g2_buf_1
X_14882__3165 _14882_/RESET_B VDD VSS sg13g2_tiehi
X_14305__2259 _14305_/RESET_B VDD VSS sg13g2_tiehi
X_08572_ _08573_/A _08445_/Y _08571_/Y _08570_/Y VDD VSS sg13g2_o21ai_1
XFILLER_81_245 VDD VSS sg13g2_decap_8
XFILLER_82_779 VDD VSS sg13g2_fill_2
XFILLER_34_161 VDD VSS sg13g2_decap_4
XFILLER_23_824 VDD VSS sg13g2_fill_1
XFILLER_62_470 VDD VSS sg13g2_decap_8
XFILLER_22_312 VDD VSS sg13g2_decap_8
XFILLER_37_1070 VDD VSS sg13g2_decap_8
X_14520__2044 _14520_/RESET_B VDD VSS sg13g2_tiehi
X_09124_ _09157_/C _14919_/Q _13168_/A _10760_/A _09150_/B VDD VSS sg13g2_and4_1
XFILLER_11_1210 VDD VSS sg13g2_decap_8
X_09055_ _09057_/B _14908_/Q _09056_/C _14909_/Q VDD VSS sg13g2_a21oi_1
XFILLER_117_940 VDD VSS sg13g2_fill_1
X_14774__3324 _14774_/RESET_B VDD VSS sg13g2_tiehi
X_08006_ _08146_/A _07820_/B _07815_/B _07812_/B _08541_/B _08055_/S0 _08044_/S1 VDD
+ VSS sg13g2_mux4_1
XFILLER_117_995 VDD VSS sg13g2_decap_8
XFILLER_132_954 VDD VSS sg13g2_decap_4
XFILLER_89_345 VDD VSS sg13g2_decap_8
XFILLER_132_976 VDD VSS sg13g2_decap_8
XFILLER_106_21 VDD VSS sg13g2_decap_8
X_09957_ _14541_/D _14541_/Q _10156_/A1 _09961_/S VDD VSS sg13g2_mux2_1
XFILLER_66_14 VDD VSS sg13g2_decap_8
X_08908_ _08908_/Y _08906_/Y _08907_/Y _08925_/S VDD VSS sg13g2_a21oi_1
X_09888_ _14474_/D _09888_/A0 _14474_/Q wire321/X VDD VSS sg13g2_mux2_1
XFILLER_58_754 VDD VSS sg13g2_decap_8
XFILLER_100_840 VDD VSS sg13g2_fill_2
XFILLER_58_765 VDD VSS sg13g2_fill_2
XFILLER_131_1044 VDD VSS sg13g2_decap_8
X_08839_ _10805_/B _10669_/S _14927_/Q VDD VSS sg13g2_nor2b_1
XFILLER_100_884 VDD VSS sg13g2_decap_4
XFILLER_72_223 VDD VSS sg13g2_fill_1
XFILLER_122_42 VDD VSS sg13g2_decap_4
X_11850_ _11850_/X _14701_/Q _14733_/Q _13773_/Q _13805_/Q _11995_/S0 _11995_/S1 VDD
+ VSS sg13g2_mux4_1
X_14730__1834 _14730_/RESET_B VDD VSS sg13g2_tiehi
XFILLER_54_960 VDD VSS sg13g2_decap_4
X_10801_ _10801_/Y _13345_/B _10844_/A _10835_/B2 VDD VSS sg13g2_o21ai_1
XFILLER_26_673 VDD VSS sg13g2_fill_1
XFILLER_72_278 VDD VSS sg13g2_decap_8
X_11781_ _11781_/X _14699_/Q _14731_/Q _13771_/Q _13803_/Q _11787_/S0 _12286_/S1 VDD
+ VSS sg13g2_mux4_1
X_13520_ _15140_/D _13547_/B _13518_/Y _13519_/Y VDD VSS sg13g2_a21oi_1
XFILLER_0_1190 VDD VSS sg13g2_decap_4
X_10732_ _11002_/A _08954_/S _09066_/Y _08898_/Y VDD VSS sg13g2_o21ai_1
XFILLER_15_84 VDD VSS sg13g2_decap_8
XFILLER_90_1050 VDD VSS sg13g2_decap_8
X_13451_ _13455_/C _15174_/Q _15175_/Q VDD VSS sg13g2_nand2_1
XFILLER_16_1132 VDD VSS sg13g2_decap_8
X_10663_ _10664_/A _14893_/Q _14892_/Q _14891_/Q _10663_/D VDD VSS sg13g2_and4_1
XFILLER_9_349 VDD VSS sg13g2_fill_1
XFILLER_103_1102 VDD VSS sg13g2_decap_8
X_12402_ _14992_/D _08173_/B _12638_/A2 _12401_/Y _12400_/Y VDD VSS sg13g2_a22oi_1
XFILLER_103_1113 VDD VSS sg13g2_fill_1
X_10594_ _10595_/A _14875_/Q _14874_/Q _12963_/A _10594_/D VDD VSS sg13g2_and4_1
X_13382_ _13431_/A _13389_/B _13382_/B VDD VSS sg13g2_nand2_1
XFILLER_127_715 VDD VSS sg13g2_decap_8
XFILLER_16_1198 VDD VSS sg13g2_decap_8
XFILLER_5_500 VDD VSS sg13g2_decap_8
X_15121_ _15121_/Q _15212_/CLK _15121_/D _15121_/RESET_B VDD VSS sg13g2_dfrbpq_1
X_12333_ _12334_/B _12322_/Y _12324_/X _12333_/B1 VDD VSS sg13g2_o21ai_1
XFILLER_103_1179 VDD VSS sg13g2_fill_2
XFILLER_126_236 VDD VSS sg13g2_fill_2
XFILLER_126_258 VDD VSS sg13g2_fill_1
X_15052_ _15052_/Q clkload34/A _15052_/D _15052_/RESET_B VDD VSS sg13g2_dfrbpq_1
X_12264_ _12264_/Y _12244_/Y _12246_/X _11765_/A VDD VSS sg13g2_o21ai_1
XFILLER_123_910 VDD VSS sg13g2_decap_8
XFILLER_141_217 VDD VSS sg13g2_decap_8
XFILLER_123_921 VDD VSS sg13g2_fill_1
X_14003_ _14003_/Q clkload11/A _14003_/D _14003_/RESET_B VDD VSS sg13g2_dfrbpq_1
X_11215_ _11216_/B _11230_/S _11210_/X _12334_/C VDD VSS sg13g2_o21ai_1
X_12195_ _12195_/Y _12194_/X _11664_/A _12126_/A VDD VSS sg13g2_a21oi_1
Xoutput50 mem_axi_araddr[21] _13712_/Q VDD VSS sg13g2_buf_1
XFILLER_122_431 VDD VSS sg13g2_fill_1
XFILLER_123_954 VDD VSS sg13g2_decap_8
Xoutput61 mem_axi_araddr[31] _16884_/A VDD VSS sg13g2_buf_1
Xoutput72 mem_axi_awaddr[11] _16864_/X VDD VSS sg13g2_buf_1
XFILLER_150_773 VDD VSS sg13g2_fill_2
Xoutput83 mem_axi_awaddr[22] _16875_/X VDD VSS sg13g2_buf_1
X_11146_ _11173_/B _11146_/A _11146_/B VDD VSS sg13g2_nor2_1
XFILLER_95_304 VDD VSS sg13g2_fill_1
Xoutput94 mem_axi_awaddr[3] _16856_/X VDD VSS sg13g2_buf_1
XFILLER_89_890 VDD VSS sg13g2_decap_4
XFILLER_110_637 VDD VSS sg13g2_decap_8
XFILLER_122_497 VDD VSS sg13g2_fill_2
XFILLER_0_271 VDD VSS sg13g2_decap_8
XFILLER_62_1152 VDD VSS sg13g2_decap_8
XFILLER_114_1220 VDD VSS sg13g2_decap_8
XFILLER_0_282 VDD VSS sg13g2_fill_1
X_11077_ _11077_/Y _11118_/B _11077_/B VDD VSS sg13g2_xnor2_1
XFILLER_76_540 VDD VSS sg13g2_fill_1
XFILLER_23_1147 VDD VSS sg13g2_decap_8
X_14905_ _14905_/Q clkload35/A _14905_/D _14905_/RESET_B VDD VSS sg13g2_dfrbpq_1
X_10028_ _14610_/D _10161_/A1 _14610_/Q _10035_/S VDD VSS sg13g2_mux2_1
XFILLER_97_1204 VDD VSS sg13g2_fill_2
XFILLER_49_798 VDD VSS sg13g2_fill_2
XFILLER_64_724 VDD VSS sg13g2_decap_8
XFILLER_110_1128 VDD VSS sg13g2_decap_8
XFILLER_76_595 VDD VSS sg13g2_decap_8
XFILLER_48_297 VDD VSS sg13g2_decap_8
XFILLER_64_757 VDD VSS sg13g2_fill_2
X_14836_ _14836_/Q _14873_/CLK _14836_/D _14836_/RESET_B VDD VSS sg13g2_dfrbpq_1
XFILLER_45_971 VDD VSS sg13g2_decap_8
XFILLER_91_587 VDD VSS sg13g2_decap_4
X_14767_ _14767_/Q clkload74/A _14767_/D _14767_/RESET_B VDD VSS sg13g2_dfrbpq_1
X_11979_ _14978_/D _11939_/Y _11978_/Y _11934_/Y VDD VSS sg13g2_a21oi_1
XFILLER_17_695 VDD VSS sg13g2_decap_8
XFILLER_16_172 VDD VSS sg13g2_decap_8
XFILLER_72_790 VDD VSS sg13g2_decap_8
XFILLER_60_941 VDD VSS sg13g2_fill_1
X_13718_ _16880_/A _15046_/CLK _13718_/D _13718_/RESET_B VDD VSS sg13g2_dfrbpq_1
XFILLER_60_952 VDD VSS sg13g2_fill_2
XFILLER_32_654 VDD VSS sg13g2_fill_1
X_14698_ _14698_/Q clkload21/A _14698_/D _14698_/RESET_B VDD VSS sg13g2_dfrbpq_1
X_14099__2465 _14099_/RESET_B VDD VSS sg13g2_tiehi
XFILLER_149_317 VDD VSS sg13g2_decap_4
XFILLER_60_996 VDD VSS sg13g2_fill_1
XFILLER_108_1057 VDD VSS sg13g2_decap_8
X_13649_ _15115_/D _15184_/D _15115_/Q _13652_/S VDD VSS sg13g2_mux2_1
XFILLER_31_197 VDD VSS sg13g2_decap_8
XFILLER_145_501 VDD VSS sg13g2_decap_8
XFILLER_30_1118 VDD VSS sg13g2_decap_8
XFILLER_121_1235 VDD VSS sg13g2_fill_2
X_15038__2934 _15038_/RESET_B VDD VSS sg13g2_tiehi
XFILLER_8_382 VDD VSS sg13g2_fill_1
XFILLER_117_225 VDD VSS sg13g2_decap_8
XFILLER_117_236 VDD VSS sg13g2_fill_1
XFILLER_145_556 VDD VSS sg13g2_decap_4
XFILLER_114_910 VDD VSS sg13g2_fill_1
XFILLER_67_1052 VDD VSS sg13g2_decap_4
X_14762__3339 _14762_/RESET_B VDD VSS sg13g2_tiehi
XFILLER_113_420 VDD VSS sg13g2_decap_4
XFILLER_154_1022 VDD VSS sg13g2_decap_4
XFILLER_125_291 VDD VSS sg13g2_fill_1
X_09811_ _14399_/D _09877_/A0 _14399_/Q _09829_/S VDD VSS sg13g2_mux2_1
Xfanout317 _09900_/S wire321/A VDD VSS sg13g2_buf_1
Xfanout328 wire329/A _09599_/S VDD VSS sg13g2_buf_1
XFILLER_114_987 VDD VSS sg13g2_decap_4
XFILLER_114_998 VDD VSS sg13g2_fill_1
XFILLER_140_272 VDD VSS sg13g2_decap_8
XFILLER_101_637 VDD VSS sg13g2_decap_4
XFILLER_113_497 VDD VSS sg13g2_decap_8
XFILLER_154_1099 VDD VSS sg13g2_decap_8
X_09742_ _14332_/D _14332_/Q _09907_/A1 _09760_/S VDD VSS sg13g2_mux2_1
XFILLER_101_648 VDD VSS sg13g2_decap_8
XFILLER_100_136 VDD VSS sg13g2_decap_8
XFILLER_101_659 VDD VSS sg13g2_fill_1
XFILLER_67_551 VDD VSS sg13g2_decap_8
XFILLER_28_938 VDD VSS sg13g2_fill_2
X_14538__2026 _14538_/RESET_B VDD VSS sg13g2_tiehi
X_09673_ _14266_/D _10069_/A0 _14266_/Q _09673_/S VDD VSS sg13g2_mux2_1
XFILLER_28_949 VDD VSS sg13g2_decap_4
X_08624_ _08633_/C _07849_/X _08306_/A _08623_/Y _08643_/C _08622_/Y VDD VSS sg13g2_a221oi_1
XFILLER_27_459 VDD VSS sg13g2_decap_8
XFILLER_70_705 VDD VSS sg13g2_decap_8
X_08555_ _08555_/Y _08554_/Y _08549_/Y _08000_/X VDD VSS sg13g2_o21ai_1
XFILLER_39_1132 VDD VSS sg13g2_decap_8
XFILLER_51_930 VDD VSS sg13g2_fill_2
X_14828__3270 _14828_/RESET_B VDD VSS sg13g2_tiehi
X_08486_ _08501_/C _07822_/B _08541_/A _08485_/Y _07820_/X _08484_/Y VDD VSS sg13g2_a221oi_1
XFILLER_74_1056 VDD VSS sg13g2_decap_8
X_13764__2800 _13764_/RESET_B VDD VSS sg13g2_tiehi
XFILLER_50_451 VDD VSS sg13g2_fill_1
XFILLER_22_164 VDD VSS sg13g2_decap_8
XFILLER_139_7 VDD VSS sg13g2_decap_8
XFILLER_149_862 VDD VSS sg13g2_fill_2
Xwire729 wire729/X wire729/A VDD VSS sg13g2_buf_2
XFILLER_109_737 VDD VSS sg13g2_decap_8
XFILLER_148_383 VDD VSS sg13g2_decap_8
X_09107_ _09107_/Y _15241_/Q _09161_/S VDD VSS sg13g2_nand2b_1
X_14144__2420 _14144_/RESET_B VDD VSS sg13g2_tiehi
X_09038_ _13767_/D _13767_/Q _10150_/A1 _09038_/S VDD VSS sg13g2_mux2_1
X_13797__2767 _13797_/RESET_B VDD VSS sg13g2_tiehi
XFILLER_123_217 VDD VSS sg13g2_decap_8
XFILLER_11_1084 VDD VSS sg13g2_decap_8
XFILLER_117_42 VDD VSS sg13g2_fill_2
XFILLER_2_558 VDD VSS sg13g2_decap_8
X_11000_ _14941_/D _10999_/X _10998_/Y _10987_/Y VDD VSS sg13g2_o21ai_1
XFILLER_117_97 VDD VSS sg13g2_decap_8
XFILLER_77_315 VDD VSS sg13g2_decap_8
Xfanout840 _10903_/B _13294_/B VDD VSS sg13g2_buf_1
XFILLER_104_497 VDD VSS sg13g2_fill_2
Xfanout851 _10767_/A _08943_/A VDD VSS sg13g2_buf_1
Xfanout862 _10691_/S fanout866/X VDD VSS sg13g2_buf_1
X_14177__2387 _14177_/RESET_B VDD VSS sg13g2_tiehi
Xfanout873 _08871_/S _08831_/Y VDD VSS sg13g2_buf_1
XFILLER_19_905 VDD VSS sg13g2_decap_8
X_12951_ _12951_/Y _12900_/A _12825_/B input35/X VDD VSS sg13g2_a21oi_1
XFILLER_133_74 VDD VSS sg13g2_decap_8
X_11902_ _11902_/Y _11902_/A _12334_/C VDD VSS sg13g2_nor2b_1
XFILLER_45_223 VDD VSS sg13g2_decap_8
X_12882_ _12882_/Y _12879_/Y _12880_/Y _12881_/Y VDD VSS sg13g2_a21oi_1
XFILLER_73_565 VDD VSS sg13g2_decap_4
XFILLER_27_960 VDD VSS sg13g2_decap_8
XFILLER_22_1191 VDD VSS sg13g2_decap_8
X_14621_ _14621_/Q clkload52/A _14621_/D _14621_/RESET_B VDD VSS sg13g2_dfrbpq_1
XFILLER_93_89 VDD VSS sg13g2_decap_8
X_11833_ _11833_/Y _11813_/Y _11815_/X _11330_/S VDD VSS sg13g2_o21ai_1
X_14392__2172 _14392_/RESET_B VDD VSS sg13g2_tiehi
XFILLER_26_481 VDD VSS sg13g2_decap_8
XFILLER_18_1205 VDD VSS sg13g2_decap_8
X_14552_ _14552_/Q _15248_/CLK _14552_/D _14552_/RESET_B VDD VSS sg13g2_dfrbpq_1
X_11764_ _11765_/B _11761_/Y _11763_/Y _12191_/B1 VDD VSS sg13g2_a21oi_1
X_13503_ _15129_/D _15174_/D _13504_/A _13501_/Y VDD VSS sg13g2_o21ai_1
XFILLER_41_473 VDD VSS sg13g2_decap_8
X_10715_ _14906_/D _10985_/B1 _10712_/Y _10714_/Y VDD VSS sg13g2_o21ai_1
XFILLER_105_1208 VDD VSS sg13g2_decap_8
X_14483_ _14483_/Q clkload7/A _14483_/D _14483_/RESET_B VDD VSS sg13g2_dfrbpq_1
X_11695_ _11696_/A _13960_/Q _13992_/Q _14024_/Q _14056_/Q _11695_/S0 _11693_/C VDD
+ VSS sg13g2_mux4_1
XFILLER_9_124 VDD VSS sg13g2_decap_4
XFILLER_9_157 VDD VSS sg13g2_fill_2
XFILLER_42_60 VDD VSS sg13g2_decap_8
X_13434_ _15099_/D _15099_/Q _13470_/A2 _13433_/Y VDD VSS sg13g2_a21o_1
X_10646_ _10655_/C _14889_/Q _10643_/C hold3519/X VDD VSS sg13g2_a21oi_1
X_14984__2988 _14984_/RESET_B VDD VSS sg13g2_tiehi
XFILLER_10_871 VDD VSS sg13g2_decap_4
XFILLER_155_854 VDD VSS sg13g2_decap_8
X_13365_ _15074_/D _13361_/C _13435_/A _13363_/Y VDD VSS sg13g2_o21ai_1
Xmax_cap1157 _12685_/S0 _12521_/S0 VDD VSS sg13g2_buf_4
X_10577_ _14870_/D _10586_/D _10595_/B _10577_/C VDD VSS sg13g2_nor3_1
X_15104_ _15104_/Q clkload66/A _15104_/D _15104_/RESET_B VDD VSS sg13g2_dfrbpq_1
X_12316_ _12317_/A _13754_/Q _14106_/Q _14458_/Q _14554_/Q _12303_/S _12307_/C VDD
+ VSS sg13g2_mux4_1
XFILLER_6_875 VDD VSS sg13g2_decap_8
XFILLER_54_7 VDD VSS sg13g2_decap_8
X_13296_ _15056_/D _13296_/A1 _07710_/Y _13295_/Y VDD VSS sg13g2_a21o_1
XFILLER_114_228 VDD VSS sg13g2_fill_1
XFILLER_5_385 VDD VSS sg13g2_decap_4
X_15035_ _15035_/Q clkload35/A _15035_/D _15035_/RESET_B VDD VSS sg13g2_dfrbpq_1
X_12247_ _12247_/Y _11531_/A _14392_/Q VDD VSS sg13g2_nand2b_1
XFILLER_3_21 VDD VSS sg13g2_decap_8
XFILLER_96_613 VDD VSS sg13g2_decap_4
X_12178_ _12178_/Y _12252_/S0 _14518_/Q _12233_/B VDD VSS sg13g2_a21oi_1
XFILLER_69_838 VDD VSS sg13g2_decap_8
XFILLER_110_401 VDD VSS sg13g2_decap_8
XFILLER_151_1217 VDD VSS sg13g2_decap_8
XFILLER_96_635 VDD VSS sg13g2_decap_8
X_11129_ _11129_/Y _11128_/A _11128_/B _11151_/A VDD VSS sg13g2_a21oi_1
XFILLER_111_968 VDD VSS sg13g2_fill_2
X_14007__2557 _14007_/RESET_B VDD VSS sg13g2_tiehi
XFILLER_7_1152 VDD VSS sg13g2_decap_8
X_13842__2722 _13842_/RESET_B VDD VSS sg13g2_tiehi
XFILLER_3_98 VDD VSS sg13g2_decap_8
XFILLER_95_167 VDD VSS sg13g2_decap_8
XFILLER_77_882 VDD VSS sg13g2_fill_1
XFILLER_37_724 VDD VSS sg13g2_fill_1
XFILLER_97_1001 VDD VSS sg13g2_fill_2
XFILLER_110_489 VDD VSS sg13g2_decap_8
XFILLER_114_1061 VDD VSS sg13g2_decap_8
XFILLER_64_532 VDD VSS sg13g2_decap_8
XFILLER_92_841 VDD VSS sg13g2_fill_1
XFILLER_37_757 VDD VSS sg13g2_decap_8
XFILLER_97_1056 VDD VSS sg13g2_decap_8
XFILLER_18_960 VDD VSS sg13g2_decap_8
XFILLER_64_565 VDD VSS sg13g2_decap_8
XFILLER_36_267 VDD VSS sg13g2_decap_8
X_14819_ _14819_/Q clkload83/A _14819_/D _14819_/RESET_B VDD VSS sg13g2_dfrbpq_1
XFILLER_149_1179 VDD VSS sg13g2_decap_8
X_14222__2342 _14222_/RESET_B VDD VSS sg13g2_tiehi
X_08340_ _08340_/Y _08484_/B _08340_/B VDD VSS sg13g2_nand2_1
X_13875__2689 _13875_/RESET_B VDD VSS sg13g2_tiehi
XFILLER_71_1207 VDD VSS sg13g2_fill_1
XFILLER_71_1218 VDD VSS sg13g2_decap_8
X_08271_ _08271_/Y _08098_/B _08363_/S0 _08027_/Y VDD VSS sg13g2_a21oi_1
XFILLER_80_0 VDD VSS sg13g2_decap_8
X_15109__3128 _15109_/RESET_B VDD VSS sg13g2_tiehi
XFILLER_146_832 VDD VSS sg13g2_decap_8
XFILLER_118_523 VDD VSS sg13g2_decap_8
XFILLER_69_1158 VDD VSS sg13g2_decap_4
XFILLER_69_1169 VDD VSS sg13g2_decap_8
XFILLER_105_228 VDD VSS sg13g2_fill_1
XFILLER_99_440 VDD VSS sg13g2_fill_1
XFILLER_99_462 VDD VSS sg13g2_decap_8
XFILLER_59_304 VDD VSS sg13g2_fill_2
X_14470__2094 _14470_/RESET_B VDD VSS sg13g2_tiehi
XFILLER_113_294 VDD VSS sg13g2_decap_8
XFILLER_59_359 VDD VSS sg13g2_decap_8
Xfanout169 _10098_/A0 _10165_/A1 VDD VSS sg13g2_buf_1
X_07986_ _07988_/D _13290_/A wire145/X VDD VSS sg13g2_nand2_1
XFILLER_41_1011 VDD VSS sg13g2_decap_4
XFILLER_45_1191 VDD VSS sg13g2_decap_8
X_09725_ _14316_/D _09824_/A0 _14316_/Q _09729_/S VDD VSS sg13g2_mux2_1
XFILLER_41_1044 VDD VSS sg13g2_decap_8
X_09656_ _14249_/D _09887_/A0 _14249_/Q _09666_/S VDD VSS sg13g2_mux2_1
XFILLER_82_351 VDD VSS sg13g2_fill_2
XFILLER_83_885 VDD VSS sg13g2_fill_1
X_08607_ _08615_/C _08688_/C _08603_/Y _08606_/Y VDD VSS sg13g2_a21oi_1
XFILLER_76_1129 VDD VSS sg13g2_decap_8
X_09587_ _14184_/D _14184_/Q _09655_/A0 _09587_/S VDD VSS sg13g2_mux2_1
XFILLER_36_790 VDD VSS sg13g2_decap_8
XFILLER_24_952 VDD VSS sg13g2_decap_8
X_08538_ _08538_/X _08465_/X _08537_/X _08538_/S VDD VSS sg13g2_mux2_1
X_13705__2859 _13705_/RESET_B VDD VSS sg13g2_tiehi
X_08469_ _08475_/C _08469_/A _08469_/B VDD VSS sg13g2_nor2_1
XFILLER_50_281 VDD VSS sg13g2_decap_8
XFILLER_156_618 VDD VSS sg13g2_fill_1
X_10500_ _10502_/B _10511_/C _14840_/Q _14839_/Q VDD VSS sg13g2_nand3_1
XFILLER_7_606 VDD VSS sg13g2_fill_2
X_11480_ _11480_/Y _11479_/Y _11478_/Y _11465_/Y _11631_/A2 _11701_/C1 VDD VSS sg13g2_a221oi_1
XFILLER_52_1151 VDD VSS sg13g2_fill_1
Xwire537 wire537/X wire537/A VDD VSS sg13g2_buf_2
XFILLER_149_681 VDD VSS sg13g2_decap_4
XFILLER_6_105 VDD VSS sg13g2_decap_8
XFILLER_137_832 VDD VSS sg13g2_fill_1
X_10431_ _10431_/Y _14833_/Q _10434_/C _10444_/C VDD VSS sg13g2_o21ai_1
XFILLER_13_1146 VDD VSS sg13g2_decap_8
XFILLER_12_63 VDD VSS sg13g2_decap_8
X_13920__2644 _13920_/RESET_B VDD VSS sg13g2_tiehi
X_14680__1884 _14680_/RESET_B VDD VSS sg13g2_tiehi
X_13150_ _13150_/Y _14853_/Q _13150_/B VDD VSS sg13g2_nand2_1
XFILLER_137_887 VDD VSS sg13g2_decap_4
X_10362_ _14812_/D _14812_/Q _10359_/Y _10361_/Y VDD VSS sg13g2_a21oi_1
XFILLER_128_63 VDD VSS sg13g2_decap_4
XFILLER_136_386 VDD VSS sg13g2_decap_8
XFILLER_88_23 VDD VSS sg13g2_fill_1
XFILLER_136_397 VDD VSS sg13g2_fill_2
X_12101_ _12101_/X _12101_/A _12108_/B VDD VSS sg13g2_and2_1
XFILLER_152_857 VDD VSS sg13g2_decap_8
X_10293_ _10295_/A _14791_/Q _10294_/C _14792_/Q VDD VSS sg13g2_a21o_1
X_13081_ _13081_/X input12/X _13149_/A2 _13264_/B1 VDD VSS sg13g2_a21o_1
XFILLER_2_333 VDD VSS sg13g2_decap_8
XFILLER_151_356 VDD VSS sg13g2_decap_8
XFILLER_3_889 VDD VSS sg13g2_decap_4
X_12032_ _12032_/Y _12040_/A1 _14482_/Q VDD VSS sg13g2_nand2b_1
Xfanout1602 _12237_/C _12308_/C VDD VSS sg13g2_buf_1
X_14300__2264 _14300_/RESET_B VDD VSS sg13g2_tiehi
Xfanout1613 _11714_/S1 _12171_/S1 VDD VSS sg13g2_buf_1
Xfanout1624 _11598_/C _12100_/S1 VDD VSS sg13g2_buf_1
XFILLER_137_1094 VDD VSS sg13g2_fill_2
Xfanout1635 _12285_/S1 fanout1639/X VDD VSS sg13g2_buf_1
XFILLER_120_754 VDD VSS sg13g2_decap_8
Xfanout1646 _11995_/S1 fanout1650/X VDD VSS sg13g2_buf_1
Xfanout1657 _11226_/S1 _12319_/B1 VDD VSS sg13g2_buf_1
Xfanout670 wire671/A _09473_/S VDD VSS sg13g2_buf_1
XFILLER_120_776 VDD VSS sg13g2_decap_8
Xfanout681 _09407_/S _09375_/Y VDD VSS sg13g2_buf_1
Xfanout1679 _12207_/S0 fanout1688/X VDD VSS sg13g2_buf_1
XFILLER_19_713 VDD VSS sg13g2_fill_2
XFILLER_65_318 VDD VSS sg13g2_decap_8
X_13983_ _13983_/Q _14509_/CLK _13983_/D _13983_/RESET_B VDD VSS sg13g2_dfrbpq_1
XFILLER_19_746 VDD VSS sg13g2_fill_1
XFILLER_18_212 VDD VSS sg13g2_decap_4
XFILLER_86_690 VDD VSS sg13g2_decap_8
XFILLER_20_1128 VDD VSS sg13g2_decap_8
X_12934_ _12934_/Y _12900_/A _12825_/B input34/X VDD VSS sg13g2_a21oi_1
XFILLER_18_256 VDD VSS sg13g2_decap_8
XFILLER_61_502 VDD VSS sg13g2_decap_8
X_14927__3075 _14927_/RESET_B VDD VSS sg13g2_tiehi
XFILLER_94_1229 VDD VSS sg13g2_decap_8
XFILLER_61_524 VDD VSS sg13g2_decap_8
X_12865_ _12865_/Y _12862_/Y _12863_/Y _12864_/Y VDD VSS sg13g2_a21oi_1
XFILLER_61_535 VDD VSS sg13g2_fill_1
X_14604_ _14604_/Q _14714_/CLK _14604_/D _14604_/RESET_B VDD VSS sg13g2_dfrbpq_1
XFILLER_15_952 VDD VSS sg13g2_fill_1
X_11816_ _11816_/Y _11826_/A1 _14380_/Q VDD VSS sg13g2_nand2b_1
XFILLER_18_1002 VDD VSS sg13g2_decap_8
X_12796_ _12801_/B _12997_/B _12799_/A VDD VSS sg13g2_nor2b_1
X_14535_ _14535_/Q clkload10/A _14535_/D _14535_/RESET_B VDD VSS sg13g2_dfrbpq_1
XFILLER_57_1084 VDD VSS sg13g2_decap_8
X_11747_ _11747_/Y _11747_/A _11747_/B VDD VSS sg13g2_nor2_1
XFILLER_41_270 VDD VSS sg13g2_decap_8
XFILLER_18_1079 VDD VSS sg13g2_decap_8
XFILLER_31_1202 VDD VSS sg13g2_decap_8
X_14466_ _14466_/Q clkload25/A _14466_/D _14466_/RESET_B VDD VSS sg13g2_dfrbpq_1
XFILLER_30_988 VDD VSS sg13g2_decap_8
X_11678_ _11678_/X _13736_/Q _14088_/Q _14440_/Q _14536_/Q _11692_/A _11693_/C VDD
+ VSS sg13g2_mux4_1
X_13417_ _13490_/D _15129_/Q _13438_/B _13438_/D VDD VSS sg13g2_nand3_1
X_10629_ _10630_/B _14880_/Q _14879_/Q _10629_/C _10629_/D VDD VSS sg13g2_nand4_1
X_14397_ _14397_/Q clkload53/A _14397_/D _14397_/RESET_B VDD VSS sg13g2_dfrbpq_1
X_13348_ _13348_/Y _15171_/D _15169_/D _15170_/D _15172_/D VDD VSS sg13g2_nand4_1
XFILLER_154_161 VDD VSS sg13g2_decap_8
XFILLER_143_868 VDD VSS sg13g2_decap_4
X_13279_ _13279_/Y _15071_/Q _13279_/B _13307_/B _13279_/D VDD VSS sg13g2_nor4_1
XFILLER_142_378 VDD VSS sg13g2_decap_8
X_15018_ _15018_/Q clkload30/A _15018_/D _15018_/RESET_B VDD VSS sg13g2_dfrbpq_1
XFILLER_69_602 VDD VSS sg13g2_fill_2
XFILLER_64_1033 VDD VSS sg13g2_fill_1
XFILLER_9_1225 VDD VSS sg13g2_decap_8
XFILLER_69_624 VDD VSS sg13g2_decap_8
XFILLER_9_1236 VDD VSS sg13g2_fill_1
XFILLER_64_1055 VDD VSS sg13g2_decap_8
XFILLER_111_721 VDD VSS sg13g2_decap_8
XFILLER_116_1123 VDD VSS sg13g2_decap_8
XFILLER_29_1186 VDD VSS sg13g2_decap_8
XFILLER_97_955 VDD VSS sg13g2_fill_1
X_07840_ _08654_/A _15018_/Q _08653_/B VDD VSS sg13g2_nor2_1
XFILLER_25_1039 VDD VSS sg13g2_decap_8
XFILLER_57_808 VDD VSS sg13g2_fill_2
XFILLER_68_156 VDD VSS sg13g2_decap_8
XFILLER_112_1009 VDD VSS sg13g2_fill_2
XFILLER_151_1058 VDD VSS sg13g2_decap_8
XFILLER_84_616 VDD VSS sg13g2_decap_8
XFILLER_83_104 VDD VSS sg13g2_decap_4
XFILLER_110_264 VDD VSS sg13g2_decap_4
X_07771_ _08318_/B _11526_/A _14998_/Q VDD VSS sg13g2_xor2_1
XFILLER_84_638 VDD VSS sg13g2_fill_2
XFILLER_65_830 VDD VSS sg13g2_fill_1
X_09510_ _14109_/D _09609_/A0 _14109_/Q _09512_/S VDD VSS sg13g2_mux2_1
XFILLER_64_351 VDD VSS sg13g2_decap_8
XFILLER_37_587 VDD VSS sg13g2_fill_1
XFILLER_65_896 VDD VSS sg13g2_decap_4
X_09441_ _09441_/Y _15064_/Q _10004_/B _09441_/C _09441_/D VDD VSS sg13g2_nand4_1
XFILLER_80_844 VDD VSS sg13g2_decap_8
XFILLER_52_546 VDD VSS sg13g2_decap_8
XFILLER_80_855 VDD VSS sg13g2_decap_8
X_09372_ _13976_/D _09836_/A0 _13976_/Q _09374_/S VDD VSS sg13g2_mux2_1
X_08323_ _08323_/Y _07796_/B _08322_/Y _08588_/B VDD VSS sg13g2_o21ai_1
XFILLER_75_1195 VDD VSS sg13g2_decap_4
XFILLER_71_1037 VDD VSS sg13g2_fill_1
XFILLER_123_1116 VDD VSS sg13g2_decap_8
X_08254_ _08426_/B _08171_/X _08253_/X _08538_/S VDD VSS sg13g2_mux2_1
XFILLER_21_977 VDD VSS sg13g2_decap_8
X_14488__2076 _14488_/RESET_B VDD VSS sg13g2_tiehi
XFILLER_137_128 VDD VSS sg13g2_fill_2
XFILLER_20_498 VDD VSS sg13g2_decap_8
X_08185_ _08185_/Y _08184_/Y _07876_/Y _08685_/A1 VDD VSS sg13g2_a21oi_1
XFILLER_118_331 VDD VSS sg13g2_decap_8
XFILLER_3_119 VDD VSS sg13g2_decap_8
XFILLER_0_815 VDD VSS sg13g2_decap_8
XFILLER_0_826 VDD VSS sg13g2_fill_1
XFILLER_102_743 VDD VSS sg13g2_fill_2
XFILLER_101_242 VDD VSS sg13g2_decap_8
XFILLER_114_21 VDD VSS sg13g2_decap_8
XFILLER_130_1109 VDD VSS sg13g2_decap_8
X_07969_ _07976_/C _07969_/A _08666_/A _08650_/A _07969_/D VDD VSS sg13g2_nor4_1
X_14094__2470 _14094_/RESET_B VDD VSS sg13g2_tiehi
XFILLER_74_14 VDD VSS sg13g2_fill_1
X_09708_ _14299_/D _09741_/A1 _14299_/Q _09727_/S VDD VSS sg13g2_mux2_1
XFILLER_90_608 VDD VSS sg13g2_decap_8
X_10980_ _10980_/Y _10978_/Y _11009_/D _11043_/A VDD VSS sg13g2_a21oi_1
XFILLER_28_587 VDD VSS sg13g2_decap_8
XFILLER_43_513 VDD VSS sg13g2_decap_8
X_09639_ _09806_/D _09905_/A _10105_/C VDD VSS sg13g2_and2_1
XFILLER_82_170 VDD VSS sg13g2_decap_8
X_13938__2626 _13938_/RESET_B VDD VSS sg13g2_tiehi
X_14698__1866 _14698_/RESET_B VDD VSS sg13g2_tiehi
XFILLER_130_42 VDD VSS sg13g2_decap_8
X_12650_ _12650_/X _12648_/X _12649_/X _12678_/S VDD VSS sg13g2_mux2_1
XFILLER_130_53 VDD VSS sg13g2_fill_1
XFILLER_12_911 VDD VSS sg13g2_fill_2
X_11601_ _11601_/Y _11601_/A _11615_/B VDD VSS sg13g2_nand2_1
X_12581_ _12581_/X _12580_/X _12579_/X _12581_/S VDD VSS sg13g2_mux2_1
X_14320_ _14320_/Q clkload47/A _14320_/D _14320_/RESET_B VDD VSS sg13g2_dfrbpq_1
X_11532_ _11533_/B _11532_/A _11532_/B _12187_/C VDD VSS sg13g2_nand3_1
Xwire301 wire301/X wire301/A VDD VSS sg13g2_buf_2
XFILLER_156_415 VDD VSS sg13g2_decap_8
XFILLER_156_426 VDD VSS sg13g2_fill_1
X_14318__2246 _14318_/RESET_B VDD VSS sg13g2_tiehi
XFILLER_128_128 VDD VSS sg13g2_fill_1
XFILLER_23_84 VDD VSS sg13g2_decap_8
X_14251_ _14251_/Q _14731_/CLK _14251_/D _14251_/RESET_B VDD VSS sg13g2_dfrbpq_1
XFILLER_128_0 VDD VSS sg13g2_decap_8
X_11463_ _11463_/Y _11463_/A _11463_/B _11463_/C VDD VSS sg13g2_nor3_1
XFILLER_139_84 VDD VSS sg13g2_fill_2
Xwire367 wire367/X wire367/A VDD VSS sg13g2_buf_1
XFILLER_104_1071 VDD VSS sg13g2_decap_8
X_13202_ _13204_/B _13202_/A _13202_/B VDD VSS sg13g2_nand2_1
Xwire378 wire378/X wire378/A VDD VSS sg13g2_buf_2
X_10414_ _10415_/A _14827_/Q _10414_/B _10414_/C _10414_/D VDD VSS sg13g2_and4_1
X_14182_ _14182_/Q _14662_/CLK _14182_/D _14182_/RESET_B VDD VSS sg13g2_dfrbpq_1
XFILLER_125_824 VDD VSS sg13g2_decap_4
X_11394_ _11395_/A _14687_/Q _14719_/Q _13759_/Q _13791_/Q _11418_/A _11391_/B VDD
+ VSS sg13g2_mux4_1
XFILLER_99_77 VDD VSS sg13g2_decap_8
XFILLER_3_620 VDD VSS sg13g2_decap_8
XFILLER_87_1066 VDD VSS sg13g2_decap_4
X_13133_ _13146_/C _14914_/Q _13673_/Q _13133_/C VDD VSS sg13g2_nand3_1
X_10345_ _10346_/B _14807_/Q _14808_/Q _10345_/C _10345_/D VDD VSS sg13g2_nand4_1
X_14533__2031 _14533_/RESET_B VDD VSS sg13g2_tiehi
XFILLER_87_1099 VDD VSS sg13g2_decap_4
XFILLER_152_698 VDD VSS sg13g2_decap_8
X_13064_ _13172_/A _13064_/A _13064_/B VDD VSS sg13g2_xor2_1
XFILLER_151_175 VDD VSS sg13g2_fill_2
X_10276_ _10279_/B _14786_/Q _10305_/A _14787_/Q VDD VSS sg13g2_a21oi_1
XFILLER_133_890 VDD VSS sg13g2_fill_2
XFILLER_2_174 VDD VSS sg13g2_decap_8
XFILLER_61_1206 VDD VSS sg13g2_fill_2
Xfanout1410 _12229_/A _14986_/Q VDD VSS sg13g2_buf_1
XFILLER_79_966 VDD VSS sg13g2_fill_2
X_12015_ _12019_/A _12014_/X _12023_/B VDD VSS sg13g2_nand2b_1
Xfanout1421 _08635_/A3 _12084_/A VDD VSS sg13g2_buf_1
XFILLER_78_443 VDD VSS sg13g2_decap_8
X_14787__3311 _14787_/RESET_B VDD VSS sg13g2_tiehi
Xfanout1432 _07815_/B _14978_/Q VDD VSS sg13g2_buf_1
Xfanout1443 _08456_/B _07804_/B VDD VSS sg13g2_buf_1
XFILLER_94_914 VDD VSS sg13g2_decap_8
Xfanout1454 _11726_/A _14972_/Q VDD VSS sg13g2_buf_1
Xfanout1465 _07775_/A _11591_/A VDD VSS sg13g2_buf_1
XFILLER_17_7 VDD VSS sg13g2_decap_8
XFILLER_4_1111 VDD VSS sg13g2_decap_8
Xfanout1476 _08219_/A _11483_/A VDD VSS sg13g2_buf_1
XFILLER_65_115 VDD VSS sg13g2_decap_8
XFILLER_66_638 VDD VSS sg13g2_fill_2
XFILLER_24_1050 VDD VSS sg13g2_decap_8
XFILLER_65_126 VDD VSS sg13g2_decap_8
Xfanout1487 _07893_/B _11384_/A VDD VSS sg13g2_buf_1
Xfanout1498 _12997_/A _12844_/B VDD VSS sg13g2_buf_1
XFILLER_93_457 VDD VSS sg13g2_decap_8
X_13966_ _13966_/Q _14494_/CLK _13966_/D _13966_/RESET_B VDD VSS sg13g2_dfrbpq_1
XFILLER_0_22 VDD VSS sg13g2_fill_2
X_15134__3074 _15134_/RESET_B VDD VSS sg13g2_tiehi
XFILLER_98_1140 VDD VSS sg13g2_decap_4
XFILLER_4_1188 VDD VSS sg13g2_decap_8
XFILLER_111_1075 VDD VSS sg13g2_decap_4
X_12917_ _12917_/Y _14806_/Q _07728_/A _13082_/B VDD VSS sg13g2_a21oi_1
XFILLER_46_384 VDD VSS sg13g2_decap_8
X_13897_ _13897_/Q clkload1/A _13897_/D _13897_/RESET_B VDD VSS sg13g2_dfrbpq_1
XFILLER_46_395 VDD VSS sg13g2_fill_1
XFILLER_61_321 VDD VSS sg13g2_fill_1
XFILLER_94_1048 VDD VSS sg13g2_decap_8
XFILLER_59_1179 VDD VSS sg13g2_fill_2
XFILLER_146_1138 VDD VSS sg13g2_decap_8
X_12848_ _12848_/X _14897_/Q _13690_/Q VDD VSS sg13g2_xor2_1
XFILLER_22_719 VDD VSS sg13g2_fill_2
XFILLER_148_905 VDD VSS sg13g2_decap_8
XFILLER_9_42 VDD VSS sg13g2_decap_8
X_12779_ _12792_/A _10177_/A _12779_/A2 _15020_/Q VDD VSS sg13g2_a21oi_1
X_13792__2772 _13792_/RESET_B VDD VSS sg13g2_tiehi
X_14518_ _14518_/Q clkload24/A _14518_/D _14518_/RESET_B VDD VSS sg13g2_dfrbpq_1
X_15226__3379 _15226_/RESET_B VDD VSS sg13g2_tiehi
XFILLER_119_106 VDD VSS sg13g2_decap_8
XFILLER_147_448 VDD VSS sg13g2_fill_2
XFILLER_30_796 VDD VSS sg13g2_fill_2
X_14743__1821 _14743_/RESET_B VDD VSS sg13g2_tiehi
XFILLER_80_90 VDD VSS sg13g2_fill_2
X_14449_ _14449_/Q clkload45/A _14449_/D _14449_/RESET_B VDD VSS sg13g2_dfrbpq_1
XFILLER_122_1160 VDD VSS sg13g2_fill_2
XFILLER_128_673 VDD VSS sg13g2_fill_1
XFILLER_155_481 VDD VSS sg13g2_decap_8
XFILLER_128_695 VDD VSS sg13g2_decap_8
X_14172__2392 _14172_/RESET_B VDD VSS sg13g2_tiehi
XFILLER_31_1098 VDD VSS sg13g2_decap_8
Xmax_cap645 _09569_/S _09553_/S VDD VSS sg13g2_buf_4
X_09990_ _14573_/D _10089_/A0 _14573_/Q _10003_/S VDD VSS sg13g2_mux2_1
Xmax_cap667 _09467_/S _09457_/S VDD VSS sg13g2_buf_4
XFILLER_116_879 VDD VSS sg13g2_fill_2
XFILLER_142_142 VDD VSS sg13g2_decap_8
XFILLER_118_1207 VDD VSS sg13g2_decap_8
XFILLER_43_0 VDD VSS sg13g2_decap_8
Xmax_cap678 _09406_/S _09380_/S VDD VSS sg13g2_buf_4
XFILLER_143_687 VDD VSS sg13g2_fill_2
XFILLER_142_164 VDD VSS sg13g2_decap_8
X_08941_ _13719_/D _16881_/A _08940_/X _08941_/S VDD VSS sg13g2_mux2_1
XFILLER_88_229 VDD VSS sg13g2_fill_1
X_15180__3232 _15180_/RESET_B VDD VSS sg13g2_tiehi
X_08872_ _13701_/D _16863_/A _08871_/X _08892_/S VDD VSS sg13g2_mux2_1
XFILLER_85_903 VDD VSS sg13g2_decap_8
XFILLER_29_307 VDD VSS sg13g2_decap_4
XFILLER_57_616 VDD VSS sg13g2_fill_1
XFILLER_57_627 VDD VSS sg13g2_decap_8
X_07823_ _07823_/Y _07822_/A _07822_/B _07818_/Y VDD VSS sg13g2_o21ai_1
XFILLER_9_1099 VDD VSS sg13g2_decap_8
Xclkbuf_5_15__f_clk_i clkbuf_leaf_92_clk_i/A clkbuf_4_7_0_clk_i/X VDD VSS sg13g2_buf_16
XFILLER_111_584 VDD VSS sg13g2_fill_1
XFILLER_85_969 VDD VSS sg13g2_decap_4
XFILLER_56_137 VDD VSS sg13g2_fill_1
XFILLER_38_863 VDD VSS sg13g2_decap_4
X_07754_ _07754_/Y _13281_/B _07754_/B VDD VSS sg13g2_nor2_1
XFILLER_37_340 VDD VSS sg13g2_fill_1
XFILLER_65_682 VDD VSS sg13g2_decap_8
XFILLER_53_833 VDD VSS sg13g2_decap_4
X_07685_ _07687_/B _15055_/Q _11243_/B _13281_/B VDD VSS sg13g2_a21o_1
XFILLER_25_546 VDD VSS sg13g2_fill_2
XFILLER_44_28 VDD VSS sg13g2_decap_8
X_09424_ _14026_/D _09789_/A0 _14026_/Q _09424_/S VDD VSS sg13g2_mux2_1
XFILLER_38_1219 VDD VSS sg13g2_decap_8
XFILLER_64_192 VDD VSS sg13g2_decap_8
XFILLER_52_376 VDD VSS sg13g2_fill_2
X_09355_ _13959_/D _10083_/A0 _13959_/Q _09368_/S VDD VSS sg13g2_mux2_1
X_08306_ _08306_/Y _08306_/A _08306_/B _08306_/C VDD VSS sg13g2_nand3_1
X_09286_ _13894_/D _13894_/Q _10082_/A0 _09299_/S VDD VSS sg13g2_mux2_1
XFILLER_21_774 VDD VSS sg13g2_decap_8
XFILLER_60_49 VDD VSS sg13g2_decap_8
X_08237_ _08237_/Y _08036_/A _08234_/Y _08329_/B _08236_/X VDD VSS sg13g2_a22oi_1
XFILLER_121_7 VDD VSS sg13g2_decap_8
XFILLER_153_418 VDD VSS sg13g2_decap_8
XFILLER_101_1233 VDD VSS sg13g2_decap_4
XFILLER_119_673 VDD VSS sg13g2_decap_4
X_08168_ _08168_/Y _13525_/A _08044_/X _08167_/X VDD VSS sg13g2_o21ai_1
XFILLER_4_428 VDD VSS sg13g2_decap_8
XFILLER_134_632 VDD VSS sg13g2_fill_2
XFILLER_4_439 VDD VSS sg13g2_fill_1
XFILLER_69_14 VDD VSS sg13g2_decap_8
X_14002__2562 _14002_/RESET_B VDD VSS sg13g2_tiehi
XFILLER_118_183 VDD VSS sg13g2_decap_4
X_08099_ _08200_/C _08278_/A3 _08258_/C _07888_/B _07768_/A _08099_/S0 _08048_/A VDD
+ VSS sg13g2_mux4_1
X_10130_ _14708_/D _10163_/A1 _14708_/Q _10132_/S VDD VSS sg13g2_mux2_1
Xclkbuf_leaf_112_clk_i clkload33/A clkbuf_5_12__f_clk_i/X VDD VSS sg13g2_buf_8
X_14606__1958 _14606_/RESET_B VDD VSS sg13g2_tiehi
X_10061_ _14642_/D _10161_/A1 _14642_/Q _10061_/S VDD VSS sg13g2_mux2_1
XFILLER_0_678 VDD VSS sg13g2_fill_1
XFILLER_75_402 VDD VSS sg13g2_decap_8
XFILLER_102_562 VDD VSS sg13g2_decap_8
XFILLER_85_35 VDD VSS sg13g2_decap_8
X_13870__2694 _13870_/RESET_B VDD VSS sg13g2_tiehi
XFILLER_21_1201 VDD VSS sg13g2_decap_8
XFILLER_47_137 VDD VSS sg13g2_decap_8
XFILLER_76_969 VDD VSS sg13g2_fill_1
X_13820_ _13820_/Q clkload76/A _13820_/D _13820_/RESET_B VDD VSS sg13g2_dfrbpq_1
XFILLER_47_148 VDD VSS sg13g2_fill_2
XFILLER_85_79 VDD VSS sg13g2_fill_1
Xclkbuf_leaf_127_clk_i clkload2/A clkbuf_leaf_1_clk_i/A VDD VSS sg13g2_buf_8
XFILLER_91_928 VDD VSS sg13g2_decap_8
X_13751_ _13751_/Q clkload3/A _13751_/D _13751_/RESET_B VDD VSS sg13g2_dfrbpq_1
XFILLER_18_84 VDD VSS sg13g2_decap_8
XFILLER_141_63 VDD VSS sg13g2_decap_8
X_10963_ _10964_/B _10949_/Y _11004_/A _10942_/Y VDD VSS sg13g2_a21oi_1
X_12702_ _12702_/X _14580_/Q _14612_/Q _14644_/Q _14676_/Q _12703_/S0 _12703_/S1 VDD
+ VSS sg13g2_mux4_1
X_13682_ _13682_/Q clkload62/A _13682_/D _13682_/RESET_B VDD VSS sg13g2_dfrbpq_1
XFILLER_71_674 VDD VSS sg13g2_decap_4
X_10894_ _10904_/B _10893_/A _10893_/B _10948_/A VDD VSS sg13g2_a21o_1
X_12633_ _12633_/X _14703_/Q _14735_/Q _13775_/Q _13807_/Q _12715_/S0 _12770_/S1 VDD
+ VSS sg13g2_mux4_1
XFILLER_19_1163 VDD VSS sg13g2_decap_8
XFILLER_141_1002 VDD VSS sg13g2_decap_8
XFILLER_34_83 VDD VSS sg13g2_decap_4
XFILLER_12_752 VDD VSS sg13g2_decap_8
X_12564_ _12564_/X _13962_/Q _13994_/Q _14026_/Q _14058_/Q _12564_/S0 _12564_/S1 VDD
+ VSS sg13g2_mux4_1
XFILLER_12_774 VDD VSS sg13g2_decap_8
XFILLER_11_240 VDD VSS sg13g2_decap_8
XFILLER_15_1038 VDD VSS sg13g2_fill_1
XFILLER_156_223 VDD VSS sg13g2_decap_8
XFILLER_141_1046 VDD VSS sg13g2_fill_2
X_14303_ _14303_/Q _14509_/CLK _14303_/D _14303_/RESET_B VDD VSS sg13g2_dfrbpq_1
XFILLER_156_234 VDD VSS sg13g2_fill_1
X_11515_ _11516_/A _11509_/X _11510_/X _11513_/X _11514_/X wire964/X _12217_/A VDD
+ VSS sg13g2_mux4_1
XFILLER_141_1068 VDD VSS sg13g2_decap_8
X_12495_ _12495_/X _12492_/X _12491_/X _12488_/X _12487_/X _12746_/S1 _12748_/S VDD
+ VSS sg13g2_mux4_1
Xwire142 wire142/X wire142/A VDD VSS sg13g2_buf_2
XFILLER_11_295 VDD VSS sg13g2_fill_1
Xwire153 wire153/X wire153/A VDD VSS sg13g2_buf_2
XFILLER_156_278 VDD VSS sg13g2_decap_4
X_14234_ _14234_/Q clkload57/A _14234_/D _14234_/RESET_B VDD VSS sg13g2_dfrbpq_1
X_11446_ _11446_/Y _11446_/A _11446_/B VDD VSS sg13g2_nor2_1
XFILLER_50_82 VDD VSS sg13g2_decap_8
XFILLER_153_930 VDD VSS sg13g2_decap_8
X_14165_ _14165_/Q _14671_/CLK _14165_/D _14165_/RESET_B VDD VSS sg13g2_dfrbpq_1
X_11377_ _11377_/Y _11375_/Y _11374_/Y _11875_/B _11376_/X VDD VSS sg13g2_a22oi_1
XFILLER_4_951 VDD VSS sg13g2_decap_8
X_13116_ _13171_/A _13116_/A _13116_/B _13116_/C VDD VSS sg13g2_nand3_1
XFILLER_152_484 VDD VSS sg13g2_decap_8
X_10328_ _14802_/D _10405_/C _10345_/C _10325_/B _07646_/Y _10347_/B VDD VSS sg13g2_a221oi_1
XFILLER_3_472 VDD VSS sg13g2_decap_4
X_14096_ _14096_/Q clkload50/A _14096_/D _14096_/RESET_B VDD VSS sg13g2_dfrbpq_1
XFILLER_112_326 VDD VSS sg13g2_decap_8
XFILLER_65_1150 VDD VSS sg13g2_fill_1
XFILLER_79_741 VDD VSS sg13g2_fill_1
X_13047_ _13048_/A _12937_/A _13046_/Y _12933_/Y VDD VSS sg13g2_o21ai_1
X_10259_ _10259_/Y _10265_/A _10265_/D _10256_/C VDD VSS sg13g2_o21ai_1
XFILLER_140_679 VDD VSS sg13g2_fill_2
XFILLER_67_903 VDD VSS sg13g2_fill_2
XFILLER_26_1156 VDD VSS sg13g2_decap_8
XFILLER_61_1036 VDD VSS sg13g2_decap_8
XFILLER_67_925 VDD VSS sg13g2_decap_8
Xfanout1240 _13566_/B _13601_/B VDD VSS sg13g2_buf_1
Xfanout1251 _13381_/B _15183_/Q VDD VSS sg13g2_buf_1
XFILLER_152_1175 VDD VSS sg13g2_decap_8
XFILLER_22_1009 VDD VSS sg13g2_decap_8
Xfanout1262 _12346_/A _15120_/Q VDD VSS sg13g2_buf_1
Xfanout1273 _12930_/B1 _13162_/A2 VDD VSS sg13g2_buf_1
X_13700__2864 _13700_/RESET_B VDD VSS sg13g2_tiehi
X_13672__2913 _13672_/RESET_B VDD VSS sg13g2_tiehi
Xfanout1284 _08497_/A _08229_/B VDD VSS sg13g2_buf_1
Xfanout1295 _10895_/B1 fanout1298/X VDD VSS sg13g2_buf_1
X_14998_ _14998_/Q clkload30/A _14998_/D _14998_/RESET_B VDD VSS sg13g2_dfrbpq_1
XFILLER_35_811 VDD VSS sg13g2_fill_2
XFILLER_93_276 VDD VSS sg13g2_decap_4
XFILLER_75_90 VDD VSS sg13g2_decap_8
X_13949_ _13949_/Q _14525_/CLK _13949_/D _13949_/RESET_B VDD VSS sg13g2_dfrbpq_1
XFILLER_74_490 VDD VSS sg13g2_decap_8
Xclkbuf_leaf_91_clk_i clkload40/A clkbuf_leaf_92_clk_i/A VDD VSS sg13g2_buf_8
XFILLER_50_803 VDD VSS sg13g2_decap_8
XFILLER_22_505 VDD VSS sg13g2_decap_8
XFILLER_62_674 VDD VSS sg13g2_fill_2
XFILLER_37_1230 VDD VSS sg13g2_decap_8
XFILLER_50_836 VDD VSS sg13g2_decap_8
XFILLER_61_184 VDD VSS sg13g2_decap_8
XFILLER_61_195 VDD VSS sg13g2_fill_1
X_09140_ _10781_/A _15049_/Q _15246_/Q _09147_/B VDD VSS sg13g2_mux2_1
XFILLER_148_746 VDD VSS sg13g2_decap_4
XFILLER_33_1138 VDD VSS sg13g2_fill_1
X_09071_ _13772_/D _13772_/Q _10155_/A1 _09106_/S VDD VSS sg13g2_mux2_1
X_08022_ _08402_/C _08110_/C _08199_/B VDD VSS sg13g2_nand2_1
Xmax_cap420 _09934_/S _09933_/S VDD VSS sg13g2_buf_4
Xmax_cap431 _09865_/S _09855_/S VDD VSS sg13g2_buf_4
Xmax_cap442 _09770_/S _09769_/S VDD VSS sg13g2_buf_4
XFILLER_89_505 VDD VSS sg13g2_fill_2
XFILLER_104_805 VDD VSS sg13g2_decap_8
Xmax_cap464 _09635_/S _09632_/S VDD VSS sg13g2_buf_4
XFILLER_131_613 VDD VSS sg13g2_fill_2
XFILLER_116_698 VDD VSS sg13g2_decap_8
X_09973_ _14556_/D _10039_/A0 _14556_/Q _09991_/S VDD VSS sg13g2_mux2_1
X_14997__2975 _14997_/RESET_B VDD VSS sg13g2_tiehi
XFILLER_89_549 VDD VSS sg13g2_fill_1
XFILLER_103_326 VDD VSS sg13g2_decap_4
XFILLER_39_28 VDD VSS sg13g2_decap_8
X_08924_ _08924_/X _15044_/Q _14948_/Q _10757_/A VDD VSS sg13g2_mux2_1
Xclkbuf_leaf_44_clk_i _14763_/CLK clkbuf_leaf_62_clk_i/A VDD VSS sg13g2_buf_8
X_08855_ _13696_/D _13696_/Q _08854_/X _08935_/S VDD VSS sg13g2_mux2_1
XFILLER_85_733 VDD VSS sg13g2_decap_4
X_07806_ _07948_/A _07807_/C _08476_/A VDD VSS sg13g2_and2_1
X_08786_ _13680_/D _08728_/Y _08785_/Y _08784_/Y VDD VSS sg13g2_a21oi_1
XFILLER_38_660 VDD VSS sg13g2_decap_4
X_07737_ _07737_/Y _10213_/A _07737_/B VDD VSS sg13g2_nand2_1
Xclkbuf_leaf_59_clk_i clkload73/A clkbuf_leaf_67_clk_i/A VDD VSS sg13g2_buf_8
XFILLER_25_343 VDD VSS sg13g2_decap_8
XFILLER_81_961 VDD VSS sg13g2_decap_4
X_07668_ _10171_/D _13613_/B _13613_/C VDD VSS sg13g2_nand2_1
X_09407_ _14010_/D _10102_/A0 _14010_/Q _09407_/S VDD VSS sg13g2_mux2_1
XFILLER_90_1221 VDD VSS sg13g2_decap_8
XFILLER_13_549 VDD VSS sg13g2_fill_2
X_09338_ _13945_/D _09705_/A0 _13945_/Q _09339_/S VDD VSS sg13g2_mux2_1
X_09269_ _13878_/D _13878_/Q _10132_/A0 _09269_/S VDD VSS sg13g2_mux2_1
XFILLER_154_705 VDD VSS sg13g2_decap_4
X_11300_ _11300_/X _14685_/Q _14717_/Q _13757_/Q _13789_/Q _11300_/S0 _11391_/B VDD
+ VSS sg13g2_mux4_1
XFILLER_14_1071 VDD VSS sg13g2_decap_8
X_13888__2676 _13888_/RESET_B VDD VSS sg13g2_tiehi
X_12280_ _12280_/Y wire147/X _12280_/B VDD VSS sg13g2_xnor2_1
XFILLER_101_1052 VDD VSS sg13g2_fill_2
XFILLER_106_120 VDD VSS sg13g2_fill_2
X_11231_ _11231_/X _11230_/X _11227_/X _12334_/C VDD VSS sg13g2_mux2_1
XFILLER_153_259 VDD VSS sg13g2_decap_8
XFILLER_4_247 VDD VSS sg13g2_decap_8
XFILLER_20_63 VDD VSS sg13g2_decap_8
XFILLER_136_1104 VDD VSS sg13g2_decap_8
X_11162_ _11162_/Y _14953_/Q _10767_/A _11152_/B _11180_/C _10781_/X VDD VSS sg13g2_a221oi_1
XFILLER_136_63 VDD VSS sg13g2_decap_8
XFILLER_45_1009 VDD VSS sg13g2_decap_8
XFILLER_136_1148 VDD VSS sg13g2_fill_2
XFILLER_1_943 VDD VSS sg13g2_fill_1
X_10113_ _14691_/D _10146_/A1 _14691_/Q _10133_/S VDD VSS sg13g2_mux2_1
XFILLER_0_431 VDD VSS sg13g2_decap_8
XFILLER_150_977 VDD VSS sg13g2_fill_1
X_14268__2296 _14268_/RESET_B VDD VSS sg13g2_tiehi
XFILLER_0_442 VDD VSS sg13g2_fill_1
X_11093_ _11093_/Y _11094_/B _11118_/C VDD VSS sg13g2_nand2_1
XFILLER_95_519 VDD VSS sg13g2_decap_8
XFILLER_88_571 VDD VSS sg13g2_fill_1
XFILLER_121_167 VDD VSS sg13g2_fill_2
XFILLER_1_998 VDD VSS sg13g2_fill_1
X_10044_ _14625_/D _10077_/A0 _14625_/Q _10067_/S VDD VSS sg13g2_mux2_1
XFILLER_0_486 VDD VSS sg13g2_decap_4
X_14921_ _14921_/Q _15046_/CLK _14921_/D _14921_/RESET_B VDD VSS sg13g2_dfrbpq_1
XFILLER_103_893 VDD VSS sg13g2_decap_8
XFILLER_49_958 VDD VSS sg13g2_decap_8
X_15225__3378 _15225_/RESET_B VDD VSS sg13g2_tiehi
XFILLER_75_221 VDD VSS sg13g2_fill_1
XFILLER_75_243 VDD VSS sg13g2_decap_4
XFILLER_76_777 VDD VSS sg13g2_fill_2
X_14852_ _14852_/Q _14854_/CLK _14852_/D _14852_/RESET_B VDD VSS sg13g2_dfrbpq_1
XFILLER_152_84 VDD VSS sg13g2_decap_8
XFILLER_91_736 VDD VSS sg13g2_decap_4
XFILLER_1_1125 VDD VSS sg13g2_decap_8
XFILLER_57_991 VDD VSS sg13g2_decap_4
X_13803_ _13803_/Q _14731_/CLK _13803_/D _13803_/RESET_B VDD VSS sg13g2_dfrbpq_1
X_14783_ _14783_/Q clkload77/A _14783_/D _14783_/RESET_B VDD VSS sg13g2_dfrbpq_1
XFILLER_21_1075 VDD VSS sg13g2_decap_8
X_11995_ _11995_/X _13841_/Q _13873_/Q _13905_/Q _13937_/Q _11995_/S0 _11995_/S1 VDD
+ VSS sg13g2_mux4_1
X_14483__2081 _14483_/RESET_B VDD VSS sg13g2_tiehi
XFILLER_17_866 VDD VSS sg13g2_fill_2
X_13734_ _13734_/Q clkload7/A _13734_/D _13734_/RESET_B VDD VSS sg13g2_dfrbpq_1
XFILLER_16_354 VDD VSS sg13g2_fill_2
XFILLER_56_1116 VDD VSS sg13g2_decap_8
X_10946_ _10946_/Y _10946_/A _10946_/B VDD VSS sg13g2_nand2_1
X_13665_ _13665_/Q _15214_/CLK _13665_/D _13665_/RESET_B VDD VSS sg13g2_dfrbpq_1
X_10877_ _10878_/B _10897_/D _10897_/B wire584/X VDD VSS sg13g2_o21ai_1
XFILLER_31_346 VDD VSS sg13g2_decap_4
X_12616_ _12616_/X _14254_/Q _14286_/Q _14318_/Q _14350_/Q _12620_/S0 _12620_/S1 VDD
+ VSS sg13g2_mux4_1
XFILLER_84_7 VDD VSS sg13g2_decap_8
X_13596_ _13596_/Y _13600_/A _13600_/C VDD VSS sg13g2_nand2_1
X_12547_ _12547_/X _14569_/Q _14601_/Q _14633_/Q _14665_/Q _12548_/S0 _12550_/S1 VDD
+ VSS sg13g2_mux4_1
XFILLER_129_256 VDD VSS sg13g2_fill_2
XFILLER_61_92 VDD VSS sg13g2_decap_8
XFILLER_6_21 VDD VSS sg13g2_decap_8
X_12478_ _12478_/X _13732_/Q _14084_/Q _14436_/Q _14532_/Q _12752_/S0 _12757_/S1 VDD
+ VSS sg13g2_mux4_1
XANTENNA_3 _16862_/A VDD VSS sg13g2_antennanp
X_13718__2846 _13718_/RESET_B VDD VSS sg13g2_tiehi
X_14217_ _14217_/Q _14678_/CLK _14217_/D _14217_/RESET_B VDD VSS sg13g2_dfrbpq_1
X_11429_ _11430_/B _11385_/B _11385_/A _11383_/Y VDD VSS sg13g2_o21ai_1
X_15197_ _15197_/Q _15214_/CLK _15197_/D _15197_/RESET_B VDD VSS sg13g2_dfrbpq_1
XFILLER_6_98 VDD VSS sg13g2_decap_8
XFILLER_154_1204 VDD VSS sg13g2_decap_8
XFILLER_125_473 VDD VSS sg13g2_fill_1
XFILLER_126_996 VDD VSS sg13g2_decap_8
X_14148_ _14148_/Q clkload31/A _14148_/D _14148_/RESET_B VDD VSS sg13g2_dfrbpq_1
XFILLER_4_770 VDD VSS sg13g2_decap_8
XFILLER_141_955 VDD VSS sg13g2_decap_4
XFILLER_140_432 VDD VSS sg13g2_fill_1
XFILLER_141_966 VDD VSS sg13g2_decap_4
X_14079_ _14079_/Q clkload55/A _14079_/D _14079_/RESET_B VDD VSS sg13g2_dfrbpq_1
XFILLER_141_988 VDD VSS sg13g2_decap_8
XFILLER_98_368 VDD VSS sg13g2_decap_8
X_13933__2631 _13933_/RESET_B VDD VSS sg13g2_tiehi
X_14693__1871 _14693_/RESET_B VDD VSS sg13g2_tiehi
XFILLER_112_189 VDD VSS sg13g2_decap_8
XFILLER_6_1047 VDD VSS sg13g2_decap_8
Xfanout1070 _12776_/S _12790_/S VDD VSS sg13g2_buf_1
X_08640_ _08640_/X _08640_/A _08640_/B _08640_/C _08640_/D VDD VSS sg13g2_and4_1
XFILLER_39_457 VDD VSS sg13g2_fill_1
XFILLER_82_703 VDD VSS sg13g2_fill_1
XFILLER_67_799 VDD VSS sg13g2_fill_2
X_08571_ _08571_/Y _08574_/C _08574_/D VDD VSS sg13g2_nand2_1
XFILLER_82_758 VDD VSS sg13g2_decap_8
XFILLER_19_181 VDD VSS sg13g2_fill_1
X_14313__2251 _14313_/RESET_B VDD VSS sg13g2_tiehi
X_13966__2598 _13966_/RESET_B VDD VSS sg13g2_tiehi
XFILLER_23_803 VDD VSS sg13g2_decap_8
XFILLER_74_1216 VDD VSS sg13g2_decap_8
XFILLER_34_151 VDD VSS sg13g2_decap_4
XFILLER_62_493 VDD VSS sg13g2_fill_1
XFILLER_22_368 VDD VSS sg13g2_decap_4
XFILLER_50_688 VDD VSS sg13g2_fill_1
X_09123_ _09150_/C _14919_/Q _13168_/A _10760_/A VDD VSS sg13g2_and3_1
XFILLER_124_1052 VDD VSS sg13g2_decap_8
XFILLER_124_1063 VDD VSS sg13g2_fill_2
XFILLER_148_565 VDD VSS sg13g2_decap_8
XFILLER_148_576 VDD VSS sg13g2_fill_1
X_09054_ _10725_/B _09147_/B _15036_/Q _09053_/Y VDD VSS sg13g2_o21ai_1
X_08005_ _08005_/X _07825_/B _07798_/B _07949_/C _07801_/B _08005_/S0 _08044_/S1 VDD
+ VSS sg13g2_mux4_1
XFILLER_1_206 VDD VSS sg13g2_decap_4
XFILLER_104_635 VDD VSS sg13g2_decap_8
Xclkbuf_5_30__f_clk_i clkbuf_leaf_75_clk_i/A clkbuf_4_15_0_clk_i/X VDD VSS sg13g2_buf_16
XFILLER_131_432 VDD VSS sg13g2_fill_2
XFILLER_77_508 VDD VSS sg13g2_fill_1
XFILLER_89_368 VDD VSS sg13g2_fill_1
X_09956_ _14540_/D _14540_/Q _09956_/A1 _09969_/S VDD VSS sg13g2_mux2_1
XFILLER_83_1091 VDD VSS sg13g2_decap_8
X_08907_ _08907_/Y _08954_/S _14944_/Q VDD VSS sg13g2_nand2_1
XFILLER_58_733 VDD VSS sg13g2_decap_8
X_09887_ _14473_/D _09887_/A0 _14473_/Q _09901_/S VDD VSS sg13g2_mux2_1
XFILLER_112_690 VDD VSS sg13g2_fill_2
XFILLER_131_1023 VDD VSS sg13g2_decap_4
XFILLER_85_541 VDD VSS sg13g2_decap_8
XFILLER_18_608 VDD VSS sg13g2_fill_2
XFILLER_79_1105 VDD VSS sg13g2_fill_1
X_08838_ _08838_/Y _08966_/A _08959_/B VDD VSS sg13g2_nand2_1
XFILLER_58_799 VDD VSS sg13g2_decap_8
XFILLER_73_725 VDD VSS sg13g2_fill_1
XFILLER_122_21 VDD VSS sg13g2_decap_8
X_08769_ _08769_/Y _13675_/Q _08778_/B VDD VSS sg13g2_nor2_1
XFILLER_82_14 VDD VSS sg13g2_decap_4
XFILLER_122_65 VDD VSS sg13g2_decap_8
X_10800_ _10800_/Y _10800_/A _10800_/B VDD VSS sg13g2_nand2_1
XFILLER_54_972 VDD VSS sg13g2_fill_1
X_11780_ _11780_/Y _11910_/A wire210/X VDD VSS sg13g2_xnor2_1
XFILLER_53_471 VDD VSS sg13g2_decap_8
X_10731_ _14910_/D _10999_/B1 _10729_/Y _10730_/Y VDD VSS sg13g2_o21ai_1
XFILLER_15_63 VDD VSS sg13g2_decap_8
XFILLER_13_357 VDD VSS sg13g2_fill_1
XFILLER_16_1111 VDD VSS sg13g2_decap_8
X_13450_ _13455_/B _15172_/Q _15173_/Q VDD VSS sg13g2_nand2b_1
XFILLER_51_1002 VDD VSS sg13g2_fill_1
X_10662_ _10664_/C _14892_/Q _10666_/D _14893_/Q VDD VSS sg13g2_a21oi_1
X_12401_ _12401_/Y _15122_/Q _12348_/A _12416_/B1 _13690_/Q _13282_/A1 VDD VSS sg13g2_a221oi_1
XFILLER_142_1152 VDD VSS sg13g2_fill_2
XFILLER_40_187 VDD VSS sg13g2_fill_1
XFILLER_51_1046 VDD VSS sg13g2_fill_1
X_13381_ _13382_/B _13381_/A _13381_/B VDD VSS sg13g2_nor2_1
X_10593_ _10595_/C _14874_/Q _10597_/D _14875_/Q VDD VSS sg13g2_a21oi_1
XFILLER_16_1177 VDD VSS sg13g2_decap_8
X_15120_ _15120_/Q _15212_/CLK _15120_/D _15120_/RESET_B VDD VSS sg13g2_dfrbpq_1
XFILLER_142_1196 VDD VSS sg13g2_decap_8
X_12332_ _12332_/Y _12308_/Y _12310_/Y _11224_/A VDD VSS sg13g2_a21oi_1
XFILLER_154_524 VDD VSS sg13g2_decap_8
XFILLER_126_215 VDD VSS sg13g2_decap_8
XFILLER_110_0 VDD VSS sg13g2_decap_8
X_15051_ _15051_/Q clkload61/A _15051_/D _15051_/RESET_B VDD VSS sg13g2_dfrbpq_1
X_12263_ _12263_/Y _12261_/Y _12263_/B _12263_/C VDD VSS sg13g2_nand3b_1
XFILLER_142_719 VDD VSS sg13g2_fill_2
XFILLER_5_567 VDD VSS sg13g2_fill_1
XFILLER_123_900 VDD VSS sg13g2_decap_4
XFILLER_147_84 VDD VSS sg13g2_decap_8
XFILLER_108_985 VDD VSS sg13g2_decap_8
X_14002_ _14002_/Q _14738_/CLK _14002_/D _14002_/RESET_B VDD VSS sg13g2_dfrbpq_1
X_11214_ _11216_/A _11894_/B _11211_/X _11213_/X VDD VSS sg13g2_a21oi_1
X_14355__2209 _14355_/RESET_B VDD VSS sg13g2_tiehi
X_15182__3224 _15182_/RESET_B VDD VSS sg13g2_tiehi
XFILLER_122_410 VDD VSS sg13g2_decap_8
X_12194_ _12194_/X _14921_/Q _12267_/A2 _12193_/Y VDD VSS sg13g2_a21o_1
Xoutput40 mem_axi_araddr[11] _16864_/A VDD VSS sg13g2_buf_1
Xoutput51 mem_axi_araddr[22] _13713_/Q VDD VSS sg13g2_buf_1
Xoutput62 mem_axi_araddr[3] _16856_/A VDD VSS sg13g2_buf_1
XFILLER_96_806 VDD VSS sg13g2_decap_8
Xoutput73 mem_axi_awaddr[12] _16865_/X VDD VSS sg13g2_buf_1
X_11145_ _11150_/B _11172_/A _11164_/B VDD VSS sg13g2_xnor2_1
Xoutput84 mem_axi_awaddr[23] _16876_/X VDD VSS sg13g2_buf_1
XFILLER_0_250 VDD VSS sg13g2_fill_1
Xoutput95 mem_axi_awaddr[4] _16857_/X VDD VSS sg13g2_buf_1
XFILLER_62_1131 VDD VSS sg13g2_fill_2
XFILLER_114_1210 VDD VSS sg13g2_fill_2
XFILLER_49_733 VDD VSS sg13g2_fill_2
X_11076_ _11077_/B _11088_/A _11118_/A _11058_/Y VDD VSS sg13g2_a21oi_1
XFILLER_23_1126 VDD VSS sg13g2_decap_8
XFILLER_0_294 VDD VSS sg13g2_decap_4
XFILLER_3_1209 VDD VSS sg13g2_decap_8
X_14904_ _14904_/Q clkload39/A _14904_/D _14904_/RESET_B VDD VSS sg13g2_dfrbpq_1
XFILLER_62_1197 VDD VSS sg13g2_fill_2
XFILLER_76_552 VDD VSS sg13g2_decap_4
X_10027_ _14609_/D _10093_/A0 _14609_/Q wire601/X VDD VSS sg13g2_mux2_1
XFILLER_36_438 VDD VSS sg13g2_fill_1
XFILLER_5_1080 VDD VSS sg13g2_decap_8
X_14835_ _14835_/Q clkload80/A _14835_/D _14835_/RESET_B VDD VSS sg13g2_dfrbpq_1
XFILLER_56_81 VDD VSS sg13g2_fill_1
XFILLER_17_641 VDD VSS sg13g2_decap_8
XFILLER_56_92 VDD VSS sg13g2_decap_8
XFILLER_91_566 VDD VSS sg13g2_decap_8
X_14852__3225 _14852_/RESET_B VDD VSS sg13g2_tiehi
XFILLER_17_663 VDD VSS sg13g2_decap_8
X_14766_ _14766_/Q _15209_/CLK _14766_/D _14766_/RESET_B VDD VSS sg13g2_dfrbpq_1
X_11978_ _11978_/Y _11977_/X _12301_/B1 _11980_/A VDD VSS sg13g2_a21oi_1
X_13717_ _16879_/A clkload33/A _13717_/D _13717_/RESET_B VDD VSS sg13g2_dfrbpq_1
X_10929_ _10929_/Y _10929_/A _10929_/B VDD VSS sg13g2_nand2_1
X_14697_ _14697_/Q clkload1/A _14697_/D _14697_/RESET_B VDD VSS sg13g2_dfrbpq_1
XFILLER_31_143 VDD VSS sg13g2_decap_8
XFILLER_60_975 VDD VSS sg13g2_decap_8
XFILLER_20_817 VDD VSS sg13g2_fill_2
XFILLER_32_688 VDD VSS sg13g2_decap_8
X_13648_ _14760_/D _15188_/D _14760_/Q _13651_/S VDD VSS sg13g2_mux2_1
XFILLER_108_1069 VDD VSS sg13g2_decap_4
XFILLER_31_176 VDD VSS sg13g2_decap_8
X_14885__3159 _14885_/RESET_B VDD VSS sg13g2_tiehi
X_13579_ _15158_/D _13590_/B _13577_/Y _13578_/Y VDD VSS sg13g2_a21oi_1
XFILLER_121_1214 VDD VSS sg13g2_decap_8
X_14601__1963 _14601_/RESET_B VDD VSS sg13g2_tiehi
XFILLER_117_215 VDD VSS sg13g2_decap_4
X_15249_ _15249_/Q clkload37/A _15249_/D _15249_/RESET_B VDD VSS sg13g2_dfrbpq_1
XFILLER_67_1020 VDD VSS sg13g2_decap_8
XFILLER_114_922 VDD VSS sg13g2_decap_8
XFILLER_99_633 VDD VSS sg13g2_fill_1
XFILLER_153_590 VDD VSS sg13g2_decap_4
XFILLER_99_644 VDD VSS sg13g2_fill_1
X_09810_ _14398_/D _09909_/A1 _14398_/Q _09810_/S VDD VSS sg13g2_mux2_1
Xfanout307 _10062_/S _10069_/S VDD VSS sg13g2_buf_1
XFILLER_67_1086 VDD VSS sg13g2_fill_1
XFILLER_87_806 VDD VSS sg13g2_fill_2
XFILLER_98_132 VDD VSS sg13g2_decap_4
XFILLER_99_666 VDD VSS sg13g2_decap_8
XFILLER_114_966 VDD VSS sg13g2_decap_8
XFILLER_140_251 VDD VSS sg13g2_decap_4
XFILLER_28_1059 VDD VSS sg13g2_decap_8
XFILLER_101_616 VDD VSS sg13g2_decap_8
XFILLER_115_1018 VDD VSS sg13g2_fill_2
XFILLER_113_487 VDD VSS sg13g2_decap_4
X_09741_ _14331_/D _14331_/Q _09741_/A1 _09760_/S VDD VSS sg13g2_mux2_1
XFILLER_67_530 VDD VSS sg13g2_decap_4
XFILLER_28_917 VDD VSS sg13g2_decap_8
X_09672_ _14265_/D _09705_/A0 _14265_/Q wire641/X VDD VSS sg13g2_mux2_1
XFILLER_55_714 VDD VSS sg13g2_decap_8
X_08623_ _08623_/Y _07849_/X _08689_/B1 _08654_/B VDD VSS sg13g2_o21ai_1
XFILLER_54_213 VDD VSS sg13g2_decap_8
XFILLER_55_736 VDD VSS sg13g2_fill_1
XFILLER_82_522 VDD VSS sg13g2_decap_8
XFILLER_55_758 VDD VSS sg13g2_decap_8
XFILLER_55_769 VDD VSS sg13g2_fill_2
XFILLER_54_257 VDD VSS sg13g2_fill_1
XFILLER_54_268 VDD VSS sg13g2_fill_1
X_08554_ _08554_/Y _08548_/A _08550_/Y _08553_/A VDD VSS sg13g2_o21ai_1
XFILLER_39_1122 VDD VSS sg13g2_decap_4
XFILLER_42_419 VDD VSS sg13g2_decap_4
XFILLER_78_1171 VDD VSS sg13g2_decap_8
XFILLER_78_1182 VDD VSS sg13g2_decap_8
XFILLER_74_1035 VDD VSS sg13g2_decap_8
XFILLER_126_1103 VDD VSS sg13g2_fill_2
X_08485_ _08485_/Y _07822_/B _08001_/A _08542_/A2 VDD VSS sg13g2_o21ai_1
XFILLER_23_655 VDD VSS sg13g2_decap_8
XFILLER_39_1177 VDD VSS sg13g2_decap_8
XFILLER_52_28 VDD VSS sg13g2_fill_2
XFILLER_51_975 VDD VSS sg13g2_decap_4
XFILLER_149_841 VDD VSS sg13g2_decap_8
XFILLER_50_485 VDD VSS sg13g2_fill_2
X_15224__3377 _15224_/RESET_B VDD VSS sg13g2_tiehi
X_09106_ _13777_/D _13777_/Q _09730_/A0 _09106_/S VDD VSS sg13g2_mux2_1
X_09037_ _09037_/X _09044_/A _09034_/X _09036_/Y VDD VSS sg13g2_a21o_1
XFILLER_105_900 VDD VSS sg13g2_decap_8
XFILLER_11_1063 VDD VSS sg13g2_decap_8
XFILLER_105_911 VDD VSS sg13g2_fill_1
XFILLER_2_515 VDD VSS sg13g2_decap_8
XFILLER_102_1191 VDD VSS sg13g2_decap_8
XFILLER_117_21 VDD VSS sg13g2_decap_8
XFILLER_105_933 VDD VSS sg13g2_decap_4
XFILLER_104_421 VDD VSS sg13g2_decap_4
XFILLER_105_944 VDD VSS sg13g2_decap_8
XFILLER_105_955 VDD VSS sg13g2_fill_1
XFILLER_46_1126 VDD VSS sg13g2_fill_2
XFILLER_77_14 VDD VSS sg13g2_decap_8
XFILLER_120_914 VDD VSS sg13g2_fill_2
XFILLER_78_839 VDD VSS sg13g2_decap_4
Xfanout830 _11655_/B _11433_/B VDD VSS sg13g2_buf_1
Xfanout841 _10929_/B _13294_/B VDD VSS sg13g2_buf_1
Xfanout852 _10769_/A2 _08943_/A VDD VSS sg13g2_buf_1
XFILLER_131_284 VDD VSS sg13g2_decap_8
X_09939_ _14523_/D _14523_/Q _10071_/A0 _09970_/S VDD VSS sg13g2_mux2_1
Xfanout863 _08877_/A fanout866/X VDD VSS sg13g2_buf_1
Xfanout874 _10173_/B _13508_/C VDD VSS sg13g2_buf_1
Xfanout885 _08674_/B1 _07998_/X VDD VSS sg13g2_buf_1
XFILLER_58_552 VDD VSS sg13g2_decap_8
X_12950_ _12950_/Y _12947_/Y _12948_/Y _12949_/Y VDD VSS sg13g2_a21oi_1
Xfanout896 _08565_/A2 _08522_/C VDD VSS sg13g2_buf_1
XFILLER_133_53 VDD VSS sg13g2_decap_8
XFILLER_19_939 VDD VSS sg13g2_decap_8
XFILLER_45_202 VDD VSS sg13g2_decap_8
XFILLER_100_671 VDD VSS sg13g2_fill_2
X_11901_ _11902_/A _11898_/Y _11900_/Y _11224_/A VDD VSS sg13g2_a21oi_1
XFILLER_73_522 VDD VSS sg13g2_fill_2
XFILLER_100_682 VDD VSS sg13g2_decap_8
XFILLER_2_1220 VDD VSS sg13g2_decap_8
XFILLER_93_35 VDD VSS sg13g2_decap_4
XFILLER_46_758 VDD VSS sg13g2_fill_2
X_12881_ _12881_/Y _14772_/Q _12918_/A2 _12978_/B1 VDD VSS sg13g2_o21ai_1
XFILLER_22_1170 VDD VSS sg13g2_decap_8
X_14620_ _14620_/Q clkload75/A _14620_/D _14620_/RESET_B VDD VSS sg13g2_dfrbpq_1
X_11832_ _11832_/Y _11830_/Y _11832_/B _11832_/C VDD VSS sg13g2_nand3b_1
XFILLER_57_1233 VDD VSS sg13g2_decap_4
X_14551_ _14551_/Q clkload9/A _14551_/D _14551_/RESET_B VDD VSS sg13g2_dfrbpq_1
XFILLER_26_84 VDD VSS sg13g2_decap_8
XFILLER_54_791 VDD VSS sg13g2_decap_8
XFILLER_60_238 VDD VSS sg13g2_decap_4
X_11763_ _11763_/Y _11763_/A _11763_/B VDD VSS sg13g2_nand2_1
X_10714_ _10714_/Y _14906_/Q _10973_/B VDD VSS sg13g2_nand2_1
X_13502_ _13504_/A _13502_/A _13502_/B _15175_/D _13502_/D VDD VSS sg13g2_or4_1
XFILLER_13_154 VDD VSS sg13g2_decap_8
X_14482_ _14482_/Q clkload46/A _14482_/D _14482_/RESET_B VDD VSS sg13g2_dfrbpq_1
X_14409__2155 _14409_/RESET_B VDD VSS sg13g2_tiehi
X_11694_ _11694_/Y _11694_/A _11694_/B _12308_/C VDD VSS sg13g2_nand3_1
XFILLER_42_50 VDD VSS sg13g2_decap_4
X_13433_ _13433_/Y _13433_/A _13435_/B _13444_/C VDD VSS sg13g2_nor3_1
X_10645_ _14889_/D _14889_/Q _10643_/C _10644_/Y VDD VSS sg13g2_a21oi_1
XFILLER_10_850 VDD VSS sg13g2_decap_8
X_14992__2980 _14992_/RESET_B VDD VSS sg13g2_tiehi
X_13364_ _13435_/A _13381_/B _13364_/B VDD VSS sg13g2_nand2_1
Xmax_cap1147 _12464_/S0 _12546_/S0 VDD VSS sg13g2_buf_4
X_10576_ _10584_/C _14870_/Q _12895_/A _10576_/C _10576_/D VDD VSS sg13g2_and4_1
Xmax_cap1169 _12564_/S0 _12561_/S0 VDD VSS sg13g2_buf_4
XFILLER_154_343 VDD VSS sg13g2_decap_8
X_15103_ _15103_/Q clkload66/A _15103_/D _15103_/RESET_B VDD VSS sg13g2_dfrbpq_1
X_12315_ _12315_/Y _12311_/Y _12312_/Y _12314_/Y _12313_/Y _12317_/B VDD VSS sg13g2_a221oi_1
XFILLER_154_354 VDD VSS sg13g2_decap_8
X_13295_ _13295_/Y _07672_/X _08832_/D _13294_/Y VDD VSS sg13g2_a21oi_1
X_15034_ _15034_/Q clkload38/A _15034_/D _15034_/RESET_B VDD VSS sg13g2_dfrbpq_1
X_12246_ _12246_/X _12246_/A _12246_/B VDD VSS sg13g2_and2_1
XFILLER_47_7 VDD VSS sg13g2_decap_8
X_12177_ _12177_/Y _12252_/S0 _14486_/Q VDD VSS sg13g2_nand2b_1
XFILLER_150_571 VDD VSS sg13g2_decap_8
X_11128_ _11128_/Y _11128_/A _11128_/B VDD VSS sg13g2_nand2_1
XFILLER_111_947 VDD VSS sg13g2_decap_8
XFILLER_3_77 VDD VSS sg13g2_decap_8
XFILLER_7_1131 VDD VSS sg13g2_decap_8
XFILLER_110_446 VDD VSS sg13g2_decap_8
XFILLER_95_146 VDD VSS sg13g2_decap_8
XFILLER_110_457 VDD VSS sg13g2_fill_1
XFILLER_114_1040 VDD VSS sg13g2_decap_8
XFILLER_49_563 VDD VSS sg13g2_decap_8
X_11059_ _11118_/A _11202_/A _11078_/B VDD VSS sg13g2_xnor2_1
XFILLER_77_894 VDD VSS sg13g2_decap_4
XFILLER_37_736 VDD VSS sg13g2_decap_8
XFILLER_36_224 VDD VSS sg13g2_fill_2
XFILLER_36_246 VDD VSS sg13g2_decap_4
XFILLER_58_1008 VDD VSS sg13g2_decap_8
X_14619__1945 _14619_/RESET_B VDD VSS sg13g2_tiehi
XFILLER_91_352 VDD VSS sg13g2_fill_2
X_14818_ _14818_/Q clkload83/A _14818_/D _14818_/RESET_B VDD VSS sg13g2_dfrbpq_1
XFILLER_149_1147 VDD VSS sg13g2_fill_1
XFILLER_64_577 VDD VSS sg13g2_decap_8
XFILLER_92_897 VDD VSS sg13g2_fill_2
X_14801__3297 _14801_/RESET_B VDD VSS sg13g2_tiehi
XFILLER_51_227 VDD VSS sg13g2_decap_4
XFILLER_91_396 VDD VSS sg13g2_decap_8
XFILLER_33_942 VDD VSS sg13g2_decap_8
X_14749_ _14749_/Q clkload61/A _14749_/D _14749_/RESET_B VDD VSS sg13g2_dfrbpq_1
X_13883__2681 _13883_/RESET_B VDD VSS sg13g2_tiehi
X_08270_ _08270_/Y _08270_/A _08270_/B _08270_/C VDD VSS sg13g2_nand3_1
XFILLER_149_126 VDD VSS sg13g2_fill_1
XFILLER_34_1063 VDD VSS sg13g2_decap_8
XFILLER_121_1011 VDD VSS sg13g2_decap_8
XFILLER_73_0 VDD VSS sg13g2_decap_8
XFILLER_121_1022 VDD VSS sg13g2_fill_2
XFILLER_125_1191 VDD VSS sg13g2_fill_2
XFILLER_145_332 VDD VSS sg13g2_decap_8
XFILLER_121_1055 VDD VSS sg13g2_decap_8
XFILLER_145_343 VDD VSS sg13g2_fill_1
XFILLER_146_877 VDD VSS sg13g2_decap_8
Xmax_cap1681 _12206_/S0 _12107_/S0 VDD VSS sg13g2_buf_4
XFILLER_121_1099 VDD VSS sg13g2_decap_8
XFILLER_114_763 VDD VSS sg13g2_decap_8
XFILLER_102_936 VDD VSS sg13g2_decap_8
XFILLER_86_124 VDD VSS sg13g2_decap_8
Xfanout148 _10169_/A1 _10136_/A0 VDD VSS sg13g2_buf_1
Xfanout159 _09836_/A0 _09935_/A1 VDD VSS sg13g2_buf_1
X_07985_ wire145/A _07985_/A _07985_/B _07985_/C _07985_/D VDD VSS sg13g2_nand4_1
XFILLER_87_658 VDD VSS sg13g2_fill_1
XFILLER_80_1050 VDD VSS sg13g2_fill_2
XFILLER_47_28 VDD VSS sg13g2_decap_8
XFILLER_80_1061 VDD VSS sg13g2_decap_8
X_09724_ _14315_/D _10154_/A1 _14315_/Q _09738_/S VDD VSS sg13g2_mux2_1
XFILLER_83_820 VDD VSS sg13g2_fill_2
XFILLER_27_224 VDD VSS sg13g2_decap_8
X_09655_ _14248_/D _09655_/A0 _14248_/Q wire639/X VDD VSS sg13g2_mux2_1
XFILLER_16_909 VDD VSS sg13g2_fill_1
X_08606_ _08606_/Y _08282_/Y _08625_/A _08605_/X VDD VSS sg13g2_o21ai_1
XFILLER_103_67 VDD VSS sg13g2_decap_8
X_09586_ _14183_/D _14183_/Q _10017_/A0 wire329/X VDD VSS sg13g2_mux2_1
XFILLER_55_588 VDD VSS sg13g2_decap_8
XFILLER_83_897 VDD VSS sg13g2_fill_2
XFILLER_55_599 VDD VSS sg13g2_fill_2
XFILLER_24_931 VDD VSS sg13g2_decap_8
X_08537_ _08537_/X _08541_/B _07812_/B _11936_/A _07821_/B _08686_/S0 _08686_/S1 VDD
+ VSS sg13g2_mux4_1
XFILLER_151_7 VDD VSS sg13g2_decap_8
X_13713__2851 _13713_/RESET_B VDD VSS sg13g2_tiehi
X_08468_ _08469_/B _08617_/A _08301_/X _08110_/D VDD VSS sg13g2_o21ai_1
XFILLER_10_102 VDD VSS sg13g2_fill_1
XFILLER_52_1130 VDD VSS sg13g2_decap_8
XFILLER_137_800 VDD VSS sg13g2_fill_2
X_08399_ _08410_/C _08034_/A _08016_/Y _08518_/B1 VDD VSS sg13g2_o21ai_1
XFILLER_52_1163 VDD VSS sg13g2_fill_2
XFILLER_13_1125 VDD VSS sg13g2_decap_8
X_10430_ _14832_/D _10434_/C _10490_/A _10430_/C VDD VSS sg13g2_nor3_1
XFILLER_148_170 VDD VSS sg13g2_fill_2
X_14057__2507 _14057_/RESET_B VDD VSS sg13g2_tiehi
XFILLER_136_321 VDD VSS sg13g2_fill_1
XFILLER_12_42 VDD VSS sg13g2_decap_8
XFILLER_136_343 VDD VSS sg13g2_decap_8
X_10361_ _10361_/Y _14812_/Q _10359_/Y _10496_/B VDD VSS sg13g2_o21ai_1
XFILLER_136_354 VDD VSS sg13g2_fill_1
XFILLER_128_42 VDD VSS sg13g2_decap_8
XFILLER_3_813 VDD VSS sg13g2_decap_4
X_12100_ _12101_/A _13748_/Q _14100_/Q _14452_/Q _14548_/Q _12100_/S0 _12100_/S1 VDD
+ VSS sg13g2_mux4_1
X_13080_ _13080_/Y _13067_/C _13076_/Y _13079_/Y VDD VSS sg13g2_a21oi_1
X_10292_ _14791_/D _10468_/A _10292_/B _10292_/C VDD VSS sg13g2_nor3_1
XFILLER_151_335 VDD VSS sg13g2_decap_8
XFILLER_105_741 VDD VSS sg13g2_decap_8
X_12031_ _12031_/Y _12040_/A1 _14418_/Q _12026_/C VDD VSS sg13g2_a21oi_1
XFILLER_88_79 VDD VSS sg13g2_fill_2
XFILLER_137_1051 VDD VSS sg13g2_decap_4
XFILLER_132_571 VDD VSS sg13g2_decap_8
XFILLER_78_625 VDD VSS sg13g2_decap_4
XFILLER_137_1073 VDD VSS sg13g2_decap_8
Xfanout1614 _11493_/S1 _12171_/S1 VDD VSS sg13g2_buf_1
Xfanout1625 _12100_/S1 fanout1634/X VDD VSS sg13g2_buf_1
XFILLER_144_63 VDD VSS sg13g2_decap_8
XFILLER_78_658 VDD VSS sg13g2_decap_8
Xfanout1636 _12287_/S1 fanout1639/X VDD VSS sg13g2_buf_1
Xfanout1647 _11391_/B _11328_/S1 VDD VSS sg13g2_buf_1
XFILLER_77_146 VDD VSS sg13g2_decap_4
Xfanout660 _09527_/S fanout662/X VDD VSS sg13g2_buf_1
Xfanout1658 _12319_/B1 _13658_/Q VDD VSS sg13g2_buf_1
XFILLER_24_1232 VDD VSS sg13g2_decap_4
XFILLER_144_96 VDD VSS sg13g2_fill_2
Xfanout1669 _12168_/A _12162_/S0 VDD VSS sg13g2_buf_1
XFILLER_93_617 VDD VSS sg13g2_decap_4
Xfanout682 _09371_/S _09368_/S VDD VSS sg13g2_buf_1
Xfanout693 _09232_/S wire700/X VDD VSS sg13g2_buf_1
X_13982_ _13982_/Q clkload58/A _13982_/D _13982_/RESET_B VDD VSS sg13g2_dfrbpq_1
XFILLER_59_894 VDD VSS sg13g2_decap_8
XFILLER_20_1107 VDD VSS sg13g2_decap_8
XFILLER_92_127 VDD VSS sg13g2_decap_4
XFILLER_111_1235 VDD VSS sg13g2_fill_2
X_12933_ _12933_/Y _12933_/A _15062_/Q VDD VSS sg13g2_nand2_1
XFILLER_18_235 VDD VSS sg13g2_decap_8
XFILLER_73_330 VDD VSS sg13g2_decap_8
XFILLER_37_94 VDD VSS sg13g2_decap_8
XFILLER_74_886 VDD VSS sg13g2_decap_8
XFILLER_46_588 VDD VSS sg13g2_decap_8
X_12864_ _12864_/Y _14771_/Q _12918_/A2 _12978_/B1 VDD VSS sg13g2_o21ai_1
XFILLER_15_920 VDD VSS sg13g2_decap_8
XFILLER_2_1094 VDD VSS sg13g2_decap_8
X_14603_ _14603_/Q _14667_/CLK _14603_/D _14603_/RESET_B VDD VSS sg13g2_dfrbpq_1
X_11815_ _11815_/X _11815_/A _11822_/B VDD VSS sg13g2_and2_1
X_12795_ _12795_/Y _12997_/B _12899_/C _12997_/A VDD VSS sg13g2_o21ai_1
X_11746_ _11747_/B _11743_/Y _11745_/Y _12191_/B1 VDD VSS sg13g2_a21oi_1
X_14534_ _14534_/Q clkload7/A _14534_/D _14534_/RESET_B VDD VSS sg13g2_dfrbpq_1
XFILLER_144_1044 VDD VSS sg13g2_fill_1
XFILLER_18_1058 VDD VSS sg13g2_decap_8
XFILLER_105_1006 VDD VSS sg13g2_fill_1
XFILLER_144_1066 VDD VSS sg13g2_decap_8
XFILLER_30_956 VDD VSS sg13g2_decap_4
XFILLER_109_1197 VDD VSS sg13g2_fill_1
X_14465_ _14465_/Q _14465_/CLK _14465_/D _14465_/RESET_B VDD VSS sg13g2_dfrbpq_1
X_11677_ _11677_/Y _11673_/Y _11674_/Y _11676_/Y _11675_/Y _11696_/B VDD VSS sg13g2_a221oi_1
XFILLER_146_118 VDD VSS sg13g2_decap_8
XFILLER_128_822 VDD VSS sg13g2_decap_8
X_10628_ _10629_/D _14884_/Q _14883_/Q _14882_/Q _14881_/Q VDD VSS sg13g2_and4_1
X_13416_ _13416_/Y _13412_/B _13412_/C _15093_/Q VDD VSS sg13g2_o21ai_1
X_14396_ _14396_/Q clkload77/A _14396_/D _14396_/RESET_B VDD VSS sg13g2_dfrbpq_1
XFILLER_154_140 VDD VSS sg13g2_decap_8
X_13347_ _13351_/C _13347_/A _15174_/D _15175_/D VDD VSS sg13g2_nand3_1
X_10559_ _10561_/C _13273_/A _14861_/Q _14860_/Q _14855_/Q VDD VSS sg13g2_nand4_1
XFILLER_143_847 VDD VSS sg13g2_decap_8
X_13278_ _15052_/D _13271_/Y wire205/X _13266_/A VDD VSS sg13g2_a21oi_1
XFILLER_29_1132 VDD VSS sg13g2_fill_1
X_14819__3279 _14819_/RESET_B VDD VSS sg13g2_tiehi
XFILLER_9_1204 VDD VSS sg13g2_decap_8
X_15017_ _15017_/Q clkload30/A _15017_/D _15017_/RESET_B VDD VSS sg13g2_dfrbpq_1
X_12229_ _12231_/A _12229_/A _13664_/Q VDD VSS sg13g2_xor2_1
XFILLER_130_519 VDD VSS sg13g2_decap_8
XFILLER_29_1165 VDD VSS sg13g2_decap_8
XFILLER_151_1004 VDD VSS sg13g2_fill_1
XFILLER_97_945 VDD VSS sg13g2_fill_1
XFILLER_155_1184 VDD VSS sg13g2_decap_8
X_13755__2809 _13755_/RESET_B VDD VSS sg13g2_tiehi
XFILLER_25_1018 VDD VSS sg13g2_decap_8
XFILLER_64_1067 VDD VSS sg13g2_fill_2
XFILLER_69_647 VDD VSS sg13g2_fill_1
XFILLER_116_1157 VDD VSS sg13g2_decap_8
XFILLER_56_308 VDD VSS sg13g2_decap_8
X_07770_ _08315_/A _08258_/C _14998_/Q VDD VSS sg13g2_nor2_1
X_15223__3376 _15223_/RESET_B VDD VSS sg13g2_tiehi
X_09440_ _14042_/D _10102_/A0 _14042_/Q _09440_/S VDD VSS sg13g2_mux2_1
X_14135__2429 _14135_/RESET_B VDD VSS sg13g2_tiehi
XFILLER_18_780 VDD VSS sg13g2_decap_8
X_09371_ _13975_/D _09967_/A1 _13975_/Q _09371_/S VDD VSS sg13g2_mux2_1
XFILLER_17_290 VDD VSS sg13g2_fill_2
XFILLER_36_1103 VDD VSS sg13g2_fill_2
XFILLER_33_761 VDD VSS sg13g2_decap_8
X_08322_ _08322_/Y _08369_/B _08366_/D _08321_/Y VDD VSS sg13g2_o21ai_1
XFILLER_36_1147 VDD VSS sg13g2_decap_8
XFILLER_32_282 VDD VSS sg13g2_decap_8
XFILLER_21_956 VDD VSS sg13g2_decap_8
X_08253_ _08253_/X _08219_/A _07888_/B _08258_/C _08300_/A3 _08427_/S0 _13553_/A1
+ VDD VSS sg13g2_mux4_1
XFILLER_138_619 VDD VSS sg13g2_decap_8
X_14350__2214 _14350_/RESET_B VDD VSS sg13g2_tiehi
XFILLER_123_1139 VDD VSS sg13g2_fill_1
XFILLER_146_630 VDD VSS sg13g2_decap_8
X_08184_ _08184_/Y _08183_/A _07920_/Y _08183_/Y VDD VSS sg13g2_a21oi_1
XFILLER_145_162 VDD VSS sg13g2_fill_1
XFILLER_145_195 VDD VSS sg13g2_fill_2
XFILLER_82_1134 VDD VSS sg13g2_fill_2
XFILLER_102_700 VDD VSS sg13g2_fill_1
XFILLER_87_411 VDD VSS sg13g2_decap_8
XFILLER_0_838 VDD VSS sg13g2_fill_2
XFILLER_82_1156 VDD VSS sg13g2_decap_8
XFILLER_48_809 VDD VSS sg13g2_decap_4
XFILLER_87_455 VDD VSS sg13g2_fill_1
XFILLER_102_755 VDD VSS sg13g2_decap_8
XFILLER_47_308 VDD VSS sg13g2_decap_8
X_07968_ _07969_/D _08641_/A _07966_/Y _07967_/Y VDD VSS sg13g2_a21oi_1
XFILLER_28_500 VDD VSS sg13g2_fill_1
XFILLER_75_639 VDD VSS sg13g2_decap_8
XFILLER_74_127 VDD VSS sg13g2_fill_1
XFILLER_101_298 VDD VSS sg13g2_fill_1
XFILLER_28_533 VDD VSS sg13g2_decap_4
X_09707_ _09707_/X _09740_/B _09707_/B _09707_/C VDD VSS sg13g2_or3_1
XFILLER_74_26 VDD VSS sg13g2_decap_8
XFILLER_55_330 VDD VSS sg13g2_decap_8
X_07899_ _08073_/B _07903_/B _08063_/A VDD VSS sg13g2_nor2_1
XFILLER_16_706 VDD VSS sg13g2_fill_2
XFILLER_74_48 VDD VSS sg13g2_decap_8
XFILLER_28_566 VDD VSS sg13g2_decap_8
XFILLER_83_661 VDD VSS sg13g2_decap_8
XFILLER_71_812 VDD VSS sg13g2_fill_1
XFILLER_56_897 VDD VSS sg13g2_decap_8
X_09638_ _14234_/D _09970_/A1 _14234_/Q wire470/X VDD VSS sg13g2_mux2_1
XFILLER_15_216 VDD VSS sg13g2_decap_8
XFILLER_130_21 VDD VSS sg13g2_decap_8
XFILLER_15_227 VDD VSS sg13g2_fill_1
XFILLER_128_1017 VDD VSS sg13g2_decap_8
X_09569_ _14167_/D _10033_/A0 _14167_/Q _09569_/S VDD VSS sg13g2_mux2_1
XFILLER_130_65 VDD VSS sg13g2_decap_8
X_11600_ _11601_/A _13958_/Q _13990_/Q _14022_/Q _14054_/Q _11614_/S0 _11598_/C VDD
+ VSS sg13g2_mux4_1
XFILLER_24_772 VDD VSS sg13g2_decap_8
XFILLER_70_388 VDD VSS sg13g2_fill_1
X_12580_ _12580_/X _12572_/X _12576_/X _12571_/X _12575_/X wire1073/X wire1090/X VDD
+ VSS sg13g2_mux4_1
XFILLER_54_1236 VDD VSS sg13g2_fill_1
XFILLER_11_411 VDD VSS sg13g2_fill_1
XFILLER_70_399 VDD VSS sg13g2_fill_2
XFILLER_12_945 VDD VSS sg13g2_decap_4
XFILLER_11_422 VDD VSS sg13g2_decap_8
X_11531_ _11532_/B _11531_/A _14212_/Q VDD VSS sg13g2_nand2_1
Xwire302 wire302/X wire302/A VDD VSS sg13g2_buf_2
XFILLER_23_63 VDD VSS sg13g2_decap_8
XFILLER_12_989 VDD VSS sg13g2_decap_8
XFILLER_156_438 VDD VSS sg13g2_decap_4
X_14250_ _14250_/Q clkload25/A _14250_/D _14250_/RESET_B VDD VSS sg13g2_dfrbpq_1
X_11462_ _11463_/C _11454_/A _13688_/Q _11430_/B _11430_/A _11427_/X VDD VSS sg13g2_a221oi_1
XFILLER_139_63 VDD VSS sg13g2_decap_8
X_13979__2585 _13979_/RESET_B VDD VSS sg13g2_tiehi
XFILLER_7_448 VDD VSS sg13g2_decap_4
Xwire368 wire368/X wire368/A VDD VSS sg13g2_buf_1
X_13201_ _13202_/B _14919_/Q _13668_/Q _13189_/X VDD VSS sg13g2_a21oi_1
Xwire379 wire379/X wire380/X VDD VSS sg13g2_buf_2
X_10413_ _10422_/D _14827_/Q _10413_/B _10414_/D VDD VSS sg13g2_and3_1
X_14181_ _14181_/Q _14405_/CLK _14181_/D _14181_/RESET_B VDD VSS sg13g2_dfrbpq_1
X_11393_ _11393_/X _11388_/Y _11389_/Y _11395_/B VDD VSS sg13g2_a21o_1
XFILLER_87_1034 VDD VSS sg13g2_decap_4
X_13132_ _13146_/B _13132_/A _13133_/C VDD VSS sg13g2_nand2_1
X_10344_ _10347_/C _14808_/Q _10343_/B VDD VSS sg13g2_nor2b_1
XFILLER_139_1146 VDD VSS sg13g2_decap_8
XFILLER_139_1157 VDD VSS sg13g2_fill_1
XFILLER_124_357 VDD VSS sg13g2_decap_8
XFILLER_3_0 VDD VSS sg13g2_decap_8
XFILLER_151_154 VDD VSS sg13g2_fill_2
X_13063_ _13078_/A wire234/X _13063_/B VDD VSS sg13g2_nand2b_1
XFILLER_152_688 VDD VSS sg13g2_fill_2
X_10275_ _14786_/D _14786_/Q _10305_/A _10274_/Y VDD VSS sg13g2_a21oi_1
XFILLER_124_379 VDD VSS sg13g2_decap_8
XFILLER_79_934 VDD VSS sg13g2_fill_1
XFILLER_105_571 VDD VSS sg13g2_fill_2
XFILLER_155_84 VDD VSS sg13g2_decap_8
Xfanout1400 wire1401/A _14989_/Q VDD VSS sg13g2_buf_1
X_12014_ _12014_/X _13842_/Q _13874_/Q _12017_/A VDD VSS sg13g2_mux2_1
X_15101__3152 _15101_/RESET_B VDD VSS sg13g2_tiehi
XFILLER_151_198 VDD VSS sg13g2_decap_4
Xfanout1411 _07972_/B _08686_/A3 VDD VSS sg13g2_buf_1
Xfanout1422 _12084_/A _14982_/Q VDD VSS sg13g2_buf_1
Xfanout1433 _07818_/B _11936_/A VDD VSS sg13g2_buf_1
Xfanout1444 _07804_/B _11843_/A VDD VSS sg13g2_buf_1
Xfanout1455 _07790_/A _08427_/A1 VDD VSS sg13g2_buf_1
XFILLER_66_617 VDD VSS sg13g2_decap_8
Xfanout1466 _11591_/A _14968_/Q VDD VSS sg13g2_buf_1
Xfanout1477 _08278_/A3 _11483_/A VDD VSS sg13g2_buf_1
Xfanout490 _09311_/S _09307_/X VDD VSS sg13g2_buf_1
XFILLER_19_511 VDD VSS sg13g2_decap_4
Xfanout1488 _08142_/C _11384_/A VDD VSS sg13g2_buf_1
Xfanout1499 _12844_/B _12911_/B VDD VSS sg13g2_buf_1
X_13965_ _13965_/Q clkload45/A _13965_/D _13965_/RESET_B VDD VSS sg13g2_dfrbpq_1
XFILLER_81_609 VDD VSS sg13g2_fill_1
XFILLER_4_1167 VDD VSS sg13g2_decap_8
XFILLER_47_864 VDD VSS sg13g2_decap_8
X_12916_ _12916_/Y _14838_/Q _12930_/B1 _12963_/B _14870_/Q VDD VSS sg13g2_a22oi_1
XFILLER_73_160 VDD VSS sg13g2_decap_8
XFILLER_74_683 VDD VSS sg13g2_fill_2
X_13896_ _13896_/Q _15148_/CLK _13896_/D _13896_/RESET_B VDD VSS sg13g2_dfrbpq_1
X_12847_ _12847_/X _14897_/Q _13690_/Q VDD VSS sg13g2_and2_1
XFILLER_9_21 VDD VSS sg13g2_decap_8
XFILLER_61_388 VDD VSS sg13g2_decap_8
X_12778_ _15019_/D _12778_/A wire367/X VDD VSS sg13g2_nor2_1
X_14517_ _14517_/Q _14706_/CLK _14517_/D _14517_/RESET_B VDD VSS sg13g2_dfrbpq_1
X_11729_ _11729_/Y _07682_/A _11236_/B _11728_/Y VDD VSS sg13g2_o21ai_1
XFILLER_9_98 VDD VSS sg13g2_decap_8
XFILLER_35_1180 VDD VSS sg13g2_decap_8
X_14448_ _14448_/Q clkload50/A _14448_/D _14448_/RESET_B VDD VSS sg13g2_dfrbpq_1
X_13809__2755 _13809_/RESET_B VDD VSS sg13g2_tiehi
X_14569__1995 _14569_/RESET_B VDD VSS sg13g2_tiehi
XFILLER_31_1055 VDD VSS sg13g2_fill_2
XFILLER_155_460 VDD VSS sg13g2_decap_8
X_14379_ _14379_/Q _14731_/CLK _14379_/D _14379_/RESET_B VDD VSS sg13g2_dfrbpq_1
X_14950__3029 _14950_/RESET_B VDD VSS sg13g2_tiehi
XFILLER_6_481 VDD VSS sg13g2_decap_8
XFILLER_116_858 VDD VSS sg13g2_fill_2
Xmax_cap657 _09533_/S _09523_/S VDD VSS sg13g2_buf_4
XFILLER_116_869 VDD VSS sg13g2_fill_2
X_08940_ _08940_/X _08939_/X _12203_/A _08940_/S VDD VSS sg13g2_mux2_1
XFILLER_36_0 VDD VSS sg13g2_decap_8
X_14965__3007 _14965_/RESET_B VDD VSS sg13g2_tiehi
XFILLER_130_338 VDD VSS sg13g2_decap_8
X_08871_ _08871_/X _08870_/X _11570_/A _08871_/S VDD VSS sg13g2_mux2_1
XFILLER_69_455 VDD VSS sg13g2_fill_2
XFILLER_111_552 VDD VSS sg13g2_decap_4
XFILLER_9_1078 VDD VSS sg13g2_decap_8
X_07822_ _08527_/B _07822_/A _07822_/B VDD VSS sg13g2_nor2_1
XFILLER_96_263 VDD VSS sg13g2_fill_1
XFILLER_84_436 VDD VSS sg13g2_decap_4
X_07753_ _15206_/D _08724_/B _07753_/B _07754_/B _10935_/A VDD VSS sg13g2_and4_1
XFILLER_49_190 VDD VSS sg13g2_decap_8
XFILLER_42_1184 VDD VSS sg13g2_decap_8
XFILLER_84_469 VDD VSS sg13g2_decap_8
X_14404__2160 _14404_/RESET_B VDD VSS sg13g2_tiehi
XFILLER_42_1195 VDD VSS sg13g2_fill_1
XFILLER_38_897 VDD VSS sg13g2_decap_8
X_07684_ _07684_/Y _11241_/A _07684_/B _08832_/D VDD VSS sg13g2_nand3_1
XFILLER_92_480 VDD VSS sg13g2_fill_2
X_09423_ _14025_/D _09621_/A0 _14025_/Q _09437_/S VDD VSS sg13g2_mux2_1
XFILLER_53_867 VDD VSS sg13g2_decap_8
X_09354_ _13958_/D _09653_/A0 _13958_/Q _09371_/S VDD VSS sg13g2_mux2_1
XFILLER_80_686 VDD VSS sg13g2_decap_8
XFILLER_12_219 VDD VSS sg13g2_decap_8
XFILLER_33_591 VDD VSS sg13g2_decap_4
X_08305_ _08305_/Y _08565_/A2 _08304_/Y _08674_/B1 VDD VSS sg13g2_a21oi_1
XFILLER_100_46 VDD VSS sg13g2_fill_2
X_09285_ _13893_/D _13893_/Q _10148_/A1 _09303_/S VDD VSS sg13g2_mux2_1
XFILLER_60_28 VDD VSS sg13g2_decap_8
XFILLER_127_1094 VDD VSS sg13g2_decap_8
X_08236_ _08236_/X _08151_/X _08235_/X _08328_/S VDD VSS sg13g2_mux2_1
XFILLER_101_1212 VDD VSS sg13g2_decap_8
X_08167_ _08167_/X _08167_/A _08167_/B VDD VSS sg13g2_or2_1
XFILLER_114_7 VDD VSS sg13g2_decap_8
XFILLER_119_696 VDD VSS sg13g2_decap_4
X_08098_ _08098_/Y _08140_/B _08098_/B VDD VSS sg13g2_nand2_1
XFILLER_134_655 VDD VSS sg13g2_decap_8
XFILLER_109_88 VDD VSS sg13g2_decap_8
XFILLER_0_613 VDD VSS sg13g2_fill_2
XFILLER_115_891 VDD VSS sg13g2_decap_4
XFILLER_47_1062 VDD VSS sg13g2_decap_8
Xhold3530 hold3530/X _14934_/Q VDD VSS sg13g2_dlygate4sd3_1
XFILLER_125_21 VDD VSS sg13g2_decap_8
X_14614__1950 _14614_/RESET_B VDD VSS sg13g2_tiehi
X_10060_ _14641_/D _10093_/A0 _14641_/Q _10060_/S VDD VSS sg13g2_mux2_1
XFILLER_0_646 VDD VSS sg13g2_decap_4
XFILLER_76_904 VDD VSS sg13g2_fill_1
XFILLER_102_541 VDD VSS sg13g2_decap_8
XFILLER_76_926 VDD VSS sg13g2_decap_4
XFILLER_85_14 VDD VSS sg13g2_decap_8
XFILLER_76_948 VDD VSS sg13g2_decap_8
XFILLER_91_907 VDD VSS sg13g2_decap_8
XFILLER_18_63 VDD VSS sg13g2_decap_8
XFILLER_141_42 VDD VSS sg13g2_decap_8
X_13750_ _13750_/Q clkload9/A _13750_/D _13750_/RESET_B VDD VSS sg13g2_dfrbpq_1
XFILLER_62_119 VDD VSS sg13g2_decap_8
X_10962_ _11004_/B _14759_/Q _10967_/B VDD VSS sg13g2_xor2_1
XFILLER_43_300 VDD VSS sg13g2_decap_4
XFILLER_55_160 VDD VSS sg13g2_decap_8
XFILLER_55_171 VDD VSS sg13g2_fill_1
XFILLER_16_536 VDD VSS sg13g2_decap_8
XFILLER_71_631 VDD VSS sg13g2_fill_2
X_12701_ _12701_/X _13844_/Q _13876_/Q _13908_/Q _13940_/Q _12758_/S0 _12758_/S1 VDD
+ VSS sg13g2_mux4_1
X_10893_ _10893_/X _10893_/A _10893_/B VDD VSS sg13g2_and2_1
X_13681_ _13681_/Q _15214_/CLK _13681_/D _13681_/RESET_B VDD VSS sg13g2_dfrbpq_1
X_12632_ _12632_/X _13839_/Q _13871_/Q _13903_/Q _13935_/Q _12686_/S0 _12686_/S1 VDD
+ VSS sg13g2_mux4_1
XFILLER_19_1142 VDD VSS sg13g2_decap_8
XFILLER_70_174 VDD VSS sg13g2_fill_1
XFILLER_34_62 VDD VSS sg13g2_decap_8
XFILLER_54_1033 VDD VSS sg13g2_fill_2
XFILLER_93_1082 VDD VSS sg13g2_decap_8
XFILLER_140_0 VDD VSS sg13g2_decap_8
X_12563_ _12563_/X _14122_/Q _14154_/Q _14186_/Q _14218_/Q _12754_/S0 _12754_/S1 VDD
+ VSS sg13g2_mux4_1
XFILLER_8_702 VDD VSS sg13g2_decap_8
XFILLER_156_202 VDD VSS sg13g2_fill_1
X_15137__3068 _15137_/RESET_B VDD VSS sg13g2_tiehi
X_11514_ _11514_/X _13955_/Q _13987_/Q _14019_/Q _14051_/Q _11514_/S0 _11715_/S1 VDD
+ VSS sg13g2_mux4_1
X_14302_ _14302_/Q clkload57/A _14302_/D _14302_/RESET_B VDD VSS sg13g2_dfrbpq_1
XFILLER_106_1167 VDD VSS sg13g2_decap_4
X_12494_ _12494_/X _13957_/Q _13989_/Q _14021_/Q _14053_/Q _12494_/S0 _12494_/S1 VDD
+ VSS sg13g2_mux4_1
XFILLER_102_1009 VDD VSS sg13g2_fill_2
XFILLER_156_246 VDD VSS sg13g2_decap_4
Xwire143 wire143/X wire143/A VDD VSS sg13g2_buf_2
X_11445_ _11448_/C _11445_/A _11446_/A _11445_/C VDD VSS sg13g2_nand3_1
X_14233_ _14233_/Q clkload43/A _14233_/D _14233_/RESET_B VDD VSS sg13g2_dfrbpq_1
X_15222__3375 _15222_/RESET_B VDD VSS sg13g2_tiehi
XFILLER_138_994 VDD VSS sg13g2_decap_8
XFILLER_7_289 VDD VSS sg13g2_decap_8
Xwire198 wire198/X wire198/A VDD VSS sg13g2_buf_2
X_14446__2118 _14446_/RESET_B VDD VSS sg13g2_tiehi
X_14164_ _14164_/Q clkload33/A _14164_/D _14164_/RESET_B VDD VSS sg13g2_dfrbpq_1
X_11376_ _11376_/X _13950_/Q _13982_/Q _14014_/Q _14046_/Q _11365_/A _12307_/C VDD
+ VSS sg13g2_mux4_1
XFILLER_153_975 VDD VSS sg13g2_decap_8
X_13115_ _13116_/C _14913_/Q _13674_/Q _13088_/X VDD VSS sg13g2_o21ai_1
X_10327_ _10336_/D _14798_/Q _10327_/B _10327_/C _10345_/C VDD VSS sg13g2_and4_1
X_14095_ _14095_/Q clkload11/A _14095_/D _14095_/RESET_B VDD VSS sg13g2_dfrbpq_1
XFILLER_98_539 VDD VSS sg13g2_decap_8
XFILLER_106_880 VDD VSS sg13g2_decap_4
X_13046_ _13046_/Y _13050_/C _15061_/Q VDD VSS sg13g2_nor2b_1
XFILLER_117_1230 VDD VSS sg13g2_decap_8
X_10258_ _10262_/B _14779_/Q _14780_/Q _14781_/Q _10258_/D VDD VSS sg13g2_nand4_1
XFILLER_61_1015 VDD VSS sg13g2_fill_1
XFILLER_26_1135 VDD VSS sg13g2_decap_8
Xfanout1230 _12962_/C _15207_/Q VDD VSS sg13g2_buf_1
XFILLER_152_1154 VDD VSS sg13g2_decap_8
XFILLER_6_1229 VDD VSS sg13g2_decap_8
Xfanout1241 _12997_/B _13601_/B VDD VSS sg13g2_buf_1
XFILLER_39_628 VDD VSS sg13g2_decap_4
XFILLER_121_883 VDD VSS sg13g2_decap_8
XFILLER_61_1059 VDD VSS sg13g2_fill_1
X_10189_ _15195_/D input22/X _15195_/Q _13340_/S VDD VSS sg13g2_mux2_1
Xfanout1252 _13401_/B _10201_/A1 VDD VSS sg13g2_buf_1
XFILLER_93_211 VDD VSS sg13g2_decap_4
Xfanout1263 _12862_/B _15108_/Q VDD VSS sg13g2_buf_1
XFILLER_38_127 VDD VSS sg13g2_decap_8
Xfanout1274 _13162_/A2 _13273_/B VDD VSS sg13g2_buf_1
Xfanout1285 _08229_/B _13427_/C VDD VSS sg13g2_buf_1
XFILLER_113_1149 VDD VSS sg13g2_fill_2
Xfanout1296 _13345_/B fanout1298/X VDD VSS sg13g2_buf_1
XFILLER_82_918 VDD VSS sg13g2_decap_8
X_14997_ _14997_/Q _15001_/CLK _14997_/D _14997_/RESET_B VDD VSS sg13g2_dfrbpq_1
XFILLER_47_661 VDD VSS sg13g2_decap_8
X_13948_ _13948_/Q clkload60/A _13948_/D _13948_/RESET_B VDD VSS sg13g2_dfrbpq_1
XFILLER_81_439 VDD VSS sg13g2_decap_8
X_15183__3204 _15183_/RESET_B VDD VSS sg13g2_tiehi
XFILLER_35_845 VDD VSS sg13g2_decap_8
XFILLER_46_182 VDD VSS sg13g2_decap_8
XFILLER_62_653 VDD VSS sg13g2_decap_8
X_14052__2512 _14052_/RESET_B VDD VSS sg13g2_tiehi
X_13879_ _13879_/Q clkload4/A _13879_/D _13879_/RESET_B VDD VSS sg13g2_dfrbpq_1
XFILLER_72_1100 VDD VSS sg13g2_decap_8
XFILLER_62_697 VDD VSS sg13g2_decap_4
XFILLER_148_703 VDD VSS sg13g2_decap_8
X_14656__1908 _14656_/RESET_B VDD VSS sg13g2_tiehi
XFILLER_124_1234 VDD VSS sg13g2_fill_2
X_09070_ wire246/A _09162_/A _09066_/Y _09069_/X VDD VSS sg13g2_o21ai_1
XFILLER_147_246 VDD VSS sg13g2_decap_4
XFILLER_120_1109 VDD VSS sg13g2_decap_8
XFILLER_135_408 VDD VSS sg13g2_fill_1
X_08021_ _08021_/Y _08021_/A _08140_/B VDD VSS sg13g2_nand2_1
XFILLER_135_419 VDD VSS sg13g2_decap_8
X_14085__2479 _14085_/RESET_B VDD VSS sg13g2_tiehi
XFILLER_116_600 VDD VSS sg13g2_decap_4
Xmax_cap410 _09967_/S _09951_/S VDD VSS sg13g2_buf_4
XFILLER_156_791 VDD VSS sg13g2_fill_1
XFILLER_115_143 VDD VSS sg13g2_decap_8
Xmax_cap476 _09500_/S _09490_/S VDD VSS sg13g2_buf_4
XFILLER_89_528 VDD VSS sg13g2_decap_8
X_09972_ _14555_/D _10071_/A0 _14555_/Q _09991_/S VDD VSS sg13g2_mux2_1
Xmax_cap487 _09337_/S fanout486/X VDD VSS sg13g2_buf_4
X_15024__2948 _15024_/RESET_B VDD VSS sg13g2_tiehi
Xmax_cap498 _09306_/S _09279_/S VDD VSS sg13g2_buf_4
XFILLER_131_647 VDD VSS sg13g2_decap_8
X_08923_ _13713_/D _16875_/A _08922_/X _08956_/S VDD VSS sg13g2_mux2_1
XFILLER_130_135 VDD VSS sg13g2_decap_4
XFILLER_131_658 VDD VSS sg13g2_fill_2
XFILLER_44_1235 VDD VSS sg13g2_fill_2
X_14894__3141 _14894_/RESET_B VDD VSS sg13g2_tiehi
XFILLER_112_883 VDD VSS sg13g2_decap_4
XFILLER_57_414 VDD VSS sg13g2_fill_2
X_08854_ _08854_/X _08853_/X _11454_/A _08882_/S VDD VSS sg13g2_mux2_1
XFILLER_112_894 VDD VSS sg13g2_decap_8
XFILLER_57_447 VDD VSS sg13g2_decap_8
XFILLER_84_222 VDD VSS sg13g2_decap_4
X_07805_ _08476_/A _07804_/B _08456_/C VDD VSS sg13g2_nand2b_1
X_08785_ _08785_/Y _13345_/B _14758_/Q _10201_/A1 _07719_/X VDD VSS sg13g2_a22oi_1
XFILLER_55_28 VDD VSS sg13g2_decap_4
X_07736_ _13284_/B _07744_/B _15124_/Q VDD VSS sg13g2_nand2_1
XFILLER_26_823 VDD VSS sg13g2_fill_1
XFILLER_66_992 VDD VSS sg13g2_decap_8
X_07667_ _07667_/Y _13613_/A _15055_/Q _13283_/A VDD VSS sg13g2_nor3_1
XFILLER_40_303 VDD VSS sg13g2_decap_8
X_09406_ _14009_/D _10068_/A0 _14009_/Q _09406_/S VDD VSS sg13g2_mux2_1
XFILLER_13_528 VDD VSS sg13g2_decap_8
XFILLER_53_697 VDD VSS sg13g2_decap_8
XFILLER_77_1099 VDD VSS sg13g2_decap_8
XFILLER_52_196 VDD VSS sg13g2_fill_1
XFILLER_71_49 VDD VSS sg13g2_decap_4
XFILLER_40_347 VDD VSS sg13g2_decap_8
X_09337_ _13944_/D _10100_/A0 _13944_/Q _09337_/S VDD VSS sg13g2_mux2_1
XFILLER_51_1206 VDD VSS sg13g2_fill_2
XFILLER_40_369 VDD VSS sg13g2_fill_1
XFILLER_138_213 VDD VSS sg13g2_fill_1
XFILLER_139_747 VDD VSS sg13g2_decap_4
X_09268_ _13877_/D _13877_/Q _10131_/A0 _09272_/S VDD VSS sg13g2_mux2_1
X_14814__3284 _14814_/RESET_B VDD VSS sg13g2_tiehi
XFILLER_14_1050 VDD VSS sg13g2_decap_8
X_08219_ _08247_/B _08219_/A _13545_/A VDD VSS sg13g2_and2_1
X_13750__2814 _13750_/RESET_B VDD VSS sg13g2_tiehi
X_09199_ _13815_/D _13815_/Q _10033_/A0 _09199_/S VDD VSS sg13g2_mux2_1
XFILLER_153_238 VDD VSS sg13g2_decap_8
X_11230_ _11230_/X _11228_/X _11229_/X _11230_/S VDD VSS sg13g2_mux2_1
XFILLER_135_953 VDD VSS sg13g2_decap_8
XFILLER_20_42 VDD VSS sg13g2_decap_8
XFILLER_107_666 VDD VSS sg13g2_decap_8
XFILLER_136_42 VDD VSS sg13g2_decap_8
XFILLER_135_997 VDD VSS sg13g2_decap_4
X_11161_ _11161_/X _11161_/A _11179_/B VDD VSS sg13g2_and2_1
XFILLER_134_485 VDD VSS sg13g2_decap_8
XFILLER_122_636 VDD VSS sg13g2_decap_8
XFILLER_0_410 VDD VSS sg13g2_fill_1
X_10112_ _14690_/D _10145_/A1 _14690_/Q _10133_/S VDD VSS sg13g2_mux2_1
XFILLER_150_967 VDD VSS sg13g2_fill_2
X_11092_ _11095_/A _11092_/A _11118_/C VDD VSS sg13g2_nor2b_1
X_14130__2434 _14130_/RESET_B VDD VSS sg13g2_tiehi
XFILLER_0_454 VDD VSS sg13g2_decap_4
XFILLER_103_861 VDD VSS sg13g2_fill_1
XFILLER_96_68 VDD VSS sg13g2_decap_8
XFILLER_103_872 VDD VSS sg13g2_decap_4
X_10043_ _14624_/D _10076_/A0 _14624_/Q _10066_/S VDD VSS sg13g2_mux2_1
X_14920_ _14920_/Q clkload35/A _14920_/D _14920_/RESET_B VDD VSS sg13g2_dfrbpq_1
XFILLER_76_712 VDD VSS sg13g2_decap_4
XFILLER_96_79 VDD VSS sg13g2_fill_2
XFILLER_88_583 VDD VSS sg13g2_fill_1
XFILLER_48_425 VDD VSS sg13g2_fill_2
XFILLER_76_745 VDD VSS sg13g2_decap_4
XFILLER_76_756 VDD VSS sg13g2_decap_8
X_14851_ _14851_/Q _14854_/CLK _14851_/D _14851_/RESET_B VDD VSS sg13g2_dfrbpq_1
XFILLER_152_63 VDD VSS sg13g2_decap_8
XFILLER_1_1104 VDD VSS sg13g2_decap_8
XFILLER_57_970 VDD VSS sg13g2_decap_8
X_13802_ _13802_/Q clkload21/A _13802_/D _13802_/RESET_B VDD VSS sg13g2_dfrbpq_1
XFILLER_57_981 VDD VSS sg13g2_fill_2
XFILLER_21_1054 VDD VSS sg13g2_decap_8
XFILLER_75_288 VDD VSS sg13g2_fill_1
X_14782_ _14782_/Q clkload77/A _14782_/D _14782_/RESET_B VDD VSS sg13g2_dfrbpq_1
XFILLER_112_1171 VDD VSS sg13g2_fill_1
XFILLER_91_759 VDD VSS sg13g2_fill_2
XFILLER_95_1122 VDD VSS sg13g2_decap_4
X_11994_ _11994_/X _14705_/Q _14737_/Q _13777_/Q _13809_/Q _11995_/S0 _11995_/S1 VDD
+ VSS sg13g2_mux4_1
XFILLER_72_940 VDD VSS sg13g2_fill_1
XFILLER_95_1133 VDD VSS sg13g2_fill_1
XFILLER_72_951 VDD VSS sg13g2_decap_8
X_13733_ _13733_/Q clkload0/A _13733_/D _13733_/RESET_B VDD VSS sg13g2_dfrbpq_1
XFILLER_147_1223 VDD VSS sg13g2_decap_8
X_10945_ _10945_/Y _10945_/A _10945_/B VDD VSS sg13g2_nor2_1
XFILLER_44_675 VDD VSS sg13g2_decap_4
XFILLER_71_461 VDD VSS sg13g2_fill_1
XFILLER_95_1177 VDD VSS sg13g2_fill_1
XFILLER_45_94 VDD VSS sg13g2_fill_2
XFILLER_32_837 VDD VSS sg13g2_fill_1
X_13664_ _13664_/Q clkload63/A _13664_/D _13664_/RESET_B VDD VSS sg13g2_dfrbpq_1
X_10876_ _10923_/D _10876_/A _10897_/B wire584/X _10876_/D VDD VSS sg13g2_or4_1
X_13675__2907 _13675_/RESET_B VDD VSS sg13g2_tiehi
X_12615_ _12615_/X _14382_/Q _14414_/Q _14478_/Q _14510_/Q _12615_/S0 _12785_/S1 VDD
+ VSS sg13g2_mux4_1
X_13595_ _13595_/Y _13600_/A _10173_/B _15164_/Q VDD VSS sg13g2_a21oi_1
X_12546_ _12546_/X _14249_/Q _14281_/Q _14313_/Q _14345_/Q _12546_/S0 _12546_/S1 VDD
+ VSS sg13g2_mux4_1
XFILLER_8_532 VDD VSS sg13g2_decap_4
XFILLER_61_71 VDD VSS sg13g2_decap_8
XFILLER_77_7 VDD VSS sg13g2_decap_8
XFILLER_32_1161 VDD VSS sg13g2_decap_4
X_12477_ _12477_/X _14564_/Q _14596_/Q _14628_/Q _14660_/Q _12752_/S0 _12757_/S1 VDD
+ VSS sg13g2_mux4_1
XFILLER_32_1183 VDD VSS sg13g2_decap_8
XANTENNA_4 _16862_/A VDD VSS sg13g2_antennanp
X_14216_ _14216_/Q clkload36/A _14216_/D _14216_/RESET_B VDD VSS sg13g2_dfrbpq_1
X_11428_ _11430_/A _11428_/A _13689_/Q VDD VSS sg13g2_xor2_1
X_15196_ _15196_/Q _15200_/CLK _15196_/D _15196_/RESET_B VDD VSS sg13g2_dfrbpq_1
XFILLER_6_77 VDD VSS sg13g2_decap_8
XFILLER_125_452 VDD VSS sg13g2_fill_1
XFILLER_125_463 VDD VSS sg13g2_fill_1
X_11359_ _11359_/Y _11359_/A _11875_/B VDD VSS sg13g2_nand2_1
X_14147_ _14147_/Q clkload0/A _14147_/D _14147_/RESET_B VDD VSS sg13g2_dfrbpq_1
XFILLER_141_934 VDD VSS sg13g2_decap_8
XFILLER_152_282 VDD VSS sg13g2_decap_8
XFILLER_98_347 VDD VSS sg13g2_decap_8
X_14078_ _14078_/Q clkload53/A _14078_/D _14078_/RESET_B VDD VSS sg13g2_dfrbpq_1
XFILLER_113_669 VDD VSS sg13g2_decap_8
X_13029_ _13029_/Y _14813_/Q _13180_/A2 _13094_/B1 _14845_/Q _13082_/B VDD VSS sg13g2_a221oi_1
XFILLER_140_488 VDD VSS sg13g2_decap_8
XFILLER_117_1071 VDD VSS sg13g2_decap_8
XFILLER_67_778 VDD VSS sg13g2_decap_8
Xfanout1082 _12705_/S0 wire1096/X VDD VSS sg13g2_buf_1
Xfanout1093 _12369_/S0 wire1096/A VDD VSS sg13g2_buf_1
XFILLER_67_789 VDD VSS sg13g2_fill_2
XFILLER_54_417 VDD VSS sg13g2_decap_4
XFILLER_81_203 VDD VSS sg13g2_decap_8
XFILLER_26_119 VDD VSS sg13g2_decap_8
X_08570_ _08570_/Y _08494_/Y _08574_/D _08569_/Y VDD VSS sg13g2_a21oi_1
XFILLER_54_439 VDD VSS sg13g2_decap_8
XFILLER_35_631 VDD VSS sg13g2_decap_8
XFILLER_63_951 VDD VSS sg13g2_fill_2
XFILLER_34_130 VDD VSS sg13g2_decap_8
X_13974__2590 _13974_/RESET_B VDD VSS sg13g2_tiehi
Xclkbuf_leaf_111_clk_i clkload32/A clkbuf_5_12__f_clk_i/X VDD VSS sg13g2_buf_8
X_09122_ _09125_/B _14919_/Q _09117_/C VDD VSS sg13g2_nor2b_1
X_09053_ _09053_/Y _15233_/Q _09147_/B VDD VSS sg13g2_nand2b_1
XFILLER_129_780 VDD VSS sg13g2_fill_2
Xclkbuf_leaf_126_clk_i clkload1/A clkbuf_leaf_1_clk_i/A VDD VSS sg13g2_buf_8
XFILLER_135_238 VDD VSS sg13g2_decap_8
X_08004_ _08004_/Y _08201_/B _08463_/A VDD VSS sg13g2_nor2b_1
XFILLER_129_791 VDD VSS sg13g2_decap_8
XFILLER_117_953 VDD VSS sg13g2_decap_4
XFILLER_144_750 VDD VSS sg13g2_fill_2
Xmax_cap240 _10400_/A _10359_/A VDD VSS sg13g2_buf_2
XFILLER_2_719 VDD VSS sg13g2_decap_8
XFILLER_116_463 VDD VSS sg13g2_fill_1
XFILLER_104_614 VDD VSS sg13g2_decap_8
XFILLER_131_400 VDD VSS sg13g2_decap_4
XFILLER_144_794 VDD VSS sg13g2_fill_1
XFILLER_132_934 VDD VSS sg13g2_decap_8
X_15103__3144 _15103_/RESET_B VDD VSS sg13g2_tiehi
XFILLER_103_135 VDD VSS sg13g2_decap_8
X_09955_ _14539_/D _14539_/Q _10021_/A0 _09969_/S VDD VSS sg13g2_mux2_1
XFILLER_131_466 VDD VSS sg13g2_decap_4
XFILLER_44_1032 VDD VSS sg13g2_fill_2
XFILLER_58_712 VDD VSS sg13g2_decap_8
X_08906_ _08906_/Y _08966_/A _08959_/B _15040_/Q VDD VSS sg13g2_nand3_1
X_09886_ _14472_/D _09919_/A1 _14472_/Q wire321/X VDD VSS sg13g2_mux2_1
XFILLER_100_842 VDD VSS sg13g2_fill_1
XFILLER_46_907 VDD VSS sg13g2_fill_2
XFILLER_58_767 VDD VSS sg13g2_fill_1
XFILLER_66_49 VDD VSS sg13g2_decap_8
X_08837_ _08837_/X _08966_/A _08959_/B VDD VSS sg13g2_and2_1
XFILLER_85_553 VDD VSS sg13g2_fill_1
XFILLER_73_704 VDD VSS sg13g2_decap_8
XFILLER_39_970 VDD VSS sg13g2_decap_4
XFILLER_85_586 VDD VSS sg13g2_decap_8
XFILLER_17_119 VDD VSS sg13g2_decap_8
XFILLER_57_288 VDD VSS sg13g2_fill_1
XFILLER_72_214 VDD VSS sg13g2_decap_8
XFILLER_73_748 VDD VSS sg13g2_fill_2
X_08768_ _13674_/D _08780_/A1 _08767_/Y _08766_/Y VDD VSS sg13g2_a21oi_1
XFILLER_72_236 VDD VSS sg13g2_fill_1
XFILLER_73_759 VDD VSS sg13g2_decap_8
X_15221__3374 _15221_/RESET_B VDD VSS sg13g2_tiehi
X_07719_ _07719_/X _13343_/B _11288_/A VDD VSS sg13g2_or2_1
X_08699_ _08699_/Y _08698_/X _08697_/Y _08696_/Y _08695_/Y VDD VSS sg13g2_a22oi_1
XFILLER_53_450 VDD VSS sg13g2_decap_8
X_13804__2760 _13804_/RESET_B VDD VSS sg13g2_tiehi
XFILLER_13_314 VDD VSS sg13g2_decap_8
X_10730_ _10730_/Y _13064_/A _11074_/B VDD VSS sg13g2_nand2_1
XFILLER_15_42 VDD VSS sg13g2_decap_8
X_10661_ _14892_/D _13507_/A _10661_/B _10661_/C VDD VSS sg13g2_nor3_1
X_12400_ _12400_/Y _12415_/A _12400_/B VDD VSS sg13g2_nand2_1
X_14148__2416 _14148_/RESET_B VDD VSS sg13g2_tiehi
XFILLER_55_1194 VDD VSS sg13g2_decap_8
X_13380_ _13380_/Y _13465_/A1 _08723_/B _15080_/Q VDD VSS sg13g2_o21ai_1
X_10592_ _14874_/D _10595_/B _10592_/B _10607_/C VDD VSS sg13g2_nor3_1
XFILLER_90_1085 VDD VSS sg13g2_fill_2
XFILLER_21_380 VDD VSS sg13g2_decap_8
XFILLER_16_1167 VDD VSS sg13g2_fill_2
XFILLER_154_503 VDD VSS sg13g2_decap_8
X_12331_ _12331_/X _11973_/B _12330_/X _12329_/Y VDD VSS sg13g2_a21o_1
X_14960__3012 _14960_/RESET_B VDD VSS sg13g2_tiehi
XFILLER_5_535 VDD VSS sg13g2_decap_4
X_12262_ _12263_/B _12251_/Y _12253_/X _11747_/A VDD VSS sg13g2_o21ai_1
X_15050_ _15050_/Q clkload35/A _15050_/D _15050_/RESET_B VDD VSS sg13g2_dfrbpq_1
XFILLER_108_964 VDD VSS sg13g2_decap_8
XFILLER_147_63 VDD VSS sg13g2_decap_8
X_11213_ _11213_/X _11212_/X _11226_/S1 _11227_/S VDD VSS sg13g2_a21o_1
XFILLER_103_0 VDD VSS sg13g2_decap_8
X_14001_ _14001_/Q clkload44/A _14001_/D _14001_/RESET_B VDD VSS sg13g2_dfrbpq_1
X_12193_ _12193_/Y _12192_/Y _12182_/Y _12174_/Y _12164_/Y _12223_/A VDD VSS sg13g2_a221oi_1
Xclkbuf_leaf_90_clk_i _15229_/CLK clkbuf_leaf_92_clk_i/A VDD VSS sg13g2_buf_8
X_14363__2201 _14363_/RESET_B VDD VSS sg13g2_tiehi
Xoutput41 mem_axi_araddr[12] _16865_/A VDD VSS sg13g2_buf_1
Xoutput52 mem_axi_araddr[23] _13714_/Q VDD VSS sg13g2_buf_1
XFILLER_1_730 VDD VSS sg13g2_fill_1
X_11144_ _11144_/Y _11172_/A _11164_/B VDD VSS sg13g2_nor2_1
Xoutput63 mem_axi_araddr[4] _16857_/A VDD VSS sg13g2_buf_1
Xoutput74 mem_axi_awaddr[13] _16866_/X VDD VSS sg13g2_buf_1
XFILLER_62_1110 VDD VSS sg13g2_fill_1
XFILLER_68_509 VDD VSS sg13g2_fill_2
Xoutput85 mem_axi_awaddr[24] _16877_/X VDD VSS sg13g2_buf_1
XFILLER_123_989 VDD VSS sg13g2_decap_8
Xoutput96 mem_axi_awaddr[5] _16858_/X VDD VSS sg13g2_buf_1
XFILLER_49_712 VDD VSS sg13g2_decap_8
XFILLER_1_785 VDD VSS sg13g2_fill_2
XFILLER_0_262 VDD VSS sg13g2_decap_4
X_11075_ _11118_/B _11202_/A _11097_/A VDD VSS sg13g2_xnor2_1
XFILLER_23_1105 VDD VSS sg13g2_decap_8
XFILLER_48_211 VDD VSS sg13g2_fill_2
X_14903_ _14903_/Q clkload38/A _14903_/D _14903_/RESET_B VDD VSS sg13g2_dfrbpq_1
X_10026_ _14608_/D _10092_/A0 _14608_/Q _10035_/S VDD VSS sg13g2_mux2_1
XFILLER_37_907 VDD VSS sg13g2_fill_2
XFILLER_76_564 VDD VSS sg13g2_decap_4
XFILLER_97_1206 VDD VSS sg13g2_fill_1
X_14396__2168 _14396_/RESET_B VDD VSS sg13g2_tiehi
XFILLER_48_277 VDD VSS sg13g2_decap_8
X_14834_ _14834_/Q clkload80/A _14834_/D _14834_/RESET_B VDD VSS sg13g2_dfrbpq_1
XFILLER_91_534 VDD VSS sg13g2_fill_2
X_14765_ _14765_/Q clkload57/A _14765_/D _14765_/RESET_B VDD VSS sg13g2_dfrbpq_1
X_11977_ _11977_/X _14915_/Q _11792_/B _11976_/Y VDD VSS sg13g2_a21o_1
XFILLER_45_995 VDD VSS sg13g2_decap_8
X_13716_ _16878_/A _15046_/CLK _13716_/D _13716_/RESET_B VDD VSS sg13g2_dfrbpq_1
XFILLER_147_1053 VDD VSS sg13g2_decap_8
X_10928_ _14936_/D _10927_/Y _10926_/X _10914_/Y VDD VSS sg13g2_o21ai_1
XFILLER_31_111 VDD VSS sg13g2_fill_1
X_14696_ _14696_/Q clkload27/A _14696_/D _14696_/RESET_B VDD VSS sg13g2_dfrbpq_1
XFILLER_31_122 VDD VSS sg13g2_decap_8
X_13647_ _14750_/D _15193_/D _14750_/Q _13653_/S VDD VSS sg13g2_mux2_1
XFILLER_31_155 VDD VSS sg13g2_decap_8
X_10859_ _10859_/Y _10885_/A1 _10857_/Y _10858_/Y VDD VSS sg13g2_a21oi_1
XFILLER_34_1234 VDD VSS sg13g2_fill_2
Xclkbuf_leaf_43_clk_i clkload59/A clkbuf_leaf_62_clk_i/A VDD VSS sg13g2_buf_8
X_13578_ _13578_/Y _15158_/Q _13593_/B VDD VSS sg13g2_nor2_1
X_12529_ _12529_/X _14120_/Q _14152_/Q _14184_/Q _14216_/Q _12529_/S0 _12534_/S1 VDD
+ VSS sg13g2_mux4_1
X_15248_ _15248_/Q _15248_/CLK wire144/X _15248_/RESET_B VDD VSS sg13g2_dfrbpq_1
XFILLER_132_219 VDD VSS sg13g2_decap_8
Xclkbuf_leaf_58_clk_i _15178_/CLK clkbuf_leaf_67_clk_i/A VDD VSS sg13g2_buf_8
XFILLER_28_1005 VDD VSS sg13g2_decap_8
X_15179_ _15179_/Q clkload72/A _15179_/D _15179_/RESET_B VDD VSS sg13g2_dfrbpq_1
XFILLER_114_945 VDD VSS sg13g2_decap_8
X_13846__2718 _13846_/RESET_B VDD VSS sg13g2_tiehi
XFILLER_140_230 VDD VSS sg13g2_decap_8
XFILLER_28_1038 VDD VSS sg13g2_decap_8
Xfanout319 _09898_/S wire321/A VDD VSS sg13g2_buf_1
XFILLER_119_1166 VDD VSS sg13g2_decap_8
XFILLER_86_306 VDD VSS sg13g2_fill_2
XFILLER_141_797 VDD VSS sg13g2_decap_8
X_09740_ wire447/A _09938_/D _09740_/B VDD VSS sg13g2_nor2_1
.ends
