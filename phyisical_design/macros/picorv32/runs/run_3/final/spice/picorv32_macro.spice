* NGSPICE file created from picorv32_macro.ext - technology: ihp-sg13g2

* Black-box entry subcircuit for sg13g2_fill_2 abstract view
.subckt sg13g2_fill_2 VDD VSS
.ends

* Black-box entry subcircuit for sg13g2_decap_8 abstract view
.subckt sg13g2_decap_8 VDD VSS
.ends

* Black-box entry subcircuit for sg13g2_mux2_1 abstract view
.subckt sg13g2_mux2_1 X A0 A1 S VDD VSS
.ends

* Black-box entry subcircuit for sg13g2_tiehi abstract view
.subckt sg13g2_tiehi L_HI VDD VSS
.ends

* Black-box entry subcircuit for sg13g2_nor3_1 abstract view
.subckt sg13g2_nor3_1 Y A B C VDD VSS
.ends

* Black-box entry subcircuit for sg13g2_nor2_1 abstract view
.subckt sg13g2_nor2_1 Y A B VDD VSS
.ends

* Black-box entry subcircuit for sg13g2_fill_1 abstract view
.subckt sg13g2_fill_1 VDD VSS
.ends

* Black-box entry subcircuit for sg13g2_decap_4 abstract view
.subckt sg13g2_decap_4 VDD VSS
.ends

* Black-box entry subcircuit for sg13g2_o21ai_1 abstract view
.subckt sg13g2_o21ai_1 Y A1 A2 B1 VDD VSS
.ends

* Black-box entry subcircuit for sg13g2_a21oi_1 abstract view
.subckt sg13g2_a21oi_1 Y A1 A2 B1 VDD VSS
.ends

* Black-box entry subcircuit for sg13g2_buf_1 abstract view
.subckt sg13g2_buf_1 X A VDD VSS
.ends

* Black-box entry subcircuit for sg13g2_nor4_1 abstract view
.subckt sg13g2_nor4_1 Y A B C D VDD VSS
.ends

* Black-box entry subcircuit for sg13g2_nand2_1 abstract view
.subckt sg13g2_nand2_1 Y A B VDD VSS
.ends

* Black-box entry subcircuit for sg13g2_a221oi_1 abstract view
.subckt sg13g2_a221oi_1 Y A1 A2 B1 B2 C1 VDD VSS
.ends

* Black-box entry subcircuit for sg13g2_dfrbpq_1 abstract view
.subckt sg13g2_dfrbpq_1 Q CLK D RESET_B VDD VSS
.ends

* Black-box entry subcircuit for sg13g2_mux4_1 abstract view
.subckt sg13g2_mux4_1 X A0 A1 A2 A3 S0 S1 VDD VSS
.ends

* Black-box entry subcircuit for sg13g2_inv_1 abstract view
.subckt sg13g2_inv_1 Y A VDD VSS
.ends

* Black-box entry subcircuit for sg13g2_nand3_1 abstract view
.subckt sg13g2_nand3_1 Y A B C VDD VSS
.ends

* Black-box entry subcircuit for sg13g2_a21o_1 abstract view
.subckt sg13g2_a21o_1 X A1 A2 B1 VDD VSS
.ends

* Black-box entry subcircuit for sg13g2_and4_1 abstract view
.subckt sg13g2_and4_1 X A B C D VDD VSS
.ends

* Black-box entry subcircuit for sg13g2_nand3b_1 abstract view
.subckt sg13g2_nand3b_1 Y A_N B C VDD VSS
.ends

* Black-box entry subcircuit for sg13g2_a22oi_1 abstract view
.subckt sg13g2_a22oi_1 Y A1 A2 B1 B2 VDD VSS
.ends

* Black-box entry subcircuit for sg13g2_and2_1 abstract view
.subckt sg13g2_and2_1 X A B VDD VSS
.ends

* Black-box entry subcircuit for sg13g2_buf_16 abstract view
.subckt sg13g2_buf_16 X A VDD VSS
.ends

* Black-box entry subcircuit for sg13g2_nand2b_1 abstract view
.subckt sg13g2_nand2b_1 Y A_N B VDD VSS
.ends

* Black-box entry subcircuit for sg13g2_or2_1 abstract view
.subckt sg13g2_or2_1 X A B VDD VSS
.ends

* Black-box entry subcircuit for sg13g2_nand4_1 abstract view
.subckt sg13g2_nand4_1 Y A B C D VDD VSS
.ends

* Black-box entry subcircuit for sg13g2_xnor2_1 abstract view
.subckt sg13g2_xnor2_1 Y A B VDD VSS
.ends

* Black-box entry subcircuit for sg13g2_buf_2 abstract view
.subckt sg13g2_buf_2 X A VDD VSS
.ends

* Black-box entry subcircuit for sg13g2_and3_1 abstract view
.subckt sg13g2_and3_1 X A B C VDD VSS
.ends

* Black-box entry subcircuit for sg13g2_buf_8 abstract view
.subckt sg13g2_buf_8 X A VDD VSS
.ends

* Black-box entry subcircuit for sg13g2_or4_1 abstract view
.subckt sg13g2_or4_1 X A B C D VDD VSS
.ends

* Black-box entry subcircuit for sg13g2_antennanp abstract view
.subckt sg13g2_antennanp A VDD VSS
.ends

* Black-box entry subcircuit for sg13g2_buf_4 abstract view
.subckt sg13g2_buf_4 X A VDD VSS
.ends

* Black-box entry subcircuit for sg13g2_dlygate4sd3_1 abstract view
.subckt sg13g2_dlygate4sd3_1 X A VDD VSS
.ends

* Black-box entry subcircuit for sg13g2_nor2b_1 abstract view
.subckt sg13g2_nor2b_1 Y A B_N VDD VSS
.ends

* Black-box entry subcircuit for sg13g2_inv_2 abstract view
.subckt sg13g2_inv_2 Y A VDD VSS
.ends

* Black-box entry subcircuit for sg13g2_xor2_1 abstract view
.subckt sg13g2_xor2_1 X A B VDD VSS
.ends

* Black-box entry subcircuit for sg13g2_tielo abstract view
.subckt sg13g2_tielo L_LO VDD VSS
.ends

* Black-box entry subcircuit for sg13g2_inv_4 abstract view
.subckt sg13g2_inv_4 Y A VDD VSS
.ends

* Black-box entry subcircuit for sg13g2_or3_1 abstract view
.subckt sg13g2_or3_1 X A B C VDD VSS
.ends

* Black-box entry subcircuit for sg13g2_inv_8 abstract view
.subckt sg13g2_inv_8 Y A VDD VSS
.ends

.subckt picorv32_macro VDD VSS clk_i mem_axi_araddr[0] mem_axi_araddr[10] mem_axi_araddr[11]
+ mem_axi_araddr[12] mem_axi_araddr[13] mem_axi_araddr[14] mem_axi_araddr[15] mem_axi_araddr[16]
+ mem_axi_araddr[17] mem_axi_araddr[18] mem_axi_araddr[19] mem_axi_araddr[1] mem_axi_araddr[20]
+ mem_axi_araddr[21] mem_axi_araddr[22] mem_axi_araddr[23] mem_axi_araddr[24] mem_axi_araddr[25]
+ mem_axi_araddr[26] mem_axi_araddr[27] mem_axi_araddr[28] mem_axi_araddr[29] mem_axi_araddr[2]
+ mem_axi_araddr[30] mem_axi_araddr[31] mem_axi_araddr[3] mem_axi_araddr[4] mem_axi_araddr[5]
+ mem_axi_araddr[6] mem_axi_araddr[7] mem_axi_araddr[8] mem_axi_araddr[9] mem_axi_arprot[0]
+ mem_axi_arprot[1] mem_axi_arprot[2] mem_axi_arready mem_axi_arvalid mem_axi_awaddr[0]
+ mem_axi_awaddr[10] mem_axi_awaddr[11] mem_axi_awaddr[12] mem_axi_awaddr[13] mem_axi_awaddr[14]
+ mem_axi_awaddr[15] mem_axi_awaddr[16] mem_axi_awaddr[17] mem_axi_awaddr[18] mem_axi_awaddr[19]
+ mem_axi_awaddr[1] mem_axi_awaddr[20] mem_axi_awaddr[21] mem_axi_awaddr[22] mem_axi_awaddr[23]
+ mem_axi_awaddr[24] mem_axi_awaddr[25] mem_axi_awaddr[26] mem_axi_awaddr[27] mem_axi_awaddr[28]
+ mem_axi_awaddr[29] mem_axi_awaddr[2] mem_axi_awaddr[30] mem_axi_awaddr[31] mem_axi_awaddr[3]
+ mem_axi_awaddr[4] mem_axi_awaddr[5] mem_axi_awaddr[6] mem_axi_awaddr[7] mem_axi_awaddr[8]
+ mem_axi_awaddr[9] mem_axi_awprot[0] mem_axi_awprot[1] mem_axi_awprot[2] mem_axi_awready
+ mem_axi_awvalid mem_axi_bready mem_axi_bvalid mem_axi_rdata[0] mem_axi_rdata[10]
+ mem_axi_rdata[11] mem_axi_rdata[12] mem_axi_rdata[13] mem_axi_rdata[14] mem_axi_rdata[15]
+ mem_axi_rdata[16] mem_axi_rdata[17] mem_axi_rdata[18] mem_axi_rdata[19] mem_axi_rdata[1]
+ mem_axi_rdata[20] mem_axi_rdata[21] mem_axi_rdata[22] mem_axi_rdata[23] mem_axi_rdata[24]
+ mem_axi_rdata[25] mem_axi_rdata[26] mem_axi_rdata[27] mem_axi_rdata[28] mem_axi_rdata[29]
+ mem_axi_rdata[2] mem_axi_rdata[30] mem_axi_rdata[31] mem_axi_rdata[3] mem_axi_rdata[4]
+ mem_axi_rdata[5] mem_axi_rdata[6] mem_axi_rdata[7] mem_axi_rdata[8] mem_axi_rdata[9]
+ mem_axi_rready mem_axi_rvalid mem_axi_wdata[0] mem_axi_wdata[10] mem_axi_wdata[11]
+ mem_axi_wdata[12] mem_axi_wdata[13] mem_axi_wdata[14] mem_axi_wdata[15] mem_axi_wdata[16]
+ mem_axi_wdata[17] mem_axi_wdata[18] mem_axi_wdata[19] mem_axi_wdata[1] mem_axi_wdata[20]
+ mem_axi_wdata[21] mem_axi_wdata[22] mem_axi_wdata[23] mem_axi_wdata[24] mem_axi_wdata[25]
+ mem_axi_wdata[26] mem_axi_wdata[27] mem_axi_wdata[28] mem_axi_wdata[29] mem_axi_wdata[2]
+ mem_axi_wdata[30] mem_axi_wdata[31] mem_axi_wdata[3] mem_axi_wdata[4] mem_axi_wdata[5]
+ mem_axi_wdata[6] mem_axi_wdata[7] mem_axi_wdata[8] mem_axi_wdata[9] mem_axi_wready
+ mem_axi_wstrb[0] mem_axi_wstrb[1] mem_axi_wstrb[2] mem_axi_wstrb[3] mem_axi_wvalid
+ rst_ni trap
XFILLER_45_1385 VDD VSS sg13g2_fill_2
XFILLER_41_1227 VDD VSS sg13g2_decap_8
X_09671_ _14264_/D _09770_/A1 _14264_/Q _09671_/S VDD VSS sg13g2_mux2_1
XFILLER_80_1298 VDD VSS sg13g2_decap_8
XFILLER_95_884 VDD VSS sg13g2_decap_8
XFILLER_82_501 VDD VSS sg13g2_decap_8
XFILLER_67_575 VDD VSS sg13g2_decap_8
X_15045__2628 _15045_/RESET_B VDD VSS sg13g2_tiehi
X_08622_ _08622_/Y _08622_/A _08622_/B _08622_/C VDD VSS sg13g2_nor3_1
XFILLER_94_372 VDD VSS sg13g2_decap_8
XFILLER_27_428 VDD VSS sg13g2_decap_8
XFILLER_94_394 VDD VSS sg13g2_decap_8
XFILLER_167_1429 VDD VSS sg13g2_decap_8
X_08553_ _08553_/Y _08553_/A _08553_/B VDD VSS sg13g2_nor2_1
XFILLER_36_962 VDD VSS sg13g2_decap_8
XFILLER_165_1120 VDD VSS sg13g2_fill_1
XFILLER_39_1134 VDD VSS sg13g2_decap_8
XFILLER_63_781 VDD VSS sg13g2_decap_4
X_08484_ _08484_/Y wire681/X _08560_/A _08484_/C VDD VSS sg13g2_nor3_1
XFILLER_51_932 VDD VSS sg13g2_decap_8
XFILLER_126_1126 VDD VSS sg13g2_decap_8
XFILLER_126_1137 VDD VSS sg13g2_fill_1
XFILLER_22_133 VDD VSS sg13g2_decap_8
XFILLER_167_105 VDD VSS sg13g2_decap_8
XFILLER_50_464 VDD VSS sg13g2_decap_8
XFILLER_149_831 VDD VSS sg13g2_fill_1
XFILLER_17_1432 VDD VSS sg13g2_decap_8
XFILLER_91_1361 VDD VSS sg13g2_decap_4
XFILLER_91_1372 VDD VSS sg13g2_fill_1
XFILLER_91_1394 VDD VSS sg13g2_decap_8
XFILLER_52_1345 VDD VSS sg13g2_decap_8
XFILLER_104_1435 VDD VSS sg13g2_fill_2
X_09105_ wire192/A _09126_/A1 _10752_/B _09104_/X VDD VSS sg13g2_o21ai_1
XFILLER_52_1378 VDD VSS sg13g2_decap_8
XFILLER_182_119 VDD VSS sg13g2_decap_8
X_14638__1634 _14638_/RESET_B VDD VSS sg13g2_tiehi
XFILLER_104_1468 VDD VSS sg13g2_fill_2
XFILLER_109_739 VDD VSS sg13g2_decap_8
XFILLER_164_834 VDD VSS sg13g2_fill_1
XFILLER_175_182 VDD VSS sg13g2_decap_8
XFILLER_87_1419 VDD VSS sg13g2_fill_1
X_09036_ _09036_/Y _14906_/Q _09031_/C _09035_/Y VDD VSS sg13g2_a21oi_1
XFILLER_184_28 VDD VSS sg13g2_decap_8
XFILLER_105_901 VDD VSS sg13g2_fill_1
XFILLER_11_1064 VDD VSS sg13g2_decap_8
XFILLER_117_11 VDD VSS sg13g2_fill_1
XFILLER_85_1132 VDD VSS sg13g2_decap_8
XFILLER_105_934 VDD VSS sg13g2_decap_8
XFILLER_132_720 VDD VSS sg13g2_decap_8
XFILLER_89_100 VDD VSS sg13g2_decap_8
XFILLER_7_7 VDD VSS sg13g2_decap_8
XFILLER_104_433 VDD VSS sg13g2_decap_8
XFILLER_137_1233 VDD VSS sg13g2_decap_8
XFILLER_172_1124 VDD VSS sg13g2_decap_8
XFILLER_120_904 VDD VSS sg13g2_decap_4
XFILLER_120_915 VDD VSS sg13g2_decap_8
XFILLER_81_1029 VDD VSS sg13g2_decap_8
Xfanout820 _12360_/A1 _08048_/A VDD VSS sg13g2_buf_1
XFILLER_89_177 VDD VSS sg13g2_decap_8
Xfanout831 _07751_/B _10926_/C VDD VSS sg13g2_buf_1
XFILLER_104_499 VDD VSS sg13g2_decap_8
X_15006__2674 _15006_/RESET_B VDD VSS sg13g2_tiehi
Xfanout842 _12747_/S0 _15214_/Q VDD VSS sg13g2_buf_1
X_09938_ wire348/A _09938_/A _09938_/B _09938_/C _09938_/D VDD VSS sg13g2_nor4_1
XFILLER_24_1414 VDD VSS sg13g2_decap_8
Xfanout864 _12760_/S0 _12747_/S1 VDD VSS sg13g2_buf_1
XFILLER_133_21 VDD VSS sg13g2_decap_8
Xfanout875 _12675_/S1 _12674_/S1 VDD VSS sg13g2_buf_1
XFILLER_19_918 VDD VSS sg13g2_decap_8
Xfanout886 _12620_/S1 _12382_/S1 VDD VSS sg13g2_buf_1
Xfanout897 _12715_/S1 fanout899/X VDD VSS sg13g2_buf_1
X_09869_ _14456_/D _14456_/Q _10067_/A0 _09869_/S VDD VSS sg13g2_mux2_1
XFILLER_85_350 VDD VSS sg13g2_fill_2
XFILLER_18_406 VDD VSS sg13g2_decap_8
XFILLER_150_1477 VDD VSS sg13g2_fill_2
XFILLER_93_14 VDD VSS sg13g2_decap_8
XFILLER_85_361 VDD VSS sg13g2_fill_1
X_11900_ _11900_/Y _11900_/A _11900_/B VDD VSS sg13g2_nand2_1
X_12880_ _12880_/Y _14804_/Q _12851_/B _07729_/D _14868_/Q _12917_/B1 VDD VSS sg13g2_a221oi_1
XFILLER_85_394 VDD VSS sg13g2_decap_8
XFILLER_2_1232 VDD VSS sg13g2_decap_8
X_11831_ _11832_/B _11820_/Y _11822_/X _11831_/B1 VDD VSS sg13g2_o21ai_1
XFILLER_96_1261 VDD VSS sg13g2_decap_8
XFILLER_26_63 VDD VSS sg13g2_decap_8
XFILLER_14_623 VDD VSS sg13g2_decap_8
X_14550_ _14550_/Q clkload41/A _14550_/D _14550_/RESET_B VDD VSS sg13g2_dfrbpq_1
XFILLER_92_1125 VDD VSS sg13g2_decap_8
XFILLER_26_483 VDD VSS sg13g2_decap_8
X_11762_ _11763_/A _14698_/Q _14730_/Q _13770_/Q _13802_/Q _11738_/S _11963_/S1 VDD
+ VSS sg13g2_mux4_1
XFILLER_13_133 VDD VSS sg13g2_decap_8
X_13501_ _13501_/Y _13501_/A _15129_/Q VDD VSS sg13g2_nand2_1
XFILLER_186_414 VDD VSS sg13g2_fill_1
X_10713_ _10936_/B _10954_/B VDD VSS sg13g2_inv_1
XFILLER_41_453 VDD VSS sg13g2_fill_1
XFILLER_183_1297 VDD VSS sg13g2_fill_2
X_14481_ _14481_/Q _14513_/CLK _14481_/D _14481_/RESET_B VDD VSS sg13g2_dfrbpq_1
XFILLER_70_1401 VDD VSS sg13g2_decap_8
X_11693_ _11694_/B _11693_/A _11693_/B _11970_/C VDD VSS sg13g2_nand3_1
XFILLER_9_126 VDD VSS sg13g2_decap_8
X_13432_ _15098_/D _15098_/Q _13470_/A2 _13431_/Y VDD VSS sg13g2_a21o_1
X_14277__1995 _14277_/RESET_B VDD VSS sg13g2_tiehi
X_10644_ _10644_/Y _14889_/Q _10643_/C _10611_/B VDD VSS sg13g2_o21ai_1
XFILLER_70_1456 VDD VSS sg13g2_decap_8
XFILLER_10_840 VDD VSS sg13g2_decap_8
XFILLER_155_801 VDD VSS sg13g2_decap_8
XFILLER_42_84 VDD VSS sg13g2_decap_8
XFILLER_173_119 VDD VSS sg13g2_decap_8
X_13363_ _13363_/Y _13440_/A _13469_/A _15074_/Q VDD VSS sg13g2_nand3_1
X_10575_ _10586_/D _14870_/Q _10647_/C _10575_/C _10653_/A VDD VSS sg13g2_and4_1
XFILLER_155_845 VDD VSS sg13g2_decap_8
XFILLER_166_182 VDD VSS sg13g2_decap_8
XFILLER_6_833 VDD VSS sg13g2_decap_8
X_15102_ _15102_/Q _15224_/CLK _15102_/D _15102_/RESET_B VDD VSS sg13g2_dfrbpq_1
X_12314_ _12314_/Y _12328_/A1 _14682_/Q _12328_/B1 VDD VSS sg13g2_a21oi_1
XFILLER_155_889 VDD VSS sg13g2_fill_1
X_13294_ _13294_/Y _15204_/Q _13294_/B _13294_/C VDD VSS sg13g2_nand3b_1
XFILLER_5_343 VDD VSS sg13g2_decap_8
XFILLER_138_1008 VDD VSS sg13g2_decap_8
XFILLER_177_1057 VDD VSS sg13g2_decap_8
XFILLER_182_686 VDD VSS sg13g2_decap_8
XFILLER_108_783 VDD VSS sg13g2_decap_8
X_15033_ _15033_/Q clkload74/A _15033_/D _15033_/RESET_B VDD VSS sg13g2_dfrbpq_1
XFILLER_170_848 VDD VSS sg13g2_decap_8
X_13732__2540 _13732_/RESET_B VDD VSS sg13g2_tiehi
X_12245_ _12246_/A _13752_/Q _14104_/Q _14456_/Q _14552_/Q _12245_/S0 _12245_/S1 VDD
+ VSS sg13g2_mux4_1
X_14492__1780 _14492_/RESET_B VDD VSS sg13g2_tiehi
XFILLER_68_1363 VDD VSS sg13g2_decap_8
XFILLER_123_731 VDD VSS sg13g2_decap_8
XFILLER_181_196 VDD VSS sg13g2_decap_8
XFILLER_64_1205 VDD VSS sg13g2_decap_8
XFILLER_29_1325 VDD VSS sg13g2_fill_2
X_12176_ _12176_/Y _12243_/A1 _14422_/Q _12169_/C VDD VSS sg13g2_a21oi_1
XFILLER_69_818 VDD VSS sg13g2_decap_8
XFILLER_111_915 VDD VSS sg13g2_fill_2
XFILLER_123_797 VDD VSS sg13g2_decap_8
XFILLER_151_1219 VDD VSS sg13g2_decap_8
XFILLER_1_560 VDD VSS sg13g2_decap_8
X_11127_ _11127_/Y _11127_/A _11127_/B _11146_/A VDD VSS sg13g2_nand3_1
XFILLER_3_56 VDD VSS sg13g2_decap_8
XFILLER_95_125 VDD VSS sg13g2_decap_8
XFILLER_122_296 VDD VSS sg13g2_decap_8
XFILLER_49_531 VDD VSS sg13g2_decap_8
XFILLER_110_458 VDD VSS sg13g2_decap_8
XFILLER_114_1030 VDD VSS sg13g2_decap_8
X_14112__2160 _14112_/RESET_B VDD VSS sg13g2_tiehi
X_11058_ _11058_/Y _11185_/A _11078_/B VDD VSS sg13g2_nor2_1
XFILLER_77_862 VDD VSS sg13g2_decap_8
XFILLER_83_309 VDD VSS sg13g2_decap_8
XFILLER_7_1176 VDD VSS sg13g2_decap_8
XFILLER_97_1003 VDD VSS sg13g2_fill_2
XFILLER_67_92 VDD VSS sg13g2_decap_8
X_10009_ _14591_/D _10075_/A0 _14591_/Q _10030_/S VDD VSS sg13g2_mux2_1
XFILLER_3_1029 VDD VSS sg13g2_decap_8
XFILLER_92_832 VDD VSS sg13g2_decap_8
XFILLER_36_214 VDD VSS sg13g2_decap_8
XFILLER_37_748 VDD VSS sg13g2_decap_8
XFILLER_36_225 VDD VSS sg13g2_fill_1
XFILLER_40_1260 VDD VSS sg13g2_decap_8
XFILLER_149_1126 VDD VSS sg13g2_decap_8
XFILLER_36_247 VDD VSS sg13g2_decap_8
X_14716__1556 _14716_/RESET_B VDD VSS sg13g2_tiehi
X_14817_ _14817_/Q _14886_/CLK _14817_/D _14817_/RESET_B VDD VSS sg13g2_dfrbpq_1
XFILLER_18_995 VDD VSS sg13g2_decap_4
XFILLER_17_483 VDD VSS sg13g2_decap_8
X_14748_ _14748_/Q clkload90/A _14748_/D _14748_/RESET_B VDD VSS sg13g2_dfrbpq_1
XFILLER_75_1356 VDD VSS sg13g2_decap_8
XFILLER_127_1424 VDD VSS sg13g2_decap_4
XFILLER_32_431 VDD VSS sg13g2_decap_8
XFILLER_36_1318 VDD VSS sg13g2_decap_8
X_13980__2292 _13980_/RESET_B VDD VSS sg13g2_tiehi
XFILLER_178_948 VDD VSS sg13g2_decap_8
X_14679_ _14679_/Q clkload47/A _14679_/D _14679_/RESET_B VDD VSS sg13g2_dfrbpq_1
XFILLER_149_138 VDD VSS sg13g2_fill_2
XFILLER_20_626 VDD VSS sg13g2_decap_8
XFILLER_177_469 VDD VSS sg13g2_decap_8
XFILLER_34_1031 VDD VSS sg13g2_decap_8
XFILLER_125_1170 VDD VSS sg13g2_fill_2
XFILLER_146_801 VDD VSS sg13g2_decap_4
XFILLER_158_661 VDD VSS sg13g2_decap_8
XFILLER_121_1012 VDD VSS sg13g2_decap_4
XFILLER_146_812 VDD VSS sg13g2_decap_4
XFILLER_160_1061 VDD VSS sg13g2_decap_8
XFILLER_125_1192 VDD VSS sg13g2_decap_8
X_14865__2907 _14865_/RESET_B VDD VSS sg13g2_tiehi
XFILLER_157_182 VDD VSS sg13g2_decap_4
XFILLER_9_693 VDD VSS sg13g2_decap_8
XFILLER_173_642 VDD VSS sg13g2_decap_8
XFILLER_121_1067 VDD VSS sg13g2_decap_8
XFILLER_66_0 VDD VSS sg13g2_decap_8
XFILLER_12_1351 VDD VSS sg13g2_decap_8
XFILLER_173_653 VDD VSS sg13g2_fill_1
XFILLER_145_355 VDD VSS sg13g2_decap_8
XFILLER_133_506 VDD VSS sg13g2_decap_8
XFILLER_86_1430 VDD VSS sg13g2_decap_8
XFILLER_172_196 VDD VSS sg13g2_decap_8
X_14322__1950 _14322_/RESET_B VDD VSS sg13g2_tiehi
XFILLER_86_1463 VDD VSS sg13g2_decap_8
XFILLER_47_1414 VDD VSS sg13g2_decap_8
XFILLER_99_442 VDD VSS sg13g2_decap_8
X_14805__3001 _14805_/RESET_B VDD VSS sg13g2_tiehi
XFILLER_87_637 VDD VSS sg13g2_decap_8
Xfanout149 _10101_/A0 _09637_/A0 VDD VSS sg13g2_buf_1
X_07984_ _07985_/D _07908_/A _15073_/Q _15215_/Q _07977_/Y VDD VSS sg13g2_a22oi_1
XFILLER_101_458 VDD VSS sg13g2_fill_1
X_09723_ _14314_/D _09921_/A1 _14314_/Q _09733_/S VDD VSS sg13g2_mux2_1
XFILLER_45_1182 VDD VSS sg13g2_decap_8
XFILLER_132_1141 VDD VSS sg13g2_decap_8
XFILLER_67_350 VDD VSS sg13g2_fill_2
XFILLER_41_1035 VDD VSS sg13g2_decap_8
XFILLER_95_670 VDD VSS sg13g2_decap_8
XFILLER_67_361 VDD VSS sg13g2_decap_8
XFILLER_83_832 VDD VSS sg13g2_decap_8
X_09654_ _14247_/D _09885_/A0 _14247_/Q _09672_/S VDD VSS sg13g2_mux2_1
XFILLER_82_320 VDD VSS sg13g2_decap_8
XFILLER_28_759 VDD VSS sg13g2_fill_1
XFILLER_103_46 VDD VSS sg13g2_fill_2
X_08605_ _08605_/X _08605_/A _08605_/B VDD VSS sg13g2_and2_1
XFILLER_82_353 VDD VSS sg13g2_decap_8
XFILLER_43_718 VDD VSS sg13g2_decap_8
X_09585_ _14182_/D _14182_/Q _09618_/A0 _09605_/S VDD VSS sg13g2_mux2_1
XFILLER_27_269 VDD VSS sg13g2_decap_8
XFILLER_70_537 VDD VSS sg13g2_decap_8
X_08536_ _08545_/A _13533_/A _08214_/X _08652_/B1 VDD VSS sg13g2_o21ai_1
XFILLER_179_28 VDD VSS sg13g2_decap_8
XFILLER_42_239 VDD VSS sg13g2_decap_8
XFILLER_180_1404 VDD VSS sg13g2_fill_2
XFILLER_51_740 VDD VSS sg13g2_decap_4
XFILLER_180_1415 VDD VSS sg13g2_decap_8
XFILLER_24_965 VDD VSS sg13g2_fill_1
XFILLER_23_442 VDD VSS sg13g2_fill_1
XFILLER_168_414 VDD VSS sg13g2_decap_8
X_13810__2462 _13810_/RESET_B VDD VSS sg13g2_tiehi
XFILLER_93_1478 VDD VSS sg13g2_fill_1
XFILLER_144_7 VDD VSS sg13g2_decap_8
X_08467_ _08469_/A _08621_/A _08617_/B VDD VSS sg13g2_nor2_1
XFILLER_50_261 VDD VSS sg13g2_decap_8
XFILLER_11_637 VDD VSS sg13g2_decap_8
XFILLER_50_272 VDD VSS sg13g2_fill_1
X_08398_ _08398_/Y _07911_/A wire719/X _08242_/A VDD VSS sg13g2_o21ai_1
XFILLER_104_1210 VDD VSS sg13g2_decap_8
XFILLER_183_406 VDD VSS sg13g2_decap_8
XFILLER_10_147 VDD VSS sg13g2_decap_8
XFILLER_155_119 VDD VSS sg13g2_decap_8
XFILLER_12_21 VDD VSS sg13g2_decap_8
Xclkbuf_5_6__f_clk_i clkbuf_5_6__f_clk_i/X clkbuf_4_3_0_clk_i/X VDD VSS sg13g2_buf_16
XFILLER_52_1175 VDD VSS sg13g2_decap_8
X_14154__2118 _14154_/RESET_B VDD VSS sg13g2_tiehi
XFILLER_104_1265 VDD VSS sg13g2_decap_8
XFILLER_137_856 VDD VSS sg13g2_decap_8
XFILLER_13_1148 VDD VSS sg13g2_decap_8
X_10360_ _14811_/D _10364_/C _10608_/B _10360_/C VDD VSS sg13g2_nor3_1
XFILLER_178_1344 VDD VSS sg13g2_decap_4
XFILLER_30_1451 VDD VSS sg13g2_decap_8
XFILLER_104_1298 VDD VSS sg13g2_decap_8
XFILLER_128_43 VDD VSS sg13g2_decap_8
XFILLER_128_54 VDD VSS sg13g2_fill_1
XFILLER_12_98 VDD VSS sg13g2_decap_8
XFILLER_151_303 VDD VSS sg13g2_decap_8
XFILLER_163_163 VDD VSS sg13g2_fill_1
XFILLER_174_1208 VDD VSS sg13g2_decap_8
XFILLER_88_14 VDD VSS sg13g2_decap_8
XFILLER_128_76 VDD VSS sg13g2_decap_8
X_09019_ _09019_/Y _09019_/A _09019_/B VDD VSS sg13g2_nand2_1
X_10291_ _10292_/C _14791_/Q _10294_/C VDD VSS sg13g2_and2_1
XFILLER_3_847 VDD VSS sg13g2_decap_8
X_12030_ _12030_/Y _12033_/A1 _14386_/Q VDD VSS sg13g2_nand2b_1
XFILLER_151_358 VDD VSS sg13g2_decap_8
XFILLER_2_357 VDD VSS sg13g2_decap_8
XFILLER_104_252 VDD VSS sg13g2_decap_8
XFILLER_78_626 VDD VSS sg13g2_fill_2
XFILLER_132_594 VDD VSS sg13g2_decap_8
XFILLER_77_114 VDD VSS sg13g2_decap_8
XFILLER_24_1211 VDD VSS sg13g2_decap_8
XFILLER_144_75 VDD VSS sg13g2_decap_8
Xfanout650 _09006_/A _09137_/A VDD VSS sg13g2_buf_1
Xfanout661 _10788_/S _10743_/S VDD VSS sg13g2_buf_1
XFILLER_8_1463 VDD VSS sg13g2_decap_8
XFILLER_63_1271 VDD VSS sg13g2_fill_1
XFILLER_115_1350 VDD VSS sg13g2_decap_4
Xfanout672 _08895_/S _08831_/Y VDD VSS sg13g2_buf_1
X_13981_ _13981_/Q _14222_/CLK _13981_/D _13981_/RESET_B VDD VSS sg13g2_dfrbpq_1
Xfanout683 _08404_/B1 _07998_/X VDD VSS sg13g2_buf_1
XFILLER_63_1293 VDD VSS sg13g2_decap_8
XFILLER_4_1316 VDD VSS sg13g2_decap_8
Xfanout694 _08220_/B1 _08623_/A2 VDD VSS sg13g2_buf_1
XFILLER_18_203 VDD VSS sg13g2_decap_8
X_12932_ _12932_/Y _12929_/Y _12930_/Y _12931_/Y VDD VSS sg13g2_a21oi_1
XFILLER_46_523 VDD VSS sg13g2_decap_8
XFILLER_20_1119 VDD VSS sg13g2_decap_8
XFILLER_24_1288 VDD VSS sg13g2_decap_8
XFILLER_111_1247 VDD VSS sg13g2_decap_8
X_14961__2719 _14961_/RESET_B VDD VSS sg13g2_tiehi
XFILLER_85_180 VDD VSS sg13g2_decap_8
XFILLER_170_0 VDD VSS sg13g2_decap_8
XFILLER_73_353 VDD VSS sg13g2_decap_8
XFILLER_37_84 VDD VSS sg13g2_decap_8
XFILLER_160_63 VDD VSS sg13g2_decap_8
XFILLER_185_1337 VDD VSS sg13g2_decap_8
X_12863_ _12863_/Y _14803_/Q _12851_/B _07728_/B _14835_/Q _12917_/B1 VDD VSS sg13g2_a221oi_1
XFILLER_33_217 VDD VSS sg13g2_decap_8
X_14602_ _14602_/Q clkload19/A _14602_/D _14602_/RESET_B VDD VSS sg13g2_dfrbpq_1
X_11814_ _11815_/A _13740_/Q _14092_/Q _14444_/Q _14540_/Q _12103_/A1 _12307_/C VDD
+ VSS sg13g2_mux4_1
XFILLER_14_420 VDD VSS sg13g2_decap_8
X_12794_ _13600_/B _12997_/B _12936_/B VDD VSS sg13g2_or2_1
XFILLER_26_280 VDD VSS sg13g2_fill_1
XFILLER_144_1001 VDD VSS sg13g2_decap_4
X_14364__1908 _14364_/RESET_B VDD VSS sg13g2_tiehi
XFILLER_26_291 VDD VSS sg13g2_fill_2
XFILLER_148_1181 VDD VSS sg13g2_decap_8
XFILLER_15_976 VDD VSS sg13g2_decap_8
X_14533_ _14533_/Q _14725_/CLK _14533_/D _14533_/RESET_B VDD VSS sg13g2_dfrbpq_1
XFILLER_42_762 VDD VSS sg13g2_decap_8
XFILLER_159_425 VDD VSS sg13g2_fill_1
X_11745_ _11745_/Y _11745_/A _11763_/B VDD VSS sg13g2_nand2_1
X_14400__1872 _14400_/RESET_B VDD VSS sg13g2_tiehi
XFILLER_57_1097 VDD VSS sg13g2_decap_8
XFILLER_41_261 VDD VSS sg13g2_decap_8
XFILLER_18_1059 VDD VSS sg13g2_decap_8
XFILLER_14_497 VDD VSS sg13g2_decap_8
XFILLER_109_1187 VDD VSS sg13g2_decap_4
X_14464_ _14464_/Q clkload40/A _14464_/D _14464_/RESET_B VDD VSS sg13g2_dfrbpq_1
X_11676_ _11676_/Y _12033_/A1 _14664_/Q _12233_/B VDD VSS sg13g2_a21oi_1
XFILLER_70_1242 VDD VSS sg13g2_decap_8
X_13415_ _15092_/D _15129_/Q _13414_/Y _13409_/Y VDD VSS sg13g2_a21o_1
X_10627_ _10630_/A _14883_/Q _10632_/D _14884_/Q VDD VSS sg13g2_a21o_1
XFILLER_139_171 VDD VSS sg13g2_decap_8
XFILLER_167_480 VDD VSS sg13g2_decap_8
X_14395_ _14395_/Q _14883_/CLK _14395_/D _14395_/RESET_B VDD VSS sg13g2_dfrbpq_1
XFILLER_6_630 VDD VSS sg13g2_decap_8
XFILLER_122_1376 VDD VSS sg13g2_decap_8
XFILLER_128_878 VDD VSS sg13g2_decap_8
XFILLER_154_130 VDD VSS sg13g2_decap_8
XFILLER_183_973 VDD VSS sg13g2_decap_8
X_13346_ _13347_/A _13654_/S _15173_/D VDD VSS sg13g2_nor2_1
X_10558_ _10561_/B _14859_/Q _10558_/B _10558_/C _14856_/Q VDD VSS sg13g2_nand4_1
XFILLER_170_601 VDD VSS sg13g2_decap_8
XFILLER_5_140 VDD VSS sg13g2_decap_8
XFILLER_157_1417 VDD VSS sg13g2_fill_1
XFILLER_183_995 VDD VSS sg13g2_decap_8
XFILLER_157_1428 VDD VSS sg13g2_decap_4
XFILLER_182_483 VDD VSS sg13g2_decap_8
XFILLER_143_859 VDD VSS sg13g2_decap_8
X_13277_ _13277_/Y _13048_/X _13272_/X _13276_/Y VDD VSS sg13g2_a21oi_1
X_10489_ _10498_/D _14850_/Q _14849_/Q _10489_/C _10489_/D VDD VSS sg13g2_and4_1
X_15016_ _15016_/Q clkload42/A _15016_/D _15016_/RESET_B VDD VSS sg13g2_dfrbpq_1
XFILLER_155_1130 VDD VSS sg13g2_decap_8
X_12228_ _12274_/B _12229_/A _13664_/Q VDD VSS sg13g2_nor2_1
XFILLER_170_689 VDD VSS sg13g2_decap_8
XFILLER_64_1046 VDD VSS sg13g2_decap_8
XFILLER_29_1166 VDD VSS sg13g2_decap_8
XFILLER_151_1005 VDD VSS sg13g2_fill_1
XFILLER_97_946 VDD VSS sg13g2_decap_8
XFILLER_151_1016 VDD VSS sg13g2_decap_4
X_12159_ _12159_/Y _12186_/A _14198_/Q VDD VSS sg13g2_nand2b_1
XFILLER_69_648 VDD VSS sg13g2_decap_8
XFILLER_68_125 VDD VSS sg13g2_decap_4
XFILLER_116_1147 VDD VSS sg13g2_fill_2
X_13998__2274 _13998_/RESET_B VDD VSS sg13g2_tiehi
XFILLER_81_1360 VDD VSS sg13g2_decap_8
XFILLER_110_244 VDD VSS sg13g2_decap_8
XFILLER_84_629 VDD VSS sg13g2_decap_8
XFILLER_77_670 VDD VSS sg13g2_fill_1
XFILLER_49_372 VDD VSS sg13g2_decap_8
XFILLER_83_139 VDD VSS sg13g2_decap_8
XFILLER_37_534 VDD VSS sg13g2_decap_8
XFILLER_42_1388 VDD VSS sg13g2_decap_8
XFILLER_77_1407 VDD VSS sg13g2_fill_1
XFILLER_92_673 VDD VSS sg13g2_decap_8
XFILLER_64_364 VDD VSS sg13g2_decap_8
XFILLER_91_161 VDD VSS sg13g2_decap_4
XFILLER_80_824 VDD VSS sg13g2_decap_4
X_09370_ _13974_/D _09966_/A1 _13974_/Q _09371_/S VDD VSS sg13g2_mux2_1
XFILLER_17_280 VDD VSS sg13g2_decap_8
XFILLER_80_879 VDD VSS sg13g2_decap_8
X_08321_ _08321_/Y _08369_/B _08350_/B VDD VSS sg13g2_nand2_1
XFILLER_166_1292 VDD VSS sg13g2_fill_1
XFILLER_71_1017 VDD VSS sg13g2_decap_8
XFILLER_178_745 VDD VSS sg13g2_decap_8
XFILLER_178_756 VDD VSS sg13g2_fill_2
XFILLER_60_581 VDD VSS sg13g2_decap_8
XFILLER_123_1107 VDD VSS sg13g2_decap_4
XFILLER_127_1276 VDD VSS sg13g2_fill_2
XFILLER_21_946 VDD VSS sg13g2_fill_2
X_08252_ _08252_/Y _08241_/A _08057_/Y _08241_/Y VDD VSS sg13g2_o21ai_1
XFILLER_177_266 VDD VSS sg13g2_decap_8
XFILLER_20_456 VDD VSS sg13g2_decap_8
XFILLER_119_823 VDD VSS sg13g2_decap_8
XFILLER_159_992 VDD VSS sg13g2_fill_1
XFILLER_14_1435 VDD VSS sg13g2_decap_8
X_08183_ _08183_/Y _13427_/C _08183_/B _08183_/C VDD VSS sg13g2_nor3_1
XFILLER_174_951 VDD VSS sg13g2_decap_8
XFILLER_9_490 VDD VSS sg13g2_decap_8
XFILLER_101_1427 VDD VSS sg13g2_decap_8
XFILLER_173_450 VDD VSS sg13g2_decap_8
XFILLER_106_528 VDD VSS sg13g2_decap_8
XFILLER_146_697 VDD VSS sg13g2_fill_2
XFILLER_47_1200 VDD VSS sg13g2_decap_8
XFILLER_133_347 VDD VSS sg13g2_decap_8
XFILLER_160_133 VDD VSS sg13g2_decap_8
XFILLER_121_509 VDD VSS sg13g2_decap_8
XFILLER_0_806 VDD VSS sg13g2_decap_8
XFILLER_173_1241 VDD VSS sg13g2_decap_8
XFILLER_114_594 VDD VSS sg13g2_decap_8
XFILLER_134_1225 VDD VSS sg13g2_decap_8
XFILLER_82_1157 VDD VSS sg13g2_decap_4
XFILLER_141_380 VDD VSS sg13g2_decap_4
XFILLER_60_1400 VDD VSS sg13g2_decap_8
XFILLER_134_1258 VDD VSS sg13g2_decap_8
X_13828__2444 _13828_/RESET_B VDD VSS sg13g2_tiehi
X_14588__1684 _14588_/RESET_B VDD VSS sg13g2_tiehi
XFILLER_102_778 VDD VSS sg13g2_decap_8
X_07967_ _07967_/Y _07964_/Y _07856_/Y _07965_/Y VDD VSS sg13g2_o21ai_1
XFILLER_75_629 VDD VSS sg13g2_decap_8
XFILLER_60_1444 VDD VSS sg13g2_decap_8
XFILLER_114_45 VDD VSS sg13g2_decap_4
XFILLER_74_117 VDD VSS sg13g2_decap_8
XFILLER_21_1417 VDD VSS sg13g2_decap_8
X_09706_ _14298_/D _09739_/A0 _14298_/Q _09706_/S VDD VSS sg13g2_mux2_1
XFILLER_55_320 VDD VSS sg13g2_decap_4
X_07898_ _07905_/B _08183_/B _08188_/A _07879_/Y VDD VSS sg13g2_o21ai_1
XFILLER_28_545 VDD VSS sg13g2_decap_8
XFILLER_167_1001 VDD VSS sg13g2_decap_8
XFILLER_167_1012 VDD VSS sg13g2_fill_2
XFILLER_16_707 VDD VSS sg13g2_decap_8
X_09637_ _14233_/D _09637_/A0 _14233_/Q _09637_/S VDD VSS sg13g2_mux2_1
XFILLER_56_887 VDD VSS sg13g2_decap_8
XFILLER_130_11 VDD VSS sg13g2_fill_1
XFILLER_15_217 VDD VSS sg13g2_decap_8
X_14208__2064 _14208_/RESET_B VDD VSS sg13g2_tiehi
XFILLER_3_1393 VDD VSS sg13g2_decap_8
X_09568_ _14166_/D _09933_/A1 _14166_/Q _09571_/S VDD VSS sg13g2_mux2_1
XFILLER_169_701 VDD VSS sg13g2_decap_8
XFILLER_169_712 VDD VSS sg13g2_fill_1
XFILLER_93_1253 VDD VSS sg13g2_fill_2
XFILLER_24_751 VDD VSS sg13g2_decap_8
XFILLER_145_1332 VDD VSS sg13g2_decap_8
X_08519_ _08597_/C _08591_/A3 _07818_/B _07821_/B _08471_/B _08598_/S0 _08598_/S1
+ VDD VSS sg13g2_mux4_1
XFILLER_12_924 VDD VSS sg13g2_decap_8
X_09499_ _14099_/D _10029_/A0 _14099_/Q _09501_/S VDD VSS sg13g2_mux2_1
XFILLER_19_1357 VDD VSS sg13g2_decap_8
XFILLER_145_1365 VDD VSS sg13g2_fill_2
XFILLER_169_767 VDD VSS sg13g2_decap_8
XFILLER_54_1248 VDD VSS sg13g2_decap_8
X_11530_ _11532_/A _11531_/A _14180_/Q VDD VSS sg13g2_nand2b_1
XFILLER_11_434 VDD VSS sg13g2_decap_8
XFILLER_145_1387 VDD VSS sg13g2_fill_1
XFILLER_141_1229 VDD VSS sg13g2_decap_4
XFILLER_8_917 VDD VSS sg13g2_decap_8
XFILLER_23_42 VDD VSS sg13g2_decap_8
XFILLER_183_203 VDD VSS sg13g2_decap_8
XFILLER_109_300 VDD VSS sg13g2_fill_2
XFILLER_139_42 VDD VSS sg13g2_decap_8
XFILLER_156_439 VDD VSS sg13g2_decap_8
X_11461_ _11463_/B _11461_/A _13687_/Q VDD VSS sg13g2_xnor2_1
XFILLER_7_427 VDD VSS sg13g2_decap_8
Xwire347 wire347/X wire348/X VDD VSS sg13g2_buf_2
X_13200_ _13224_/A _13200_/A _13667_/Q VDD VSS sg13g2_xnor2_1
X_10412_ _10415_/C _10413_/B _10414_/D hold3249/X VDD VSS sg13g2_a21oi_1
XFILLER_87_1002 VDD VSS sg13g2_decap_4
XFILLER_125_804 VDD VSS sg13g2_decap_8
XFILLER_137_664 VDD VSS sg13g2_decap_8
X_14180_ _14180_/Q clkload15/A _14180_/D _14180_/RESET_B VDD VSS sg13g2_dfrbpq_1
X_11392_ _11392_/Y _11804_/A _13919_/Q _11391_/Y VDD VSS sg13g2_a21oi_1
XFILLER_125_815 VDD VSS sg13g2_fill_2
XFILLER_136_152 VDD VSS sg13g2_decap_8
XFILLER_125_837 VDD VSS sg13g2_decap_8
XFILLER_152_612 VDD VSS sg13g2_decap_8
XFILLER_87_1046 VDD VSS sg13g2_decap_8
X_13131_ _13131_/Y _14914_/Q _13673_/Q _13132_/A VDD VSS sg13g2_a21oi_1
XFILLER_99_79 VDD VSS sg13g2_decap_8
XFILLER_109_399 VDD VSS sg13g2_decap_8
X_10343_ _14807_/D _10343_/A _10343_/B _10365_/C VDD VSS sg13g2_and3_1
XFILLER_87_1057 VDD VSS sg13g2_fill_1
XFILLER_48_1019 VDD VSS sg13g2_fill_2
XFILLER_139_1147 VDD VSS sg13g2_fill_2
XFILLER_65_1300 VDD VSS sg13g2_fill_1
XFILLER_3_644 VDD VSS sg13g2_decap_8
X_13062_ _13066_/A _13063_/B VDD VSS sg13g2_inv_1
X_10274_ _10274_/Y _14786_/Q _10305_/A _10499_/C VDD VSS sg13g2_o21ai_1
XFILLER_155_63 VDD VSS sg13g2_decap_8
XFILLER_180_998 VDD VSS sg13g2_decap_8
XFILLER_117_1412 VDD VSS sg13g2_decap_8
XFILLER_2_154 VDD VSS sg13g2_decap_8
XFILLER_79_935 VDD VSS sg13g2_fill_1
XFILLER_26_1306 VDD VSS sg13g2_decap_8
X_12013_ _12013_/Y _11988_/Y _12012_/X _11664_/A VDD VSS sg13g2_a21oi_1
Xfanout1401 _11969_/A _12035_/S0 VDD VSS sg13g2_buf_1
Xfanout1412 _11418_/A _11412_/S0 VDD VSS sg13g2_buf_1
Xfanout1423 _11317_/A1 _11320_/S0 VDD VSS sg13g2_buf_1
Xfanout1434 _12090_/A _12098_/A1 VDD VSS sg13g2_buf_1
XFILLER_65_1399 VDD VSS sg13g2_decap_4
Xfanout1445 fanout1445/X fanout1452/X VDD VSS sg13g2_buf_1
XFILLER_78_467 VDD VSS sg13g2_fill_1
X_14418__1854 _14418_/RESET_B VDD VSS sg13g2_tiehi
Xfanout1456 _12288_/S0 _12215_/S0 VDD VSS sg13g2_buf_1
XFILLER_8_1260 VDD VSS sg13g2_decap_8
XFILLER_78_478 VDD VSS sg13g2_decap_8
XFILLER_19_501 VDD VSS sg13g2_decap_8
Xfanout1467 _10667_/A _10655_/B VDD VSS sg13g2_buf_1
XFILLER_59_670 VDD VSS sg13g2_decap_8
Xfanout480 _09797_/S _09793_/S VDD VSS sg13g2_buf_1
Xfanout1478 _13266_/A _13198_/B1 VDD VSS sg13g2_buf_1
XFILLER_93_426 VDD VSS sg13g2_decap_8
XFILLER_4_1113 VDD VSS sg13g2_decap_8
Xfanout491 _09572_/S _09570_/S VDD VSS sg13g2_buf_1
Xfanout1489 _10365_/C _10499_/C VDD VSS sg13g2_buf_1
XFILLER_47_821 VDD VSS sg13g2_decap_4
XFILLER_24_1052 VDD VSS sg13g2_decap_8
X_13964_ _13964_/Q clkload17/A _13964_/D _13964_/RESET_B VDD VSS sg13g2_dfrbpq_1
XFILLER_171_84 VDD VSS sg13g2_decap_8
XFILLER_98_1131 VDD VSS sg13g2_decap_8
XFILLER_93_459 VDD VSS sg13g2_decap_8
XFILLER_46_331 VDD VSS sg13g2_fill_2
XFILLER_0_35 VDD VSS sg13g2_decap_8
X_12915_ _12933_/A input33/X _12841_/B _12914_/Y VDD VSS sg13g2_a21o_1
XFILLER_62_802 VDD VSS sg13g2_decap_4
XFILLER_19_578 VDD VSS sg13g2_fill_1
XFILLER_94_1006 VDD VSS sg13g2_fill_1
X_13895_ _13895_/Q _14741_/CLK _13895_/D _13895_/RESET_B VDD VSS sg13g2_dfrbpq_1
XFILLER_34_515 VDD VSS sg13g2_decap_8
XFILLER_185_1145 VDD VSS sg13g2_decap_8
XFILLER_61_312 VDD VSS sg13g2_fill_2
XFILLER_46_386 VDD VSS sg13g2_decap_8
XFILLER_185_1167 VDD VSS sg13g2_decap_4
X_12846_ _12846_/Y _12821_/Y _12834_/Y _12833_/Y VDD VSS sg13g2_o21ai_1
XFILLER_61_334 VDD VSS sg13g2_fill_2
XFILLER_185_1189 VDD VSS sg13g2_decap_8
XFILLER_76_1473 VDD VSS sg13g2_decap_4
XFILLER_72_1304 VDD VSS sg13g2_decap_4
XFILLER_159_211 VDD VSS sg13g2_decap_4
X_12777_ _12778_/B _13663_/Q _12777_/A2 _12776_/X _12400_/A _12777_/C1 VDD VSS sg13g2_a221oi_1
XFILLER_37_1446 VDD VSS sg13g2_decap_8
XFILLER_159_222 VDD VSS sg13g2_fill_1
XFILLER_15_784 VDD VSS sg13g2_decap_8
X_14933__2771 _14933_/RESET_B VDD VSS sg13g2_tiehi
XFILLER_70_890 VDD VSS sg13g2_decap_4
XFILLER_159_244 VDD VSS sg13g2_decap_8
XFILLER_163_1465 VDD VSS sg13g2_decap_4
X_14516_ _14516_/Q clkload55/A _14516_/D _14516_/RESET_B VDD VSS sg13g2_dfrbpq_1
X_11728_ _11728_/Y _11773_/D _11728_/B VDD VSS sg13g2_xnor2_1
XFILLER_14_294 VDD VSS sg13g2_decap_8
XFILLER_9_77 VDD VSS sg13g2_decap_8
XFILLER_174_203 VDD VSS sg13g2_decap_8
XFILLER_30_765 VDD VSS sg13g2_fill_2
XFILLER_119_119 VDD VSS sg13g2_fill_2
X_14447_ _14447_/Q _14607_/CLK _14447_/D _14447_/RESET_B VDD VSS sg13g2_dfrbpq_1
X_11659_ _11702_/A _11661_/A _12227_/B VDD VSS sg13g2_nor2_1
XFILLER_156_951 VDD VSS sg13g2_decap_4
X_13906__2366 _13906_/RESET_B VDD VSS sg13g2_tiehi
XFILLER_156_962 VDD VSS sg13g2_decap_8
XFILLER_31_1045 VDD VSS sg13g2_decap_8
XFILLER_127_141 VDD VSS sg13g2_decap_8
X_14378_ _14378_/Q clkload17/A _14378_/D _14378_/RESET_B VDD VSS sg13g2_dfrbpq_1
XFILLER_115_303 VDD VSS sg13g2_fill_1
XFILLER_7_994 VDD VSS sg13g2_decap_8
XFILLER_31_1089 VDD VSS sg13g2_fill_2
XFILLER_116_848 VDD VSS sg13g2_decap_8
X_13329_ _13329_/Y _15173_/Q _13333_/S VDD VSS sg13g2_nand2b_1
XFILLER_182_280 VDD VSS sg13g2_decap_8
XFILLER_143_656 VDD VSS sg13g2_decap_8
XFILLER_157_1258 VDD VSS sg13g2_decap_8
X_14810__2996 _14810_/RESET_B VDD VSS sg13g2_tiehi
XFILLER_83_1422 VDD VSS sg13g2_decap_8
XFILLER_142_155 VDD VSS sg13g2_decap_8
XFILLER_124_870 VDD VSS sg13g2_fill_1
X_15111__2830 _15111_/RESET_B VDD VSS sg13g2_tiehi
XFILLER_97_732 VDD VSS sg13g2_decap_8
XFILLER_123_380 VDD VSS sg13g2_fill_2
XFILLER_170_1425 VDD VSS sg13g2_decap_8
X_08870_ _08870_/X _15031_/Q _10694_/S _08869_/Y VDD VSS sg13g2_a21o_1
XFILLER_111_542 VDD VSS sg13g2_fill_2
XFILLER_9_1057 VDD VSS sg13g2_decap_8
XFILLER_96_231 VDD VSS sg13g2_decap_8
XFILLER_85_905 VDD VSS sg13g2_fill_2
XFILLER_69_456 VDD VSS sg13g2_decap_8
X_07821_ _07822_/B _15009_/Q _07821_/B VDD VSS sg13g2_and2_1
XFILLER_57_607 VDD VSS sg13g2_decap_8
XFILLER_29_0 VDD VSS sg13g2_decap_8
XFILLER_84_404 VDD VSS sg13g2_decap_8
XFILLER_97_798 VDD VSS sg13g2_decap_8
X_07752_ _07752_/Y _10869_/A _10797_/C _13304_/B _07989_/B VDD VSS sg13g2_nand4_1
XFILLER_37_320 VDD VSS sg13g2_decap_8
XFILLER_37_331 VDD VSS sg13g2_fill_2
XFILLER_168_1332 VDD VSS sg13g2_decap_4
XFILLER_37_364 VDD VSS sg13g2_fill_1
X_07683_ _07683_/X _07683_/A _13289_/C VDD VSS sg13g2_or2_1
XFILLER_52_301 VDD VSS sg13g2_decap_8
XFILLER_37_375 VDD VSS sg13g2_decap_8
XFILLER_168_1354 VDD VSS sg13g2_fill_2
XFILLER_37_386 VDD VSS sg13g2_fill_1
XFILLER_129_1316 VDD VSS sg13g2_decap_4
X_09422_ _14024_/D _09620_/A0 _14024_/Q _09427_/S VDD VSS sg13g2_mux2_1
XFILLER_77_1248 VDD VSS sg13g2_decap_4
XFILLER_80_665 VDD VSS sg13g2_decap_8
X_09353_ _13957_/D _09949_/A1 _13957_/Q _09365_/S VDD VSS sg13g2_mux2_1
XFILLER_100_14 VDD VSS sg13g2_fill_1
XFILLER_40_529 VDD VSS sg13g2_decap_8
XFILLER_178_553 VDD VSS sg13g2_decap_8
X_08304_ _08304_/Y _08304_/A _08306_/B VDD VSS sg13g2_nand2_1
XFILLER_127_1073 VDD VSS sg13g2_decap_8
X_09284_ _13892_/D _13892_/Q _10080_/A0 _09303_/S VDD VSS sg13g2_mux2_1
XFILLER_20_231 VDD VSS sg13g2_decap_8
Xclkbuf_5_24__f_clk_i clkbuf_leaf_81_clk_i/A clkbuf_4_12_0_clk_i/X VDD VSS sg13g2_buf_16
X_08235_ _08235_/X _08235_/A0 _11452_/A _11502_/A _11503_/A1 _08033_/A _08063_/A VDD
+ VSS sg13g2_mux4_1
XFILLER_14_1232 VDD VSS sg13g2_decap_8
XFILLER_165_258 VDD VSS sg13g2_decap_8
XFILLER_181_707 VDD VSS sg13g2_decap_8
X_08166_ _15222_/D _08166_/A _08166_/B _08166_/C VDD VSS sg13g2_nand3_1
XFILLER_174_770 VDD VSS sg13g2_decap_8
XFILLER_101_1235 VDD VSS sg13g2_fill_2
XFILLER_107_826 VDD VSS sg13g2_decap_8
XFILLER_119_686 VDD VSS sg13g2_fill_2
XFILLER_146_472 VDD VSS sg13g2_decap_8
XFILLER_180_217 VDD VSS sg13g2_decap_8
XFILLER_109_45 VDD VSS sg13g2_decap_8
XFILLER_179_1472 VDD VSS sg13g2_fill_2
X_14071__2201 _14071_/RESET_B VDD VSS sg13g2_tiehi
XFILLER_174_792 VDD VSS sg13g2_decap_8
XFILLER_109_67 VDD VSS sg13g2_decap_8
XFILLER_173_280 VDD VSS sg13g2_decap_8
X_08097_ _08098_/B _08234_/A _08094_/X _08096_/X VDD VSS sg13g2_a21oi_1
XFILLER_133_122 VDD VSS sg13g2_decap_8
Xclkload90 clkload90/X clkload90/A VDD VSS sg13g2_buf_8
XFILLER_134_689 VDD VSS sg13g2_decap_8
XFILLER_121_317 VDD VSS sg13g2_decap_8
XFILLER_138_1180 VDD VSS sg13g2_fill_1
XFILLER_173_1060 VDD VSS sg13g2_decap_4
X_14711__1561 _14711_/RESET_B VDD VSS sg13g2_tiehi
XFILLER_0_658 VDD VSS sg13g2_decap_8
XFILLER_173_1082 VDD VSS sg13g2_fill_1
XFILLER_88_754 VDD VSS sg13g2_decap_8
XFILLER_87_242 VDD VSS sg13g2_decap_4
XFILLER_134_1055 VDD VSS sg13g2_decap_8
XFILLER_88_787 VDD VSS sg13g2_decap_8
XFILLER_5_1400 VDD VSS sg13g2_decap_8
XFILLER_102_575 VDD VSS sg13g2_decap_8
X_08999_ _08999_/Y _14900_/Q _08993_/X _08999_/B1 VDD VSS sg13g2_o21ai_1
XFILLER_25_1350 VDD VSS sg13g2_decap_8
XFILLER_47_117 VDD VSS sg13g2_fill_1
XFILLER_60_1252 VDD VSS sg13g2_decap_8
XFILLER_151_1380 VDD VSS sg13g2_fill_2
XFILLER_169_1118 VDD VSS sg13g2_decap_8
XFILLER_21_1214 VDD VSS sg13g2_decap_8
XFILLER_60_1263 VDD VSS sg13g2_fill_2
XFILLER_18_42 VDD VSS sg13g2_decap_8
XFILLER_91_919 VDD VSS sg13g2_decap_4
XFILLER_112_1364 VDD VSS sg13g2_decap_8
XFILLER_60_1296 VDD VSS sg13g2_fill_2
XFILLER_5_1477 VDD VSS sg13g2_fill_2
XFILLER_28_353 VDD VSS sg13g2_fill_2
XFILLER_16_504 VDD VSS sg13g2_decap_8
X_10961_ _11009_/A _14759_/Q _10965_/B VDD VSS sg13g2_nand2b_1
XFILLER_28_386 VDD VSS sg13g2_decap_8
X_12700_ _12700_/X _14708_/Q _14740_/Q _13780_/Q _13812_/Q _12754_/S0 _12754_/S1 VDD
+ VSS sg13g2_mux4_1
XFILLER_83_481 VDD VSS sg13g2_decap_4
X_13680_ _13680_/Q clkload73/A _13680_/D _13680_/RESET_B VDD VSS sg13g2_dfrbpq_1
XFILLER_55_194 VDD VSS sg13g2_fill_2
XFILLER_3_1190 VDD VSS sg13g2_decap_8
X_10892_ _10893_/B _10879_/Y _10863_/X _10880_/Y VDD VSS sg13g2_a21oi_1
X_12631_ _12631_/X _13743_/Q _14095_/Q _14447_/Q _14543_/Q _12633_/S0 _12633_/S1 VDD
+ VSS sg13g2_mux4_1
XFILLER_70_153 VDD VSS sg13g2_decap_8
XFILLER_34_63 VDD VSS sg13g2_decap_8
XFILLER_12_721 VDD VSS sg13g2_decap_8
XFILLER_19_1154 VDD VSS sg13g2_decap_8
XFILLER_169_564 VDD VSS sg13g2_decap_8
X_12562_ _12562_/X _13738_/Q _14090_/Q _14442_/Q _14538_/Q _12643_/S0 _12643_/S1 VDD
+ VSS sg13g2_mux4_1
XFILLER_145_1173 VDD VSS sg13g2_decap_8
XFILLER_11_231 VDD VSS sg13g2_decap_8
XFILLER_15_1018 VDD VSS sg13g2_decap_8
XFILLER_133_0 VDD VSS sg13g2_decap_8
X_14301_ _14301_/Q clkload59/A _14301_/D _14301_/RESET_B VDD VSS sg13g2_dfrbpq_1
XFILLER_8_714 VDD VSS sg13g2_decap_8
XFILLER_141_1037 VDD VSS sg13g2_decap_8
X_11513_ _11513_/X _14115_/Q _14147_/Q _14179_/Q _14211_/Q _12140_/S0 _12140_/S1 VDD
+ VSS sg13g2_mux4_1
XFILLER_32_1321 VDD VSS sg13g2_decap_8
XFILLER_12_798 VDD VSS sg13g2_decap_8
X_12493_ _12493_/X _14117_/Q _14149_/Q _14181_/Q _14213_/Q _12654_/S0 _12654_/S1 VDD
+ VSS sg13g2_mux4_1
XFILLER_71_1381 VDD VSS sg13g2_decap_4
XFILLER_89_1119 VDD VSS sg13g2_decap_8
XFILLER_7_224 VDD VSS sg13g2_decap_8
XFILLER_172_707 VDD VSS sg13g2_fill_1
X_14232_ _14232_/Q clkload24/A _14232_/D _14232_/RESET_B VDD VSS sg13g2_dfrbpq_1
XFILLER_32_1354 VDD VSS sg13g2_decap_8
XFILLER_144_409 VDD VSS sg13g2_decap_8
XFILLER_184_578 VDD VSS sg13g2_decap_8
X_11444_ _11444_/X _14688_/Q _14720_/Q _13760_/Q _13792_/Q _11444_/S0 _11444_/S1 VDD
+ VSS sg13g2_mux4_1
XFILLER_50_51 VDD VSS sg13g2_decap_4
XFILLER_67_1406 VDD VSS sg13g2_decap_8
X_14163_ _14163_/Q _14739_/CLK _14163_/D _14163_/RESET_B VDD VSS sg13g2_dfrbpq_1
XFILLER_4_931 VDD VSS sg13g2_decap_8
XFILLER_153_954 VDD VSS sg13g2_decap_8
XFILLER_164_280 VDD VSS sg13g2_decap_4
X_11375_ _11375_/Y _11370_/Y _11371_/Y _11822_/B VDD VSS sg13g2_a21oi_1
XFILLER_166_84 VDD VSS sg13g2_decap_8
X_13114_ _13116_/B _13092_/C _13172_/C VDD VSS sg13g2_nand2b_1
XFILLER_3_441 VDD VSS sg13g2_decap_8
X_10326_ _10345_/C _14799_/Q _14800_/Q _14801_/Q _14802_/Q VDD VSS sg13g2_and4_1
XFILLER_153_998 VDD VSS sg13g2_decap_4
XFILLER_180_784 VDD VSS sg13g2_decap_8
X_14094_ _14094_/Q clkload52/A _14094_/D _14094_/RESET_B VDD VSS sg13g2_dfrbpq_1
X_13045_ _13050_/C _12842_/A _13044_/Y _12914_/C VDD VSS sg13g2_a21oi_1
X_14797__3009 _14797_/RESET_B VDD VSS sg13g2_tiehi
XFILLER_26_1103 VDD VSS sg13g2_decap_8
XFILLER_105_380 VDD VSS sg13g2_decap_8
XFILLER_117_1231 VDD VSS sg13g2_decap_4
XFILLER_140_659 VDD VSS sg13g2_decap_8
X_10257_ _10268_/D _14779_/Q _14780_/Q _14781_/Q _10258_/D VDD VSS sg13g2_and4_1
XFILLER_78_231 VDD VSS sg13g2_decap_8
Xfanout1220 _11483_/A _08235_/A0 VDD VSS sg13g2_buf_1
Xfanout1231 _11384_/A _14960_/Q VDD VSS sg13g2_buf_1
XFILLER_22_7 VDD VSS sg13g2_decap_8
Xfanout1242 _12899_/A _12866_/A VDD VSS sg13g2_buf_1
X_10188_ _14751_/D _15194_/D _14751_/Q _13501_/A VDD VSS sg13g2_mux2_1
XFILLER_66_404 VDD VSS sg13g2_decap_8
Xfanout1253 _12957_/A _14904_/Q VDD VSS sg13g2_buf_1
XFILLER_117_1297 VDD VSS sg13g2_decap_8
Xfanout1264 _10558_/C _14857_/Q VDD VSS sg13g2_buf_1
XFILLER_152_1188 VDD VSS sg13g2_decap_8
Xfanout1275 _11171_/B _11203_/A1 VDD VSS sg13g2_buf_1
XFILLER_93_234 VDD VSS sg13g2_decap_8
X_14996_ _14996_/Q _15019_/CLK _14996_/D _14996_/RESET_B VDD VSS sg13g2_dfrbpq_1
XFILLER_94_768 VDD VSS sg13g2_fill_1
XFILLER_47_640 VDD VSS sg13g2_decap_8
XFILLER_81_407 VDD VSS sg13g2_fill_2
XFILLER_93_267 VDD VSS sg13g2_fill_1
XFILLER_19_364 VDD VSS sg13g2_decap_8
X_13947_ _13947_/Q _14734_/CLK _13947_/D _13947_/RESET_B VDD VSS sg13g2_dfrbpq_1
XFILLER_75_982 VDD VSS sg13g2_decap_8
XFILLER_93_289 VDD VSS sg13g2_fill_2
XFILLER_47_695 VDD VSS sg13g2_decap_8
X_15019__2661 _15019_/RESET_B VDD VSS sg13g2_tiehi
X_13878_ _13878_/Q clkload39/A _13878_/D _13878_/RESET_B VDD VSS sg13g2_dfrbpq_1
XFILLER_50_805 VDD VSS sg13g2_fill_2
X_15140__2770 _15140_/RESET_B VDD VSS sg13g2_tiehi
XFILLER_61_142 VDD VSS sg13g2_decap_8
X_12829_ _12829_/Y _14865_/Q _12895_/B VDD VSS sg13g2_nand2_1
XFILLER_90_996 VDD VSS sg13g2_decap_4
XFILLER_76_1270 VDD VSS sg13g2_fill_1
XFILLER_61_175 VDD VSS sg13g2_decap_8
XFILLER_128_1360 VDD VSS sg13g2_decap_8
XFILLER_15_581 VDD VSS sg13g2_decap_8
X_14828__2978 _14828_/RESET_B VDD VSS sg13g2_tiehi
XFILLER_37_1243 VDD VSS sg13g2_decap_4
XFILLER_128_1371 VDD VSS sg13g2_fill_1
XFILLER_124_1235 VDD VSS sg13g2_decap_8
XFILLER_175_512 VDD VSS sg13g2_decap_8
XFILLER_50_1421 VDD VSS sg13g2_decap_8
XFILLER_163_707 VDD VSS sg13g2_decap_8
X_08020_ _08021_/A _08234_/A _08018_/X _08019_/X VDD VSS sg13g2_a21oi_1
XFILLER_159_1309 VDD VSS sg13g2_decap_8
XFILLER_175_589 VDD VSS sg13g2_decap_8
XFILLER_129_984 VDD VSS sg13g2_decap_4
XFILLER_156_770 VDD VSS sg13g2_decap_8
XFILLER_116_612 VDD VSS sg13g2_decap_8
XFILLER_156_781 VDD VSS sg13g2_fill_1
XFILLER_11_1449 VDD VSS sg13g2_decap_8
XFILLER_157_1000 VDD VSS sg13g2_decap_8
XFILLER_7_791 VDD VSS sg13g2_decap_8
XFILLER_131_604 VDD VSS sg13g2_decap_8
XFILLER_144_987 VDD VSS sg13g2_decap_8
X_09971_ _09971_/Y _10070_/A _10105_/B _10070_/C VDD VSS sg13g2_nand3_1
XFILLER_103_317 VDD VSS sg13g2_fill_2
XFILLER_83_1230 VDD VSS sg13g2_decap_8
X_08922_ _08922_/X _08921_/X _11983_/A _08931_/S VDD VSS sg13g2_mux2_1
XFILLER_112_840 VDD VSS sg13g2_decap_8
XFILLER_135_1342 VDD VSS sg13g2_decap_4
XFILLER_170_1222 VDD VSS sg13g2_fill_1
XFILLER_69_231 VDD VSS sg13g2_decap_8
XFILLER_135_1364 VDD VSS sg13g2_fill_1
X_08853_ _08853_/X _15026_/Q _10691_/S _08852_/Y VDD VSS sg13g2_a21o_1
XFILLER_170_1255 VDD VSS sg13g2_decap_8
XFILLER_97_595 VDD VSS sg13g2_decap_8
XFILLER_84_212 VDD VSS sg13g2_decap_8
XFILLER_111_383 VDD VSS sg13g2_decap_8
X_07804_ _07807_/C _07805_/B _07949_/C VDD VSS sg13g2_nand2b_1
X_08784_ _08784_/Y _13680_/Q _08801_/B VDD VSS sg13g2_nor2_1
XFILLER_85_779 VDD VSS sg13g2_decap_8
XFILLER_73_919 VDD VSS sg13g2_decap_8
X_07735_ _07744_/B _15217_/D _07735_/B _07735_/C _07735_/D VDD VSS sg13g2_or4_1
XFILLER_84_278 VDD VSS sg13g2_fill_2
XFILLER_53_621 VDD VSS sg13g2_decap_8
XFILLER_38_695 VDD VSS sg13g2_decap_8
XFILLER_26_857 VDD VSS sg13g2_decap_8
XFILLER_111_24 VDD VSS sg13g2_fill_1
X_07666_ _07708_/A _13293_/A _15055_/Q VDD VSS sg13g2_nor2_1
XFILLER_20_1280 VDD VSS sg13g2_decap_8
XFILLER_0_1352 VDD VSS sg13g2_decap_8
XFILLER_168_1195 VDD VSS sg13g2_fill_2
X_09405_ _14008_/D _10134_/A0 _14008_/Q _09405_/S VDD VSS sg13g2_mux2_1
XFILLER_80_462 VDD VSS sg13g2_decap_4
XFILLER_25_367 VDD VSS sg13g2_fill_2
XFILLER_13_518 VDD VSS sg13g2_decap_8
XFILLER_107_1400 VDD VSS sg13g2_fill_2
XFILLER_71_28 VDD VSS sg13g2_decap_8
XFILLER_52_186 VDD VSS sg13g2_decap_8
X_13778__2494 _13778_/RESET_B VDD VSS sg13g2_tiehi
X_09336_ _13943_/D _10166_/A1 _13943_/Q _09337_/S VDD VSS sg13g2_mux2_1
XFILLER_142_1313 VDD VSS sg13g2_fill_1
XFILLER_178_350 VDD VSS sg13g2_decap_8
XFILLER_90_1245 VDD VSS sg13g2_fill_1
XFILLER_181_1373 VDD VSS sg13g2_fill_2
XFILLER_90_1267 VDD VSS sg13g2_decap_8
XFILLER_16_1349 VDD VSS sg13g2_decap_8
XFILLER_21_562 VDD VSS sg13g2_fill_2
X_14729__1543 _14729_/RESET_B VDD VSS sg13g2_tiehi
XFILLER_55_1398 VDD VSS sg13g2_decap_8
XFILLER_139_759 VDD VSS sg13g2_fill_2
XFILLER_142_1357 VDD VSS sg13g2_decap_8
XFILLER_166_534 VDD VSS sg13g2_decap_8
X_09267_ _13876_/D _13876_/Q _10163_/A1 _09267_/S VDD VSS sg13g2_mux2_1
XFILLER_142_1368 VDD VSS sg13g2_fill_2
X_08218_ _08319_/A _08219_/A _13545_/A VDD VSS sg13g2_nor2_1
XFILLER_154_729 VDD VSS sg13g2_decap_8
XFILLER_181_504 VDD VSS sg13g2_decap_8
XFILLER_153_206 VDD VSS sg13g2_fill_2
X_09198_ _13814_/D _13814_/Q _10165_/A1 _09200_/S VDD VSS sg13g2_mux2_1
XFILLER_107_612 VDD VSS sg13g2_decap_8
XFILLER_88_1130 VDD VSS sg13g2_decap_8
XFILLER_5_728 VDD VSS sg13g2_decap_8
XFILLER_88_1141 VDD VSS sg13g2_fill_1
XFILLER_101_1043 VDD VSS sg13g2_decap_8
XFILLER_20_21 VDD VSS sg13g2_decap_8
X_08149_ _08149_/Y _08338_/B _08011_/X _08688_/A VDD VSS sg13g2_o21ai_1
XFILLER_4_238 VDD VSS sg13g2_decap_8
XFILLER_107_667 VDD VSS sg13g2_fill_1
XFILLER_150_902 VDD VSS sg13g2_decap_4
XFILLER_175_1133 VDD VSS sg13g2_decap_4
XFILLER_134_453 VDD VSS sg13g2_decap_8
XFILLER_101_1098 VDD VSS sg13g2_decap_8
X_11160_ _11161_/A _11150_/B _11150_/A _11159_/Y VDD VSS sg13g2_o21ai_1
XFILLER_175_1155 VDD VSS sg13g2_decap_8
XFILLER_150_935 VDD VSS sg13g2_decap_8
XFILLER_161_272 VDD VSS sg13g2_decap_8
XFILLER_20_98 VDD VSS sg13g2_decap_8
XFILLER_96_14 VDD VSS sg13g2_decap_4
X_10111_ _14689_/D _10144_/A1 _14689_/Q _10135_/S VDD VSS sg13g2_mux2_1
XFILLER_1_945 VDD VSS sg13g2_decap_8
X_11091_ _11094_/B _11091_/A _11091_/B VDD VSS sg13g2_nand2_1
XFILLER_62_1314 VDD VSS sg13g2_fill_1
XFILLER_0_455 VDD VSS sg13g2_decap_8
X_10042_ _14623_/D _10075_/A0 _14623_/Q _10063_/S VDD VSS sg13g2_mux2_1
XFILLER_62_1336 VDD VSS sg13g2_fill_1
XFILLER_121_169 VDD VSS sg13g2_decap_8
XFILLER_49_927 VDD VSS sg13g2_fill_1
XFILLER_103_884 VDD VSS sg13g2_fill_1
XFILLER_62_1358 VDD VSS sg13g2_fill_1
XFILLER_23_1309 VDD VSS sg13g2_decap_8
XFILLER_75_201 VDD VSS sg13g2_decap_8
XFILLER_29_63 VDD VSS sg13g2_decap_8
X_14850_ _14850_/Q _14876_/CLK _14850_/D _14850_/RESET_B VDD VSS sg13g2_dfrbpq_1
XFILLER_57_960 VDD VSS sg13g2_decap_8
X_13801_ _13801_/Q _14729_/CLK _13801_/D _13801_/RESET_B VDD VSS sg13g2_dfrbpq_1
XFILLER_112_1150 VDD VSS sg13g2_decap_4
XFILLER_5_1274 VDD VSS sg13g2_decap_8
XFILLER_57_971 VDD VSS sg13g2_fill_2
X_14781_ _14781_/Q clkload62/A _14781_/D _14781_/RESET_B VDD VSS sg13g2_dfrbpq_1
XFILLER_90_204 VDD VSS sg13g2_fill_2
XFILLER_16_301 VDD VSS sg13g2_decap_8
XFILLER_1_1127 VDD VSS sg13g2_decap_8
XFILLER_21_1055 VDD VSS sg13g2_fill_2
X_11993_ _11993_/X _14257_/Q _14289_/Q _14321_/Q _14353_/Q _11948_/S _11952_/C VDD
+ VSS sg13g2_mux4_1
XFILLER_56_470 VDD VSS sg13g2_fill_1
X_13732_ _13732_/Q _14503_/CLK _13732_/D _13732_/RESET_B VDD VSS sg13g2_dfrbpq_1
XFILLER_72_941 VDD VSS sg13g2_decap_8
X_10944_ _10944_/Y _10948_/C _10948_/D VDD VSS sg13g2_nor2_1
XFILLER_147_1224 VDD VSS sg13g2_decap_8
XFILLER_17_868 VDD VSS sg13g2_decap_8
XFILLER_95_1156 VDD VSS sg13g2_decap_8
XFILLER_45_62 VDD VSS sg13g2_decap_4
XFILLER_72_985 VDD VSS sg13g2_decap_8
XFILLER_71_462 VDD VSS sg13g2_decap_8
XFILLER_56_1129 VDD VSS sg13g2_decap_8
XFILLER_108_1208 VDD VSS sg13g2_fill_2
XFILLER_16_378 VDD VSS sg13g2_decap_8
X_13663_ _13663_/Q clkload73/A _13663_/D _13663_/RESET_B VDD VSS sg13g2_dfrbpq_1
XFILLER_44_687 VDD VSS sg13g2_decap_8
X_10875_ _10875_/Y _10875_/A _10875_/B VDD VSS sg13g2_nand2_1
XFILLER_32_849 VDD VSS sg13g2_decap_8
XFILLER_73_1443 VDD VSS sg13g2_decap_4
X_12614_ _12614_/X _13966_/Q _13998_/Q _14030_/Q _14062_/Q _12618_/S0 _12618_/S1 VDD
+ VSS sg13g2_mux4_1
XFILLER_160_1402 VDD VSS sg13g2_decap_8
XFILLER_73_1454 VDD VSS sg13g2_fill_1
X_13594_ _15163_/D _13593_/B _13592_/Y _13593_/Y VDD VSS sg13g2_a21oi_1
X_15082__2922 _15082_/RESET_B VDD VSS sg13g2_tiehi
XFILLER_8_511 VDD VSS sg13g2_decap_8
XFILLER_61_50 VDD VSS sg13g2_decap_8
XFILLER_40_871 VDD VSS sg13g2_fill_1
XFILLER_184_320 VDD VSS sg13g2_decap_8
X_12545_ _12545_/X _14377_/Q _14409_/Q _14473_/Q _14505_/Q _12769_/S0 _12769_/S1 VDD
+ VSS sg13g2_mux4_1
XFILLER_185_865 VDD VSS sg13g2_decap_8
XFILLER_12_595 VDD VSS sg13g2_decap_8
XFILLER_185_876 VDD VSS sg13g2_fill_1
XFILLER_157_578 VDD VSS sg13g2_decap_8
XFILLER_32_1151 VDD VSS sg13g2_fill_1
X_12476_ _12476_/X _14244_/Q _14276_/Q _14308_/Q _14340_/Q _12759_/S0 _12759_/S1 VDD
+ VSS sg13g2_mux4_1
XFILLER_8_588 VDD VSS sg13g2_decap_8
X_14215_ _14215_/Q clkload13/A _14215_/D _14215_/RESET_B VDD VSS sg13g2_dfrbpq_1
XFILLER_32_1184 VDD VSS sg13g2_decap_4
XANTENNA_5 _09573_/X VDD VSS sg13g2_antennanp
X_11427_ _11427_/X _11428_/A _13689_/Q VDD VSS sg13g2_and2_1
XFILLER_158_1320 VDD VSS sg13g2_decap_4
XFILLER_172_559 VDD VSS sg13g2_fill_2
X_15195_ _15195_/Q clkload80/A _15195_/D _15195_/RESET_B VDD VSS sg13g2_dfrbpq_1
XFILLER_6_56 VDD VSS sg13g2_decap_8
XFILLER_158_1353 VDD VSS sg13g2_decap_8
X_14146_ _14146_/Q _14656_/CLK _14146_/D _14146_/RESET_B VDD VSS sg13g2_dfrbpq_1
XFILLER_141_924 VDD VSS sg13g2_fill_2
X_11358_ _11359_/A _13726_/Q _14078_/Q _14430_/Q _14526_/Q _11418_/A _11401_/C VDD
+ VSS sg13g2_mux4_1
XFILLER_98_304 VDD VSS sg13g2_decap_8
XFILLER_140_412 VDD VSS sg13g2_decap_8
XFILLER_154_1217 VDD VSS sg13g2_fill_2
XFILLER_180_581 VDD VSS sg13g2_decap_8
X_10309_ _10312_/B _14796_/Q _10327_/B _14797_/Q VDD VSS sg13g2_a21oi_1
X_14077_ _14077_/Q clkload59/A _14077_/D _14077_/RESET_B VDD VSS sg13g2_dfrbpq_1
XFILLER_141_979 VDD VSS sg13g2_fill_1
X_14167__2105 _14167_/RESET_B VDD VSS sg13g2_tiehi
X_11289_ _11289_/Y _14895_/Q _11433_/B _11340_/A1 VDD VSS sg13g2_a21oi_1
XFILLER_100_309 VDD VSS sg13g2_decap_8
X_13028_ _13028_/Y _14877_/Q _13028_/B VDD VSS sg13g2_nand2_1
XFILLER_140_489 VDD VSS sg13g2_decap_4
Xfanout1050 _13279_/B _13310_/B2 VDD VSS sg13g2_buf_1
Xfanout1061 _09938_/B _15066_/Q VDD VSS sg13g2_buf_1
XFILLER_66_223 VDD VSS sg13g2_fill_1
Xfanout1072 _09134_/S _09072_/B VDD VSS sg13g2_buf_1
Xfanout1083 _10781_/B _15058_/Q VDD VSS sg13g2_buf_1
XFILLER_94_554 VDD VSS sg13g2_fill_1
XFILLER_55_908 VDD VSS sg13g2_decap_8
XFILLER_39_459 VDD VSS sg13g2_decap_8
Xfanout1094 _08383_/B _15004_/Q VDD VSS sg13g2_buf_1
XFILLER_82_716 VDD VSS sg13g2_decap_8
XFILLER_94_587 VDD VSS sg13g2_fill_1
XFILLER_82_727 VDD VSS sg13g2_fill_2
XFILLER_19_161 VDD VSS sg13g2_decap_8
X_14979_ _14979_/Q clkload54/A _14979_/D _14979_/RESET_B VDD VSS sg13g2_dfrbpq_1
XFILLER_35_654 VDD VSS sg13g2_decap_8
XFILLER_165_1324 VDD VSS sg13g2_decap_8
XFILLER_78_1398 VDD VSS sg13g2_decap_4
XFILLER_179_147 VDD VSS sg13g2_decap_8
XFILLER_62_484 VDD VSS sg13g2_fill_2
XFILLER_96_0 VDD VSS sg13g2_decap_8
XFILLER_124_1010 VDD VSS sg13g2_decap_8
X_14974__2706 _14974_/RESET_B VDD VSS sg13g2_tiehi
X_09121_ _10767_/B _09134_/S _15046_/Q _09120_/Y VDD VSS sg13g2_o21ai_1
XFILLER_148_545 VDD VSS sg13g2_decap_8
XFILLER_175_320 VDD VSS sg13g2_decap_8
XFILLER_148_556 VDD VSS sg13g2_fill_2
X_09052_ _13769_/D _13769_/Q _10152_/A1 _09160_/S VDD VSS sg13g2_mux2_1
XFILLER_148_589 VDD VSS sg13g2_decap_8
XFILLER_129_770 VDD VSS sg13g2_fill_1
XFILLER_159_1106 VDD VSS sg13g2_decap_8
XFILLER_15_1382 VDD VSS sg13g2_decap_8
XFILLER_159_1117 VDD VSS sg13g2_fill_2
XFILLER_163_526 VDD VSS sg13g2_fill_2
XFILLER_117_932 VDD VSS sg13g2_decap_8
XFILLER_175_397 VDD VSS sg13g2_decap_8
X_08003_ _08003_/Y _13290_/B _15131_/Q _13290_/A VDD VSS sg13g2_nand3_1
XFILLER_50_1273 VDD VSS sg13g2_decap_4
XFILLER_116_420 VDD VSS sg13g2_decap_8
XFILLER_11_1246 VDD VSS sg13g2_decap_8
XFILLER_176_1420 VDD VSS sg13g2_decap_8
XFILLER_144_740 VDD VSS sg13g2_decap_8
XFILLER_46_1309 VDD VSS sg13g2_decap_4
XFILLER_89_326 VDD VSS sg13g2_decap_8
Xmax_cap296 _09432_/S _09427_/S VDD VSS sg13g2_buf_4
XFILLER_104_659 VDD VSS sg13g2_fill_2
X_09954_ _14538_/D _14538_/Q _10086_/A0 _09961_/S VDD VSS sg13g2_mux2_1
X_08905_ _13709_/D _16871_/A _08904_/X _08938_/S VDD VSS sg13g2_mux2_1
XFILLER_112_670 VDD VSS sg13g2_decap_8
X_09885_ _14471_/D _09885_/A0 _14471_/Q _09903_/S VDD VSS sg13g2_mux2_1
XFILLER_83_1093 VDD VSS sg13g2_decap_8
XFILLER_131_1003 VDD VSS sg13g2_fill_1
XFILLER_58_735 VDD VSS sg13g2_decap_8
X_08836_ _08836_/Y _11335_/A _08850_/S VDD VSS sg13g2_nand2_1
XFILLER_170_1096 VDD VSS sg13g2_decap_8
XFILLER_79_1107 VDD VSS sg13g2_decap_8
XFILLER_22_1331 VDD VSS sg13g2_decap_8
XFILLER_73_716 VDD VSS sg13g2_decap_8
XFILLER_57_278 VDD VSS sg13g2_fill_1
XFILLER_2_1414 VDD VSS sg13g2_decap_8
X_08767_ _08767_/Y _08788_/A1 _14760_/Q _15188_/Q _07719_/X VDD VSS sg13g2_a22oi_1
XFILLER_174_7 VDD VSS sg13g2_decap_8
XFILLER_39_993 VDD VSS sg13g2_decap_8
XFILLER_26_610 VDD VSS sg13g2_decap_8
XFILLER_122_56 VDD VSS sg13g2_decap_8
XFILLER_38_492 VDD VSS sg13g2_fill_2
XFILLER_122_67 VDD VSS sg13g2_fill_1
X_07718_ _08027_/B _15102_/Q _15101_/Q _15094_/Q _15093_/Q VDD VSS sg13g2_or4_1
X_13865__2407 _13865_/RESET_B VDD VSS sg13g2_tiehi
X_08698_ _08698_/X _08698_/A _08698_/B VDD VSS sg13g2_and2_1
XFILLER_96_1465 VDD VSS sg13g2_decap_4
XFILLER_26_654 VDD VSS sg13g2_decap_8
XFILLER_122_89 VDD VSS sg13g2_decap_8
XFILLER_14_805 VDD VSS sg13g2_decap_8
XFILLER_183_1424 VDD VSS sg13g2_decap_8
X_13901__2371 _13901_/RESET_B VDD VSS sg13g2_tiehi
XFILLER_54_996 VDD VSS sg13g2_decap_8
XFILLER_15_21 VDD VSS sg13g2_decap_8
X_07649_ _07649_/Y _13345_/B VDD VSS sg13g2_inv_1
XFILLER_81_782 VDD VSS sg13g2_fill_1
XFILLER_13_315 VDD VSS sg13g2_decap_8
X_10660_ _10661_/C _14892_/Q _14891_/Q _10663_/D VDD VSS sg13g2_and3_1
XFILLER_90_1031 VDD VSS sg13g2_decap_8
XFILLER_9_308 VDD VSS sg13g2_decap_8
XFILLER_139_512 VDD VSS sg13g2_decap_8
XFILLER_41_679 VDD VSS sg13g2_decap_8
XFILLER_15_98 VDD VSS sg13g2_decap_8
XFILLER_179_692 VDD VSS sg13g2_decap_8
XFILLER_40_167 VDD VSS sg13g2_decap_8
X_09319_ _13926_/D _10149_/A1 _13926_/Q _09331_/S VDD VSS sg13g2_mux2_1
XFILLER_16_1146 VDD VSS sg13g2_decap_8
XFILLER_167_854 VDD VSS sg13g2_decap_8
X_14245__2027 _14245_/RESET_B VDD VSS sg13g2_tiehi
X_10591_ _10607_/C _14874_/Q _10649_/B _10591_/C _10591_/D VDD VSS sg13g2_and4_1
XFILLER_22_893 VDD VSS sg13g2_decap_8
XFILLER_107_1285 VDD VSS sg13g2_decap_4
XFILLER_21_392 VDD VSS sg13g2_decap_4
X_12330_ _12330_/X _14714_/Q _14746_/Q _13786_/Q _13818_/Q _12330_/S0 _12330_/S1 VDD
+ VSS sg13g2_mux4_1
XFILLER_51_1059 VDD VSS sg13g2_decap_8
XFILLER_181_301 VDD VSS sg13g2_decap_8
XFILLER_182_824 VDD VSS sg13g2_decap_8
XFILLER_33_1471 VDD VSS sg13g2_fill_1
XFILLER_31_42 VDD VSS sg13g2_decap_8
XFILLER_154_548 VDD VSS sg13g2_decap_8
XFILLER_5_525 VDD VSS sg13g2_decap_8
XFILLER_147_42 VDD VSS sg13g2_decap_8
X_12261_ _12261_/Y _12237_/Y _12239_/Y _12046_/C VDD VSS sg13g2_a21oi_1
XFILLER_108_976 VDD VSS sg13g2_decap_8
X_14000_ _14000_/Q _14513_/CLK _14000_/D _14000_/RESET_B VDD VSS sg13g2_dfrbpq_1
X_11212_ _11212_/X _14171_/Q _14203_/Q _11212_/S VDD VSS sg13g2_mux2_1
XFILLER_181_378 VDD VSS sg13g2_decap_8
XFILLER_150_710 VDD VSS sg13g2_decap_8
X_12192_ _12192_/Y _12192_/A _12192_/B VDD VSS sg13g2_nor2_1
Xoutput42 mem_axi_araddr[13] output42/A VDD VSS sg13g2_buf_1
Xoutput53 mem_axi_araddr[24] _13715_/Q VDD VSS sg13g2_buf_1
X_11143_ _11143_/Y _14952_/Q _11156_/B VDD VSS sg13g2_nand2_1
Xoutput64 mem_axi_araddr[5] output64/A VDD VSS sg13g2_buf_1
XFILLER_122_456 VDD VSS sg13g2_decap_8
XFILLER_1_742 VDD VSS sg13g2_decap_8
XFILLER_96_819 VDD VSS sg13g2_decap_8
Xoutput75 mem_axi_awaddr[14] _16867_/X VDD VSS sg13g2_buf_1
Xoutput86 mem_axi_awaddr[25] _16878_/X VDD VSS sg13g2_buf_1
XFILLER_110_618 VDD VSS sg13g2_fill_2
XFILLER_150_787 VDD VSS sg13g2_decap_8
Xoutput97 mem_axi_awaddr[6] _16859_/X VDD VSS sg13g2_buf_1
XFILLER_62_1133 VDD VSS sg13g2_decap_8
XFILLER_49_713 VDD VSS sg13g2_decap_8
XFILLER_0_252 VDD VSS sg13g2_decap_8
X_11074_ _11074_/Y _14947_/Q _11170_/B VDD VSS sg13g2_nand2_1
XFILLER_88_370 VDD VSS sg13g2_decap_8
XFILLER_76_510 VDD VSS sg13g2_decap_8
XFILLER_103_681 VDD VSS sg13g2_decap_8
Xhold3180 input13/A mem_axi_rdata[18] VDD VSS sg13g2_dlygate4sd3_1
XFILLER_23_1106 VDD VSS sg13g2_decap_8
XFILLER_27_1286 VDD VSS sg13g2_decap_8
X_14902_ _14902_/Q _15226_/CLK _14902_/D _14902_/RESET_B VDD VSS sg13g2_dfrbpq_1
Xhold3191 _13622_/A _13730_/Q VDD VSS sg13g2_dlygate4sd3_1
X_10025_ _14607_/D _10091_/A0 _14607_/Q _10036_/S VDD VSS sg13g2_mux2_1
XFILLER_7_1358 VDD VSS sg13g2_decap_8
XFILLER_110_1109 VDD VSS sg13g2_decap_4
X_14833_ _14833_/Q clkload66/A _14833_/D _14833_/RESET_B VDD VSS sg13g2_dfrbpq_1
XFILLER_36_429 VDD VSS sg13g2_decap_8
XFILLER_91_524 VDD VSS sg13g2_fill_1
XFILLER_63_215 VDD VSS sg13g2_decap_8
XFILLER_5_1071 VDD VSS sg13g2_decap_8
X_14764_ _14764_/Q _15019_/CLK _14764_/D _14764_/RESET_B VDD VSS sg13g2_dfrbpq_1
XFILLER_17_654 VDD VSS sg13g2_decap_4
X_11976_ wire244/A _11975_/Y _11965_/Y _11957_/Y _11947_/Y _12001_/A VDD VSS sg13g2_a221oi_1
X_14455__1817 _14455_/RESET_B VDD VSS sg13g2_tiehi
XFILLER_45_985 VDD VSS sg13g2_decap_8
X_13715_ _13715_/Q clkload72/A _13715_/D _13715_/RESET_B VDD VSS sg13g2_dfrbpq_1
XFILLER_186_1092 VDD VSS sg13g2_decap_8
X_10927_ _10927_/Y _10926_/C _10936_/C _11183_/B1 VDD VSS sg13g2_o21ai_1
XFILLER_16_175 VDD VSS sg13g2_decap_8
X_14695_ _14695_/Q _14741_/CLK _14695_/D _14695_/RESET_B VDD VSS sg13g2_dfrbpq_1
XFILLER_71_292 VDD VSS sg13g2_decap_8
X_13646_ _13754_/D _13646_/A VDD VSS sg13g2_buf_1
X_10858_ _10858_/Y _10843_/C _10852_/X _07751_/B VDD VSS sg13g2_o21ai_1
XFILLER_20_819 VDD VSS sg13g2_decap_8
XFILLER_34_1213 VDD VSS sg13g2_decap_8
XFILLER_158_832 VDD VSS sg13g2_decap_8
XFILLER_164_1390 VDD VSS sg13g2_decap_8
XFILLER_13_882 VDD VSS sg13g2_decap_8
X_13577_ _13577_/Y _14999_/Q _13555_/B _13569_/S _15015_/Q _13525_/X VDD VSS sg13g2_a221oi_1
XFILLER_73_1295 VDD VSS sg13g2_decap_8
X_10789_ _11185_/B _08933_/S _09155_/Y _08949_/Y VDD VSS sg13g2_o21ai_1
XFILLER_185_651 VDD VSS sg13g2_decap_8
XFILLER_12_392 VDD VSS sg13g2_decap_8
XFILLER_157_353 VDD VSS sg13g2_decap_8
X_14670__1602 _14670_/RESET_B VDD VSS sg13g2_tiehi
XFILLER_158_887 VDD VSS sg13g2_decap_8
X_12528_ _12541_/A _10213_/A _12765_/A2 _15002_/Q VDD VSS sg13g2_a21oi_1
XFILLER_9_875 VDD VSS sg13g2_decap_8
XFILLER_121_1238 VDD VSS sg13g2_decap_8
XFILLER_184_161 VDD VSS sg13g2_decap_8
XFILLER_8_385 VDD VSS sg13g2_decap_8
XFILLER_184_194 VDD VSS sg13g2_decap_8
X_15247_ _15247_/Q clkload71/A _15247_/D _15247_/RESET_B VDD VSS sg13g2_dfrbpq_1
XFILLER_172_345 VDD VSS sg13g2_decap_8
X_12459_ _12459_/X _13827_/Q _13859_/Q _13891_/Q _13923_/Q _12769_/S0 _12769_/S1 VDD
+ VSS sg13g2_mux4_1
XFILLER_160_529 VDD VSS sg13g2_decap_8
X_15178_ _15178_/Q clkload84/A _15178_/D _15178_/RESET_B VDD VSS sg13g2_dfrbpq_1
XFILLER_119_1112 VDD VSS sg13g2_decap_8
XFILLER_154_1025 VDD VSS sg13g2_decap_8
X_14129_ _14129_/Q clkload7/A _14129_/D _14129_/RESET_B VDD VSS sg13g2_dfrbpq_1
XFILLER_99_657 VDD VSS sg13g2_fill_1
XFILLER_113_445 VDD VSS sg13g2_decap_4
XFILLER_119_1156 VDD VSS sg13g2_decap_8
X_13943__2329 _13943_/RESET_B VDD VSS sg13g2_tiehi
Xfanout309 _09882_/A0 _10080_/A0 VDD VSS sg13g2_buf_1
XFILLER_98_156 VDD VSS sg13g2_fill_1
XFILLER_86_307 VDD VSS sg13g2_fill_2
XFILLER_113_478 VDD VSS sg13g2_decap_8
XFILLER_154_1069 VDD VSS sg13g2_fill_2
XFILLER_45_1353 VDD VSS sg13g2_fill_2
XFILLER_39_201 VDD VSS sg13g2_fill_2
X_15219__3080 _15219_/RESET_B VDD VSS sg13g2_tiehi
XFILLER_140_297 VDD VSS sg13g2_decap_8
XFILLER_171_1372 VDD VSS sg13g2_decap_8
XFILLER_79_381 VDD VSS sg13g2_decap_8
XFILLER_41_1206 VDD VSS sg13g2_decap_8
X_09670_ _14263_/D _09934_/A1 _14263_/Q _09670_/S VDD VSS sg13g2_mux2_1
XFILLER_11_0 VDD VSS sg13g2_decap_8
XFILLER_39_256 VDD VSS sg13g2_decap_8
X_08621_ _08622_/B _08621_/A _08621_/B _08621_/C VDD VSS sg13g2_nor3_1
X_08552_ _08553_/B _08552_/A1 _08551_/X _08547_/Y _08546_/Y VDD VSS sg13g2_a22oi_1
XFILLER_54_248 VDD VSS sg13g2_fill_2
XFILLER_165_1110 VDD VSS sg13g2_fill_1
Xclkbuf_4_12_0_clk_i clkbuf_4_12_0_clk_i/X clkbuf_0_clk_i/X VDD VSS sg13g2_buf_8
XFILLER_51_911 VDD VSS sg13g2_decap_8
X_08483_ _08501_/A _08668_/A _08150_/X _08652_/B1 VDD VSS sg13g2_o21ai_1
XFILLER_74_1026 VDD VSS sg13g2_decap_8
XFILLER_22_112 VDD VSS sg13g2_decap_8
XFILLER_50_421 VDD VSS sg13g2_decap_8
XFILLER_50_432 VDD VSS sg13g2_fill_1
XFILLER_165_1176 VDD VSS sg13g2_decap_8
XFILLER_50_443 VDD VSS sg13g2_decap_8
XFILLER_17_1411 VDD VSS sg13g2_decap_8
XFILLER_91_1340 VDD VSS sg13g2_decap_8
XFILLER_11_819 VDD VSS sg13g2_decap_8
XFILLER_52_1302 VDD VSS sg13g2_fill_1
XFILLER_23_679 VDD VSS sg13g2_fill_1
XFILLER_10_329 VDD VSS sg13g2_decap_8
XFILLER_22_189 VDD VSS sg13g2_decap_8
XFILLER_104_1414 VDD VSS sg13g2_fill_2
XFILLER_143_1463 VDD VSS sg13g2_decap_8
XFILLER_143_1474 VDD VSS sg13g2_fill_1
XFILLER_52_1357 VDD VSS sg13g2_decap_8
X_09104_ _09104_/X _13142_/A _09136_/B _09102_/Y VDD VSS sg13g2_a21o_1
XFILLER_164_813 VDD VSS sg13g2_decap_8
XFILLER_175_161 VDD VSS sg13g2_decap_8
X_14792__3014 _14792_/RESET_B VDD VSS sg13g2_tiehi
XFILLER_176_695 VDD VSS sg13g2_decap_8
XFILLER_108_228 VDD VSS sg13g2_decap_8
X_09035_ _09035_/Y _14906_/Q _09031_/C _09024_/A VDD VSS sg13g2_o21ai_1
XFILLER_164_868 VDD VSS sg13g2_decap_8
XFILLER_117_740 VDD VSS sg13g2_decap_8
XFILLER_11_1043 VDD VSS sg13g2_decap_8
XFILLER_164_879 VDD VSS sg13g2_fill_1
XFILLER_163_389 VDD VSS sg13g2_decap_8
XFILLER_144_570 VDD VSS sg13g2_fill_1
XFILLER_176_1250 VDD VSS sg13g2_decap_8
XFILLER_104_412 VDD VSS sg13g2_decap_8
XFILLER_116_272 VDD VSS sg13g2_decap_8
XFILLER_137_1212 VDD VSS sg13g2_decap_8
XFILLER_144_581 VDD VSS sg13g2_decap_8
XFILLER_85_1155 VDD VSS sg13g2_fill_1
XFILLER_2_539 VDD VSS sg13g2_decap_8
XFILLER_172_1114 VDD VSS sg13g2_decap_4
XFILLER_132_765 VDD VSS sg13g2_fill_2
X_14533__1739 _14533_/RESET_B VDD VSS sg13g2_tiehi
Xfanout810 _08329_/B _08426_/A VDD VSS sg13g2_buf_1
XFILLER_89_156 VDD VSS sg13g2_decap_8
X_13919__2353 _13919_/RESET_B VDD VSS sg13g2_tiehi
Xfanout821 _08048_/A _07626_/Y VDD VSS sg13g2_buf_1
XFILLER_77_49 VDD VSS sg13g2_decap_8
XFILLER_172_1169 VDD VSS sg13g2_decap_8
X_14679__1593 _14679_/RESET_B VDD VSS sg13g2_tiehi
Xfanout832 _10797_/C _10926_/C VDD VSS sg13g2_buf_1
X_09937_ _14522_/D _14522_/Q _10169_/A1 _09937_/S VDD VSS sg13g2_mux2_1
XFILLER_131_275 VDD VSS sg13g2_decap_8
Xfanout843 _12663_/S0 _12636_/S VDD VSS sg13g2_buf_1
Xfanout854 _12761_/S0 _12747_/S1 VDD VSS sg13g2_buf_1
Xfanout865 _12747_/S1 _15212_/Q VDD VSS sg13g2_buf_1
Xfanout876 _12674_/S1 fanout880/X VDD VSS sg13g2_buf_1
Xfanout887 _12378_/S1 _12382_/S1 VDD VSS sg13g2_buf_1
X_09868_ _14455_/D _14455_/Q _10099_/A0 _09870_/S VDD VSS sg13g2_mux2_1
XFILLER_86_863 VDD VSS sg13g2_fill_1
XFILLER_100_651 VDD VSS sg13g2_decap_8
Xfanout898 _12717_/S1 fanout899/X VDD VSS sg13g2_buf_1
X_14823__2983 _14823_/RESET_B VDD VSS sg13g2_tiehi
X_08819_ _13690_/D _08817_/Y _08816_/Y _08818_/Y VDD VSS sg13g2_a21oi_1
XFILLER_85_373 VDD VSS sg13g2_decap_8
XFILLER_100_684 VDD VSS sg13g2_fill_2
XFILLER_133_77 VDD VSS sg13g2_decap_8
XFILLER_73_524 VDD VSS sg13g2_decap_4
XFILLER_2_1211 VDD VSS sg13g2_decap_8
XFILLER_133_88 VDD VSS sg13g2_fill_2
X_09799_ _14388_/D _09799_/A0 _14388_/Q _09805_/S VDD VSS sg13g2_mux2_1
X_11830_ _11830_/Y _11806_/Y _11808_/Y _11831_/B1 VDD VSS sg13g2_a21oi_1
XFILLER_45_248 VDD VSS sg13g2_decap_4
XFILLER_26_42 VDD VSS sg13g2_decap_8
XFILLER_57_1213 VDD VSS sg13g2_decap_8
XFILLER_14_602 VDD VSS sg13g2_decap_8
XFILLER_92_1104 VDD VSS sg13g2_decap_8
XFILLER_60_207 VDD VSS sg13g2_fill_1
XFILLER_26_462 VDD VSS sg13g2_decap_8
XFILLER_2_1288 VDD VSS sg13g2_decap_8
XFILLER_109_1303 VDD VSS sg13g2_fill_2
X_11761_ _11761_/Y _11761_/A _11761_/B _11953_/C VDD VSS sg13g2_nand3_1
X_14838__2961 _14838_/RESET_B VDD VSS sg13g2_tiehi
XFILLER_109_1325 VDD VSS sg13g2_decap_8
XFILLER_13_112 VDD VSS sg13g2_decap_8
XFILLER_42_944 VDD VSS sg13g2_fill_1
X_13500_ _15128_/D _13351_/C _13502_/D _13499_/Y VDD VSS sg13g2_o21ai_1
XFILLER_92_1148 VDD VSS sg13g2_fill_1
XFILLER_42_955 VDD VSS sg13g2_decap_8
XFILLER_41_432 VDD VSS sg13g2_decap_8
XFILLER_109_1336 VDD VSS sg13g2_fill_2
XFILLER_148_1385 VDD VSS sg13g2_decap_4
X_10712_ _10954_/B _09034_/X _10788_/S _08877_/Y VDD VSS sg13g2_a21oi_1
XFILLER_42_966 VDD VSS sg13g2_fill_2
XFILLER_148_1396 VDD VSS sg13g2_fill_1
X_14480_ _14480_/Q clkload10/A _14480_/D _14480_/RESET_B VDD VSS sg13g2_dfrbpq_1
XFILLER_57_1279 VDD VSS sg13g2_decap_4
X_11692_ _11693_/B _11969_/A _14216_/Q VDD VSS sg13g2_nand2_1
XFILLER_14_679 VDD VSS sg13g2_decap_8
XFILLER_158_117 VDD VSS sg13g2_decap_8
XFILLER_186_426 VDD VSS sg13g2_decap_8
XFILLER_9_105 VDD VSS sg13g2_decap_8
XFILLER_41_465 VDD VSS sg13g2_decap_8
XFILLER_158_128 VDD VSS sg13g2_fill_1
XFILLER_186_437 VDD VSS sg13g2_decap_8
X_13431_ _13431_/Y _13455_/A _13435_/B _13444_/C VDD VSS sg13g2_nor3_1
X_10643_ _14888_/D _10655_/B _10643_/B _10643_/C VDD VSS sg13g2_nor3_1
XFILLER_13_189 VDD VSS sg13g2_decap_8
XFILLER_70_1446 VDD VSS sg13g2_decap_4
XFILLER_42_63 VDD VSS sg13g2_decap_8
X_13362_ _15073_/D _15073_/Q _13470_/A2 _13361_/Y VDD VSS sg13g2_a21o_1
XFILLER_139_375 VDD VSS sg13g2_decap_8
XFILLER_166_161 VDD VSS sg13g2_decap_8
X_10574_ _10583_/D _14870_/Q _10647_/C VDD VSS sg13g2_and2_1
XFILLER_6_812 VDD VSS sg13g2_decap_8
X_15101_ _15101_/Q _15224_/CLK _15101_/D _15101_/RESET_B VDD VSS sg13g2_dfrbpq_1
XFILLER_127_548 VDD VSS sg13g2_decap_8
X_12313_ _12313_/Y _12328_/A1 _14650_/Q VDD VSS sg13g2_nand2b_1
XFILLER_10_896 VDD VSS sg13g2_decap_8
XFILLER_5_322 VDD VSS sg13g2_decap_8
X_13293_ _13294_/C _13293_/A _13293_/B _13293_/C _13293_/D VDD VSS sg13g2_nor4_1
XFILLER_120_1260 VDD VSS sg13g2_decap_4
XFILLER_177_1036 VDD VSS sg13g2_decap_8
XFILLER_182_665 VDD VSS sg13g2_decap_8
XFILLER_108_762 VDD VSS sg13g2_decap_8
XFILLER_170_827 VDD VSS sg13g2_decap_8
X_15032_ _15032_/Q clkload74/A _15032_/D _15032_/RESET_B VDD VSS sg13g2_dfrbpq_1
X_12244_ _12244_/Y _12240_/Y _12241_/Y _12243_/Y _12242_/Y _12246_/B VDD VSS sg13g2_a221oi_1
XFILLER_6_889 VDD VSS sg13g2_decap_8
XFILLER_120_1293 VDD VSS sg13g2_decap_8
XFILLER_181_175 VDD VSS sg13g2_decap_8
XFILLER_29_1304 VDD VSS sg13g2_decap_8
XFILLER_123_721 VDD VSS sg13g2_fill_1
XFILLER_5_399 VDD VSS sg13g2_decap_8
X_12175_ _12175_/Y _12243_/A1 _14390_/Q VDD VSS sg13g2_nand2b_1
XFILLER_123_776 VDD VSS sg13g2_decap_8
XFILLER_174_84 VDD VSS sg13g2_decap_8
XFILLER_29_1359 VDD VSS sg13g2_decap_8
XFILLER_122_253 VDD VSS sg13g2_decap_4
XFILLER_3_35 VDD VSS sg13g2_decap_8
XFILLER_116_1329 VDD VSS sg13g2_decap_8
X_11126_ _11146_/A _11172_/A _11147_/A VDD VSS sg13g2_xnor2_1
X_14509__1763 _14509_/RESET_B VDD VSS sg13g2_tiehi
Xclkbuf_leaf_110_clk_i _14734_/CLK clkload3/A VDD VSS sg13g2_buf_8
XFILLER_110_426 VDD VSS sg13g2_fill_1
XFILLER_96_649 VDD VSS sg13g2_decap_8
XFILLER_110_437 VDD VSS sg13g2_decap_8
X_11057_ _14945_/D _11056_/Y _11055_/Y _11048_/Y VDD VSS sg13g2_o21ai_1
XFILLER_7_1155 VDD VSS sg13g2_decap_8
XFILLER_27_1083 VDD VSS sg13g2_decap_8
XFILLER_153_1091 VDD VSS sg13g2_decap_8
XFILLER_3_1008 VDD VSS sg13g2_decap_8
XFILLER_92_811 VDD VSS sg13g2_decap_8
X_10008_ _14590_/D _10041_/A0 _14590_/Q _10030_/S VDD VSS sg13g2_mux2_1
XFILLER_37_727 VDD VSS sg13g2_decap_8
XFILLER_64_524 VDD VSS sg13g2_fill_2
XFILLER_92_844 VDD VSS sg13g2_decap_8
XFILLER_97_1048 VDD VSS sg13g2_decap_8
X_14816_ _14816_/Q _14886_/CLK _14816_/D _14816_/RESET_B VDD VSS sg13g2_dfrbpq_1
Xclkbuf_leaf_125_clk_i clkload21/A clkload1/A VDD VSS sg13g2_buf_8
XFILLER_79_1460 VDD VSS sg13g2_decap_8
XFILLER_184_1029 VDD VSS sg13g2_fill_1
XFILLER_51_207 VDD VSS sg13g2_decap_4
XFILLER_33_911 VDD VSS sg13g2_decap_8
XFILLER_17_462 VDD VSS sg13g2_decap_8
XFILLER_127_1403 VDD VSS sg13g2_decap_8
X_14747_ _14747_/Q clkload90/A _14747_/D _14747_/RESET_B VDD VSS sg13g2_dfrbpq_1
X_11959_ _11959_/Y _11738_/S _14416_/Q _11963_/S1 VDD VSS sg13g2_a21oi_1
XFILLER_75_1335 VDD VSS sg13g2_decap_8
XFILLER_83_92 VDD VSS sg13g2_decap_8
XFILLER_162_1305 VDD VSS sg13g2_fill_1
XFILLER_162_1327 VDD VSS sg13g2_fill_1
XFILLER_33_966 VDD VSS sg13g2_decap_4
XFILLER_127_1447 VDD VSS sg13g2_fill_2
X_14678_ _14678_/Q clkload41/A _14678_/D _14678_/RESET_B VDD VSS sg13g2_dfrbpq_1
XFILLER_149_117 VDD VSS sg13g2_decap_8
XFILLER_20_605 VDD VSS sg13g2_decap_8
XFILLER_177_448 VDD VSS sg13g2_decap_8
X_13629_ _13737_/D _13629_/A VDD VSS sg13g2_buf_1
XFILLER_32_487 VDD VSS sg13g2_decap_8
XFILLER_158_640 VDD VSS sg13g2_decap_8
XFILLER_160_1040 VDD VSS sg13g2_fill_1
XFILLER_118_515 VDD VSS sg13g2_decap_8
XFILLER_146_835 VDD VSS sg13g2_decap_8
XFILLER_9_672 VDD VSS sg13g2_decap_8
XFILLER_173_621 VDD VSS sg13g2_decap_8
XFILLER_12_1330 VDD VSS sg13g2_decap_8
XFILLER_145_334 VDD VSS sg13g2_decap_8
XFILLER_8_182 VDD VSS sg13g2_decap_8
X_14891__2855 _14891_/RESET_B VDD VSS sg13g2_tiehi
XFILLER_105_209 VDD VSS sg13g2_fill_1
XFILLER_59_0 VDD VSS sg13g2_decap_8
XFILLER_172_175 VDD VSS sg13g2_decap_8
XFILLER_86_1453 VDD VSS sg13g2_fill_1
XFILLER_99_421 VDD VSS sg13g2_decap_8
XFILLER_114_743 VDD VSS sg13g2_fill_2
XFILLER_160_348 VDD VSS sg13g2_decap_8
XFILLER_160_359 VDD VSS sg13g2_fill_1
XFILLER_173_1456 VDD VSS sg13g2_fill_1
XFILLER_82_1339 VDD VSS sg13g2_decap_8
XFILLER_59_307 VDD VSS sg13g2_decap_8
X_07983_ _07985_/C _07978_/Y _15077_/Q _07908_/B VDD VSS sg13g2_a21oi_1
XFILLER_99_498 VDD VSS sg13g2_decap_8
XFILLER_87_649 VDD VSS sg13g2_decap_8
X_09722_ _14313_/D _10152_/A1 _14313_/Q _09738_/S VDD VSS sg13g2_mux2_1
XFILLER_41_1014 VDD VSS sg13g2_decap_4
XFILLER_171_1180 VDD VSS sg13g2_fill_2
XFILLER_80_1096 VDD VSS sg13g2_decap_8
X_09653_ _14246_/D _09917_/A1 _14246_/Q _09665_/S VDD VSS sg13g2_mux2_1
XFILLER_28_738 VDD VSS sg13g2_decap_8
XFILLER_103_14 VDD VSS sg13g2_fill_1
XFILLER_23_1470 VDD VSS sg13g2_decap_8
XFILLER_167_1216 VDD VSS sg13g2_decap_8
X_08604_ _08605_/B _08653_/A _07855_/B _08522_/C _08643_/D VDD VSS sg13g2_a22oi_1
XFILLER_94_192 VDD VSS sg13g2_decap_4
XFILLER_167_1227 VDD VSS sg13g2_fill_2
X_09584_ _14181_/D _14181_/Q _09916_/A1 _09596_/S VDD VSS sg13g2_mux2_1
XFILLER_55_579 VDD VSS sg13g2_decap_8
XFILLER_103_69 VDD VSS sg13g2_decap_8
XFILLER_93_1413 VDD VSS sg13g2_fill_1
XFILLER_70_516 VDD VSS sg13g2_decap_8
X_08535_ _15240_/D _08535_/A _08535_/B VDD VSS sg13g2_nand2_1
XFILLER_24_933 VDD VSS sg13g2_fill_1
XFILLER_24_944 VDD VSS sg13g2_decap_8
XFILLER_93_1457 VDD VSS sg13g2_decap_8
XFILLER_169_938 VDD VSS sg13g2_decap_8
X_08466_ _08617_/B _08376_/X _08465_/X _08597_/B VDD VSS sg13g2_mux2_1
XFILLER_11_616 VDD VSS sg13g2_decap_8
XFILLER_180_1449 VDD VSS sg13g2_fill_1
X_08397_ _08397_/Y _08397_/A _08397_/B VDD VSS sg13g2_nor2_1
XFILLER_10_126 VDD VSS sg13g2_decap_8
XFILLER_137_7 VDD VSS sg13g2_fill_2
XFILLER_149_651 VDD VSS sg13g2_decap_8
XFILLER_91_1192 VDD VSS sg13g2_fill_2
XFILLER_7_609 VDD VSS sg13g2_decap_8
XFILLER_52_1154 VDD VSS sg13g2_decap_8
XFILLER_17_1285 VDD VSS sg13g2_decap_8
XFILLER_137_835 VDD VSS sg13g2_decap_8
XFILLER_13_1127 VDD VSS sg13g2_decap_8
XFILLER_6_119 VDD VSS sg13g2_decap_8
X_14162__2110 _14162_/RESET_B VDD VSS sg13g2_tiehi
XFILLER_178_1323 VDD VSS sg13g2_decap_8
XFILLER_30_1430 VDD VSS sg13g2_decap_8
XFILLER_164_654 VDD VSS sg13g2_fill_1
XFILLER_12_77 VDD VSS sg13g2_decap_8
XFILLER_152_827 VDD VSS sg13g2_fill_1
X_09018_ _09019_/B _10702_/A wire584/X _09017_/Y VDD VSS sg13g2_o21ai_1
XFILLER_136_389 VDD VSS sg13g2_decap_8
X_10290_ _10292_/B _10281_/D _10298_/D _14791_/Q VDD VSS sg13g2_a21oi_1
XFILLER_3_826 VDD VSS sg13g2_decap_8
XFILLER_105_732 VDD VSS sg13g2_decap_8
X_14756__3053 _14756_/RESET_B VDD VSS sg13g2_tiehi
XFILLER_2_336 VDD VSS sg13g2_decap_8
XFILLER_78_605 VDD VSS sg13g2_decap_8
XFILLER_144_21 VDD VSS sg13g2_decap_8
XFILLER_132_573 VDD VSS sg13g2_decap_8
XFILLER_160_882 VDD VSS sg13g2_decap_8
XFILLER_160_893 VDD VSS sg13g2_fill_1
XFILLER_144_54 VDD VSS sg13g2_decap_8
X_14195__2077 _14195_/RESET_B VDD VSS sg13g2_tiehi
Xfanout640 _11170_/B _10670_/Y VDD VSS sg13g2_buf_1
XFILLER_8_1442 VDD VSS sg13g2_decap_8
Xfanout651 _09137_/A _08966_/Y VDD VSS sg13g2_buf_1
Xfanout662 _10743_/S _08837_/X VDD VSS sg13g2_buf_1
X_13980_ _13980_/Q _14620_/CLK _13980_/D _13980_/RESET_B VDD VSS sg13g2_dfrbpq_1
XFILLER_59_863 VDD VSS sg13g2_decap_8
Xfanout673 _08834_/B _13508_/C VDD VSS sg13g2_buf_1
XFILLER_115_1362 VDD VSS sg13g2_fill_2
Xfanout684 _08238_/B _08221_/A2 VDD VSS sg13g2_buf_1
XFILLER_59_874 VDD VSS sg13g2_fill_2
Xclkbuf_leaf_42_clk_i _14656_/CLK clkbuf_leaf_47_clk_i/A VDD VSS sg13g2_buf_8
Xfanout695 _08623_/A2 _07993_/Y VDD VSS sg13g2_buf_1
XFILLER_59_885 VDD VSS sg13g2_decap_8
XFILLER_101_982 VDD VSS sg13g2_decap_8
XFILLER_115_1384 VDD VSS sg13g2_fill_2
X_12931_ _12931_/Y _14775_/Q _13236_/A2 _13236_/B1 VDD VSS sg13g2_o21ai_1
XFILLER_74_822 VDD VSS sg13g2_decap_8
XFILLER_24_1267 VDD VSS sg13g2_decap_8
XFILLER_111_1226 VDD VSS sg13g2_decap_8
XFILLER_98_1335 VDD VSS sg13g2_decap_8
XFILLER_86_693 VDD VSS sg13g2_fill_2
XFILLER_58_384 VDD VSS sg13g2_decap_8
XFILLER_73_321 VDD VSS sg13g2_decap_8
XFILLER_185_1305 VDD VSS sg13g2_decap_4
XFILLER_59_1308 VDD VSS sg13g2_fill_2
XFILLER_37_63 VDD VSS sg13g2_decap_8
XFILLER_160_42 VDD VSS sg13g2_decap_8
XFILLER_18_259 VDD VSS sg13g2_decap_8
X_12862_ _12862_/Y _14867_/Q _12895_/B VDD VSS sg13g2_nand2_1
XFILLER_163_0 VDD VSS sg13g2_decap_8
X_14601_ _14601_/Q _14729_/CLK _14601_/D _14601_/RESET_B VDD VSS sg13g2_dfrbpq_1
X_11813_ _11813_/Y _11809_/Y _11810_/Y _11812_/Y _11811_/Y _12317_/B VDD VSS sg13g2_a221oi_1
XFILLER_73_398 VDD VSS sg13g2_decap_8
XFILLER_2_1085 VDD VSS sg13g2_decap_8
XFILLER_27_782 VDD VSS sg13g2_decap_8
XFILLER_109_1100 VDD VSS sg13g2_decap_8
X_12793_ _12793_/Y _12997_/B _12936_/B VDD VSS sg13g2_nor2_1
XFILLER_96_1081 VDD VSS sg13g2_decap_8
XFILLER_27_793 VDD VSS sg13g2_fill_1
Xclkbuf_leaf_57_clk_i clkload76/A clkbuf_leaf_59_clk_i/A VDD VSS sg13g2_buf_8
XFILLER_15_955 VDD VSS sg13g2_decap_8
XFILLER_42_741 VDD VSS sg13g2_decap_8
X_14532_ _14532_/Q clkload32/A _14532_/D _14532_/RESET_B VDD VSS sg13g2_dfrbpq_1
XFILLER_18_1016 VDD VSS sg13g2_fill_1
X_14372__1900 _14372_/RESET_B VDD VSS sg13g2_tiehi
X_11744_ _11745_/A _13738_/Q _14090_/Q _14442_/Q _14538_/Q _11738_/S _11963_/S1 VDD
+ VSS sg13g2_mux4_1
XFILLER_41_240 VDD VSS sg13g2_decap_8
XFILLER_14_476 VDD VSS sg13g2_decap_8
XFILLER_159_437 VDD VSS sg13g2_decap_8
XFILLER_109_1166 VDD VSS sg13g2_decap_8
X_14463_ _14463_/Q clkload50/A _14463_/D _14463_/RESET_B VDD VSS sg13g2_dfrbpq_1
XFILLER_53_95 VDD VSS sg13g2_decap_8
XFILLER_35_1330 VDD VSS sg13g2_decap_8
XFILLER_144_1068 VDD VSS sg13g2_decap_8
X_11675_ _11675_/Y _12033_/A1 _14632_/Q VDD VSS sg13g2_nand2b_1
XFILLER_70_1221 VDD VSS sg13g2_decap_8
XFILLER_169_84 VDD VSS sg13g2_decap_8
X_13414_ _13414_/Y _13414_/A _13494_/B _13435_/B VDD VSS sg13g2_nor3_1
XFILLER_174_429 VDD VSS sg13g2_decap_8
XFILLER_179_1109 VDD VSS sg13g2_decap_8
X_10626_ _14883_/D _10626_/A _10626_/B _10626_/C VDD VSS sg13g2_and3_1
X_14394_ _14394_/Q clkload53/A _14394_/D _14394_/RESET_B VDD VSS sg13g2_dfrbpq_1
XFILLER_31_1216 VDD VSS sg13g2_fill_1
XFILLER_122_1355 VDD VSS sg13g2_decap_8
XFILLER_128_846 VDD VSS sg13g2_decap_4
XFILLER_183_941 VDD VSS sg13g2_fill_2
XFILLER_31_1249 VDD VSS sg13g2_fill_2
X_13345_ _13345_/Y _13480_/S _13345_/B VDD VSS sg13g2_nand2_1
XFILLER_10_693 VDD VSS sg13g2_decap_8
X_10557_ _14867_/D _10557_/A _10557_/B _13499_/B VDD VSS sg13g2_and3_1
XFILLER_127_356 VDD VSS sg13g2_decap_8
XFILLER_182_462 VDD VSS sg13g2_decap_8
XFILLER_115_529 VDD VSS sg13g2_decap_8
XFILLER_143_838 VDD VSS sg13g2_decap_8
X_13276_ _13276_/Y _13273_/Y _13274_/Y _13275_/Y VDD VSS sg13g2_a21oi_1
XFILLER_6_686 VDD VSS sg13g2_decap_8
XFILLER_52_7 VDD VSS sg13g2_decap_4
X_10488_ _10490_/B _10492_/C _10508_/C _14850_/Q VDD VSS sg13g2_a21oi_1
XFILLER_108_581 VDD VSS sg13g2_decap_8
X_15015_ _15015_/Q clkload42/A _15015_/D _15015_/RESET_B VDD VSS sg13g2_dfrbpq_1
X_12227_ _12270_/A _12229_/A _12227_/B VDD VSS sg13g2_nor2_1
XFILLER_5_196 VDD VSS sg13g2_decap_8
XFILLER_97_903 VDD VSS sg13g2_decap_8
XFILLER_68_1183 VDD VSS sg13g2_decap_8
XFILLER_29_1134 VDD VSS sg13g2_decap_4
XFILLER_151_860 VDD VSS sg13g2_fill_2
XFILLER_64_1025 VDD VSS sg13g2_decap_8
XFILLER_116_1115 VDD VSS sg13g2_decap_8
XFILLER_68_104 VDD VSS sg13g2_decap_8
X_12158_ _12158_/Y _12186_/A _14166_/Q _12187_/C VDD VSS sg13g2_a21oi_1
XFILLER_9_1239 VDD VSS sg13g2_decap_8
XFILLER_25_1009 VDD VSS sg13g2_decap_8
XFILLER_78_81 VDD VSS sg13g2_decap_8
XFILLER_111_746 VDD VSS sg13g2_decap_8
X_14025__2247 _14025_/RESET_B VDD VSS sg13g2_tiehi
X_13860__2412 _13860_/RESET_B VDD VSS sg13g2_tiehi
X_11109_ _11109_/Y _11109_/A _11109_/B VDD VSS sg13g2_nand2_1
XFILLER_84_608 VDD VSS sg13g2_fill_2
XFILLER_111_779 VDD VSS sg13g2_decap_8
X_12089_ _12091_/A _12090_/A _14196_/Q VDD VSS sg13g2_nand2b_1
XFILLER_81_1383 VDD VSS sg13g2_decap_8
XFILLER_42_1356 VDD VSS sg13g2_decap_8
XFILLER_37_513 VDD VSS sg13g2_decap_8
XFILLER_92_641 VDD VSS sg13g2_decap_8
XFILLER_65_888 VDD VSS sg13g2_decap_4
X_14240__2032 _14240_/RESET_B VDD VSS sg13g2_tiehi
XFILLER_40_1091 VDD VSS sg13g2_decap_8
XFILLER_18_782 VDD VSS sg13g2_fill_1
X_13893__2379 _13893_/RESET_B VDD VSS sg13g2_tiehi
XFILLER_80_858 VDD VSS sg13g2_decap_8
X_08320_ _08366_/D _08420_/A _08418_/A VDD VSS sg13g2_nor2b_1
XFILLER_127_1233 VDD VSS sg13g2_fill_2
XFILLER_178_724 VDD VSS sg13g2_decap_8
XFILLER_127_1244 VDD VSS sg13g2_fill_2
XFILLER_21_925 VDD VSS sg13g2_decap_8
XFILLER_33_785 VDD VSS sg13g2_decap_4
X_08251_ _15226_/D _08039_/A _08250_/X _08246_/Y VDD VSS sg13g2_o21ai_1
XFILLER_177_245 VDD VSS sg13g2_decap_8
XFILLER_32_284 VDD VSS sg13g2_decap_8
XFILLER_20_435 VDD VSS sg13g2_decap_8
XFILLER_21_969 VDD VSS sg13g2_decap_8
XFILLER_14_1414 VDD VSS sg13g2_decap_8
XFILLER_53_1474 VDD VSS sg13g2_decap_4
XFILLER_158_470 VDD VSS sg13g2_decap_8
X_08182_ _08188_/C _08183_/B _08182_/B _08182_/C VDD VSS sg13g2_nor3_1
XFILLER_118_312 VDD VSS sg13g2_fill_1
XFILLER_146_621 VDD VSS sg13g2_decap_8
XFILLER_158_481 VDD VSS sg13g2_fill_1
XFILLER_174_930 VDD VSS sg13g2_decap_8
XFILLER_119_879 VDD VSS sg13g2_decap_8
XFILLER_106_507 VDD VSS sg13g2_decap_8
XFILLER_134_816 VDD VSS sg13g2_decap_8
XFILLER_134_827 VDD VSS sg13g2_fill_1
XFILLER_133_326 VDD VSS sg13g2_decap_8
XFILLER_160_112 VDD VSS sg13g2_decap_8
XFILLER_161_657 VDD VSS sg13g2_fill_1
XFILLER_114_540 VDD VSS sg13g2_decap_4
XFILLER_88_925 VDD VSS sg13g2_decap_8
XFILLER_114_573 VDD VSS sg13g2_decap_8
XFILLER_82_1136 VDD VSS sg13g2_decap_8
XFILLER_160_189 VDD VSS sg13g2_decap_8
XFILLER_99_284 VDD VSS sg13g2_decap_8
XFILLER_43_1109 VDD VSS sg13g2_decap_8
XFILLER_101_212 VDD VSS sg13g2_decap_8
XFILLER_101_223 VDD VSS sg13g2_fill_2
XFILLER_59_137 VDD VSS sg13g2_decap_8
XFILLER_47_1289 VDD VSS sg13g2_decap_8
X_14450__1822 _14450_/RESET_B VDD VSS sg13g2_tiehi
X_07966_ _07966_/Y _15015_/Q _07853_/B VDD VSS sg13g2_nor2b_1
XFILLER_75_608 VDD VSS sg13g2_decap_8
XFILLER_60_1423 VDD VSS sg13g2_decap_8
XFILLER_60_1434 VDD VSS sg13g2_fill_2
X_09705_ _14297_/D _09936_/A1 _14297_/Q _09705_/S VDD VSS sg13g2_mux2_1
XFILLER_28_524 VDD VSS sg13g2_decap_8
X_07897_ _08037_/B _08023_/A _07903_/B VDD VSS sg13g2_nand2_1
X_09636_ _14232_/D _09770_/A1 _14232_/Q _09636_/S VDD VSS sg13g2_mux2_1
XFILLER_28_579 VDD VSS sg13g2_decap_8
XFILLER_167_1035 VDD VSS sg13g2_fill_1
XFILLER_3_1372 VDD VSS sg13g2_decap_8
XFILLER_167_1046 VDD VSS sg13g2_decap_4
XFILLER_82_173 VDD VSS sg13g2_fill_2
XFILLER_70_313 VDD VSS sg13g2_fill_1
XFILLER_167_1057 VDD VSS sg13g2_decap_8
X_09567_ _14165_/D _10097_/A0 _14165_/Q _09567_/S VDD VSS sg13g2_mux2_1
XFILLER_55_398 VDD VSS sg13g2_decap_8
X_13723__2549 _13723_/RESET_B VDD VSS sg13g2_tiehi
X_14483__1789 _14483_/RESET_B VDD VSS sg13g2_tiehi
XFILLER_93_1232 VDD VSS sg13g2_decap_8
XFILLER_145_1311 VDD VSS sg13g2_decap_8
X_08518_ _08526_/C _08668_/A _08197_/X _08652_/B1 VDD VSS sg13g2_o21ai_1
XFILLER_12_903 VDD VSS sg13g2_decap_8
XFILLER_130_78 VDD VSS sg13g2_decap_8
XFILLER_180_1213 VDD VSS sg13g2_decap_8
XFILLER_19_1336 VDD VSS sg13g2_decap_8
X_09498_ _14098_/D _10161_/A1 _14098_/Q _09500_/S VDD VSS sg13g2_mux2_1
XFILLER_54_1227 VDD VSS sg13g2_decap_8
XFILLER_24_774 VDD VSS sg13g2_fill_1
XFILLER_11_413 VDD VSS sg13g2_decap_8
XFILLER_157_908 VDD VSS sg13g2_fill_2
X_08449_ _08449_/Y _08448_/Y _07948_/A _08667_/A1 VDD VSS sg13g2_a21oi_1
XFILLER_23_21 VDD VSS sg13g2_decap_8
XFILLER_106_1339 VDD VSS sg13g2_decap_8
XFILLER_168_256 VDD VSS sg13g2_fill_1
XFILLER_145_1399 VDD VSS sg13g2_decap_8
XFILLER_139_21 VDD VSS sg13g2_decap_8
XFILLER_156_418 VDD VSS sg13g2_decap_8
XFILLER_168_278 VDD VSS sg13g2_decap_8
XFILLER_7_406 VDD VSS sg13g2_decap_8
XFILLER_184_738 VDD VSS sg13g2_decap_8
X_11460_ _14962_/D _07909_/B _11501_/A2 _11459_/Y VDD VSS sg13g2_a21oi_1
XFILLER_17_1082 VDD VSS sg13g2_decap_8
X_14103__2169 _14103_/RESET_B VDD VSS sg13g2_tiehi
Xwire348 wire348/X wire348/A VDD VSS sg13g2_buf_1
XFILLER_137_643 VDD VSS sg13g2_decap_8
XFILLER_165_952 VDD VSS sg13g2_fill_2
X_10411_ _14826_/D _10413_/B _10414_/D _10407_/Y _07648_/Y _10655_/B VDD VSS sg13g2_a221oi_1
XFILLER_99_14 VDD VSS sg13g2_decap_4
XFILLER_23_98 VDD VSS sg13g2_decap_8
XFILLER_165_963 VDD VSS sg13g2_fill_2
XFILLER_183_259 VDD VSS sg13g2_decap_8
X_11391_ _11391_/Y _11391_/A _11805_/C VDD VSS sg13g2_nand2_1
XFILLER_109_356 VDD VSS sg13g2_decap_8
XFILLER_139_98 VDD VSS sg13g2_decap_8
XFILLER_104_1085 VDD VSS sg13g2_decap_8
XFILLER_165_985 VDD VSS sg13g2_decap_8
XFILLER_178_1153 VDD VSS sg13g2_decap_8
X_13130_ _13170_/B _14915_/Q _13672_/Q VDD VSS sg13g2_xnor2_1
XFILLER_99_58 VDD VSS sg13g2_decap_8
XFILLER_139_1115 VDD VSS sg13g2_fill_1
X_10342_ _10343_/B _10342_/A _14807_/Q _10342_/C _10357_/D VDD VSS sg13g2_nand4_1
XFILLER_164_484 VDD VSS sg13g2_fill_1
XFILLER_174_1006 VDD VSS sg13g2_fill_1
XFILLER_180_933 VDD VSS sg13g2_decap_8
XFILLER_3_623 VDD VSS sg13g2_decap_8
XFILLER_155_42 VDD VSS sg13g2_decap_8
XFILLER_180_977 VDD VSS sg13g2_decap_8
X_13061_ _13063_/B _13026_/A _13058_/B _13060_/Y VDD VSS sg13g2_a21oi_1
X_10273_ _14785_/D _10299_/A _10299_/B _10271_/Y VDD VSS sg13g2_a21oi_1
XFILLER_2_133 VDD VSS sg13g2_decap_8
X_12012_ _12012_/X _12012_/A _12055_/D VDD VSS sg13g2_and2_1
XFILLER_78_413 VDD VSS sg13g2_decap_8
XFILLER_105_584 VDD VSS sg13g2_fill_2
Xfanout1402 _11759_/A _12035_/S0 VDD VSS sg13g2_buf_1
Xfanout1413 _11410_/A1 _11412_/S0 VDD VSS sg13g2_buf_1
Xfanout1424 _11320_/S0 fanout1429/X VDD VSS sg13g2_buf_1
XFILLER_78_446 VDD VSS sg13g2_decap_8
XFILLER_117_1468 VDD VSS sg13g2_fill_2
Xfanout1435 _11218_/S _11277_/S VDD VSS sg13g2_buf_1
XFILLER_120_554 VDD VSS sg13g2_decap_8
XFILLER_152_1359 VDD VSS sg13g2_fill_1
Xfanout1446 _12238_/S0 _12245_/S0 VDD VSS sg13g2_buf_1
Xfanout1457 _11489_/S0 _11444_/S0 VDD VSS sg13g2_buf_1
XFILLER_93_405 VDD VSS sg13g2_decap_8
Xfanout1468 _10655_/B _10347_/B VDD VSS sg13g2_buf_1
XFILLER_47_800 VDD VSS sg13g2_decap_8
Xfanout481 _09800_/S _09804_/S VDD VSS sg13g2_buf_1
XFILLER_87_980 VDD VSS sg13g2_decap_4
XFILLER_63_1091 VDD VSS sg13g2_decap_8
Xfanout1479 _13281_/B _13507_/A VDD VSS sg13g2_buf_1
XFILLER_65_118 VDD VSS sg13g2_decap_8
XFILLER_48_84 VDD VSS sg13g2_decap_8
XFILLER_115_1170 VDD VSS sg13g2_decap_8
XFILLER_171_63 VDD VSS sg13g2_decap_8
Xfanout492 _09570_/S wire495/A VDD VSS sg13g2_buf_1
XFILLER_98_1110 VDD VSS sg13g2_decap_8
XFILLER_48_95 VDD VSS sg13g2_fill_2
X_13963_ _13963_/Q clkload11/A _13963_/D _13963_/RESET_B VDD VSS sg13g2_dfrbpq_1
XFILLER_0_14 VDD VSS sg13g2_decap_8
XFILLER_150_1083 VDD VSS sg13g2_decap_4
XFILLER_47_855 VDD VSS sg13g2_decap_8
XFILLER_19_557 VDD VSS sg13g2_decap_8
X_12914_ _12914_/Y _12914_/A _12914_/B _12914_/C VDD VSS sg13g2_nor3_1
XFILLER_4_1169 VDD VSS sg13g2_decap_8
X_13894_ _13894_/Q _14726_/CLK _13894_/D _13894_/RESET_B VDD VSS sg13g2_dfrbpq_1
XFILLER_185_1124 VDD VSS sg13g2_decap_8
XFILLER_46_365 VDD VSS sg13g2_decap_8
XFILLER_94_1018 VDD VSS sg13g2_fill_1
XFILLER_111_1089 VDD VSS sg13g2_fill_1
XFILLER_59_1149 VDD VSS sg13g2_decap_8
X_12845_ _12845_/Y _12845_/A _12845_/B _12845_/C _12845_/D VDD VSS sg13g2_nand4_1
XFILLER_146_1119 VDD VSS sg13g2_decap_8
XFILLER_73_195 VDD VSS sg13g2_decap_8
X_14313__1959 _14313_/RESET_B VDD VSS sg13g2_tiehi
XFILLER_61_346 VDD VSS sg13g2_fill_1
XFILLER_163_1411 VDD VSS sg13g2_decap_4
XFILLER_61_368 VDD VSS sg13g2_fill_1
XFILLER_37_1425 VDD VSS sg13g2_decap_8
XFILLER_15_763 VDD VSS sg13g2_decap_8
X_12776_ _12776_/X _12774_/X _12775_/X _12776_/S VDD VSS sg13g2_mux2_1
XFILLER_37_1458 VDD VSS sg13g2_decap_8
XFILLER_14_273 VDD VSS sg13g2_decap_8
X_14515_ _14515_/Q _14739_/CLK _14515_/D _14515_/RESET_B VDD VSS sg13g2_dfrbpq_1
X_11727_ _11728_/B _11707_/A _11773_/C _11705_/Y VDD VSS sg13g2_o21ai_1
XFILLER_9_56 VDD VSS sg13g2_decap_8
XFILLER_175_705 VDD VSS sg13g2_decap_8
XFILLER_175_738 VDD VSS sg13g2_decap_8
X_14446_ _14446_/Q clkload52/A _14446_/D _14446_/RESET_B VDD VSS sg13g2_dfrbpq_1
X_11658_ _14969_/D _11635_/A _12271_/A _11657_/Y VDD VSS sg13g2_a21o_1
XFILLER_30_777 VDD VSS sg13g2_decap_8
XFILLER_156_930 VDD VSS sg13g2_decap_8
XFILLER_168_790 VDD VSS sg13g2_decap_8
XFILLER_175_749 VDD VSS sg13g2_fill_1
XFILLER_11_980 VDD VSS sg13g2_decap_8
XFILLER_127_120 VDD VSS sg13g2_decap_8
X_10609_ _10611_/C _14879_/Q _10614_/A VDD VSS sg13g2_nand2b_1
XFILLER_70_1084 VDD VSS sg13g2_decap_8
XFILLER_174_259 VDD VSS sg13g2_decap_8
X_14377_ _14377_/Q clkload30/A _14377_/D _14377_/RESET_B VDD VSS sg13g2_dfrbpq_1
X_11589_ _11632_/A _11591_/A _12227_/B VDD VSS sg13g2_nor2_1
XFILLER_10_490 VDD VSS sg13g2_decap_8
XFILLER_7_973 VDD VSS sg13g2_decap_8
XFILLER_171_922 VDD VSS sg13g2_decap_8
X_13328_ _15067_/D _13328_/A _13328_/B VDD VSS sg13g2_nor2_1
XFILLER_115_315 VDD VSS sg13g2_decap_8
XFILLER_127_175 VDD VSS sg13g2_decap_4
XFILLER_171_933 VDD VSS sg13g2_fill_2
XFILLER_143_635 VDD VSS sg13g2_decap_8
XFILLER_155_495 VDD VSS sg13g2_decap_8
XFILLER_157_1226 VDD VSS sg13g2_decap_8
XFILLER_6_483 VDD VSS sg13g2_decap_8
XFILLER_171_966 VDD VSS sg13g2_decap_8
XFILLER_142_134 VDD VSS sg13g2_decap_8
XFILLER_170_454 VDD VSS sg13g2_decap_8
X_13259_ _13259_/Y _13259_/A _13259_/B VDD VSS sg13g2_xnor2_1
XFILLER_130_307 VDD VSS sg13g2_decap_8
XFILLER_171_999 VDD VSS sg13g2_decap_8
X_14258__2014 _14258_/RESET_B VDD VSS sg13g2_tiehi
XFILLER_97_711 VDD VSS sg13g2_decap_8
XFILLER_97_722 VDD VSS sg13g2_fill_1
XFILLER_124_893 VDD VSS sg13g2_decap_8
XFILLER_170_1404 VDD VSS sg13g2_decap_8
XFILLER_9_1036 VDD VSS sg13g2_decap_8
XFILLER_111_521 VDD VSS sg13g2_decap_8
X_07820_ _07820_/X _15009_/Q _07820_/B VDD VSS sg13g2_or2_1
XFILLER_42_1120 VDD VSS sg13g2_decap_8
XFILLER_111_576 VDD VSS sg13g2_fill_1
XFILLER_111_587 VDD VSS sg13g2_decap_8
X_07751_ _07751_/Y _10869_/A _07751_/B VDD VSS sg13g2_nand2_1
XFILLER_42_1197 VDD VSS sg13g2_decap_8
XFILLER_38_877 VDD VSS sg13g2_decap_8
XFILLER_37_343 VDD VSS sg13g2_decap_8
X_07682_ _07682_/Y _13312_/A _11243_/C VDD VSS sg13g2_nor2_1
XFILLER_92_460 VDD VSS sg13g2_decap_8
XFILLER_38_888 VDD VSS sg13g2_fill_1
XFILLER_77_1227 VDD VSS sg13g2_decap_8
XFILLER_53_825 VDD VSS sg13g2_decap_8
X_09421_ _14023_/D _09951_/A1 _14023_/Q _09429_/S VDD VSS sg13g2_mux2_1
XFILLER_20_1462 VDD VSS sg13g2_decap_8
XFILLER_129_1328 VDD VSS sg13g2_decap_4
XFILLER_129_1339 VDD VSS sg13g2_fill_1
XFILLER_164_1219 VDD VSS sg13g2_decap_8
XFILLER_53_869 VDD VSS sg13g2_decap_8
XFILLER_52_346 VDD VSS sg13g2_decap_8
X_15159__2732 _15159_/RESET_B VDD VSS sg13g2_tiehi
X_09352_ _13956_/D _09616_/A0 _13956_/Q _09363_/S VDD VSS sg13g2_mux2_1
XFILLER_40_519 VDD VSS sg13g2_decap_4
XFILLER_178_532 VDD VSS sg13g2_decap_8
X_08303_ _08303_/Y _08304_/A _08306_/B VDD VSS sg13g2_nor2_1
XFILLER_61_880 VDD VSS sg13g2_decap_8
XFILLER_127_1052 VDD VSS sg13g2_decap_8
XFILLER_20_210 VDD VSS sg13g2_decap_8
X_09283_ _13891_/D _13891_/Q _09914_/A1 _09305_/S VDD VSS sg13g2_mux2_1
XFILLER_90_1449 VDD VSS sg13g2_fill_2
XFILLER_139_919 VDD VSS sg13g2_fill_1
XFILLER_138_407 VDD VSS sg13g2_decap_8
XFILLER_166_716 VDD VSS sg13g2_decap_8
XFILLER_21_766 VDD VSS sg13g2_decap_4
X_08234_ _08234_/Y _08234_/A _08234_/B VDD VSS sg13g2_nor2_1
XFILLER_14_1211 VDD VSS sg13g2_decap_8
XFILLER_165_215 VDD VSS sg13g2_decap_8
XFILLER_166_749 VDD VSS sg13g2_fill_2
XFILLER_21_788 VDD VSS sg13g2_decap_8
XFILLER_165_237 VDD VSS sg13g2_decap_8
XFILLER_119_632 VDD VSS sg13g2_decap_8
XFILLER_147_941 VDD VSS sg13g2_fill_1
X_14468__1804 _14468_/RESET_B VDD VSS sg13g2_tiehi
XFILLER_53_1293 VDD VSS sg13g2_decap_8
XFILLER_20_287 VDD VSS sg13g2_decap_8
X_08165_ _08166_/A _07871_/X _08163_/Y _08164_/Y VDD VSS sg13g2_o21ai_1
XFILLER_101_1214 VDD VSS sg13g2_decap_8
XFILLER_162_900 VDD VSS sg13g2_fill_1
XFILLER_109_24 VDD VSS sg13g2_decap_8
XFILLER_146_451 VDD VSS sg13g2_decap_8
XFILLER_14_1288 VDD VSS sg13g2_decap_8
XFILLER_134_613 VDD VSS sg13g2_fill_1
XFILLER_119_698 VDD VSS sg13g2_fill_1
XFILLER_133_101 VDD VSS sg13g2_decap_8
X_08096_ _08096_/X _08199_/C _08223_/S VDD VSS sg13g2_and2_1
XFILLER_161_421 VDD VSS sg13g2_fill_1
XFILLER_161_432 VDD VSS sg13g2_decap_4
XFILLER_175_1337 VDD VSS sg13g2_fill_2
Xclkload80 clkload80/Y clkload80/A VDD VSS sg13g2_inv_2
Xclkload91 clkload91/Y clkload91/A VDD VSS sg13g2_inv_1
XFILLER_161_487 VDD VSS sg13g2_decap_8
XFILLER_134_1001 VDD VSS sg13g2_decap_4
XFILLER_0_637 VDD VSS sg13g2_decap_8
XFILLER_102_554 VDD VSS sg13g2_decap_8
XFILLER_47_1097 VDD VSS sg13g2_decap_8
X_08998_ _08998_/X _15027_/Q _15224_/Q _09009_/S VDD VSS sg13g2_mux2_1
XFILLER_87_287 VDD VSS sg13g2_fill_2
XFILLER_112_1321 VDD VSS sg13g2_decap_8
XFILLER_18_21 VDD VSS sg13g2_decap_8
X_07949_ _07950_/C _07805_/B _07949_/B _07949_/C VDD VSS sg13g2_nand3b_1
XFILLER_169_1108 VDD VSS sg13g2_decap_4
XFILLER_29_844 VDD VSS sg13g2_decap_8
XFILLER_68_490 VDD VSS sg13g2_decap_4
XFILLER_5_1456 VDD VSS sg13g2_decap_8
XFILLER_29_855 VDD VSS sg13g2_fill_2
XFILLER_1_1309 VDD VSS sg13g2_decap_8
XFILLER_186_1422 VDD VSS sg13g2_fill_1
X_10960_ _10978_/A _14759_/Q _11015_/C VDD VSS sg13g2_nor2_1
X_13956__2316 _13956_/RESET_B VDD VSS sg13g2_tiehi
XFILLER_95_1316 VDD VSS sg13g2_decap_8
XFILLER_83_460 VDD VSS sg13g2_decap_8
XFILLER_71_600 VDD VSS sg13g2_decap_4
XFILLER_55_162 VDD VSS sg13g2_fill_1
XFILLER_112_1398 VDD VSS sg13g2_decap_8
XFILLER_186_1455 VDD VSS sg13g2_decap_8
XFILLER_18_98 VDD VSS sg13g2_decap_8
X_09619_ _14215_/D _09619_/A0 _14215_/Q _09633_/S VDD VSS sg13g2_mux2_1
XFILLER_43_324 VDD VSS sg13g2_decap_8
XFILLER_141_88 VDD VSS sg13g2_fill_2
X_10891_ _10893_/A _10865_/Y _10841_/Y _10890_/Y VDD VSS sg13g2_o21ai_1
XFILLER_44_869 VDD VSS sg13g2_decap_4
XFILLER_70_132 VDD VSS sg13g2_decap_8
X_12630_ _12630_/X _14575_/Q _14607_/Q _14639_/Q _14671_/Q _12633_/S0 _12633_/S1 VDD
+ VSS sg13g2_mux4_1
XFILLER_93_1051 VDD VSS sg13g2_decap_8
XFILLER_12_700 VDD VSS sg13g2_decap_8
XFILLER_19_1133 VDD VSS sg13g2_decap_8
XFILLER_34_42 VDD VSS sg13g2_decap_8
XFILLER_145_1141 VDD VSS sg13g2_decap_8
X_12561_ _12561_/X _14570_/Q _14602_/Q _14634_/Q _14666_/Q _12564_/S0 _12564_/S1 VDD
+ VSS sg13g2_mux4_1
XFILLER_11_210 VDD VSS sg13g2_decap_8
XFILLER_157_716 VDD VSS sg13g2_decap_8
XFILLER_141_1016 VDD VSS sg13g2_decap_8
X_14300_ _14300_/Q _14716_/CLK _14300_/D _14300_/RESET_B VDD VSS sg13g2_dfrbpq_1
X_11512_ _11512_/X _13731_/Q _14083_/Q _14435_/Q _14531_/Q _12284_/S0 _12284_/S1 VDD
+ VSS sg13g2_mux4_1
XFILLER_12_777 VDD VSS sg13g2_decap_8
XFILLER_184_524 VDD VSS sg13g2_decap_8
X_14903__2831 _14903_/RESET_B VDD VSS sg13g2_tiehi
X_12492_ _12492_/X _13733_/Q _14085_/Q _14437_/Q _14533_/Q _12654_/S0 _12654_/S1 VDD
+ VSS sg13g2_mux4_1
XFILLER_7_203 VDD VSS sg13g2_decap_8
XFILLER_138_930 VDD VSS sg13g2_decap_8
X_13685__2595 _13685_/RESET_B VDD VSS sg13g2_tiehi
XFILLER_11_287 VDD VSS sg13g2_decap_8
XFILLER_126_0 VDD VSS sg13g2_decap_8
X_14231_ _14231_/Q clkload47/A _14231_/D _14231_/RESET_B VDD VSS sg13g2_dfrbpq_1
XFILLER_156_259 VDD VSS sg13g2_decap_8
X_11443_ _11446_/B _11443_/A _11443_/B VDD VSS sg13g2_nor2_1
XFILLER_171_207 VDD VSS sg13g2_decap_8
X_14162_ _14162_/Q _14674_/CLK _14162_/D _14162_/RESET_B VDD VSS sg13g2_dfrbpq_1
XFILLER_4_910 VDD VSS sg13g2_decap_8
XFILLER_32_1399 VDD VSS sg13g2_decap_8
XFILLER_166_63 VDD VSS sg13g2_decap_8
X_11374_ _11374_/Y _11374_/A _11374_/B _11419_/C VDD VSS sg13g2_nand3_1
XFILLER_180_741 VDD VSS sg13g2_fill_1
XFILLER_125_657 VDD VSS sg13g2_decap_4
X_13113_ _13113_/X _13172_/A _13172_/B _13172_/C VDD VSS sg13g2_and3_1
XFILLER_3_420 VDD VSS sg13g2_decap_8
X_14936__2765 _14936_/RESET_B VDD VSS sg13g2_tiehi
X_10325_ _14801_/D _10325_/A _10325_/B _10441_/C VDD VSS sg13g2_and3_1
XFILLER_180_763 VDD VSS sg13g2_decap_8
X_14093_ _14093_/Q clkload11/A _14093_/D _14093_/RESET_B VDD VSS sg13g2_dfrbpq_1
XFILLER_4_987 VDD VSS sg13g2_decap_8
XFILLER_112_329 VDD VSS sg13g2_fill_1
X_13044_ _13044_/Y input28/X _13609_/A _12997_/B VDD VSS sg13g2_o21ai_1
XFILLER_79_722 VDD VSS sg13g2_decap_4
X_10256_ _14780_/D _10256_/A _10265_/D _10350_/C VDD VSS sg13g2_and3_1
XFILLER_78_210 VDD VSS sg13g2_decap_8
XFILLER_3_497 VDD VSS sg13g2_decap_8
Xfanout1210 _08306_/C _14968_/Q VDD VSS sg13g2_buf_1
Xfanout1221 _08219_/A _08235_/A0 VDD VSS sg13g2_buf_1
Xfanout1232 _07879_/A _14959_/Q VDD VSS sg13g2_buf_1
XFILLER_59_94 VDD VSS sg13g2_decap_8
X_10187_ _10187_/X hold3152/X _15194_/Q _10187_/S VDD VSS sg13g2_mux2_1
XFILLER_26_1159 VDD VSS sg13g2_decap_8
XFILLER_182_84 VDD VSS sg13g2_decap_8
Xfanout1243 _12866_/A _14957_/Q VDD VSS sg13g2_buf_1
Xfanout1254 _10702_/A _14903_/Q VDD VSS sg13g2_buf_1
Xfanout1265 _10508_/A _14851_/Q VDD VSS sg13g2_buf_1
XFILLER_38_118 VDD VSS sg13g2_decap_8
Xfanout1276 _11203_/A1 _14761_/Q VDD VSS sg13g2_buf_1
XFILLER_15_7 VDD VSS sg13g2_decap_8
X_14995_ _14995_/Q clkload78/A _14995_/D _14995_/RESET_B VDD VSS sg13g2_dfrbpq_1
XFILLER_19_343 VDD VSS sg13g2_decap_8
XFILLER_75_961 VDD VSS sg13g2_decap_8
X_13946_ _13946_/Q clkload51/A _13946_/D _13946_/RESET_B VDD VSS sg13g2_dfrbpq_1
X_14546__1726 _14546_/RESET_B VDD VSS sg13g2_tiehi
XFILLER_35_825 VDD VSS sg13g2_fill_1
XFILLER_35_836 VDD VSS sg13g2_fill_2
X_15114__2824 _15114_/RESET_B VDD VSS sg13g2_tiehi
XFILLER_61_110 VDD VSS sg13g2_decap_8
X_13877_ _13877_/Q clkload28/A _13877_/D _13877_/RESET_B VDD VSS sg13g2_dfrbpq_1
XFILLER_90_953 VDD VSS sg13g2_decap_8
XFILLER_90_975 VDD VSS sg13g2_decap_8
XFILLER_179_329 VDD VSS sg13g2_decap_8
X_12828_ _12828_/Y _12828_/A _12828_/B VDD VSS sg13g2_nand2_1
XFILLER_37_1211 VDD VSS sg13g2_decap_4
XFILLER_22_519 VDD VSS sg13g2_decap_8
XFILLER_15_560 VDD VSS sg13g2_decap_8
XFILLER_124_1214 VDD VSS sg13g2_decap_8
X_12759_ _12759_/X _13976_/Q _14008_/Q _14040_/Q _14072_/Q _12759_/S0 _12759_/S1 VDD
+ VSS sg13g2_mux4_1
XFILLER_72_1168 VDD VSS sg13g2_decap_8
XFILLER_175_568 VDD VSS sg13g2_decap_8
X_14429_ _14429_/Q clkload59/A _14429_/D _14429_/RESET_B VDD VSS sg13g2_dfrbpq_1
XFILLER_50_1466 VDD VSS sg13g2_decap_8
XFILLER_11_1428 VDD VSS sg13g2_decap_8
X_14190__2082 _14190_/RESET_B VDD VSS sg13g2_tiehi
XFILLER_50_1477 VDD VSS sg13g2_fill_2
XFILLER_7_770 VDD VSS sg13g2_decap_8
XFILLER_144_944 VDD VSS sg13g2_fill_1
XFILLER_143_432 VDD VSS sg13g2_fill_2
XFILLER_144_966 VDD VSS sg13g2_decap_8
XFILLER_6_280 VDD VSS sg13g2_decap_8
XFILLER_171_752 VDD VSS sg13g2_decap_4
XFILLER_115_145 VDD VSS sg13g2_decap_8
X_09970_ _14554_/D _14554_/Q _10102_/A0 _09970_/S VDD VSS sg13g2_mux2_1
XFILLER_116_679 VDD VSS sg13g2_decap_8
XFILLER_157_1056 VDD VSS sg13g2_decap_8
XFILLER_89_519 VDD VSS sg13g2_decap_4
XFILLER_157_1067 VDD VSS sg13g2_fill_2
XFILLER_41_0 VDD VSS sg13g2_decap_8
X_08921_ _08921_/X _15043_/Q _14947_/Q _10757_/A VDD VSS sg13g2_mux2_1
XFILLER_135_1321 VDD VSS sg13g2_decap_4
XFILLER_69_210 VDD VSS sg13g2_decap_8
XFILLER_170_1212 VDD VSS sg13g2_fill_1
XFILLER_170_1234 VDD VSS sg13g2_decap_8
X_08852_ _08852_/Y _10691_/S _14930_/Q VDD VSS sg13g2_nor2b_1
XFILLER_83_1286 VDD VSS sg13g2_decap_8
XFILLER_97_563 VDD VSS sg13g2_decap_8
XFILLER_111_362 VDD VSS sg13g2_decap_8
XFILLER_112_885 VDD VSS sg13g2_decap_8
XFILLER_57_416 VDD VSS sg13g2_fill_2
XFILLER_29_107 VDD VSS sg13g2_decap_8
X_07803_ _08481_/A _07950_/A _07949_/B VDD VSS sg13g2_and2_1
XFILLER_85_736 VDD VSS sg13g2_decap_4
X_08783_ _13679_/D _08728_/Y _08782_/Y _08781_/Y VDD VSS sg13g2_a21oi_1
XFILLER_85_758 VDD VSS sg13g2_decap_8
X_07734_ _07735_/D wire705/X _07734_/B _07734_/C VDD VSS sg13g2_nand3_1
XFILLER_66_961 VDD VSS sg13g2_decap_4
XFILLER_26_836 VDD VSS sg13g2_decap_8
XFILLER_93_791 VDD VSS sg13g2_decap_8
XFILLER_81_931 VDD VSS sg13g2_decap_8
X_07665_ _07665_/X _13508_/B _10187_/S VDD VSS sg13g2_or2_1
XFILLER_81_942 VDD VSS sg13g2_fill_2
XFILLER_0_1331 VDD VSS sg13g2_decap_8
XFILLER_111_14 VDD VSS sg13g2_decap_4
XFILLER_25_346 VDD VSS sg13g2_decap_8
XFILLER_168_1185 VDD VSS sg13g2_fill_2
X_09404_ _14007_/D _10066_/A0 _14007_/Q _09404_/S VDD VSS sg13g2_mux2_1
XFILLER_52_154 VDD VSS sg13g2_fill_1
XFILLER_164_1038 VDD VSS sg13g2_fill_1
XFILLER_179_830 VDD VSS sg13g2_decap_8
XFILLER_81_997 VDD VSS sg13g2_decap_8
XFILLER_52_165 VDD VSS sg13g2_decap_8
XFILLER_55_1322 VDD VSS sg13g2_decap_8
XFILLER_53_699 VDD VSS sg13g2_decap_8
XFILLER_80_485 VDD VSS sg13g2_decap_8
X_09335_ _13942_/D _09634_/A0 _13942_/Q _09337_/S VDD VSS sg13g2_mux2_1
XFILLER_90_1224 VDD VSS sg13g2_decap_8
XFILLER_16_1328 VDD VSS sg13g2_decap_8
XFILLER_166_513 VDD VSS sg13g2_decap_8
XFILLER_179_896 VDD VSS sg13g2_decap_8
XFILLER_181_1385 VDD VSS sg13g2_fill_1
XFILLER_139_738 VDD VSS sg13g2_decap_8
XFILLER_142_1347 VDD VSS sg13g2_decap_4
X_09266_ _13875_/D _13875_/Q _10162_/A1 _09271_/S VDD VSS sg13g2_mux2_1
XFILLER_138_248 VDD VSS sg13g2_decap_8
X_08217_ _08217_/X _08544_/A _08234_/B VDD VSS sg13g2_and2_1
XFILLER_154_708 VDD VSS sg13g2_decap_8
X_09197_ _13813_/D _13813_/Q _09899_/A0 _09201_/S VDD VSS sg13g2_mux2_1
XFILLER_5_707 VDD VSS sg13g2_decap_8
XFILLER_101_1011 VDD VSS sg13g2_decap_8
XFILLER_140_1060 VDD VSS sg13g2_decap_8
XFILLER_147_782 VDD VSS sg13g2_fill_1
X_14020__2252 _14020_/RESET_B VDD VSS sg13g2_tiehi
XFILLER_119_484 VDD VSS sg13g2_decap_4
XFILLER_14_1085 VDD VSS sg13g2_decap_8
X_08148_ _08688_/A _08242_/A _08194_/B VDD VSS sg13g2_nand2_1
XFILLER_4_217 VDD VSS sg13g2_decap_8
XFILLER_175_1101 VDD VSS sg13g2_fill_1
XFILLER_135_955 VDD VSS sg13g2_decap_8
XFILLER_106_123 VDD VSS sg13g2_decap_8
XFILLER_134_432 VDD VSS sg13g2_decap_8
XFILLER_88_1186 VDD VSS sg13g2_fill_1
XFILLER_107_679 VDD VSS sg13g2_decap_8
XFILLER_122_605 VDD VSS sg13g2_fill_1
X_08079_ _08079_/X _08397_/B _08009_/X _08079_/S VDD VSS sg13g2_mux2_1
XFILLER_20_77 VDD VSS sg13g2_decap_8
X_14624__1648 _14624_/RESET_B VDD VSS sg13g2_tiehi
XFILLER_1_924 VDD VSS sg13g2_decap_8
X_10110_ _14688_/D _10143_/A1 _14688_/Q _10135_/S VDD VSS sg13g2_mux2_1
XFILLER_136_77 VDD VSS sg13g2_fill_1
X_11090_ _11092_/A _11125_/A _10754_/X _11088_/A _11087_/X _11058_/Y VDD VSS sg13g2_a221oi_1
XFILLER_0_434 VDD VSS sg13g2_decap_8
XFILLER_103_852 VDD VSS sg13g2_decap_4
XFILLER_121_148 VDD VSS sg13g2_decap_8
XFILLER_62_1326 VDD VSS sg13g2_decap_4
X_10041_ _14622_/D _10041_/A0 _14622_/Q _10063_/S VDD VSS sg13g2_mux2_1
XFILLER_49_917 VDD VSS sg13g2_fill_2
XFILLER_27_1468 VDD VSS sg13g2_decap_8
XFILLER_76_725 VDD VSS sg13g2_decap_4
XFILLER_29_42 VDD VSS sg13g2_decap_8
XFILLER_88_596 VDD VSS sg13g2_decap_4
XFILLER_114_1449 VDD VSS sg13g2_decap_4
XFILLER_130_693 VDD VSS sg13g2_decap_8
XFILLER_5_1253 VDD VSS sg13g2_decap_8
X_13800_ _13800_/Q _14740_/CLK _13800_/D _13800_/RESET_B VDD VSS sg13g2_dfrbpq_1
XFILLER_21_1034 VDD VSS sg13g2_decap_8
XFILLER_1_1106 VDD VSS sg13g2_decap_8
X_14780_ _14780_/Q clkload62/A _14780_/D _14780_/RESET_B VDD VSS sg13g2_dfrbpq_1
X_11992_ _11992_/X _14385_/Q _14417_/Q _14481_/Q _14513_/Q _11951_/A _11952_/C VDD
+ VSS sg13g2_mux4_1
XFILLER_75_279 VDD VSS sg13g2_decap_8
XFILLER_29_674 VDD VSS sg13g2_fill_2
XFILLER_91_739 VDD VSS sg13g2_decap_8
XFILLER_99_1282 VDD VSS sg13g2_decap_8
XFILLER_84_780 VDD VSS sg13g2_decap_8
XFILLER_72_920 VDD VSS sg13g2_decap_8
X_13731_ _13731_/Q _14723_/CLK _13731_/D _13731_/RESET_B VDD VSS sg13g2_dfrbpq_1
X_10943_ _11004_/A _14758_/Q _10954_/C VDD VSS sg13g2_xnor2_1
XFILLER_147_1203 VDD VSS sg13g2_decap_8
XFILLER_16_357 VDD VSS sg13g2_decap_8
XFILLER_182_1116 VDD VSS sg13g2_decap_8
XFILLER_32_806 VDD VSS sg13g2_fill_2
XFILLER_182_1127 VDD VSS sg13g2_fill_2
X_13662_ _13662_/Q _15212_/CLK _13662_/D _13662_/RESET_B VDD VSS sg13g2_dfrbpq_1
X_15187__2896 _15187_/RESET_B VDD VSS sg13g2_tiehi
X_10874_ _14932_/D _10873_/Y _10872_/Y _10862_/Y VDD VSS sg13g2_o21ai_1
XFILLER_32_828 VDD VSS sg13g2_decap_8
XFILLER_73_1422 VDD VSS sg13g2_decap_8
X_12613_ _12613_/X _14126_/Q _14158_/Q _14190_/Q _14222_/Q _12618_/S0 _12618_/S1 VDD
+ VSS sg13g2_mux4_1
XFILLER_31_338 VDD VSS sg13g2_decap_8
XFILLER_169_340 VDD VSS sg13g2_decap_8
X_13593_ _13593_/Y _13593_/A _13593_/B VDD VSS sg13g2_nor2_1
XFILLER_73_1466 VDD VSS sg13g2_decap_8
XFILLER_34_1428 VDD VSS sg13g2_fill_2
X_12544_ _12544_/X _14697_/Q _14729_/Q _13769_/Q _13801_/Q _12769_/S0 _12769_/S1 VDD
+ VSS sg13g2_mux4_1
XFILLER_121_1409 VDD VSS sg13g2_fill_2
XFILLER_12_574 VDD VSS sg13g2_decap_8
XFILLER_160_1469 VDD VSS sg13g2_decap_4
XFILLER_185_888 VDD VSS sg13g2_fill_2
X_12475_ _12475_/X _14372_/Q _14404_/Q _14468_/Q _14500_/Q _12759_/S0 _12759_/S1 VDD
+ VSS sg13g2_mux4_1
XFILLER_8_567 VDD VSS sg13g2_decap_8
XFILLER_177_84 VDD VSS sg13g2_decap_8
XFILLER_32_1163 VDD VSS sg13g2_decap_8
XFILLER_123_1291 VDD VSS sg13g2_decap_8
X_14214_ _14214_/Q _14662_/CLK _14214_/D _14214_/RESET_B VDD VSS sg13g2_dfrbpq_1
X_11426_ _11426_/Y _12859_/A _11433_/B _07684_/B VDD VSS sg13g2_a21oi_1
XFILLER_6_35 VDD VSS sg13g2_decap_8
XANTENNA_6 _13701_/Q VDD VSS sg13g2_antennanp
XFILLER_125_410 VDD VSS sg13g2_decap_8
X_15143__2764 _15143_/RESET_B VDD VSS sg13g2_tiehi
X_15194_ _15194_/Q clkload84/A _15194_/D _15194_/RESET_B VDD VSS sg13g2_dfrbpq_1
XFILLER_126_977 VDD VSS sg13g2_fill_2
X_14145_ _14145_/Q clkload37/A _14145_/D _14145_/RESET_B VDD VSS sg13g2_dfrbpq_1
XFILLER_119_1305 VDD VSS sg13g2_decap_4
XFILLER_153_763 VDD VSS sg13g2_decap_4
X_11357_ _11357_/Y _11401_/C _11353_/X _11356_/Y VDD VSS sg13g2_o21ai_1
XFILLER_180_560 VDD VSS sg13g2_decap_8
XFILLER_153_796 VDD VSS sg13g2_decap_8
X_10308_ _14796_/D _14796_/Q _10327_/B _10307_/Y VDD VSS sg13g2_a21oi_1
XFILLER_4_784 VDD VSS sg13g2_decap_8
XFILLER_154_1229 VDD VSS sg13g2_fill_1
X_14076_ _14076_/Q _14652_/CLK _14076_/D _14076_/RESET_B VDD VSS sg13g2_dfrbpq_1
X_11288_ _11288_/Y _11288_/A _15217_/Q VDD VSS sg13g2_nor2b_1
XFILLER_3_294 VDD VSS sg13g2_decap_8
X_13027_ _13027_/Y _13026_/Y _13271_/C _13042_/B VDD VSS sg13g2_nand3b_1
XFILLER_80_1426 VDD VSS sg13g2_decap_8
X_10239_ _14774_/D _10237_/B _10234_/Y _10238_/Y VDD VSS sg13g2_a21oi_1
XFILLER_79_563 VDD VSS sg13g2_decap_8
XFILLER_121_660 VDD VSS sg13g2_fill_1
XFILLER_117_1062 VDD VSS sg13g2_fill_1
Xfanout1040 _08391_/A _15096_/Q VDD VSS sg13g2_buf_1
Xfanout1051 _13310_/B2 _10898_/B1 VDD VSS sg13g2_buf_1
Xfanout1062 _10070_/A _10004_/A VDD VSS sg13g2_buf_1
XFILLER_94_533 VDD VSS sg13g2_decap_8
Xfanout1073 _09161_/S _09072_/B VDD VSS sg13g2_buf_1
XFILLER_67_769 VDD VSS sg13g2_decap_8
Xfanout1084 _13412_/B _15057_/Q VDD VSS sg13g2_buf_1
Xfanout1095 _08351_/B _15001_/Q VDD VSS sg13g2_buf_1
XFILLER_19_140 VDD VSS sg13g2_decap_8
X_14978_ _14978_/Q clkload54/A _14978_/D _14978_/RESET_B VDD VSS sg13g2_dfrbpq_1
XFILLER_81_205 VDD VSS sg13g2_fill_2
XFILLER_78_1333 VDD VSS sg13g2_fill_2
XFILLER_63_931 VDD VSS sg13g2_decap_4
XFILLER_35_622 VDD VSS sg13g2_decap_8
XFILLER_81_238 VDD VSS sg13g2_fill_2
XFILLER_165_1303 VDD VSS sg13g2_decap_8
X_13929_ _13929_/Q clkload34/A _13929_/D _13929_/RESET_B VDD VSS sg13g2_dfrbpq_1
XFILLER_63_986 VDD VSS sg13g2_decap_8
XFILLER_62_452 VDD VSS sg13g2_decap_8
XFILLER_179_126 VDD VSS sg13g2_decap_8
XFILLER_35_699 VDD VSS sg13g2_decap_8
XFILLER_62_496 VDD VSS sg13g2_fill_2
XFILLER_22_338 VDD VSS sg13g2_decap_4
XFILLER_148_502 VDD VSS sg13g2_decap_4
XFILLER_31_850 VDD VSS sg13g2_fill_1
X_09120_ _09120_/Y _15243_/Q _09147_/B VDD VSS sg13g2_nand2b_1
XFILLER_163_1071 VDD VSS sg13g2_decap_8
XFILLER_176_833 VDD VSS sg13g2_decap_8
XFILLER_89_0 VDD VSS sg13g2_decap_8
XFILLER_124_1066 VDD VSS sg13g2_decap_8
XFILLER_176_866 VDD VSS sg13g2_decap_8
XFILLER_148_568 VDD VSS sg13g2_decap_8
X_09051_ wire243/A _09024_/A _10720_/B _09050_/X VDD VSS sg13g2_o21ai_1
XFILLER_50_1230 VDD VSS sg13g2_decap_8
XFILLER_15_1361 VDD VSS sg13g2_decap_8
XFILLER_175_376 VDD VSS sg13g2_decap_8
X_08002_ _08002_/Y _08037_/A _08037_/B _08039_/A VDD VSS sg13g2_a21oi_1
XFILLER_89_1440 VDD VSS sg13g2_decap_8
XFILLER_11_1225 VDD VSS sg13g2_decap_8
XFILLER_129_782 VDD VSS sg13g2_decap_8
XFILLER_128_270 VDD VSS sg13g2_fill_1
XFILLER_89_305 VDD VSS sg13g2_decap_8
XFILLER_104_627 VDD VSS sg13g2_decap_4
XFILLER_176_1476 VDD VSS sg13g2_fill_2
XFILLER_116_487 VDD VSS sg13g2_decap_8
XFILLER_104_638 VDD VSS sg13g2_decap_8
XFILLER_116_498 VDD VSS sg13g2_fill_2
X_09953_ _14537_/D _14537_/Q _09953_/A1 _09969_/S VDD VSS sg13g2_mux2_1
XFILLER_106_14 VDD VSS sg13g2_fill_1
X_08904_ _08904_/X _08903_/X _11843_/A _08931_/S VDD VSS sg13g2_mux2_1
XFILLER_83_1072 VDD VSS sg13g2_decap_8
XFILLER_98_872 VDD VSS sg13g2_decap_8
X_09884_ _14470_/D _09917_/A1 _14470_/Q _09896_/S VDD VSS sg13g2_mux2_1
XFILLER_97_360 VDD VSS sg13g2_decap_8
XFILLER_58_714 VDD VSS sg13g2_decap_8
XFILLER_135_1162 VDD VSS sg13g2_decap_8
XFILLER_170_1053 VDD VSS sg13g2_decap_4
XFILLER_131_1015 VDD VSS sg13g2_decap_8
XFILLER_135_1184 VDD VSS sg13g2_decap_8
X_08835_ _08842_/S _13600_/A _08835_/B VDD VSS sg13g2_nand2_1
XFILLER_22_1310 VDD VSS sg13g2_decap_8
XFILLER_100_888 VDD VSS sg13g2_decap_8
X_14920__2797 _14920_/RESET_B VDD VSS sg13g2_tiehi
X_08766_ _08766_/Y _13674_/Q _08775_/B VDD VSS sg13g2_nor2_1
XFILLER_39_972 VDD VSS sg13g2_fill_2
XFILLER_85_588 VDD VSS sg13g2_fill_2
XFILLER_45_419 VDD VSS sg13g2_decap_8
XFILLER_38_460 VDD VSS sg13g2_decap_8
XFILLER_122_35 VDD VSS sg13g2_decap_8
XFILLER_72_216 VDD VSS sg13g2_fill_2
XFILLER_38_471 VDD VSS sg13g2_fill_1
X_07717_ wire719/A _15102_/Q _15101_/Q _15094_/Q _15093_/Q VDD VSS sg13g2_nor4_1
XFILLER_22_1387 VDD VSS sg13g2_decap_8
XFILLER_183_1403 VDD VSS sg13g2_decap_8
X_08697_ _08697_/Y _08697_/A _08697_/B VDD VSS sg13g2_nand2_1
XFILLER_167_7 VDD VSS sg13g2_decap_8
X_14038__2234 _14038_/RESET_B VDD VSS sg13g2_tiehi
XFILLER_81_761 VDD VSS sg13g2_decap_8
X_07648_ _07648_/Y _14826_/Q VDD VSS sg13g2_inv_1
XFILLER_41_603 VDD VSS sg13g2_decap_8
XFILLER_55_1130 VDD VSS sg13g2_decap_8
XFILLER_53_496 VDD VSS sg13g2_decap_8
XFILLER_15_77 VDD VSS sg13g2_decap_8
XFILLER_40_146 VDD VSS sg13g2_decap_8
XFILLER_22_850 VDD VSS sg13g2_fill_1
XFILLER_16_1125 VDD VSS sg13g2_decap_8
X_09318_ _13925_/D _09883_/A0 _13925_/Q _09331_/S VDD VSS sg13g2_mux2_1
XFILLER_22_872 VDD VSS sg13g2_decap_8
XFILLER_139_535 VDD VSS sg13g2_decap_8
X_10590_ _10606_/B _14874_/Q _10649_/B VDD VSS sg13g2_nand2_1
XFILLER_103_1106 VDD VSS sg13g2_fill_2
XFILLER_51_1038 VDD VSS sg13g2_decap_8
XFILLER_166_343 VDD VSS sg13g2_decap_8
XFILLER_142_1177 VDD VSS sg13g2_fill_2
XFILLER_182_803 VDD VSS sg13g2_decap_8
X_09249_ _13858_/D _13858_/Q _10145_/A1 _09272_/S VDD VSS sg13g2_mux2_1
XFILLER_31_21 VDD VSS sg13g2_decap_8
XFILLER_154_505 VDD VSS sg13g2_decap_8
XFILLER_108_911 VDD VSS sg13g2_fill_2
XFILLER_5_504 VDD VSS sg13g2_decap_8
XFILLER_120_1431 VDD VSS sg13g2_decap_8
XFILLER_147_21 VDD VSS sg13g2_decap_8
XFILLER_154_527 VDD VSS sg13g2_decap_8
XFILLER_126_229 VDD VSS sg13g2_decap_8
XFILLER_166_398 VDD VSS sg13g2_decap_4
X_12260_ _12260_/X _12239_/B _12259_/X _12258_/Y VDD VSS sg13g2_a21o_1
XFILLER_181_357 VDD VSS sg13g2_decap_8
X_11211_ _11211_/X _14107_/Q _14139_/Q _11212_/S VDD VSS sg13g2_mux2_1
X_12191_ _12192_/B _12188_/Y _12190_/Y _12191_/B1 VDD VSS sg13g2_a21oi_1
XFILLER_107_487 VDD VSS sg13g2_decap_8
XFILLER_123_936 VDD VSS sg13g2_fill_1
Xoutput43 mem_axi_araddr[14] output43/A VDD VSS sg13g2_buf_1
X_11142_ _14951_/D _11141_/X _11140_/Y _11133_/Y VDD VSS sg13g2_o21ai_1
XFILLER_122_435 VDD VSS sg13g2_decap_8
XFILLER_1_721 VDD VSS sg13g2_decap_8
X_15085__2916 _15085_/RESET_B VDD VSS sg13g2_tiehi
Xoutput54 mem_axi_araddr[25] _13716_/Q VDD VSS sg13g2_buf_1
Xoutput65 mem_axi_araddr[6] output65/A VDD VSS sg13g2_buf_1
XFILLER_150_766 VDD VSS sg13g2_decap_8
Xoutput76 mem_axi_awaddr[15] _16868_/X VDD VSS sg13g2_buf_1
XFILLER_0_231 VDD VSS sg13g2_decap_8
XFILLER_163_42 VDD VSS sg13g2_decap_8
Xoutput87 mem_axi_awaddr[26] _16879_/X VDD VSS sg13g2_buf_1
XFILLER_62_1112 VDD VSS sg13g2_decap_8
X_11073_ _14946_/D _14946_/Q _11048_/B _11072_/Y VDD VSS sg13g2_a21o_1
XFILLER_114_1202 VDD VSS sg13g2_decap_8
Xoutput98 mem_axi_awaddr[7] _16860_/X VDD VSS sg13g2_buf_1
XFILLER_114_1213 VDD VSS sg13g2_fill_2
XFILLER_27_1265 VDD VSS sg13g2_decap_8
XFILLER_1_798 VDD VSS sg13g2_decap_8
Xhold3170 input3/A mem_axi_bvalid VDD VSS sg13g2_dlygate4sd3_1
XFILLER_7_1337 VDD VSS sg13g2_decap_8
X_14901_ _14901_/Q _15226_/CLK _14901_/D _14901_/RESET_B VDD VSS sg13g2_dfrbpq_1
Xhold3181 input14/A mem_axi_rdata[19] VDD VSS sg13g2_dlygate4sd3_1
X_10024_ _14606_/D _10024_/A0 _14606_/Q _10030_/S VDD VSS sg13g2_mux2_1
Xhold3192 _13615_/A _13723_/Q VDD VSS sg13g2_dlygate4sd3_1
XFILLER_114_1257 VDD VSS sg13g2_decap_4
XFILLER_76_566 VDD VSS sg13g2_decap_8
XFILLER_114_1279 VDD VSS sg13g2_decap_8
X_14832_ _14832_/Q clkload66/A _14832_/D _14832_/RESET_B VDD VSS sg13g2_dfrbpq_1
XFILLER_5_1050 VDD VSS sg13g2_decap_8
XFILLER_149_1309 VDD VSS sg13g2_decap_8
XFILLER_57_791 VDD VSS sg13g2_decap_4
X_14763_ _14763_/Q clkload90/A _14763_/D _14763_/RESET_B VDD VSS sg13g2_dfrbpq_1
X_11975_ _11975_/Y _11975_/A _11975_/B VDD VSS sg13g2_nor2_1
XFILLER_44_430 VDD VSS sg13g2_fill_1
XFILLER_45_964 VDD VSS sg13g2_decap_8
XFILLER_44_441 VDD VSS sg13g2_decap_4
XFILLER_60_901 VDD VSS sg13g2_decap_8
XFILLER_16_154 VDD VSS sg13g2_decap_8
X_13714_ _13714_/Q clkload57/A _13714_/D _13714_/RESET_B VDD VSS sg13g2_dfrbpq_1
XFILLER_147_1033 VDD VSS sg13g2_decap_8
X_10926_ _10926_/X _10926_/A _10926_/B _10926_/C VDD VSS sg13g2_and3_1
XFILLER_60_923 VDD VSS sg13g2_decap_8
X_14694_ _14694_/Q _14726_/CLK _14694_/D _14694_/RESET_B VDD VSS sg13g2_dfrbpq_1
XFILLER_44_474 VDD VSS sg13g2_fill_2
XFILLER_31_102 VDD VSS sg13g2_decap_4
XFILLER_44_496 VDD VSS sg13g2_decap_8
X_13645_ _13753_/D _13645_/A VDD VSS sg13g2_buf_1
X_10857_ _10857_/Y _10857_/A _10857_/B VDD VSS sg13g2_xnor2_1
XFILLER_32_658 VDD VSS sg13g2_fill_1
XFILLER_108_1039 VDD VSS sg13g2_fill_1
XFILLER_32_669 VDD VSS sg13g2_decap_8
XFILLER_72_83 VDD VSS sg13g2_decap_4
XFILLER_13_861 VDD VSS sg13g2_decap_8
XFILLER_73_1274 VDD VSS sg13g2_decap_8
XFILLER_82_7 VDD VSS sg13g2_decap_8
XFILLER_185_630 VDD VSS sg13g2_decap_8
X_13576_ _15157_/D _13581_/B _13574_/Y _13575_/Y VDD VSS sg13g2_a21oi_1
X_10788_ _11199_/B _07614_/Y _09155_/Y _10788_/S VDD VSS sg13g2_mux2_1
XFILLER_12_371 VDD VSS sg13g2_decap_8
XFILLER_157_332 VDD VSS sg13g2_decap_8
XFILLER_121_1206 VDD VSS sg13g2_decap_8
XFILLER_160_1255 VDD VSS sg13g2_decap_8
XFILLER_9_854 VDD VSS sg13g2_decap_8
XFILLER_160_1266 VDD VSS sg13g2_fill_1
XFILLER_34_1269 VDD VSS sg13g2_decap_8
XFILLER_184_140 VDD VSS sg13g2_decap_8
X_12527_ _15001_/D _12527_/A wire323/X VDD VSS sg13g2_nor2_1
XFILLER_145_516 VDD VSS sg13g2_decap_4
XFILLER_157_376 VDD VSS sg13g2_decap_8
X_13736__2536 _13736_/RESET_B VDD VSS sg13g2_tiehi
XFILLER_8_364 VDD VSS sg13g2_decap_8
XFILLER_160_1299 VDD VSS sg13g2_decap_8
XFILLER_173_836 VDD VSS sg13g2_fill_2
X_14496__1776 _14496_/RESET_B VDD VSS sg13g2_tiehi
XFILLER_172_324 VDD VSS sg13g2_decap_8
XFILLER_173_847 VDD VSS sg13g2_fill_2
X_15246_ _15246_/Q clkload71/A _15246_/D _15246_/RESET_B VDD VSS sg13g2_dfrbpq_1
X_12458_ _12471_/A _10213_/A _07737_/B _08263_/B VDD VSS sg13g2_a21oi_1
XFILLER_126_752 VDD VSS sg13g2_fill_2
XFILLER_160_508 VDD VSS sg13g2_decap_8
X_11409_ _11409_/Y _11410_/A1 _14463_/Q VDD VSS sg13g2_nand2b_1
X_15177_ _15177_/Q _15182_/CLK _15177_/D _15177_/RESET_B VDD VSS sg13g2_dfrbpq_1
X_12389_ _12389_/X _14686_/Q _14718_/Q _13758_/Q _13790_/Q _12585_/S0 _12591_/S1 VDD
+ VSS sg13g2_mux4_1
XFILLER_125_262 VDD VSS sg13g2_decap_8
XFILLER_126_796 VDD VSS sg13g2_fill_1
XFILLER_114_947 VDD VSS sg13g2_decap_4
XFILLER_153_582 VDD VSS sg13g2_decap_8
XFILLER_158_1173 VDD VSS sg13g2_decap_8
X_14128_ _14128_/Q clkload10/A _14128_/D _14128_/RESET_B VDD VSS sg13g2_dfrbpq_1
XFILLER_4_581 VDD VSS sg13g2_decap_8
XFILLER_28_1018 VDD VSS sg13g2_fill_2
XFILLER_154_1037 VDD VSS sg13g2_decap_8
X_14116__2156 _14116_/RESET_B VDD VSS sg13g2_tiehi
X_13951__2321 _13951_/RESET_B VDD VSS sg13g2_tiehi
XFILLER_84_1370 VDD VSS sg13g2_decap_4
X_14059_ _14059_/Q clkload11/A _14059_/D _14059_/RESET_B VDD VSS sg13g2_dfrbpq_1
XFILLER_171_1351 VDD VSS sg13g2_decap_8
XFILLER_79_360 VDD VSS sg13g2_decap_8
XFILLER_67_500 VDD VSS sg13g2_decap_8
XFILLER_132_1313 VDD VSS sg13g2_fill_1
XFILLER_45_1387 VDD VSS sg13g2_fill_1
X_08620_ _08621_/C _14984_/Q _08627_/A2 _08620_/A2 _08620_/A3 _08686_/S0 _13510_/A1
+ VDD VSS sg13g2_mux4_1
XFILLER_48_780 VDD VSS sg13g2_fill_2
XFILLER_82_536 VDD VSS sg13g2_decap_4
X_08551_ _08551_/X _08567_/B _08531_/B _07956_/Y VDD VSS sg13g2_a21o_1
XFILLER_78_1130 VDD VSS sg13g2_decap_8
X_13984__2288 _13984_/RESET_B VDD VSS sg13g2_tiehi
XFILLER_82_569 VDD VSS sg13g2_decap_8
XFILLER_78_1174 VDD VSS sg13g2_decap_8
XFILLER_23_603 VDD VSS sg13g2_decap_8
XFILLER_169_1291 VDD VSS sg13g2_decap_8
X_08482_ _15237_/D _08395_/A _08481_/X _08475_/Y VDD VSS sg13g2_o21ai_1
XFILLER_1_1470 VDD VSS sg13g2_decap_4
XFILLER_78_1185 VDD VSS sg13g2_fill_1
XFILLER_165_1155 VDD VSS sg13g2_decap_8
XFILLER_168_608 VDD VSS sg13g2_decap_8
XFILLER_74_1049 VDD VSS sg13g2_decap_8
XFILLER_39_1169 VDD VSS sg13g2_decap_8
XFILLER_168_619 VDD VSS sg13g2_fill_2
XFILLER_51_967 VDD VSS sg13g2_decap_4
XFILLER_143_1420 VDD VSS sg13g2_decap_8
XFILLER_51_989 VDD VSS sg13g2_decap_8
XFILLER_10_308 VDD VSS sg13g2_decap_8
XFILLER_52_1314 VDD VSS sg13g2_decap_8
XFILLER_22_168 VDD VSS sg13g2_decap_8
XFILLER_176_641 VDD VSS sg13g2_decap_8
XFILLER_50_499 VDD VSS sg13g2_decap_8
XFILLER_17_1467 VDD VSS sg13g2_decap_8
X_09103_ _09150_/B _13142_/A _14915_/Q _09103_/C _09103_/D VDD VSS sg13g2_and4_1
XFILLER_13_1309 VDD VSS sg13g2_decap_8
XFILLER_31_691 VDD VSS sg13g2_decap_8
XFILLER_175_140 VDD VSS sg13g2_decap_8
XFILLER_108_207 VDD VSS sg13g2_decap_8
X_14326__1946 _14326_/RESET_B VDD VSS sg13g2_tiehi
X_09034_ _09034_/X _15033_/Q _15230_/Q _09053_/B VDD VSS sg13g2_mux2_1
XFILLER_11_1022 VDD VSS sg13g2_decap_8
XFILLER_50_1093 VDD VSS sg13g2_decap_4
XFILLER_89_1281 VDD VSS sg13g2_decap_8
XFILLER_116_251 VDD VSS sg13g2_decap_8
XFILLER_2_518 VDD VSS sg13g2_decap_8
XFILLER_11_1099 VDD VSS sg13g2_decap_8
XFILLER_117_46 VDD VSS sg13g2_fill_1
XFILLER_105_969 VDD VSS sg13g2_fill_1
XFILLER_117_68 VDD VSS sg13g2_decap_8
XFILLER_176_1295 VDD VSS sg13g2_decap_8
XFILLER_89_135 VDD VSS sg13g2_fill_2
Xfanout800 _08428_/S _08431_/D VDD VSS sg13g2_buf_1
XFILLER_85_1189 VDD VSS sg13g2_decap_8
XFILLER_77_28 VDD VSS sg13g2_decap_8
Xfanout811 _08452_/C _08617_/A VDD VSS sg13g2_buf_1
XFILLER_104_468 VDD VSS sg13g2_decap_8
XFILLER_131_254 VDD VSS sg13g2_decap_8
XFILLER_132_777 VDD VSS sg13g2_decap_8
X_14541__1731 _14541_/RESET_B VDD VSS sg13g2_tiehi
Xfanout822 _09141_/A _08992_/A VDD VSS sg13g2_buf_1
X_09936_ _14521_/D _14521_/Q _09936_/A1 _09936_/S VDD VSS sg13g2_mux2_1
Xfanout833 _10926_/C _15250_/Q VDD VSS sg13g2_buf_1
Xfanout844 _12636_/S _12761_/S1 VDD VSS sg13g2_buf_1
XFILLER_113_991 VDD VSS sg13g2_decap_8
Xfanout855 wire856/A _12789_/S0 VDD VSS sg13g2_buf_1
XFILLER_63_1465 VDD VSS sg13g2_decap_8
Xfanout866 _12600_/S1 _12604_/S1 VDD VSS sg13g2_buf_1
XFILLER_86_842 VDD VSS sg13g2_decap_8
XFILLER_58_533 VDD VSS sg13g2_decap_4
Xfanout877 _12668_/S1 _12754_/S1 VDD VSS sg13g2_buf_1
X_09867_ _14454_/D _14454_/Q _09966_/A1 _09870_/S VDD VSS sg13g2_mux2_1
Xfanout888 _12382_/S1 fanout894/X VDD VSS sg13g2_buf_1
XFILLER_24_1449 VDD VSS sg13g2_decap_8
Xfanout899 fanout899/X fanout912/X VDD VSS sg13g2_buf_1
XFILLER_133_56 VDD VSS sg13g2_decap_8
XFILLER_85_352 VDD VSS sg13g2_fill_1
X_08818_ _08818_/Y _13690_/Q _13482_/B VDD VSS sg13g2_nor2_1
XFILLER_45_205 VDD VSS sg13g2_decap_8
X_09798_ _14387_/D _09831_/A0 _14387_/Q _09804_/S VDD VSS sg13g2_mux2_1
XFILLER_93_49 VDD VSS sg13g2_decap_8
XFILLER_113_1290 VDD VSS sg13g2_decap_8
XFILLER_27_942 VDD VSS sg13g2_decap_8
XFILLER_26_21 VDD VSS sg13g2_decap_8
XFILLER_22_1184 VDD VSS sg13g2_decap_8
X_08749_ _08749_/Y _13668_/Q _08775_/B VDD VSS sg13g2_nor2_1
X_13814__2458 _13814_/RESET_B VDD VSS sg13g2_tiehi
XFILLER_61_709 VDD VSS sg13g2_decap_4
X_14574__1698 _14574_/RESET_B VDD VSS sg13g2_tiehi
XFILLER_2_1267 VDD VSS sg13g2_decap_8
XFILLER_26_441 VDD VSS sg13g2_decap_8
XFILLER_148_1331 VDD VSS sg13g2_decap_4
X_11760_ _11761_/B _11760_/A _11760_/B _11760_/C VDD VSS sg13g2_nand3_1
XFILLER_42_912 VDD VSS sg13g2_fill_1
XFILLER_54_783 VDD VSS sg13g2_decap_8
XFILLER_42_923 VDD VSS sg13g2_decap_8
XFILLER_53_260 VDD VSS sg13g2_decap_8
XFILLER_96_1296 VDD VSS sg13g2_decap_8
XFILLER_41_411 VDD VSS sg13g2_decap_8
XFILLER_144_1206 VDD VSS sg13g2_fill_2
XFILLER_159_608 VDD VSS sg13g2_decap_4
X_10711_ _14905_/D _10999_/B1 _10954_/A _10708_/Y VDD VSS sg13g2_o21ai_1
XFILLER_57_1258 VDD VSS sg13g2_decap_8
XFILLER_26_98 VDD VSS sg13g2_decap_4
XFILLER_14_658 VDD VSS sg13g2_decap_8
X_11691_ _11693_/A _11969_/A _14184_/Q VDD VSS sg13g2_nand2b_1
XFILLER_13_168 VDD VSS sg13g2_decap_8
X_13430_ _15097_/D _15097_/Q _13470_/A2 _13429_/Y VDD VSS sg13g2_a21o_1
X_10642_ _10643_/C _14888_/Q _14887_/Q _10642_/C VDD VSS sg13g2_and3_1
XFILLER_167_630 VDD VSS sg13g2_fill_1
XFILLER_179_490 VDD VSS sg13g2_decap_8
XFILLER_42_42 VDD VSS sg13g2_decap_8
XFILLER_107_1061 VDD VSS sg13g2_decap_4
XFILLER_139_343 VDD VSS sg13g2_decap_8
XFILLER_158_42 VDD VSS sg13g2_decap_4
XFILLER_166_140 VDD VSS sg13g2_decap_8
X_13361_ _13361_/Y _13494_/B _13438_/B _13361_/C VDD VSS sg13g2_nor3_1
X_10573_ _10577_/C _10647_/C _10591_/C _14870_/Q VDD VSS sg13g2_a21oi_1
XFILLER_107_1094 VDD VSS sg13g2_fill_2
XFILLER_127_516 VDD VSS sg13g2_decap_4
XFILLER_167_685 VDD VSS sg13g2_decap_8
XFILLER_10_875 VDD VSS sg13g2_decap_8
X_15100_ _15100_/Q clkload86/A _15100_/D _15100_/RESET_B VDD VSS sg13g2_dfrbpq_1
XFILLER_5_301 VDD VSS sg13g2_decap_8
X_12312_ _12312_/Y _12328_/A1 _14618_/Q _12307_/C VDD VSS sg13g2_a21oi_1
XFILLER_177_1015 VDD VSS sg13g2_decap_8
XFILLER_182_644 VDD VSS sg13g2_decap_8
X_13292_ _15055_/D _15055_/Q _07710_/Y _07694_/Y VDD VSS sg13g2_a21o_1
XFILLER_170_806 VDD VSS sg13g2_decap_8
XFILLER_6_868 VDD VSS sg13g2_decap_8
XFILLER_120_1272 VDD VSS sg13g2_decap_8
XFILLER_181_154 VDD VSS sg13g2_decap_8
X_15031_ _15031_/Q _15226_/CLK _15031_/D _15031_/RESET_B VDD VSS sg13g2_dfrbpq_1
X_12243_ _12243_/Y _12243_/A1 _14680_/Q _12184_/B VDD VSS sg13g2_a21oi_1
XFILLER_135_571 VDD VSS sg13g2_decap_4
XFILLER_5_378 VDD VSS sg13g2_decap_8
XFILLER_163_891 VDD VSS sg13g2_fill_1
XFILLER_29_1327 VDD VSS sg13g2_fill_1
X_12174_ _12174_/Y _12291_/A _12174_/B VDD VSS sg13g2_nor2_1
XFILLER_155_1335 VDD VSS sg13g2_decap_8
XFILLER_162_390 VDD VSS sg13g2_decap_8
XFILLER_174_63 VDD VSS sg13g2_decap_8
XFILLER_155_1346 VDD VSS sg13g2_fill_1
XFILLER_116_1308 VDD VSS sg13g2_decap_8
XFILLER_3_14 VDD VSS sg13g2_decap_8
XFILLER_150_563 VDD VSS sg13g2_decap_8
X_11125_ _11128_/B _11125_/A _11147_/A VDD VSS sg13g2_xnor2_1
XFILLER_96_628 VDD VSS sg13g2_decap_8
XFILLER_49_511 VDD VSS sg13g2_decap_4
XFILLER_104_991 VDD VSS sg13g2_decap_8
XFILLER_7_1134 VDD VSS sg13g2_decap_8
XFILLER_1_595 VDD VSS sg13g2_decap_8
X_11056_ _11056_/Y _11044_/C _11068_/C _11056_/B1 VDD VSS sg13g2_o21ai_1
XFILLER_37_706 VDD VSS sg13g2_decap_8
X_10007_ _14589_/D _10140_/A1 _14589_/Q _10030_/S VDD VSS sg13g2_mux2_1
XFILLER_76_363 VDD VSS sg13g2_fill_2
XFILLER_97_1016 VDD VSS sg13g2_decap_8
XFILLER_77_897 VDD VSS sg13g2_fill_1
XFILLER_114_1087 VDD VSS sg13g2_decap_8
XFILLER_18_920 VDD VSS sg13g2_fill_2
XFILLER_91_311 VDD VSS sg13g2_decap_8
XFILLER_149_1106 VDD VSS sg13g2_decap_4
X_14815_ _14815_/Q _14886_/CLK _14815_/D _14815_/RESET_B VDD VSS sg13g2_dfrbpq_1
XFILLER_52_709 VDD VSS sg13g2_decap_4
XFILLER_17_441 VDD VSS sg13g2_decap_8
XFILLER_40_1295 VDD VSS sg13g2_fill_1
X_14404__1868 _14404_/RESET_B VDD VSS sg13g2_tiehi
XFILLER_91_377 VDD VSS sg13g2_decap_8
X_14746_ _14746_/Q clkload53/A _14746_/D _14746_/RESET_B VDD VSS sg13g2_dfrbpq_1
XFILLER_83_71 VDD VSS sg13g2_decap_8
X_15041__2636 _15041_/RESET_B VDD VSS sg13g2_tiehi
X_11958_ _11958_/Y _11738_/S _14384_/Q VDD VSS sg13g2_nand2b_1
XFILLER_60_720 VDD VSS sg13g2_decap_8
XFILLER_33_945 VDD VSS sg13g2_decap_8
XFILLER_178_928 VDD VSS sg13g2_fill_1
X_10909_ _10954_/D wire276/X _10936_/D VDD VSS sg13g2_nand2_1
XFILLER_44_293 VDD VSS sg13g2_fill_2
X_14677_ _14677_/Q clkload28/A _14677_/D _14677_/RESET_B VDD VSS sg13g2_dfrbpq_1
X_11889_ _11889_/Y _11885_/Y _11886_/Y _11888_/Y _11887_/Y _11875_/B VDD VSS sg13g2_a221oi_1
XFILLER_177_427 VDD VSS sg13g2_decap_8
XFILLER_60_775 VDD VSS sg13g2_decap_8
XFILLER_32_466 VDD VSS sg13g2_decap_8
X_13628_ _13736_/D _13628_/A VDD VSS sg13g2_buf_1
XFILLER_38_1180 VDD VSS sg13g2_fill_2
X_13969__2303 _13969_/RESET_B VDD VSS sg13g2_tiehi
XFILLER_157_140 VDD VSS sg13g2_fill_1
XFILLER_9_651 VDD VSS sg13g2_decap_8
X_13559_ _13559_/Y _08138_/C _13564_/A2 _13558_/Y VDD VSS sg13g2_a21oi_1
XFILLER_121_1025 VDD VSS sg13g2_decap_8
XFILLER_157_162 VDD VSS sg13g2_fill_2
XFILLER_34_1077 VDD VSS sg13g2_decap_8
XFILLER_145_313 VDD VSS sg13g2_decap_8
XFILLER_34_1088 VDD VSS sg13g2_fill_1
XFILLER_8_161 VDD VSS sg13g2_decap_8
XFILLER_172_154 VDD VSS sg13g2_decap_8
X_15229_ _15229_/Q _15237_/CLK _15229_/D _15229_/RESET_B VDD VSS sg13g2_dfrbpq_1
XFILLER_12_1386 VDD VSS sg13g2_decap_8
XFILLER_99_400 VDD VSS sg13g2_decap_8
XFILLER_160_327 VDD VSS sg13g2_decap_8
XFILLER_173_1424 VDD VSS sg13g2_fill_2
XFILLER_82_1318 VDD VSS sg13g2_decap_8
XFILLER_134_1408 VDD VSS sg13g2_decap_8
XFILLER_99_477 VDD VSS sg13g2_decap_8
XFILLER_113_265 VDD VSS sg13g2_fill_2
X_07982_ _07985_/B _07834_/B _07980_/Y _15216_/Q VDD VSS sg13g2_o21ai_1
XFILLER_102_939 VDD VSS sg13g2_decap_8
XFILLER_68_820 VDD VSS sg13g2_fill_1
XFILLER_86_127 VDD VSS sg13g2_decap_4
XFILLER_45_1151 VDD VSS sg13g2_decap_4
X_09721_ _14312_/D _09919_/A1 _14312_/Q _09733_/S VDD VSS sg13g2_mux2_1
XFILLER_80_1064 VDD VSS sg13g2_decap_8
XFILLER_80_1075 VDD VSS sg13g2_fill_2
XFILLER_67_352 VDD VSS sg13g2_fill_1
XFILLER_110_972 VDD VSS sg13g2_decap_8
X_09652_ _14245_/D _09916_/A1 _14245_/Q _09665_/S VDD VSS sg13g2_mux2_1
Xclkbuf_5_18__f_clk_i clkbuf_leaf_18_clk_i/A clkbuf_4_9_0_clk_i/X VDD VSS sg13g2_buf_16
XFILLER_67_396 VDD VSS sg13g2_decap_8
X_08603_ _08603_/Y _13533_/A _08603_/B VDD VSS sg13g2_nand2b_1
X_09583_ _14180_/D _14180_/Q _09616_/A0 _09601_/S VDD VSS sg13g2_mux2_1
XFILLER_83_889 VDD VSS sg13g2_decap_8
XFILLER_70_506 VDD VSS sg13g2_fill_2
X_08534_ _08535_/A _08567_/B _08532_/Y _08533_/Y VDD VSS sg13g2_o21ai_1
XFILLER_42_208 VDD VSS sg13g2_decap_8
XFILLER_24_912 VDD VSS sg13g2_decap_8
XFILLER_36_783 VDD VSS sg13g2_decap_8
XFILLER_23_411 VDD VSS sg13g2_decap_4
XFILLER_169_917 VDD VSS sg13g2_decap_8
XFILLER_63_591 VDD VSS sg13g2_decap_8
XFILLER_54_1409 VDD VSS sg13g2_decap_8
X_08465_ _08465_/X _08471_/B _07949_/C _07945_/B _07946_/B _08686_/S0 _13510_/A1 VDD
+ VSS sg13g2_mux4_1
XFILLER_168_449 VDD VSS sg13g2_decap_8
XFILLER_10_105 VDD VSS sg13g2_decap_8
XFILLER_184_909 VDD VSS sg13g2_fill_1
X_08396_ _15233_/D _08395_/Y _08393_/Y _08388_/Y VDD VSS sg13g2_a21o_1
XFILLER_52_1133 VDD VSS sg13g2_decap_8
XFILLER_143_1261 VDD VSS sg13g2_decap_4
XFILLER_17_1264 VDD VSS sg13g2_decap_8
X_14559__1713 _14559_/RESET_B VDD VSS sg13g2_tiehi
XFILLER_13_1106 VDD VSS sg13g2_decap_8
XFILLER_136_302 VDD VSS sg13g2_fill_2
XFILLER_177_994 VDD VSS sg13g2_decap_8
XFILLER_104_1245 VDD VSS sg13g2_decap_8
XFILLER_143_1294 VDD VSS sg13g2_fill_1
XFILLER_149_696 VDD VSS sg13g2_decap_8
XFILLER_148_184 VDD VSS sg13g2_decap_8
XFILLER_164_633 VDD VSS sg13g2_decap_8
XFILLER_12_56 VDD VSS sg13g2_decap_8
XFILLER_152_806 VDD VSS sg13g2_decap_4
XFILLER_163_132 VDD VSS sg13g2_fill_1
XFILLER_124_508 VDD VSS sg13g2_decap_4
X_15239__3100 _15239_/RESET_B VDD VSS sg13g2_tiehi
X_09017_ _09017_/Y _09141_/A _10781_/B _10702_/A wire584/X VDD VSS sg13g2_a22oi_1
XFILLER_139_1319 VDD VSS sg13g2_decap_4
XFILLER_163_154 VDD VSS sg13g2_decap_8
XFILLER_3_805 VDD VSS sg13g2_decap_8
XFILLER_105_700 VDD VSS sg13g2_fill_1
XFILLER_2_315 VDD VSS sg13g2_decap_8
XFILLER_151_338 VDD VSS sg13g2_fill_2
XFILLER_88_49 VDD VSS sg13g2_decap_8
XFILLER_132_530 VDD VSS sg13g2_decap_8
XFILLER_160_861 VDD VSS sg13g2_decap_8
XFILLER_144_33 VDD VSS sg13g2_decap_8
XFILLER_105_799 VDD VSS sg13g2_decap_8
XFILLER_137_1087 VDD VSS sg13g2_fill_1
Xfanout630 _12914_/A _13561_/S VDD VSS sg13g2_buf_1
XFILLER_8_1421 VDD VSS sg13g2_decap_8
XFILLER_104_287 VDD VSS sg13g2_decap_8
Xfanout641 _11048_/B _11021_/B VDD VSS sg13g2_buf_1
Xfanout652 _10757_/A _10740_/A1 VDD VSS sg13g2_buf_1
X_09919_ _14504_/D _14504_/Q _09919_/A1 _09929_/S VDD VSS sg13g2_mux2_1
XFILLER_63_1262 VDD VSS sg13g2_decap_8
XFILLER_59_842 VDD VSS sg13g2_decap_8
Xfanout663 _08848_/A _10669_/S VDD VSS sg13g2_buf_1
Xfanout674 _13508_/C _08835_/B VDD VSS sg13g2_buf_1
Xfanout685 _08654_/B _07997_/Y VDD VSS sg13g2_buf_1
XFILLER_24_1246 VDD VSS sg13g2_decap_8
X_12930_ _12930_/Y _14807_/Q _13274_/A2 _13218_/B _14839_/Q _13248_/B VDD VSS sg13g2_a221oi_1
XFILLER_86_672 VDD VSS sg13g2_decap_8
XFILLER_74_812 VDD VSS sg13g2_fill_2
XFILLER_58_363 VDD VSS sg13g2_decap_8
XFILLER_86_683 VDD VSS sg13g2_fill_2
XFILLER_100_471 VDD VSS sg13g2_fill_1
XFILLER_37_42 VDD VSS sg13g2_decap_8
XFILLER_100_482 VDD VSS sg13g2_decap_8
XFILLER_150_1287 VDD VSS sg13g2_decap_8
XFILLER_160_21 VDD VSS sg13g2_decap_8
XFILLER_74_845 VDD VSS sg13g2_fill_1
XFILLER_18_238 VDD VSS sg13g2_decap_8
X_12861_ _12861_/X _12861_/A _12861_/B VDD VSS sg13g2_xor2_1
XFILLER_73_344 VDD VSS sg13g2_decap_4
XFILLER_46_558 VDD VSS sg13g2_decap_8
XFILLER_74_889 VDD VSS sg13g2_decap_8
X_14600_ _14600_/Q _14664_/CLK _14600_/D _14600_/RESET_B VDD VSS sg13g2_dfrbpq_1
XFILLER_2_1064 VDD VSS sg13g2_decap_8
X_11812_ _11812_/Y _12103_/A1 _14668_/Q _11802_/B VDD VSS sg13g2_a21oi_1
XFILLER_160_98 VDD VSS sg13g2_decap_8
XFILLER_73_388 VDD VSS sg13g2_decap_4
XFILLER_61_528 VDD VSS sg13g2_decap_8
XFILLER_15_934 VDD VSS sg13g2_decap_8
X_12792_ _15020_/D _12792_/A _12792_/B VDD VSS sg13g2_nor2_1
XFILLER_42_720 VDD VSS sg13g2_decap_8
XFILLER_26_271 VDD VSS sg13g2_decap_8
XFILLER_148_1161 VDD VSS sg13g2_fill_1
XFILLER_54_591 VDD VSS sg13g2_decap_8
XFILLER_156_0 VDD VSS sg13g2_decap_8
X_14531_ _14531_/Q _14723_/CLK _14531_/D _14531_/RESET_B VDD VSS sg13g2_dfrbpq_1
XFILLER_57_1055 VDD VSS sg13g2_fill_1
XFILLER_26_293 VDD VSS sg13g2_fill_1
X_11743_ _11743_/Y _11743_/A _11743_/B _11953_/C VDD VSS sg13g2_nand3_1
XFILLER_144_1014 VDD VSS sg13g2_decap_4
XFILLER_14_455 VDD VSS sg13g2_decap_8
XFILLER_109_1145 VDD VSS sg13g2_decap_8
XFILLER_53_63 VDD VSS sg13g2_decap_4
XFILLER_183_1096 VDD VSS sg13g2_fill_2
XFILLER_70_1200 VDD VSS sg13g2_decap_8
XFILLER_105_1009 VDD VSS sg13g2_fill_2
X_14462_ _14462_/Q _14734_/CLK _14462_/D _14462_/RESET_B VDD VSS sg13g2_dfrbpq_1
XFILLER_42_797 VDD VSS sg13g2_decap_8
XFILLER_169_63 VDD VSS sg13g2_decap_8
XFILLER_186_246 VDD VSS sg13g2_decap_8
X_11674_ _11674_/Y _12033_/A1 _14600_/Q _12236_/C VDD VSS sg13g2_a21oi_1
XFILLER_30_948 VDD VSS sg13g2_decap_8
XFILLER_186_257 VDD VSS sg13g2_decap_8
XFILLER_35_1353 VDD VSS sg13g2_decap_8
XFILLER_174_408 VDD VSS sg13g2_decap_8
X_13413_ _13444_/B _15198_/Q _15199_/Q _13490_/B _13490_/C VDD VSS sg13g2_or4_1
XFILLER_35_1364 VDD VSS sg13g2_fill_1
XFILLER_128_814 VDD VSS sg13g2_decap_8
X_10625_ _10626_/A _14883_/Q _14882_/Q _10651_/D _10625_/D VDD VSS sg13g2_nand4_1
XFILLER_168_994 VDD VSS sg13g2_decap_4
X_14393_ _14393_/Q clkload36/A _14393_/D _14393_/RESET_B VDD VSS sg13g2_dfrbpq_1
XFILLER_10_672 VDD VSS sg13g2_decap_8
XFILLER_127_324 VDD VSS sg13g2_decap_8
X_13344_ _15069_/D _13341_/A _15174_/D _13343_/Y VDD VSS sg13g2_o21ai_1
X_10556_ _10557_/B _14867_/Q _14866_/Q _14865_/Q _10556_/D VDD VSS sg13g2_nand4_1
XFILLER_182_441 VDD VSS sg13g2_decap_8
XFILLER_143_817 VDD VSS sg13g2_decap_8
XFILLER_157_1408 VDD VSS sg13g2_fill_2
XFILLER_6_665 VDD VSS sg13g2_decap_8
XFILLER_154_165 VDD VSS sg13g2_decap_8
X_13275_ _13275_/Y _14798_/Q _13275_/A2 _13275_/B1 VDD VSS sg13g2_o21ai_1
X_10487_ _14849_/D _10580_/B _10487_/B _10495_/D VDD VSS sg13g2_nor3_1
XFILLER_120_1080 VDD VSS sg13g2_fill_2
XFILLER_185_84 VDD VSS sg13g2_decap_8
XFILLER_5_175 VDD VSS sg13g2_decap_8
XFILLER_154_198 VDD VSS sg13g2_decap_8
X_14861__2915 _14861_/RESET_B VDD VSS sg13g2_tiehi
X_15014_ _15014_/Q _15019_/CLK _15014_/D _15014_/RESET_B VDD VSS sg13g2_dfrbpq_1
X_12226_ _14985_/D _12203_/A _12271_/A _12225_/Y VDD VSS sg13g2_a21o_1
XFILLER_68_1162 VDD VSS sg13g2_decap_8
XFILLER_135_390 VDD VSS sg13g2_decap_8
XFILLER_45_7 VDD VSS sg13g2_decap_8
XFILLER_123_541 VDD VSS sg13g2_fill_1
XFILLER_111_703 VDD VSS sg13g2_decap_8
XFILLER_123_563 VDD VSS sg13g2_decap_8
XFILLER_9_1218 VDD VSS sg13g2_decap_8
XFILLER_69_617 VDD VSS sg13g2_decap_8
X_12157_ _12157_/Y _12186_/A _14134_/Q VDD VSS sg13g2_nand2b_1
XFILLER_96_403 VDD VSS sg13g2_fill_2
XFILLER_111_725 VDD VSS sg13g2_decap_8
XFILLER_2_882 VDD VSS sg13g2_decap_8
XFILLER_116_1149 VDD VSS sg13g2_fill_1
X_11108_ _11109_/A _10764_/X _11097_/Y _11107_/Y VDD VSS sg13g2_o21ai_1
XFILLER_46_1471 VDD VSS sg13g2_decap_4
XFILLER_1_392 VDD VSS sg13g2_decap_8
X_12088_ _12092_/A _12087_/X _12166_/B VDD VSS sg13g2_nand2b_1
XFILLER_49_330 VDD VSS sg13g2_decap_8
XFILLER_42_1335 VDD VSS sg13g2_decap_8
X_14894__2849 _14894_/RESET_B VDD VSS sg13g2_tiehi
XFILLER_77_661 VDD VSS sg13g2_decap_8
XFILLER_110_279 VDD VSS sg13g2_decap_8
XFILLER_133_1474 VDD VSS sg13g2_fill_1
X_11039_ _11043_/B _11052_/A _11052_/D _11052_/B VDD VSS sg13g2_o21ai_1
XFILLER_92_620 VDD VSS sg13g2_decap_8
X_14637__1635 _14637_/RESET_B VDD VSS sg13g2_tiehi
XFILLER_64_322 VDD VSS sg13g2_fill_1
XFILLER_94_81 VDD VSS sg13g2_decap_8
XFILLER_65_867 VDD VSS sg13g2_decap_8
XFILLER_37_558 VDD VSS sg13g2_fill_2
XFILLER_80_804 VDD VSS sg13g2_decap_8
XFILLER_18_761 VDD VSS sg13g2_decap_8
XFILLER_75_1111 VDD VSS sg13g2_fill_2
XFILLER_24_219 VDD VSS sg13g2_fill_2
XFILLER_33_731 VDD VSS sg13g2_fill_2
XFILLER_162_1103 VDD VSS sg13g2_decap_8
X_14729_ _14729_/Q _14729_/CLK _14729_/D _14729_/RESET_B VDD VSS sg13g2_dfrbpq_1
XFILLER_33_764 VDD VSS sg13g2_decap_8
XFILLER_177_224 VDD VSS sg13g2_decap_8
XFILLER_20_403 VDD VSS sg13g2_fill_1
X_08250_ _08250_/X _08318_/A _08250_/B VDD VSS sg13g2_xor2_1
XFILLER_32_263 VDD VSS sg13g2_decap_8
XFILLER_127_1278 VDD VSS sg13g2_fill_1
XFILLER_162_1158 VDD VSS sg13g2_decap_8
XFILLER_178_769 VDD VSS sg13g2_decap_8
XFILLER_159_961 VDD VSS sg13g2_fill_1
X_15005__2675 _15005_/RESET_B VDD VSS sg13g2_tiehi
XFILLER_119_814 VDD VSS sg13g2_decap_4
XFILLER_140_1412 VDD VSS sg13g2_decap_8
X_08181_ _08183_/C _14961_/Q _07911_/A _08162_/Y VDD VSS sg13g2_a21oi_1
XFILLER_71_0 VDD VSS sg13g2_decap_8
XFILLER_119_858 VDD VSS sg13g2_decap_4
XFILLER_145_110 VDD VSS sg13g2_decap_8
XFILLER_158_493 VDD VSS sg13g2_decap_4
XFILLER_119_869 VDD VSS sg13g2_fill_2
XFILLER_145_121 VDD VSS sg13g2_fill_2
XFILLER_146_644 VDD VSS sg13g2_decap_4
XFILLER_118_357 VDD VSS sg13g2_decap_4
XFILLER_146_666 VDD VSS sg13g2_decap_4
XFILLER_133_305 VDD VSS sg13g2_decap_8
XFILLER_173_485 VDD VSS sg13g2_decap_8
XFILLER_12_1183 VDD VSS sg13g2_decap_8
XFILLER_177_1390 VDD VSS sg13g2_fill_2
XFILLER_88_904 VDD VSS sg13g2_decap_8
XFILLER_86_1273 VDD VSS sg13g2_decap_8
XFILLER_47_1235 VDD VSS sg13g2_fill_2
XFILLER_160_168 VDD VSS sg13g2_decap_8
XFILLER_99_263 VDD VSS sg13g2_decap_8
XFILLER_102_725 VDD VSS sg13g2_decap_8
XFILLER_47_1268 VDD VSS sg13g2_decap_8
X_07965_ _07965_/Y _15016_/Q _07965_/B VDD VSS sg13g2_nand2b_1
X_14276__1996 _14276_/RESET_B VDD VSS sg13g2_tiehi
XFILLER_96_970 VDD VSS sg13g2_decap_8
X_09704_ _14296_/D _09770_/A1 _14296_/Q _09704_/S VDD VSS sg13g2_mux2_1
XFILLER_68_672 VDD VSS sg13g2_fill_2
XFILLER_68_683 VDD VSS sg13g2_fill_1
X_07896_ _07896_/X _08023_/A _07903_/B VDD VSS sg13g2_and2_1
XFILLER_95_480 VDD VSS sg13g2_decap_8
XFILLER_67_182 VDD VSS sg13g2_decap_4
XFILLER_56_845 VDD VSS sg13g2_decap_4
X_09635_ _14231_/D _10099_/A0 _14231_/Q _09637_/S VDD VSS sg13g2_mux2_1
XFILLER_3_1351 VDD VSS sg13g2_decap_8
XFILLER_83_675 VDD VSS sg13g2_decap_8
XFILLER_43_506 VDD VSS sg13g2_decap_8
XFILLER_71_826 VDD VSS sg13g2_decap_4
X_09566_ _14164_/D _09799_/A0 _14164_/Q _09570_/S VDD VSS sg13g2_mux2_1
XFILLER_93_1211 VDD VSS sg13g2_decap_8
X_13731__2541 _13731_/RESET_B VDD VSS sg13g2_tiehi
XFILLER_184_1361 VDD VSS sg13g2_decap_8
XFILLER_19_1315 VDD VSS sg13g2_decap_8
X_14491__1781 _14491_/RESET_B VDD VSS sg13g2_tiehi
X_08517_ _15239_/D _08517_/A _08517_/B _08517_/C _08517_/D VDD VSS sg13g2_nand4_1
XFILLER_54_1206 VDD VSS sg13g2_decap_8
XFILLER_169_725 VDD VSS sg13g2_decap_8
X_09497_ _14097_/D _10093_/A0 _14097_/Q _09497_/S VDD VSS sg13g2_mux2_1
XFILLER_90_28 VDD VSS sg13g2_decap_4
XFILLER_106_1318 VDD VSS sg13g2_decap_8
X_08448_ _08448_/Y _08497_/A _08443_/Y _08447_/X VDD VSS sg13g2_a21oi_1
XFILLER_145_1378 VDD VSS sg13g2_decap_8
XFILLER_12_959 VDD VSS sg13g2_decap_8
XFILLER_17_1061 VDD VSS sg13g2_decap_8
X_08379_ _08379_/Y _08621_/A _08544_/A VDD VSS sg13g2_nand2_1
XFILLER_11_469 VDD VSS sg13g2_decap_8
XFILLER_177_780 VDD VSS sg13g2_decap_8
XFILLER_109_313 VDD VSS sg13g2_decap_8
XFILLER_137_622 VDD VSS sg13g2_decap_8
XFILLER_23_77 VDD VSS sg13g2_decap_8
XFILLER_183_238 VDD VSS sg13g2_decap_8
X_14111__2161 _14111_/RESET_B VDD VSS sg13g2_tiehi
X_10410_ _10414_/D _14823_/Q _14824_/Q _14825_/Q _14826_/Q VDD VSS sg13g2_and4_1
XFILLER_139_77 VDD VSS sg13g2_decap_8
X_11390_ _11391_/A _11804_/A _13887_/Q VDD VSS sg13g2_nand2b_1
XFILLER_99_37 VDD VSS sg13g2_decap_8
XFILLER_87_1015 VDD VSS sg13g2_decap_8
XFILLER_164_463 VDD VSS sg13g2_decap_8
XFILLER_180_912 VDD VSS sg13g2_decap_8
X_10341_ _10343_/A _10313_/X _10357_/D _14807_/Q VDD VSS sg13g2_a21o_1
XFILLER_3_602 VDD VSS sg13g2_decap_8
XFILLER_137_699 VDD VSS sg13g2_decap_8
XFILLER_151_102 VDD VSS sg13g2_decap_8
Xclkbuf_leaf_124_clk_i clkload20/A clkload1/A VDD VSS sg13g2_buf_8
XFILLER_155_21 VDD VSS sg13g2_decap_8
X_14715__1557 _14715_/RESET_B VDD VSS sg13g2_tiehi
XFILLER_152_647 VDD VSS sg13g2_decap_8
X_13060_ _13060_/Y _13042_/A _13037_/Y _13057_/C VDD VSS sg13g2_o21ai_1
XFILLER_2_112 VDD VSS sg13g2_decap_8
X_10272_ _10281_/D _10299_/A _10299_/B VDD VSS sg13g2_nor2_1
XFILLER_140_809 VDD VSS sg13g2_decap_8
XFILLER_79_904 VDD VSS sg13g2_decap_8
Xpicorv32_macro_1510 mem_axi_arprot[1] VDD VSS sg13g2_tielo
X_12011_ _12011_/X _12012_/A _11988_/Y _12055_/D VDD VSS sg13g2_a21o_1
XFILLER_151_168 VDD VSS sg13g2_decap_8
XFILLER_3_679 VDD VSS sg13g2_decap_8
XFILLER_151_179 VDD VSS sg13g2_fill_2
XFILLER_133_894 VDD VSS sg13g2_decap_8
XFILLER_156_1474 VDD VSS sg13g2_decap_4
XFILLER_155_98 VDD VSS sg13g2_decap_8
XFILLER_160_680 VDD VSS sg13g2_decap_4
Xfanout1403 _12114_/S0 _12035_/S0 VDD VSS sg13g2_buf_1
XFILLER_117_1447 VDD VSS sg13g2_decap_8
Xfanout1414 _11412_/S0 fanout1419/X VDD VSS sg13g2_buf_1
XFILLER_2_189 VDD VSS sg13g2_decap_8
Xfanout1425 _11365_/A _11226_/S0 VDD VSS sg13g2_buf_1
Xfanout1436 _11275_/S0 _11279_/A1 VDD VSS sg13g2_buf_1
XFILLER_94_918 VDD VSS sg13g2_decap_8
Xfanout1447 _12245_/S0 fanout1452/X VDD VSS sg13g2_buf_1
XFILLER_63_1070 VDD VSS sg13g2_decap_8
Xfanout460 _10120_/S _10136_/S VDD VSS sg13g2_buf_1
Xfanout1458 _11493_/S0 _11444_/S0 VDD VSS sg13g2_buf_1
XFILLER_48_63 VDD VSS sg13g2_decap_8
XFILLER_171_42 VDD VSS sg13g2_decap_8
Xfanout471 _09997_/S _10003_/S VDD VSS sg13g2_buf_1
Xfanout1469 _10608_/B _10347_/B VDD VSS sg13g2_buf_1
XFILLER_120_588 VDD VSS sg13g2_fill_1
Xfanout482 _09804_/S _09793_/S VDD VSS sg13g2_buf_1
X_13962_ _13962_/Q clkload16/A _13962_/D _13962_/RESET_B VDD VSS sg13g2_dfrbpq_1
Xfanout493 _09567_/S _09571_/S VDD VSS sg13g2_buf_1
XFILLER_150_1062 VDD VSS sg13g2_decap_4
XFILLER_8_1295 VDD VSS sg13g2_decap_8
XFILLER_74_620 VDD VSS sg13g2_decap_4
XFILLER_4_1148 VDD VSS sg13g2_decap_8
X_12913_ _12914_/C _12842_/A _12867_/C input10/X VDD VSS sg13g2_a21oi_1
XFILLER_46_333 VDD VSS sg13g2_fill_1
XFILLER_111_1046 VDD VSS sg13g2_decap_8
XFILLER_185_1103 VDD VSS sg13g2_decap_4
XFILLER_46_344 VDD VSS sg13g2_decap_4
XFILLER_111_1057 VDD VSS sg13g2_decap_8
X_13893_ _13893_/Q clkload12/A _13893_/D _13893_/RESET_B VDD VSS sg13g2_dfrbpq_1
XFILLER_98_1166 VDD VSS sg13g2_fill_2
XFILLER_59_1117 VDD VSS sg13g2_fill_1
XFILLER_104_91 VDD VSS sg13g2_decap_8
X_12844_ _12845_/D _12899_/A _12867_/C _12936_/B input23/X VDD VSS sg13g2_nand4_1
XFILLER_73_174 VDD VSS sg13g2_decap_8
XFILLER_15_742 VDD VSS sg13g2_decap_8
XFILLER_37_1404 VDD VSS sg13g2_decap_8
X_14321__1951 _14321_/RESET_B VDD VSS sg13g2_tiehi
X_12775_ _12775_/X _12769_/X _12773_/X _12768_/X _12772_/X _12553_/S _12775_/S1 VDD
+ VSS sg13g2_mux4_1
XFILLER_14_252 VDD VSS sg13g2_decap_8
X_14514_ _14514_/Q clkload15/A _14514_/D _14514_/RESET_B VDD VSS sg13g2_dfrbpq_1
XFILLER_9_35 VDD VSS sg13g2_decap_8
XFILLER_72_1339 VDD VSS sg13g2_fill_2
X_11726_ _11773_/D _11726_/A _13678_/Q VDD VSS sg13g2_xnor2_1
XFILLER_148_909 VDD VSS sg13g2_decap_8
XFILLER_124_1429 VDD VSS sg13g2_decap_4
X_14804__3002 _14804_/RESET_B VDD VSS sg13g2_tiehi
XFILLER_42_594 VDD VSS sg13g2_decap_8
XFILLER_175_717 VDD VSS sg13g2_decap_8
X_14445_ _14445_/Q _14669_/CLK _14445_/D _14445_/RESET_B VDD VSS sg13g2_dfrbpq_1
X_11657_ _11657_/Y _11656_/Y _11655_/Y _11643_/Y _11722_/B2 _12271_/A VDD VSS sg13g2_a221oi_1
XFILLER_80_83 VDD VSS sg13g2_fill_2
XFILLER_35_1172 VDD VSS sg13g2_decap_8
XFILLER_70_1063 VDD VSS sg13g2_decap_8
XFILLER_174_238 VDD VSS sg13g2_decap_8
X_10608_ _14878_/D _10629_/C _10608_/B _10608_/C VDD VSS sg13g2_nor3_1
X_14376_ _14376_/Q _14740_/CLK _14376_/D _14376_/RESET_B VDD VSS sg13g2_dfrbpq_1
XFILLER_155_441 VDD VSS sg13g2_fill_1
X_11588_ _14967_/D _11570_/A _12271_/A _11587_/Y VDD VSS sg13g2_a21o_1
XFILLER_7_952 VDD VSS sg13g2_decap_8
XFILLER_128_666 VDD VSS sg13g2_decap_8
XFILLER_128_677 VDD VSS sg13g2_fill_2
XFILLER_122_1197 VDD VSS sg13g2_decap_8
XFILLER_13_1470 VDD VSS sg13g2_decap_8
XFILLER_143_614 VDD VSS sg13g2_decap_8
XFILLER_155_474 VDD VSS sg13g2_decap_8
XFILLER_156_997 VDD VSS sg13g2_decap_8
X_13327_ _13328_/B _15114_/Q _13306_/B _13309_/Y _15067_/Q VDD VSS sg13g2_a22oi_1
X_10539_ _14861_/D _10543_/C _10543_/D _10535_/B _07622_/Y _10577_/B VDD VSS sg13g2_a221oi_1
XFILLER_6_462 VDD VSS sg13g2_decap_8
XFILLER_183_794 VDD VSS sg13g2_fill_2
XFILLER_89_70 VDD VSS sg13g2_decap_8
X_13258_ _13259_/B _14924_/Q _13663_/Q VDD VSS sg13g2_xnor2_1
X_12209_ _12210_/B _14711_/Q _14743_/Q _13783_/Q _13815_/Q _12213_/S0 _12169_/C VDD
+ VSS sg13g2_mux4_1
XFILLER_9_1015 VDD VSS sg13g2_decap_8
XFILLER_111_500 VDD VSS sg13g2_decap_8
XFILLER_83_1457 VDD VSS sg13g2_decap_8
X_13189_ _13189_/X _13190_/A _13190_/B _13225_/B VDD VSS sg13g2_and3_1
XFILLER_111_544 VDD VSS sg13g2_fill_1
XFILLER_97_767 VDD VSS sg13g2_decap_8
XFILLER_78_981 VDD VSS sg13g2_fill_1
XFILLER_133_1260 VDD VSS sg13g2_fill_2
X_07750_ _15207_/D _07750_/A _07750_/B VDD VSS sg13g2_or2_1
XFILLER_81_1192 VDD VSS sg13g2_decap_8
XFILLER_38_823 VDD VSS sg13g2_decap_8
XFILLER_84_439 VDD VSS sg13g2_decap_8
XFILLER_65_631 VDD VSS sg13g2_decap_8
XFILLER_93_951 VDD VSS sg13g2_decap_4
XFILLER_65_642 VDD VSS sg13g2_fill_1
XFILLER_38_856 VDD VSS sg13g2_decap_8
X_14153__2119 _14153_/RESET_B VDD VSS sg13g2_tiehi
X_07681_ _07687_/A _07677_/Y _07680_/Y _11241_/C _11241_/A VDD VSS sg13g2_a22oi_1
X_16879_ _16879_/X _16879_/A VDD VSS sg13g2_buf_1
XFILLER_53_804 VDD VSS sg13g2_decap_8
XFILLER_20_1441 VDD VSS sg13g2_decap_8
X_09420_ _14022_/D _09618_/A0 _14022_/Q _09428_/S VDD VSS sg13g2_mux2_1
XFILLER_25_517 VDD VSS sg13g2_decap_4
XFILLER_168_1356 VDD VSS sg13g2_fill_1
XFILLER_65_697 VDD VSS sg13g2_decap_8
XFILLER_168_1367 VDD VSS sg13g2_fill_1
XFILLER_92_483 VDD VSS sg13g2_decap_8
X_09351_ _13955_/D _09582_/A1 _13955_/Q _09363_/S VDD VSS sg13g2_mux2_1
XFILLER_178_511 VDD VSS sg13g2_decap_8
XFILLER_166_1080 VDD VSS sg13g2_decap_8
XFILLER_166_1091 VDD VSS sg13g2_fill_1
X_08302_ _08625_/B _08138_/A _08234_/Y _08452_/C _08301_/X VDD VSS sg13g2_a22oi_1
XFILLER_21_723 VDD VSS sg13g2_decap_8
X_09282_ _13890_/D _13890_/Q _10045_/A0 _09305_/S VDD VSS sg13g2_mux2_1
XFILLER_100_49 VDD VSS sg13g2_decap_8
XFILLER_21_745 VDD VSS sg13g2_decap_8
X_08233_ _15225_/D _08232_/Y _08233_/B _08233_/C VDD VSS sg13g2_nand3b_1
XFILLER_178_588 VDD VSS sg13g2_decap_8
XFILLER_18_1381 VDD VSS sg13g2_decap_8
XFILLER_119_611 VDD VSS sg13g2_decap_8
XFILLER_159_780 VDD VSS sg13g2_fill_2
XFILLER_140_1220 VDD VSS sg13g2_fill_1
XFILLER_20_266 VDD VSS sg13g2_decap_8
X_08164_ _08164_/Y _08163_/Y _07871_/X _08039_/A VDD VSS sg13g2_a21oi_1
XFILLER_101_1204 VDD VSS sg13g2_decap_4
Xclkbuf_leaf_41_clk_i clkload45/A clkbuf_leaf_47_clk_i/A VDD VSS sg13g2_buf_8
XFILLER_109_14 VDD VSS sg13g2_decap_4
XFILLER_140_1264 VDD VSS sg13g2_fill_1
XFILLER_14_1267 VDD VSS sg13g2_decap_8
XFILLER_118_143 VDD VSS sg13g2_decap_4
XFILLER_119_666 VDD VSS sg13g2_fill_1
XFILLER_105_1395 VDD VSS sg13g2_decap_8
XFILLER_101_1237 VDD VSS sg13g2_fill_1
XFILLER_119_688 VDD VSS sg13g2_fill_1
XFILLER_161_400 VDD VSS sg13g2_fill_2
X_08095_ _08199_/C _08296_/A1 _08304_/A _07786_/A _07782_/A _08253_/S0 _08402_/A VDD
+ VSS sg13g2_mux4_1
XFILLER_88_1357 VDD VSS sg13g2_decap_8
XFILLER_118_176 VDD VSS sg13g2_decap_4
XFILLER_162_934 VDD VSS sg13g2_decap_8
XFILLER_179_1474 VDD VSS sg13g2_fill_1
XFILLER_106_327 VDD VSS sg13g2_decap_8
XFILLER_175_1316 VDD VSS sg13g2_decap_8
XFILLER_49_1319 VDD VSS sg13g2_fill_2
XFILLER_106_338 VDD VSS sg13g2_fill_1
Xclkload70 clkload70/Y clkload70/A VDD VSS sg13g2_inv_4
Xclkload81 clkload81/Y clkload81/A VDD VSS sg13g2_inv_2
XFILLER_161_466 VDD VSS sg13g2_decap_8
XFILLER_88_701 VDD VSS sg13g2_fill_1
XFILLER_115_872 VDD VSS sg13g2_decap_8
Xclkbuf_leaf_56_clk_i _15237_/CLK clkbuf_leaf_59_clk_i/A VDD VSS sg13g2_buf_8
XFILLER_0_616 VDD VSS sg13g2_decap_8
XFILLER_114_360 VDD VSS sg13g2_fill_2
X_14363__1909 _14363_/RESET_B VDD VSS sg13g2_tiehi
X_13749__2523 _13749_/RESET_B VDD VSS sg13g2_tiehi
XFILLER_134_1024 VDD VSS sg13g2_decap_8
XFILLER_142_691 VDD VSS sg13g2_decap_8
XFILLER_173_1073 VDD VSS sg13g2_fill_2
XFILLER_125_46 VDD VSS sg13g2_decap_8
XFILLER_130_842 VDD VSS sg13g2_decap_8
XFILLER_130_853 VDD VSS sg13g2_fill_2
XFILLER_125_68 VDD VSS sg13g2_decap_4
X_08997_ _13760_/D _13760_/Q _10143_/A1 _09160_/S VDD VSS sg13g2_mux2_1
XFILLER_87_266 VDD VSS sg13g2_decap_8
XFILLER_64_1390 VDD VSS sg13g2_decap_8
XFILLER_47_108 VDD VSS sg13g2_decap_8
X_07948_ _07950_/B _07948_/A _08443_/A _07950_/A _07949_/B VDD VSS sg13g2_nand4_1
XFILLER_5_1435 VDD VSS sg13g2_decap_8
XFILLER_25_1385 VDD VSS sg13g2_decap_8
XFILLER_112_1344 VDD VSS sg13g2_decap_8
XFILLER_21_1249 VDD VSS sg13g2_decap_8
X_07879_ _07879_/Y _07879_/A _13525_/A VDD VSS sg13g2_xnor2_1
XFILLER_186_1434 VDD VSS sg13g2_decap_8
XFILLER_18_77 VDD VSS sg13g2_decap_8
X_14129__2143 _14129_/RESET_B VDD VSS sg13g2_tiehi
XFILLER_43_303 VDD VSS sg13g2_decap_8
X_09618_ _14214_/D _09618_/A0 _14214_/Q _09638_/S VDD VSS sg13g2_mux2_1
XFILLER_16_539 VDD VSS sg13g2_decap_8
XFILLER_71_623 VDD VSS sg13g2_fill_2
X_10890_ _10890_/Y _10890_/A _10890_/B _10890_/C VDD VSS sg13g2_nor3_1
XFILLER_147_1429 VDD VSS sg13g2_decap_8
XFILLER_93_1030 VDD VSS sg13g2_decap_8
XFILLER_71_667 VDD VSS sg13g2_fill_1
XFILLER_19_1112 VDD VSS sg13g2_decap_8
X_09549_ _14147_/D _09582_/A1 _14147_/Q _09567_/S VDD VSS sg13g2_mux2_1
XFILLER_34_21 VDD VSS sg13g2_decap_8
XFILLER_54_1003 VDD VSS sg13g2_decap_4
XFILLER_180_1033 VDD VSS sg13g2_decap_4
X_12560_ _12560_/X _14250_/Q _14282_/Q _14314_/Q _14346_/Q _12564_/S0 _12564_/S1 VDD
+ VSS sg13g2_mux4_1
XFILLER_93_1085 VDD VSS sg13g2_decap_8
XFILLER_12_756 VDD VSS sg13g2_decap_8
XFILLER_19_1189 VDD VSS sg13g2_decap_8
X_11511_ _11511_/X _14563_/Q _14595_/Q _14627_/Q _14659_/Q _12284_/S0 _12284_/S1 VDD
+ VSS sg13g2_mux4_1
XFILLER_169_599 VDD VSS sg13g2_decap_8
X_13997__2275 _13997_/RESET_B VDD VSS sg13g2_tiehi
X_12491_ _12491_/X _14565_/Q _14597_/Q _14629_/Q _14661_/Q _12654_/S0 _12654_/S1 VDD
+ VSS sg13g2_mux4_1
XFILLER_71_1361 VDD VSS sg13g2_decap_8
XFILLER_11_266 VDD VSS sg13g2_decap_8
XFILLER_156_227 VDD VSS sg13g2_decap_8
XFILLER_180_1099 VDD VSS sg13g2_decap_8
XFILLER_184_536 VDD VSS sg13g2_decap_8
XFILLER_184_547 VDD VSS sg13g2_fill_2
XFILLER_8_749 VDD VSS sg13g2_decap_8
X_14230_ _14230_/Q clkload69/A _14230_/D _14230_/RESET_B VDD VSS sg13g2_dfrbpq_1
XFILLER_109_121 VDD VSS sg13g2_decap_8
X_11442_ _11443_/B _13824_/Q _13856_/Q _13888_/Q _13920_/Q _11442_/S0 _11442_/S1 VDD
+ VSS sg13g2_mux4_1
XFILLER_50_42 VDD VSS sg13g2_decap_4
XFILLER_7_259 VDD VSS sg13g2_decap_8
XFILLER_32_1378 VDD VSS sg13g2_decap_8
XFILLER_125_603 VDD VSS sg13g2_decap_8
XFILLER_165_772 VDD VSS sg13g2_decap_8
XFILLER_119_0 VDD VSS sg13g2_decap_8
XFILLER_166_42 VDD VSS sg13g2_decap_8
X_14161_ _14161_/Q _14513_/CLK _14161_/D _14161_/RESET_B VDD VSS sg13g2_dfrbpq_1
X_11373_ _11374_/B _11896_/A _14206_/Q VDD VSS sg13g2_nand2_1
XFILLER_124_102 VDD VSS sg13g2_decap_8
XFILLER_125_636 VDD VSS sg13g2_decap_8
X_13112_ _13172_/C _13112_/A _13104_/A VDD VSS sg13g2_nor2b_1
X_10324_ _10325_/B _14799_/Q _14800_/Q _14801_/Q _10414_/B VDD VSS sg13g2_nand4_1
XFILLER_113_809 VDD VSS sg13g2_fill_1
X_14092_ _14092_/Q clkload17/A _14092_/D _14092_/RESET_B VDD VSS sg13g2_dfrbpq_1
XFILLER_4_966 VDD VSS sg13g2_decap_8
XFILLER_69_1290 VDD VSS sg13g2_decap_8
XFILLER_152_477 VDD VSS sg13g2_fill_1
XFILLER_1_0 VDD VSS sg13g2_decap_8
XFILLER_106_883 VDD VSS sg13g2_decap_8
X_13043_ _13043_/Y _13041_/Y _13043_/B _13271_/C VDD VSS sg13g2_nand3b_1
X_10255_ _10265_/D _14778_/Q _14779_/Q _14780_/Q _10255_/D VDD VSS sg13g2_nand4_1
XFILLER_3_476 VDD VSS sg13g2_decap_8
XFILLER_65_1143 VDD VSS sg13g2_decap_8
XFILLER_121_820 VDD VSS sg13g2_fill_2
XFILLER_152_1102 VDD VSS sg13g2_decap_4
XFILLER_79_734 VDD VSS sg13g2_fill_1
XFILLER_59_62 VDD VSS sg13g2_decap_8
XFILLER_152_1113 VDD VSS sg13g2_fill_2
Xfanout1200 _07790_/A _08887_/A1 VDD VSS sg13g2_buf_1
X_14339__1933 _14339_/RESET_B VDD VSS sg13g2_tiehi
Xfanout1211 _11570_/A _14967_/Q VDD VSS sg13g2_buf_1
XFILLER_26_1138 VDD VSS sg13g2_decap_8
XFILLER_117_1255 VDD VSS sg13g2_decap_8
XFILLER_182_63 VDD VSS sg13g2_decap_8
Xfanout1222 _08235_/A0 _14964_/Q VDD VSS sg13g2_buf_1
X_10186_ _14749_/D _10185_/Y _14749_/Q _08858_/S VDD VSS sg13g2_a21o_1
XFILLER_39_609 VDD VSS sg13g2_decap_8
Xfanout1233 _11335_/A _14959_/Q VDD VSS sg13g2_buf_1
Xfanout1244 _07903_/B _13601_/A VDD VSS sg13g2_buf_1
XFILLER_67_929 VDD VSS sg13g2_decap_8
Xfanout1255 _12859_/A _14898_/Q VDD VSS sg13g2_buf_1
XFILLER_152_1179 VDD VSS sg13g2_fill_2
XFILLER_130_1411 VDD VSS sg13g2_decap_8
Xfanout1266 _10489_/C _14848_/Q VDD VSS sg13g2_buf_1
X_14994_ _14994_/Q clkload86/A _14994_/D _14994_/RESET_B VDD VSS sg13g2_dfrbpq_1
Xfanout1277 _12347_/B _14750_/Q VDD VSS sg13g2_buf_1
XFILLER_94_748 VDD VSS sg13g2_fill_2
XFILLER_59_480 VDD VSS sg13g2_fill_2
XFILLER_19_322 VDD VSS sg13g2_decap_8
Xfanout290 _09605_/S _09603_/S VDD VSS sg13g2_buf_1
XFILLER_94_759 VDD VSS sg13g2_decap_8
XFILLER_8_1092 VDD VSS sg13g2_decap_8
X_13945_ _13945_/Q _14745_/CLK _13945_/D _13945_/RESET_B VDD VSS sg13g2_dfrbpq_1
XFILLER_81_409 VDD VSS sg13g2_fill_1
XFILLER_74_461 VDD VSS sg13g2_decap_4
XFILLER_90_921 VDD VSS sg13g2_decap_8
XFILLER_75_94 VDD VSS sg13g2_decap_4
XFILLER_90_932 VDD VSS sg13g2_fill_2
XFILLER_19_399 VDD VSS sg13g2_decap_8
X_13876_ _13876_/Q clkload55/A _13876_/D _13876_/RESET_B VDD VSS sg13g2_dfrbpq_1
XFILLER_46_185 VDD VSS sg13g2_decap_8
XFILLER_34_336 VDD VSS sg13g2_decap_8
XFILLER_179_308 VDD VSS sg13g2_decap_8
XFILLER_62_656 VDD VSS sg13g2_fill_2
XFILLER_34_347 VDD VSS sg13g2_fill_1
X_12827_ _12828_/A input26/X _12841_/B _12803_/X input5/X _12826_/X VDD VSS sg13g2_a221oi_1
XFILLER_50_807 VDD VSS sg13g2_fill_1
XFILLER_34_369 VDD VSS sg13g2_decap_8
X_12758_ _12758_/X _14136_/Q _14168_/Q _14200_/Q _14232_/Q _12758_/S0 _12758_/S1 VDD
+ VSS sg13g2_mux4_1
XFILLER_72_1147 VDD VSS sg13g2_decap_8
XFILLER_37_1267 VDD VSS sg13g2_decap_4
XFILLER_128_1384 VDD VSS sg13g2_decap_8
XFILLER_163_1275 VDD VSS sg13g2_fill_1
XFILLER_148_728 VDD VSS sg13g2_fill_1
X_11709_ _11709_/X _13737_/Q _14089_/Q _14441_/Q _14537_/Q _11713_/S0 _11713_/S1 VDD
+ VSS sg13g2_mux4_1
XFILLER_37_1289 VDD VSS sg13g2_decap_8
X_12689_ _12689_/X _14259_/Q _14291_/Q _14323_/Q _14355_/Q _12689_/S0 _12689_/S1 VDD
+ VSS sg13g2_mux4_1
X_13827__2445 _13827_/RESET_B VDD VSS sg13g2_tiehi
XFILLER_30_564 VDD VSS sg13g2_fill_1
X_14587__1685 _14587_/RESET_B VDD VSS sg13g2_tiehi
XFILLER_175_547 VDD VSS sg13g2_decap_8
X_14428_ _14428_/Q _14620_/CLK _14428_/D _14428_/RESET_B VDD VSS sg13g2_dfrbpq_1
XFILLER_30_597 VDD VSS sg13g2_decap_8
XFILLER_11_1407 VDD VSS sg13g2_decap_8
XFILLER_128_452 VDD VSS sg13g2_fill_2
XFILLER_162_208 VDD VSS sg13g2_decap_4
XFILLER_144_923 VDD VSS sg13g2_fill_2
XFILLER_144_934 VDD VSS sg13g2_fill_1
X_14359_ _14359_/Q clkload42/A _14359_/D _14359_/RESET_B VDD VSS sg13g2_dfrbpq_1
XFILLER_128_485 VDD VSS sg13g2_decap_8
XFILLER_115_124 VDD VSS sg13g2_decap_8
XFILLER_116_647 VDD VSS sg13g2_decap_4
XFILLER_157_1024 VDD VSS sg13g2_decap_4
Xmax_cap468 fanout467/A _10004_/Y VDD VSS sg13g2_buf_2
XFILLER_100_1270 VDD VSS sg13g2_decap_8
XFILLER_143_466 VDD VSS sg13g2_decap_8
X_14207__2065 _14207_/RESET_B VDD VSS sg13g2_tiehi
XFILLER_143_477 VDD VSS sg13g2_decap_4
XFILLER_103_319 VDD VSS sg13g2_fill_1
X_08920_ _13712_/D _16874_/A _08919_/X _08932_/S VDD VSS sg13g2_mux2_1
XFILLER_131_639 VDD VSS sg13g2_decap_8
XFILLER_124_680 VDD VSS sg13g2_decap_8
XFILLER_48_1374 VDD VSS sg13g2_decap_8
XFILLER_83_1265 VDD VSS sg13g2_decap_8
XFILLER_48_1385 VDD VSS sg13g2_fill_2
XFILLER_34_0 VDD VSS sg13g2_decap_8
XFILLER_174_1393 VDD VSS sg13g2_decap_8
X_08851_ _13695_/D _16857_/A _08850_/X _08858_/S VDD VSS sg13g2_mux2_1
XFILLER_111_341 VDD VSS sg13g2_decap_8
XFILLER_85_715 VDD VSS sg13g2_decap_8
XFILLER_58_929 VDD VSS sg13g2_decap_8
XFILLER_69_266 VDD VSS sg13g2_decap_8
XFILLER_131_1219 VDD VSS sg13g2_decap_8
X_07802_ _07949_/B _08471_/B _15008_/Q VDD VSS sg13g2_nand2b_1
X_08782_ _08782_/Y _08788_/A1 _14759_/Q _15183_/Q _07719_/X VDD VSS sg13g2_a22oi_1
X_07733_ _07734_/C _15097_/Q _15077_/Q _15075_/Q _15092_/Q VDD VSS sg13g2_nor4_1
XFILLER_37_130 VDD VSS sg13g2_decap_8
XFILLER_26_815 VDD VSS sg13g2_decap_8
XFILLER_93_770 VDD VSS sg13g2_decap_8
XFILLER_81_910 VDD VSS sg13g2_decap_8
XFILLER_65_461 VDD VSS sg13g2_decap_8
XFILLER_77_1014 VDD VSS sg13g2_decap_8
XFILLER_53_612 VDD VSS sg13g2_decap_4
XFILLER_0_1310 VDD VSS sg13g2_decap_8
XFILLER_1_91 VDD VSS sg13g2_decap_8
XFILLER_37_174 VDD VSS sg13g2_decap_8
X_07664_ _13508_/B _13613_/B _13613_/C VDD VSS sg13g2_nor2_1
XFILLER_25_325 VDD VSS sg13g2_decap_8
XFILLER_129_1115 VDD VSS sg13g2_decap_8
XFILLER_168_1164 VDD VSS sg13g2_decap_8
X_09403_ _14006_/D _09966_/A1 _14006_/Q _09404_/S VDD VSS sg13g2_mux2_1
XFILLER_77_1058 VDD VSS sg13g2_fill_2
XFILLER_53_656 VDD VSS sg13g2_fill_1
XFILLER_52_133 VDD VSS sg13g2_decap_8
XFILLER_164_1017 VDD VSS sg13g2_decap_8
XFILLER_81_976 VDD VSS sg13g2_decap_8
XFILLER_77_1069 VDD VSS sg13g2_decap_8
XFILLER_55_1301 VDD VSS sg13g2_decap_8
XFILLER_53_678 VDD VSS sg13g2_decap_8
XFILLER_25_369 VDD VSS sg13g2_fill_1
XFILLER_0_1387 VDD VSS sg13g2_decap_8
XFILLER_90_1203 VDD VSS sg13g2_decap_8
XFILLER_107_1402 VDD VSS sg13g2_fill_1
X_09334_ _13941_/D _10164_/A1 _13941_/Q _09338_/S VDD VSS sg13g2_mux2_1
XFILLER_94_1383 VDD VSS sg13g2_decap_4
XFILLER_16_1307 VDD VSS sg13g2_decap_8
XFILLER_21_520 VDD VSS sg13g2_decap_8
XFILLER_139_717 VDD VSS sg13g2_fill_2
XFILLER_55_1378 VDD VSS sg13g2_decap_8
X_09265_ _13874_/D _13874_/Q _10128_/A0 _09265_/S VDD VSS sg13g2_mux2_1
XFILLER_107_1468 VDD VSS sg13g2_fill_2
XFILLER_138_216 VDD VSS sg13g2_decap_8
XFILLER_178_385 VDD VSS sg13g2_decap_8
XFILLER_21_564 VDD VSS sg13g2_fill_1
X_14417__1855 _14417_/RESET_B VDD VSS sg13g2_tiehi
XFILLER_21_597 VDD VSS sg13g2_decap_8
X_08216_ _08544_/A _08138_/A _08215_/X _08223_/S VDD VSS sg13g2_mux2_1
XFILLER_53_1080 VDD VSS sg13g2_decap_8
X_09196_ _13812_/D _13812_/Q _10163_/A1 _09196_/S VDD VSS sg13g2_mux2_1
XFILLER_14_1064 VDD VSS sg13g2_decap_8
XFILLER_181_539 VDD VSS sg13g2_decap_8
X_08147_ _08147_/Y _08338_/B _08013_/X _08146_/X VDD VSS sg13g2_a21oi_1
XFILLER_107_647 VDD VSS sg13g2_decap_8
XFILLER_107_658 VDD VSS sg13g2_fill_2
XFILLER_20_56 VDD VSS sg13g2_decap_8
X_08078_ _15219_/D _08068_/Y _08078_/B _08078_/C VDD VSS sg13g2_nand3b_1
XFILLER_1_903 VDD VSS sg13g2_decap_8
XFILLER_84_1029 VDD VSS sg13g2_fill_2
XFILLER_106_168 VDD VSS sg13g2_decap_8
XFILLER_134_488 VDD VSS sg13g2_decap_8
X_14632__1640 _14632_/RESET_B VDD VSS sg13g2_tiehi
XFILLER_0_413 VDD VSS sg13g2_decap_8
XFILLER_66_1463 VDD VSS sg13g2_decap_8
XFILLER_103_831 VDD VSS sg13g2_decap_8
XFILLER_121_127 VDD VSS sg13g2_decap_8
X_14906__2825 _14906_/RESET_B VDD VSS sg13g2_tiehi
XFILLER_96_38 VDD VSS sg13g2_decap_8
X_10040_ _14621_/D _10140_/A1 _14621_/Q _10063_/S VDD VSS sg13g2_mux2_1
XFILLER_88_542 VDD VSS sg13g2_decap_8
X_13688__2589 _13688_/RESET_B VDD VSS sg13g2_tiehi
XFILLER_27_1447 VDD VSS sg13g2_decap_8
XFILLER_76_704 VDD VSS sg13g2_decap_8
XFILLER_29_21 VDD VSS sg13g2_decap_8
XFILLER_62_1349 VDD VSS sg13g2_decap_8
XFILLER_114_1417 VDD VSS sg13g2_decap_8
XFILLER_130_661 VDD VSS sg13g2_fill_2
XFILLER_130_672 VDD VSS sg13g2_decap_8
XFILLER_102_374 VDD VSS sg13g2_decap_8
XFILLER_103_897 VDD VSS sg13g2_decap_4
XFILLER_76_748 VDD VSS sg13g2_decap_8
XFILLER_76_759 VDD VSS sg13g2_fill_1
XFILLER_60_1051 VDD VSS sg13g2_fill_2
XFILLER_5_1232 VDD VSS sg13g2_decap_8
XFILLER_57_940 VDD VSS sg13g2_decap_8
XFILLER_21_1013 VDD VSS sg13g2_decap_8
XFILLER_75_258 VDD VSS sg13g2_decap_8
XFILLER_25_1182 VDD VSS sg13g2_decap_8
XFILLER_91_718 VDD VSS sg13g2_decap_8
X_13905__2367 _13905_/RESET_B VDD VSS sg13g2_tiehi
X_14939__2759 _14939_/RESET_B VDD VSS sg13g2_tiehi
X_11991_ _11991_/X _13969_/Q _14001_/Q _14033_/Q _14065_/Q _11997_/S0 _11997_/S1 VDD
+ VSS sg13g2_mux4_1
XFILLER_152_99 VDD VSS sg13g2_decap_8
XFILLER_90_206 VDD VSS sg13g2_fill_1
XFILLER_56_461 VDD VSS sg13g2_decap_8
XFILLER_21_1057 VDD VSS sg13g2_fill_1
X_13730_ _13730_/Q _14656_/CLK _13730_/D _13730_/RESET_B VDD VSS sg13g2_dfrbpq_1
X_15000__2680 _15000_/RESET_B VDD VSS sg13g2_tiehi
X_10942_ _10942_/Y _10954_/C _14758_/Q VDD VSS sg13g2_nor2b_1
XFILLER_95_1136 VDD VSS sg13g2_fill_2
XFILLER_56_494 VDD VSS sg13g2_decap_8
XFILLER_16_336 VDD VSS sg13g2_decap_8
XFILLER_44_645 VDD VSS sg13g2_decap_8
X_13661_ _13661_/Q clkload82/A _13661_/D _13661_/RESET_B VDD VSS sg13g2_dfrbpq_1
X_10873_ _10873_/Y _07751_/B _10871_/A _07753_/B VDD VSS sg13g2_o21ai_1
XFILLER_182_1139 VDD VSS sg13g2_decap_4
XFILLER_45_97 VDD VSS sg13g2_decap_8
XFILLER_31_317 VDD VSS sg13g2_decap_8
X_12612_ _12625_/A _12956_/B _13293_/C _15008_/Q VDD VSS sg13g2_a21oi_1
X_13592_ _13592_/Y _15004_/Q _13558_/B _13569_/S _15020_/Q _13545_/X VDD VSS sg13g2_a221oi_1
XFILLER_43_199 VDD VSS sg13g2_decap_8
XFILLER_101_70 VDD VSS sg13g2_decap_4
XFILLER_34_1407 VDD VSS sg13g2_decap_8
XFILLER_12_553 VDD VSS sg13g2_decap_8
XFILLER_160_1437 VDD VSS sg13g2_decap_8
X_12543_ _12543_/X _13833_/Q _13865_/Q _13897_/Q _13929_/Q _12550_/S0 _12550_/S1 VDD
+ VSS sg13g2_mux4_1
XFILLER_185_834 VDD VSS sg13g2_fill_2
XFILLER_40_895 VDD VSS sg13g2_decap_8
XFILLER_8_546 VDD VSS sg13g2_decap_8
XFILLER_145_709 VDD VSS sg13g2_decap_8
XFILLER_177_63 VDD VSS sg13g2_decap_8
X_12474_ _12474_/X _13956_/Q _13988_/Q _14020_/Q _14052_/Q _12710_/S0 _12710_/S1 VDD
+ VSS sg13g2_mux4_1
X_15117__2818 _15117_/RESET_B VDD VSS sg13g2_tiehi
XFILLER_144_208 VDD VSS sg13g2_fill_2
XFILLER_6_14 VDD VSS sg13g2_decap_8
X_14213_ _14213_/Q clkload8/A _14213_/D _14213_/RESET_B VDD VSS sg13g2_dfrbpq_1
XFILLER_172_528 VDD VSS sg13g2_decap_4
X_11425_ wire231/A _11425_/A wire579/X _11425_/C VDD VSS sg13g2_nand3_1
XFILLER_138_794 VDD VSS sg13g2_decap_4
XFILLER_184_399 VDD VSS sg13g2_decap_8
X_15193_ _15193_/Q clkload91/A _15193_/D _15193_/RESET_B VDD VSS sg13g2_dfrbpq_1
XANTENNA_7 _16864_/A VDD VSS sg13g2_antennanp
XFILLER_137_293 VDD VSS sg13g2_decap_8
X_14144_ _14144_/Q clkload46/A _14144_/D _14144_/RESET_B VDD VSS sg13g2_dfrbpq_1
XFILLER_67_1227 VDD VSS sg13g2_decap_8
X_11356_ _11356_/Y _11355_/Y _11354_/Y _11422_/B VDD VSS sg13g2_a21oi_1
XFILLER_67_1238 VDD VSS sg13g2_fill_2
XFILLER_126_989 VDD VSS sg13g2_decap_8
XFILLER_4_763 VDD VSS sg13g2_decap_8
XFILLER_112_105 VDD VSS sg13g2_decap_8
XFILLER_154_1219 VDD VSS sg13g2_fill_1
XFILLER_158_1388 VDD VSS sg13g2_decap_8
X_10307_ _10307_/Y _14796_/Q _10327_/B _10337_/C VDD VSS sg13g2_o21ai_1
X_14075_ _14075_/Q clkload60/A _14075_/D _14075_/RESET_B VDD VSS sg13g2_dfrbpq_1
XFILLER_98_339 VDD VSS sg13g2_decap_8
X_11287_ _11287_/Y _11287_/A _11287_/B wire579/X VDD VSS sg13g2_nand3_1
XFILLER_3_273 VDD VSS sg13g2_decap_8
XFILLER_80_1405 VDD VSS sg13g2_decap_8
XFILLER_140_447 VDD VSS sg13g2_decap_8
XFILLER_140_458 VDD VSS sg13g2_fill_1
X_13026_ _13026_/Y _13026_/A _13057_/A _13026_/C VDD VSS sg13g2_nor3_1
XFILLER_105_190 VDD VSS sg13g2_fill_1
X_10238_ _10238_/Y _10237_/B _10234_/Y _10337_/C VDD VSS sg13g2_o21ai_1
Xfanout1030 _13274_/A2 _13250_/A2 VDD VSS sg13g2_buf_1
Xfanout1041 _11140_/B2 _11206_/A1 VDD VSS sg13g2_buf_1
XFILLER_6_1029 VDD VSS sg13g2_decap_8
XFILLER_39_428 VDD VSS sg13g2_decap_8
Xfanout1052 _10898_/B1 _15070_/Q VDD VSS sg13g2_buf_1
X_10169_ _14746_/D _14746_/Q _10169_/A1 _10169_/S VDD VSS sg13g2_mux2_1
XFILLER_121_694 VDD VSS sg13g2_decap_8
Xfanout1063 _10004_/A _10137_/A VDD VSS sg13g2_buf_1
XFILLER_67_748 VDD VSS sg13g2_decap_8
Xfanout1074 _09072_/B _09078_/B VDD VSS sg13g2_buf_1
XFILLER_86_82 VDD VSS sg13g2_decap_8
XFILLER_43_1260 VDD VSS sg13g2_decap_8
XFILLER_120_193 VDD VSS sg13g2_decap_8
XFILLER_43_1271 VDD VSS sg13g2_fill_1
Xfanout1085 _13493_/A1 _15057_/Q VDD VSS sg13g2_buf_1
Xfanout1096 _08306_/B _15000_/Q VDD VSS sg13g2_buf_1
X_14977_ _14977_/Q clkload54/A _14977_/D _14977_/RESET_B VDD VSS sg13g2_dfrbpq_1
XFILLER_94_578 VDD VSS sg13g2_decap_8
XFILLER_54_409 VDD VSS sg13g2_decap_8
XFILLER_78_1312 VDD VSS sg13g2_decap_8
XFILLER_35_601 VDD VSS sg13g2_decap_8
XFILLER_48_995 VDD VSS sg13g2_decap_4
XFILLER_130_1274 VDD VSS sg13g2_decap_4
X_13928_ _13928_/Q _14664_/CLK _13928_/D _13928_/RESET_B VDD VSS sg13g2_dfrbpq_1
XFILLER_34_100 VDD VSS sg13g2_decap_4
X_14070__2202 _14070_/RESET_B VDD VSS sg13g2_tiehi
XFILLER_19_196 VDD VSS sg13g2_decap_8
XFILLER_34_122 VDD VSS sg13g2_decap_8
XFILLER_74_1209 VDD VSS sg13g2_decap_8
XFILLER_63_965 VDD VSS sg13g2_decap_8
XFILLER_39_1329 VDD VSS sg13g2_fill_1
XFILLER_179_105 VDD VSS sg13g2_decap_8
X_13859_ _13859_/Q _14723_/CLK _13859_/D _13859_/RESET_B VDD VSS sg13g2_dfrbpq_1
XFILLER_35_678 VDD VSS sg13g2_decap_8
XFILLER_23_829 VDD VSS sg13g2_fill_1
XFILLER_16_870 VDD VSS sg13g2_decap_8
XFILLER_90_784 VDD VSS sg13g2_decap_8
XFILLER_76_1080 VDD VSS sg13g2_decap_8
XFILLER_163_1050 VDD VSS sg13g2_decap_8
XFILLER_176_801 VDD VSS sg13g2_decap_8
X_14710__1562 _14710_/RESET_B VDD VSS sg13g2_tiehi
XFILLER_148_536 VDD VSS sg13g2_decap_4
XFILLER_124_1045 VDD VSS sg13g2_decap_8
X_09050_ _09050_/X _14908_/Q _09056_/C _09049_/Y VDD VSS sg13g2_a21o_1
XFILLER_15_1340 VDD VSS sg13g2_decap_8
XFILLER_30_383 VDD VSS sg13g2_decap_8
XFILLER_175_355 VDD VSS sg13g2_decap_8
XFILLER_30_394 VDD VSS sg13g2_fill_2
XFILLER_117_901 VDD VSS sg13g2_decap_4
XFILLER_11_1204 VDD VSS sg13g2_decap_8
XFILLER_141_1370 VDD VSS sg13g2_fill_2
X_08001_ _08001_/Y _08001_/A _08275_/B _08238_/B _08001_/D VDD VSS sg13g2_nand4_1
XFILLER_85_1305 VDD VSS sg13g2_decap_8
XFILLER_85_1316 VDD VSS sg13g2_fill_2
XFILLER_116_455 VDD VSS sg13g2_decap_8
XFILLER_85_1338 VDD VSS sg13g2_decap_8
XFILLER_144_775 VDD VSS sg13g2_decap_8
XFILLER_143_263 VDD VSS sg13g2_decap_4
XFILLER_132_937 VDD VSS sg13g2_fill_1
XFILLER_137_1428 VDD VSS sg13g2_decap_4
Xmax_cap287 fanout285/A wire288/X VDD VSS sg13g2_buf_2
X_09952_ _14536_/D _14536_/Q _10051_/A0 _09952_/S VDD VSS sg13g2_mux2_1
XFILLER_143_285 VDD VSS sg13g2_decap_8
Xmax_cap298 _09429_/S _09438_/S VDD VSS sg13g2_buf_8
XFILLER_83_1051 VDD VSS sg13g2_decap_8
XFILLER_44_1002 VDD VSS sg13g2_fill_1
XFILLER_131_458 VDD VSS sg13g2_fill_2
X_08903_ _08903_/X _15039_/Q _14943_/Q _08903_/S VDD VSS sg13g2_mux2_1
XFILLER_135_1141 VDD VSS sg13g2_decap_8
X_09883_ _14469_/D _09883_/A0 _14469_/Q _09896_/S VDD VSS sg13g2_mux2_1
XFILLER_170_1032 VDD VSS sg13g2_decap_8
XFILLER_85_501 VDD VSS sg13g2_decap_8
XFILLER_44_1046 VDD VSS sg13g2_decap_4
XFILLER_57_203 VDD VSS sg13g2_decap_8
X_08834_ _08834_/X _13600_/A _08834_/B VDD VSS sg13g2_and2_1
XFILLER_112_694 VDD VSS sg13g2_decap_8
XFILLER_111_182 VDD VSS sg13g2_decap_8
XFILLER_85_545 VDD VSS sg13g2_fill_2
XFILLER_111_193 VDD VSS sg13g2_fill_1
XFILLER_61_1371 VDD VSS sg13g2_fill_1
XFILLER_57_258 VDD VSS sg13g2_decap_8
XFILLER_122_14 VDD VSS sg13g2_decap_8
X_08765_ _13673_/D _08765_/A1 _08763_/Y _08764_/Y VDD VSS sg13g2_a21oi_1
XFILLER_57_269 VDD VSS sg13g2_fill_1
XFILLER_22_1366 VDD VSS sg13g2_decap_8
X_07716_ _08049_/A _15102_/Q _15094_/Q VDD VSS sg13g2_nor2_1
XFILLER_2_1449 VDD VSS sg13g2_decap_8
X_08696_ _08696_/Y _15019_/Q _12278_/A _08698_/B VDD VSS sg13g2_a21oi_1
XFILLER_82_18 VDD VSS sg13g2_fill_1
XFILLER_81_740 VDD VSS sg13g2_decap_8
XFILLER_54_954 VDD VSS sg13g2_decap_8
XFILLER_26_645 VDD VSS sg13g2_decap_4
XFILLER_57_1429 VDD VSS sg13g2_decap_8
X_07647_ _07647_/Y _14806_/Q VDD VSS sg13g2_inv_1
X_13699__2573 _13699_/RESET_B VDD VSS sg13g2_tiehi
XFILLER_80_261 VDD VSS sg13g2_fill_1
XFILLER_53_475 VDD VSS sg13g2_decap_8
XFILLER_25_166 VDD VSS sg13g2_decap_8
XFILLER_183_1459 VDD VSS sg13g2_decap_8
XFILLER_81_795 VDD VSS sg13g2_decap_4
XFILLER_0_1184 VDD VSS sg13g2_decap_8
XFILLER_90_1000 VDD VSS sg13g2_fill_1
XFILLER_25_199 VDD VSS sg13g2_decap_8
XFILLER_15_56 VDD VSS sg13g2_decap_8
XFILLER_16_1104 VDD VSS sg13g2_decap_8
XFILLER_142_1112 VDD VSS sg13g2_fill_2
XFILLER_185_119 VDD VSS sg13g2_decap_8
X_09317_ _13924_/D _09882_/A0 _13924_/Q _09337_/S VDD VSS sg13g2_mux2_1
XFILLER_55_1164 VDD VSS sg13g2_fill_2
XFILLER_181_1183 VDD VSS sg13g2_decap_8
XFILLER_51_1017 VDD VSS sg13g2_decap_8
XFILLER_166_322 VDD VSS sg13g2_decap_8
XFILLER_178_182 VDD VSS sg13g2_decap_8
XFILLER_90_1077 VDD VSS sg13g2_decap_8
XFILLER_139_558 VDD VSS sg13g2_decap_8
XFILLER_142_1156 VDD VSS sg13g2_decap_8
X_09248_ _13857_/D _13857_/Q _10144_/A1 _09272_/S VDD VSS sg13g2_mux2_1
XFILLER_120_1410 VDD VSS sg13g2_fill_2
XFILLER_142_1189 VDD VSS sg13g2_fill_1
XFILLER_167_889 VDD VSS sg13g2_fill_2
X_14079__2193 _14079_/RESET_B VDD VSS sg13g2_tiehi
XFILLER_33_1462 VDD VSS sg13g2_decap_8
XFILLER_126_208 VDD VSS sg13g2_decap_8
XFILLER_108_923 VDD VSS sg13g2_fill_2
XFILLER_177_1208 VDD VSS sg13g2_fill_2
XFILLER_119_260 VDD VSS sg13g2_decap_4
X_09179_ _13795_/D _13795_/Q _09914_/A1 _09201_/S VDD VSS sg13g2_mux2_1
XFILLER_181_336 VDD VSS sg13g2_decap_8
XFILLER_182_859 VDD VSS sg13g2_decap_8
XFILLER_31_77 VDD VSS sg13g2_decap_4
XFILLER_135_742 VDD VSS sg13g2_decap_8
XFILLER_120_1476 VDD VSS sg13g2_fill_2
X_11210_ _11210_/X _13947_/Q _13979_/Q _14011_/Q _14043_/Q _11365_/A _11366_/C VDD
+ VSS sg13g2_mux4_1
XFILLER_135_753 VDD VSS sg13g2_fill_1
X_12190_ _12190_/Y _12190_/A _12190_/B VDD VSS sg13g2_nand2_1
XFILLER_123_915 VDD VSS sg13g2_decap_8
XFILLER_1_700 VDD VSS sg13g2_decap_8
X_15018__2662 _15018_/RESET_B VDD VSS sg13g2_tiehi
XFILLER_122_414 VDD VSS sg13g2_decap_8
XFILLER_134_274 VDD VSS sg13g2_fill_1
XFILLER_162_583 VDD VSS sg13g2_fill_1
X_11141_ _11141_/X _11163_/A _11193_/A2 _11168_/B1 VDD VSS sg13g2_a21o_1
Xoutput44 mem_axi_araddr[15] _13706_/Q VDD VSS sg13g2_buf_1
XFILLER_150_745 VDD VSS sg13g2_decap_8
Xoutput55 mem_axi_araddr[26] _16879_/A VDD VSS sg13g2_buf_1
XFILLER_0_210 VDD VSS sg13g2_decap_8
XFILLER_163_21 VDD VSS sg13g2_decap_8
Xoutput66 mem_axi_araddr[7] output66/A VDD VSS sg13g2_buf_1
Xoutput77 mem_axi_awaddr[16] _16869_/X VDD VSS sg13g2_buf_1
X_11072_ _11072_/Y _11082_/A1 _11070_/Y _11071_/Y VDD VSS sg13g2_a21oi_1
Xoutput88 mem_axi_awaddr[27] _16880_/X VDD VSS sg13g2_buf_1
XFILLER_1_777 VDD VSS sg13g2_decap_8
X_14827__2979 _14827_/RESET_B VDD VSS sg13g2_tiehi
Xoutput99 mem_axi_awaddr[8] _16861_/X VDD VSS sg13g2_buf_1
XFILLER_7_1316 VDD VSS sg13g2_decap_8
XFILLER_27_1244 VDD VSS sg13g2_decap_8
Xhold3160 _15193_/D _08721_/X VDD VSS sg13g2_dlygate4sd3_1
X_14900_ _14900_/Q clkload79/A _14900_/D _14900_/RESET_B VDD VSS sg13g2_dfrbpq_1
Xhold3171 hold3171/X _07663_/Y VDD VSS sg13g2_dlygate4sd3_1
X_10023_ _14605_/D _10089_/A0 _14605_/Q _10027_/S VDD VSS sg13g2_mux2_1
XFILLER_118_1394 VDD VSS sg13g2_fill_2
XFILLER_131_992 VDD VSS sg13g2_decap_8
XFILLER_0_287 VDD VSS sg13g2_decap_8
XFILLER_114_1236 VDD VSS sg13g2_decap_8
Xhold3182 input19/A mem_axi_rdata[23] VDD VSS sg13g2_dlygate4sd3_1
XFILLER_62_1168 VDD VSS sg13g2_decap_8
XFILLER_49_748 VDD VSS sg13g2_decap_8
Xhold3193 _13640_/A _13748_/Q VDD VSS sg13g2_dlygate4sd3_1
XFILLER_49_759 VDD VSS sg13g2_fill_1
XFILLER_48_225 VDD VSS sg13g2_decap_8
XFILLER_102_182 VDD VSS sg13g2_decap_8
X_15146__2758 _15146_/RESET_B VDD VSS sg13g2_tiehi
XFILLER_48_236 VDD VSS sg13g2_fill_1
XFILLER_186_0 VDD VSS sg13g2_decap_8
X_14831_ _14831_/Q clkload65/A _14831_/D _14831_/RESET_B VDD VSS sg13g2_dfrbpq_1
XFILLER_40_1433 VDD VSS sg13g2_decap_8
XFILLER_64_729 VDD VSS sg13g2_decap_4
XFILLER_40_1444 VDD VSS sg13g2_fill_1
XFILLER_45_910 VDD VSS sg13g2_decap_4
XFILLER_17_623 VDD VSS sg13g2_decap_8
X_14762_ _14762_/Q _15019_/CLK _14762_/D _14762_/RESET_B VDD VSS sg13g2_dfrbpq_1
XFILLER_40_1477 VDD VSS sg13g2_fill_2
X_11974_ _11975_/B _11971_/Y _11973_/Y _12048_/A1 VDD VSS sg13g2_a21oi_1
XFILLER_56_96 VDD VSS sg13g2_decap_8
XFILLER_45_943 VDD VSS sg13g2_decap_8
XFILLER_16_133 VDD VSS sg13g2_decap_8
X_13713_ _13713_/Q clkload57/A _13713_/D _13713_/RESET_B VDD VSS sg13g2_dfrbpq_1
X_10925_ _10926_/B _10954_/A _10954_/D _10924_/Y VDD VSS sg13g2_o21ai_1
XFILLER_72_762 VDD VSS sg13g2_fill_2
X_14693_ _14693_/Q _14725_/CLK _14693_/D _14693_/RESET_B VDD VSS sg13g2_dfrbpq_1
XFILLER_72_773 VDD VSS sg13g2_fill_2
X_14289__1983 _14289_/RESET_B VDD VSS sg13g2_tiehi
XFILLER_71_261 VDD VSS sg13g2_decap_4
XFILLER_32_637 VDD VSS sg13g2_decap_8
XFILLER_177_609 VDD VSS sg13g2_fill_2
X_13644_ _13752_/D _13644_/A VDD VSS sg13g2_buf_1
X_10856_ _10857_/B _14752_/Q _10870_/A VDD VSS sg13g2_xnor2_1
XFILLER_13_840 VDD VSS sg13g2_decap_8
XFILLER_158_812 VDD VSS sg13g2_fill_1
XFILLER_60_979 VDD VSS sg13g2_fill_1
XFILLER_176_119 VDD VSS sg13g2_decap_8
XFILLER_38_1373 VDD VSS sg13g2_decap_8
XFILLER_12_350 VDD VSS sg13g2_decap_8
XFILLER_160_1223 VDD VSS sg13g2_decap_8
X_13575_ _13575_/Y _13575_/A _13581_/B VDD VSS sg13g2_nor2_1
XFILLER_31_169 VDD VSS sg13g2_decap_8
XFILLER_160_1234 VDD VSS sg13g2_fill_2
X_10787_ _14923_/D _10787_/A VDD VSS sg13g2_inv_1
XFILLER_9_833 VDD VSS sg13g2_decap_8
XFILLER_158_867 VDD VSS sg13g2_decap_8
XFILLER_34_1259 VDD VSS sg13g2_decap_4
X_13659__1520 _13659_/RESET_B VDD VSS sg13g2_tiehi
X_12526_ wire323/A _13681_/Q _12791_/A2 _12525_/X _12763_/B2 _12763_/C1 VDD VSS sg13g2_a221oi_1
XFILLER_8_343 VDD VSS sg13g2_decap_8
XFILLER_125_1398 VDD VSS sg13g2_fill_1
XFILLER_173_815 VDD VSS sg13g2_decap_8
XFILLER_75_7 VDD VSS sg13g2_decap_8
XFILLER_185_686 VDD VSS sg13g2_decap_8
XFILLER_117_219 VDD VSS sg13g2_fill_1
XFILLER_172_303 VDD VSS sg13g2_decap_8
X_15245_ _15245_/Q clkload71/A _15245_/D _15245_/RESET_B VDD VSS sg13g2_dfrbpq_1
X_12457_ _14996_/D _12457_/A _12457_/B VDD VSS sg13g2_nor2_1
XFILLER_126_731 VDD VSS sg13g2_fill_1
X_11408_ _11408_/Y _11410_/A1 _14399_/Q _11419_/C VDD VSS sg13g2_a21oi_1
X_15176_ _15176_/Q _15182_/CLK _15176_/D _15176_/RESET_B VDD VSS sg13g2_dfrbpq_1
XFILLER_125_241 VDD VSS sg13g2_decap_8
X_12388_ _14991_/D _08070_/B _12443_/A2 _12387_/Y _12386_/Y VDD VSS sg13g2_a22oi_1
XFILLER_114_926 VDD VSS sg13g2_decap_8
XFILLER_153_561 VDD VSS sg13g2_decap_8
XFILLER_158_1152 VDD VSS sg13g2_decap_8
XFILLER_181_870 VDD VSS sg13g2_decap_4
XFILLER_4_560 VDD VSS sg13g2_decap_8
X_14127_ _14127_/Q clkload12/A _14127_/D _14127_/RESET_B VDD VSS sg13g2_dfrbpq_1
XFILLER_10_1281 VDD VSS sg13g2_decap_8
X_11339_ _11339_/Y _11339_/A _11339_/B VDD VSS sg13g2_xnor2_1
XFILLER_140_211 VDD VSS sg13g2_fill_1
X_14058_ _14058_/Q clkload16/A _14058_/D _14058_/RESET_B VDD VSS sg13g2_dfrbpq_1
X_13777__2495 _13777_/RESET_B VDD VSS sg13g2_tiehi
XFILLER_80_1235 VDD VSS sg13g2_decap_8
XFILLER_140_277 VDD VSS sg13g2_fill_2
XFILLER_45_1355 VDD VSS sg13g2_fill_1
XFILLER_39_203 VDD VSS sg13g2_fill_1
X_13009_ _13009_/Y _13009_/A _13010_/A _13010_/B VDD VSS sg13g2_nand3_1
XFILLER_95_832 VDD VSS sg13g2_decap_8
XFILLER_39_225 VDD VSS sg13g2_fill_2
XFILLER_121_491 VDD VSS sg13g2_fill_1
XFILLER_95_854 VDD VSS sg13g2_decap_8
X_14728__1544 _14728_/RESET_B VDD VSS sg13g2_tiehi
XFILLER_45_1399 VDD VSS sg13g2_decap_8
XFILLER_132_1369 VDD VSS sg13g2_decap_8
XFILLER_95_898 VDD VSS sg13g2_decap_8
XFILLER_82_515 VDD VSS sg13g2_decap_8
XFILLER_67_589 VDD VSS sg13g2_decap_8
XFILLER_43_1090 VDD VSS sg13g2_decap_4
XFILLER_130_1060 VDD VSS sg13g2_decap_8
X_08550_ _08550_/Y _08567_/B _08531_/B _07956_/Y VDD VSS sg13g2_a21oi_1
X_13992__2280 _13992_/RESET_B VDD VSS sg13g2_tiehi
XFILLER_47_291 VDD VSS sg13g2_decap_8
XFILLER_78_1153 VDD VSS sg13g2_decap_8
XFILLER_36_976 VDD VSS sg13g2_decap_8
XFILLER_35_453 VDD VSS sg13g2_decap_8
X_08481_ _08481_/X _08481_/A _08481_/B VDD VSS sg13g2_xor2_1
XFILLER_39_1148 VDD VSS sg13g2_decap_8
XFILLER_126_1107 VDD VSS sg13g2_fill_1
XFILLER_90_592 VDD VSS sg13g2_decap_8
XFILLER_51_946 VDD VSS sg13g2_decap_8
XFILLER_56_1440 VDD VSS sg13g2_decap_4
XFILLER_161_1009 VDD VSS sg13g2_decap_8
XFILLER_22_147 VDD VSS sg13g2_decap_8
XFILLER_167_119 VDD VSS sg13g2_decap_8
XFILLER_50_478 VDD VSS sg13g2_decap_8
XFILLER_17_1446 VDD VSS sg13g2_decap_8
XFILLER_31_670 VDD VSS sg13g2_decap_8
XFILLER_104_1416 VDD VSS sg13g2_fill_1
X_09102_ _09102_/Y _13142_/A _09136_/B _09126_/A1 VDD VSS sg13g2_o21ai_1
XFILLER_11_1001 VDD VSS sg13g2_decap_8
X_09033_ _13766_/D _13766_/Q _10149_/A1 _09106_/S VDD VSS sg13g2_mux2_1
XFILLER_50_1050 VDD VSS sg13g2_decap_8
XFILLER_50_1072 VDD VSS sg13g2_decap_8
XFILLER_175_196 VDD VSS sg13g2_decap_8
XFILLER_89_1260 VDD VSS sg13g2_decap_8
XFILLER_151_509 VDD VSS sg13g2_fill_1
XFILLER_11_1078 VDD VSS sg13g2_decap_8
XFILLER_117_786 VDD VSS sg13g2_decap_4
XFILLER_85_1146 VDD VSS sg13g2_decap_8
XFILLER_105_948 VDD VSS sg13g2_fill_2
XFILLER_176_1274 VDD VSS sg13g2_decap_8
XFILLER_89_114 VDD VSS sg13g2_decap_8
XFILLER_132_734 VDD VSS sg13g2_decap_8
XFILLER_116_296 VDD VSS sg13g2_decap_8
XFILLER_171_391 VDD VSS sg13g2_decap_8
XFILLER_104_447 VDD VSS sg13g2_decap_8
XFILLER_131_233 VDD VSS sg13g2_decap_8
XFILLER_137_1247 VDD VSS sg13g2_fill_2
XFILLER_132_767 VDD VSS sg13g2_fill_1
XFILLER_172_1138 VDD VSS sg13g2_decap_8
Xfanout801 _08431_/D _08511_/S VDD VSS sg13g2_buf_1
XFILLER_137_1269 VDD VSS sg13g2_decap_8
Xfanout812 _08617_/A _08426_/A VDD VSS sg13g2_buf_1
X_09935_ _14520_/D _14520_/Q _10100_/A0 _09935_/S VDD VSS sg13g2_mux2_1
XFILLER_120_929 VDD VSS sg13g2_decap_8
Xfanout823 _08577_/A _08422_/S VDD VSS sg13g2_buf_1
XFILLER_77_309 VDD VSS sg13g2_decap_8
Xfanout834 _12664_/S _12789_/S1 VDD VSS sg13g2_buf_1
XFILLER_150_1403 VDD VSS sg13g2_fill_1
Xfanout845 _12720_/S _12776_/S VDD VSS sg13g2_buf_1
XFILLER_98_681 VDD VSS sg13g2_decap_8
XFILLER_86_821 VDD VSS sg13g2_decap_8
XFILLER_58_512 VDD VSS sg13g2_decap_8
Xfanout867 _12659_/S1 _12604_/S1 VDD VSS sg13g2_buf_1
X_09866_ _14453_/D _14453_/Q _09998_/A0 _09866_/S VDD VSS sg13g2_mux2_1
XFILLER_24_1428 VDD VSS sg13g2_decap_8
Xfanout878 _12758_/S1 _12754_/S1 VDD VSS sg13g2_buf_1
XFILLER_133_35 VDD VSS sg13g2_decap_8
Xfanout889 _12783_/S1 _12702_/S1 VDD VSS sg13g2_buf_1
X_08817_ _08817_/Y _13279_/B _15122_/Q _13482_/A _15192_/Q _08825_/C1 VDD VSS sg13g2_a221oi_1
Xclkbuf_4_6_0_clk_i clkbuf_4_6_0_clk_i/X clkbuf_0_clk_i/X VDD VSS sg13g2_buf_8
X_09797_ _14386_/D _09896_/A0 _14386_/Q _09797_/S VDD VSS sg13g2_mux2_1
XFILLER_100_686 VDD VSS sg13g2_fill_1
XFILLER_93_28 VDD VSS sg13g2_decap_8
XFILLER_22_1163 VDD VSS sg13g2_decap_8
XFILLER_6_1393 VDD VSS sg13g2_decap_8
X_08748_ _08748_/Y _07719_/A _11288_/A _15194_/Q VDD VSS sg13g2_o21ai_1
XFILLER_2_1246 VDD VSS sg13g2_decap_8
X_13822__2450 _13822_/RESET_B VDD VSS sg13g2_tiehi
XFILLER_27_965 VDD VSS sg13g2_fill_2
X_14582__1690 _14582_/RESET_B VDD VSS sg13g2_tiehi
XFILLER_54_762 VDD VSS sg13g2_decap_8
X_08679_ _08679_/Y _08642_/Y _08645_/X _08678_/Y VDD VSS sg13g2_a21oi_1
XFILLER_96_1275 VDD VSS sg13g2_decap_8
XFILLER_109_1305 VDD VSS sg13g2_fill_1
XFILLER_183_1234 VDD VSS sg13g2_fill_2
XFILLER_26_77 VDD VSS sg13g2_decap_8
XFILLER_183_1245 VDD VSS sg13g2_fill_2
XFILLER_14_637 VDD VSS sg13g2_decap_8
X_10710_ _10936_/C _09027_/X _10743_/S _08873_/Y VDD VSS sg13g2_a21o_1
XFILLER_92_1139 VDD VSS sg13g2_decap_8
XFILLER_26_497 VDD VSS sg13g2_decap_8
X_11690_ _11694_/A _11689_/X _11967_/B VDD VSS sg13g2_nand2b_1
XFILLER_144_1229 VDD VSS sg13g2_decap_4
XFILLER_13_147 VDD VSS sg13g2_decap_8
X_14166__2106 _14166_/RESET_B VDD VSS sg13g2_tiehi
X_10641_ _10643_/B _14887_/Q _10642_/C _14888_/Q VDD VSS sg13g2_a21oi_1
XFILLER_70_1415 VDD VSS sg13g2_fill_1
XFILLER_42_21 VDD VSS sg13g2_decap_8
XFILLER_139_322 VDD VSS sg13g2_decap_8
XFILLER_167_642 VDD VSS sg13g2_decap_8
XFILLER_158_21 VDD VSS sg13g2_decap_8
X_14202__2070 _14202_/RESET_B VDD VSS sg13g2_tiehi
XFILLER_107_1073 VDD VSS sg13g2_decap_8
X_13360_ _13494_/B _13396_/B _13396_/A VDD VSS sg13g2_nand2b_1
X_10572_ _14869_/D _10572_/A _13155_/A _10572_/C VDD VSS sg13g2_nor3_1
XFILLER_10_854 VDD VSS sg13g2_decap_8
XFILLER_155_815 VDD VSS sg13g2_decap_4
XFILLER_154_303 VDD VSS sg13g2_decap_8
XFILLER_155_826 VDD VSS sg13g2_decap_8
XFILLER_42_98 VDD VSS sg13g2_decap_8
XFILLER_182_623 VDD VSS sg13g2_decap_8
X_12311_ _12311_/Y _12328_/A1 _14586_/Q VDD VSS sg13g2_nand2b_1
X_13291_ _15054_/D _13291_/A _13291_/B _13291_/C VDD VSS sg13g2_nand3_1
XFILLER_33_1281 VDD VSS sg13g2_decap_8
XFILLER_155_859 VDD VSS sg13g2_decap_8
XFILLER_166_196 VDD VSS sg13g2_decap_8
XFILLER_6_847 VDD VSS sg13g2_decap_8
XFILLER_181_133 VDD VSS sg13g2_decap_8
X_15030_ _15030_/Q clkload74/A _15030_/D _15030_/RESET_B VDD VSS sg13g2_dfrbpq_1
X_12242_ _12242_/Y _12243_/A1 _14648_/Q VDD VSS sg13g2_nand2b_1
XFILLER_154_369 VDD VSS sg13g2_decap_8
XFILLER_5_357 VDD VSS sg13g2_decap_8
XFILLER_101_0 VDD VSS sg13g2_decap_4
XFILLER_155_1314 VDD VSS sg13g2_decap_8
XFILLER_174_42 VDD VSS sg13g2_decap_8
X_12173_ _12174_/B _12170_/Y _12172_/Y _11559_/C VDD VSS sg13g2_a21oi_1
XFILLER_123_745 VDD VSS sg13g2_fill_2
XFILLER_150_542 VDD VSS sg13g2_decap_8
XFILLER_155_1358 VDD VSS sg13g2_decap_8
X_11124_ _11128_/A _11127_/A _11127_/B VDD VSS sg13g2_nand2_1
XFILLER_96_607 VDD VSS sg13g2_decap_8
XFILLER_155_1369 VDD VSS sg13g2_fill_2
XFILLER_110_406 VDD VSS sg13g2_decap_8
XFILLER_1_574 VDD VSS sg13g2_decap_8
XFILLER_7_1113 VDD VSS sg13g2_decap_8
XFILLER_150_597 VDD VSS sg13g2_fill_2
X_11055_ _11055_/Y _11206_/A1 _11051_/Y _11054_/Y VDD VSS sg13g2_a21oi_1
XFILLER_95_139 VDD VSS sg13g2_decap_8
X_14973__2707 _14973_/RESET_B VDD VSS sg13g2_tiehi
XFILLER_88_191 VDD VSS sg13g2_decap_4
XFILLER_49_545 VDD VSS sg13g2_decap_8
XFILLER_67_73 VDD VSS sg13g2_decap_8
XFILLER_114_1055 VDD VSS sg13g2_decap_8
X_10006_ _14588_/D _10039_/A0 _14588_/Q _10030_/S VDD VSS sg13g2_mux2_1
XFILLER_77_876 VDD VSS sg13g2_decap_8
XFILLER_77_887 VDD VSS sg13g2_fill_1
XFILLER_36_206 VDD VSS sg13g2_decap_4
XFILLER_64_526 VDD VSS sg13g2_fill_1
X_14814_ _14814_/Q clkload61/A _14814_/D _14814_/RESET_B VDD VSS sg13g2_dfrbpq_1
XFILLER_64_548 VDD VSS sg13g2_decap_8
XFILLER_17_420 VDD VSS sg13g2_decap_8
XFILLER_40_1274 VDD VSS sg13g2_decap_8
X_14412__1860 _14412_/RESET_B VDD VSS sg13g2_tiehi
X_14745_ _14745_/Q _14745_/CLK _14745_/D _14745_/RESET_B VDD VSS sg13g2_dfrbpq_1
XFILLER_75_1315 VDD VSS sg13g2_fill_2
X_11957_ _11957_/Y _11957_/A _11957_/B VDD VSS sg13g2_nor2_1
XFILLER_178_907 VDD VSS sg13g2_decap_8
XFILLER_17_497 VDD VSS sg13g2_decap_8
X_10908_ _10908_/Y _10923_/A _10923_/D _10923_/B VDD VSS sg13g2_o21ai_1
XFILLER_162_1318 VDD VSS sg13g2_fill_2
X_14676_ _14676_/Q _14982_/CLK _14676_/D _14676_/RESET_B VDD VSS sg13g2_dfrbpq_1
XFILLER_177_406 VDD VSS sg13g2_decap_8
X_11888_ _11888_/Y _11365_/A _14510_/Q _11894_/B VDD VSS sg13g2_a21oi_1
XFILLER_60_754 VDD VSS sg13g2_decap_8
XFILLER_32_445 VDD VSS sg13g2_decap_8
XFILLER_127_1449 VDD VSS sg13g2_fill_1
X_13627_ _13735_/D _13627_/A VDD VSS sg13g2_buf_1
X_10839_ _10841_/B _14751_/Q _10876_/A VDD VSS sg13g2_xor2_1
XFILLER_160_1031 VDD VSS sg13g2_decap_8
XFILLER_9_630 VDD VSS sg13g2_decap_8
XFILLER_125_1162 VDD VSS sg13g2_decap_4
XFILLER_34_1045 VDD VSS sg13g2_decap_8
X_13558_ _13558_/Y _15008_/Q _13558_/B _13566_/C VDD VSS sg13g2_nor3_1
XFILLER_158_675 VDD VSS sg13g2_decap_8
XFILLER_186_984 VDD VSS sg13g2_decap_8
XFILLER_160_1075 VDD VSS sg13g2_decap_4
XFILLER_186_995 VDD VSS sg13g2_decap_8
XFILLER_8_140 VDD VSS sg13g2_decap_8
XFILLER_73_4 VDD VSS sg13g2_fill_1
XFILLER_173_612 VDD VSS sg13g2_fill_1
XFILLER_185_483 VDD VSS sg13g2_decap_8
X_12509_ _12509_/X _12508_/X _12507_/X _12501_/X _12502_/X _12663_/S1 _12636_/S VDD
+ VSS sg13g2_mux4_1
XFILLER_69_1108 VDD VSS sg13g2_decap_8
X_13489_ _15124_/D _15124_/Q _13501_/A _13488_/Y VDD VSS sg13g2_a21o_1
XFILLER_86_1400 VDD VSS sg13g2_decap_8
XFILLER_172_133 VDD VSS sg13g2_decap_8
XFILLER_173_667 VDD VSS sg13g2_decap_8
X_15228_ _15228_/Q _15237_/CLK _15228_/D _15228_/RESET_B VDD VSS sg13g2_dfrbpq_1
XFILLER_126_550 VDD VSS sg13g2_fill_1
XFILLER_12_1365 VDD VSS sg13g2_decap_8
XFILLER_145_369 VDD VSS sg13g2_decap_8
XFILLER_154_870 VDD VSS sg13g2_fill_2
XFILLER_86_1444 VDD VSS sg13g2_decap_8
XFILLER_114_712 VDD VSS sg13g2_fill_1
XFILLER_113_200 VDD VSS sg13g2_decap_4
XFILLER_126_583 VDD VSS sg13g2_decap_8
X_13864__2408 _13864_/RESET_B VDD VSS sg13g2_tiehi
X_15159_ _15159_/Q _15216_/CLK _15159_/D _15159_/RESET_B VDD VSS sg13g2_dfrbpq_1
XFILLER_114_745 VDD VSS sg13g2_fill_1
XFILLER_153_380 VDD VSS sg13g2_fill_1
XFILLER_47_1428 VDD VSS sg13g2_decap_8
XFILLER_113_233 VDD VSS sg13g2_decap_8
XFILLER_114_756 VDD VSS sg13g2_decap_8
X_13900__2372 _13900_/RESET_B VDD VSS sg13g2_tiehi
XFILLER_99_456 VDD VSS sg13g2_decap_8
XFILLER_141_564 VDD VSS sg13g2_decap_8
XFILLER_173_1469 VDD VSS sg13g2_decap_4
X_07981_ _07985_/A _07980_/Y _15075_/Q _07981_/C VDD VSS sg13g2_nand3b_1
X_09720_ _14311_/D _09885_/A0 _14311_/Q _09738_/S VDD VSS sg13g2_mux2_1
XFILLER_80_1032 VDD VSS sg13g2_decap_4
XFILLER_68_854 VDD VSS sg13g2_decap_8
XFILLER_45_1196 VDD VSS sg13g2_fill_2
X_14244__2028 _14244_/RESET_B VDD VSS sg13g2_tiehi
X_09651_ _14244_/D _10147_/A1 _14244_/Q _09672_/S VDD VSS sg13g2_mux2_1
XFILLER_83_802 VDD VSS sg13g2_decap_4
XFILLER_41_1049 VDD VSS sg13g2_decap_8
XFILLER_110_984 VDD VSS sg13g2_decap_8
XFILLER_95_684 VDD VSS sg13g2_decap_8
XFILLER_68_898 VDD VSS sg13g2_fill_2
XFILLER_67_375 VDD VSS sg13g2_decap_8
XFILLER_27_206 VDD VSS sg13g2_decap_8
XFILLER_132_1177 VDD VSS sg13g2_decap_8
X_08602_ _08615_/A _15015_/Q _08627_/A2 _08674_/B1 VDD VSS sg13g2_o21ai_1
XFILLER_103_27 VDD VSS sg13g2_decap_4
XFILLER_83_846 VDD VSS sg13g2_fill_2
XFILLER_55_537 VDD VSS sg13g2_decap_8
X_09582_ _14179_/D _14179_/Q _09582_/A1 _09601_/S VDD VSS sg13g2_mux2_1
XFILLER_82_334 VDD VSS sg13g2_decap_8
XFILLER_83_868 VDD VSS sg13g2_decap_8
X_08533_ _08533_/Y _08567_/B _08532_/Y _08667_/A1 VDD VSS sg13g2_a21oi_1
XFILLER_93_1404 VDD VSS sg13g2_decap_8
XFILLER_82_367 VDD VSS sg13g2_decap_4
XFILLER_63_570 VDD VSS sg13g2_decap_8
XFILLER_35_283 VDD VSS sg13g2_decap_8
X_08464_ _08475_/D _08027_/Y _08242_/A _08463_/Y VDD VSS sg13g2_a21oi_1
XFILLER_168_428 VDD VSS sg13g2_decap_8
X_08395_ _08395_/Y _08395_/A _08395_/B VDD VSS sg13g2_nor2_1
XFILLER_52_1112 VDD VSS sg13g2_decap_8
XFILLER_17_1243 VDD VSS sg13g2_decap_8
XFILLER_91_1172 VDD VSS sg13g2_decap_8
XFILLER_177_951 VDD VSS sg13g2_decap_8
XFILLER_32_990 VDD VSS sg13g2_decap_8
XFILLER_137_9 VDD VSS sg13g2_fill_1
XFILLER_177_962 VDD VSS sg13g2_fill_2
XFILLER_108_1382 VDD VSS sg13g2_decap_8
XFILLER_91_1194 VDD VSS sg13g2_fill_1
XFILLER_104_1224 VDD VSS sg13g2_decap_8
XFILLER_149_675 VDD VSS sg13g2_decap_8
XFILLER_148_163 VDD VSS sg13g2_decap_8
XFILLER_12_35 VDD VSS sg13g2_decap_8
XFILLER_176_483 VDD VSS sg13g2_decap_8
XFILLER_52_1189 VDD VSS sg13g2_decap_4
XFILLER_163_100 VDD VSS sg13g2_fill_1
XFILLER_176_494 VDD VSS sg13g2_decap_8
XFILLER_104_1279 VDD VSS sg13g2_fill_1
X_09016_ _09019_/A _09141_/A _09016_/B _09016_/C VDD VSS sg13g2_nand3_1
XFILLER_30_1465 VDD VSS sg13g2_decap_8
XFILLER_164_689 VDD VSS sg13g2_decap_8
XFILLER_151_317 VDD VSS sg13g2_decap_8
XFILLER_88_28 VDD VSS sg13g2_decap_8
XFILLER_145_892 VDD VSS sg13g2_decap_8
XFILLER_144_380 VDD VSS sg13g2_decap_4
XFILLER_137_1022 VDD VSS sg13g2_decap_4
X_14454__1818 _14454_/RESET_B VDD VSS sg13g2_tiehi
XFILLER_5_7 VDD VSS sg13g2_decap_8
XFILLER_176_1093 VDD VSS sg13g2_decap_8
XFILLER_105_778 VDD VSS sg13g2_decap_8
XFILLER_8_1400 VDD VSS sg13g2_decap_8
XFILLER_104_266 VDD VSS sg13g2_decap_8
XFILLER_137_1066 VDD VSS sg13g2_decap_8
Xfanout620 _13220_/B1 _13236_/B1 VDD VSS sg13g2_buf_1
Xfanout631 _13569_/S _13561_/S VDD VSS sg13g2_buf_1
XFILLER_63_1241 VDD VSS sg13g2_decap_8
Xfanout642 _11196_/B _11021_/B VDD VSS sg13g2_buf_1
X_09918_ _14503_/D _14503_/Q _09918_/A1 _09936_/S VDD VSS sg13g2_mux2_1
XFILLER_77_128 VDD VSS sg13g2_fill_2
Xfanout653 _10767_/A _10740_/A1 VDD VSS sg13g2_buf_1
XFILLER_120_759 VDD VSS sg13g2_decap_8
XFILLER_24_1225 VDD VSS sg13g2_decap_8
XFILLER_144_89 VDD VSS sg13g2_decap_8
Xfanout664 _10669_/S _10691_/S VDD VSS sg13g2_buf_1
XFILLER_150_1233 VDD VSS sg13g2_decap_8
Xfanout675 _08835_/B _08828_/Y VDD VSS sg13g2_buf_1
XFILLER_8_1477 VDD VSS sg13g2_fill_2
XFILLER_58_342 VDD VSS sg13g2_decap_8
XFILLER_115_1364 VDD VSS sg13g2_fill_1
Xfanout686 _08221_/A2 _07997_/Y VDD VSS sg13g2_buf_1
XFILLER_101_973 VDD VSS sg13g2_fill_1
Xfanout697 _12763_/C1 _12791_/C1 VDD VSS sg13g2_buf_1
X_09849_ _14436_/D _14436_/Q _10047_/A0 _09866_/S VDD VSS sg13g2_mux2_1
XFILLER_37_21 VDD VSS sg13g2_decap_8
XFILLER_115_1386 VDD VSS sg13g2_fill_1
XFILLER_19_729 VDD VSS sg13g2_decap_8
XFILLER_85_150 VDD VSS sg13g2_decap_8
XFILLER_85_161 VDD VSS sg13g2_fill_2
XFILLER_18_217 VDD VSS sg13g2_decap_8
X_12860_ _12876_/A _12861_/B _12861_/A VDD VSS sg13g2_nor2_1
XFILLER_98_1359 VDD VSS sg13g2_decap_8
XFILLER_6_1190 VDD VSS sg13g2_decap_8
XFILLER_85_194 VDD VSS sg13g2_decap_8
XFILLER_74_868 VDD VSS sg13g2_decap_8
XFILLER_2_1043 VDD VSS sg13g2_decap_8
X_11811_ _11811_/Y _12103_/A1 _14636_/Q VDD VSS sg13g2_nand2b_1
XFILLER_73_367 VDD VSS sg13g2_decap_8
XFILLER_37_98 VDD VSS sg13g2_decap_4
XFILLER_15_913 VDD VSS sg13g2_decap_8
XFILLER_160_77 VDD VSS sg13g2_decap_8
XFILLER_96_1050 VDD VSS sg13g2_decap_8
X_12791_ _12792_/B _13662_/Q _12791_/A2 _12790_/X _12791_/B2 _12791_/C1 VDD VSS sg13g2_a221oi_1
XFILLER_57_1023 VDD VSS sg13g2_fill_1
XFILLER_54_570 VDD VSS sg13g2_decap_8
X_14530_ _14530_/Q _14656_/CLK _14530_/D _14530_/RESET_B VDD VSS sg13g2_dfrbpq_1
XFILLER_57_1034 VDD VSS sg13g2_decap_8
X_11742_ _11743_/B _11742_/A _11742_/B _11742_/C VDD VSS sg13g2_nand3_1
XFILLER_109_1124 VDD VSS sg13g2_decap_8
XFILLER_14_434 VDD VSS sg13g2_decap_8
XFILLER_57_1067 VDD VSS sg13g2_decap_8
XFILLER_186_203 VDD VSS sg13g2_decap_8
XFILLER_57_1078 VDD VSS sg13g2_fill_2
XFILLER_148_1195 VDD VSS sg13g2_decap_8
XFILLER_42_776 VDD VSS sg13g2_decap_8
XFILLER_149_0 VDD VSS sg13g2_decap_8
XFILLER_169_42 VDD VSS sg13g2_decap_8
X_14461_ _14461_/Q _14883_/CLK _14461_/D _14461_/RESET_B VDD VSS sg13g2_dfrbpq_1
X_11673_ _11673_/Y _12033_/A1 _14568_/Q VDD VSS sg13g2_nand2b_1
XFILLER_74_1370 VDD VSS sg13g2_fill_2
XFILLER_41_275 VDD VSS sg13g2_decap_8
XFILLER_161_1340 VDD VSS sg13g2_decap_8
XFILLER_122_1302 VDD VSS sg13g2_decap_8
X_13412_ _13448_/C _15198_/Q _13412_/B _13412_/C VDD VSS sg13g2_nor3_1
X_10624_ _10626_/C _14883_/Q _10636_/A VDD VSS sg13g2_nand2b_1
XFILLER_122_1313 VDD VSS sg13g2_fill_2
XFILLER_168_973 VDD VSS sg13g2_decap_8
X_14392_ _14392_/Q clkload24/A _14392_/D _14392_/RESET_B VDD VSS sg13g2_dfrbpq_1
XFILLER_70_1256 VDD VSS sg13g2_decap_8
XFILLER_10_651 VDD VSS sg13g2_decap_8
XFILLER_127_303 VDD VSS sg13g2_decap_8
XFILLER_183_921 VDD VSS sg13g2_fill_2
XFILLER_70_1267 VDD VSS sg13g2_fill_1
X_13343_ _13343_/Y _13654_/S _13343_/B VDD VSS sg13g2_nand2_1
XFILLER_139_185 VDD VSS sg13g2_decap_8
XFILLER_167_494 VDD VSS sg13g2_decap_8
XFILLER_182_420 VDD VSS sg13g2_decap_8
X_10555_ _10557_/A _14867_/Q _10555_/B VDD VSS sg13g2_nand2b_1
XFILLER_183_954 VDD VSS sg13g2_fill_1
XFILLER_6_644 VDD VSS sg13g2_decap_8
XFILLER_154_144 VDD VSS sg13g2_decap_8
XFILLER_185_63 VDD VSS sg13g2_decap_8
X_13274_ _13274_/Y _14830_/Q _13274_/A2 _13249_/B _14894_/Q _13274_/C1 VDD VSS sg13g2_a221oi_1
X_10486_ _10512_/B _14849_/Q _10489_/C _14847_/Q _10486_/D VDD VSS sg13g2_nand4_1
XFILLER_154_177 VDD VSS sg13g2_decap_8
XFILLER_5_154 VDD VSS sg13g2_decap_8
XFILLER_142_328 VDD VSS sg13g2_decap_4
X_15013_ _15013_/Q clkload47/A _15013_/D _15013_/RESET_B VDD VSS sg13g2_dfrbpq_1
XFILLER_120_1092 VDD VSS sg13g2_fill_2
XFILLER_155_1100 VDD VSS sg13g2_decap_8
XFILLER_182_497 VDD VSS sg13g2_decap_8
X_12225_ _12225_/Y _12224_/Y _12223_/X _12204_/Y _12225_/B2 _12271_/A VDD VSS sg13g2_a221oi_1
XFILLER_170_648 VDD VSS sg13g2_decap_8
XFILLER_151_862 VDD VSS sg13g2_fill_1
XFILLER_155_1144 VDD VSS sg13g2_decap_8
X_12156_ _12156_/Y _12156_/A _12156_/B _12156_/C VDD VSS sg13g2_nand3_1
XFILLER_78_50 VDD VSS sg13g2_decap_8
XFILLER_2_861 VDD VSS sg13g2_decap_8
XFILLER_38_7 VDD VSS sg13g2_decap_8
XFILLER_150_383 VDD VSS sg13g2_decap_8
XFILLER_1_371 VDD VSS sg13g2_decap_8
X_11107_ _11107_/Y _11097_/Y _10764_/X _11140_/B2 VDD VSS sg13g2_a21oi_1
XFILLER_155_1199 VDD VSS sg13g2_decap_8
XFILLER_68_139 VDD VSS sg13g2_decap_8
X_12087_ _12087_/X _14132_/Q _14164_/Q _12090_/A VDD VSS sg13g2_mux2_1
XFILLER_81_1374 VDD VSS sg13g2_decap_4
XFILLER_77_640 VDD VSS sg13g2_decap_8
XFILLER_110_258 VDD VSS sg13g2_decap_8
XFILLER_133_1453 VDD VSS sg13g2_decap_8
X_11038_ _11044_/A _11064_/C _11036_/Y _11037_/Y VDD VSS sg13g2_o21ai_1
XFILLER_49_386 VDD VSS sg13g2_fill_2
XFILLER_65_846 VDD VSS sg13g2_decap_8
X_14791__3015 _14791_/RESET_B VDD VSS sg13g2_tiehi
XFILLER_92_687 VDD VSS sg13g2_decap_8
XFILLER_75_1101 VDD VSS sg13g2_fill_2
XFILLER_64_378 VDD VSS sg13g2_decap_4
X_12989_ _12993_/B _12943_/A _12989_/B _12989_/C VDD VSS sg13g2_nand3b_1
XFILLER_79_1281 VDD VSS sg13g2_decap_8
XFILLER_33_710 VDD VSS sg13g2_decap_8
XFILLER_127_1202 VDD VSS sg13g2_decap_8
XFILLER_166_1251 VDD VSS sg13g2_decap_8
XFILLER_91_197 VDD VSS sg13g2_decap_8
XFILLER_17_294 VDD VSS sg13g2_decap_8
X_14728_ _14728_/Q clkload23/A _14728_/D _14728_/RESET_B VDD VSS sg13g2_dfrbpq_1
XFILLER_127_1235 VDD VSS sg13g2_fill_1
XFILLER_177_203 VDD VSS sg13g2_decap_8
XFILLER_75_1167 VDD VSS sg13g2_decap_8
XFILLER_75_1178 VDD VSS sg13g2_fill_2
XFILLER_36_1129 VDD VSS sg13g2_decap_8
X_14659_ _14659_/Q _14729_/CLK _14659_/D _14659_/RESET_B VDD VSS sg13g2_dfrbpq_1
X_13918__2354 _13918_/RESET_B VDD VSS sg13g2_tiehi
X_14678__1594 _14678_/RESET_B VDD VSS sg13g2_tiehi
XFILLER_60_595 VDD VSS sg13g2_decap_8
XFILLER_159_973 VDD VSS sg13g2_decap_8
X_08180_ _08187_/B _08246_/A1 _08170_/X _08397_/A _08179_/Y VDD VSS sg13g2_a22oi_1
XFILLER_174_910 VDD VSS sg13g2_decap_8
XFILLER_119_837 VDD VSS sg13g2_decap_8
XFILLER_14_1449 VDD VSS sg13g2_decap_8
XFILLER_146_634 VDD VSS sg13g2_decap_4
XFILLER_185_280 VDD VSS sg13g2_decap_8
X_14822__2984 _14822_/RESET_B VDD VSS sg13g2_tiehi
XFILLER_64_0 VDD VSS sg13g2_decap_8
XFILLER_173_464 VDD VSS sg13g2_decap_8
XFILLER_12_1162 VDD VSS sg13g2_decap_8
Xmax_cap1482 _13021_/A _10209_/A VDD VSS sg13g2_buf_8
XFILLER_86_1252 VDD VSS sg13g2_decap_8
XFILLER_47_1214 VDD VSS sg13g2_decap_8
XFILLER_126_391 VDD VSS sg13g2_decap_8
XFILLER_138_1342 VDD VSS sg13g2_decap_8
XFILLER_160_147 VDD VSS sg13g2_decap_8
XFILLER_99_242 VDD VSS sg13g2_decap_8
XFILLER_173_1233 VDD VSS sg13g2_fill_2
XFILLER_86_1296 VDD VSS sg13g2_decap_4
XFILLER_47_1247 VDD VSS sg13g2_decap_8
XFILLER_134_1206 VDD VSS sg13g2_decap_4
XFILLER_173_1255 VDD VSS sg13g2_decap_8
XFILLER_88_938 VDD VSS sg13g2_decap_8
XFILLER_88_949 VDD VSS sg13g2_fill_1
XFILLER_87_426 VDD VSS sg13g2_fill_1
XFILLER_141_394 VDD VSS sg13g2_decap_8
X_07964_ _07964_/Y _08641_/C _07963_/Y _07962_/Y VDD VSS sg13g2_a21oi_1
XFILLER_4_91 VDD VSS sg13g2_decap_8
XFILLER_101_236 VDD VSS sg13g2_decap_8
X_09703_ _14295_/D _09934_/A1 _14295_/Q _09703_/S VDD VSS sg13g2_mux2_1
X_07895_ _08037_/A _08023_/A _07903_/B VDD VSS sg13g2_or2_1
XFILLER_60_1458 VDD VSS sg13g2_decap_8
XFILLER_56_835 VDD VSS sg13g2_decap_8
X_09634_ _14230_/D _09634_/A0 _14230_/Q _09637_/S VDD VSS sg13g2_mux2_1
XFILLER_3_1330 VDD VSS sg13g2_decap_8
XFILLER_28_559 VDD VSS sg13g2_decap_8
XFILLER_71_805 VDD VSS sg13g2_decap_8
XFILLER_167_1026 VDD VSS sg13g2_decap_8
X_09565_ _14163_/D _10095_/A0 _14163_/Q _09567_/S VDD VSS sg13g2_mux2_1
XFILLER_110_1272 VDD VSS sg13g2_decap_4
XFILLER_82_175 VDD VSS sg13g2_fill_1
XFILLER_71_849 VDD VSS sg13g2_decap_4
XFILLER_58_1332 VDD VSS sg13g2_decap_8
XFILLER_184_1340 VDD VSS sg13g2_decap_8
X_08516_ _08517_/D _07816_/X _08653_/A _08515_/Y _07815_/X _08514_/Y VDD VSS sg13g2_a221oi_1
X_09496_ _14096_/D _10159_/A1 _14096_/Q _09500_/S VDD VSS sg13g2_mux2_1
XFILLER_23_220 VDD VSS sg13g2_fill_2
XFILLER_93_1267 VDD VSS sg13g2_decap_4
XFILLER_51_551 VDD VSS sg13g2_decap_8
XFILLER_24_765 VDD VSS sg13g2_decap_8
XFILLER_145_1346 VDD VSS sg13g2_decap_8
XFILLER_168_214 VDD VSS sg13g2_decap_8
XFILLER_51_562 VDD VSS sg13g2_fill_1
XFILLER_23_253 VDD VSS sg13g2_decap_8
XFILLER_169_748 VDD VSS sg13g2_decap_8
XFILLER_180_1237 VDD VSS sg13g2_fill_2
X_08447_ _08447_/X _08577_/A _08447_/B VDD VSS sg13g2_and2_1
XFILLER_12_938 VDD VSS sg13g2_decap_8
XFILLER_142_7 VDD VSS sg13g2_fill_2
X_14508__1764 _14508_/RESET_B VDD VSS sg13g2_tiehi
XFILLER_11_448 VDD VSS sg13g2_decap_8
X_08378_ _08378_/Y _08621_/B _08376_/X _08377_/Y VDD VSS sg13g2_o21ai_1
XFILLER_23_56 VDD VSS sg13g2_decap_8
XFILLER_137_601 VDD VSS sg13g2_decap_8
XFILLER_183_217 VDD VSS sg13g2_decap_8
XFILLER_104_1043 VDD VSS sg13g2_decap_8
XFILLER_139_56 VDD VSS sg13g2_decap_8
XFILLER_176_280 VDD VSS sg13g2_decap_8
XFILLER_137_678 VDD VSS sg13g2_decap_8
X_10340_ _14806_/D _10414_/B _10357_/D _10337_/B _07647_/Y _13328_/A VDD VSS sg13g2_a221oi_1
XFILLER_118_881 VDD VSS sg13g2_decap_8
XFILLER_152_626 VDD VSS sg13g2_decap_8
XFILLER_69_1450 VDD VSS sg13g2_fill_1
XFILLER_178_1188 VDD VSS sg13g2_decap_8
XFILLER_178_1199 VDD VSS sg13g2_fill_1
X_10271_ _10271_/Y _10305_/A _10423_/C VDD VSS sg13g2_nand2b_1
XFILLER_30_1295 VDD VSS sg13g2_decap_8
XFILLER_151_136 VDD VSS sg13g2_fill_1
XFILLER_3_658 VDD VSS sg13g2_decap_8
X_12010_ _12055_/D _12008_/Y _12010_/B VDD VSS sg13g2_nand2b_1
Xpicorv32_macro_1511 mem_axi_awaddr[0] VDD VSS sg13g2_tielo
XFILLER_155_77 VDD VSS sg13g2_decap_8
XFILLER_65_1347 VDD VSS sg13g2_fill_1
XFILLER_117_1426 VDD VSS sg13g2_decap_8
XFILLER_65_1358 VDD VSS sg13g2_decap_8
XFILLER_2_168 VDD VSS sg13g2_decap_8
Xfanout1404 _12035_/S0 fanout1410/X VDD VSS sg13g2_buf_1
Xfanout1415 _11804_/A fanout1419/X VDD VSS sg13g2_buf_1
Xfanout1426 _11874_/S0 _11226_/S0 VDD VSS sg13g2_buf_1
Xfanout1437 _11279_/A1 _11277_/S VDD VSS sg13g2_buf_1
Xfanout450 _12415_/A _12400_/A VDD VSS sg13g2_buf_1
Xfanout1448 _12259_/S0 fanout1452/X VDD VSS sg13g2_buf_1
XFILLER_48_42 VDD VSS sg13g2_decap_8
XFILLER_171_21 VDD VSS sg13g2_decap_8
Xfanout461 _10130_/S _10136_/S VDD VSS sg13g2_buf_1
Xfanout1459 _11442_/S0 _11444_/S0 VDD VSS sg13g2_buf_1
XFILLER_115_1150 VDD VSS sg13g2_decap_8
XFILLER_150_1030 VDD VSS sg13g2_fill_1
Xfanout472 _10003_/S _09971_/Y VDD VSS sg13g2_buf_1
X_13961_ _13961_/Q clkload35/A _13961_/D _13961_/RESET_B VDD VSS sg13g2_dfrbpq_1
XFILLER_8_1274 VDD VSS sg13g2_decap_8
XFILLER_65_109 VDD VSS sg13g2_fill_1
XFILLER_19_515 VDD VSS sg13g2_decap_8
Xfanout483 _09805_/S _09793_/S VDD VSS sg13g2_buf_1
Xfanout494 _09571_/S wire495/X VDD VSS sg13g2_buf_1
XFILLER_59_684 VDD VSS sg13g2_decap_8
XFILLER_4_1127 VDD VSS sg13g2_decap_8
X_12912_ _12914_/B _12911_/Y _12799_/X input19/X _12801_/Y VDD VSS sg13g2_a22oi_1
XFILLER_58_183 VDD VSS sg13g2_decap_8
XFILLER_100_280 VDD VSS sg13g2_fill_2
XFILLER_171_98 VDD VSS sg13g2_decap_8
X_13892_ _13892_/Q clkload39/A _13892_/D _13892_/RESET_B VDD VSS sg13g2_dfrbpq_1
X_14864__2909 _14864_/RESET_B VDD VSS sg13g2_tiehi
XFILLER_98_1145 VDD VSS sg13g2_decap_8
XFILLER_0_49 VDD VSS sg13g2_decap_8
XFILLER_104_70 VDD VSS sg13g2_decap_8
XFILLER_73_153 VDD VSS sg13g2_decap_8
X_12843_ _12845_/C _13609_/A _12899_/C input6/X _12899_/A VDD VSS sg13g2_nand4_1
XFILLER_76_1410 VDD VSS sg13g2_fill_1
XFILLER_34_529 VDD VSS sg13g2_fill_1
XFILLER_15_721 VDD VSS sg13g2_decap_8
XFILLER_76_1454 VDD VSS sg13g2_fill_1
X_12774_ _12774_/X _12767_/X _12771_/X _12766_/X _12770_/X _12553_/S _12775_/S1 VDD
+ VSS sg13g2_mux4_1
XFILLER_14_231 VDD VSS sg13g2_decap_8
XFILLER_42_551 VDD VSS sg13g2_decap_8
XFILLER_163_1435 VDD VSS sg13g2_decap_8
X_14513_ _14513_/Q _14513_/CLK _14513_/D _14513_/RESET_B VDD VSS sg13g2_dfrbpq_1
XFILLER_9_14 VDD VSS sg13g2_decap_8
XFILLER_30_702 VDD VSS sg13g2_fill_2
X_11725_ _11725_/Y _11726_/A _13678_/Q VDD VSS sg13g2_nor2_1
XFILLER_15_798 VDD VSS sg13g2_decap_4
XFILLER_159_258 VDD VSS sg13g2_decap_8
XFILLER_147_409 VDD VSS sg13g2_decap_8
X_14444_ _14444_/Q clkload17/A _14444_/D _14444_/RESET_B VDD VSS sg13g2_dfrbpq_1
X_11656_ _11656_/Y _11793_/A1 _11654_/X _11722_/B2 VDD VSS sg13g2_a21oi_1
XFILLER_122_1121 VDD VSS sg13g2_decap_4
XFILLER_174_217 VDD VSS sg13g2_decap_8
X_10607_ _10614_/A _14878_/Q _14877_/Q _10607_/C _10607_/D VDD VSS sg13g2_nand4_1
XFILLER_167_280 VDD VSS sg13g2_decap_8
X_14375_ _14375_/Q _14741_/CLK _14375_/D _14375_/RESET_B VDD VSS sg13g2_dfrbpq_1
XFILLER_7_931 VDD VSS sg13g2_decap_8
X_14948__2741 _14948_/RESET_B VDD VSS sg13g2_tiehi
X_11587_ _11587_/Y _11586_/Y wire274/X _11572_/X _12225_/B2 _12271_/A VDD VSS sg13g2_a221oi_1
XFILLER_116_807 VDD VSS sg13g2_decap_8
XFILLER_156_976 VDD VSS sg13g2_decap_8
XFILLER_171_902 VDD VSS sg13g2_fill_2
XFILLER_31_1059 VDD VSS sg13g2_fill_2
XFILLER_155_453 VDD VSS sg13g2_decap_8
X_13326_ _15066_/D _13328_/A _13326_/B VDD VSS sg13g2_nor2_1
XFILLER_6_441 VDD VSS sg13g2_decap_8
XFILLER_127_155 VDD VSS sg13g2_fill_2
X_10538_ _10547_/D _10538_/A _10538_/B _10567_/A _10567_/B VDD VSS sg13g2_nor4_1
XFILLER_100_1452 VDD VSS sg13g2_fill_2
XFILLER_182_294 VDD VSS sg13g2_decap_8
X_13257_ _13270_/A _14924_/Q _13663_/Q VDD VSS sg13g2_nand2_1
X_10469_ _10472_/C _10500_/A _10473_/D _14845_/Q VDD VSS sg13g2_a21oi_1
XFILLER_171_979 VDD VSS sg13g2_fill_1
X_12208_ _12208_/Y _12207_/X _12219_/S VDD VSS sg13g2_nand2b_1
XFILLER_83_1436 VDD VSS sg13g2_decap_8
X_13188_ _13202_/A _13188_/A _13225_/B _13225_/A VDD VSS sg13g2_nand3_1
XFILLER_151_681 VDD VSS sg13g2_fill_2
XFILLER_96_212 VDD VSS sg13g2_fill_1
XFILLER_97_746 VDD VSS sg13g2_decap_8
XFILLER_170_1439 VDD VSS sg13g2_fill_2
X_12139_ _12139_/X _14133_/Q _14165_/Q _14197_/Q _14229_/Q _12140_/S0 _12140_/S1 VDD
+ VSS sg13g2_mux4_1
XFILLER_96_245 VDD VSS sg13g2_fill_2
XFILLER_81_1171 VDD VSS sg13g2_decap_8
XFILLER_38_802 VDD VSS sg13g2_decap_8
XFILLER_84_418 VDD VSS sg13g2_decap_8
X_15126__2800 _15126_/RESET_B VDD VSS sg13g2_tiehi
XFILLER_65_610 VDD VSS sg13g2_decap_8
XFILLER_93_930 VDD VSS sg13g2_decap_8
XFILLER_93_941 VDD VSS sg13g2_fill_2
XFILLER_77_492 VDD VSS sg13g2_decap_8
X_07680_ _07680_/Y _13293_/A _11243_/C _07679_/Y VDD VSS sg13g2_a21oi_1
XFILLER_168_1313 VDD VSS sg13g2_fill_2
XFILLER_20_1420 VDD VSS sg13g2_decap_8
X_14161__2111 _14161_/RESET_B VDD VSS sg13g2_tiehi
X_16878_ _16878_/X _16878_/A VDD VSS sg13g2_buf_1
XFILLER_93_985 VDD VSS sg13g2_decap_8
XFILLER_65_676 VDD VSS sg13g2_decap_8
XFILLER_64_153 VDD VSS sg13g2_decap_8
XFILLER_80_613 VDD VSS sg13g2_decap_8
XFILLER_168_1379 VDD VSS sg13g2_decap_4
XFILLER_46_890 VDD VSS sg13g2_decap_8
X_09350_ _13954_/D _10045_/A0 _13954_/Q _09363_/S VDD VSS sg13g2_mux2_1
X_14755__3054 _14755_/RESET_B VDD VSS sg13g2_tiehi
XFILLER_80_679 VDD VSS sg13g2_decap_8
X_08301_ _08301_/X _08215_/X _08300_/X _08301_/S VDD VSS sg13g2_mux2_1
XFILLER_21_702 VDD VSS sg13g2_decap_8
X_09281_ _13889_/D _13889_/Q _09945_/A1 _09305_/S VDD VSS sg13g2_mux2_1
XFILLER_90_1429 VDD VSS sg13g2_decap_8
XFILLER_33_573 VDD VSS sg13g2_fill_2
XFILLER_178_567 VDD VSS sg13g2_decap_8
X_08232_ _08232_/Y _07924_/C _08230_/Y _08231_/Y VDD VSS sg13g2_a21oi_1
XFILLER_127_1087 VDD VSS sg13g2_decap_8
XFILLER_18_1360 VDD VSS sg13g2_decap_8
X_14194__2078 _14194_/RESET_B VDD VSS sg13g2_tiehi
XFILLER_20_245 VDD VSS sg13g2_decap_8
XFILLER_53_1273 VDD VSS sg13g2_fill_1
X_08163_ _08163_/Y _08290_/S _08162_/Y _08160_/Y VDD VSS sg13g2_a21oi_1
XFILLER_105_1363 VDD VSS sg13g2_decap_4
XFILLER_140_1243 VDD VSS sg13g2_decap_8
XFILLER_14_1246 VDD VSS sg13g2_decap_8
XFILLER_88_1303 VDD VSS sg13g2_fill_2
XFILLER_179_1431 VDD VSS sg13g2_decap_8
XFILLER_107_807 VDD VSS sg13g2_fill_2
XFILLER_162_913 VDD VSS sg13g2_decap_8
X_08094_ _08094_/X _08383_/A _07945_/B _07790_/A _08427_/A3 _08402_/A _08063_/A VDD
+ VSS sg13g2_mux4_1
XFILLER_109_59 VDD VSS sg13g2_decap_4
XFILLER_146_486 VDD VSS sg13g2_decap_8
Xclkload60 clkload60/Y clkload60/A VDD VSS sg13g2_inv_1
XFILLER_173_294 VDD VSS sg13g2_decap_8
Xclkload71 clkload71/Y clkload71/A VDD VSS sg13g2_inv_2
Xmax_cap1290 _16868_/A _13706_/Q VDD VSS sg13g2_buf_4
XFILLER_162_968 VDD VSS sg13g2_decap_8
XFILLER_175_1339 VDD VSS sg13g2_fill_1
Xclkload82 clkload82/Y clkload82/A VDD VSS sg13g2_inv_1
XFILLER_162_979 VDD VSS sg13g2_fill_2
XFILLER_115_851 VDD VSS sg13g2_decap_8
XFILLER_133_147 VDD VSS sg13g2_decap_8
XFILLER_133_158 VDD VSS sg13g2_fill_2
XFILLER_86_1082 VDD VSS sg13g2_decap_8
XFILLER_86_1093 VDD VSS sg13g2_fill_1
XFILLER_47_1044 VDD VSS sg13g2_decap_8
XFILLER_125_14 VDD VSS sg13g2_decap_8
XFILLER_142_670 VDD VSS sg13g2_decap_8
XFILLER_125_25 VDD VSS sg13g2_fill_2
XFILLER_170_990 VDD VSS sg13g2_decap_4
X_14371__1901 _14371_/RESET_B VDD VSS sg13g2_tiehi
XFILLER_130_832 VDD VSS sg13g2_decap_4
XFILLER_114_394 VDD VSS sg13g2_decap_4
XFILLER_141_180 VDD VSS sg13g2_decap_8
XFILLER_76_908 VDD VSS sg13g2_fill_1
X_08996_ wire432/A _08993_/X _08995_/Y _08992_/Y VDD VSS sg13g2_o21ai_1
XFILLER_60_1222 VDD VSS sg13g2_decap_4
XFILLER_5_1414 VDD VSS sg13g2_decap_8
XFILLER_102_589 VDD VSS sg13g2_decap_8
X_07947_ _08443_/A _08435_/A _08574_/A _07945_/Y VDD VSS sg13g2_o21ai_1
XFILLER_99_1410 VDD VSS sg13g2_fill_1
XFILLER_112_1312 VDD VSS sg13g2_decap_4
XFILLER_87_289 VDD VSS sg13g2_fill_1
XFILLER_69_993 VDD VSS sg13g2_fill_2
XFILLER_25_1364 VDD VSS sg13g2_decap_8
XFILLER_99_1421 VDD VSS sg13g2_decap_8
XFILLER_68_470 VDD VSS sg13g2_decap_8
XFILLER_21_1228 VDD VSS sg13g2_decap_8
XFILLER_18_56 VDD VSS sg13g2_decap_8
X_07878_ _07878_/Y _08105_/A _08103_/B VDD VSS sg13g2_nand2_1
XFILLER_29_868 VDD VSS sg13g2_decap_8
X_09617_ _14213_/D _09916_/A1 _14213_/Q _09630_/S VDD VSS sg13g2_mux2_1
XFILLER_16_518 VDD VSS sg13g2_decap_8
XFILLER_70_101 VDD VSS sg13g2_decap_8
XFILLER_71_646 VDD VSS sg13g2_decap_8
X_09548_ _14146_/D _10078_/A0 _14146_/Q _09567_/S VDD VSS sg13g2_mux2_1
XFILLER_43_359 VDD VSS sg13g2_decap_8
XFILLER_71_679 VDD VSS sg13g2_decap_8
XFILLER_58_1162 VDD VSS sg13g2_decap_8
XFILLER_180_1012 VDD VSS sg13g2_fill_1
XFILLER_24_573 VDD VSS sg13g2_fill_2
X_09479_ _14079_/D _09976_/A0 _14079_/Q _09506_/S VDD VSS sg13g2_mux2_1
XFILLER_34_77 VDD VSS sg13g2_decap_4
XFILLER_12_735 VDD VSS sg13g2_decap_8
XFILLER_19_1168 VDD VSS sg13g2_decap_8
XFILLER_93_1097 VDD VSS sg13g2_decap_8
X_11510_ _11510_/X _14243_/Q _14275_/Q _14307_/Q _14339_/Q _12140_/S0 _12140_/S1 VDD
+ VSS sg13g2_mux4_1
XFILLER_169_578 VDD VSS sg13g2_decap_8
XFILLER_156_206 VDD VSS sg13g2_decap_4
X_14024__2248 _14024_/RESET_B VDD VSS sg13g2_tiehi
X_12490_ _12490_/X _14245_/Q _14277_/Q _14309_/Q _14341_/Q _12654_/S0 _12654_/S1 VDD
+ VSS sg13g2_mux4_1
XFILLER_11_245 VDD VSS sg13g2_decap_8
XFILLER_8_728 VDD VSS sg13g2_decap_8
X_11441_ _11441_/X _13728_/Q _14080_/Q _14432_/Q _14528_/Q _11442_/S0 _11442_/S1 VDD
+ VSS sg13g2_mux4_1
XFILLER_50_21 VDD VSS sg13g2_decap_8
XFILLER_7_238 VDD VSS sg13g2_decap_8
XFILLER_165_751 VDD VSS sg13g2_decap_8
XFILLER_166_21 VDD VSS sg13g2_decap_8
XFILLER_153_913 VDD VSS sg13g2_decap_8
X_14160_ _14160_/Q _14733_/CLK _14160_/D _14160_/RESET_B VDD VSS sg13g2_dfrbpq_1
X_11372_ _11374_/A _11418_/A _14174_/Q VDD VSS sg13g2_nand2b_1
XFILLER_180_710 VDD VSS sg13g2_fill_1
XFILLER_50_87 VDD VSS sg13g2_decap_8
XFILLER_137_486 VDD VSS sg13g2_fill_2
XFILLER_109_188 VDD VSS sg13g2_fill_1
XFILLER_180_732 VDD VSS sg13g2_decap_8
X_13111_ _15040_/D _13155_/A _13111_/B VDD VSS sg13g2_nor2_1
XFILLER_124_125 VDD VSS sg13g2_fill_2
X_10323_ _10325_/A _14801_/Q _10323_/B VDD VSS sg13g2_nand2b_1
X_14091_ _14091_/Q clkload9/A _14091_/D _14091_/RESET_B VDD VSS sg13g2_dfrbpq_1
XFILLER_4_945 VDD VSS sg13g2_decap_8
XFILLER_166_98 VDD VSS sg13g2_decap_8
XFILLER_152_456 VDD VSS sg13g2_decap_8
XFILLER_106_862 VDD VSS sg13g2_decap_8
X_13042_ _13043_/B _13042_/A _13042_/B _13042_/C VDD VSS sg13g2_nand3_1
XFILLER_3_455 VDD VSS sg13g2_decap_8
X_10254_ _10256_/A _14779_/Q _10258_/D _14780_/Q VDD VSS sg13g2_a21o_1
XFILLER_59_41 VDD VSS sg13g2_decap_8
XFILLER_182_42 VDD VSS sg13g2_decap_8
Xfanout1201 _08887_/A1 _14971_/Q VDD VSS sg13g2_buf_1
XFILLER_26_1117 VDD VSS sg13g2_decap_8
XFILLER_105_394 VDD VSS sg13g2_decap_8
XFILLER_120_320 VDD VSS sg13g2_fill_2
Xfanout1212 _08276_/A _08296_/A1 VDD VSS sg13g2_buf_1
XFILLER_61_1008 VDD VSS sg13g2_decap_4
XFILLER_121_854 VDD VSS sg13g2_fill_1
Xfanout1223 _11503_/A1 _11461_/A VDD VSS sg13g2_buf_1
X_10185_ _10185_/Y _10185_/A _10185_/B _10185_/C VDD VSS sg13g2_nand3_1
XFILLER_67_908 VDD VSS sg13g2_decap_8
XFILLER_120_342 VDD VSS sg13g2_decap_8
XFILLER_152_1147 VDD VSS sg13g2_fill_1
Xfanout1234 _12900_/C _12814_/C VDD VSS sg13g2_buf_1
Xfanout1245 _13601_/A _14957_/Q VDD VSS sg13g2_buf_1
Xfanout1256 _10681_/A _14897_/Q VDD VSS sg13g2_buf_1
XFILLER_66_418 VDD VSS sg13g2_decap_8
Xfanout1267 _10486_/D _14846_/Q VDD VSS sg13g2_buf_1
XFILLER_8_1071 VDD VSS sg13g2_decap_8
XFILLER_43_1453 VDD VSS sg13g2_fill_2
XFILLER_120_386 VDD VSS sg13g2_decap_8
XFILLER_19_301 VDD VSS sg13g2_decap_8
X_14993_ _14993_/Q _15249_/CLK _14993_/D _14993_/RESET_B VDD VSS sg13g2_dfrbpq_1
Xfanout280 _10064_/S _10068_/S VDD VSS sg13g2_buf_1
Xfanout1278 _13613_/C _14748_/Q VDD VSS sg13g2_buf_1
Xfanout291 _09603_/S _09573_/X VDD VSS sg13g2_buf_1
XFILLER_93_248 VDD VSS sg13g2_decap_8
X_13944_ _13944_/Q _14744_/CLK _13944_/D _13944_/RESET_B VDD VSS sg13g2_dfrbpq_1
XFILLER_93_259 VDD VSS sg13g2_fill_2
XFILLER_46_120 VDD VSS sg13g2_fill_1
XFILLER_74_440 VDD VSS sg13g2_decap_8
XFILLER_47_654 VDD VSS sg13g2_decap_8
XFILLER_75_73 VDD VSS sg13g2_decap_8
XFILLER_46_142 VDD VSS sg13g2_decap_8
XFILLER_19_378 VDD VSS sg13g2_decap_8
X_13875_ _13875_/Q clkload41/A _13875_/D _13875_/RESET_B VDD VSS sg13g2_dfrbpq_1
X_12826_ _12826_/X _12900_/A _12900_/B _12867_/C input13/X VDD VSS sg13g2_and4_1
XFILLER_131_90 VDD VSS sg13g2_decap_8
X_15165__2606 _15165_/RESET_B VDD VSS sg13g2_tiehi
XFILLER_61_156 VDD VSS sg13g2_decap_8
X_12757_ _12757_/X _13752_/Q _14104_/Q _14456_/Q _14552_/Q _12757_/S0 _12757_/S1 VDD
+ VSS sg13g2_mux4_1
XFILLER_61_189 VDD VSS sg13g2_decap_8
XFILLER_30_510 VDD VSS sg13g2_decap_8
XFILLER_15_595 VDD VSS sg13g2_decap_8
XFILLER_163_1254 VDD VSS sg13g2_decap_8
X_11708_ _11708_/X _14569_/Q _14601_/Q _14633_/Q _14665_/Q _11713_/S0 _11713_/S1 VDD
+ VSS sg13g2_mux4_1
XFILLER_163_1287 VDD VSS sg13g2_decap_8
XFILLER_30_543 VDD VSS sg13g2_decap_8
X_12688_ _12688_/X _14387_/Q _14419_/Q _14483_/Q _14515_/Q _12689_/S0 _12689_/S1 VDD
+ VSS sg13g2_mux4_1
X_15155__2740 _15155_/RESET_B VDD VSS sg13g2_tiehi
XFILLER_50_1402 VDD VSS sg13g2_fill_2
XFILLER_124_1249 VDD VSS sg13g2_decap_8
XFILLER_175_526 VDD VSS sg13g2_decap_8
XFILLER_147_228 VDD VSS sg13g2_decap_8
XFILLER_30_576 VDD VSS sg13g2_decap_8
X_14427_ _14427_/Q clkload60/A _14427_/D _14427_/RESET_B VDD VSS sg13g2_dfrbpq_1
X_11639_ _11639_/Y _11570_/A _13683_/Q _13682_/Q _11591_/A VDD VSS sg13g2_a22oi_1
XFILLER_50_1435 VDD VSS sg13g2_fill_1
XFILLER_128_431 VDD VSS sg13g2_decap_8
XFILLER_50_1446 VDD VSS sg13g2_decap_8
XFILLER_128_464 VDD VSS sg13g2_decap_8
X_14358_ _14358_/Q _14518_/CLK _14358_/D _14358_/RESET_B VDD VSS sg13g2_dfrbpq_1
XFILLER_115_103 VDD VSS sg13g2_decap_8
XFILLER_116_626 VDD VSS sg13g2_decap_8
Xwire681 wire681/X wire681/A VDD VSS sg13g2_buf_4
XFILLER_183_581 VDD VSS sg13g2_decap_8
XFILLER_155_283 VDD VSS sg13g2_decap_8
XFILLER_157_1014 VDD VSS sg13g2_decap_4
X_13309_ _13309_/Y _13499_/C _15207_/Q _13306_/B VDD VSS sg13g2_a21oi_1
XFILLER_143_434 VDD VSS sg13g2_fill_1
X_14289_ _14289_/Q _14513_/CLK _14289_/D _14289_/RESET_B VDD VSS sg13g2_dfrbpq_1
XFILLER_131_618 VDD VSS sg13g2_decap_8
XFILLER_135_1301 VDD VSS sg13g2_decap_8
XFILLER_48_1353 VDD VSS sg13g2_decap_8
XFILLER_135_1312 VDD VSS sg13g2_fill_1
XFILLER_170_286 VDD VSS sg13g2_fill_1
XFILLER_83_1244 VDD VSS sg13g2_decap_8
XFILLER_130_128 VDD VSS sg13g2_fill_1
XFILLER_174_1372 VDD VSS sg13g2_decap_8
XFILLER_44_1217 VDD VSS sg13g2_decap_8
XFILLER_111_320 VDD VSS sg13g2_decap_8
X_08850_ _08850_/X _08849_/X _07912_/B _08850_/S VDD VSS sg13g2_mux2_1
XFILLER_69_245 VDD VSS sg13g2_decap_8
X_07801_ _07950_/A _15008_/Q _08471_/B VDD VSS sg13g2_nand2b_1
XFILLER_27_0 VDD VSS sg13g2_decap_8
XFILLER_57_418 VDD VSS sg13g2_fill_1
XFILLER_112_898 VDD VSS sg13g2_decap_4
X_08781_ _08781_/Y _13679_/Q _08781_/B VDD VSS sg13g2_nor2_1
XFILLER_57_429 VDD VSS sg13g2_decap_8
XFILLER_38_610 VDD VSS sg13g2_decap_8
XFILLER_84_226 VDD VSS sg13g2_decap_8
X_07732_ _08174_/B _15097_/Q _15092_/Q VDD VSS sg13g2_nor2_1
XFILLER_168_1121 VDD VSS sg13g2_decap_8
XFILLER_1_70 VDD VSS sg13g2_decap_8
X_07663_ _07663_/Y input36/X input3/X _14749_/Q VDD VSS sg13g2_o21ai_1
XFILLER_25_304 VDD VSS sg13g2_decap_8
XFILLER_53_635 VDD VSS sg13g2_decap_8
X_09402_ _14005_/D _09998_/A0 _14005_/Q _09406_/S VDD VSS sg13g2_mux2_1
XFILLER_81_955 VDD VSS sg13g2_decap_8
Xclkbuf_leaf_123_clk_i _14540_/CLK clkload1/A VDD VSS sg13g2_buf_8
XFILLER_111_38 VDD VSS sg13g2_decap_8
XFILLER_94_1340 VDD VSS sg13g2_fill_1
XFILLER_20_1294 VDD VSS sg13g2_decap_8
XFILLER_0_1366 VDD VSS sg13g2_decap_8
XFILLER_59_1471 VDD VSS sg13g2_fill_1
XFILLER_94_1362 VDD VSS sg13g2_decap_8
X_09333_ _13940_/D _09799_/A0 _13940_/Q _09333_/S VDD VSS sg13g2_mux2_1
XFILLER_181_1332 VDD VSS sg13g2_decap_8
XFILLER_107_1425 VDD VSS sg13g2_decap_4
XFILLER_178_364 VDD VSS sg13g2_decap_8
X_09264_ _13873_/D _13873_/Q _09730_/A0 _09265_/S VDD VSS sg13g2_mux2_1
X_08215_ _08215_/X _08219_/A _14963_/Q _14962_/Q _14961_/Q _13517_/A _08300_/S1 VDD
+ VSS sg13g2_mux4_1
XFILLER_166_548 VDD VSS sg13g2_fill_1
XFILLER_166_559 VDD VSS sg13g2_decap_8
X_09195_ _13811_/D _13811_/Q _09831_/A0 _09200_/S VDD VSS sg13g2_mux2_1
XFILLER_14_1043 VDD VSS sg13g2_decap_8
XFILLER_135_902 VDD VSS sg13g2_fill_2
XFILLER_181_518 VDD VSS sg13g2_decap_8
X_08146_ _08146_/X _08146_/A _08431_/D VDD VSS sg13g2_and2_1
XFILLER_105_1193 VDD VSS sg13g2_decap_8
XFILLER_134_401 VDD VSS sg13g2_decap_8
XFILLER_162_710 VDD VSS sg13g2_decap_8
XFILLER_107_626 VDD VSS sg13g2_decap_8
XFILLER_140_1084 VDD VSS sg13g2_decap_8
XFILLER_134_412 VDD VSS sg13g2_fill_2
XFILLER_101_1057 VDD VSS sg13g2_decap_8
XFILLER_20_35 VDD VSS sg13g2_decap_8
X_08077_ _08078_/C _08588_/B _08076_/Y _08246_/A1 _08058_/X VDD VSS sg13g2_a22oi_1
XFILLER_88_1177 VDD VSS sg13g2_decap_8
XFILLER_105_7 VDD VSS sg13g2_decap_8
XFILLER_134_467 VDD VSS sg13g2_decap_8
XFILLER_121_106 VDD VSS sg13g2_decap_8
XFILLER_66_1442 VDD VSS sg13g2_decap_8
XFILLER_150_949 VDD VSS sg13g2_decap_8
XFILLER_115_681 VDD VSS sg13g2_decap_4
XFILLER_161_286 VDD VSS sg13g2_decap_8
XFILLER_88_521 VDD VSS sg13g2_decap_8
XFILLER_1_959 VDD VSS sg13g2_decap_8
XFILLER_102_342 VDD VSS sg13g2_decap_8
XFILLER_103_865 VDD VSS sg13g2_decap_8
XFILLER_153_1456 VDD VSS sg13g2_decap_8
X_14932__2773 _14932_/RESET_B VDD VSS sg13g2_tiehi
XFILLER_88_565 VDD VSS sg13g2_decap_4
XFILLER_49_919 VDD VSS sg13g2_fill_1
XFILLER_0_469 VDD VSS sg13g2_decap_8
X_08979_ _13757_/D _13757_/Q _10140_/A1 _09127_/S VDD VSS sg13g2_mux2_1
XFILLER_75_215 VDD VSS sg13g2_decap_8
XFILLER_5_1211 VDD VSS sg13g2_decap_8
XFILLER_29_77 VDD VSS sg13g2_fill_2
XFILLER_25_1161 VDD VSS sg13g2_decap_8
X_11990_ _11990_/X _14129_/Q _14161_/Q _14193_/Q _14225_/Q _11997_/S0 _11997_/S1 VDD
+ VSS sg13g2_mux4_1
XFILLER_29_654 VDD VSS sg13g2_fill_2
XFILLER_56_440 VDD VSS sg13g2_decap_8
XFILLER_5_1288 VDD VSS sg13g2_decap_8
XFILLER_28_153 VDD VSS sg13g2_decap_4
XFILLER_112_1175 VDD VSS sg13g2_fill_2
X_10941_ _10941_/X _14938_/Q _11196_/B VDD VSS sg13g2_and2_1
XFILLER_45_21 VDD VSS sg13g2_decap_8
XFILLER_29_687 VDD VSS sg13g2_decap_8
XFILLER_112_1186 VDD VSS sg13g2_fill_1
XFILLER_16_315 VDD VSS sg13g2_decap_8
XFILLER_44_624 VDD VSS sg13g2_decap_8
XFILLER_186_1254 VDD VSS sg13g2_decap_8
XFILLER_186_1265 VDD VSS sg13g2_decap_8
XFILLER_72_955 VDD VSS sg13g2_fill_1
X_13660_ _13660_/Q _14947_/CLK _13660_/D _13660_/RESET_B VDD VSS sg13g2_dfrbpq_1
XFILLER_147_1238 VDD VSS sg13g2_decap_8
X_10872_ _10872_/Y _10871_/Y _07649_/Y _10869_/Y _10867_/Y _13307_/B VDD VSS sg13g2_a221oi_1
XFILLER_72_999 VDD VSS sg13g2_fill_1
X_12611_ _15007_/D _12611_/A _12611_/B VDD VSS sg13g2_nor2_1
XFILLER_25_871 VDD VSS sg13g2_fill_1
X_13591_ _15162_/D _13593_/B _13589_/Y _13590_/Y VDD VSS sg13g2_a21oi_1
X_14257__2015 _14257_/RESET_B VDD VSS sg13g2_tiehi
X_15110__2832 _15110_/RESET_B VDD VSS sg13g2_tiehi
XFILLER_12_532 VDD VSS sg13g2_decap_8
XFILLER_160_1416 VDD VSS sg13g2_decap_8
X_12542_ _12555_/A _12765_/A1 _07737_/B _15003_/Q VDD VSS sg13g2_a21oi_1
XFILLER_185_824 VDD VSS sg13g2_decap_8
XFILLER_131_0 VDD VSS sg13g2_decap_8
XFILLER_8_525 VDD VSS sg13g2_decap_8
XFILLER_61_64 VDD VSS sg13g2_decap_8
XFILLER_32_1110 VDD VSS sg13g2_decap_8
XFILLER_177_42 VDD VSS sg13g2_decap_8
XFILLER_61_75 VDD VSS sg13g2_fill_1
X_12473_ _12473_/X _14116_/Q _14148_/Q _14180_/Q _14212_/Q _12522_/S0 _12522_/S1 VDD
+ VSS sg13g2_mux4_1
XFILLER_184_345 VDD VSS sg13g2_decap_8
XFILLER_184_356 VDD VSS sg13g2_decap_8
XFILLER_172_507 VDD VSS sg13g2_decap_8
X_14212_ _14212_/Q _14503_/CLK _14212_/D _14212_/RESET_B VDD VSS sg13g2_dfrbpq_1
XFILLER_126_913 VDD VSS sg13g2_fill_2
XFILLER_138_773 VDD VSS sg13g2_decap_8
X_11424_ _11425_/A _11423_/Y _11832_/C _11424_/C VDD VSS sg13g2_nand3b_1
X_15192_ _15192_/Q clkload83/A _15192_/D _15192_/RESET_B VDD VSS sg13g2_dfrbpq_1
XFILLER_137_261 VDD VSS sg13g2_decap_8
XANTENNA_8 _13708_/Q VDD VSS sg13g2_antennanp
X_14143_ _14143_/Q clkload21/A _14143_/D _14143_/RESET_B VDD VSS sg13g2_dfrbpq_1
X_11355_ _11355_/Y _11410_/A1 _14654_/Q _12304_/B VDD VSS sg13g2_a21oi_1
XFILLER_4_742 VDD VSS sg13g2_decap_8
XFILLER_10_1463 VDD VSS sg13g2_decap_8
XFILLER_158_1367 VDD VSS sg13g2_decap_8
X_10306_ _14795_/D _10327_/B _10347_/B _10306_/C VDD VSS sg13g2_nor3_1
X_14074_ _14074_/Q clkload53/A _14074_/D _14074_/RESET_B VDD VSS sg13g2_dfrbpq_1
XFILLER_98_318 VDD VSS sg13g2_decap_8
XFILLER_3_252 VDD VSS sg13g2_decap_8
X_11286_ _11287_/B _11378_/S _11276_/Y _11285_/Y VDD VSS sg13g2_o21ai_1
XFILLER_106_681 VDD VSS sg13g2_decap_8
XFILLER_140_426 VDD VSS sg13g2_decap_8
XFILLER_152_286 VDD VSS sg13g2_fill_1
XFILLER_180_595 VDD VSS sg13g2_decap_8
X_13025_ _13042_/B _13026_/A _13026_/C _13057_/A VDD VSS sg13g2_o21ai_1
X_10237_ _10237_/Y _10237_/A _10237_/B _10237_/C _10237_/D VDD VSS sg13g2_nor4_1
XFILLER_67_705 VDD VSS sg13g2_decap_8
XFILLER_117_1053 VDD VSS sg13g2_decap_8
Xfanout1020 _07729_/D _13028_/B VDD VSS sg13g2_buf_1
XFILLER_6_1008 VDD VSS sg13g2_decap_8
Xfanout1031 _12851_/B _07729_/B VDD VSS sg13g2_buf_1
XFILLER_94_502 VDD VSS sg13g2_decap_8
XFILLER_67_716 VDD VSS sg13g2_fill_1
XFILLER_121_673 VDD VSS sg13g2_decap_8
XFILLER_20_7 VDD VSS sg13g2_decap_8
Xfanout1042 _11206_/A1 _11191_/A VDD VSS sg13g2_buf_1
XFILLER_67_727 VDD VSS sg13g2_decap_8
XFILLER_0_981 VDD VSS sg13g2_decap_8
Xfanout1053 _07719_/A _07720_/A VDD VSS sg13g2_buf_1
X_10168_ _14745_/D _14745_/Q _10168_/A1 _10168_/S VDD VSS sg13g2_mux2_1
XFILLER_120_172 VDD VSS sg13g2_decap_8
Xfanout1064 _10137_/A _09938_/C VDD VSS sg13g2_buf_1
Xfanout1075 _09053_/B _09078_/B VDD VSS sg13g2_buf_1
Xfanout1086 _13293_/A _15056_/Q VDD VSS sg13g2_buf_1
Xfanout1097 _08276_/B _14999_/Q VDD VSS sg13g2_buf_1
XFILLER_48_963 VDD VSS sg13g2_decap_4
X_14467__1805 _14467_/RESET_B VDD VSS sg13g2_tiehi
X_14976_ _14976_/Q clkload57/A _14976_/D _14976_/RESET_B VDD VSS sg13g2_dfrbpq_1
X_10099_ _14679_/D _10099_/A0 _14679_/Q _10101_/S VDD VSS sg13g2_mux2_1
XFILLER_130_1253 VDD VSS sg13g2_decap_8
Xclkbuf_leaf_40_clk_i clkload44/A clkbuf_leaf_47_clk_i/A VDD VSS sg13g2_buf_8
XFILLER_75_760 VDD VSS sg13g2_fill_2
XFILLER_169_1430 VDD VSS sg13g2_fill_1
X_13927_ _13927_/Q _14741_/CLK _13927_/D _13927_/RESET_B VDD VSS sg13g2_dfrbpq_1
XFILLER_78_1335 VDD VSS sg13g2_fill_1
XFILLER_19_175 VDD VSS sg13g2_decap_8
XFILLER_75_793 VDD VSS sg13g2_decap_8
XFILLER_169_1474 VDD VSS sg13g2_fill_1
XFILLER_78_1368 VDD VSS sg13g2_fill_2
XFILLER_90_752 VDD VSS sg13g2_decap_8
XFILLER_165_1338 VDD VSS sg13g2_decap_8
X_13858_ _13858_/Q clkload44/A _13858_/D _13858_/RESET_B VDD VSS sg13g2_dfrbpq_1
XFILLER_165_1349 VDD VSS sg13g2_fill_1
X_12809_ _12809_/Y _14767_/Q _13275_/A2 _13140_/B2 VDD VSS sg13g2_o21ai_1
XFILLER_62_498 VDD VSS sg13g2_fill_1
X_13789_ _13789_/Q clkload58/A _13789_/D _13789_/RESET_B VDD VSS sg13g2_dfrbpq_1
Xclkbuf_leaf_55_clk_i _15249_/CLK clkbuf_leaf_81_clk_i/A VDD VSS sg13g2_buf_8
XFILLER_43_690 VDD VSS sg13g2_decap_8
XFILLER_128_1171 VDD VSS sg13g2_decap_8
XFILLER_15_392 VDD VSS sg13g2_decap_8
XFILLER_128_1182 VDD VSS sg13g2_fill_2
XFILLER_124_1024 VDD VSS sg13g2_decap_8
XFILLER_175_301 VDD VSS sg13g2_fill_1
XFILLER_37_1098 VDD VSS sg13g2_decap_8
XFILLER_30_362 VDD VSS sg13g2_decap_4
XFILLER_175_334 VDD VSS sg13g2_decap_8
XFILLER_129_740 VDD VSS sg13g2_decap_4
X_08000_ _08000_/X _08001_/A _08275_/B _08238_/B _08001_/D VDD VSS sg13g2_and4_1
XFILLER_102_1333 VDD VSS sg13g2_fill_1
XFILLER_15_1396 VDD VSS sg13g2_decap_8
XFILLER_117_946 VDD VSS sg13g2_decap_8
XFILLER_50_1287 VDD VSS sg13g2_fill_2
XFILLER_102_1366 VDD VSS sg13g2_fill_1
XFILLER_116_434 VDD VSS sg13g2_decap_8
X_13955__2317 _13955_/RESET_B VDD VSS sg13g2_tiehi
XFILLER_144_754 VDD VSS sg13g2_decap_8
XFILLER_176_1434 VDD VSS sg13g2_decap_4
XFILLER_137_1407 VDD VSS sg13g2_decap_8
XFILLER_143_242 VDD VSS sg13g2_decap_8
XFILLER_176_1478 VDD VSS sg13g2_fill_1
X_09951_ _14535_/D _14535_/Q _09951_/A1 _09965_/S VDD VSS sg13g2_mux2_1
XFILLER_103_106 VDD VSS sg13g2_decap_4
X_08902_ _13708_/D _08938_/S _08900_/Y _08901_/Y VDD VSS sg13g2_a21oi_1
XFILLER_135_1120 VDD VSS sg13g2_decap_4
XFILLER_98_852 VDD VSS sg13g2_decap_4
XFILLER_170_1011 VDD VSS sg13g2_decap_8
X_09882_ _14468_/D _09882_/A0 _14468_/Q _09903_/S VDD VSS sg13g2_mux2_1
XFILLER_48_1183 VDD VSS sg13g2_decap_8
XFILLER_174_1191 VDD VSS sg13g2_decap_8
XFILLER_112_651 VDD VSS sg13g2_decap_4
XFILLER_100_802 VDD VSS sg13g2_fill_1
XFILLER_111_150 VDD VSS sg13g2_decap_8
X_08833_ _08833_/Y _13613_/B _13613_/C _08833_/C VDD VSS sg13g2_nor3_1
XFILLER_100_824 VDD VSS sg13g2_decap_8
XFILLER_58_749 VDD VSS sg13g2_decap_8
XFILLER_131_1039 VDD VSS sg13g2_decap_8
XFILLER_61_1361 VDD VSS sg13g2_decap_4
XFILLER_57_237 VDD VSS sg13g2_decap_8
X_08764_ _08764_/Y _13673_/Q _08781_/B VDD VSS sg13g2_nor2_1
XFILLER_61_1383 VDD VSS sg13g2_decap_8
XFILLER_39_963 VDD VSS sg13g2_decap_4
XFILLER_22_1345 VDD VSS sg13g2_decap_8
XFILLER_66_760 VDD VSS sg13g2_decap_8
XFILLER_39_974 VDD VSS sg13g2_fill_1
X_07715_ _07721_/B _15099_/Q _15098_/Q _15088_/Q _15087_/Q VDD VSS sg13g2_nor4_1
XFILLER_2_1428 VDD VSS sg13g2_decap_8
X_08695_ _08695_/Y _08681_/B _08679_/Y _08673_/X VDD VSS sg13g2_o21ai_1
XFILLER_72_229 VDD VSS sg13g2_fill_2
XFILLER_66_793 VDD VSS sg13g2_decap_8
XFILLER_65_270 VDD VSS sg13g2_decap_8
XFILLER_26_624 VDD VSS sg13g2_decap_8
XFILLER_93_590 VDD VSS sg13g2_fill_1
X_14909__2819 _14909_/RESET_B VDD VSS sg13g2_tiehi
X_07646_ _07646_/Y _14802_/Q VDD VSS sg13g2_inv_1
XFILLER_14_819 VDD VSS sg13g2_decap_8
XFILLER_183_1438 VDD VSS sg13g2_decap_8
XFILLER_26_679 VDD VSS sg13g2_decap_8
XFILLER_0_1163 VDD VSS sg13g2_decap_8
XFILLER_20_1091 VDD VSS sg13g2_decap_8
XFILLER_15_35 VDD VSS sg13g2_decap_8
XFILLER_13_329 VDD VSS sg13g2_decap_8
XFILLER_179_651 VDD VSS sg13g2_decap_4
XFILLER_41_649 VDD VSS sg13g2_decap_8
X_09316_ _13923_/D _09914_/A1 _13923_/Q _09338_/S VDD VSS sg13g2_mux2_1
XFILLER_22_841 VDD VSS sg13g2_decap_8
XFILLER_181_1162 VDD VSS sg13g2_decap_8
XFILLER_90_1045 VDD VSS sg13g2_decap_8
XFILLER_166_301 VDD VSS sg13g2_decap_8
XFILLER_178_161 VDD VSS sg13g2_decap_8
XFILLER_139_526 VDD VSS sg13g2_fill_1
XFILLER_21_340 VDD VSS sg13g2_decap_8
XFILLER_107_1255 VDD VSS sg13g2_decap_8
XFILLER_103_1108 VDD VSS sg13g2_fill_1
X_09247_ _13856_/D _13856_/Q _10143_/A1 _09272_/S VDD VSS sg13g2_mux2_1
XFILLER_167_868 VDD VSS sg13g2_decap_8
XFILLER_33_1441 VDD VSS sg13g2_decap_8
Xclkbuf_4_2_0_clk_i clkbuf_4_2_0_clk_i/X clkbuf_0_clk_i/X VDD VSS sg13g2_buf_8
XFILLER_181_315 VDD VSS sg13g2_decap_8
XFILLER_182_838 VDD VSS sg13g2_decap_8
X_09178_ _13794_/D _13794_/Q _10145_/A1 _09200_/S VDD VSS sg13g2_mux2_1
XFILLER_31_56 VDD VSS sg13g2_decap_8
Xclkbuf_5_9__f_clk_i clkload2/A clkbuf_4_4_0_clk_i/X VDD VSS sg13g2_buf_16
XFILLER_135_721 VDD VSS sg13g2_decap_8
XFILLER_5_539 VDD VSS sg13g2_decap_8
X_08129_ _08129_/X _08304_/A _08879_/A1 _07782_/A _08887_/A1 _07900_/B _08300_/S1
+ VDD VSS sg13g2_mux4_1
XFILLER_179_1080 VDD VSS sg13g2_fill_2
XFILLER_107_456 VDD VSS sg13g2_decap_4
XFILLER_135_765 VDD VSS sg13g2_decap_8
X_14545__1727 _14545_/RESET_B VDD VSS sg13g2_tiehi
XFILLER_162_562 VDD VSS sg13g2_decap_8
X_11140_ _11140_/Y _11139_/Y _11138_/Y _11136_/Y _11140_/B2 _11193_/A2 VDD VSS sg13g2_a221oi_1
XFILLER_135_798 VDD VSS sg13g2_decap_4
XFILLER_150_724 VDD VSS sg13g2_decap_8
Xoutput45 mem_axi_araddr[16] _13707_/Q VDD VSS sg13g2_buf_1
Xoutput56 mem_axi_araddr[27] _16880_/A VDD VSS sg13g2_buf_1
Xoutput67 mem_axi_araddr[8] output67/A VDD VSS sg13g2_buf_1
Xoutput78 mem_axi_awaddr[17] _16870_/X VDD VSS sg13g2_buf_1
X_11071_ _11071_/Y _11082_/A1 _11068_/B _11154_/B1 VDD VSS sg13g2_o21ai_1
XFILLER_27_1223 VDD VSS sg13g2_decap_8
XFILLER_1_756 VDD VSS sg13g2_decap_8
XFILLER_89_863 VDD VSS sg13g2_decap_8
XFILLER_66_1283 VDD VSS sg13g2_decap_8
Xoutput89 mem_axi_awaddr[28] _16881_/X VDD VSS sg13g2_buf_1
XFILLER_131_971 VDD VSS sg13g2_fill_1
Xhold3150 hold3150/X input10/X VDD VSS sg13g2_dlygate4sd3_1
Xhold3161 input28/A mem_axi_rdata[31] VDD VSS sg13g2_dlygate4sd3_1
X_10022_ _14604_/D _10122_/A0 _14604_/Q _10030_/S VDD VSS sg13g2_mux2_1
XFILLER_62_1147 VDD VSS sg13g2_decap_8
XFILLER_49_727 VDD VSS sg13g2_decap_8
XFILLER_0_266 VDD VSS sg13g2_decap_8
Xhold3172 input22/A mem_axi_rdata[26] VDD VSS sg13g2_dlygate4sd3_1
XFILLER_102_161 VDD VSS sg13g2_decap_8
Xhold3183 hold3183/X mem_axi_rdata[8] VDD VSS sg13g2_dlygate4sd3_1
XFILLER_88_384 VDD VSS sg13g2_decap_4
XFILLER_76_524 VDD VSS sg13g2_decap_8
XFILLER_103_695 VDD VSS sg13g2_decap_8
XFILLER_153_1286 VDD VSS sg13g2_decap_4
Xhold3194 _13626_/A _13734_/Q VDD VSS sg13g2_dlygate4sd3_1
XFILLER_76_535 VDD VSS sg13g2_decap_8
XFILLER_40_1412 VDD VSS sg13g2_fill_2
X_14830_ _14830_/Q clkload63/A _14830_/D _14830_/RESET_B VDD VSS sg13g2_dfrbpq_1
XFILLER_56_42 VDD VSS sg13g2_decap_8
XFILLER_56_53 VDD VSS sg13g2_fill_2
XFILLER_17_602 VDD VSS sg13g2_decap_8
XFILLER_179_0 VDD VSS sg13g2_decap_8
X_14761_ _14761_/Q _15200_/CLK _14761_/D _14761_/RESET_B VDD VSS sg13g2_dfrbpq_1
X_11973_ _11973_/Y _11973_/A _12029_/B VDD VSS sg13g2_nand2_1
XFILLER_63_229 VDD VSS sg13g2_decap_8
XFILLER_5_1085 VDD VSS sg13g2_decap_8
XFILLER_16_112 VDD VSS sg13g2_decap_8
XFILLER_72_741 VDD VSS sg13g2_decap_8
X_13712_ _13712_/Q clkload56/A _13712_/D _13712_/RESET_B VDD VSS sg13g2_dfrbpq_1
X_10924_ _10924_/Y _10954_/D _10954_/A _10924_/B1 VDD VSS sg13g2_a21oi_1
XFILLER_147_1013 VDD VSS sg13g2_decap_8
X_14692_ _14692_/Q clkload33/A _14692_/D _14692_/RESET_B VDD VSS sg13g2_dfrbpq_1
XFILLER_45_999 VDD VSS sg13g2_decap_8
XFILLER_72_785 VDD VSS sg13g2_fill_1
XFILLER_44_476 VDD VSS sg13g2_fill_1
XFILLER_32_616 VDD VSS sg13g2_decap_8
XFILLER_16_189 VDD VSS sg13g2_decap_8
X_13643_ _13751_/D _13643_/A VDD VSS sg13g2_buf_1
X_10855_ _10890_/A _14752_/Q _10870_/A VDD VSS sg13g2_nor2_1
XFILLER_108_1019 VDD VSS sg13g2_decap_8
XFILLER_60_958 VDD VSS sg13g2_decap_8
XFILLER_125_1300 VDD VSS sg13g2_fill_2
XFILLER_38_1352 VDD VSS sg13g2_decap_8
XFILLER_73_1243 VDD VSS sg13g2_decap_8
XFILLER_125_1333 VDD VSS sg13g2_fill_1
X_13574_ _13574_/Y _14998_/Q _13555_/B _13569_/S _15014_/Q _13521_/X VDD VSS sg13g2_a221oi_1
X_10786_ _10787_/A _14923_/Q _11156_/B _11154_/B1 _11181_/A VDD VSS sg13g2_a22oi_1
XFILLER_9_812 VDD VSS sg13g2_decap_8
XFILLER_34_1227 VDD VSS sg13g2_decap_4
XFILLER_158_846 VDD VSS sg13g2_decap_8
XFILLER_34_1238 VDD VSS sg13g2_decap_8
XFILLER_13_896 VDD VSS sg13g2_decap_8
X_12525_ _12525_/X _12524_/X _12523_/X _12762_/S VDD VSS sg13g2_mux2_1
XFILLER_8_322 VDD VSS sg13g2_decap_8
XFILLER_185_665 VDD VSS sg13g2_decap_8
XFILLER_9_889 VDD VSS sg13g2_decap_8
X_15244_ _15244_/Q clkload71/A _15244_/D _15244_/RESET_B VDD VSS sg13g2_dfrbpq_1
X_12456_ _12457_/B _13686_/Q _12693_/A2 _12455_/X _12415_/A _12749_/C1 VDD VSS sg13g2_a221oi_1
XFILLER_184_175 VDD VSS sg13g2_decap_8
XFILLER_184_186 VDD VSS sg13g2_fill_1
XFILLER_138_592 VDD VSS sg13g2_decap_8
XFILLER_8_399 VDD VSS sg13g2_decap_8
X_11407_ _11407_/Y _11410_/A1 _14367_/Q VDD VSS sg13g2_nand2b_1
XFILLER_125_220 VDD VSS sg13g2_decap_8
XFILLER_172_359 VDD VSS sg13g2_decap_8
X_15175_ _15175_/Q clkload85/A _15175_/D _15175_/RESET_B VDD VSS sg13g2_dfrbpq_1
X_12387_ _12387_/Y _15121_/Q _12348_/A _12442_/A2 _13691_/Q _13282_/A1 VDD VSS sg13g2_a221oi_1
XFILLER_67_1025 VDD VSS sg13g2_decap_8
XFILLER_141_702 VDD VSS sg13g2_decap_8
XFILLER_67_1036 VDD VSS sg13g2_fill_2
XFILLER_10_1260 VDD VSS sg13g2_decap_8
X_14126_ _14126_/Q _14222_/CLK _14126_/D _14126_/RESET_B VDD VSS sg13g2_dfrbpq_1
X_11338_ _11339_/B _11338_/A _11338_/B VDD VSS sg13g2_nor2_1
XFILLER_119_1126 VDD VSS sg13g2_decap_8
XFILLER_181_893 VDD VSS sg13g2_decap_8
XFILLER_119_1137 VDD VSS sg13g2_fill_1
XFILLER_180_392 VDD VSS sg13g2_decap_8
XFILLER_45_1312 VDD VSS sg13g2_decap_4
X_14057_ _14057_/Q clkload34/A _14057_/D _14057_/RESET_B VDD VSS sg13g2_dfrbpq_1
XFILLER_98_148 VDD VSS sg13g2_fill_2
X_11269_ _11287_/A _11224_/A _11258_/Y _11268_/Y VDD VSS sg13g2_o21ai_1
XFILLER_97_82 VDD VSS sg13g2_decap_8
XFILLER_80_1214 VDD VSS sg13g2_decap_8
XFILLER_45_1334 VDD VSS sg13g2_decap_8
X_13008_ _13010_/B _13058_/A _13058_/C VDD VSS sg13g2_nand2_1
XFILLER_121_470 VDD VSS sg13g2_decap_8
XFILLER_45_1378 VDD VSS sg13g2_decap_8
XFILLER_171_1386 VDD VSS sg13g2_fill_2
XFILLER_79_395 VDD VSS sg13g2_decap_8
XFILLER_95_866 VDD VSS sg13g2_decap_8
XFILLER_95_877 VDD VSS sg13g2_decap_8
XFILLER_94_365 VDD VSS sg13g2_decap_8
X_15053__2612 _15053_/RESET_B VDD VSS sg13g2_tiehi
X_14959_ _14959_/Q clkload79/A _14959_/D _14959_/RESET_B VDD VSS sg13g2_dfrbpq_1
XFILLER_47_270 VDD VSS sg13g2_decap_8
XFILLER_36_955 VDD VSS sg13g2_decap_8
XFILLER_35_432 VDD VSS sg13g2_fill_2
XFILLER_39_1105 VDD VSS sg13g2_decap_4
X_08480_ _08481_/B _08478_/Y _08479_/Y _08477_/Y VDD VSS sg13g2_a21oi_1
XFILLER_39_1127 VDD VSS sg13g2_decap_8
XFILLER_63_785 VDD VSS sg13g2_fill_1
XFILLER_62_262 VDD VSS sg13g2_decap_8
XFILLER_51_925 VDD VSS sg13g2_decap_8
XFILLER_126_1119 VDD VSS sg13g2_decap_8
X_14623__1649 _14623_/RESET_B VDD VSS sg13g2_tiehi
XFILLER_22_126 VDD VSS sg13g2_decap_8
XFILLER_149_802 VDD VSS sg13g2_decap_8
XFILLER_149_813 VDD VSS sg13g2_fill_2
XFILLER_94_0 VDD VSS sg13g2_decap_8
XFILLER_17_1425 VDD VSS sg13g2_decap_8
XFILLER_91_1354 VDD VSS sg13g2_decap_8
X_09101_ _10752_/B _09134_/S _15043_/Q _09100_/Y VDD VSS sg13g2_o21ai_1
XFILLER_91_1387 VDD VSS sg13g2_decap_8
XFILLER_52_1338 VDD VSS sg13g2_decap_8
XFILLER_104_1428 VDD VSS sg13g2_decap_8
XFILLER_164_827 VDD VSS sg13g2_decap_8
X_09032_ _09032_/X _09057_/A _09027_/X _09031_/Y VDD VSS sg13g2_a21o_1
XFILLER_175_175 VDD VSS sg13g2_decap_8
XFILLER_15_1193 VDD VSS sg13g2_decap_8
XFILLER_7_91 VDD VSS sg13g2_decap_8
XFILLER_11_1057 VDD VSS sg13g2_decap_8
XFILLER_85_1125 VDD VSS sg13g2_decap_8
XFILLER_105_927 VDD VSS sg13g2_decap_8
XFILLER_172_882 VDD VSS sg13g2_decap_8
XFILLER_176_1264 VDD VSS sg13g2_fill_1
XFILLER_104_426 VDD VSS sg13g2_decap_8
XFILLER_137_1226 VDD VSS sg13g2_decap_8
XFILLER_144_595 VDD VSS sg13g2_decap_8
XFILLER_89_137 VDD VSS sg13g2_fill_1
Xfanout802 _08511_/S _08301_/S VDD VSS sg13g2_buf_1
XFILLER_63_1412 VDD VSS sg13g2_fill_2
XFILLER_120_908 VDD VSS sg13g2_fill_2
X_09934_ _14519_/D _14519_/Q _09934_/A1 _09935_/S VDD VSS sg13g2_mux2_1
Xfanout813 _08426_/A _07629_/Y VDD VSS sg13g2_buf_1
Xfanout824 _08649_/S _08422_/S VDD VSS sg13g2_buf_1
XFILLER_98_660 VDD VSS sg13g2_fill_1
XFILLER_86_800 VDD VSS sg13g2_decap_8
Xfanout835 _12678_/S _12789_/S1 VDD VSS sg13g2_buf_1
Xfanout846 _12776_/S _12761_/S1 VDD VSS sg13g2_buf_1
XFILLER_24_1407 VDD VSS sg13g2_decap_8
XFILLER_131_289 VDD VSS sg13g2_decap_4
Xfanout857 _12622_/S0 _12789_/S0 VDD VSS sg13g2_buf_1
X_09865_ _14452_/D _14452_/Q _09997_/A0 _09865_/S VDD VSS sg13g2_mux2_1
XFILLER_133_14 VDD VSS sg13g2_decap_8
XFILLER_140_790 VDD VSS sg13g2_fill_1
Xfanout868 _12661_/S1 _12604_/S1 VDD VSS sg13g2_buf_1
X_15081__2924 _15081_/RESET_B VDD VSS sg13g2_tiehi
Xfanout879 _12754_/S1 fanout880/X VDD VSS sg13g2_buf_1
X_08816_ _08816_/Y _13499_/C _13481_/A _15179_/Q VDD VSS sg13g2_o21ai_1
XFILLER_86_877 VDD VSS sg13g2_fill_2
X_09796_ _14385_/D _09928_/A1 _14385_/Q _09797_/S VDD VSS sg13g2_mux2_1
XFILLER_6_1372 VDD VSS sg13g2_decap_8
XFILLER_22_1142 VDD VSS sg13g2_decap_8
X_08747_ _13667_/D _08753_/A1 _08745_/Y _08746_/Y VDD VSS sg13g2_a21oi_1
XFILLER_85_387 VDD VSS sg13g2_decap_8
XFILLER_2_1225 VDD VSS sg13g2_decap_8
XFILLER_172_7 VDD VSS sg13g2_decap_8
XFILLER_54_741 VDD VSS sg13g2_decap_8
XFILLER_96_1254 VDD VSS sg13g2_decap_8
X_08678_ _08678_/Y _08678_/A _08678_/B _08678_/C VDD VSS sg13g2_nand3_1
XFILLER_26_56 VDD VSS sg13g2_decap_8
XFILLER_57_1227 VDD VSS sg13g2_fill_1
XFILLER_14_616 VDD VSS sg13g2_decap_8
XFILLER_92_1118 VDD VSS sg13g2_decap_8
XFILLER_26_476 VDD VSS sg13g2_decap_8
XFILLER_109_1317 VDD VSS sg13g2_decap_4
X_07629_ _07629_/Y _08154_/A VDD VSS sg13g2_inv_1
XFILLER_81_582 VDD VSS sg13g2_decap_4
XFILLER_144_1208 VDD VSS sg13g2_fill_1
XFILLER_53_284 VDD VSS sg13g2_fill_2
XFILLER_13_126 VDD VSS sg13g2_decap_8
XFILLER_186_407 VDD VSS sg13g2_decap_8
XFILLER_41_446 VDD VSS sg13g2_decap_8
X_10640_ _14887_/D _10640_/A _10639_/Y VDD VSS sg13g2_nor2b_1
XFILLER_139_301 VDD VSS sg13g2_decap_4
XFILLER_167_621 VDD VSS sg13g2_decap_8
XFILLER_9_119 VDD VSS sg13g2_decap_8
XFILLER_22_682 VDD VSS sg13g2_decap_4
XFILLER_10_833 VDD VSS sg13g2_decap_8
X_10571_ _10572_/A _10647_/C _10579_/B _10579_/C VDD VSS sg13g2_and3_1
XFILLER_42_77 VDD VSS sg13g2_decap_8
XFILLER_182_602 VDD VSS sg13g2_decap_8
X_12310_ _12310_/Y _12310_/A _12317_/B VDD VSS sg13g2_nand2_1
XFILLER_108_710 VDD VSS sg13g2_fill_2
XFILLER_155_838 VDD VSS sg13g2_decap_8
XFILLER_166_175 VDD VSS sg13g2_decap_8
X_13290_ _13291_/C _13290_/A _13290_/B _13294_/B _13290_/D VDD VSS sg13g2_nand4_1
XFILLER_6_826 VDD VSS sg13g2_decap_8
XFILLER_181_112 VDD VSS sg13g2_decap_8
X_12241_ _12241_/Y _12243_/A1 _14616_/Q _12169_/C VDD VSS sg13g2_a21oi_1
XFILLER_68_1312 VDD VSS sg13g2_decap_8
XFILLER_5_336 VDD VSS sg13g2_decap_8
XFILLER_182_679 VDD VSS sg13g2_decap_8
XFILLER_108_776 VDD VSS sg13g2_decap_8
XFILLER_123_702 VDD VSS sg13g2_decap_4
XFILLER_174_21 VDD VSS sg13g2_decap_8
XFILLER_163_882 VDD VSS sg13g2_decap_8
XFILLER_68_1356 VDD VSS sg13g2_decap_8
XFILLER_181_189 VDD VSS sg13g2_decap_8
X_12172_ _12172_/Y _12172_/A _12246_/B VDD VSS sg13g2_nand2_1
XFILLER_29_1318 VDD VSS sg13g2_decap_8
XFILLER_122_223 VDD VSS sg13g2_fill_2
XFILLER_150_532 VDD VSS sg13g2_decap_4
X_11123_ _11127_/B _11123_/A _11123_/B VDD VSS sg13g2_nor2_1
XFILLER_104_960 VDD VSS sg13g2_decap_8
XFILLER_174_98 VDD VSS sg13g2_decap_8
XFILLER_1_553 VDD VSS sg13g2_decap_8
XFILLER_27_1031 VDD VSS sg13g2_fill_2
XFILLER_95_118 VDD VSS sg13g2_decap_8
XFILLER_77_811 VDD VSS sg13g2_fill_2
XFILLER_3_49 VDD VSS sg13g2_decap_8
XFILLER_122_289 VDD VSS sg13g2_decap_8
X_11054_ _11054_/Y _11069_/B _11053_/Y _11044_/C VDD VSS sg13g2_o21ai_1
XFILLER_118_1181 VDD VSS sg13g2_decap_8
XFILLER_76_310 VDD VSS sg13g2_decap_8
XFILLER_67_41 VDD VSS sg13g2_decap_8
XFILLER_114_1023 VDD VSS sg13g2_decap_8
XFILLER_77_855 VDD VSS sg13g2_decap_8
X_10005_ _14587_/D _10071_/A0 _14587_/Q _10030_/S VDD VSS sg13g2_mux2_1
XFILLER_114_1045 VDD VSS sg13g2_decap_4
XFILLER_7_1169 VDD VSS sg13g2_decap_8
XFILLER_27_1097 VDD VSS sg13g2_decap_8
XFILLER_67_85 VDD VSS sg13g2_decap_8
XFILLER_49_568 VDD VSS sg13g2_fill_2
XFILLER_92_825 VDD VSS sg13g2_decap_8
X_14813_ _14813_/Q clkload61/A _14813_/D _14813_/RESET_B VDD VSS sg13g2_dfrbpq_1
XFILLER_40_1253 VDD VSS sg13g2_decap_8
XFILLER_131_1381 VDD VSS sg13g2_fill_1
XFILLER_149_1119 VDD VSS sg13g2_decap_8
XFILLER_92_869 VDD VSS sg13g2_decap_4
XFILLER_166_1411 VDD VSS sg13g2_decap_4
XFILLER_166_1422 VDD VSS sg13g2_decap_8
X_14744_ _14744_/Q _14744_/CLK _14744_/D _14744_/RESET_B VDD VSS sg13g2_dfrbpq_1
XFILLER_83_51 VDD VSS sg13g2_decap_8
XFILLER_79_1474 VDD VSS sg13g2_decap_4
XFILLER_18_988 VDD VSS sg13g2_decap_8
X_11956_ _11957_/B _11953_/Y _11955_/Y _11999_/S1 VDD VSS sg13g2_a21oi_1
XFILLER_17_476 VDD VSS sg13g2_decap_8
XFILLER_127_1417 VDD VSS sg13g2_decap_8
X_10907_ _10907_/Y _10907_/A _10948_/B VDD VSS sg13g2_xnor2_1
XFILLER_75_1349 VDD VSS sg13g2_decap_8
XFILLER_32_424 VDD VSS sg13g2_decap_8
X_14675_ _14675_/Q clkload31/A _14675_/D _14675_/RESET_B VDD VSS sg13g2_dfrbpq_1
X_11887_ _11887_/Y _11365_/A _14478_/Q VDD VSS sg13g2_nand2b_1
XFILLER_72_593 VDD VSS sg13g2_decap_8
X_13626_ _13734_/D _13626_/A VDD VSS sg13g2_buf_1
X_10838_ _10865_/A _10851_/C _14751_/Q VDD VSS sg13g2_nand2_1
XFILLER_20_619 VDD VSS sg13g2_decap_8
XFILLER_186_930 VDD VSS sg13g2_decap_8
XFILLER_38_1182 VDD VSS sg13g2_fill_1
XFILLER_125_1141 VDD VSS sg13g2_decap_8
XFILLER_160_1021 VDD VSS sg13g2_decap_4
XFILLER_186_941 VDD VSS sg13g2_decap_8
XFILLER_60_799 VDD VSS sg13g2_decap_8
XFILLER_158_654 VDD VSS sg13g2_decap_8
XFILLER_13_693 VDD VSS sg13g2_decap_8
XFILLER_146_805 VDD VSS sg13g2_fill_2
X_13557_ _15150_/D _15150_/Q _13556_/Y _13562_/S VDD VSS sg13g2_mux2_1
X_10769_ _10769_/X _14950_/Q _10767_/A _10767_/Y VDD VSS sg13g2_a21o_1
XFILLER_160_1054 VDD VSS sg13g2_decap_8
XFILLER_121_1016 VDD VSS sg13g2_fill_2
XFILLER_185_462 VDD VSS sg13g2_decap_8
XFILLER_118_529 VDD VSS sg13g2_fill_2
X_12508_ _12508_/X _13958_/Q _13990_/Q _14022_/Q _14054_/Q _12564_/S0 _12564_/S1 VDD
+ VSS sg13g2_mux4_1
XFILLER_146_849 VDD VSS sg13g2_decap_8
XFILLER_157_175 VDD VSS sg13g2_decap_8
XFILLER_160_1098 VDD VSS sg13g2_decap_4
X_13488_ _13488_/Y _15174_/D _13487_/Y VDD VSS sg13g2_nor2b_1
XFILLER_9_686 VDD VSS sg13g2_decap_8
XFILLER_157_186 VDD VSS sg13g2_fill_2
XFILLER_172_112 VDD VSS sg13g2_decap_8
XFILLER_173_635 VDD VSS sg13g2_decap_8
XFILLER_51_1382 VDD VSS sg13g2_decap_8
XFILLER_12_1344 VDD VSS sg13g2_decap_8
XFILLER_145_348 VDD VSS sg13g2_decap_8
XFILLER_51_1393 VDD VSS sg13g2_decap_8
XFILLER_103_1472 VDD VSS sg13g2_decap_8
X_15227_ _15227_/Q clkload76/A _15227_/D _15227_/RESET_B VDD VSS sg13g2_dfrbpq_1
X_12439_ _12439_/X _12432_/X _12436_/X _12431_/X _12435_/X _12553_/S _12775_/S1 VDD
+ VSS sg13g2_mux4_1
XFILLER_8_196 VDD VSS sg13g2_decap_8
XFILLER_86_1423 VDD VSS sg13g2_decap_8
XFILLER_126_562 VDD VSS sg13g2_decap_8
XFILLER_154_882 VDD VSS sg13g2_fill_2
XFILLER_172_189 VDD VSS sg13g2_decap_8
X_14037__2235 _14037_/RESET_B VDD VSS sg13g2_tiehi
X_15158_ _15158_/Q _15216_/CLK _15158_/D _15158_/RESET_B VDD VSS sg13g2_dfrbpq_1
X_13872__2400 _13872_/RESET_B VDD VSS sg13g2_tiehi
XFILLER_99_435 VDD VSS sg13g2_decap_8
X_14109_ _14109_/Q _14222_/CLK _14109_/D _14109_/RESET_B VDD VSS sg13g2_dfrbpq_1
X_15089_ _15089_/Q clkload87/A _15089_/D _15089_/RESET_B VDD VSS sg13g2_dfrbpq_1
X_07980_ _07980_/Y _08577_/B _07866_/Y _07979_/Y VDD VSS sg13g2_a21oi_1
XFILLER_113_267 VDD VSS sg13g2_fill_1
XFILLER_122_790 VDD VSS sg13g2_decap_8
XFILLER_136_1292 VDD VSS sg13g2_fill_1
XFILLER_132_1134 VDD VSS sg13g2_decap_8
X_09650_ _14243_/D _09881_/A0 _14243_/Q _09672_/S VDD VSS sg13g2_mux2_1
XFILLER_67_343 VDD VSS sg13g2_decap_8
XFILLER_41_1028 VDD VSS sg13g2_decap_8
XFILLER_95_663 VDD VSS sg13g2_decap_8
X_14252__2020 _14252_/RESET_B VDD VSS sg13g2_tiehi
XFILLER_94_151 VDD VSS sg13g2_decap_4
X_08601_ _08605_/A _08617_/A _08458_/X _08600_/Y VDD VSS sg13g2_o21ai_1
XFILLER_83_825 VDD VSS sg13g2_decap_8
XFILLER_82_313 VDD VSS sg13g2_decap_8
X_09581_ _14178_/D _14178_/Q _10078_/A0 _09601_/S VDD VSS sg13g2_mux2_1
XFILLER_94_173 VDD VSS sg13g2_fill_1
XFILLER_110_1432 VDD VSS sg13g2_decap_8
XFILLER_110_1443 VDD VSS sg13g2_fill_1
X_08532_ _08532_/Y _08577_/A _08529_/Y _08531_/Y VDD VSS sg13g2_a21oi_1
X_08463_ _08463_/Y _13533_/A _08463_/B VDD VSS sg13g2_nor2_1
XFILLER_24_958 VDD VSS sg13g2_decap_8
XFILLER_51_744 VDD VSS sg13g2_fill_2
XFILLER_168_407 VDD VSS sg13g2_decap_8
XFILLER_50_232 VDD VSS sg13g2_fill_2
XFILLER_17_1222 VDD VSS sg13g2_decap_8
X_08394_ _08395_/B _08414_/C _08394_/B _08394_/C VDD VSS sg13g2_nor3_1
XFILLER_51_777 VDD VSS sg13g2_fill_1
XFILLER_50_254 VDD VSS sg13g2_decap_8
XFILLER_51_799 VDD VSS sg13g2_decap_8
XFILLER_104_1203 VDD VSS sg13g2_decap_8
XFILLER_108_1372 VDD VSS sg13g2_decap_4
XFILLER_148_142 VDD VSS sg13g2_decap_8
XFILLER_31_490 VDD VSS sg13g2_decap_8
XFILLER_12_14 VDD VSS sg13g2_decap_8
XFILLER_176_462 VDD VSS sg13g2_decap_8
XFILLER_52_1168 VDD VSS sg13g2_decap_8
XFILLER_164_613 VDD VSS sg13g2_decap_4
XFILLER_17_1299 VDD VSS sg13g2_decap_8
Xclkbuf_5_27__f_clk_i clkbuf_leaf_78_clk_i/A clkbuf_4_13_0_clk_i/X VDD VSS sg13g2_buf_16
XFILLER_128_14 VDD VSS sg13g2_decap_4
XFILLER_137_849 VDD VSS sg13g2_decap_8
XFILLER_178_1337 VDD VSS sg13g2_decap_8
X_09015_ _09016_/B _15030_/Q _15227_/Q _09053_/B VDD VSS sg13g2_mux2_1
XFILLER_128_36 VDD VSS sg13g2_decap_8
XFILLER_178_1348 VDD VSS sg13g2_fill_1
XFILLER_30_1444 VDD VSS sg13g2_decap_8
XFILLER_176_1072 VDD VSS sg13g2_decap_8
X_14462__1810 _14462_/RESET_B VDD VSS sg13g2_tiehi
XFILLER_104_245 VDD VSS sg13g2_decap_8
XFILLER_105_768 VDD VSS sg13g2_decap_4
XFILLER_137_1056 VDD VSS sg13g2_decap_4
XFILLER_78_619 VDD VSS sg13g2_decap_8
Xfanout610 _08688_/C _08398_/Y VDD VSS sg13g2_buf_1
Xfanout621 _13236_/B1 _13297_/A0 VDD VSS sg13g2_buf_1
XFILLER_77_107 VDD VSS sg13g2_decap_8
XFILLER_132_587 VDD VSS sg13g2_decap_8
XFILLER_120_738 VDD VSS sg13g2_fill_2
Xfanout632 _13561_/S _12793_/Y VDD VSS sg13g2_buf_1
X_09917_ _14502_/D _14502_/Q _09917_/A1 _09929_/S VDD VSS sg13g2_mux2_1
XFILLER_28_1362 VDD VSS sg13g2_decap_8
XFILLER_144_68 VDD VSS sg13g2_decap_8
Xfanout643 _11021_/B _10670_/Y VDD VSS sg13g2_buf_1
XFILLER_28_1373 VDD VSS sg13g2_fill_1
XFILLER_24_1204 VDD VSS sg13g2_decap_8
Xfanout654 _10747_/A _10740_/A1 VDD VSS sg13g2_buf_1
XFILLER_8_1456 VDD VSS sg13g2_decap_8
XFILLER_115_1343 VDD VSS sg13g2_fill_2
Xfanout665 _10691_/S _10694_/S VDD VSS sg13g2_buf_1
XFILLER_101_952 VDD VSS sg13g2_decap_8
XFILLER_115_1354 VDD VSS sg13g2_fill_1
Xfanout676 _13490_/B _08825_/C1 VDD VSS sg13g2_buf_1
XFILLER_4_1309 VDD VSS sg13g2_decap_8
Xfanout687 _08653_/A _08692_/A VDD VSS sg13g2_buf_1
X_09848_ _14435_/D _14435_/Q _10079_/A0 _09870_/S VDD VSS sg13g2_mux2_1
Xfanout698 _12791_/C1 _12749_/C1 VDD VSS sg13g2_buf_1
XFILLER_46_516 VDD VSS sg13g2_decap_8
XFILLER_101_996 VDD VSS sg13g2_decap_4
XFILLER_74_836 VDD VSS sg13g2_fill_1
X_13735__2537 _13735_/RESET_B VDD VSS sg13g2_tiehi
XFILLER_85_173 VDD VSS sg13g2_decap_8
X_14495__1777 _14495_/RESET_B VDD VSS sg13g2_tiehi
XFILLER_58_398 VDD VSS sg13g2_fill_2
X_09779_ _14368_/D _09911_/A1 _14368_/Q _09804_/S VDD VSS sg13g2_mux2_1
XFILLER_73_335 VDD VSS sg13g2_decap_4
XFILLER_2_1022 VDD VSS sg13g2_decap_8
XFILLER_37_77 VDD VSS sg13g2_decap_8
XFILLER_160_56 VDD VSS sg13g2_decap_8
X_11810_ _11810_/Y _12103_/A1 _14604_/Q _12307_/C VDD VSS sg13g2_a21oi_1
X_12790_ _12790_/X _12789_/X _12788_/X _12790_/S VDD VSS sg13g2_mux2_1
XFILLER_27_763 VDD VSS sg13g2_fill_2
XFILLER_82_880 VDD VSS sg13g2_decap_4
XFILLER_14_413 VDD VSS sg13g2_decap_8
X_11741_ _11742_/B _11741_/A _14666_/Q VDD VSS sg13g2_nand2_1
XFILLER_2_1099 VDD VSS sg13g2_decap_8
XFILLER_53_21 VDD VSS sg13g2_decap_8
XFILLER_109_1114 VDD VSS sg13g2_decap_4
XFILLER_144_1005 VDD VSS sg13g2_fill_1
XFILLER_148_1174 VDD VSS sg13g2_decap_8
XFILLER_15_969 VDD VSS sg13g2_decap_8
XFILLER_42_755 VDD VSS sg13g2_decap_8
XFILLER_169_21 VDD VSS sg13g2_decap_8
XFILLER_183_1076 VDD VSS sg13g2_decap_4
X_14115__2157 _14115_/RESET_B VDD VSS sg13g2_tiehi
X_14460_ _14460_/Q clkload64/A _14460_/D _14460_/RESET_B VDD VSS sg13g2_dfrbpq_1
X_11672_ _11672_/Y _11669_/Y _11671_/X _11957_/A VDD VSS sg13g2_o21ai_1
XFILLER_41_254 VDD VSS sg13g2_decap_8
XFILLER_168_930 VDD VSS sg13g2_decap_8
X_13950__2322 _13950_/RESET_B VDD VSS sg13g2_tiehi
X_13411_ _13490_/C _13448_/B _13421_/B VDD VSS sg13g2_nand2b_1
X_10623_ _14882_/D _10633_/A _10623_/B _10632_/D VDD VSS sg13g2_nor3_1
X_14391_ _14391_/Q clkload42/A _14391_/D _14391_/RESET_B VDD VSS sg13g2_dfrbpq_1
XFILLER_70_1235 VDD VSS sg13g2_decap_8
XFILLER_10_630 VDD VSS sg13g2_decap_8
XFILLER_169_98 VDD VSS sg13g2_decap_8
XFILLER_139_164 VDD VSS sg13g2_decap_8
XFILLER_167_473 VDD VSS sg13g2_decap_8
X_13342_ _15068_/D _15068_/Q _13480_/S _13341_/Y VDD VSS sg13g2_a21o_1
X_10554_ _14866_/D _10554_/A _10555_/B _13499_/B VDD VSS sg13g2_and3_1
XFILLER_35_1399 VDD VSS sg13g2_decap_8
XFILLER_122_1369 VDD VSS sg13g2_decap_8
XFILLER_6_623 VDD VSS sg13g2_decap_8
XFILLER_154_123 VDD VSS sg13g2_decap_8
XFILLER_185_42 VDD VSS sg13g2_decap_8
X_13273_ _13273_/Y _14862_/Q _13273_/B VDD VSS sg13g2_nand2_1
X_10485_ _10508_/C _14849_/Q _10489_/C _14847_/Q _10486_/D VDD VSS sg13g2_and4_1
XFILLER_5_133 VDD VSS sg13g2_decap_8
XFILLER_108_551 VDD VSS sg13g2_fill_2
XFILLER_182_476 VDD VSS sg13g2_decap_8
XFILLER_120_1082 VDD VSS sg13g2_fill_1
X_13983__2289 _13983_/RESET_B VDD VSS sg13g2_tiehi
X_15012_ _15012_/Q clkload43/A _15012_/D _15012_/RESET_B VDD VSS sg13g2_dfrbpq_1
X_12224_ _12224_/Y _13245_/A _12294_/A2 _12225_/B2 VDD VSS sg13g2_a21oi_1
XFILLER_108_595 VDD VSS sg13g2_decap_4
XFILLER_123_532 VDD VSS sg13g2_decap_8
X_12155_ _12156_/C _12155_/A _12155_/B _12198_/D VDD VSS sg13g2_nand3_1
XFILLER_2_840 VDD VSS sg13g2_decap_8
XFILLER_64_1039 VDD VSS sg13g2_decap_8
XFILLER_150_362 VDD VSS sg13g2_decap_8
XFILLER_1_350 VDD VSS sg13g2_decap_8
X_11106_ _11106_/Y _11093_/Y _11105_/Y _11151_/A VDD VSS sg13g2_a21oi_1
XFILLER_68_118 VDD VSS sg13g2_decap_8
XFILLER_155_1189 VDD VSS sg13g2_decap_4
X_12086_ _12086_/X _12197_/B _12086_/B VDD VSS sg13g2_xor2_1
XFILLER_81_1353 VDD VSS sg13g2_decap_8
XFILLER_78_95 VDD VSS sg13g2_fill_2
XFILLER_133_1421 VDD VSS sg13g2_decap_8
XFILLER_110_237 VDD VSS sg13g2_decap_8
XFILLER_133_1432 VDD VSS sg13g2_fill_1
X_11037_ _11037_/Y _11036_/Y _11064_/C _11043_/A VDD VSS sg13g2_a21oi_1
XFILLER_81_1397 VDD VSS sg13g2_decap_4
XFILLER_37_527 VDD VSS sg13g2_decap_8
X_14325__1947 _14325_/RESET_B VDD VSS sg13g2_tiehi
XFILLER_40_1061 VDD VSS sg13g2_decap_8
XFILLER_64_357 VDD VSS sg13g2_decap_8
XFILLER_40_1072 VDD VSS sg13g2_fill_1
X_12988_ _12989_/C _12988_/A _12988_/B _12988_/C _12988_/D VDD VSS sg13g2_nor4_1
XFILLER_80_839 VDD VSS sg13g2_fill_1
XFILLER_17_273 VDD VSS sg13g2_decap_8
XFILLER_45_582 VDD VSS sg13g2_fill_2
X_14727_ _14727_/Q _14727_/CLK _14727_/D _14727_/RESET_B VDD VSS sg13g2_dfrbpq_1
XFILLER_33_733 VDD VSS sg13g2_fill_1
X_11939_ _11939_/Y _12055_/B _11937_/Y _11938_/Y VDD VSS sg13g2_o21ai_1
XFILLER_32_221 VDD VSS sg13g2_fill_1
XFILLER_127_1225 VDD VSS sg13g2_decap_4
XFILLER_178_738 VDD VSS sg13g2_decap_8
X_14658_ _14658_/Q clkload45/A _14658_/D _14658_/RESET_B VDD VSS sg13g2_dfrbpq_1
XFILLER_127_1269 VDD VSS sg13g2_decap_8
XFILLER_159_930 VDD VSS sg13g2_decap_8
XFILLER_21_939 VDD VSS sg13g2_decap_8
XFILLER_60_574 VDD VSS sg13g2_decap_8
XFILLER_53_1422 VDD VSS sg13g2_decap_8
XFILLER_14_980 VDD VSS sg13g2_decap_8
X_14540__1732 _14540_/RESET_B VDD VSS sg13g2_tiehi
XFILLER_177_259 VDD VSS sg13g2_decap_8
X_13609_ _13609_/Y _13609_/A _13609_/B VDD VSS sg13g2_nor2_1
XFILLER_32_298 VDD VSS sg13g2_fill_1
XFILLER_20_449 VDD VSS sg13g2_decap_8
XFILLER_13_490 VDD VSS sg13g2_decap_8
X_14589_ _14589_/Q clkload59/A _14589_/D _14589_/RESET_B VDD VSS sg13g2_dfrbpq_1
XFILLER_14_1428 VDD VSS sg13g2_decap_8
XFILLER_159_985 VDD VSS sg13g2_decap_8
XFILLER_174_944 VDD VSS sg13g2_decap_8
XFILLER_9_483 VDD VSS sg13g2_decap_8
XFILLER_173_443 VDD VSS sg13g2_decap_8
XFILLER_12_1141 VDD VSS sg13g2_decap_8
XFILLER_174_988 VDD VSS sg13g2_fill_2
XFILLER_57_0 VDD VSS sg13g2_decap_8
XFILLER_126_370 VDD VSS sg13g2_decap_8
X_13813__2459 _13813_/RESET_B VDD VSS sg13g2_tiehi
XFILLER_138_1321 VDD VSS sg13g2_decap_4
XFILLER_154_690 VDD VSS sg13g2_decap_4
XFILLER_160_126 VDD VSS sg13g2_decap_8
X_14573__1699 _14573_/RESET_B VDD VSS sg13g2_tiehi
XFILLER_142_863 VDD VSS sg13g2_fill_2
X_14837__2963 _14837_/RESET_B VDD VSS sg13g2_tiehi
XFILLER_114_587 VDD VSS sg13g2_decap_8
XFILLER_142_896 VDD VSS sg13g2_decap_8
XFILLER_141_373 VDD VSS sg13g2_decap_8
XFILLER_4_70 VDD VSS sg13g2_decap_8
X_07963_ _07963_/Y _15013_/Q _07861_/B VDD VSS sg13g2_nor2b_1
XFILLER_99_298 VDD VSS sg13g2_decap_8
X_09702_ _14294_/D _10165_/A1 _14294_/Q _09704_/S VDD VSS sg13g2_mux2_1
XFILLER_114_38 VDD VSS sg13g2_decap_8
X_07894_ _07904_/B _07917_/B _08160_/B VDD VSS sg13g2_nor2_1
XFILLER_68_674 VDD VSS sg13g2_fill_1
XFILLER_55_313 VDD VSS sg13g2_decap_8
X_09633_ _14229_/D _10097_/A0 _14229_/Q _09633_/S VDD VSS sg13g2_mux2_1
XFILLER_55_324 VDD VSS sg13g2_fill_1
XFILLER_28_538 VDD VSS sg13g2_decap_8
XFILLER_23_1281 VDD VSS sg13g2_decap_8
X_09564_ _14162_/D _09597_/A1 _14162_/Q _09570_/S VDD VSS sg13g2_mux2_1
XFILLER_110_1251 VDD VSS sg13g2_decap_8
XFILLER_3_1386 VDD VSS sg13g2_decap_8
XFILLER_36_560 VDD VSS sg13g2_decap_8
X_08515_ _08515_/Y _07816_/X _08623_/A2 _08654_/B VDD VSS sg13g2_o21ai_1
X_09495_ _14095_/D _10091_/A0 _14095_/Q _09497_/S VDD VSS sg13g2_mux2_1
XFILLER_93_1246 VDD VSS sg13g2_decap_8
XFILLER_51_530 VDD VSS sg13g2_decap_8
XFILLER_145_1325 VDD VSS sg13g2_decap_8
XFILLER_23_232 VDD VSS sg13g2_decap_8
XFILLER_12_917 VDD VSS sg13g2_decap_8
X_08446_ _08447_/B _08421_/Y _08444_/Y _08445_/Y VDD VSS sg13g2_o21ai_1
XFILLER_180_1227 VDD VSS sg13g2_decap_4
XFILLER_11_427 VDD VSS sg13g2_decap_8
XFILLER_23_35 VDD VSS sg13g2_decap_8
X_08377_ _08377_/Y _08300_/X _08621_/B VDD VSS sg13g2_nand2b_1
XFILLER_149_451 VDD VSS sg13g2_decap_8
XFILLER_108_1180 VDD VSS sg13g2_fill_1
XFILLER_139_35 VDD VSS sg13g2_decap_8
XFILLER_143_1082 VDD VSS sg13g2_fill_2
XFILLER_17_1096 VDD VSS sg13g2_decap_8
XFILLER_20_983 VDD VSS sg13g2_fill_2
XFILLER_178_1112 VDD VSS sg13g2_fill_1
XFILLER_137_657 VDD VSS sg13g2_decap_8
XFILLER_152_605 VDD VSS sg13g2_decap_8
XFILLER_104_1099 VDD VSS sg13g2_decap_8
XFILLER_121_1391 VDD VSS sg13g2_decap_8
XFILLER_180_947 VDD VSS sg13g2_decap_4
X_10270_ _10305_/A _14784_/Q _14785_/Q _10278_/C VDD VSS sg13g2_and3_1
XFILLER_180_958 VDD VSS sg13g2_decap_4
XFILLER_3_637 VDD VSS sg13g2_decap_8
XFILLER_156_1421 VDD VSS sg13g2_decap_8
X_14403__1869 _14403_/RESET_B VDD VSS sg13g2_tiehi
XFILLER_69_1473 VDD VSS sg13g2_decap_4
XFILLER_155_56 VDD VSS sg13g2_decap_8
XFILLER_117_1405 VDD VSS sg13g2_decap_8
XFILLER_2_147 VDD VSS sg13g2_decap_8
Xpicorv32_macro_1512 mem_axi_awaddr[1] VDD VSS sg13g2_tielo
Xfanout1405 _12033_/A1 _12232_/S VDD VSS sg13g2_buf_1
Xfanout1416 _11826_/A1 fanout1419/X VDD VSS sg13g2_buf_1
XFILLER_132_395 VDD VSS sg13g2_decap_8
Xfanout1427 _11212_/S _11226_/S0 VDD VSS sg13g2_buf_1
XFILLER_48_21 VDD VSS sg13g2_decap_8
Xfanout440 _09106_/S _09059_/S VDD VSS sg13g2_buf_1
Xfanout1438 _11277_/S _12098_/A1 VDD VSS sg13g2_buf_1
XFILLER_59_641 VDD VSS sg13g2_decap_8
Xfanout451 _12400_/A _12791_/B2 VDD VSS sg13g2_buf_1
Xfanout1449 _12070_/S0 _12171_/S0 VDD VSS sg13g2_buf_1
XFILLER_8_1253 VDD VSS sg13g2_decap_8
XFILLER_120_568 VDD VSS sg13g2_fill_2
X_13968__2304 _13968_/RESET_B VDD VSS sg13g2_tiehi
Xfanout462 _10136_/S _10103_/Y VDD VSS sg13g2_buf_1
X_13960_ _13960_/Q clkload23/A _13960_/D _13960_/RESET_B VDD VSS sg13g2_dfrbpq_1
X_15055__2604 _15055_/RESET_B VDD VSS sg13g2_tiehi
Xfanout473 _09998_/S _10002_/S VDD VSS sg13g2_buf_1
XFILLER_4_1106 VDD VSS sg13g2_decap_8
Xfanout484 _09793_/S _09773_/Y VDD VSS sg13g2_buf_1
XFILLER_93_419 VDD VSS sg13g2_decap_8
XFILLER_47_814 VDD VSS sg13g2_decap_8
XFILLER_24_1045 VDD VSS sg13g2_decap_8
XFILLER_101_782 VDD VSS sg13g2_decap_8
XFILLER_58_162 VDD VSS sg13g2_decap_4
XFILLER_115_1184 VDD VSS sg13g2_decap_4
XFILLER_171_77 VDD VSS sg13g2_decap_8
X_12911_ _12911_/Y input28/X _13602_/A VDD VSS sg13g2_nand2b_1
XFILLER_98_1124 VDD VSS sg13g2_decap_8
XFILLER_46_324 VDD VSS sg13g2_decap_8
XFILLER_0_28 VDD VSS sg13g2_decap_8
X_13891_ _13891_/Q clkload30/A _13891_/D _13891_/RESET_B VDD VSS sg13g2_dfrbpq_1
XFILLER_100_292 VDD VSS sg13g2_decap_8
XFILLER_150_1097 VDD VSS sg13g2_decap_8
XFILLER_47_869 VDD VSS sg13g2_decap_4
XFILLER_98_1168 VDD VSS sg13g2_fill_1
XFILLER_34_508 VDD VSS sg13g2_decap_8
X_12842_ _12845_/B _12842_/A _12900_/B _12867_/C input14/X VDD VSS sg13g2_nand4_1
X_14890__2857 _14890_/RESET_B VDD VSS sg13g2_tiehi
XFILLER_15_700 VDD VSS sg13g2_decap_8
XFILLER_185_1138 VDD VSS sg13g2_decap_8
XFILLER_64_42 VDD VSS sg13g2_decap_8
XFILLER_61_305 VDD VSS sg13g2_decap_8
XFILLER_46_379 VDD VSS sg13g2_decap_8
XFILLER_161_0 VDD VSS sg13g2_decap_8
XFILLER_55_891 VDD VSS sg13g2_decap_8
XFILLER_14_210 VDD VSS sg13g2_decap_8
X_12773_ _12773_/X _14265_/Q _14297_/Q _14329_/Q _14361_/Q _12773_/S0 _12773_/S1 VDD
+ VSS sg13g2_mux4_1
XFILLER_76_1466 VDD VSS sg13g2_decap_8
XFILLER_64_97 VDD VSS sg13g2_decap_8
XFILLER_76_1477 VDD VSS sg13g2_fill_2
XFILLER_70_850 VDD VSS sg13g2_decap_8
XFILLER_159_204 VDD VSS sg13g2_decap_8
X_14512_ _14512_/Q clkload27/A _14512_/D _14512_/RESET_B VDD VSS sg13g2_dfrbpq_1
XFILLER_37_1439 VDD VSS sg13g2_decap_8
XFILLER_159_215 VDD VSS sg13g2_fill_1
XFILLER_15_777 VDD VSS sg13g2_decap_8
X_11724_ _11724_/Y _11726_/A _12298_/B VDD VSS sg13g2_nor2_1
XFILLER_70_883 VDD VSS sg13g2_decap_8
XFILLER_163_1458 VDD VSS sg13g2_decap_8
XFILLER_163_1469 VDD VSS sg13g2_fill_1
XFILLER_14_287 VDD VSS sg13g2_decap_8
X_14443_ _14443_/Q clkload9/A _14443_/D _14443_/RESET_B VDD VSS sg13g2_dfrbpq_1
X_11655_ _11655_/Y _14906_/Q _11655_/B VDD VSS sg13g2_nand2_1
XFILLER_80_52 VDD VSS sg13g2_fill_2
XFILLER_7_910 VDD VSS sg13g2_decap_8
X_10606_ _10629_/C _10606_/A _10606_/B _10652_/A VDD VSS sg13g2_nor3_1
XFILLER_156_944 VDD VSS sg13g2_decap_8
XFILLER_161_1193 VDD VSS sg13g2_fill_1
X_14374_ _14374_/Q _14726_/CLK _14374_/D _14374_/RESET_B VDD VSS sg13g2_dfrbpq_1
X_11586_ _11586_/Y _12957_/A _12294_/A2 _12225_/B2 VDD VSS sg13g2_a21oi_1
XFILLER_156_955 VDD VSS sg13g2_fill_2
XFILLER_31_1038 VDD VSS sg13g2_decap_8
XFILLER_11_994 VDD VSS sg13g2_decap_8
XFILLER_183_741 VDD VSS sg13g2_fill_2
XFILLER_6_420 VDD VSS sg13g2_decap_8
XFILLER_127_134 VDD VSS sg13g2_decap_8
XFILLER_70_1098 VDD VSS sg13g2_decap_8
X_13325_ _13326_/B _15113_/Q _13306_/B _13309_/Y _15066_/Q VDD VSS sg13g2_a22oi_1
X_10537_ _10567_/B _14861_/Q _14860_/Q _14859_/Q _10558_/B VDD VSS sg13g2_nand4_1
XFILLER_7_987 VDD VSS sg13g2_decap_8
XFILLER_182_273 VDD VSS sg13g2_decap_8
XFILLER_109_893 VDD VSS sg13g2_decap_8
XFILLER_115_329 VDD VSS sg13g2_fill_1
XFILLER_50_7 VDD VSS sg13g2_decap_8
XFILLER_108_370 VDD VSS sg13g2_fill_1
XFILLER_143_649 VDD VSS sg13g2_decap_8
X_13256_ _13259_/A _13243_/Y _13232_/A _13255_/Y VDD VSS sg13g2_o21ai_1
X_10468_ _14844_/D _10633_/A _10468_/B _10468_/C VDD VSS sg13g2_nor3_1
XFILLER_6_497 VDD VSS sg13g2_decap_8
XFILLER_124_852 VDD VSS sg13g2_decap_8
XFILLER_142_148 VDD VSS sg13g2_decap_8
X_12207_ _12207_/X _13847_/Q _13879_/Q _13911_/Q _13943_/Q _12213_/S0 _12169_/C VDD
+ VSS sg13g2_mux4_1
X_13187_ _13191_/A _13188_/A _13225_/A _13186_/X VDD VSS sg13g2_a21o_1
X_10399_ _10414_/C _10400_/B _10400_/C _10400_/D VDD VSS sg13g2_nor3_1
XFILLER_123_362 VDD VSS sg13g2_decap_8
XFILLER_170_1418 VDD VSS sg13g2_decap_8
X_12138_ _12138_/X _14389_/Q _14421_/Q _14485_/Q _14517_/Q _12138_/S0 _12138_/S1 VDD
+ VSS sg13g2_mux4_1
XFILLER_96_224 VDD VSS sg13g2_decap_8
XFILLER_111_535 VDD VSS sg13g2_decap_8
XFILLER_81_1150 VDD VSS sg13g2_decap_8
X_12069_ _12069_/X _14259_/Q _14291_/Q _14323_/Q _14355_/Q _12070_/S0 _12073_/S1 VDD
+ VSS sg13g2_mux4_1
XFILLER_78_972 VDD VSS sg13g2_decap_8
XFILLER_42_1134 VDD VSS sg13g2_fill_1
XFILLER_133_1262 VDD VSS sg13g2_fill_1
X_14558__1714 _14558_/RESET_B VDD VSS sg13g2_tiehi
XFILLER_77_471 VDD VSS sg13g2_decap_8
XFILLER_37_313 VDD VSS sg13g2_decap_8
X_16877_ _16877_/X _16877_/A VDD VSS sg13g2_buf_1
XFILLER_37_357 VDD VSS sg13g2_decap_8
XFILLER_168_1336 VDD VSS sg13g2_fill_1
XFILLER_168_1347 VDD VSS sg13g2_decap_8
XFILLER_129_1309 VDD VSS sg13g2_decap_8
XFILLER_18_560 VDD VSS sg13g2_decap_4
XFILLER_53_839 VDD VSS sg13g2_fill_2
XFILLER_20_1476 VDD VSS sg13g2_fill_2
XFILLER_92_496 VDD VSS sg13g2_decap_8
XFILLER_18_593 VDD VSS sg13g2_decap_8
XFILLER_80_658 VDD VSS sg13g2_decap_8
X_08300_ _08300_/X _08304_/A _08276_/A _08867_/A1 _08863_/A1 _13518_/A1 _08300_/S1
+ VDD VSS sg13g2_mux4_1
X_09280_ _13888_/D _13888_/Q _10143_/A1 _09305_/S VDD VSS sg13g2_mux2_1
XFILLER_127_1044 VDD VSS sg13g2_fill_1
XFILLER_178_546 VDD VSS sg13g2_decap_8
XFILLER_61_894 VDD VSS sg13g2_decap_8
XFILLER_60_371 VDD VSS sg13g2_fill_1
XFILLER_127_1066 VDD VSS sg13g2_decap_8
X_08231_ _08231_/Y _07924_/C _08230_/Y _08000_/X VDD VSS sg13g2_o21ai_1
XFILLER_60_382 VDD VSS sg13g2_decap_8
XFILLER_20_224 VDD VSS sg13g2_decap_8
XFILLER_53_1252 VDD VSS sg13g2_decap_8
XFILLER_119_602 VDD VSS sg13g2_fill_1
XFILLER_159_782 VDD VSS sg13g2_fill_1
XFILLER_105_1342 VDD VSS sg13g2_decap_8
XFILLER_14_1225 VDD VSS sg13g2_decap_8
X_08162_ _08162_/Y _08182_/B _08115_/B _08140_/Y VDD VSS sg13g2_o21ai_1
XFILLER_119_646 VDD VSS sg13g2_decap_4
XFILLER_147_966 VDD VSS sg13g2_fill_2
XFILLER_9_280 VDD VSS sg13g2_decap_8
XFILLER_101_1228 VDD VSS sg13g2_fill_2
XFILLER_107_819 VDD VSS sg13g2_decap_8
XFILLER_119_679 VDD VSS sg13g2_decap_8
XFILLER_174_763 VDD VSS sg13g2_decap_8
X_08093_ _08093_/Y _07879_/Y _08091_/Y _08092_/Y VDD VSS sg13g2_a21oi_1
XFILLER_109_38 VDD VSS sg13g2_decap_8
XFILLER_146_465 VDD VSS sg13g2_decap_8
XFILLER_161_402 VDD VSS sg13g2_fill_1
XFILLER_174_785 VDD VSS sg13g2_decap_8
Xclkload50 clkload50/Y clkload50/A VDD VSS sg13g2_inv_1
XFILLER_173_273 VDD VSS sg13g2_decap_8
Xmax_cap1280 _16878_/A _13716_/Q VDD VSS sg13g2_buf_4
XFILLER_133_115 VDD VSS sg13g2_decap_8
Xclkload61 clkload61/Y clkload61/A VDD VSS sg13g2_inv_2
Xmax_cap1291 output43/A _16867_/A VDD VSS sg13g2_buf_4
Xclkload72 clkload72/Y clkload72/A VDD VSS sg13g2_inv_4
Xclkload83 clkload83/Y clkload83/A VDD VSS sg13g2_inv_1
XFILLER_86_1072 VDD VSS sg13g2_fill_2
XFILLER_138_1173 VDD VSS sg13g2_decap_8
XFILLER_173_1053 VDD VSS sg13g2_decap_8
XFILLER_87_235 VDD VSS sg13g2_decap_8
X_08995_ _08995_/Y _14899_/Q _08988_/C _08999_/B1 VDD VSS sg13g2_o21ai_1
XFILLER_134_1048 VDD VSS sg13g2_decap_8
XFILLER_87_246 VDD VSS sg13g2_fill_2
XFILLER_64_1370 VDD VSS sg13g2_decap_4
XFILLER_60_1201 VDD VSS sg13g2_decap_8
XFILLER_102_568 VDD VSS sg13g2_decap_8
XFILLER_69_972 VDD VSS sg13g2_decap_8
XFILLER_25_1343 VDD VSS sg13g2_decap_8
X_07946_ _08435_/A _15005_/Q _07946_/B VDD VSS sg13g2_nand2b_1
XFILLER_116_1471 VDD VSS sg13g2_decap_4
XFILLER_60_1245 VDD VSS sg13g2_decap_8
XFILLER_21_1207 VDD VSS sg13g2_decap_8
XFILLER_18_35 VDD VSS sg13g2_decap_8
X_07877_ _07917_/A _07879_/A _08138_/B VDD VSS sg13g2_nor2_1
XFILLER_112_1357 VDD VSS sg13g2_decap_8
XFILLER_99_1477 VDD VSS sg13g2_fill_2
XFILLER_141_47 VDD VSS sg13g2_decap_4
X_09616_ _14212_/D _09616_/A0 _14212_/Q _09633_/S VDD VSS sg13g2_mux2_1
XFILLER_83_474 VDD VSS sg13g2_decap_8
XFILLER_83_485 VDD VSS sg13g2_fill_2
XFILLER_3_1183 VDD VSS sg13g2_decap_8
XFILLER_93_1010 VDD VSS sg13g2_fill_2
XFILLER_58_1130 VDD VSS sg13g2_decap_4
XFILLER_43_338 VDD VSS sg13g2_decap_4
X_09547_ _14145_/D _10077_/A0 _14145_/Q _09567_/S VDD VSS sg13g2_mux2_1
XFILLER_70_146 VDD VSS sg13g2_decap_8
XFILLER_58_1174 VDD VSS sg13g2_fill_1
XFILLER_52_872 VDD VSS sg13g2_fill_2
XFILLER_12_714 VDD VSS sg13g2_decap_8
XFILLER_19_1147 VDD VSS sg13g2_decap_8
X_09478_ _14078_/D _10041_/A0 _14078_/Q _09478_/S VDD VSS sg13g2_mux2_1
XFILLER_34_56 VDD VSS sg13g2_decap_8
XFILLER_106_1106 VDD VSS sg13g2_fill_1
XFILLER_145_1155 VDD VSS sg13g2_fill_2
XFILLER_145_1166 VDD VSS sg13g2_decap_8
XFILLER_51_382 VDD VSS sg13g2_decap_8
XFILLER_11_224 VDD VSS sg13g2_decap_8
XFILLER_180_1057 VDD VSS sg13g2_decap_4
X_08429_ _08429_/Y _08659_/A _08659_/B _08429_/C VDD VSS sg13g2_nor3_1
XFILLER_8_707 VDD VSS sg13g2_decap_8
X_13667__2631 _13667_/RESET_B VDD VSS sg13g2_tiehi
X_14032__2240 _14032_/RESET_B VDD VSS sg13g2_tiehi
XFILLER_32_1314 VDD VSS sg13g2_decap_8
Xclkload0 clkload0/X clkload0/A VDD VSS sg13g2_buf_8
X_11440_ _11440_/X _14560_/Q _14592_/Q _14624_/Q _14656_/Q _11442_/S0 _11442_/S1 VDD
+ VSS sg13g2_mux4_1
XFILLER_123_1442 VDD VSS sg13g2_fill_2
XFILLER_7_217 VDD VSS sg13g2_decap_8
XFILLER_138_944 VDD VSS sg13g2_decap_4
XFILLER_165_741 VDD VSS sg13g2_decap_4
XFILLER_32_1347 VDD VSS sg13g2_decap_8
XFILLER_137_443 VDD VSS sg13g2_decap_4
XFILLER_20_791 VDD VSS sg13g2_decap_8
XFILLER_50_55 VDD VSS sg13g2_fill_2
X_11371_ _11371_/Y _11418_/A _14142_/Q _11419_/C VDD VSS sg13g2_a21oi_1
XFILLER_180_700 VDD VSS sg13g2_fill_2
XFILLER_50_66 VDD VSS sg13g2_decap_4
X_14636__1636 _14636_/RESET_B VDD VSS sg13g2_tiehi
XFILLER_152_413 VDD VSS sg13g2_decap_8
X_13110_ _13111_/B _13166_/A1 _13105_/X _13104_/Y _13160_/B _13109_/Y VDD VSS sg13g2_a221oi_1
X_14918__2801 _14918_/RESET_B VDD VSS sg13g2_tiehi
X_10322_ _14800_/D _10322_/A _10323_/B _10337_/C VDD VSS sg13g2_and3_1
XFILLER_4_924 VDD VSS sg13g2_decap_8
X_14090_ _14090_/Q clkload19/A _14090_/D _14090_/RESET_B VDD VSS sg13g2_dfrbpq_1
XFILLER_166_77 VDD VSS sg13g2_decap_8
XFILLER_30_1082 VDD VSS sg13g2_decap_8
XFILLER_3_434 VDD VSS sg13g2_decap_8
X_13041_ _13041_/Y _13042_/A _13042_/B _13042_/C VDD VSS sg13g2_a21oi_1
XFILLER_65_1112 VDD VSS sg13g2_decap_8
XFILLER_180_777 VDD VSS sg13g2_decap_8
X_10253_ _14779_/D _14779_/Q _10258_/D _10252_/Y VDD VSS sg13g2_a21oi_1
XFILLER_117_1213 VDD VSS sg13g2_decap_4
XFILLER_182_21 VDD VSS sg13g2_decap_8
XFILLER_105_373 VDD VSS sg13g2_decap_8
XFILLER_133_682 VDD VSS sg13g2_decap_8
XFILLER_117_1235 VDD VSS sg13g2_fill_1
Xfanout1202 _11661_/A _08882_/A1 VDD VSS sg13g2_buf_1
X_10184_ _10185_/C input36/X input3/X _10184_/C VDD VSS sg13g2_or3_1
XFILLER_78_224 VDD VSS sg13g2_decap_8
XFILLER_132_181 VDD VSS sg13g2_decap_8
Xfanout1213 _08296_/A1 _14967_/Q VDD VSS sg13g2_buf_1
Xfanout1224 _11461_/A _14963_/Q VDD VSS sg13g2_buf_1
XFILLER_79_769 VDD VSS sg13g2_decap_4
Xfanout1235 _12814_/C _12997_/A VDD VSS sg13g2_buf_1
Xfanout1246 _13245_/A _14922_/Q VDD VSS sg13g2_buf_1
XFILLER_8_1050 VDD VSS sg13g2_decap_8
XFILLER_182_98 VDD VSS sg13g2_decap_8
X_14992_ _14992_/Q _15249_/CLK _14992_/D _14992_/RESET_B VDD VSS sg13g2_dfrbpq_1
Xfanout1257 _10674_/A _14896_/Q VDD VSS sg13g2_buf_1
X_15004__2676 _15004_/RESET_B VDD VSS sg13g2_tiehi
Xfanout270 _10082_/A0 _09719_/A0 VDD VSS sg13g2_buf_1
Xfanout1268 _10500_/A _14844_/Q VDD VSS sg13g2_buf_1
XFILLER_115_70 VDD VSS sg13g2_decap_8
Xfanout281 _10068_/S _10037_/Y VDD VSS sg13g2_buf_1
Xfanout1279 _13613_/B _14747_/Q VDD VSS sg13g2_buf_1
XFILLER_93_227 VDD VSS sg13g2_fill_2
Xfanout292 _09601_/S _09604_/S VDD VSS sg13g2_buf_1
XFILLER_59_482 VDD VSS sg13g2_fill_1
X_13943_ _13943_/Q _15017_/CLK _13943_/D _13943_/RESET_B VDD VSS sg13g2_dfrbpq_1
XFILLER_101_590 VDD VSS sg13g2_decap_8
XFILLER_130_1446 VDD VSS sg13g2_fill_1
XFILLER_86_290 VDD VSS sg13g2_fill_1
XFILLER_19_357 VDD VSS sg13g2_decap_8
XFILLER_75_975 VDD VSS sg13g2_decap_8
XFILLER_35_806 VDD VSS sg13g2_fill_1
X_13874_ _13874_/Q _14674_/CLK _13874_/D _13874_/RESET_B VDD VSS sg13g2_dfrbpq_1
XFILLER_47_688 VDD VSS sg13g2_fill_2
X_12825_ _12828_/B _12866_/A _12867_/C _12899_/C input22/X VDD VSS sg13g2_nand4_1
XFILLER_61_124 VDD VSS sg13g2_fill_1
XFILLER_62_658 VDD VSS sg13g2_fill_1
XFILLER_61_135 VDD VSS sg13g2_decap_8
XFILLER_76_1252 VDD VSS sg13g2_decap_8
XFILLER_90_989 VDD VSS sg13g2_decap_8
XFILLER_163_1211 VDD VSS sg13g2_decap_8
XFILLER_167_1380 VDD VSS sg13g2_fill_1
XFILLER_163_1222 VDD VSS sg13g2_fill_2
XFILLER_72_1105 VDD VSS sg13g2_fill_1
XFILLER_15_574 VDD VSS sg13g2_decap_8
X_12756_ _12756_/X _14584_/Q _14616_/Q _14648_/Q _14680_/Q _12756_/S0 _12756_/S1 VDD
+ VSS sg13g2_mux4_1
XFILLER_98_7 VDD VSS sg13g2_decap_8
XFILLER_42_360 VDD VSS sg13g2_decap_8
XFILLER_91_73 VDD VSS sg13g2_fill_1
X_11707_ _11707_/Y _11707_/A _11773_/C VDD VSS sg13g2_xnor2_1
XFILLER_42_393 VDD VSS sg13g2_decap_8
XFILLER_124_1228 VDD VSS sg13g2_decap_8
XFILLER_129_900 VDD VSS sg13g2_decap_8
X_12687_ _12687_/X _14707_/Q _14739_/Q _13779_/Q _13811_/Q _12689_/S0 _12689_/S1 VDD
+ VSS sg13g2_mux4_1
XFILLER_50_1414 VDD VSS sg13g2_decap_8
XFILLER_128_410 VDD VSS sg13g2_decap_8
X_14426_ _14426_/Q clkload57/A _14426_/D _14426_/RESET_B VDD VSS sg13g2_dfrbpq_1
X_11638_ _11638_/X _11638_/A _11638_/B _11638_/C VDD VSS sg13g2_or3_1
X_14275__1997 _14275_/RESET_B VDD VSS sg13g2_tiehi
XFILLER_11_791 VDD VSS sg13g2_decap_8
XFILLER_156_763 VDD VSS sg13g2_decap_8
XFILLER_116_605 VDD VSS sg13g2_decap_8
XFILLER_129_988 VDD VSS sg13g2_fill_1
X_14357_ _14357_/Q clkload32/A _14357_/D _14357_/RESET_B VDD VSS sg13g2_dfrbpq_1
XFILLER_183_560 VDD VSS sg13g2_decap_8
Xmax_cap404 _09306_/S _09274_/Y VDD VSS sg13g2_buf_2
X_11569_ _11572_/A _11638_/A _11571_/C VDD VSS sg13g2_nor2_1
XFILLER_155_262 VDD VSS sg13g2_decap_8
XFILLER_7_784 VDD VSS sg13g2_decap_8
X_13308_ _13308_/Y _13308_/A _15205_/Q VDD VSS sg13g2_nor2_1
XFILLER_109_690 VDD VSS sg13g2_decap_8
X_14288_ _14288_/Q clkload19/A _14288_/D _14288_/RESET_B VDD VSS sg13g2_dfrbpq_1
XFILLER_6_294 VDD VSS sg13g2_decap_8
XFILLER_48_1310 VDD VSS sg13g2_decap_8
XFILLER_48_1332 VDD VSS sg13g2_decap_8
XFILLER_174_1340 VDD VSS sg13g2_decap_8
X_13239_ _15049_/D _13266_/A _13239_/B VDD VSS sg13g2_nor2_1
XFILLER_83_1223 VDD VSS sg13g2_decap_8
X_13730__2542 _13730_/RESET_B VDD VSS sg13g2_tiehi
X_14490__1782 _14490_/RESET_B VDD VSS sg13g2_tiehi
XFILLER_112_833 VDD VSS sg13g2_decap_8
XFILLER_97_522 VDD VSS sg13g2_fill_2
XFILLER_69_224 VDD VSS sg13g2_decap_8
XFILLER_123_192 VDD VSS sg13g2_fill_1
XFILLER_135_1346 VDD VSS sg13g2_fill_2
XFILLER_135_1357 VDD VSS sg13g2_decap_8
XFILLER_170_1248 VDD VSS sg13g2_decap_8
X_07800_ _08574_/A _15006_/Q _07945_/B VDD VSS sg13g2_xor2_1
X_08780_ _13678_/D _08728_/Y _08779_/Y _08778_/Y VDD VSS sg13g2_a21oi_1
XFILLER_97_577 VDD VSS sg13g2_fill_1
XFILLER_97_588 VDD VSS sg13g2_decap_8
XFILLER_84_205 VDD VSS sg13g2_decap_8
XFILLER_111_376 VDD VSS sg13g2_decap_8
XFILLER_66_920 VDD VSS sg13g2_decap_8
XFILLER_111_398 VDD VSS sg13g2_decap_8
X_07731_ _07907_/D _15077_/Q _15075_/Q VDD VSS sg13g2_or2_1
X_14110__2162 _14110_/RESET_B VDD VSS sg13g2_tiehi
X_07662_ _07662_/Y _14764_/Q _07766_/B VDD VSS sg13g2_nor2_1
XFILLER_4_1470 VDD VSS sg13g2_decap_8
XFILLER_38_688 VDD VSS sg13g2_decap_8
X_09401_ _14004_/D _09997_/A0 _14004_/Q _09404_/S VDD VSS sg13g2_mux2_1
XFILLER_20_1273 VDD VSS sg13g2_decap_8
XFILLER_0_1345 VDD VSS sg13g2_decap_8
XFILLER_92_293 VDD VSS sg13g2_fill_1
X_14714__1558 _14714_/RESET_B VDD VSS sg13g2_tiehi
XFILLER_80_455 VDD VSS sg13g2_decap_8
XFILLER_80_466 VDD VSS sg13g2_fill_1
XFILLER_34_861 VDD VSS sg13g2_decap_8
XFILLER_146_1431 VDD VSS sg13g2_decap_4
X_09332_ _13939_/D _10162_/A1 _13939_/Q _09337_/S VDD VSS sg13g2_mux2_1
XFILLER_34_872 VDD VSS sg13g2_fill_2
XFILLER_179_844 VDD VSS sg13g2_decap_8
XFILLER_52_179 VDD VSS sg13g2_decap_8
XFILLER_55_1336 VDD VSS sg13g2_decap_4
XFILLER_142_1306 VDD VSS sg13g2_decap_8
XFILLER_178_343 VDD VSS sg13g2_decap_8
X_09263_ _13872_/D _13872_/Q _09927_/A1 _09265_/S VDD VSS sg13g2_mux2_1
XFILLER_139_719 VDD VSS sg13g2_fill_1
XFILLER_21_555 VDD VSS sg13g2_decap_8
XFILLER_166_527 VDD VSS sg13g2_decap_8
X_08214_ _08214_/X _08374_/B _08452_/C _08212_/X VDD VSS sg13g2_a21o_1
XFILLER_14_1022 VDD VSS sg13g2_decap_8
X_09194_ _13810_/D _13810_/Q _10128_/A0 _09201_/S VDD VSS sg13g2_mux2_1
X_08145_ _15221_/D _08145_/A _08145_/B _08145_/C VDD VSS sg13g2_nand3_1
XFILLER_107_605 VDD VSS sg13g2_decap_8
XFILLER_88_1123 VDD VSS sg13g2_decap_8
XFILLER_101_1025 VDD VSS sg13g2_decap_4
XFILLER_101_1036 VDD VSS sg13g2_decap_8
XFILLER_174_582 VDD VSS sg13g2_decap_8
XFILLER_179_1262 VDD VSS sg13g2_decap_8
XFILLER_20_14 VDD VSS sg13g2_decap_8
XFILLER_14_1099 VDD VSS sg13g2_decap_8
XFILLER_49_1107 VDD VSS sg13g2_fill_2
X_08076_ _08076_/Y _07900_/B _08074_/X _08075_/Y VDD VSS sg13g2_a21oi_1
XFILLER_31_1391 VDD VSS sg13g2_fill_2
XFILLER_106_137 VDD VSS sg13g2_fill_2
XFILLER_134_446 VDD VSS sg13g2_fill_2
XFILLER_135_969 VDD VSS sg13g2_fill_2
XFILLER_175_1126 VDD VSS sg13g2_decap_8
XFILLER_150_906 VDD VSS sg13g2_fill_1
XFILLER_162_766 VDD VSS sg13g2_decap_8
XFILLER_175_1137 VDD VSS sg13g2_fill_1
XFILLER_175_1148 VDD VSS sg13g2_decap_8
XFILLER_66_1421 VDD VSS sg13g2_decap_8
XFILLER_150_928 VDD VSS sg13g2_decap_8
XFILLER_161_265 VDD VSS sg13g2_decap_8
XFILLER_88_500 VDD VSS sg13g2_decap_8
XFILLER_27_1405 VDD VSS sg13g2_fill_1
XFILLER_1_938 VDD VSS sg13g2_decap_8
XFILLER_96_18 VDD VSS sg13g2_fill_2
XFILLER_153_1413 VDD VSS sg13g2_decap_4
X_14320__1952 _14320_/RESET_B VDD VSS sg13g2_tiehi
XFILLER_114_170 VDD VSS sg13g2_decap_8
XFILLER_0_448 VDD VSS sg13g2_decap_8
XFILLER_130_641 VDD VSS sg13g2_decap_8
XFILLER_130_663 VDD VSS sg13g2_fill_1
X_14803__3003 _14803_/RESET_B VDD VSS sg13g2_tiehi
X_08978_ wire439/A _10674_/A _09006_/A _08977_/Y VDD VSS sg13g2_o21ai_1
XFILLER_29_56 VDD VSS sg13g2_decap_8
XFILLER_25_1140 VDD VSS sg13g2_decap_8
XFILLER_29_611 VDD VSS sg13g2_fill_2
XFILLER_102_398 VDD VSS sg13g2_decap_4
X_07929_ _07930_/A _08263_/B _07929_/B VDD VSS sg13g2_nand2b_1
XFILLER_28_110 VDD VSS sg13g2_decap_8
XFILLER_68_290 VDD VSS sg13g2_decap_8
XFILLER_112_1143 VDD VSS sg13g2_decap_8
XFILLER_186_1200 VDD VSS sg13g2_decap_8
XFILLER_5_1267 VDD VSS sg13g2_decap_8
XFILLER_112_1154 VDD VSS sg13g2_fill_2
XFILLER_112_1165 VDD VSS sg13g2_fill_1
XFILLER_186_1211 VDD VSS sg13g2_decap_8
XFILLER_21_1048 VDD VSS sg13g2_decap_8
XFILLER_99_1263 VDD VSS sg13g2_fill_2
X_10940_ _14937_/D _10939_/Y _10938_/Y _10929_/Y VDD VSS sg13g2_o21ai_1
XFILLER_83_271 VDD VSS sg13g2_fill_1
XFILLER_72_934 VDD VSS sg13g2_decap_8
XFILLER_112_1198 VDD VSS sg13g2_fill_1
XFILLER_95_1149 VDD VSS sg13g2_decap_8
XFILLER_147_1217 VDD VSS sg13g2_decap_8
X_10871_ _10871_/Y _10871_/A _10871_/B VDD VSS sg13g2_xnor2_1
XFILLER_72_978 VDD VSS sg13g2_decap_8
XFILLER_71_455 VDD VSS sg13g2_decap_8
X_12610_ _12611_/B _13675_/Q _12707_/A2 _12609_/X _12707_/B2 _12707_/C1 VDD VSS sg13g2_a221oi_1
X_13590_ _13590_/Y _13590_/A _13593_/B VDD VSS sg13g2_nor2_1
XFILLER_12_511 VDD VSS sg13g2_decap_8
XFILLER_73_1436 VDD VSS sg13g2_decap_8
X_12541_ _15002_/D _12541_/A wire322/X VDD VSS sg13g2_nor2_1
XFILLER_61_21 VDD VSS sg13g2_decap_4
XFILLER_169_376 VDD VSS sg13g2_decap_4
XFILLER_184_302 VDD VSS sg13g2_decap_8
XFILLER_8_504 VDD VSS sg13g2_decap_8
XFILLER_61_43 VDD VSS sg13g2_decap_8
XFILLER_177_21 VDD VSS sg13g2_decap_8
XFILLER_36_1280 VDD VSS sg13g2_fill_1
XFILLER_12_588 VDD VSS sg13g2_decap_8
X_12472_ _12485_/A _10213_/A _07737_/B _14998_/Q VDD VSS sg13g2_a21oi_1
XFILLER_124_0 VDD VSS sg13g2_decap_8
X_14211_ _14211_/Q clkload30/A _14211_/D _14211_/RESET_B VDD VSS sg13g2_dfrbpq_1
XFILLER_137_240 VDD VSS sg13g2_decap_8
XFILLER_138_763 VDD VSS sg13g2_decap_4
X_11423_ _11423_/Y _11420_/Y _11422_/Y _11831_/B1 VDD VSS sg13g2_a21oi_1
X_15191_ _15191_/Q _15200_/CLK _15191_/D _15191_/RESET_B VDD VSS sg13g2_dfrbpq_1
XFILLER_177_98 VDD VSS sg13g2_decap_8
XFILLER_32_1177 VDD VSS sg13g2_decap_8
XFILLER_32_1188 VDD VSS sg13g2_fill_1
XANTENNA_9 _13710_/Q VDD VSS sg13g2_antennanp
XFILLER_158_1313 VDD VSS sg13g2_decap_8
XFILLER_6_49 VDD VSS sg13g2_decap_8
XFILLER_153_733 VDD VSS sg13g2_fill_2
X_14142_ _14142_/Q clkload52/A _14142_/D _14142_/RESET_B VDD VSS sg13g2_dfrbpq_1
X_11354_ _11354_/Y _11410_/A1 _14622_/Q VDD VSS sg13g2_nand2b_1
XFILLER_4_721 VDD VSS sg13g2_decap_8
XFILLER_10_1442 VDD VSS sg13g2_decap_8
X_10305_ _10327_/B _10305_/A _10305_/B _10311_/B _10311_/C VDD VSS sg13g2_and4_1
XFILLER_3_231 VDD VSS sg13g2_decap_8
XFILLER_119_1319 VDD VSS sg13g2_decap_4
XFILLER_106_660 VDD VSS sg13g2_decap_8
XFILLER_140_405 VDD VSS sg13g2_decap_8
XFILLER_180_574 VDD VSS sg13g2_decap_8
X_14073_ _14073_/Q clkload34/A _14073_/D _14073_/RESET_B VDD VSS sg13g2_dfrbpq_1
X_11285_ _11285_/Y _11285_/A _12334_/C VDD VSS sg13g2_nor2b_1
XFILLER_134_980 VDD VSS sg13g2_decap_8
X_15158__2734 _15158_/RESET_B VDD VSS sg13g2_tiehi
XFILLER_4_798 VDD VSS sg13g2_decap_8
X_13024_ _13026_/A _13009_/A _13010_/B _13058_/C VDD VSS sg13g2_o21ai_1
X_10236_ _14773_/D _07638_/Y _10232_/B _10235_/Y VDD VSS sg13g2_a21oi_1
XFILLER_10_91 VDD VSS sg13g2_decap_8
XFILLER_117_1032 VDD VSS sg13g2_decap_8
Xfanout1010 _10199_/A1 _15181_/Q VDD VSS sg13g2_buf_1
Xfanout1021 _13028_/B _15108_/Q VDD VSS sg13g2_buf_1
XFILLER_126_91 VDD VSS sg13g2_decap_4
XFILLER_79_577 VDD VSS sg13g2_fill_2
XFILLER_0_960 VDD VSS sg13g2_decap_8
Xfanout1032 _07729_/B _13250_/A2 VDD VSS sg13g2_buf_1
X_10167_ _14744_/D _14744_/Q _10167_/A1 _10167_/S VDD VSS sg13g2_mux2_1
Xfanout1043 _11191_/A _10924_/B1 VDD VSS sg13g2_buf_1
Xfanout1054 _07720_/A _15069_/Q VDD VSS sg13g2_buf_1
Xfanout1065 _09938_/C _15065_/Q VDD VSS sg13g2_buf_1
XFILLER_94_547 VDD VSS sg13g2_decap_8
XFILLER_130_1221 VDD VSS sg13g2_decap_8
XFILLER_13_7 VDD VSS sg13g2_decap_8
Xfanout1076 _09147_/B _09078_/B VDD VSS sg13g2_buf_1
X_14975_ _14975_/Q clkload53/A _14975_/D _14975_/RESET_B VDD VSS sg13g2_dfrbpq_1
Xfanout1087 _13613_/A _15056_/Q VDD VSS sg13g2_buf_1
X_10098_ _14678_/D _10098_/A0 _14678_/Q _10101_/S VDD VSS sg13g2_mux2_1
Xfanout1098 _08263_/B _14997_/Q VDD VSS sg13g2_buf_1
XFILLER_82_709 VDD VSS sg13g2_decap_8
XFILLER_47_452 VDD VSS sg13g2_decap_8
XFILLER_19_154 VDD VSS sg13g2_decap_8
X_13926_ _13926_/Q _14726_/CLK _13926_/D _13926_/RESET_B VDD VSS sg13g2_dfrbpq_1
XFILLER_75_772 VDD VSS sg13g2_decap_8
XFILLER_74_271 VDD VSS sg13g2_decap_8
XFILLER_90_731 VDD VSS sg13g2_decap_8
XFILLER_165_1317 VDD VSS sg13g2_decap_8
X_13857_ _13857_/Q clkload44/A _13857_/D _13857_/RESET_B VDD VSS sg13g2_dfrbpq_1
X_12808_ _12808_/Y _13293_/B _13048_/B VDD VSS sg13g2_nor2_1
XFILLER_34_168 VDD VSS sg13g2_fill_2
XFILLER_37_1022 VDD VSS sg13g2_decap_8
X_13788_ _13788_/Q _14716_/CLK _13788_/D _13788_/RESET_B VDD VSS sg13g2_dfrbpq_1
XFILLER_15_371 VDD VSS sg13g2_decap_8
X_12739_ _12739_/X _13751_/Q _14103_/Q _14455_/Q _14551_/Q _12742_/S0 _12756_/S1 VDD
+ VSS sg13g2_mux4_1
X_13748__2524 _13748_/RESET_B VDD VSS sg13g2_tiehi
XFILLER_30_341 VDD VSS sg13g2_decap_8
XFILLER_163_1085 VDD VSS sg13g2_fill_2
XFILLER_175_313 VDD VSS sg13g2_decap_8
XFILLER_176_847 VDD VSS sg13g2_decap_8
XFILLER_54_1380 VDD VSS sg13g2_decap_8
XFILLER_129_763 VDD VSS sg13g2_decap_8
X_14409_ _14409_/Q clkload30/A _14409_/D _14409_/RESET_B VDD VSS sg13g2_dfrbpq_1
XFILLER_141_1372 VDD VSS sg13g2_fill_1
XFILLER_15_1375 VDD VSS sg13g2_decap_8
XFILLER_50_1266 VDD VSS sg13g2_decap_8
XFILLER_50_1277 VDD VSS sg13g2_fill_1
XFILLER_116_413 VDD VSS sg13g2_decap_8
XFILLER_11_1239 VDD VSS sg13g2_decap_8
XFILLER_129_796 VDD VSS sg13g2_decap_4
XFILLER_144_733 VDD VSS sg13g2_decap_8
XFILLER_176_1413 VDD VSS sg13g2_decap_8
XFILLER_143_210 VDD VSS sg13g2_fill_1
XFILLER_7_581 VDD VSS sg13g2_decap_8
XFILLER_143_221 VDD VSS sg13g2_decap_8
X_14128__2144 _14128_/RESET_B VDD VSS sg13g2_tiehi
XFILLER_104_608 VDD VSS sg13g2_decap_4
X_09950_ _14534_/D _14534_/Q _10082_/A0 _09961_/S VDD VSS sg13g2_mux2_1
XFILLER_89_319 VDD VSS sg13g2_decap_8
X_08901_ _08901_/Y _13608_/A1 _08835_/B _16870_/A VDD VSS sg13g2_a21oi_1
XFILLER_98_831 VDD VSS sg13g2_decap_8
XFILLER_112_630 VDD VSS sg13g2_decap_8
X_09881_ _14467_/D _09881_/A0 _14467_/Q _09903_/S VDD VSS sg13g2_mux2_1
XFILLER_83_1086 VDD VSS sg13g2_decap_8
X_08832_ _08833_/C _13293_/A _15055_/Q _13283_/A _15053_/Q VDD VSS sg13g2_nor4_1
XFILLER_98_886 VDD VSS sg13g2_decap_4
XFILLER_58_728 VDD VSS sg13g2_decap_8
XFILLER_61_1340 VDD VSS sg13g2_decap_8
XFILLER_26_1460 VDD VSS sg13g2_decap_8
XFILLER_135_1198 VDD VSS sg13g2_decap_8
XFILLER_170_1089 VDD VSS sg13g2_decap_8
X_13996__2276 _13996_/RESET_B VDD VSS sg13g2_tiehi
X_14902__2833 _14902_/RESET_B VDD VSS sg13g2_tiehi
XFILLER_85_547 VDD VSS sg13g2_fill_1
XFILLER_22_1324 VDD VSS sg13g2_decap_8
X_08763_ _08763_/Y _07719_/A _07720_/B _15189_/Q VDD VSS sg13g2_o21ai_1
XFILLER_73_709 VDD VSS sg13g2_decap_8
X_13684__2597 _13684_/RESET_B VDD VSS sg13g2_tiehi
XFILLER_2_1407 VDD VSS sg13g2_decap_8
X_07714_ _07714_/Y _07740_/A _13293_/D VDD VSS sg13g2_nand2_1
XFILLER_39_986 VDD VSS sg13g2_decap_8
XFILLER_26_603 VDD VSS sg13g2_decap_8
XFILLER_122_49 VDD VSS sg13g2_decap_8
X_08694_ _08694_/Y _08380_/Y _08544_/B _08687_/X _08637_/B _08693_/Y VDD VSS sg13g2_a221oi_1
XFILLER_38_485 VDD VSS sg13g2_decap_8
XFILLER_96_1458 VDD VSS sg13g2_decap_8
XFILLER_183_1417 VDD VSS sg13g2_decap_8
X_07645_ _10297_/B _14793_/Q VDD VSS sg13g2_inv_1
XFILLER_96_1469 VDD VSS sg13g2_fill_2
XFILLER_0_1142 VDD VSS sg13g2_decap_8
XFILLER_54_989 VDD VSS sg13g2_decap_8
XFILLER_15_14 VDD VSS sg13g2_decap_8
XFILLER_81_775 VDD VSS sg13g2_decap_8
XFILLER_80_252 VDD VSS sg13g2_decap_8
XFILLER_13_308 VDD VSS sg13g2_decap_8
X_14935__2767 _14935_/RESET_B VDD VSS sg13g2_tiehi
XFILLER_179_630 VDD VSS sg13g2_decap_8
XFILLER_59_1291 VDD VSS sg13g2_fill_1
XFILLER_94_1182 VDD VSS sg13g2_decap_8
XFILLER_90_1024 VDD VSS sg13g2_decap_8
XFILLER_80_296 VDD VSS sg13g2_decap_4
XFILLER_181_1141 VDD VSS sg13g2_decap_8
X_09315_ _13922_/D _10145_/A1 _13922_/Q _09338_/S VDD VSS sg13g2_mux2_1
XFILLER_55_1144 VDD VSS sg13g2_fill_2
XFILLER_139_505 VDD VSS sg13g2_decap_8
XFILLER_146_1272 VDD VSS sg13g2_decap_8
XFILLER_178_140 VDD VSS sg13g2_decap_8
XFILLER_142_1114 VDD VSS sg13g2_fill_1
XFILLER_55_1166 VDD VSS sg13g2_fill_1
XFILLER_107_1245 VDD VSS sg13g2_fill_1
X_14338__1934 _14338_/RESET_B VDD VSS sg13g2_tiehi
XFILLER_16_1139 VDD VSS sg13g2_decap_8
XFILLER_167_847 VDD VSS sg13g2_decap_8
XFILLER_33_1420 VDD VSS sg13g2_decap_8
XFILLER_22_886 VDD VSS sg13g2_decap_8
X_09246_ _13855_/D _13855_/Q _10142_/A1 _09261_/S VDD VSS sg13g2_mux2_1
XFILLER_107_1278 VDD VSS sg13g2_decap_8
XFILLER_107_1289 VDD VSS sg13g2_fill_1
XFILLER_21_385 VDD VSS sg13g2_decap_8
XFILLER_21_396 VDD VSS sg13g2_fill_1
XFILLER_120_1412 VDD VSS sg13g2_fill_1
XFILLER_182_817 VDD VSS sg13g2_decap_8
XFILLER_31_35 VDD VSS sg13g2_decap_8
X_09177_ _13793_/D _13793_/Q _10144_/A1 _09201_/S VDD VSS sg13g2_mux2_1
XFILLER_108_925 VDD VSS sg13g2_fill_1
XFILLER_5_518 VDD VSS sg13g2_decap_8
XFILLER_107_413 VDD VSS sg13g2_fill_2
XFILLER_108_936 VDD VSS sg13g2_fill_1
XFILLER_120_1445 VDD VSS sg13g2_decap_4
XFILLER_147_35 VDD VSS sg13g2_decap_8
X_08128_ _08128_/X _08383_/A _08487_/A3 _08427_/A3 _08456_/B _08300_/S1 _07900_/B
+ VDD VSS sg13g2_mux4_1
XFILLER_147_593 VDD VSS sg13g2_fill_1
XFILLER_120_1478 VDD VSS sg13g2_fill_1
X_15113__2826 _15113_/RESET_B VDD VSS sg13g2_tiehi
X_08059_ _08059_/X _11706_/A _08427_/A3 _11661_/A _11726_/A _07627_/A _08048_/A VDD
+ VSS sg13g2_mux4_1
Xoutput46 mem_axi_araddr[17] _13708_/Q VDD VSS sg13g2_buf_1
XFILLER_27_1202 VDD VSS sg13g2_decap_8
XFILLER_1_735 VDD VSS sg13g2_decap_8
Xoutput57 mem_axi_araddr[28] _16881_/A VDD VSS sg13g2_buf_1
X_11070_ _11070_/Y _11151_/A _11069_/Y _11067_/Y VDD VSS sg13g2_a21oi_1
XFILLER_89_842 VDD VSS sg13g2_decap_8
XFILLER_122_449 VDD VSS sg13g2_decap_8
XFILLER_153_1221 VDD VSS sg13g2_decap_4
Xoutput68 mem_axi_araddr[9] output68/A VDD VSS sg13g2_buf_1
Xoutput79 mem_axi_awaddr[18] _16871_/X VDD VSS sg13g2_buf_1
Xhold3140 input2/A mem_axi_awready VDD VSS sg13g2_dlygate4sd3_1
XFILLER_0_245 VDD VSS sg13g2_decap_8
XFILLER_103_652 VDD VSS sg13g2_fill_2
XFILLER_163_56 VDD VSS sg13g2_decap_4
Xhold3151 input21/A mem_axi_rdata[25] VDD VSS sg13g2_dlygate4sd3_1
X_10021_ _14603_/D _10087_/A0 _14603_/Q _10027_/S VDD VSS sg13g2_mux2_1
XFILLER_88_352 VDD VSS sg13g2_fill_2
XFILLER_62_1126 VDD VSS sg13g2_decap_8
XFILLER_102_140 VDD VSS sg13g2_decap_8
Xhold3162 hold3162/X input28/X VDD VSS sg13g2_dlygate4sd3_1
XFILLER_76_503 VDD VSS sg13g2_decap_8
Xhold3173 hold3173/X input22/X VDD VSS sg13g2_dlygate4sd3_1
XFILLER_27_1279 VDD VSS sg13g2_decap_8
Xhold3184 input36/A mem_axi_rvalid VDD VSS sg13g2_dlygate4sd3_1
Xhold3195 _13624_/A _13732_/Q VDD VSS sg13g2_dlygate4sd3_1
X_13826__2446 _13826_/RESET_B VDD VSS sg13g2_tiehi
XFILLER_56_21 VDD VSS sg13g2_decap_4
X_14586__1686 _14586_/RESET_B VDD VSS sg13g2_tiehi
XFILLER_63_208 VDD VSS sg13g2_decap_8
XFILLER_5_1064 VDD VSS sg13g2_decap_8
X_14760_ _14760_/Q clkload82/A _14760_/D _14760_/RESET_B VDD VSS sg13g2_dfrbpq_1
X_11972_ _11973_/A _14704_/Q _14736_/Q _13776_/Q _13808_/Q _12040_/A1 _12038_/B1 VDD
+ VSS sg13g2_mux4_1
XFILLER_72_720 VDD VSS sg13g2_decap_8
X_13711_ _13711_/Q _14947_/CLK _13711_/D _13711_/RESET_B VDD VSS sg13g2_dfrbpq_1
XFILLER_17_658 VDD VSS sg13g2_fill_1
X_10923_ _10937_/B _10923_/A _10923_/B _10954_/A _10923_/D VDD VSS sg13g2_nor4_1
X_14691_ _14691_/Q _14723_/CLK _14691_/D _14691_/RESET_B VDD VSS sg13g2_dfrbpq_1
XFILLER_186_1074 VDD VSS sg13g2_decap_8
XFILLER_72_764 VDD VSS sg13g2_fill_1
XFILLER_45_978 VDD VSS sg13g2_decap_8
XFILLER_112_71 VDD VSS sg13g2_decap_8
XFILLER_16_168 VDD VSS sg13g2_decap_8
XFILLER_186_1085 VDD VSS sg13g2_decap_8
X_13642_ _13750_/D _13642_/A VDD VSS sg13g2_buf_1
XFILLER_60_937 VDD VSS sg13g2_decap_8
X_14206__2066 _14206_/RESET_B VDD VSS sg13g2_tiehi
X_10854_ _10865_/B _10870_/A _14752_/Q VDD VSS sg13g2_nand2_1
XFILLER_72_797 VDD VSS sg13g2_decap_4
XFILLER_38_1331 VDD VSS sg13g2_decap_8
XFILLER_72_53 VDD VSS sg13g2_fill_2
XFILLER_125_1312 VDD VSS sg13g2_decap_8
XFILLER_169_140 VDD VSS sg13g2_fill_2
X_13573_ _15156_/D _13570_/S _13571_/Y _13572_/Y VDD VSS sg13g2_a21oi_1
XFILLER_164_1383 VDD VSS sg13g2_decap_8
X_10785_ _10785_/Y _08933_/S _09148_/Y _08943_/Y VDD VSS sg13g2_o21ai_1
XFILLER_125_1345 VDD VSS sg13g2_decap_4
XFILLER_13_875 VDD VSS sg13g2_decap_8
XFILLER_8_301 VDD VSS sg13g2_decap_8
XFILLER_73_1288 VDD VSS sg13g2_decap_8
XFILLER_40_661 VDD VSS sg13g2_fill_2
X_12524_ _12524_/X _12520_/X _12519_/X _12516_/X _12515_/X _12732_/S0 _12720_/S VDD
+ VSS sg13g2_mux4_1
XFILLER_185_644 VDD VSS sg13g2_decap_8
XFILLER_12_385 VDD VSS sg13g2_decap_8
XFILLER_157_346 VDD VSS sg13g2_decap_8
XFILLER_9_868 VDD VSS sg13g2_decap_8
XFILLER_184_154 VDD VSS sg13g2_decap_8
X_15243_ _15243_/Q _15249_/CLK _15243_/D _15243_/RESET_B VDD VSS sg13g2_dfrbpq_1
X_12455_ _12455_/X _12454_/X _12453_/X _12776_/S VDD VSS sg13g2_mux2_1
XFILLER_8_378 VDD VSS sg13g2_decap_8
XFILLER_126_722 VDD VSS sg13g2_decap_8
XFILLER_172_338 VDD VSS sg13g2_decap_8
X_11406_ _11425_/C _11831_/B1 _11404_/Y _11405_/Y VDD VSS sg13g2_o21ai_1
X_15174_ _15174_/Q _15182_/CLK _15174_/D _15174_/RESET_B VDD VSS sg13g2_dfrbpq_1
X_12386_ _12386_/Y _12386_/A _12386_/B VDD VSS sg13g2_nand2_1
XFILLER_158_1132 VDD VSS sg13g2_decap_8
XFILLER_119_1105 VDD VSS sg13g2_decap_8
X_14125_ _14125_/Q _14669_/CLK _14125_/D _14125_/RESET_B VDD VSS sg13g2_dfrbpq_1
X_11337_ _11338_/B _12866_/A _15123_/Q _12836_/B _11290_/A VDD VSS sg13g2_a22oi_1
XFILLER_125_276 VDD VSS sg13g2_decap_8
Xclkbuf_leaf_122_clk_i clkload17/A clkbuf_5_4__f_clk_i/X VDD VSS sg13g2_buf_8
XFILLER_98_105 VDD VSS sg13g2_fill_2
XFILLER_140_202 VDD VSS sg13g2_decap_8
XFILLER_180_371 VDD VSS sg13g2_decap_8
XFILLER_153_596 VDD VSS sg13g2_decap_8
XFILLER_154_1018 VDD VSS sg13g2_decap_8
XFILLER_119_1149 VDD VSS sg13g2_decap_8
XFILLER_4_595 VDD VSS sg13g2_decap_8
XFILLER_113_449 VDD VSS sg13g2_fill_2
XFILLER_171_1310 VDD VSS sg13g2_fill_2
X_14056_ _14056_/Q clkload23/A _14056_/D _14056_/RESET_B VDD VSS sg13g2_dfrbpq_1
X_11268_ _11268_/Y _11267_/Y _11224_/A _12334_/C VDD VSS sg13g2_a21oi_1
X_13007_ _13058_/C _14907_/Q _13680_/Q VDD VSS sg13g2_nand2_1
X_10219_ _10219_/X _14767_/Q _14768_/Q VDD VSS sg13g2_and2_1
XFILLER_171_1365 VDD VSS sg13g2_decap_8
X_11199_ _11199_/Y _11181_/A _11199_/B VDD VSS sg13g2_nand2b_1
XFILLER_79_374 VDD VSS sg13g2_decap_8
XFILLER_67_514 VDD VSS sg13g2_decap_8
XFILLER_39_227 VDD VSS sg13g2_fill_1
XFILLER_39_249 VDD VSS sg13g2_fill_2
X_14416__1856 _14416_/RESET_B VDD VSS sg13g2_tiehi
XFILLER_36_912 VDD VSS sg13g2_decap_8
X_14958_ _14958_/Q clkload73/A _14958_/D _14958_/RESET_B VDD VSS sg13g2_dfrbpq_1
XFILLER_63_720 VDD VSS sg13g2_decap_8
XFILLER_48_794 VDD VSS sg13g2_decap_8
XFILLER_35_411 VDD VSS sg13g2_decap_8
XFILLER_130_1084 VDD VSS sg13g2_fill_1
XFILLER_63_731 VDD VSS sg13g2_fill_1
X_13909_ _13909_/Q _14741_/CLK _13909_/D _13909_/RESET_B VDD VSS sg13g2_dfrbpq_1
XFILLER_78_1144 VDD VSS sg13g2_fill_1
XFILLER_165_1103 VDD VSS sg13g2_decap_8
X_14889_ _14889_/Q _14890_/CLK _14889_/D _14889_/RESET_B VDD VSS sg13g2_dfrbpq_1
XFILLER_51_904 VDD VSS sg13g2_decap_8
XFILLER_74_1008 VDD VSS sg13g2_decap_8
XFILLER_62_241 VDD VSS sg13g2_decap_4
XFILLER_74_1019 VDD VSS sg13g2_decap_8
XFILLER_23_617 VDD VSS sg13g2_fill_1
XFILLER_22_105 VDD VSS sg13g2_decap_8
XFILLER_63_797 VDD VSS sg13g2_decap_8
XFILLER_50_414 VDD VSS sg13g2_decap_8
XFILLER_35_499 VDD VSS sg13g2_fill_1
XFILLER_23_639 VDD VSS sg13g2_fill_2
XFILLER_165_1169 VDD VSS sg13g2_decap_8
XFILLER_17_1404 VDD VSS sg13g2_decap_8
X_14631__1641 _14631_/RESET_B VDD VSS sg13g2_tiehi
XFILLER_91_1333 VDD VSS sg13g2_decap_8
XFILLER_143_1434 VDD VSS sg13g2_decap_4
X_09100_ _09100_/Y _15240_/Q _09147_/B VDD VSS sg13g2_nand2b_1
XFILLER_52_1328 VDD VSS sg13g2_decap_4
XFILLER_143_1456 VDD VSS sg13g2_decap_8
XFILLER_87_0 VDD VSS sg13g2_decap_8
X_09031_ _09031_/Y _09057_/A _09031_/B _09031_/C VDD VSS sg13g2_nor3_1
XFILLER_30_182 VDD VSS sg13g2_decap_8
XFILLER_175_154 VDD VSS sg13g2_decap_8
XFILLER_30_193 VDD VSS sg13g2_fill_2
XFILLER_102_1120 VDD VSS sg13g2_decap_8
XFILLER_15_1172 VDD VSS sg13g2_decap_8
XFILLER_157_880 VDD VSS sg13g2_decap_8
XFILLER_163_327 VDD VSS sg13g2_decap_4
XFILLER_116_210 VDD VSS sg13g2_decap_8
XFILLER_117_733 VDD VSS sg13g2_decap_8
XFILLER_7_70 VDD VSS sg13g2_decap_8
XFILLER_11_1036 VDD VSS sg13g2_decap_8
X_13904__2368 _13904_/RESET_B VDD VSS sg13g2_tiehi
XFILLER_156_390 VDD VSS sg13g2_decap_8
XFILLER_105_906 VDD VSS sg13g2_fill_1
XFILLER_144_563 VDD VSS sg13g2_decap_8
XFILLER_176_1243 VDD VSS sg13g2_decap_8
XFILLER_89_1295 VDD VSS sg13g2_decap_8
XFILLER_104_405 VDD VSS sg13g2_decap_8
XFILLER_116_265 VDD VSS sg13g2_decap_8
XFILLER_117_799 VDD VSS sg13g2_decap_4
XFILLER_131_202 VDD VSS sg13g2_decap_8
XFILLER_172_1107 VDD VSS sg13g2_decap_8
XFILLER_131_213 VDD VSS sg13g2_fill_2
XFILLER_172_1118 VDD VSS sg13g2_fill_2
XFILLER_132_758 VDD VSS sg13g2_decap_8
XFILLER_137_1249 VDD VSS sg13g2_fill_1
X_09933_ _14518_/D _14518_/Q _09933_/A1 _09935_/S VDD VSS sg13g2_mux2_1
Xfanout803 _08452_/D _08597_/B VDD VSS sg13g2_buf_1
XFILLER_89_149 VDD VSS sg13g2_decap_8
Xfanout814 _08234_/B _08138_/C VDD VSS sg13g2_buf_1
XFILLER_63_1424 VDD VSS sg13g2_decap_4
XFILLER_113_961 VDD VSS sg13g2_decap_8
Xfanout825 _08422_/S _08290_/S VDD VSS sg13g2_buf_1
XFILLER_131_268 VDD VSS sg13g2_decap_8
Xfanout836 _12355_/S _12705_/S1 VDD VSS sg13g2_buf_1
Xfanout847 _12761_/S1 _15213_/Q VDD VSS sg13g2_buf_1
X_09864_ _14451_/D _14451_/Q _10029_/A0 _09866_/S VDD VSS sg13g2_mux2_1
Xfanout858 _12369_/S0 _12747_/S1 VDD VSS sg13g2_buf_1
Xfanout869 _12604_/S1 fanout880/X VDD VSS sg13g2_buf_1
XFILLER_85_311 VDD VSS sg13g2_fill_2
XFILLER_150_1438 VDD VSS sg13g2_fill_2
XFILLER_97_182 VDD VSS sg13g2_decap_8
X_08815_ _13689_/D _08813_/Y _08812_/Y _08814_/Y VDD VSS sg13g2_a21oi_1
XFILLER_86_856 VDD VSS sg13g2_decap_8
XFILLER_58_547 VDD VSS sg13g2_fill_2
XFILLER_100_644 VDD VSS sg13g2_decap_8
X_09795_ _14384_/D _09927_/A1 _14384_/Q _09797_/S VDD VSS sg13g2_mux2_1
XFILLER_6_1351 VDD VSS sg13g2_decap_8
XFILLER_22_1121 VDD VSS sg13g2_decap_8
XFILLER_100_677 VDD VSS sg13g2_decap_8
XFILLER_85_366 VDD VSS sg13g2_decap_8
XFILLER_61_1181 VDD VSS sg13g2_decap_8
XFILLER_2_1204 VDD VSS sg13g2_decap_8
XFILLER_73_517 VDD VSS sg13g2_decap_8
X_08746_ _08746_/Y _13667_/Q _08775_/B VDD VSS sg13g2_nor2_1
XFILLER_73_528 VDD VSS sg13g2_fill_1
XFILLER_100_699 VDD VSS sg13g2_decap_4
XFILLER_66_580 VDD VSS sg13g2_fill_1
XFILLER_54_720 VDD VSS sg13g2_fill_2
X_15142__2766 _15142_/RESET_B VDD VSS sg13g2_tiehi
XFILLER_22_1198 VDD VSS sg13g2_decap_8
XFILLER_26_35 VDD VSS sg13g2_decap_8
X_08677_ _08697_/A _08662_/B _07847_/Y _07974_/C VDD VSS sg13g2_a21oi_1
XFILLER_57_1206 VDD VSS sg13g2_decap_8
XFILLER_53_230 VDD VSS sg13g2_decap_8
XFILLER_165_7 VDD VSS sg13g2_decap_8
XFILLER_53_241 VDD VSS sg13g2_fill_1
XFILLER_26_455 VDD VSS sg13g2_decap_8
XFILLER_81_561 VDD VSS sg13g2_decap_8
XFILLER_13_105 VDD VSS sg13g2_decap_8
X_07628_ _13609_/A _13602_/A VDD VSS sg13g2_inv_1
XFILLER_54_797 VDD VSS sg13g2_decap_8
XFILLER_42_937 VDD VSS sg13g2_fill_2
XFILLER_148_1378 VDD VSS sg13g2_decap_8
XFILLER_41_425 VDD VSS sg13g2_decap_8
XFILLER_186_419 VDD VSS sg13g2_decap_8
XFILLER_41_458 VDD VSS sg13g2_decap_8
XFILLER_10_812 VDD VSS sg13g2_decap_8
X_10570_ _10572_/C _10579_/B _10579_/C _10647_/C VDD VSS sg13g2_a21oi_1
XFILLER_42_56 VDD VSS sg13g2_decap_8
XFILLER_139_368 VDD VSS sg13g2_decap_8
XFILLER_166_154 VDD VSS sg13g2_decap_8
XFILLER_21_182 VDD VSS sg13g2_decap_8
XFILLER_6_805 VDD VSS sg13g2_decap_8
X_09229_ _13840_/D _09927_/A1 _13840_/Q _09231_/S VDD VSS sg13g2_mux2_1
XFILLER_167_699 VDD VSS sg13g2_fill_1
XFILLER_10_889 VDD VSS sg13g2_decap_8
XFILLER_5_315 VDD VSS sg13g2_decap_8
XFILLER_177_1029 VDD VSS sg13g2_decap_8
XFILLER_182_658 VDD VSS sg13g2_decap_8
X_12240_ _12240_/Y _12243_/A1 _14584_/Q VDD VSS sg13g2_nand2b_1
XFILLER_68_1302 VDD VSS sg13g2_decap_4
XFILLER_120_1253 VDD VSS sg13g2_decap_8
XFILLER_107_232 VDD VSS sg13g2_decap_8
XFILLER_108_755 VDD VSS sg13g2_decap_8
XFILLER_120_1264 VDD VSS sg13g2_fill_2
XFILLER_163_861 VDD VSS sg13g2_decap_8
XFILLER_120_1286 VDD VSS sg13g2_decap_8
XFILLER_181_168 VDD VSS sg13g2_decap_8
X_12171_ _12172_/A _13750_/Q _14102_/Q _14454_/Q _14550_/Q _12171_/S0 _12187_/C VDD
+ VSS sg13g2_mux4_1
XFILLER_123_714 VDD VSS sg13g2_decap_8
XFILLER_150_500 VDD VSS sg13g2_decap_8
X_11122_ _11123_/B _11119_/B _11063_/Y _11091_/B VDD VSS sg13g2_o21ai_1
XFILLER_174_77 VDD VSS sg13g2_decap_8
XFILLER_1_532 VDD VSS sg13g2_decap_8
XFILLER_123_769 VDD VSS sg13g2_decap_8
XFILLER_122_257 VDD VSS sg13g2_fill_1
XFILLER_3_28 VDD VSS sg13g2_decap_8
Xclkbuf_leaf_54_clk_i clkload71/A clkbuf_leaf_81_clk_i/A VDD VSS sg13g2_buf_8
X_11053_ _11053_/Y _11068_/C _11068_/A _11151_/A VDD VSS sg13g2_o21ai_1
XFILLER_107_82 VDD VSS sg13g2_decap_8
XFILLER_118_1160 VDD VSS sg13g2_decap_8
XFILLER_27_1054 VDD VSS sg13g2_fill_2
X_10004_ _10004_/Y _10004_/A _10004_/B _10004_/C _10070_/C VDD VSS sg13g2_nand4_1
XFILLER_7_1148 VDD VSS sg13g2_decap_8
XFILLER_27_1076 VDD VSS sg13g2_decap_8
XFILLER_153_1084 VDD VSS sg13g2_fill_2
XFILLER_92_804 VDD VSS sg13g2_decap_8
X_14812_ _14812_/Q clkload61/A _14812_/D _14812_/RESET_B VDD VSS sg13g2_dfrbpq_1
XFILLER_64_517 VDD VSS sg13g2_decap_8
XFILLER_91_325 VDD VSS sg13g2_fill_2
Xclkbuf_leaf_69_clk_i clkload79/A clkbuf_leaf_78_clk_i/A VDD VSS sg13g2_buf_8
XFILLER_83_30 VDD VSS sg13g2_decap_8
X_14743_ _14743_/Q _15017_/CLK _14743_/D _14743_/RESET_B VDD VSS sg13g2_dfrbpq_1
X_11955_ _11955_/Y _11955_/A _12029_/B VDD VSS sg13g2_nand2_1
XFILLER_75_1306 VDD VSS sg13g2_fill_2
XFILLER_17_455 VDD VSS sg13g2_decap_8
XFILLER_33_904 VDD VSS sg13g2_decap_8
XFILLER_75_1328 VDD VSS sg13g2_decap_8
X_10906_ _10948_/B _14756_/Q _10923_/B VDD VSS sg13g2_xor2_1
XFILLER_83_85 VDD VSS sg13g2_decap_8
X_14674_ _14674_/Q _14674_/CLK _14674_/D _14674_/RESET_B VDD VSS sg13g2_dfrbpq_1
X_11886_ _11886_/Y _11365_/A _14414_/Q _11366_/C VDD VSS sg13g2_a21oi_1
XFILLER_60_734 VDD VSS sg13g2_fill_2
XFILLER_33_959 VDD VSS sg13g2_decap_8
X_13625_ _13733_/D _13625_/A VDD VSS sg13g2_buf_1
X_10837_ _10849_/A _10837_/A _10850_/B VDD VSS sg13g2_nand2_1
XFILLER_125_1120 VDD VSS sg13g2_decap_8
XFILLER_160_1011 VDD VSS sg13g2_decap_4
XFILLER_13_672 VDD VSS sg13g2_decap_8
XFILLER_158_633 VDD VSS sg13g2_decap_8
XFILLER_164_1191 VDD VSS sg13g2_decap_8
X_13556_ _13556_/Y _08070_/B _13564_/A2 _13555_/Y VDD VSS sg13g2_a21oi_1
XFILLER_80_7 VDD VSS sg13g2_decap_8
XFILLER_185_441 VDD VSS sg13g2_decap_8
X_10768_ _11147_/A _14950_/Q _10767_/A _10767_/Y VDD VSS sg13g2_a21oi_1
XFILLER_118_508 VDD VSS sg13g2_decap_8
XFILLER_12_182 VDD VSS sg13g2_decap_8
XFILLER_146_828 VDD VSS sg13g2_decap_8
X_12507_ _12507_/X _14118_/Q _14150_/Q _14182_/Q _14214_/Q _12564_/S0 _12564_/S1 VDD
+ VSS sg13g2_mux4_1
XFILLER_9_665 VDD VSS sg13g2_decap_8
X_13487_ _13487_/Y _13654_/S _15173_/D _15175_/D _13502_/D VDD VSS sg13g2_nor4_1
XFILLER_12_1323 VDD VSS sg13g2_decap_8
XFILLER_145_327 VDD VSS sg13g2_decap_8
X_10699_ _10699_/Y _14902_/Q _10875_/B VDD VSS sg13g2_nand2_1
XFILLER_103_1451 VDD VSS sg13g2_decap_8
XFILLER_8_175 VDD VSS sg13g2_decap_8
X_15226_ _15226_/Q _15226_/CLK _15226_/D _15226_/RESET_B VDD VSS sg13g2_dfrbpq_1
XFILLER_173_658 VDD VSS sg13g2_decap_4
X_12438_ _12438_/X _14241_/Q _14273_/Q _14305_/Q _14337_/Q _12452_/S0 _12452_/S1 VDD
+ VSS sg13g2_mux4_1
XFILLER_161_809 VDD VSS sg13g2_decap_4
XFILLER_160_308 VDD VSS sg13g2_fill_1
XFILLER_172_168 VDD VSS sg13g2_decap_8
X_15157_ _15157_/Q _15216_/CLK _15157_/D _15157_/RESET_B VDD VSS sg13g2_dfrbpq_1
XFILLER_173_1405 VDD VSS sg13g2_fill_2
X_12369_ _12369_/X _12368_/X _12367_/X _12361_/X _12362_/X _12369_/S0 _12705_/S1 VDD
+ VSS sg13g2_mux4_1
XFILLER_99_414 VDD VSS sg13g2_decap_8
XFILLER_114_736 VDD VSS sg13g2_decap_8
XFILLER_5_882 VDD VSS sg13g2_decap_8
XFILLER_141_533 VDD VSS sg13g2_decap_8
X_14108_ _14108_/Q _14652_/CLK _14108_/D _14108_/RESET_B VDD VSS sg13g2_dfrbpq_1
X_13698__2574 _13698_/RESET_B VDD VSS sg13g2_tiehi
XFILLER_173_1449 VDD VSS sg13g2_decap_8
X_15088_ _15088_/Q clkload89/A _15088_/D _15088_/RESET_B VDD VSS sg13g2_dfrbpq_1
XFILLER_4_392 VDD VSS sg13g2_decap_8
X_14039_ _14039_/Q clkload47/A _14039_/D _14039_/RESET_B VDD VSS sg13g2_dfrbpq_1
XFILLER_84_1192 VDD VSS sg13g2_decap_4
XFILLER_110_920 VDD VSS sg13g2_fill_1
X_14649__1623 _14649_/RESET_B VDD VSS sg13g2_tiehi
XFILLER_67_322 VDD VSS sg13g2_decap_8
XFILLER_171_1173 VDD VSS sg13g2_decap_8
XFILLER_79_182 VDD VSS sg13g2_decap_8
XFILLER_41_1007 VDD VSS sg13g2_decap_8
XFILLER_110_953 VDD VSS sg13g2_fill_2
XFILLER_95_642 VDD VSS sg13g2_decap_8
XFILLER_94_130 VDD VSS sg13g2_decap_8
XFILLER_45_1198 VDD VSS sg13g2_fill_1
XFILLER_80_1089 VDD VSS sg13g2_decap_8
X_08600_ _08600_/Y _08668_/A _08659_/B _08600_/C _08600_/D VDD VSS sg13g2_nor4_1
X_14078__2194 _14078_/RESET_B VDD VSS sg13g2_tiehi
X_09580_ _14177_/D _14177_/Q _09613_/A0 _09601_/S VDD VSS sg13g2_mux2_1
XFILLER_23_1463 VDD VSS sg13g2_decap_8
XFILLER_94_185 VDD VSS sg13g2_decap_8
XFILLER_83_848 VDD VSS sg13g2_fill_1
XFILLER_167_1209 VDD VSS sg13g2_decap_8
XFILLER_94_196 VDD VSS sg13g2_fill_2
X_08531_ _08531_/Y _08577_/A _08531_/B VDD VSS sg13g2_nor2_1
XFILLER_36_742 VDD VSS sg13g2_fill_1
XFILLER_35_252 VDD VSS sg13g2_decap_8
XFILLER_24_926 VDD VSS sg13g2_decap_8
XFILLER_91_881 VDD VSS sg13g2_decap_8
XFILLER_35_263 VDD VSS sg13g2_fill_2
X_08462_ _15236_/D _08462_/A _08462_/B _08462_/C VDD VSS sg13g2_nand3_1
XFILLER_91_892 VDD VSS sg13g2_fill_1
XFILLER_36_797 VDD VSS sg13g2_decap_8
XFILLER_1_1281 VDD VSS sg13g2_decap_8
X_15017__2663 _15017_/RESET_B VDD VSS sg13g2_tiehi
XFILLER_149_600 VDD VSS sg13g2_decap_8
XFILLER_17_1201 VDD VSS sg13g2_decap_8
X_15084__2918 _15084_/RESET_B VDD VSS sg13g2_tiehi
X_08393_ _08393_/Y _08394_/B _08394_/C _08414_/C VDD VSS sg13g2_o21ai_1
XFILLER_11_609 VDD VSS sg13g2_decap_8
XFILLER_56_1272 VDD VSS sg13g2_fill_1
XFILLER_10_119 VDD VSS sg13g2_decap_8
XFILLER_148_121 VDD VSS sg13g2_decap_8
XFILLER_149_644 VDD VSS sg13g2_decap_8
XFILLER_91_1185 VDD VSS sg13g2_decap_8
XFILLER_176_441 VDD VSS sg13g2_decap_8
XFILLER_52_1147 VDD VSS sg13g2_decap_8
XFILLER_143_1275 VDD VSS sg13g2_fill_1
XFILLER_17_1278 VDD VSS sg13g2_decap_8
XFILLER_137_828 VDD VSS sg13g2_decap_8
XFILLER_178_1305 VDD VSS sg13g2_fill_2
XFILLER_104_1259 VDD VSS sg13g2_fill_2
XFILLER_148_198 VDD VSS sg13g2_decap_8
XFILLER_164_647 VDD VSS sg13g2_decap_8
X_09014_ _13763_/D _13763_/Q _10079_/A0 _09160_/S VDD VSS sg13g2_mux2_1
XFILLER_3_819 VDD VSS sg13g2_decap_8
XFILLER_105_725 VDD VSS sg13g2_decap_8
XFILLER_137_1002 VDD VSS sg13g2_fill_2
XFILLER_176_1051 VDD VSS sg13g2_decap_8
XFILLER_160_831 VDD VSS sg13g2_decap_4
XFILLER_2_329 VDD VSS sg13g2_decap_8
XFILLER_105_747 VDD VSS sg13g2_fill_2
XFILLER_132_544 VDD VSS sg13g2_decap_8
XFILLER_144_14 VDD VSS sg13g2_decap_8
X_14288__1984 _14288_/RESET_B VDD VSS sg13g2_tiehi
XFILLER_132_566 VDD VSS sg13g2_decap_8
XFILLER_160_875 VDD VSS sg13g2_decap_8
Xfanout600 _13600_/A _13608_/A1 VDD VSS sg13g2_buf_1
Xfanout611 _08675_/A1 _08035_/X VDD VSS sg13g2_buf_1
XFILLER_59_801 VDD VSS sg13g2_decap_8
XFILLER_28_1341 VDD VSS sg13g2_decap_8
XFILLER_144_47 VDD VSS sg13g2_decap_8
Xfanout622 _13140_/B2 _13275_/B1 VDD VSS sg13g2_buf_1
X_09916_ _14501_/D _14501_/Q _09916_/A1 _09929_/S VDD VSS sg13g2_mux2_1
Xfanout633 _12122_/A2 _11792_/B VDD VSS sg13g2_buf_1
Xfanout644 _10875_/B _13294_/B VDD VSS sg13g2_buf_1
XFILLER_8_1435 VDD VSS sg13g2_decap_8
XFILLER_101_931 VDD VSS sg13g2_decap_8
XFILLER_58_311 VDD VSS sg13g2_decap_8
Xfanout655 _10740_/A1 _08903_/S VDD VSS sg13g2_buf_1
XFILLER_98_491 VDD VSS sg13g2_fill_1
Xfanout666 _10694_/S _08837_/X VDD VSS sg13g2_buf_1
XFILLER_59_856 VDD VSS sg13g2_decap_8
Xfanout677 _08825_/C1 _08724_/Y VDD VSS sg13g2_buf_1
X_09847_ _14434_/D _14434_/Q _10078_/A0 _09866_/S VDD VSS sg13g2_mux2_1
Xfanout688 _08692_/A _07996_/X VDD VSS sg13g2_buf_1
XFILLER_100_452 VDD VSS sg13g2_decap_8
XFILLER_115_1377 VDD VSS sg13g2_decap_8
Xfanout699 _12707_/C1 _12749_/C1 VDD VSS sg13g2_buf_1
XFILLER_98_1328 VDD VSS sg13g2_decap_8
XFILLER_58_377 VDD VSS sg13g2_decap_8
XFILLER_73_314 VDD VSS sg13g2_decap_8
XFILLER_2_1001 VDD VSS sg13g2_decap_8
X_09778_ _14367_/D _10109_/A0 _14367_/Q _09805_/S VDD VSS sg13g2_mux2_1
XFILLER_37_56 VDD VSS sg13g2_decap_8
XFILLER_100_496 VDD VSS sg13g2_decap_8
XFILLER_160_35 VDD VSS sg13g2_decap_8
XFILLER_27_742 VDD VSS sg13g2_decap_8
X_08729_ _08729_/Y _13345_/B _11203_/A1 _08727_/X _13448_/B _13490_/B VDD VSS sg13g2_a221oi_1
XFILLER_26_230 VDD VSS sg13g2_fill_2
XFILLER_42_701 VDD VSS sg13g2_decap_8
XFILLER_2_1078 VDD VSS sg13g2_decap_8
XFILLER_27_775 VDD VSS sg13g2_decap_8
X_11740_ _11742_/A _11741_/A _14634_/Q VDD VSS sg13g2_nand2b_1
XFILLER_96_1074 VDD VSS sg13g2_decap_8
XFILLER_15_948 VDD VSS sg13g2_decap_8
XFILLER_42_734 VDD VSS sg13g2_decap_8
XFILLER_18_1009 VDD VSS sg13g2_fill_2
XFILLER_41_233 VDD VSS sg13g2_decap_8
XFILLER_14_469 VDD VSS sg13g2_decap_8
X_11671_ _11671_/X _11671_/A _12253_/B VDD VSS sg13g2_and2_1
XFILLER_109_1159 VDD VSS sg13g2_decap_8
XFILLER_53_88 VDD VSS sg13g2_decap_8
XFILLER_35_1323 VDD VSS sg13g2_decap_8
X_13410_ _13421_/B _15194_/Q _15195_/Q _15196_/Q _15197_/Q VDD VSS sg13g2_nor4_1
XFILLER_70_1214 VDD VSS sg13g2_decap_8
X_13776__2496 _13776_/RESET_B VDD VSS sg13g2_tiehi
X_10622_ _10636_/A _14882_/Q _10651_/D _10622_/C VDD VSS sg13g2_nand3_1
XFILLER_169_77 VDD VSS sg13g2_decap_8
X_14390_ _14390_/Q _14518_/CLK _14390_/D _14390_/RESET_B VDD VSS sg13g2_dfrbpq_1
XFILLER_122_1315 VDD VSS sg13g2_fill_1
XFILLER_161_1375 VDD VSS sg13g2_decap_8
XFILLER_31_1209 VDD VSS sg13g2_decap_8
XFILLER_128_828 VDD VSS sg13g2_decap_8
XFILLER_155_614 VDD VSS sg13g2_fill_1
X_13341_ _13341_/Y _13341_/A _15174_/D VDD VSS sg13g2_nor2b_1
XFILLER_122_1348 VDD VSS sg13g2_decap_8
XFILLER_128_839 VDD VSS sg13g2_decap_8
X_10553_ _10555_/B _14866_/Q _14865_/Q _10556_/D VDD VSS sg13g2_nand3_1
XFILLER_6_602 VDD VSS sg13g2_decap_8
XFILLER_154_102 VDD VSS sg13g2_decap_8
X_14727__1545 _14727_/RESET_B VDD VSS sg13g2_tiehi
XFILLER_10_686 VDD VSS sg13g2_decap_8
XFILLER_185_21 VDD VSS sg13g2_decap_8
XFILLER_127_349 VDD VSS sg13g2_decap_8
XFILLER_5_112 VDD VSS sg13g2_decap_8
X_13272_ _13272_/X input28/X _13272_/A2 _13049_/X VDD VSS sg13g2_a21o_1
XFILLER_33_1091 VDD VSS sg13g2_decap_8
XFILLER_182_455 VDD VSS sg13g2_decap_8
X_10484_ _10495_/D _14849_/Q _10489_/C _14847_/Q _10484_/D VDD VSS sg13g2_and4_1
XFILLER_136_861 VDD VSS sg13g2_decap_8
X_15011_ _15011_/Q clkload42/A _15011_/D _15011_/RESET_B VDD VSS sg13g2_dfrbpq_1
XFILLER_6_679 VDD VSS sg13g2_decap_8
X_12223_ _12223_/X _12223_/A _12223_/B _12223_/C VDD VSS sg13g2_or3_1
XFILLER_108_574 VDD VSS sg13g2_decap_8
XFILLER_123_511 VDD VSS sg13g2_decap_8
XFILLER_185_98 VDD VSS sg13g2_decap_8
X_13991__2281 _13991_/RESET_B VDD VSS sg13g2_tiehi
XFILLER_5_189 VDD VSS sg13g2_decap_8
XFILLER_78_30 VDD VSS sg13g2_fill_2
XFILLER_68_1176 VDD VSS sg13g2_decap_8
XFILLER_29_1127 VDD VSS sg13g2_decap_8
XFILLER_151_853 VDD VSS sg13g2_decap_8
X_12154_ _12156_/B _12155_/A _12155_/B _12198_/D VDD VSS sg13g2_a21o_1
XFILLER_64_1018 VDD VSS sg13g2_decap_8
XFILLER_29_1138 VDD VSS sg13g2_fill_1
XFILLER_150_341 VDD VSS sg13g2_decap_8
XFILLER_68_1198 VDD VSS sg13g2_decap_8
XFILLER_151_875 VDD VSS sg13g2_decap_4
X_11105_ _11105_/Y _11125_/A _10759_/X _11118_/D VDD VSS sg13g2_a21oi_1
XFILLER_78_74 VDD VSS sg13g2_decap_8
XFILLER_133_1400 VDD VSS sg13g2_decap_8
XFILLER_81_1332 VDD VSS sg13g2_decap_8
XFILLER_111_739 VDD VSS sg13g2_fill_2
X_12085_ _12086_/B _12061_/A _13190_/B _12063_/Y VDD VSS sg13g2_a21oi_1
XFILLER_2_896 VDD VSS sg13g2_decap_8
XFILLER_172_1471 VDD VSS sg13g2_decap_4
XFILLER_104_791 VDD VSS sg13g2_decap_4
X_11036_ _11036_/Y _11023_/A _11040_/A _11034_/Y _11022_/B VDD VSS sg13g2_a22oi_1
XFILLER_65_804 VDD VSS sg13g2_decap_4
XFILLER_42_1349 VDD VSS sg13g2_decap_8
XFILLER_37_506 VDD VSS sg13g2_decap_8
XFILLER_49_388 VDD VSS sg13g2_fill_1
XFILLER_92_634 VDD VSS sg13g2_decap_8
XFILLER_91_111 VDD VSS sg13g2_decap_8
XFILLER_40_1040 VDD VSS sg13g2_decap_8
XFILLER_94_95 VDD VSS sg13g2_decap_8
XFILLER_40_1084 VDD VSS sg13g2_decap_8
X_12987_ _12987_/Y _12988_/C _12988_/D VDD VSS sg13g2_nor2_1
XFILLER_17_252 VDD VSS sg13g2_decap_8
XFILLER_18_775 VDD VSS sg13g2_decap_8
XFILLER_45_561 VDD VSS sg13g2_fill_2
X_14726_ _14726_/Q _14726_/CLK _14726_/D _14726_/RESET_B VDD VSS sg13g2_dfrbpq_1
XFILLER_73_881 VDD VSS sg13g2_decap_8
X_11938_ _11938_/Y _11937_/Y _12055_/B _11664_/A VDD VSS sg13g2_a21oi_1
XFILLER_45_594 VDD VSS sg13g2_fill_1
XFILLER_60_531 VDD VSS sg13g2_fill_2
XFILLER_162_1117 VDD VSS sg13g2_decap_4
X_14657_ _14657_/Q clkload38/A _14657_/D _14657_/RESET_B VDD VSS sg13g2_dfrbpq_1
X_11869_ _11869_/Y _11874_/S0 _13838_/Q VDD VSS sg13g2_nand2b_1
XFILLER_33_778 VDD VSS sg13g2_decap_8
XFILLER_33_789 VDD VSS sg13g2_fill_2
XFILLER_177_238 VDD VSS sg13g2_decap_8
X_13608_ _13608_/Y _13608_/A1 _08834_/B hold3230/X VDD VSS sg13g2_a21oi_1
XFILLER_32_277 VDD VSS sg13g2_decap_8
XFILLER_158_430 VDD VSS sg13g2_decap_8
XFILLER_14_1407 VDD VSS sg13g2_decap_8
X_14588_ _14588_/Q _14652_/CLK _14588_/D _14588_/RESET_B VDD VSS sg13g2_dfrbpq_1
XFILLER_186_761 VDD VSS sg13g2_decap_8
XFILLER_53_1467 VDD VSS sg13g2_decap_8
XFILLER_53_1478 VDD VSS sg13g2_fill_1
XFILLER_140_1437 VDD VSS sg13g2_fill_1
XFILLER_174_923 VDD VSS sg13g2_decap_8
X_13539_ _13539_/Y _13539_/A _13547_/B VDD VSS sg13g2_nor2_1
XFILLER_9_462 VDD VSS sg13g2_decap_8
XFILLER_12_1120 VDD VSS sg13g2_decap_8
XFILLER_173_422 VDD VSS sg13g2_decap_8
XFILLER_134_809 VDD VSS sg13g2_decap_8
XFILLER_51_1191 VDD VSS sg13g2_decap_8
X_15209_ _15209_/Q clkload88/A _15209_/D _15209_/RESET_B VDD VSS sg13g2_dfrbpq_1
XFILLER_86_1221 VDD VSS sg13g2_decap_4
XFILLER_133_319 VDD VSS sg13g2_decap_8
XFILLER_160_105 VDD VSS sg13g2_decap_8
XFILLER_173_499 VDD VSS sg13g2_decap_8
XFILLER_12_1197 VDD VSS sg13g2_decap_8
X_13821__2451 _13821_/RESET_B VDD VSS sg13g2_tiehi
X_14581__1691 _14581_/RESET_B VDD VSS sg13g2_tiehi
XFILLER_114_533 VDD VSS sg13g2_decap_8
XFILLER_142_842 VDD VSS sg13g2_fill_2
XFILLER_114_544 VDD VSS sg13g2_fill_2
XFILLER_173_1235 VDD VSS sg13g2_fill_1
XFILLER_88_918 VDD VSS sg13g2_decap_8
XFILLER_102_706 VDD VSS sg13g2_decap_4
XFILLER_114_566 VDD VSS sg13g2_decap_8
XFILLER_99_277 VDD VSS sg13g2_decap_8
XFILLER_59_108 VDD VSS sg13g2_fill_2
XFILLER_101_205 VDD VSS sg13g2_decap_8
XFILLER_102_739 VDD VSS sg13g2_decap_8
X_07962_ _07962_/Y _15014_/Q _07859_/B VDD VSS sg13g2_nor2b_1
XFILLER_68_620 VDD VSS sg13g2_fill_1
X_14165__2107 _14165_/RESET_B VDD VSS sg13g2_tiehi
X_09701_ _14293_/D _09899_/A0 _14293_/Q _09705_/S VDD VSS sg13g2_mux2_1
XFILLER_60_1416 VDD VSS sg13g2_decap_8
X_07893_ _07893_/Y _08138_/C _08142_/C VDD VSS sg13g2_nand2_1
X_14201__2071 _14201_/RESET_B VDD VSS sg13g2_tiehi
XFILLER_96_995 VDD VSS sg13g2_decap_8
XFILLER_28_517 VDD VSS sg13g2_decap_8
X_09632_ _14228_/D _10096_/A0 _14228_/Q _09632_/S VDD VSS sg13g2_mux2_1
XFILLER_95_494 VDD VSS sg13g2_decap_8
XFILLER_56_859 VDD VSS sg13g2_decap_4
XFILLER_23_1260 VDD VSS sg13g2_decap_8
XFILLER_110_1230 VDD VSS sg13g2_decap_8
X_09563_ _14161_/D _09596_/A1 _14161_/Q _09563_/S VDD VSS sg13g2_mux2_1
XFILLER_3_1365 VDD VSS sg13g2_decap_8
XFILLER_97_1372 VDD VSS sg13g2_decap_8
XFILLER_24_701 VDD VSS sg13g2_decap_8
X_08514_ _08514_/Y _08514_/A wire681/X VDD VSS sg13g2_nor2_1
XFILLER_64_881 VDD VSS sg13g2_decap_8
XFILLER_93_1225 VDD VSS sg13g2_decap_8
X_09494_ _14094_/D _10024_/A0 _14094_/Q _09506_/S VDD VSS sg13g2_mux2_1
XFILLER_63_391 VDD VSS sg13g2_fill_2
XFILLER_180_1206 VDD VSS sg13g2_decap_8
XFILLER_184_1375 VDD VSS sg13g2_decap_4
XFILLER_19_1329 VDD VSS sg13g2_decap_8
X_08445_ _08445_/Y _07798_/X _07826_/X _07799_/X VDD VSS sg13g2_a21oi_1
XFILLER_169_739 VDD VSS sg13g2_decap_4
XFILLER_11_406 VDD VSS sg13g2_decap_8
XFILLER_23_14 VDD VSS sg13g2_decap_8
XFILLER_168_249 VDD VSS sg13g2_decap_8
X_08376_ _08376_/X _08383_/A _07790_/A _07782_/A _07786_/A _08686_/S0 _13510_/A1 VDD
+ VSS sg13g2_mux4_1
XFILLER_139_14 VDD VSS sg13g2_decap_8
X_14972__2708 _14972_/RESET_B VDD VSS sg13g2_tiehi
XFILLER_17_1075 VDD VSS sg13g2_decap_8
XFILLER_177_794 VDD VSS sg13g2_fill_2
XFILLER_109_327 VDD VSS sg13g2_decap_4
XFILLER_128_7 VDD VSS sg13g2_decap_8
XFILLER_136_102 VDD VSS sg13g2_decap_4
XFILLER_137_636 VDD VSS sg13g2_decap_8
XFILLER_178_1102 VDD VSS sg13g2_decap_4
XFILLER_149_496 VDD VSS sg13g2_decap_8
XFILLER_99_18 VDD VSS sg13g2_fill_2
XFILLER_109_349 VDD VSS sg13g2_decap_8
XFILLER_165_978 VDD VSS sg13g2_decap_8
XFILLER_121_1370 VDD VSS sg13g2_decap_8
XFILLER_139_1108 VDD VSS sg13g2_decap_8
XFILLER_164_477 VDD VSS sg13g2_decap_8
XFILLER_180_926 VDD VSS sg13g2_decap_8
XFILLER_3_616 VDD VSS sg13g2_decap_8
XFILLER_156_1400 VDD VSS sg13g2_decap_8
XFILLER_155_35 VDD VSS sg13g2_decap_8
XFILLER_65_1305 VDD VSS sg13g2_fill_2
XFILLER_117_393 VDD VSS sg13g2_decap_8
XFILLER_133_842 VDD VSS sg13g2_decap_8
X_14411__1861 _14411_/RESET_B VDD VSS sg13g2_tiehi
XFILLER_2_126 VDD VSS sg13g2_decap_8
XFILLER_144_190 VDD VSS sg13g2_decap_8
X_15040__2638 _15040_/RESET_B VDD VSS sg13g2_tiehi
Xpicorv32_macro_1513 mem_axi_awprot[0] VDD VSS sg13g2_tielo
XFILLER_78_406 VDD VSS sg13g2_decap_8
Xfanout1406 _12232_/S _12235_/A VDD VSS sg13g2_buf_1
Xfanout1417 _11821_/S0 _11819_/A1 VDD VSS sg13g2_buf_1
XFILLER_78_439 VDD VSS sg13g2_decap_8
XFILLER_59_620 VDD VSS sg13g2_decap_8
Xfanout430 _10043_/A0 _10076_/A0 VDD VSS sg13g2_buf_1
Xfanout1428 _11226_/S0 fanout1429/X VDD VSS sg13g2_buf_1
XFILLER_8_1232 VDD VSS sg13g2_decap_8
XFILLER_120_547 VDD VSS sg13g2_decap_8
Xfanout441 _09160_/S _09059_/S VDD VSS sg13g2_buf_1
Xfanout1439 _12098_/A1 fanout1440/X VDD VSS sg13g2_buf_1
Xfanout452 _12791_/B2 _12386_/A VDD VSS sg13g2_buf_1
Xfanout463 _10027_/S _10036_/S VDD VSS sg13g2_buf_1
XFILLER_28_1193 VDD VSS sg13g2_decap_8
XFILLER_63_1084 VDD VSS sg13g2_decap_8
Xfanout474 _10002_/S _09971_/Y VDD VSS sg13g2_buf_1
XFILLER_58_141 VDD VSS sg13g2_decap_8
XFILLER_171_56 VDD VSS sg13g2_decap_8
Xfanout485 _09665_/S _09671_/S VDD VSS sg13g2_buf_1
XFILLER_98_1103 VDD VSS sg13g2_decap_8
XFILLER_48_77 VDD VSS sg13g2_decap_8
X_12910_ _12910_/Y _12910_/A _12909_/Y VDD VSS sg13g2_nor2b_1
Xfanout496 _09530_/S _09537_/S VDD VSS sg13g2_buf_1
XFILLER_150_1076 VDD VSS sg13g2_decap_8
X_13890_ _13890_/Q clkload45/A _13890_/D _13890_/RESET_B VDD VSS sg13g2_dfrbpq_1
XFILLER_150_1087 VDD VSS sg13g2_fill_1
X_12841_ _12845_/A input29/X _12841_/B VDD VSS sg13g2_nand2_1
XFILLER_64_21 VDD VSS sg13g2_decap_8
XFILLER_46_358 VDD VSS sg13g2_decap_8
XFILLER_55_870 VDD VSS sg13g2_decap_8
XFILLER_27_561 VDD VSS sg13g2_decap_4
XFILLER_73_188 VDD VSS sg13g2_decap_8
X_12772_ _12772_/X _14393_/Q _14425_/Q _14489_/Q _14521_/Q _12773_/S0 _12773_/S1 VDD
+ VSS sg13g2_mux4_1
XFILLER_27_594 VDD VSS sg13g2_decap_8
X_13863__2409 _13863_/RESET_B VDD VSS sg13g2_tiehi
XFILLER_54_391 VDD VSS sg13g2_decap_8
XFILLER_154_0 VDD VSS sg13g2_decap_8
XFILLER_15_756 VDD VSS sg13g2_decap_8
XFILLER_163_1415 VDD VSS sg13g2_fill_1
X_14511_ _14511_/Q _14610_/CLK _14511_/D _14511_/RESET_B VDD VSS sg13g2_dfrbpq_1
XFILLER_37_1418 VDD VSS sg13g2_decap_8
X_11723_ _14971_/D _11706_/A _11723_/A2 _11722_/Y VDD VSS sg13g2_a21o_1
XFILLER_14_266 VDD VSS sg13g2_decap_8
XFILLER_9_49 VDD VSS sg13g2_decap_8
X_14442_ _14442_/Q clkload19/A _14442_/D _14442_/RESET_B VDD VSS sg13g2_dfrbpq_1
X_11654_ _11654_/X _11652_/X _11653_/X _11654_/S VDD VSS sg13g2_mux2_1
XFILLER_70_1022 VDD VSS sg13g2_decap_8
XFILLER_161_1150 VDD VSS sg13g2_decap_8
XFILLER_70_1033 VDD VSS sg13g2_fill_1
XFILLER_128_603 VDD VSS sg13g2_fill_1
XFILLER_161_1161 VDD VSS sg13g2_fill_2
X_10605_ _10652_/A _14878_/Q _14877_/Q _14876_/Q _14875_/Q VDD VSS sg13g2_nand4_1
XFILLER_168_783 VDD VSS sg13g2_decap_8
X_14373_ _14373_/Q clkload14/A _14373_/D _14373_/RESET_B VDD VSS sg13g2_dfrbpq_1
XFILLER_11_973 VDD VSS sg13g2_decap_8
XFILLER_155_411 VDD VSS sg13g2_decap_8
X_11585_ wire274/A _11975_/A _11583_/X _11584_/Y VDD VSS sg13g2_o21ai_1
XFILLER_127_113 VDD VSS sg13g2_decap_8
XFILLER_70_1077 VDD VSS sg13g2_decap_8
XFILLER_35_1197 VDD VSS sg13g2_fill_2
X_14243__2029 _14243_/RESET_B VDD VSS sg13g2_tiehi
X_13324_ _15065_/D _13324_/A _13324_/B VDD VSS sg13g2_nor2_1
Xwire853 wire853/X wire853/A VDD VSS sg13g2_buf_8
XFILLER_10_483 VDD VSS sg13g2_decap_8
X_10536_ _10543_/D _14861_/Q _14860_/Q _14859_/Q _10558_/B VDD VSS sg13g2_and4_1
XFILLER_13_91 VDD VSS sg13g2_decap_8
XFILLER_171_904 VDD VSS sg13g2_fill_1
XFILLER_7_966 VDD VSS sg13g2_decap_8
XFILLER_171_915 VDD VSS sg13g2_decap_8
XFILLER_182_252 VDD VSS sg13g2_decap_8
XFILLER_115_308 VDD VSS sg13g2_decap_8
XFILLER_127_168 VDD VSS sg13g2_decap_8
XFILLER_127_179 VDD VSS sg13g2_fill_2
XFILLER_143_628 VDD VSS sg13g2_decap_8
XFILLER_155_488 VDD VSS sg13g2_decap_8
X_13255_ _13255_/Y _14923_/Q _13664_/Q _13245_/X VDD VSS sg13g2_a21oi_1
XFILLER_6_476 VDD VSS sg13g2_decap_8
X_10467_ _10468_/C _10500_/A _10471_/C _10471_/D VDD VSS sg13g2_and3_1
XFILLER_100_1454 VDD VSS sg13g2_fill_1
XFILLER_124_831 VDD VSS sg13g2_decap_8
XFILLER_142_127 VDD VSS sg13g2_decap_8
XFILLER_171_959 VDD VSS sg13g2_decap_8
X_12206_ _12206_/X _14391_/Q _14423_/Q _14487_/Q _14519_/Q _12213_/S0 _12169_/C VDD
+ VSS sg13g2_mux4_1
XFILLER_123_330 VDD VSS sg13g2_decap_8
X_13186_ _13186_/X _13190_/A _13190_/B _13225_/B VDD VSS sg13g2_a21o_1
XFILLER_43_7 VDD VSS sg13g2_decap_8
X_10398_ _10400_/D _14820_/Q _14821_/Q _14822_/Q _10398_/D VDD VSS sg13g2_nand4_1
XFILLER_124_886 VDD VSS sg13g2_fill_1
XFILLER_9_1029 VDD VSS sg13g2_decap_8
XFILLER_111_514 VDD VSS sg13g2_decap_8
XFILLER_150_160 VDD VSS sg13g2_decap_8
X_12137_ _12137_/X _14261_/Q _14293_/Q _14325_/Q _14357_/Q _12138_/S0 _12138_/S1 VDD
+ VSS sg13g2_mux4_1
XFILLER_46_1260 VDD VSS sg13g2_decap_8
XFILLER_2_693 VDD VSS sg13g2_decap_8
XFILLER_96_247 VDD VSS sg13g2_fill_1
XFILLER_78_951 VDD VSS sg13g2_decap_8
X_12068_ _12068_/X _14387_/Q _14419_/Q _14483_/Q _14515_/Q _12186_/A _12073_/S1 VDD
+ VSS sg13g2_mux4_1
XFILLER_49_130 VDD VSS sg13g2_fill_1
XFILLER_77_450 VDD VSS sg13g2_decap_8
XFILLER_49_152 VDD VSS sg13g2_decap_8
X_11019_ _11019_/Y _11082_/A1 _11042_/D _11056_/B1 VDD VSS sg13g2_o21ai_1
XFILLER_38_837 VDD VSS sg13g2_decap_8
X_16876_ _16876_/X _16876_/A VDD VSS sg13g2_buf_1
XFILLER_168_1315 VDD VSS sg13g2_fill_1
XFILLER_92_453 VDD VSS sg13g2_decap_8
XFILLER_53_818 VDD VSS sg13g2_decap_8
XFILLER_20_1455 VDD VSS sg13g2_decap_8
XFILLER_80_637 VDD VSS sg13g2_decap_4
XFILLER_52_339 VDD VSS sg13g2_decap_8
X_14453__1819 _14453_/RESET_B VDD VSS sg13g2_tiehi
XFILLER_127_1023 VDD VSS sg13g2_decap_8
X_13839__2433 _13839_/RESET_B VDD VSS sg13g2_tiehi
X_14709_ _14709_/Q _14741_/CLK _14709_/D _14709_/RESET_B VDD VSS sg13g2_dfrbpq_1
XFILLER_178_525 VDD VSS sg13g2_decap_8
X_14599__1673 _14599_/RESET_B VDD VSS sg13g2_tiehi
XFILLER_61_873 VDD VSS sg13g2_decap_8
XFILLER_20_203 VDD VSS sg13g2_decap_8
X_08230_ _08230_/Y _08248_/A _08227_/Y _08229_/Y VDD VSS sg13g2_o21ai_1
XFILLER_147_901 VDD VSS sg13g2_decap_8
XFILLER_21_759 VDD VSS sg13g2_decap_8
XFILLER_105_1321 VDD VSS sg13g2_decap_8
XFILLER_14_1204 VDD VSS sg13g2_decap_8
XFILLER_165_208 VDD VSS sg13g2_decap_8
X_08161_ _08182_/C _08843_/A _08142_/B _14959_/Q _13525_/A _08113_/Y VDD VSS sg13g2_a221oi_1
XFILLER_119_625 VDD VSS sg13g2_decap_8
XFILLER_144_1392 VDD VSS sg13g2_decap_8
XFILLER_179_1400 VDD VSS sg13g2_decap_8
XFILLER_18_1395 VDD VSS sg13g2_decap_8
XFILLER_179_1411 VDD VSS sg13g2_fill_2
XFILLER_53_1286 VDD VSS sg13g2_decap_8
XFILLER_174_742 VDD VSS sg13g2_decap_8
XFILLER_146_444 VDD VSS sg13g2_decap_8
X_08092_ _08092_/Y _07879_/Y _08091_/Y _08588_/B VDD VSS sg13g2_o21ai_1
X_14219__2053 _14219_/RESET_B VDD VSS sg13g2_tiehi
XFILLER_173_252 VDD VSS sg13g2_decap_8
Xclkload40 clkload40/Y clkload40/A VDD VSS sg13g2_inv_1
XFILLER_161_414 VDD VSS sg13g2_decap_8
Xclkload51 clkload51/Y clkload51/A VDD VSS sg13g2_inv_1
XFILLER_162_948 VDD VSS sg13g2_decap_4
Xclkload62 clkload62/Y clkload62/A VDD VSS sg13g2_inv_1
Xmax_cap1281 _16877_/A _13715_/Q VDD VSS sg13g2_buf_4
XFILLER_161_436 VDD VSS sg13g2_fill_2
Xclkload73 clkload73/Y clkload73/A VDD VSS sg13g2_inv_2
Xmax_cap1292 output42/A _16866_/A VDD VSS sg13g2_buf_4
XFILLER_115_831 VDD VSS sg13g2_fill_1
XFILLER_127_691 VDD VSS sg13g2_decap_8
Xclkload84 clkload84/Y clkload84/A VDD VSS sg13g2_inv_2
XFILLER_86_1051 VDD VSS sg13g2_decap_8
XFILLER_173_1032 VDD VSS sg13g2_fill_2
XFILLER_115_897 VDD VSS sg13g2_decap_4
XFILLER_134_1005 VDD VSS sg13g2_fill_1
X_08994_ _09011_/D _14899_/Q _12859_/A _10681_/A _10674_/A VDD VSS sg13g2_nand4_1
XFILLER_134_1038 VDD VSS sg13g2_decap_4
XFILLER_102_547 VDD VSS sg13g2_decap_8
XFILLER_173_1098 VDD VSS sg13g2_fill_2
XFILLER_25_1322 VDD VSS sg13g2_decap_8
X_07945_ _07945_/Y _15006_/Q _07945_/B VDD VSS sg13g2_nand2b_1
XFILLER_130_889 VDD VSS sg13g2_decap_4
XFILLER_99_1401 VDD VSS sg13g2_decap_8
XFILLER_151_1363 VDD VSS sg13g2_decap_4
XFILLER_18_14 VDD VSS sg13g2_decap_8
XFILLER_96_781 VDD VSS sg13g2_decap_8
XFILLER_96_792 VDD VSS sg13g2_fill_2
XFILLER_5_1449 VDD VSS sg13g2_decap_8
X_07876_ _07876_/Y _07876_/A _07876_/B VDD VSS sg13g2_nand2_1
XFILLER_68_494 VDD VSS sg13g2_fill_1
XFILLER_25_1399 VDD VSS sg13g2_decap_8
XFILLER_186_1415 VDD VSS sg13g2_decap_8
X_09615_ _14211_/D _09881_/A0 _14211_/Q _09633_/S VDD VSS sg13g2_mux2_1
XFILLER_95_1309 VDD VSS sg13g2_decap_8
XFILLER_83_453 VDD VSS sg13g2_decap_8
XFILLER_84_987 VDD VSS sg13g2_fill_1
XFILLER_71_604 VDD VSS sg13g2_fill_1
XFILLER_186_1448 VDD VSS sg13g2_decap_8
XFILLER_3_1162 VDD VSS sg13g2_decap_8
XFILLER_43_317 VDD VSS sg13g2_decap_8
X_09546_ _14144_/D _10043_/A0 _14144_/Q _09567_/S VDD VSS sg13g2_mux2_1
XFILLER_97_1180 VDD VSS sg13g2_decap_8
XFILLER_24_520 VDD VSS sg13g2_decap_8
XFILLER_145_1101 VDD VSS sg13g2_fill_1
X_14860__2917 _14860_/RESET_B VDD VSS sg13g2_tiehi
XFILLER_93_1044 VDD VSS sg13g2_decap_8
XFILLER_52_851 VDD VSS sg13g2_decap_8
XFILLER_34_35 VDD VSS sg13g2_decap_8
XFILLER_145_1123 VDD VSS sg13g2_fill_1
XFILLER_19_1126 VDD VSS sg13g2_decap_8
X_09477_ _14077_/D _09941_/A1 _14077_/Q _09478_/S VDD VSS sg13g2_mux2_1
XFILLER_145_1134 VDD VSS sg13g2_fill_2
XFILLER_169_536 VDD VSS sg13g2_fill_2
X_14429__1843 _14429_/RESET_B VDD VSS sg13g2_tiehi
XFILLER_11_203 VDD VSS sg13g2_decap_8
X_08428_ _08428_/X _08337_/X _08427_/X _08428_/S VDD VSS sg13g2_mux2_1
XFILLER_157_709 VDD VSS sg13g2_decap_8
XFILLER_184_506 VDD VSS sg13g2_decap_8
XFILLER_162_1470 VDD VSS sg13g2_decap_4
XFILLER_184_517 VDD VSS sg13g2_decap_8
Xclkload1 clkload1/X clkload1/A VDD VSS sg13g2_buf_8
X_08359_ _08373_/C _08415_/A _08522_/C _08668_/B _08381_/A _08358_/Y VDD VSS sg13g2_a221oi_1
XFILLER_71_1375 VDD VSS sg13g2_fill_2
XFILLER_109_102 VDD VSS sg13g2_decap_8
XFILLER_137_411 VDD VSS sg13g2_decap_4
XFILLER_20_770 VDD VSS sg13g2_decap_8
XFILLER_149_293 VDD VSS sg13g2_fill_1
XFILLER_71_1397 VDD VSS sg13g2_decap_8
XFILLER_109_135 VDD VSS sg13g2_fill_1
Xclkbuf_5_11__f_clk_i clkbuf_leaf_39_clk_i/A clkbuf_4_5_0_clk_i/X VDD VSS sg13g2_buf_16
X_11370_ _11370_/Y _11418_/A _14110_/Q VDD VSS sg13g2_nand2b_1
XFILLER_4_903 VDD VSS sg13g2_decap_8
XFILLER_125_617 VDD VSS sg13g2_fill_1
XFILLER_165_786 VDD VSS sg13g2_decap_8
X_14790__3016 _14790_/RESET_B VDD VSS sg13g2_tiehi
XFILLER_137_488 VDD VSS sg13g2_fill_1
XFILLER_166_56 VDD VSS sg13g2_decap_8
X_10321_ _10323_/B _10342_/A _14799_/Q _14800_/Q _10342_/C VDD VSS sg13g2_nand4_1
XFILLER_124_116 VDD VSS sg13g2_fill_1
XFILLER_3_413 VDD VSS sg13g2_decap_8
XFILLER_118_691 VDD VSS sg13g2_decap_8
XFILLER_124_127 VDD VSS sg13g2_fill_1
XFILLER_124_138 VDD VSS sg13g2_fill_2
X_13040_ _13042_/C _13057_/B _13057_/C VDD VSS sg13g2_nand2_1
XFILLER_105_330 VDD VSS sg13g2_decap_8
X_10252_ _10252_/Y _14779_/Q _10258_/D _10350_/C VDD VSS sg13g2_o21ai_1
XFILLER_59_21 VDD VSS sg13g2_fill_2
XFILLER_161_981 VDD VSS sg13g2_decap_8
XFILLER_79_726 VDD VSS sg13g2_fill_2
XFILLER_106_897 VDD VSS sg13g2_fill_2
XFILLER_78_203 VDD VSS sg13g2_decap_8
XFILLER_132_160 VDD VSS sg13g2_decap_8
X_10183_ _14748_/D _10173_/Y _10181_/Y _10182_/Y VDD VSS sg13g2_o21ai_1
Xfanout1203 _07782_/A _08882_/A1 VDD VSS sg13g2_buf_1
XFILLER_120_322 VDD VSS sg13g2_fill_1
Xfanout1214 _11526_/A _08867_/A1 VDD VSS sg13g2_buf_1
XFILLER_59_87 VDD VSS sg13g2_decap_8
Xfanout1225 _11452_/A _11454_/A VDD VSS sg13g2_buf_1
XFILLER_117_1269 VDD VSS sg13g2_fill_2
XFILLER_182_77 VDD VSS sg13g2_decap_8
Xfanout1236 _12997_/A _12867_/C VDD VSS sg13g2_buf_1
X_13917__2355 _13917_/RESET_B VDD VSS sg13g2_tiehi
X_14991_ _14991_/Q clkload79/A _14991_/D _14991_/RESET_B VDD VSS sg13g2_dfrbpq_1
Xfanout1247 _13200_/A _14920_/Q VDD VSS sg13g2_buf_1
XFILLER_43_1433 VDD VSS sg13g2_fill_1
X_14677__1595 _14677_/RESET_B VDD VSS sg13g2_tiehi
Xfanout260 _10151_/A1 wire262/X VDD VSS sg13g2_buf_1
Xfanout1258 _12835_/A _14896_/Q VDD VSS sg13g2_buf_1
Xfanout271 _10149_/A1 _09719_/A0 VDD VSS sg13g2_buf_1
Xfanout1269 _10471_/C _10511_/D VDD VSS sg13g2_buf_1
Xfanout282 _09896_/S _09902_/S VDD VSS sg13g2_buf_1
XFILLER_43_1466 VDD VSS sg13g2_decap_4
XFILLER_130_1425 VDD VSS sg13g2_fill_2
X_13942_ _13942_/Q _14518_/CLK _13942_/D _13942_/RESET_B VDD VSS sg13g2_dfrbpq_1
XFILLER_87_792 VDD VSS sg13g2_decap_8
Xfanout293 _09604_/S _09573_/X VDD VSS sg13g2_buf_1
XFILLER_75_42 VDD VSS sg13g2_decap_8
XFILLER_74_420 VDD VSS sg13g2_decap_8
XFILLER_59_494 VDD VSS sg13g2_decap_8
XFILLER_19_336 VDD VSS sg13g2_decap_8
XFILLER_75_954 VDD VSS sg13g2_decap_8
X_13873_ _13873_/Q _14513_/CLK _13873_/D _13873_/RESET_B VDD VSS sg13g2_dfrbpq_1
X_14821__2985 _14821_/RESET_B VDD VSS sg13g2_tiehi
XFILLER_61_103 VDD VSS sg13g2_decap_8
X_12824_ _15022_/D _13211_/A _12824_/B VDD VSS sg13g2_nor2_1
XFILLER_90_946 VDD VSS sg13g2_decap_8
XFILLER_46_199 VDD VSS sg13g2_decap_8
XFILLER_90_968 VDD VSS sg13g2_decap_8
XFILLER_76_1231 VDD VSS sg13g2_decap_8
XFILLER_37_1204 VDD VSS sg13g2_decap_8
XFILLER_15_553 VDD VSS sg13g2_decap_8
XFILLER_37_1215 VDD VSS sg13g2_fill_1
X_12755_ _12755_/X _14264_/Q _14296_/Q _14328_/Q _14360_/Q _12755_/S0 _12758_/S1 VDD
+ VSS sg13g2_mux4_1
XFILLER_124_1207 VDD VSS sg13g2_decap_8
X_11706_ _11773_/C _11706_/A _13679_/Q VDD VSS sg13g2_xnor2_1
X_12686_ _12686_/X _13843_/Q _13875_/Q _13907_/Q _13939_/Q _12689_/S0 _12689_/S1 VDD
+ VSS sg13g2_mux4_1
XFILLER_128_1398 VDD VSS sg13g2_fill_1
X_14425_ _14425_/Q clkload36/A _14425_/D _14425_/RESET_B VDD VSS sg13g2_dfrbpq_1
X_11637_ _11776_/A _11638_/C _11637_/B VDD VSS sg13g2_nor2_1
XFILLER_168_580 VDD VSS sg13g2_decap_8
XFILLER_11_770 VDD VSS sg13g2_decap_8
XFILLER_129_945 VDD VSS sg13g2_decap_4
X_14356_ _14356_/Q _14740_/CLK _14356_/D _14356_/RESET_B VDD VSS sg13g2_dfrbpq_1
XFILLER_50_1459 VDD VSS sg13g2_decap_8
XFILLER_10_280 VDD VSS sg13g2_decap_8
XFILLER_155_241 VDD VSS sg13g2_decap_8
X_11568_ _11571_/C _11502_/A _13685_/Q _12942_/B _11526_/A _11505_/X VDD VSS sg13g2_a221oi_1
XFILLER_7_763 VDD VSS sg13g2_decap_8
X_13307_ _13307_/Y _13308_/A _13307_/B VDD VSS sg13g2_nor2_1
X_10519_ _14855_/D _13155_/A _10519_/B _10519_/C VDD VSS sg13g2_nor3_1
XFILLER_128_499 VDD VSS sg13g2_decap_8
XFILLER_13_1281 VDD VSS sg13g2_decap_8
X_14287_ _14287_/Q _14610_/CLK _14287_/D _14287_/RESET_B VDD VSS sg13g2_dfrbpq_1
X_14766__3040 _14766_/RESET_B VDD VSS sg13g2_tiehi
XFILLER_6_273 VDD VSS sg13g2_decap_8
XFILLER_144_959 VDD VSS sg13g2_decap_8
X_11499_ _11499_/Y _14901_/Q _11433_/B _11721_/B1 VDD VSS sg13g2_a21oi_1
XFILLER_115_138 VDD VSS sg13g2_decap_8
XFILLER_171_756 VDD VSS sg13g2_fill_1
XFILLER_171_767 VDD VSS sg13g2_decap_8
XFILLER_157_1049 VDD VSS sg13g2_decap_8
X_13238_ _13239_/B _13253_/B2 _13233_/X _13232_/Y _13160_/B _13237_/Y VDD VSS sg13g2_a221oi_1
XFILLER_87_1371 VDD VSS sg13g2_decap_8
XFILLER_100_1284 VDD VSS sg13g2_decap_8
XFILLER_3_980 VDD VSS sg13g2_decap_8
XFILLER_124_694 VDD VSS sg13g2_decap_4
XFILLER_170_1205 VDD VSS sg13g2_decap_8
X_13169_ _13169_/Y _13170_/C _13170_/D VDD VSS sg13g2_nor2_1
XFILLER_151_491 VDD VSS sg13g2_decap_8
XFILLER_83_1279 VDD VSS sg13g2_decap_8
XFILLER_97_556 VDD VSS sg13g2_decap_8
XFILLER_2_490 VDD VSS sg13g2_decap_8
XFILLER_111_355 VDD VSS sg13g2_decap_8
XFILLER_112_878 VDD VSS sg13g2_decap_8
XFILLER_85_729 VDD VSS sg13g2_decap_8
X_14507__1765 _14507_/RESET_B VDD VSS sg13g2_tiehi
XFILLER_78_770 VDD VSS sg13g2_decap_8
X_07730_ _07734_/B _15078_/Q _15084_/Q _15085_/Q _15081_/Q VDD VSS sg13g2_nor4_1
XFILLER_66_954 VDD VSS sg13g2_decap_8
XFILLER_66_965 VDD VSS sg13g2_fill_1
XFILLER_38_656 VDD VSS sg13g2_decap_4
X_07661_ _07661_/Y _07766_/B VDD VSS sg13g2_inv_1
X_16859_ _16859_/X _16859_/A VDD VSS sg13g2_buf_1
XFILLER_26_829 VDD VSS sg13g2_decap_8
XFILLER_93_784 VDD VSS sg13g2_decap_8
XFILLER_92_261 VDD VSS sg13g2_fill_2
XFILLER_81_924 VDD VSS sg13g2_decap_8
X_09400_ _14003_/D _10029_/A0 _14003_/Q _09406_/S VDD VSS sg13g2_mux2_1
XFILLER_80_412 VDD VSS sg13g2_decap_4
XFILLER_77_1028 VDD VSS sg13g2_decap_4
XFILLER_0_1324 VDD VSS sg13g2_decap_8
XFILLER_20_1252 VDD VSS sg13g2_decap_8
XFILLER_94_1331 VDD VSS sg13g2_decap_4
XFILLER_25_339 VDD VSS sg13g2_decap_8
XFILLER_129_1129 VDD VSS sg13g2_decap_8
XFILLER_168_1178 VDD VSS sg13g2_decap_8
XFILLER_146_1410 VDD VSS sg13g2_decap_8
X_14722__1550 _14722_/RESET_B VDD VSS sg13g2_tiehi
XFILLER_59_1462 VDD VSS sg13g2_decap_8
XFILLER_52_147 VDD VSS sg13g2_decap_8
XFILLER_179_823 VDD VSS sg13g2_decap_8
X_09331_ _13938_/D _10128_/A0 _13938_/Q _09331_/S VDD VSS sg13g2_mux2_1
XFILLER_181_1312 VDD VSS sg13g2_decap_8
XFILLER_55_1315 VDD VSS sg13g2_decap_8
XFILLER_178_322 VDD VSS sg13g2_decap_8
XFILLER_90_1217 VDD VSS sg13g2_decap_8
XFILLER_179_867 VDD VSS sg13g2_fill_1
XFILLER_61_681 VDD VSS sg13g2_fill_1
X_09262_ _13871_/D _13871_/Q _09627_/A0 _09265_/S VDD VSS sg13g2_mux2_1
XFILLER_107_1438 VDD VSS sg13g2_fill_1
XFILLER_142_1329 VDD VSS sg13g2_fill_2
XFILLER_166_506 VDD VSS sg13g2_decap_8
XFILLER_179_889 VDD VSS sg13g2_decap_8
XFILLER_14_1001 VDD VSS sg13g2_decap_8
X_08213_ _08374_/B _08121_/X _08124_/X _08621_/B VDD VSS sg13g2_mux2_1
XFILLER_178_399 VDD VSS sg13g2_decap_8
X_09193_ _13809_/D _13809_/Q _09730_/A0 _09193_/S VDD VSS sg13g2_mux2_1
XFILLER_18_1192 VDD VSS sg13g2_decap_8
XFILLER_105_1151 VDD VSS sg13g2_decap_8
XFILLER_53_1094 VDD VSS sg13g2_decap_8
X_08144_ _08145_/C _08110_/D _08138_/X _08463_/B _08246_/A1 _08143_/Y VDD VSS sg13g2_a221oi_1
XFILLER_101_1004 VDD VSS sg13g2_decap_8
XFILLER_140_1053 VDD VSS sg13g2_decap_8
XFILLER_119_477 VDD VSS sg13g2_decap_8
XFILLER_14_1078 VDD VSS sg13g2_decap_8
XFILLER_174_561 VDD VSS sg13g2_decap_8
XFILLER_119_488 VDD VSS sg13g2_fill_1
XFILLER_135_937 VDD VSS sg13g2_decap_8
XFILLER_134_425 VDD VSS sg13g2_decap_8
XFILLER_135_948 VDD VSS sg13g2_decap_8
X_08075_ _08075_/Y _08023_/A _08290_/S _08074_/C _08074_/B VDD VSS sg13g2_a22oi_1
XFILLER_161_211 VDD VSS sg13g2_decap_8
XFILLER_66_1400 VDD VSS sg13g2_decap_8
XFILLER_115_650 VDD VSS sg13g2_decap_8
XFILLER_1_917 VDD VSS sg13g2_decap_8
XFILLER_0_427 VDD VSS sg13g2_decap_8
XFILLER_115_694 VDD VSS sg13g2_decap_8
XFILLER_103_845 VDD VSS sg13g2_decap_8
XFILLER_130_620 VDD VSS sg13g2_decap_8
XFILLER_66_1477 VDD VSS sg13g2_fill_2
XFILLER_102_322 VDD VSS sg13g2_fill_2
XFILLER_114_182 VDD VSS sg13g2_decap_8
XFILLER_62_1319 VDD VSS sg13g2_decap_8
XFILLER_103_856 VDD VSS sg13g2_fill_2
XFILLER_76_718 VDD VSS sg13g2_decap_8
XFILLER_29_35 VDD VSS sg13g2_decap_8
XFILLER_152_14 VDD VSS sg13g2_decap_4
X_08977_ _08977_/Y _09141_/A _08977_/B _10697_/B VDD VSS sg13g2_nand3_1
XFILLER_76_729 VDD VSS sg13g2_fill_1
XFILLER_130_686 VDD VSS sg13g2_decap_8
XFILLER_102_388 VDD VSS sg13g2_decap_4
XFILLER_112_1100 VDD VSS sg13g2_decap_4
XFILLER_9_1393 VDD VSS sg13g2_decap_8
XFILLER_57_921 VDD VSS sg13g2_fill_1
X_07928_ _07928_/Y _07923_/Y _07925_/Y _07797_/X VDD VSS sg13g2_a21oi_1
XFILLER_29_79 VDD VSS sg13g2_fill_1
XFILLER_112_1122 VDD VSS sg13g2_decap_8
XFILLER_5_1246 VDD VSS sg13g2_decap_8
XFILLER_21_1027 VDD VSS sg13g2_decap_8
XFILLER_99_1253 VDD VSS sg13g2_fill_1
XFILLER_84_751 VDD VSS sg13g2_fill_2
XFILLER_25_1196 VDD VSS sg13g2_decap_8
XFILLER_72_902 VDD VSS sg13g2_decap_8
XFILLER_29_667 VDD VSS sg13g2_decap_8
X_07859_ _08641_/C _15014_/Q _07859_/B VDD VSS sg13g2_xnor2_1
XFILLER_99_1275 VDD VSS sg13g2_decap_8
XFILLER_84_773 VDD VSS sg13g2_decap_8
XFILLER_72_913 VDD VSS sg13g2_decap_8
X_10870_ _10897_/B _10870_/A _10871_/A VDD VSS sg13g2_nand2_1
XFILLER_182_1109 VDD VSS sg13g2_decap_8
X_09529_ _14128_/D _10026_/A0 _14128_/Q _09530_/S VDD VSS sg13g2_mux2_1
XFILLER_73_1415 VDD VSS sg13g2_decap_8
XFILLER_169_333 VDD VSS sg13g2_decap_8
XFILLER_52_681 VDD VSS sg13g2_decap_8
X_12540_ wire322/A _13680_/Q _12693_/A2 _12539_/X _12415_/A _12763_/C1 VDD VSS sg13g2_a221oi_1
XFILLER_73_1459 VDD VSS sg13g2_decap_8
XFILLER_24_394 VDD VSS sg13g2_decap_4
XFILLER_12_567 VDD VSS sg13g2_decap_8
X_12471_ _14997_/D _12471_/A _12471_/B VDD VSS sg13g2_nor2_1
XFILLER_138_742 VDD VSS sg13g2_decap_8
X_14210_ _14210_/Q _14656_/CLK _14210_/D _14210_/RESET_B VDD VSS sg13g2_dfrbpq_1
X_11422_ _11422_/Y _11422_/A _11422_/B VDD VSS sg13g2_nand2_1
XFILLER_177_77 VDD VSS sg13g2_decap_8
X_15190_ _15190_/Q clkload81/A _15190_/D _15190_/RESET_B VDD VSS sg13g2_dfrbpq_1
XFILLER_32_1156 VDD VSS sg13g2_decap_8
XFILLER_126_915 VDD VSS sg13g2_fill_1
XFILLER_123_1284 VDD VSS sg13g2_decap_8
XFILLER_165_561 VDD VSS sg13g2_decap_8
XFILLER_6_28 VDD VSS sg13g2_decap_8
XFILLER_125_403 VDD VSS sg13g2_decap_8
XFILLER_153_712 VDD VSS sg13g2_decap_8
XFILLER_4_700 VDD VSS sg13g2_decap_8
XFILLER_117_0 VDD VSS sg13g2_decap_8
X_14141_ _14141_/Q clkload59/A _14141_/D _14141_/RESET_B VDD VSS sg13g2_dfrbpq_1
XFILLER_10_1421 VDD VSS sg13g2_decap_8
X_14160__2112 _14160_/RESET_B VDD VSS sg13g2_tiehi
X_11353_ _11353_/X _14558_/Q _14590_/Q _11418_/A VDD VSS sg13g2_mux2_1
XFILLER_3_210 VDD VSS sg13g2_decap_8
XFILLER_119_1309 VDD VSS sg13g2_fill_2
XFILLER_153_767 VDD VSS sg13g2_fill_2
XFILLER_180_553 VDD VSS sg13g2_decap_8
X_10304_ _10311_/C _14794_/Q _14795_/Q VDD VSS sg13g2_and2_1
X_14072_ _14072_/Q clkload24/A _14072_/D _14072_/RESET_B VDD VSS sg13g2_dfrbpq_1
XFILLER_141_929 VDD VSS sg13g2_decap_4
X_11284_ _11285_/A _11281_/Y _11283_/Y _11901_/B1 VDD VSS sg13g2_a21oi_1
XFILLER_4_777 VDD VSS sg13g2_decap_8
XFILLER_10_70 VDD VSS sg13g2_decap_8
XFILLER_112_119 VDD VSS sg13g2_decap_8
X_13023_ _13057_/A _14908_/Q _13679_/Q VDD VSS sg13g2_xor2_1
X_14754__3055 _14754_/RESET_B VDD VSS sg13g2_tiehi
X_10235_ _10235_/Y _07638_/Y _10232_/B _10441_/C VDD VSS sg13g2_o21ai_1
XFILLER_105_171 VDD VSS sg13g2_decap_8
XFILLER_156_1071 VDD VSS sg13g2_decap_8
XFILLER_3_287 VDD VSS sg13g2_decap_8
XFILLER_80_1419 VDD VSS sg13g2_decap_8
XFILLER_126_70 VDD VSS sg13g2_decap_8
Xfanout1000 _12936_/B _15202_/Q VDD VSS sg13g2_buf_1
XFILLER_156_1093 VDD VSS sg13g2_decap_8
Xfanout1011 _13499_/C _15128_/Q VDD VSS sg13g2_buf_1
XFILLER_121_653 VDD VSS sg13g2_decap_8
Xfanout1022 _13150_/B _07727_/B VDD VSS sg13g2_buf_1
Xfanout1033 _13250_/A2 _15106_/Q VDD VSS sg13g2_buf_1
X_10166_ _14743_/D _14743_/Q _10166_/A1 wire333/X VDD VSS sg13g2_mux2_1
XFILLER_120_152 VDD VSS sg13g2_fill_2
X_14193__2079 _14193_/RESET_B VDD VSS sg13g2_tiehi
Xfanout1044 _11027_/B1 _10924_/B1 VDD VSS sg13g2_buf_1
Xfanout1055 _11288_/A _07720_/B VDD VSS sg13g2_buf_1
XFILLER_94_526 VDD VSS sg13g2_decap_8
XFILLER_117_1099 VDD VSS sg13g2_decap_8
Xfanout1066 _09441_/A _15064_/Q VDD VSS sg13g2_buf_1
Xfanout1077 _09078_/B _15059_/Q VDD VSS sg13g2_buf_1
X_14974_ _14974_/Q clkload54/A _14974_/D _14974_/RESET_B VDD VSS sg13g2_dfrbpq_1
Xfanout1088 _13283_/A _15054_/Q VDD VSS sg13g2_buf_1
X_10097_ _14677_/D _10097_/A0 _14677_/Q _10097_/S VDD VSS sg13g2_mux2_1
XFILLER_86_96 VDD VSS sg13g2_fill_2
XFILLER_47_431 VDD VSS sg13g2_decap_8
XFILLER_130_1244 VDD VSS sg13g2_fill_1
XFILLER_19_133 VDD VSS sg13g2_decap_8
Xfanout1099 _13545_/A _14996_/Q VDD VSS sg13g2_buf_1
XFILLER_169_1421 VDD VSS sg13g2_decap_8
X_13925_ _13925_/Q clkload14/A _13925_/D _13925_/RESET_B VDD VSS sg13g2_dfrbpq_1
XFILLER_78_1326 VDD VSS sg13g2_decap_8
XFILLER_74_250 VDD VSS sg13g2_decap_8
XFILLER_90_710 VDD VSS sg13g2_decap_8
XFILLER_35_615 VDD VSS sg13g2_decap_8
XFILLER_142_91 VDD VSS sg13g2_decap_4
XFILLER_63_935 VDD VSS sg13g2_fill_2
XFILLER_62_423 VDD VSS sg13g2_fill_1
XFILLER_47_497 VDD VSS sg13g2_decap_8
XFILLER_130_1299 VDD VSS sg13g2_decap_8
X_13856_ _13856_/Q _14720_/CLK _13856_/D _13856_/RESET_B VDD VSS sg13g2_dfrbpq_1
XFILLER_62_445 VDD VSS sg13g2_decap_8
XFILLER_34_136 VDD VSS sg13g2_decap_4
XFILLER_63_979 VDD VSS sg13g2_decap_8
XFILLER_179_119 VDD VSS sg13g2_decap_8
X_12807_ _12807_/Y _14799_/Q _12851_/B _07728_/B _14831_/Q _13248_/B VDD VSS sg13g2_a221oi_1
XFILLER_15_350 VDD VSS sg13g2_decap_8
X_13787_ _13787_/Q _14716_/CLK _13787_/D _13787_/RESET_B VDD VSS sg13g2_dfrbpq_1
XFILLER_16_884 VDD VSS sg13g2_decap_4
X_10999_ _10999_/X _10995_/B _11207_/A2 _10999_/B1 VDD VSS sg13g2_a21o_1
XFILLER_90_798 VDD VSS sg13g2_fill_2
XFILLER_31_810 VDD VSS sg13g2_fill_2
XFILLER_31_832 VDD VSS sg13g2_decap_8
X_12738_ _12738_/X _14583_/Q _14615_/Q _14647_/Q _14679_/Q _12742_/S0 _12756_/S1 VDD
+ VSS sg13g2_mux4_1
X_14370__1902 _14370_/RESET_B VDD VSS sg13g2_tiehi
XFILLER_148_506 VDD VSS sg13g2_fill_2
XFILLER_163_1064 VDD VSS sg13g2_decap_8
XFILLER_176_815 VDD VSS sg13g2_fill_1
XFILLER_176_826 VDD VSS sg13g2_decap_8
X_12669_ _12669_/X _14386_/Q _14418_/Q _14482_/Q _14514_/Q _12755_/S0 _12758_/S1 VDD
+ VSS sg13g2_mux4_1
XFILLER_124_1059 VDD VSS sg13g2_fill_2
XFILLER_50_1223 VDD VSS sg13g2_decap_8
XFILLER_15_1354 VDD VSS sg13g2_decap_8
X_14408_ _14408_/Q clkload26/A _14408_/D _14408_/RESET_B VDD VSS sg13g2_dfrbpq_1
XFILLER_175_369 VDD VSS sg13g2_decap_8
XFILLER_11_1218 VDD VSS sg13g2_decap_8
XFILLER_129_775 VDD VSS sg13g2_decap_8
XFILLER_89_1433 VDD VSS sg13g2_decap_8
XFILLER_7_560 VDD VSS sg13g2_decap_8
X_14339_ _14339_/Q clkload29/A _14339_/D _14339_/RESET_B VDD VSS sg13g2_dfrbpq_1
XFILLER_117_959 VDD VSS sg13g2_decap_8
XFILLER_89_1477 VDD VSS sg13g2_fill_2
XFILLER_116_469 VDD VSS sg13g2_fill_1
X_13789__2483 _13789_/RESET_B VDD VSS sg13g2_tiehi
XFILLER_131_428 VDD VSS sg13g2_fill_2
X_08900_ _08900_/Y _11798_/A _08931_/S _08899_/Y VDD VSS sg13g2_a21oi_1
X_09880_ _14466_/D _09913_/A1 _14466_/Q _09901_/S VDD VSS sg13g2_mux2_1
XFILLER_83_1065 VDD VSS sg13g2_decap_8
XFILLER_32_0 VDD VSS sg13g2_decap_8
XFILLER_140_962 VDD VSS sg13g2_decap_8
X_08831_ _08831_/Y _13283_/A _08831_/B VDD VSS sg13g2_nor2_1
XFILLER_97_353 VDD VSS sg13g2_decap_8
XFILLER_58_707 VDD VSS sg13g2_decap_8
XFILLER_112_664 VDD VSS sg13g2_fill_1
XFILLER_135_1155 VDD VSS sg13g2_decap_8
XFILLER_170_1046 VDD VSS sg13g2_decap_8
XFILLER_131_1008 VDD VSS sg13g2_decap_8
XFILLER_85_515 VDD VSS sg13g2_fill_2
XFILLER_57_217 VDD VSS sg13g2_fill_2
XFILLER_39_921 VDD VSS sg13g2_fill_2
XFILLER_22_1303 VDD VSS sg13g2_decap_8
X_14023__2249 _14023_/RESET_B VDD VSS sg13g2_tiehi
XFILLER_113_1420 VDD VSS sg13g2_decap_4
X_08762_ _13672_/D _08765_/A1 _08760_/Y _08761_/Y VDD VSS sg13g2_a21oi_1
X_07713_ _07740_/A _07713_/A _07748_/B VDD VSS sg13g2_nor2b_1
XFILLER_38_453 VDD VSS sg13g2_decap_8
XFILLER_122_28 VDD VSS sg13g2_decap_8
X_08693_ _08693_/Y _08693_/A _08693_/B _08693_/C VDD VSS sg13g2_nand3_1
XFILLER_53_412 VDD VSS sg13g2_decap_4
X_07644_ _10297_/A _14790_/Q VDD VSS sg13g2_inv_1
XFILLER_0_1121 VDD VSS sg13g2_decap_8
XFILLER_81_754 VDD VSS sg13g2_decap_8
XFILLER_80_231 VDD VSS sg13g2_decap_8
XFILLER_54_968 VDD VSS sg13g2_decap_8
XFILLER_94_1150 VDD VSS sg13g2_fill_1
XFILLER_59_1270 VDD VSS sg13g2_fill_2
XFILLER_53_489 VDD VSS sg13g2_decap_8
XFILLER_55_1123 VDD VSS sg13g2_decap_8
XFILLER_0_1198 VDD VSS sg13g2_decap_8
XFILLER_146_1251 VDD VSS sg13g2_fill_1
X_09314_ _13921_/D _09945_/A1 _13921_/Q _09338_/S VDD VSS sg13g2_mux2_1
XFILLER_167_804 VDD VSS sg13g2_fill_1
XFILLER_40_139 VDD VSS sg13g2_decap_8
XFILLER_167_815 VDD VSS sg13g2_decap_8
XFILLER_16_1118 VDD VSS sg13g2_decap_8
XFILLER_22_865 VDD VSS sg13g2_decap_8
X_09245_ _13854_/D _13854_/Q _09909_/A1 _09261_/S VDD VSS sg13g2_mux2_1
XFILLER_181_1197 VDD VSS sg13g2_decap_8
XFILLER_166_336 VDD VSS sg13g2_decap_8
XFILLER_178_196 VDD VSS sg13g2_decap_8
XFILLER_31_14 VDD VSS sg13g2_decap_8
X_09176_ _13792_/D _13792_/Q _10143_/A1 _09201_/S VDD VSS sg13g2_mux2_1
XFILLER_120_1424 VDD VSS sg13g2_decap_8
XFILLER_135_701 VDD VSS sg13g2_fill_2
XFILLER_147_14 VDD VSS sg13g2_decap_8
XFILLER_175_881 VDD VSS sg13g2_fill_1
X_08127_ _08463_/B _13529_/A _08122_/Y _08126_/Y VDD VSS sg13g2_o21ai_1
XFILLER_110_7 VDD VSS sg13g2_decap_8
XFILLER_174_380 VDD VSS sg13g2_decap_8
X_08058_ _08058_/X _08044_/X _08052_/Y _08042_/X _08167_/B _08241_/A _08428_/S VDD
+ VSS sg13g2_mux4_1
XFILLER_123_929 VDD VSS sg13g2_decap_8
X_14379__1893 _14379_/RESET_B VDD VSS sg13g2_tiehi
XFILLER_1_714 VDD VSS sg13g2_decap_8
XFILLER_66_1241 VDD VSS sg13g2_decap_4
XFILLER_122_428 VDD VSS sg13g2_decap_8
Xoutput47 mem_axi_araddr[18] _13709_/Q VDD VSS sg13g2_buf_1
XFILLER_118_1320 VDD VSS sg13g2_fill_2
XFILLER_153_1200 VDD VSS sg13g2_decap_8
Xoutput58 mem_axi_araddr[29] _16882_/A VDD VSS sg13g2_buf_1
XFILLER_150_759 VDD VSS sg13g2_decap_8
Xoutput69 mem_axi_arprot[2] _16854_/X VDD VSS sg13g2_buf_1
XFILLER_0_224 VDD VSS sg13g2_decap_8
XFILLER_103_631 VDD VSS sg13g2_decap_8
XFILLER_131_940 VDD VSS sg13g2_decap_4
XFILLER_163_35 VDD VSS sg13g2_decap_8
Xhold3130 input26/A mem_axi_rdata[2] VDD VSS sg13g2_dlygate4sd3_1
XFILLER_66_1274 VDD VSS sg13g2_fill_1
XFILLER_62_1105 VDD VSS sg13g2_decap_8
Xhold3141 hold3141/X input2/X VDD VSS sg13g2_dlygate4sd3_1
X_10020_ _14602_/D _10086_/A0 _14602_/Q _10027_/S VDD VSS sg13g2_mux2_1
XFILLER_88_342 VDD VSS sg13g2_decap_4
Xhold3152 hold3152/X input21/X VDD VSS sg13g2_dlygate4sd3_1
Xhold3163 input25/A mem_axi_rdata[29] VDD VSS sg13g2_dlygate4sd3_1
XFILLER_27_1258 VDD VSS sg13g2_decap_8
XFILLER_130_461 VDD VSS sg13g2_decap_8
Xhold3174 input18/A mem_axi_rdata[22] VDD VSS sg13g2_dlygate4sd3_1
Xhold3185 input16/A mem_axi_rdata[20] VDD VSS sg13g2_dlygate4sd3_1
Xhold3196 _13632_/A _13740_/Q VDD VSS sg13g2_dlygate4sd3_1
XFILLER_9_1190 VDD VSS sg13g2_decap_8
XFILLER_40_1414 VDD VSS sg13g2_fill_1
XFILLER_29_420 VDD VSS sg13g2_decap_8
XFILLER_102_196 VDD VSS sg13g2_decap_8
XFILLER_76_559 VDD VSS sg13g2_decap_8
X_15059__2590 _15059_/RESET_B VDD VSS sg13g2_tiehi
XFILLER_5_1043 VDD VSS sg13g2_decap_8
X_11971_ _11971_/Y _11971_/A _11971_/B _12237_/C VDD VSS sg13g2_nand3_1
XFILLER_57_784 VDD VSS sg13g2_decap_8
XFILLER_186_1020 VDD VSS sg13g2_fill_2
XFILLER_186_1031 VDD VSS sg13g2_decap_8
X_13710_ _13710_/Q clkload75/A _13710_/D _13710_/RESET_B VDD VSS sg13g2_dfrbpq_1
XFILLER_57_795 VDD VSS sg13g2_fill_2
XFILLER_44_412 VDD VSS sg13g2_decap_8
X_10922_ _10926_/A _10920_/A _10920_/B _10921_/Y VDD VSS sg13g2_a21o_1
XFILLER_99_1094 VDD VSS sg13g2_decap_8
X_14690_ _14690_/Q clkload44/A _14690_/D _14690_/RESET_B VDD VSS sg13g2_dfrbpq_1
XFILLER_45_957 VDD VSS sg13g2_decap_8
XFILLER_44_445 VDD VSS sg13g2_fill_2
XFILLER_147_1026 VDD VSS sg13g2_decap_8
XFILLER_16_147 VDD VSS sg13g2_decap_8
X_13641_ _13749_/D _13641_/A VDD VSS sg13g2_buf_1
XFILLER_60_916 VDD VSS sg13g2_decap_8
XFILLER_44_467 VDD VSS sg13g2_decap_8
XFILLER_38_1310 VDD VSS sg13g2_decap_8
X_10853_ _10857_/A _14751_/Q _10851_/C _10841_/Y VDD VSS sg13g2_a21o_1
XFILLER_44_489 VDD VSS sg13g2_decap_8
XFILLER_31_106 VDD VSS sg13g2_fill_2
XFILLER_25_681 VDD VSS sg13g2_decap_8
XFILLER_25_692 VDD VSS sg13g2_fill_1
X_13572_ _13572_/Y _15156_/Q _13581_/B VDD VSS sg13g2_nor2_1
XFILLER_13_854 VDD VSS sg13g2_decap_8
X_10784_ _14922_/D _11168_/B1 _11164_/C _10783_/Y VDD VSS sg13g2_o21ai_1
XFILLER_72_76 VDD VSS sg13g2_decap_8
XFILLER_72_87 VDD VSS sg13g2_fill_1
XFILLER_40_640 VDD VSS sg13g2_decap_8
XFILLER_72_98 VDD VSS sg13g2_decap_8
XFILLER_38_1387 VDD VSS sg13g2_decap_8
XFILLER_185_623 VDD VSS sg13g2_decap_8
X_12523_ _12523_/X _12522_/X _12521_/X _12518_/X _12517_/X _12732_/S0 _12720_/S VDD
+ VSS sg13g2_mux4_1
XFILLER_38_1398 VDD VSS sg13g2_decap_8
XFILLER_12_364 VDD VSS sg13g2_decap_8
XFILLER_9_847 VDD VSS sg13g2_decap_8
XFILLER_184_133 VDD VSS sg13g2_decap_8
X_15242_ _15242_/Q clkload76/A _15242_/D _15242_/RESET_B VDD VSS sg13g2_dfrbpq_1
XFILLER_145_509 VDD VSS sg13g2_decap_8
X_12454_ _12454_/X _12446_/X _12450_/X _12445_/X _12449_/X _12692_/S _12691_/S1 VDD
+ VSS sg13g2_mux4_1
XFILLER_173_829 VDD VSS sg13g2_decap_8
XFILLER_8_357 VDD VSS sg13g2_decap_8
XFILLER_138_561 VDD VSS sg13g2_decap_8
XFILLER_172_317 VDD VSS sg13g2_decap_8
X_11405_ _11405_/Y _11396_/Y _11831_/B1 _11832_/C VDD VSS sg13g2_a21oi_1
X_15173_ _15173_/Q clkload85/A _15173_/D _15173_/RESET_B VDD VSS sg13g2_dfrbpq_1
XFILLER_158_1111 VDD VSS sg13g2_decap_4
X_12385_ _12386_/B _12383_/X _12384_/X _12748_/S VDD VSS sg13g2_mux2_1
XFILLER_126_745 VDD VSS sg13g2_decap_8
XFILLER_158_1122 VDD VSS sg13g2_decap_4
X_14124_ _14124_/Q _14540_/CLK _14124_/D _14124_/RESET_B VDD VSS sg13g2_dfrbpq_1
X_11336_ _11339_/A _11336_/A _11335_/X VDD VSS sg13g2_nor2b_1
XFILLER_125_255 VDD VSS sg13g2_decap_8
XFILLER_180_350 VDD VSS sg13g2_decap_8
XFILLER_21_91 VDD VSS sg13g2_decap_8
XFILLER_153_575 VDD VSS sg13g2_decap_8
XFILLER_158_1166 VDD VSS sg13g2_decap_8
XFILLER_107_981 VDD VSS sg13g2_decap_8
XFILLER_4_574 VDD VSS sg13g2_decap_8
XFILLER_10_1295 VDD VSS sg13g2_decap_8
X_14055_ _14055_/Q _14607_/CLK _14055_/D _14055_/RESET_B VDD VSS sg13g2_dfrbpq_1
XFILLER_97_40 VDD VSS sg13g2_decap_8
X_11267_ _11267_/Y _11263_/Y _11264_/X _11266_/Y VDD VSS sg13g2_o21ai_1
XFILLER_140_247 VDD VSS sg13g2_fill_1
XFILLER_79_331 VDD VSS sg13g2_fill_1
X_13006_ _13058_/A _14907_/Q _13680_/Q VDD VSS sg13g2_or2_1
XFILLER_136_1464 VDD VSS sg13g2_fill_2
XFILLER_171_1344 VDD VSS sg13g2_decap_8
X_10218_ _14767_/D _14767_/Q _13324_/A VDD VSS sg13g2_nor2_1
XFILLER_84_1396 VDD VSS sg13g2_fill_2
XFILLER_79_353 VDD VSS sg13g2_fill_2
XFILLER_122_973 VDD VSS sg13g2_decap_4
X_11198_ _11201_/A _11177_/B _11177_/C _11197_/X VDD VSS sg13g2_o21ai_1
XFILLER_80_1249 VDD VSS sg13g2_decap_4
XFILLER_171_1388 VDD VSS sg13g2_fill_1
XFILLER_95_846 VDD VSS sg13g2_fill_2
XFILLER_94_323 VDD VSS sg13g2_decap_4
X_10149_ _14726_/D _14726_/Q _10149_/A1 _10160_/S VDD VSS sg13g2_mux2_1
XFILLER_67_559 VDD VSS sg13g2_decap_4
XFILLER_48_773 VDD VSS sg13g2_decap_8
X_14957_ _14957_/Q clkload73/A _14957_/D _14957_/RESET_B VDD VSS sg13g2_dfrbpq_1
XFILLER_82_529 VDD VSS sg13g2_decap_8
XFILLER_78_1123 VDD VSS sg13g2_decap_8
X_13908_ _13908_/Q _14740_/CLK _13908_/D _13908_/RESET_B VDD VSS sg13g2_dfrbpq_1
XFILLER_35_434 VDD VSS sg13g2_fill_1
X_14888_ _14888_/Q _14890_/CLK _14888_/D _14888_/RESET_B VDD VSS sg13g2_dfrbpq_1
XFILLER_78_1167 VDD VSS sg13g2_decap_8
XFILLER_1_1463 VDD VSS sg13g2_decap_8
XFILLER_1_1474 VDD VSS sg13g2_fill_1
XFILLER_165_1148 VDD VSS sg13g2_decap_8
X_13839_ _13839_/Q clkload13/A _13839_/D _13839_/RESET_B VDD VSS sg13g2_dfrbpq_1
XFILLER_91_1312 VDD VSS sg13g2_decap_8
XFILLER_143_1413 VDD VSS sg13g2_decap_8
X_14905__2827 _14905_/RESET_B VDD VSS sg13g2_tiehi
XFILLER_52_1307 VDD VSS sg13g2_decap_8
XFILLER_104_1408 VDD VSS sg13g2_fill_2
XFILLER_176_634 VDD VSS sg13g2_decap_8
XFILLER_31_684 VDD VSS sg13g2_decap_8
XFILLER_30_161 VDD VSS sg13g2_decap_8
XFILLER_175_133 VDD VSS sg13g2_decap_8
XFILLER_164_807 VDD VSS sg13g2_fill_1
X_09030_ _09043_/A _14905_/Q _12957_/A _10702_/A wire584/X VDD VSS sg13g2_nand4_1
XFILLER_15_1151 VDD VSS sg13g2_decap_8
XFILLER_50_1031 VDD VSS sg13g2_decap_8
XFILLER_117_712 VDD VSS sg13g2_decap_8
XFILLER_141_1170 VDD VSS sg13g2_decap_4
XFILLER_11_1015 VDD VSS sg13g2_decap_8
XFILLER_141_1192 VDD VSS sg13g2_decap_4
XFILLER_50_1086 VDD VSS sg13g2_decap_8
XFILLER_102_1165 VDD VSS sg13g2_fill_2
XFILLER_144_542 VDD VSS sg13g2_decap_8
XFILLER_176_1222 VDD VSS sg13g2_decap_8
X_13912__2360 _13912_/RESET_B VDD VSS sg13g2_tiehi
XFILLER_89_1274 VDD VSS sg13g2_decap_8
XFILLER_117_767 VDD VSS sg13g2_decap_8
XFILLER_172_873 VDD VSS sg13g2_decap_4
XFILLER_117_39 VDD VSS sg13g2_decap_8
XFILLER_171_383 VDD VSS sg13g2_decap_4
XFILLER_176_1288 VDD VSS sg13g2_decap_8
X_09932_ _14517_/D _14517_/Q _09131_/X _09936_/S VDD VSS sg13g2_mux2_1
XFILLER_89_128 VDD VSS sg13g2_decap_8
XFILLER_132_748 VDD VSS sg13g2_decap_4
XFILLER_113_940 VDD VSS sg13g2_decap_8
XFILLER_131_247 VDD VSS sg13g2_decap_8
Xfanout804 _08597_/B _08301_/S VDD VSS sg13g2_buf_1
Xfanout815 _08138_/C _08070_/C VDD VSS sg13g2_buf_1
X_14256__2016 _14256_/RESET_B VDD VSS sg13g2_tiehi
Xfanout826 _08290_/S _07612_/Y VDD VSS sg13g2_buf_1
XFILLER_112_450 VDD VSS sg13g2_fill_1
Xfanout837 _12705_/S1 _12789_/S1 VDD VSS sg13g2_buf_1
X_09863_ _14450_/D _14450_/Q _10161_/A1 _09866_/S VDD VSS sg13g2_mux2_1
Xfanout848 _12371_/S _12748_/S VDD VSS sg13g2_buf_1
XFILLER_63_1458 VDD VSS sg13g2_decap_8
XFILLER_98_695 VDD VSS sg13g2_decap_8
XFILLER_86_835 VDD VSS sg13g2_decap_8
X_08814_ _08814_/Y _13689_/Q _08822_/B VDD VSS sg13g2_nor2_1
XFILLER_6_1330 VDD VSS sg13g2_decap_8
XFILLER_22_1100 VDD VSS sg13g2_decap_8
X_09794_ _14383_/D _10158_/A1 _14383_/Q _09800_/S VDD VSS sg13g2_mux2_1
XFILLER_133_49 VDD VSS sg13g2_decap_8
XFILLER_61_1160 VDD VSS sg13g2_decap_8
X_08745_ _08745_/Y _07720_/A _07720_/B _15195_/Q VDD VSS sg13g2_o21ai_1
XFILLER_39_762 VDD VSS sg13g2_fill_2
XFILLER_61_1193 VDD VSS sg13g2_decap_8
XFILLER_54_710 VDD VSS sg13g2_decap_4
XFILLER_113_1283 VDD VSS sg13g2_decap_8
XFILLER_27_935 VDD VSS sg13g2_decap_8
XFILLER_22_1177 VDD VSS sg13g2_decap_8
XFILLER_26_14 VDD VSS sg13g2_decap_8
XFILLER_148_1302 VDD VSS sg13g2_fill_2
XFILLER_66_592 VDD VSS sg13g2_decap_8
X_08676_ _08676_/Y _08363_/X _08544_/B _08668_/X _08688_/C _08675_/Y VDD VSS sg13g2_a221oi_1
XFILLER_38_294 VDD VSS sg13g2_decap_8
XFILLER_26_434 VDD VSS sg13g2_decap_8
XFILLER_42_905 VDD VSS sg13g2_decap_8
XFILLER_148_1335 VDD VSS sg13g2_fill_2
XFILLER_54_776 VDD VSS sg13g2_decap_8
X_07627_ _07627_/Y _07627_/A VDD VSS sg13g2_inv_1
XFILLER_53_253 VDD VSS sg13g2_decap_8
XFILLER_96_1289 VDD VSS sg13g2_decap_8
XFILLER_41_404 VDD VSS sg13g2_decap_8
XFILLER_158_7 VDD VSS sg13g2_decap_8
XFILLER_53_297 VDD VSS sg13g2_decap_8
XFILLER_179_483 VDD VSS sg13g2_decap_8
XFILLER_42_35 VDD VSS sg13g2_decap_8
XFILLER_107_1054 VDD VSS sg13g2_decap_8
XFILLER_139_336 VDD VSS sg13g2_decap_8
XFILLER_21_161 VDD VSS sg13g2_decap_8
XFILLER_139_358 VDD VSS sg13g2_decap_4
XFILLER_158_35 VDD VSS sg13g2_decap_8
XFILLER_166_133 VDD VSS sg13g2_decap_8
XFILLER_107_1087 VDD VSS sg13g2_decap_8
XFILLER_158_46 VDD VSS sg13g2_fill_1
X_09228_ _13839_/D _09627_/A0 _13839_/Q _09231_/S VDD VSS sg13g2_mux2_1
XFILLER_127_509 VDD VSS sg13g2_decap_8
XFILLER_10_868 VDD VSS sg13g2_decap_8
XFILLER_154_317 VDD VSS sg13g2_decap_4
XFILLER_177_1008 VDD VSS sg13g2_decap_8
XFILLER_33_1273 VDD VSS sg13g2_fill_2
XFILLER_182_637 VDD VSS sg13g2_decap_8
X_14466__1806 _14466_/RESET_B VDD VSS sg13g2_tiehi
X_09159_ _09159_/Y _09162_/A _09155_/Y _09158_/Y VDD VSS sg13g2_o21ai_1
XFILLER_33_1295 VDD VSS sg13g2_decap_8
XFILLER_135_531 VDD VSS sg13g2_fill_2
XFILLER_181_147 VDD VSS sg13g2_decap_8
X_14502__1770 _14502_/RESET_B VDD VSS sg13g2_tiehi
XFILLER_135_564 VDD VSS sg13g2_decap_8
X_12170_ _12170_/Y _12170_/A _12170_/B _12219_/S VDD VSS sg13g2_nand3_1
XFILLER_68_1347 VDD VSS sg13g2_decap_4
XFILLER_135_575 VDD VSS sg13g2_fill_1
XFILLER_107_277 VDD VSS sg13g2_fill_1
XFILLER_155_1328 VDD VSS sg13g2_decap_8
XFILLER_162_383 VDD VSS sg13g2_decap_8
XFILLER_174_56 VDD VSS sg13g2_decap_8
XFILLER_1_511 VDD VSS sg13g2_decap_8
X_11121_ _11123_/A _11115_/A _11115_/B _11172_/A VDD VSS sg13g2_a21oi_1
XFILLER_122_225 VDD VSS sg13g2_fill_1
XFILLER_150_556 VDD VSS sg13g2_decap_8
X_11052_ _11069_/B _11052_/A _11052_/B _11078_/A _11052_/D VDD VSS sg13g2_nor4_1
XFILLER_49_504 VDD VSS sg13g2_decap_8
XFILLER_49_515 VDD VSS sg13g2_fill_2
XFILLER_1_588 VDD VSS sg13g2_decap_8
XFILLER_7_1127 VDD VSS sg13g2_decap_8
X_10003_ _14586_/D _10102_/A0 _14586_/Q _10003_/S VDD VSS sg13g2_mux2_1
XFILLER_118_1194 VDD VSS sg13g2_fill_2
XFILLER_49_559 VDD VSS sg13g2_decap_4
XFILLER_114_1069 VDD VSS sg13g2_fill_2
XFILLER_40_1222 VDD VSS sg13g2_decap_8
XFILLER_184_0 VDD VSS sg13g2_decap_8
XFILLER_18_902 VDD VSS sg13g2_decap_8
X_14811_ _14811_/Q clkload61/A _14811_/D _14811_/RESET_B VDD VSS sg13g2_dfrbpq_1
XFILLER_97_1009 VDD VSS sg13g2_decap_8
XFILLER_131_1372 VDD VSS sg13g2_decap_8
XFILLER_79_1432 VDD VSS sg13g2_decap_8
XFILLER_29_261 VDD VSS sg13g2_decap_8
XFILLER_131_1394 VDD VSS sg13g2_fill_1
XFILLER_17_434 VDD VSS sg13g2_decap_8
X_14742_ _14742_/Q clkload39/A _14742_/D _14742_/RESET_B VDD VSS sg13g2_dfrbpq_1
X_11954_ _11955_/A _13744_/Q _14096_/Q _14448_/Q _14544_/Q _12040_/A1 _12038_/B1 VDD
+ VSS sg13g2_mux4_1
XFILLER_40_1288 VDD VSS sg13g2_decap_8
XFILLER_123_93 VDD VSS sg13g2_decap_8
X_13954__2318 _13954_/RESET_B VDD VSS sg13g2_tiehi
XFILLER_83_64 VDD VSS sg13g2_decap_8
X_10905_ _10945_/A _14756_/Q _10936_/D VDD VSS sg13g2_nor2_1
X_14673_ _14673_/Q clkload7/A _14673_/D _14673_/RESET_B VDD VSS sg13g2_dfrbpq_1
XFILLER_60_713 VDD VSS sg13g2_decap_8
X_11885_ _11885_/Y _11365_/A _14382_/Q VDD VSS sg13g2_nand2b_1
XFILLER_33_938 VDD VSS sg13g2_decap_8
XFILLER_44_286 VDD VSS sg13g2_decap_8
X_13624_ _13732_/D _13624_/A VDD VSS sg13g2_buf_1
X_10836_ _14929_/D _14929_/Q _10850_/B _10835_/Y VDD VSS sg13g2_a21o_1
XFILLER_73_1031 VDD VSS sg13g2_decap_4
XFILLER_16_91 VDD VSS sg13g2_decap_8
XFILLER_60_768 VDD VSS sg13g2_decap_8
XFILLER_32_459 VDD VSS sg13g2_decap_8
XFILLER_158_601 VDD VSS sg13g2_decap_8
XFILLER_13_651 VDD VSS sg13g2_decap_8
XFILLER_164_1170 VDD VSS sg13g2_decap_8
XFILLER_38_1173 VDD VSS sg13g2_decap_8
X_13555_ _13555_/Y _15007_/Q _13555_/B _13555_/C VDD VSS sg13g2_nor3_1
XFILLER_185_420 VDD VSS sg13g2_decap_8
X_10767_ _10767_/Y _10767_/A _10767_/B VDD VSS sg13g2_nor2_1
XFILLER_12_161 VDD VSS sg13g2_decap_8
XFILLER_41_993 VDD VSS sg13g2_decap_8
XFILLER_160_1045 VDD VSS sg13g2_decap_4
XFILLER_9_644 VDD VSS sg13g2_decap_8
X_12506_ _12506_/X _13734_/Q _14086_/Q _14438_/Q _14534_/Q _12606_/S0 _12606_/S1 VDD
+ VSS sg13g2_mux4_1
XFILLER_12_1302 VDD VSS sg13g2_decap_8
XFILLER_145_306 VDD VSS sg13g2_decap_8
XFILLER_158_689 VDD VSS sg13g2_fill_2
X_13486_ _13502_/D _13486_/A _13486_/B _13486_/C VDD VSS sg13g2_nand3_1
XFILLER_160_1089 VDD VSS sg13g2_fill_2
X_10698_ _10897_/A _14933_/Q _10675_/A _10697_/X VDD VSS sg13g2_a21oi_1
XFILLER_8_154 VDD VSS sg13g2_decap_8
XFILLER_103_1441 VDD VSS sg13g2_decap_4
XFILLER_139_892 VDD VSS sg13g2_decap_8
XFILLER_185_497 VDD VSS sg13g2_decap_8
X_15225_ _15225_/Q _15226_/CLK _15225_/D _15225_/RESET_B VDD VSS sg13g2_dfrbpq_1
X_12437_ _12437_/X _14369_/Q _14401_/Q _14465_/Q _14497_/Q _12452_/S0 _12452_/S1 VDD
+ VSS sg13g2_mux4_1
XFILLER_172_147 VDD VSS sg13g2_decap_8
XFILLER_86_1414 VDD VSS sg13g2_decap_4
XFILLER_12_1379 VDD VSS sg13g2_decap_8
X_15156_ _15156_/Q _15216_/CLK _15156_/D _15156_/RESET_B VDD VSS sg13g2_dfrbpq_1
X_12368_ _12368_/X _14684_/Q _14716_/Q _13756_/Q _13788_/Q _12368_/S0 _12368_/S1 VDD
+ VSS sg13g2_mux4_1
XFILLER_5_861 VDD VSS sg13g2_decap_8
XFILLER_126_597 VDD VSS sg13g2_decap_8
XFILLER_173_1417 VDD VSS sg13g2_decap_8
X_14107_ _14107_/Q _14734_/CLK _14107_/D _14107_/RESET_B VDD VSS sg13g2_dfrbpq_1
X_11319_ _11319_/Y _11314_/Y _11315_/Y _11329_/B1 VDD VSS sg13g2_a21oi_1
XFILLER_4_371 VDD VSS sg13g2_decap_8
X_15087_ _15087_/Q clkload89/A _15087_/D _15087_/RESET_B VDD VSS sg13g2_dfrbpq_1
XFILLER_10_1092 VDD VSS sg13g2_decap_8
XFILLER_141_545 VDD VSS sg13g2_fill_1
X_12299_ _12299_/Y _12280_/A _12279_/B _12277_/X VDD VSS sg13g2_a21oi_1
X_14038_ _14038_/Q clkload41/A _14038_/D _14038_/RESET_B VDD VSS sg13g2_dfrbpq_1
XFILLER_45_1144 VDD VSS sg13g2_decap_8
XFILLER_171_1152 VDD VSS sg13g2_decap_8
XFILLER_67_301 VDD VSS sg13g2_decap_8
XFILLER_110_932 VDD VSS sg13g2_decap_8
XFILLER_80_1057 VDD VSS sg13g2_decap_8
XFILLER_110_965 VDD VSS sg13g2_decap_8
XFILLER_23_1442 VDD VSS sg13g2_decap_8
XFILLER_110_998 VDD VSS sg13g2_decap_8
XFILLER_95_698 VDD VSS sg13g2_decap_4
XFILLER_67_389 VDD VSS sg13g2_decap_8
X_08530_ _08531_/B _07823_/Y _08497_/B _07954_/C VDD VSS sg13g2_o21ai_1
X_15197__2850 _15197_/RESET_B VDD VSS sg13g2_tiehi
XFILLER_82_348 VDD VSS sg13g2_fill_1
XFILLER_35_231 VDD VSS sg13g2_decap_8
XFILLER_169_1070 VDD VSS sg13g2_decap_8
XFILLER_24_905 VDD VSS sg13g2_decap_8
XFILLER_93_1418 VDD VSS sg13g2_fill_1
XFILLER_36_776 VDD VSS sg13g2_decap_8
XFILLER_1_1260 VDD VSS sg13g2_decap_8
X_14544__1728 _14544_/RESET_B VDD VSS sg13g2_tiehi
X_08461_ _08462_/C _08461_/A _08461_/B _08461_/C _08461_/D VDD VSS sg13g2_and4_1
XFILLER_23_404 VDD VSS sg13g2_decap_8
XFILLER_63_584 VDD VSS sg13g2_decap_8
XFILLER_90_381 VDD VSS sg13g2_decap_8
XFILLER_90_392 VDD VSS sg13g2_fill_2
X_08392_ _08394_/C _08367_/Y _08391_/Y _08390_/Y VDD VSS sg13g2_a21oi_1
XFILLER_56_1251 VDD VSS sg13g2_decap_8
XFILLER_177_910 VDD VSS sg13g2_decap_4
XFILLER_143_1232 VDD VSS sg13g2_decap_4
XFILLER_176_420 VDD VSS sg13g2_decap_8
XFILLER_56_1295 VDD VSS sg13g2_decap_4
XFILLER_52_1126 VDD VSS sg13g2_decap_8
XFILLER_17_1257 VDD VSS sg13g2_decap_8
XFILLER_143_1265 VDD VSS sg13g2_fill_2
XFILLER_108_1396 VDD VSS sg13g2_decap_8
XFILLER_177_987 VDD VSS sg13g2_decap_8
XFILLER_104_1238 VDD VSS sg13g2_decap_8
XFILLER_149_689 VDD VSS sg13g2_decap_8
XFILLER_148_177 VDD VSS sg13g2_decap_8
XFILLER_12_49 VDD VSS sg13g2_decap_8
X_09013_ wire422/A wire584/A _09012_/Y _09010_/Y VDD VSS sg13g2_o21ai_1
XFILLER_30_1424 VDD VSS sg13g2_fill_2
XFILLER_117_531 VDD VSS sg13g2_decap_4
XFILLER_145_873 VDD VSS sg13g2_decap_4
XFILLER_176_1030 VDD VSS sg13g2_decap_8
XFILLER_89_1082 VDD VSS sg13g2_decap_8
XFILLER_2_308 VDD VSS sg13g2_decap_8
XFILLER_117_586 VDD VSS sg13g2_fill_2
XFILLER_172_681 VDD VSS sg13g2_fill_2
XFILLER_132_523 VDD VSS sg13g2_decap_8
XFILLER_171_180 VDD VSS sg13g2_decap_8
XFILLER_171_191 VDD VSS sg13g2_fill_2
Xfanout601 _13608_/A1 _08833_/Y VDD VSS sg13g2_buf_1
Xfanout612 _08637_/B _08110_/D VDD VSS sg13g2_buf_1
X_09915_ _14500_/D _14500_/Q _10080_/A0 _09936_/S VDD VSS sg13g2_mux2_1
XFILLER_8_1414 VDD VSS sg13g2_decap_8
XFILLER_63_1233 VDD VSS sg13g2_fill_2
Xfanout623 _13275_/B1 _13297_/A0 VDD VSS sg13g2_buf_1
XFILLER_154_1361 VDD VSS sg13g2_decap_8
Xfanout634 _11792_/B _11655_/B VDD VSS sg13g2_buf_1
XFILLER_113_781 VDD VSS sg13g2_decap_8
Xfanout645 _10850_/B _13294_/B VDD VSS sg13g2_buf_1
XFILLER_63_1255 VDD VSS sg13g2_decap_8
XFILLER_59_835 VDD VSS sg13g2_decap_8
Xfanout656 _10725_/A _08933_/S VDD VSS sg13g2_buf_1
XFILLER_115_1345 VDD VSS sg13g2_fill_1
Xfanout667 _08931_/S _08937_/S VDD VSS sg13g2_buf_1
X_09846_ _14433_/D _14433_/Q _10077_/A0 _09866_/S VDD VSS sg13g2_mux2_1
XFILLER_112_280 VDD VSS sg13g2_fill_1
XFILLER_24_1239 VDD VSS sg13g2_decap_8
XFILLER_100_431 VDD VSS sg13g2_decap_8
Xfanout678 _13440_/A _13407_/A VDD VSS sg13g2_buf_1
XFILLER_150_1247 VDD VSS sg13g2_decap_8
Xfanout689 _08470_/A _07996_/X VDD VSS sg13g2_buf_1
XFILLER_86_665 VDD VSS sg13g2_decap_8
XFILLER_74_805 VDD VSS sg13g2_decap_8
XFILLER_58_356 VDD VSS sg13g2_decap_8
XFILLER_150_1258 VDD VSS sg13g2_fill_1
XFILLER_37_35 VDD VSS sg13g2_decap_8
XFILLER_160_14 VDD VSS sg13g2_decap_8
X_09777_ _14366_/D _09909_/A1 _14366_/Q _09805_/S VDD VSS sg13g2_mux2_1
XFILLER_27_721 VDD VSS sg13g2_decap_8
X_08728_ _08728_/Y _08727_/X _13448_/B _13490_/B VDD VSS sg13g2_a21oi_1
XFILLER_73_348 VDD VSS sg13g2_fill_1
XFILLER_2_1057 VDD VSS sg13g2_decap_8
XFILLER_82_860 VDD VSS sg13g2_fill_1
XFILLER_15_927 VDD VSS sg13g2_decap_8
X_08659_ _08661_/C _08659_/A _08659_/B _08659_/C VDD VSS sg13g2_or3_1
XFILLER_42_713 VDD VSS sg13g2_decap_8
XFILLER_26_264 VDD VSS sg13g2_decap_8
XFILLER_82_893 VDD VSS sg13g2_decap_8
XFILLER_54_584 VDD VSS sg13g2_decap_8
XFILLER_57_1048 VDD VSS sg13g2_decap_8
XFILLER_41_212 VDD VSS sg13g2_decap_8
Xclkbuf_leaf_121_clk_i clkload16/A clkbuf_5_4__f_clk_i/X VDD VSS sg13g2_buf_8
XFILLER_109_1138 VDD VSS sg13g2_decap_8
XFILLER_144_1018 VDD VSS sg13g2_fill_1
XFILLER_14_448 VDD VSS sg13g2_decap_8
X_11670_ _11671_/A _14696_/Q _14728_/Q _13768_/Q _13800_/Q _11759_/A _11970_/C VDD
+ VSS sg13g2_mux4_1
XFILLER_53_56 VDD VSS sg13g2_decap_8
XFILLER_186_228 VDD VSS sg13g2_decap_8
XFILLER_169_56 VDD VSS sg13g2_decap_8
X_10621_ _10632_/D _14882_/Q _10651_/D _10625_/D VDD VSS sg13g2_and3_1
XFILLER_179_280 VDD VSS sg13g2_decap_8
XFILLER_186_239 VDD VSS sg13g2_decap_8
XFILLER_23_982 VDD VSS sg13g2_decap_8
XFILLER_126_1463 VDD VSS sg13g2_decap_8
XFILLER_161_1354 VDD VSS sg13g2_fill_1
XFILLER_128_807 VDD VSS sg13g2_decap_8
X_13340_ _15174_/D hold3148/X _15174_/Q _13477_/S VDD VSS sg13g2_mux2_1
XFILLER_168_987 VDD VSS sg13g2_decap_8
X_10552_ _10554_/A _14865_/Q _10556_/D _14866_/Q VDD VSS sg13g2_a21o_1
XFILLER_127_317 VDD VSS sg13g2_decap_8
XFILLER_161_1398 VDD VSS sg13g2_fill_2
XFILLER_10_665 VDD VSS sg13g2_decap_8
XFILLER_182_434 VDD VSS sg13g2_decap_8
X_13271_ _13271_/Y _13269_/Y _13271_/B _13271_/C VDD VSS sg13g2_nand3b_1
X_10483_ _10487_/B _10489_/C _10489_/D _14849_/Q VDD VSS sg13g2_a21oi_1
X_15010_ _15010_/Q clkload42/A _15010_/D _15010_/RESET_B VDD VSS sg13g2_dfrbpq_1
XFILLER_6_658 VDD VSS sg13g2_decap_8
XFILLER_154_158 VDD VSS sg13g2_decap_8
X_12222_ _12223_/C _12265_/A2 _12219_/X _12221_/Y VDD VSS sg13g2_a21oi_1
XFILLER_108_564 VDD VSS sg13g2_decap_4
XFILLER_120_1073 VDD VSS sg13g2_decap_8
XFILLER_185_77 VDD VSS sg13g2_decap_8
XFILLER_5_168 VDD VSS sg13g2_decap_8
XFILLER_159_1272 VDD VSS sg13g2_fill_2
XFILLER_68_1155 VDD VSS sg13g2_decap_8
XFILLER_135_383 VDD VSS sg13g2_decap_8
XFILLER_151_832 VDD VSS sg13g2_decap_8
XFILLER_155_1114 VDD VSS sg13g2_fill_2
XFILLER_163_692 VDD VSS sg13g2_fill_2
X_12153_ _12198_/D _12151_/Y _12153_/B VDD VSS sg13g2_nand2b_1
XFILLER_150_320 VDD VSS sg13g2_decap_8
XFILLER_155_1158 VDD VSS sg13g2_decap_4
X_11104_ _11104_/Y _11085_/Y _11095_/A _11118_/D VDD VSS sg13g2_o21ai_1
XFILLER_111_718 VDD VSS sg13g2_decap_8
XFILLER_2_875 VDD VSS sg13g2_decap_8
XFILLER_172_1450 VDD VSS sg13g2_decap_8
X_12084_ _12197_/B _12084_/A _13668_/Q VDD VSS sg13g2_xnor2_1
XFILLER_78_97 VDD VSS sg13g2_fill_1
XFILLER_46_1464 VDD VSS sg13g2_decap_8
XFILLER_150_397 VDD VSS sg13g2_decap_8
XFILLER_1_385 VDD VSS sg13g2_decap_8
X_11035_ _11035_/Y _11023_/A _11052_/A _11034_/Y VDD VSS sg13g2_a21oi_1
XFILLER_89_492 VDD VSS sg13g2_decap_8
XFILLER_49_323 VDD VSS sg13g2_decap_8
XFILLER_103_280 VDD VSS sg13g2_fill_2
XFILLER_42_1328 VDD VSS sg13g2_decap_8
XFILLER_77_654 VDD VSS sg13g2_decap_8
XFILLER_134_70 VDD VSS sg13g2_decap_8
XFILLER_133_1467 VDD VSS sg13g2_decap_8
XFILLER_92_602 VDD VSS sg13g2_fill_1
XFILLER_92_613 VDD VSS sg13g2_decap_8
XFILLER_64_315 VDD VSS sg13g2_decap_8
XFILLER_18_754 VDD VSS sg13g2_decap_8
X_12986_ _13058_/D _14906_/Q _13681_/Q VDD VSS sg13g2_xor2_1
XFILLER_79_1251 VDD VSS sg13g2_decap_8
XFILLER_17_231 VDD VSS sg13g2_decap_8
XFILLER_45_540 VDD VSS sg13g2_decap_8
XFILLER_166_1210 VDD VSS sg13g2_decap_8
X_14725_ _14725_/Q _14725_/CLK _14725_/D _14725_/RESET_B VDD VSS sg13g2_dfrbpq_1
X_11937_ _11937_/Y _11914_/A _13673_/Q _11916_/Y VDD VSS sg13g2_a21oi_1
XFILLER_79_1295 VDD VSS sg13g2_decap_8
XFILLER_33_724 VDD VSS sg13g2_decap_8
XFILLER_150_80 VDD VSS sg13g2_decap_8
XFILLER_72_370 VDD VSS sg13g2_decap_8
XFILLER_60_510 VDD VSS sg13g2_decap_8
XFILLER_166_1265 VDD VSS sg13g2_fill_2
XFILLER_72_392 VDD VSS sg13g2_fill_2
XFILLER_33_746 VDD VSS sg13g2_fill_2
X_14656_ _14656_/Q _14656_/CLK _14656_/D _14656_/RESET_B VDD VSS sg13g2_dfrbpq_1
X_11868_ _11868_/Y _11868_/A _11868_/B _11868_/C VDD VSS sg13g2_nand3_1
XFILLER_166_1298 VDD VSS sg13g2_decap_8
XFILLER_177_217 VDD VSS sg13g2_decap_8
XFILLER_32_256 VDD VSS sg13g2_decap_8
XFILLER_92_1473 VDD VSS sg13g2_decap_4
X_13607_ _15166_/D _13606_/Y _08834_/B _13605_/Y VDD VSS sg13g2_a21oi_1
X_10819_ _10821_/B _10844_/B _15122_/Q VDD VSS sg13g2_nand2_1
X_14587_ _14587_/Q clkload60/A _14587_/D _14587_/RESET_B VDD VSS sg13g2_dfrbpq_1
X_11799_ _11800_/B _11770_/A _13064_/B _11779_/Y VDD VSS sg13g2_a21oi_1
XFILLER_119_818 VDD VSS sg13g2_fill_1
XFILLER_9_441 VDD VSS sg13g2_decap_8
X_13538_ _13538_/Y _14994_/Q _13555_/C _15002_/Q _13546_/B2 VDD VSS sg13g2_a22oi_1
XFILLER_173_401 VDD VSS sg13g2_decap_8
XFILLER_145_103 VDD VSS sg13g2_decap_8
XFILLER_158_486 VDD VSS sg13g2_decap_8
XFILLER_146_659 VDD VSS sg13g2_decap_8
XFILLER_185_294 VDD VSS sg13g2_decap_8
X_13469_ _13469_/X _13469_/A _13507_/B _13469_/C wire566/X VDD VSS sg13g2_and4_1
XFILLER_103_1271 VDD VSS sg13g2_decap_4
XFILLER_173_478 VDD VSS sg13g2_decap_8
X_15208_ _15208_/Q _15219_/CLK _15208_/D _15208_/RESET_B VDD VSS sg13g2_dfrbpq_1
XFILLER_12_1176 VDD VSS sg13g2_decap_8
XFILLER_142_821 VDD VSS sg13g2_decap_8
XFILLER_182_990 VDD VSS sg13g2_fill_1
XFILLER_86_1266 VDD VSS sg13g2_decap_8
X_15139_ _15139_/Q clkload77/A _15139_/D _15139_/RESET_B VDD VSS sg13g2_dfrbpq_1
XFILLER_82_1108 VDD VSS sg13g2_fill_2
XFILLER_47_1228 VDD VSS sg13g2_decap_8
XFILLER_82_1119 VDD VSS sg13g2_fill_2
XFILLER_99_256 VDD VSS sg13g2_fill_2
XFILLER_102_718 VDD VSS sg13g2_decap_8
X_07961_ _08577_/B _07961_/A _07961_/B VDD VSS sg13g2_nand2_1
X_09700_ _14292_/D _10163_/A1 _14292_/Q _09706_/S VDD VSS sg13g2_mux2_1
XFILLER_136_1080 VDD VSS sg13g2_decap_8
X_07892_ _08160_/B _08142_/B _08142_/C VDD VSS sg13g2_nor2b_1
XFILLER_96_963 VDD VSS sg13g2_decap_8
XFILLER_68_665 VDD VSS sg13g2_decap_8
X_09631_ _14227_/D _10095_/A0 _14227_/Q _09633_/S VDD VSS sg13g2_mux2_1
XFILLER_83_602 VDD VSS sg13g2_decap_4
XFILLER_110_773 VDD VSS sg13g2_decap_4
XFILLER_110_795 VDD VSS sg13g2_decap_8
XFILLER_67_175 VDD VSS sg13g2_decap_8
XFILLER_67_186 VDD VSS sg13g2_fill_2
X_09562_ _14160_/D _10026_/A0 _14160_/Q _09563_/S VDD VSS sg13g2_mux2_1
XFILLER_3_1344 VDD VSS sg13g2_decap_8
XFILLER_83_668 VDD VSS sg13g2_decap_8
XFILLER_71_819 VDD VSS sg13g2_decap_8
X_08513_ _08517_/C _08560_/A _08511_/X _08512_/Y VDD VSS sg13g2_o21ai_1
XFILLER_93_1204 VDD VSS sg13g2_decap_8
X_09493_ _14093_/D _10089_/A0 _14093_/Q _09493_/S VDD VSS sg13g2_mux2_1
XFILLER_130_39 VDD VSS sg13g2_fill_2
XFILLER_149_1463 VDD VSS sg13g2_fill_2
XFILLER_63_370 VDD VSS sg13g2_decap_8
XFILLER_58_1346 VDD VSS sg13g2_fill_2
XFILLER_184_1354 VDD VSS sg13g2_decap_8
XFILLER_19_1308 VDD VSS sg13g2_decap_8
XFILLER_91_690 VDD VSS sg13g2_decap_8
XFILLER_169_718 VDD VSS sg13g2_decap_8
X_08444_ _08444_/Y _08574_/A _08574_/B VDD VSS sg13g2_nand2_1
XFILLER_23_267 VDD VSS sg13g2_decap_4
X_08375_ _08375_/Y _14992_/Q _08223_/X _08397_/A VDD VSS sg13g2_o21ai_1
Xclkbuf_leaf_53_clk_i clkload70/A clkbuf_leaf_81_clk_i/A VDD VSS sg13g2_buf_8
XFILLER_51_598 VDD VSS sg13g2_decap_4
XFILLER_23_289 VDD VSS sg13g2_fill_1
XFILLER_177_773 VDD VSS sg13g2_decap_8
XFILLER_109_306 VDD VSS sg13g2_decap_8
XFILLER_137_615 VDD VSS sg13g2_decap_8
X_14980__2700 _14980_/RESET_B VDD VSS sg13g2_tiehi
XFILLER_164_423 VDD VSS sg13g2_decap_4
XFILLER_104_1057 VDD VSS sg13g2_decap_4
XFILLER_176_294 VDD VSS sg13g2_decap_8
XFILLER_30_1221 VDD VSS sg13g2_fill_1
XFILLER_178_1125 VDD VSS sg13g2_fill_1
XFILLER_164_456 VDD VSS sg13g2_decap_8
XFILLER_180_905 VDD VSS sg13g2_decap_8
XFILLER_118_862 VDD VSS sg13g2_fill_1
Xclkbuf_leaf_68_clk_i _15219_/CLK clkbuf_leaf_68_clk_i/A VDD VSS sg13g2_buf_8
XFILLER_155_14 VDD VSS sg13g2_decap_8
XFILLER_164_489 VDD VSS sg13g2_fill_2
XFILLER_118_895 VDD VSS sg13g2_decap_8
XFILLER_133_821 VDD VSS sg13g2_decap_8
XFILLER_117_372 VDD VSS sg13g2_decap_8
XFILLER_2_105 VDD VSS sg13g2_decap_8
XFILLER_105_523 VDD VSS sg13g2_decap_8
XFILLER_132_320 VDD VSS sg13g2_decap_8
XFILLER_132_331 VDD VSS sg13g2_decap_8
XFILLER_65_1328 VDD VSS sg13g2_fill_2
XFILLER_3_7 VDD VSS sg13g2_decap_8
XFILLER_160_651 VDD VSS sg13g2_fill_2
Xpicorv32_macro_1514 mem_axi_awprot[1] VDD VSS sg13g2_tielo
XFILLER_133_887 VDD VSS sg13g2_decap_8
XFILLER_156_1478 VDD VSS sg13g2_fill_1
XFILLER_160_684 VDD VSS sg13g2_fill_2
Xfanout1407 _12100_/S0 _12235_/A VDD VSS sg13g2_buf_1
XFILLER_8_1211 VDD VSS sg13g2_decap_8
XFILLER_120_526 VDD VSS sg13g2_fill_1
XFILLER_160_695 VDD VSS sg13g2_fill_2
Xfanout420 _09881_/A0 _09914_/A1 VDD VSS sg13g2_buf_1
Xfanout1418 _11819_/A1 fanout1419/X VDD VSS sg13g2_buf_1
XFILLER_120_537 VDD VSS sg13g2_fill_2
X_15168__2592 _15168_/RESET_B VDD VSS sg13g2_tiehi
Xfanout431 _10076_/A0 wire432/X VDD VSS sg13g2_buf_1
XFILLER_99_790 VDD VSS sg13g2_decap_8
X_15229__3090 _15229_/RESET_B VDD VSS sg13g2_tiehi
Xfanout1429 fanout1429/X fanout1440/X VDD VSS sg13g2_buf_1
Xfanout442 _09153_/S _09059_/S VDD VSS sg13g2_buf_1
XFILLER_28_1172 VDD VSS sg13g2_decap_8
Xfanout453 _12386_/A _12348_/Y VDD VSS sg13g2_buf_1
XFILLER_63_1063 VDD VSS sg13g2_decap_8
Xfanout464 _10030_/S _10036_/S VDD VSS sg13g2_buf_1
XFILLER_87_963 VDD VSS sg13g2_fill_2
XFILLER_48_56 VDD VSS sg13g2_decap_8
XFILLER_171_35 VDD VSS sg13g2_decap_8
Xfanout475 _09830_/S _09826_/S VDD VSS sg13g2_buf_1
XFILLER_115_1164 VDD VSS sg13g2_fill_1
Xfanout486 _09672_/S _09671_/S VDD VSS sg13g2_buf_1
XFILLER_74_602 VDD VSS sg13g2_decap_8
XFILLER_8_1288 VDD VSS sg13g2_decap_8
XFILLER_87_996 VDD VSS sg13g2_fill_1
XFILLER_19_529 VDD VSS sg13g2_fill_1
Xfanout497 _09539_/S _09537_/S VDD VSS sg13g2_buf_1
X_09829_ _14417_/D _09928_/A1 _14417_/Q _09830_/S VDD VSS sg13g2_mux2_1
XFILLER_150_1066 VDD VSS sg13g2_fill_2
XFILLER_74_624 VDD VSS sg13g2_fill_1
XFILLER_59_698 VDD VSS sg13g2_decap_8
XFILLER_74_646 VDD VSS sg13g2_fill_2
XFILLER_58_197 VDD VSS sg13g2_decap_8
XFILLER_41_1361 VDD VSS sg13g2_fill_1
X_12840_ _15023_/D _13211_/A _12840_/B VDD VSS sg13g2_nor2_1
XFILLER_185_1107 VDD VSS sg13g2_fill_2
XFILLER_98_1159 VDD VSS sg13g2_decap_8
XFILLER_27_540 VDD VSS sg13g2_decap_8
XFILLER_104_84 VDD VSS sg13g2_decap_8
XFILLER_76_1402 VDD VSS sg13g2_fill_1
XFILLER_73_167 VDD VSS sg13g2_decap_8
XFILLER_61_318 VDD VSS sg13g2_decap_8
X_12771_ _12771_/X _13977_/Q _14009_/Q _14041_/Q _14073_/Q _12771_/S0 _12771_/S1 VDD
+ VSS sg13g2_mux4_1
XFILLER_27_584 VDD VSS sg13g2_fill_1
XFILLER_15_735 VDD VSS sg13g2_decap_8
XFILLER_76_1446 VDD VSS sg13g2_fill_1
X_14036__2236 _14036_/RESET_B VDD VSS sg13g2_tiehi
X_14510_ _14510_/Q _14685_/CLK _14510_/D _14510_/RESET_B VDD VSS sg13g2_dfrbpq_1
X_11722_ _11722_/Y _11721_/Y _11720_/Y _11707_/Y _11722_/B2 _11723_/A2 VDD VSS sg13g2_a221oi_1
X_13871__2401 _13871_/RESET_B VDD VSS sg13g2_tiehi
XFILLER_14_245 VDD VSS sg13g2_decap_8
XFILLER_9_28 VDD VSS sg13g2_decap_8
XFILLER_120_72 VDD VSS sg13g2_decap_8
XFILLER_147_0 VDD VSS sg13g2_decap_8
X_14441_ _14441_/Q _14729_/CLK _14441_/D _14441_/RESET_B VDD VSS sg13g2_dfrbpq_1
X_11653_ _11653_/X _11646_/X _11647_/X _11650_/X _11651_/X _11542_/B _12191_/B1 VDD
+ VSS sg13g2_mux4_1
XFILLER_35_1121 VDD VSS sg13g2_decap_4
XFILLER_80_54 VDD VSS sg13g2_fill_1
XFILLER_168_762 VDD VSS sg13g2_decap_8
X_10604_ _10613_/A _14878_/Q _14877_/Q _10610_/D VDD VSS sg13g2_nand3_1
XFILLER_11_952 VDD VSS sg13g2_decap_8
X_14372_ _14372_/Q clkload24/A _14372_/D _14372_/RESET_B VDD VSS sg13g2_dfrbpq_1
XFILLER_35_1165 VDD VSS sg13g2_decap_8
X_11584_ _11584_/Y _12001_/A _11584_/B VDD VSS sg13g2_nor2_1
XFILLER_80_76 VDD VSS sg13g2_decap_8
XFILLER_70_1056 VDD VSS sg13g2_decap_8
XFILLER_10_462 VDD VSS sg13g2_decap_8
X_13323_ _13324_/B _15112_/Q _13306_/B _13309_/Y _15065_/Q VDD VSS sg13g2_a22oi_1
XFILLER_128_648 VDD VSS sg13g2_decap_4
XFILLER_13_70 VDD VSS sg13g2_decap_8
XFILLER_155_434 VDD VSS sg13g2_decap_8
XFILLER_167_294 VDD VSS sg13g2_decap_8
X_10535_ _14860_/D _10535_/A _10535_/B _10544_/C VDD VSS sg13g2_and3_1
XFILLER_7_945 VDD VSS sg13g2_decap_8
X_14251__2021 _14251_/RESET_B VDD VSS sg13g2_tiehi
XFILLER_182_231 VDD VSS sg13g2_decap_8
XFILLER_13_1463 VDD VSS sg13g2_decap_8
XFILLER_143_607 VDD VSS sg13g2_decap_8
XFILLER_155_467 VDD VSS sg13g2_decap_8
XFILLER_6_455 VDD VSS sg13g2_decap_8
XFILLER_129_81 VDD VSS sg13g2_fill_2
XFILLER_183_787 VDD VSS sg13g2_decap_8
X_13254_ _15050_/D _13247_/Y _13253_/Y _13021_/A VDD VSS sg13g2_a21oi_1
X_10466_ _10509_/B _10500_/A _10511_/D VDD VSS sg13g2_nand2_1
XFILLER_108_361 VDD VSS sg13g2_decap_8
XFILLER_100_1466 VDD VSS sg13g2_decap_4
X_12205_ _12205_/X _14263_/Q _14295_/Q _14327_/Q _14359_/Q _12213_/S0 _12169_/C VDD
+ VSS sg13g2_mux4_1
XFILLER_89_63 VDD VSS sg13g2_decap_8
XFILLER_83_1406 VDD VSS sg13g2_fill_2
X_13185_ _13225_/B _14919_/Q _13668_/Q VDD VSS sg13g2_xor2_1
XFILLER_159_1091 VDD VSS sg13g2_decap_8
X_10397_ _10401_/A wire220/X _10397_/B _10397_/C VDD VSS sg13g2_nor3_1
XFILLER_97_705 VDD VSS sg13g2_fill_2
XFILLER_9_1008 VDD VSS sg13g2_decap_8
X_12136_ _12136_/X _14709_/Q _14741_/Q _13781_/Q _13813_/Q _11531_/A _12136_/S1 VDD
+ VSS sg13g2_mux4_1
X_14989__2691 _14989_/RESET_B VDD VSS sg13g2_tiehi
XFILLER_36_7 VDD VSS sg13g2_decap_8
XFILLER_2_672 VDD VSS sg13g2_decap_8
XFILLER_1_182 VDD VSS sg13g2_decap_8
X_12067_ _12067_/X _13971_/Q _14003_/Q _14035_/Q _14067_/Q _12070_/S0 _12073_/S1 VDD
+ VSS sg13g2_mux4_1
XFILLER_133_1253 VDD VSS sg13g2_decap_8
X_14833__2971 _14833_/RESET_B VDD VSS sg13g2_tiehi
XFILLER_81_1185 VDD VSS sg13g2_decap_8
XFILLER_38_816 VDD VSS sg13g2_decap_8
X_11018_ _11018_/Y _11022_/B _11014_/Y _11017_/Y VDD VSS sg13g2_a21oi_1
X_16875_ _16875_/X _16875_/A VDD VSS sg13g2_buf_1
XFILLER_65_624 VDD VSS sg13g2_decap_8
XFILLER_38_849 VDD VSS sg13g2_decap_8
XFILLER_133_1297 VDD VSS sg13g2_fill_1
XFILLER_20_1434 VDD VSS sg13g2_decap_8
XFILLER_161_90 VDD VSS sg13g2_decap_8
XFILLER_93_999 VDD VSS sg13g2_decap_8
XFILLER_64_167 VDD VSS sg13g2_decap_4
XFILLER_20_1478 VDD VSS sg13g2_fill_1
X_12969_ _12969_/Y _12967_/Y _12968_/Y _12933_/Y VDD VSS sg13g2_o21ai_1
XFILLER_178_504 VDD VSS sg13g2_decap_8
X_14708_ _14708_/Q _14740_/CLK _14708_/D _14708_/RESET_B VDD VSS sg13g2_dfrbpq_1
XFILLER_166_1073 VDD VSS sg13g2_decap_8
X_14461__1811 _14461_/RESET_B VDD VSS sg13g2_tiehi
XFILLER_21_716 VDD VSS sg13g2_decap_8
XFILLER_53_1210 VDD VSS sg13g2_fill_2
XFILLER_21_738 VDD VSS sg13g2_decap_8
X_14639_ _14639_/Q clkload12/A _14639_/D _14639_/RESET_B VDD VSS sg13g2_dfrbpq_1
XFILLER_57_1390 VDD VSS sg13g2_fill_2
XFILLER_105_1300 VDD VSS sg13g2_decap_8
XFILLER_144_1371 VDD VSS sg13g2_decap_8
XFILLER_159_773 VDD VSS sg13g2_decap_8
XFILLER_18_1374 VDD VSS sg13g2_decap_8
X_08160_ _08160_/Y _08290_/S _08160_/B _08160_/C VDD VSS sg13g2_nor3_1
XFILLER_140_1213 VDD VSS sg13g2_decap_8
XFILLER_20_259 VDD VSS sg13g2_decap_8
XFILLER_158_261 VDD VSS sg13g2_fill_2
XFILLER_174_710 VDD VSS sg13g2_fill_1
XFILLER_186_570 VDD VSS sg13g2_decap_8
XFILLER_146_412 VDD VSS sg13g2_decap_8
XFILLER_174_721 VDD VSS sg13g2_decap_8
XFILLER_186_581 VDD VSS sg13g2_decap_8
XFILLER_118_114 VDD VSS sg13g2_fill_2
XFILLER_101_1208 VDD VSS sg13g2_fill_1
XFILLER_119_659 VDD VSS sg13g2_decap_8
XFILLER_140_1257 VDD VSS sg13g2_decap_8
XFILLER_147_968 VDD VSS sg13g2_fill_1
X_08091_ _08091_/Y _08074_/B _08088_/Y _08090_/Y VDD VSS sg13g2_a21oi_1
XFILLER_109_18 VDD VSS sg13g2_fill_2
XFILLER_173_231 VDD VSS sg13g2_decap_8
XFILLER_118_147 VDD VSS sg13g2_fill_2
X_13734__2538 _13734_/RESET_B VDD VSS sg13g2_tiehi
Xclkload30 clkload30/Y clkload30/A VDD VSS sg13g2_inv_1
XFILLER_62_0 VDD VSS sg13g2_decap_8
XFILLER_162_927 VDD VSS sg13g2_decap_8
X_14494__1778 _14494_/RESET_B VDD VSS sg13g2_tiehi
Xclkload41 clkload41/Y clkload41/A VDD VSS sg13g2_inv_2
XFILLER_175_1309 VDD VSS sg13g2_decap_8
XFILLER_115_810 VDD VSS sg13g2_decap_8
Xclkload52 clkload52/Y clkload52/A VDD VSS sg13g2_inv_1
Xmax_cap1282 _16876_/A _13714_/Q VDD VSS sg13g2_buf_4
Xclkload63 clkload63/Y clkload63/A VDD VSS sg13g2_inv_2
Xmax_cap1293 output41/A _16865_/A VDD VSS sg13g2_buf_4
Xclkload74 clkload74/X clkload74/A VDD VSS sg13g2_buf_8
XFILLER_173_1000 VDD VSS sg13g2_decap_8
Xclkload85 clkload85/Y clkload85/A VDD VSS sg13g2_inv_2
XFILLER_161_459 VDD VSS sg13g2_decap_8
XFILLER_86_1063 VDD VSS sg13g2_fill_1
XFILLER_115_865 VDD VSS sg13g2_decap_8
XFILLER_0_609 VDD VSS sg13g2_decap_8
XFILLER_138_1153 VDD VSS sg13g2_fill_1
XFILLER_47_1058 VDD VSS sg13g2_decap_4
XFILLER_142_684 VDD VSS sg13g2_decap_8
X_08993_ _08993_/X _14899_/Q _12859_/A _10681_/A _10674_/A VDD VSS sg13g2_and4_1
XFILLER_134_1017 VDD VSS sg13g2_decap_8
XFILLER_25_1301 VDD VSS sg13g2_decap_8
X_14114__2158 _14114_/RESET_B VDD VSS sg13g2_tiehi
XFILLER_141_194 VDD VSS sg13g2_decap_8
XFILLER_151_1320 VDD VSS sg13g2_decap_8
X_07944_ _07961_/A _07942_/A _07928_/Y _07906_/B VDD VSS sg13g2_o21ai_1
XFILLER_87_259 VDD VSS sg13g2_decap_8
XFILLER_130_879 VDD VSS sg13g2_decap_4
XFILLER_151_1342 VDD VSS sg13g2_decap_8
XFILLER_60_1236 VDD VSS sg13g2_decap_4
XFILLER_5_1428 VDD VSS sg13g2_decap_8
X_07875_ _07905_/A _07876_/A _07876_/B VDD VSS sg13g2_and2_1
XFILLER_25_1378 VDD VSS sg13g2_decap_8
XFILLER_112_1337 VDD VSS sg13g2_decap_8
XFILLER_99_1435 VDD VSS sg13g2_decap_4
XFILLER_84_944 VDD VSS sg13g2_decap_4
XFILLER_83_421 VDD VSS sg13g2_decap_8
XFILLER_110_592 VDD VSS sg13g2_decap_8
X_09614_ _14210_/D _10078_/A0 _14210_/Q _09633_/S VDD VSS sg13g2_mux2_1
XFILLER_186_1427 VDD VSS sg13g2_decap_8
XFILLER_3_1141 VDD VSS sg13g2_decap_8
XFILLER_37_860 VDD VSS sg13g2_decap_8
XFILLER_71_616 VDD VSS sg13g2_decap_8
X_09545_ _14143_/D _10075_/A0 _14143_/Q _09572_/S VDD VSS sg13g2_mux2_1
XFILLER_70_115 VDD VSS sg13g2_decap_8
XFILLER_52_830 VDD VSS sg13g2_decap_8
XFILLER_34_14 VDD VSS sg13g2_decap_8
XFILLER_19_1105 VDD VSS sg13g2_decap_8
X_09476_ _14076_/D _10039_/A0 _14076_/Q _09478_/S VDD VSS sg13g2_mux2_1
XFILLER_54_1007 VDD VSS sg13g2_fill_1
XFILLER_54_1018 VDD VSS sg13g2_fill_2
XFILLER_180_1026 VDD VSS sg13g2_decap_8
XFILLER_93_1078 VDD VSS sg13g2_decap_8
X_08427_ _08427_/X _11726_/A _11706_/A _08487_/A3 _08427_/A3 _08009_/S _08079_/S VDD
+ VSS sg13g2_mux4_1
XFILLER_58_1198 VDD VSS sg13g2_decap_8
XFILLER_140_7 VDD VSS sg13g2_decap_8
XFILLER_145_1157 VDD VSS sg13g2_fill_1
XFILLER_180_1037 VDD VSS sg13g2_fill_2
XFILLER_12_749 VDD VSS sg13g2_decap_8
XFILLER_138_902 VDD VSS sg13g2_fill_1
XFILLER_71_1354 VDD VSS sg13g2_decap_8
X_08358_ _08358_/Y _08412_/A _08275_/B _08357_/Y VDD VSS sg13g2_o21ai_1
XFILLER_11_259 VDD VSS sg13g2_decap_8
Xclkload2 clkload2/X clkload2/A VDD VSS sg13g2_buf_8
XFILLER_177_581 VDD VSS sg13g2_decap_8
XFILLER_123_1466 VDD VSS sg13g2_decap_4
XFILLER_50_35 VDD VSS sg13g2_decap_8
XFILLER_50_46 VDD VSS sg13g2_fill_1
X_08289_ _08289_/Y _08265_/X _08315_/C _08315_/A VDD VSS sg13g2_a21oi_1
XFILLER_165_765 VDD VSS sg13g2_decap_8
XFILLER_166_35 VDD VSS sg13g2_decap_8
XFILLER_153_927 VDD VSS sg13g2_decap_4
X_10320_ _10322_/A _14799_/Q _10414_/B _14800_/Q VDD VSS sg13g2_a21o_1
XFILLER_125_629 VDD VSS sg13g2_decap_8
X_14324__1948 _14324_/RESET_B VDD VSS sg13g2_tiehi
XFILLER_30_1062 VDD VSS sg13g2_decap_4
XFILLER_180_746 VDD VSS sg13g2_decap_4
XFILLER_106_832 VDD VSS sg13g2_decap_8
X_10251_ _14778_/D _10251_/A _10258_/D VDD VSS sg13g2_nor2_1
XFILLER_4_959 VDD VSS sg13g2_decap_8
XFILLER_106_876 VDD VSS sg13g2_decap_8
XFILLER_121_802 VDD VSS sg13g2_decap_8
XFILLER_133_662 VDD VSS sg13g2_decap_8
XFILLER_3_469 VDD VSS sg13g2_decap_8
X_10182_ _10182_/Y _10182_/A _10182_/B VDD VSS sg13g2_nand2_1
XFILLER_59_55 VDD VSS sg13g2_decap_8
Xfanout1204 _08882_/A1 _14970_/Q VDD VSS sg13g2_buf_1
XFILLER_117_1248 VDD VSS sg13g2_decap_8
XFILLER_156_1297 VDD VSS sg13g2_fill_2
XFILLER_182_56 VDD VSS sg13g2_decap_8
Xfanout1215 _08258_/C _08867_/A1 VDD VSS sg13g2_buf_1
XFILLER_132_194 VDD VSS sg13g2_decap_8
Xfanout1226 _11454_/A _14962_/Q VDD VSS sg13g2_buf_1
XFILLER_121_868 VDD VSS sg13g2_fill_1
Xfanout1237 _12867_/C _11290_/A VDD VSS sg13g2_buf_1
XFILLER_78_259 VDD VSS sg13g2_fill_2
XFILLER_120_356 VDD VSS sg13g2_decap_4
X_14990_ _14990_/Q clkload79/A _14990_/D _14990_/RESET_B VDD VSS sg13g2_dfrbpq_1
Xfanout250 _12271_/A _11723_/A2 VDD VSS sg13g2_buf_1
Xfanout1248 _13190_/A _14918_/Q VDD VSS sg13g2_buf_1
Xfanout261 _09919_/A1 wire262/X VDD VSS sg13g2_buf_1
Xfanout1259 _10651_/D _14881_/Q VDD VSS sg13g2_buf_1
Xfanout272 _09917_/A1 _09719_/A0 VDD VSS sg13g2_buf_1
XFILLER_87_771 VDD VSS sg13g2_decap_8
X_13941_ _13941_/Q _14741_/CLK _13941_/D _13941_/RESET_B VDD VSS sg13g2_dfrbpq_1
Xfanout283 _09903_/S _09902_/S VDD VSS sg13g2_buf_1
XFILLER_93_229 VDD VSS sg13g2_fill_1
XFILLER_8_1085 VDD VSS sg13g2_decap_8
XFILLER_75_21 VDD VSS sg13g2_decap_8
XFILLER_59_473 VDD VSS sg13g2_decap_8
XFILLER_101_570 VDD VSS sg13g2_fill_2
XFILLER_19_315 VDD VSS sg13g2_decap_8
Xfanout294 _09428_/S _09440_/S VDD VSS sg13g2_buf_1
XFILLER_130_1437 VDD VSS sg13g2_fill_1
X_13872_ _13872_/Q clkload22/A _13872_/D _13872_/RESET_B VDD VSS sg13g2_dfrbpq_1
XFILLER_74_454 VDD VSS sg13g2_decap_8
XFILLER_47_668 VDD VSS sg13g2_fill_2
XFILLER_90_914 VDD VSS sg13g2_decap_8
XFILLER_75_87 VDD VSS sg13g2_decap_8
XFILLER_74_465 VDD VSS sg13g2_fill_1
XFILLER_46_156 VDD VSS sg13g2_fill_1
XFILLER_75_999 VDD VSS sg13g2_fill_2
XFILLER_75_98 VDD VSS sg13g2_fill_1
X_14269__2003 _14269_/RESET_B VDD VSS sg13g2_tiehi
X_12823_ _12824_/B _12878_/D _12822_/X _12816_/Y _13048_/B _12820_/Y VDD VSS sg13g2_a221oi_1
XFILLER_76_1210 VDD VSS sg13g2_decap_8
XFILLER_46_178 VDD VSS sg13g2_decap_8
XFILLER_34_329 VDD VSS sg13g2_decap_8
XFILLER_28_893 VDD VSS sg13g2_decap_8
XFILLER_128_1311 VDD VSS sg13g2_decap_8
XFILLER_15_532 VDD VSS sg13g2_decap_8
X_12754_ _12754_/X _14392_/Q _14424_/Q _14488_/Q _14520_/Q _12754_/S0 _12754_/S1 VDD
+ VSS sg13g2_mux4_1
XFILLER_43_863 VDD VSS sg13g2_decap_4
X_11705_ _11705_/Y _11706_/A _13679_/Q VDD VSS sg13g2_nand2_1
XFILLER_128_1377 VDD VSS sg13g2_decap_8
X_12685_ _12685_/X _13971_/Q _14003_/Q _14035_/Q _14067_/Q _12689_/S0 _12689_/S1 VDD
+ VSS sg13g2_mux4_1
XFILLER_30_524 VDD VSS sg13g2_decap_4
XFILLER_163_1268 VDD VSS sg13g2_decap_8
X_14424_ _14424_/Q clkload25/A _14424_/D _14424_/RESET_B VDD VSS sg13g2_dfrbpq_1
X_11636_ _11637_/B _11636_/A _11636_/B _11636_/C VDD VSS sg13g2_nand3_1
XFILLER_30_557 VDD VSS sg13g2_decap_8
XFILLER_156_721 VDD VSS sg13g2_decap_8
XFILLER_155_220 VDD VSS sg13g2_decap_8
XFILLER_128_445 VDD VSS sg13g2_decap_8
X_14355_ _14355_/Q clkload39/A _14355_/D _14355_/RESET_B VDD VSS sg13g2_dfrbpq_1
X_11567_ _11638_/B _11502_/A _13685_/Q _12942_/B _11526_/A VDD VSS sg13g2_a22oi_1
XFILLER_7_742 VDD VSS sg13g2_decap_8
XFILLER_144_916 VDD VSS sg13g2_decap_8
XFILLER_128_478 VDD VSS sg13g2_decap_8
XFILLER_13_1260 VDD VSS sg13g2_decap_8
X_13306_ _15059_/D _13324_/A _13306_/B _13306_/C VDD VSS sg13g2_nor3_1
X_10518_ _10519_/C _14855_/Q _10579_/B VDD VSS sg13g2_and2_1
X_14286_ _14286_/Q _14685_/CLK _14286_/D _14286_/RESET_B VDD VSS sg13g2_dfrbpq_1
XFILLER_6_252 VDD VSS sg13g2_decap_8
XFILLER_115_117 VDD VSS sg13g2_decap_8
X_11498_ _11498_/Y _11498_/A1 _11496_/X _11497_/Y VDD VSS sg13g2_o21ai_1
XFILLER_183_595 VDD VSS sg13g2_decap_8
XFILLER_155_297 VDD VSS sg13g2_decap_8
X_13237_ _13237_/Y _13234_/Y _13235_/Y _13236_/Y VDD VSS sg13g2_a21oi_1
XFILLER_100_1263 VDD VSS sg13g2_decap_8
XFILLER_143_459 VDD VSS sg13g2_decap_8
X_10449_ _10450_/C _10647_/A _14839_/Q _10647_/D _10514_/A VDD VSS sg13g2_and4_1
XFILLER_112_802 VDD VSS sg13g2_fill_2
XFILLER_156_90 VDD VSS sg13g2_decap_8
XFILLER_124_673 VDD VSS sg13g2_decap_8
XFILLER_152_982 VDD VSS sg13g2_decap_4
X_13168_ _13225_/A _13190_/A _13190_/B VDD VSS sg13g2_xor2_1
XFILLER_48_1367 VDD VSS sg13g2_decap_8
XFILLER_97_524 VDD VSS sg13g2_fill_1
XFILLER_83_1258 VDD VSS sg13g2_decap_8
XFILLER_174_1386 VDD VSS sg13g2_decap_8
XFILLER_111_334 VDD VSS sg13g2_decap_8
XFILLER_170_1228 VDD VSS sg13g2_fill_2
X_12119_ _12119_/Y _12099_/Y _12101_/X _12192_/A VDD VSS sg13g2_o21ai_1
X_13099_ _13099_/Y _13166_/A1 _13098_/X _13097_/Y VDD VSS sg13g2_a21oi_1
XFILLER_85_708 VDD VSS sg13g2_decap_8
XFILLER_69_259 VDD VSS sg13g2_decap_8
XFILLER_46_1091 VDD VSS sg13g2_decap_8
XFILLER_120_890 VDD VSS sg13g2_decap_8
XFILLER_37_123 VDD VSS sg13g2_decap_8
X_07660_ _07766_/B _10210_/D _14749_/Q VDD VSS sg13g2_nand2b_1
XFILLER_168_1113 VDD VSS sg13g2_fill_2
X_16858_ _16858_/X _16858_/A VDD VSS sg13g2_buf_1
XFILLER_81_903 VDD VSS sg13g2_decap_8
XFILLER_26_808 VDD VSS sg13g2_decap_8
XFILLER_92_240 VDD VSS sg13g2_fill_1
XFILLER_53_605 VDD VSS sg13g2_decap_8
XFILLER_0_1303 VDD VSS sg13g2_decap_8
XFILLER_168_1135 VDD VSS sg13g2_fill_2
XFILLER_19_860 VDD VSS sg13g2_decap_8
XFILLER_20_1231 VDD VSS sg13g2_decap_8
XFILLER_1_84 VDD VSS sg13g2_decap_8
XFILLER_53_616 VDD VSS sg13g2_fill_1
XFILLER_37_167 VDD VSS sg13g2_decap_8
XFILLER_168_1146 VDD VSS sg13g2_fill_1
XFILLER_25_318 VDD VSS sg13g2_decap_8
XFILLER_129_1108 VDD VSS sg13g2_decap_8
XFILLER_168_1157 VDD VSS sg13g2_decap_8
XFILLER_94_1310 VDD VSS sg13g2_decap_8
XFILLER_53_649 VDD VSS sg13g2_decap_8
XFILLER_111_1392 VDD VSS sg13g2_decap_8
XFILLER_81_969 VDD VSS sg13g2_decap_8
XFILLER_52_126 VDD VSS sg13g2_decap_8
XFILLER_185_1460 VDD VSS sg13g2_decap_8
XFILLER_18_392 VDD VSS sg13g2_decap_8
X_09330_ _13937_/D _09730_/A0 _13937_/Q _09331_/S VDD VSS sg13g2_mux2_1
XFILLER_179_813 VDD VSS sg13g2_fill_1
XFILLER_178_301 VDD VSS sg13g2_decap_8
XFILLER_94_1376 VDD VSS sg13g2_decap_8
XFILLER_181_1346 VDD VSS sg13g2_decap_4
XFILLER_21_513 VDD VSS sg13g2_decap_8
X_09261_ _13870_/D _13870_/Q _09925_/A1 _09261_/S VDD VSS sg13g2_mux2_1
XFILLER_94_1398 VDD VSS sg13g2_decap_8
XFILLER_34_896 VDD VSS sg13g2_decap_8
XFILLER_146_1477 VDD VSS sg13g2_fill_2
X_08212_ _08212_/X _13529_/A _08688_/D _08688_/A VDD VSS sg13g2_and3_1
XFILLER_178_378 VDD VSS sg13g2_decap_8
XFILLER_18_1171 VDD VSS sg13g2_decap_8
X_09192_ _13808_/D _13808_/Q _10159_/A1 _09193_/S VDD VSS sg13g2_mux2_1
XFILLER_105_1130 VDD VSS sg13g2_decap_8
XFILLER_119_401 VDD VSS sg13g2_fill_1
XFILLER_147_710 VDD VSS sg13g2_decap_8
XFILLER_119_412 VDD VSS sg13g2_fill_2
X_13967__2305 _13967_/RESET_B VDD VSS sg13g2_tiehi
XFILLER_53_1073 VDD VSS sg13g2_decap_8
XFILLER_140_1032 VDD VSS sg13g2_decap_8
X_08143_ _08143_/Y _08182_/B _08141_/Y _08142_/Y VDD VSS sg13g2_o21ai_1
XFILLER_14_1057 VDD VSS sg13g2_decap_8
XFILLER_174_540 VDD VSS sg13g2_decap_8
X_08074_ _08074_/X _08290_/S _08074_/B _08074_/C VDD VSS sg13g2_and3_1
XFILLER_140_1098 VDD VSS sg13g2_decap_8
XFILLER_162_724 VDD VSS sg13g2_decap_8
XFILLER_175_1106 VDD VSS sg13g2_decap_4
XFILLER_175_1117 VDD VSS sg13g2_decap_4
XFILLER_179_1286 VDD VSS sg13g2_decap_4
XFILLER_88_1169 VDD VSS sg13g2_fill_1
XFILLER_106_139 VDD VSS sg13g2_fill_1
XFILLER_134_448 VDD VSS sg13g2_fill_1
XFILLER_179_1297 VDD VSS sg13g2_decap_8
XFILLER_20_49 VDD VSS sg13g2_decap_8
XFILLER_0_406 VDD VSS sg13g2_decap_8
XFILLER_66_1456 VDD VSS sg13g2_decap_8
XFILLER_103_824 VDD VSS sg13g2_decap_8
XFILLER_88_535 VDD VSS sg13g2_decap_8
XFILLER_29_14 VDD VSS sg13g2_decap_8
XFILLER_103_879 VDD VSS sg13g2_fill_1
X_08976_ _08977_/B _10675_/B _10675_/C VDD VSS sg13g2_nor2_1
XFILLER_9_1372 VDD VSS sg13g2_decap_8
XFILLER_64_1191 VDD VSS sg13g2_decap_8
XFILLER_29_613 VDD VSS sg13g2_fill_1
X_07927_ _07927_/Y _07922_/Y _07904_/A _07926_/X VDD VSS sg13g2_a21oi_1
XFILLER_5_1225 VDD VSS sg13g2_decap_8
XFILLER_57_933 VDD VSS sg13g2_decap_8
XFILLER_99_1221 VDD VSS sg13g2_fill_1
XFILLER_21_1006 VDD VSS sg13g2_decap_8
XFILLER_99_1232 VDD VSS sg13g2_decap_8
XFILLER_29_635 VDD VSS sg13g2_decap_4
XFILLER_25_1175 VDD VSS sg13g2_decap_8
X_14947__2743 _14947_/RESET_B VDD VSS sg13g2_tiehi
X_07858_ _07858_/X _15014_/Q _07859_/B VDD VSS sg13g2_and2_1
XFILLER_56_454 VDD VSS sg13g2_decap_8
XFILLER_95_1118 VDD VSS sg13g2_decap_4
XFILLER_83_262 VDD VSS sg13g2_decap_8
XFILLER_84_796 VDD VSS sg13g2_decap_8
XFILLER_56_487 VDD VSS sg13g2_decap_8
XFILLER_16_329 VDD VSS sg13g2_decap_8
XFILLER_44_638 VDD VSS sg13g2_decap_8
X_07789_ _08391_/B _07790_/A _15003_/Q VDD VSS sg13g2_nor2_1
XFILLER_43_126 VDD VSS sg13g2_decap_4
X_09528_ _14127_/D _10091_/A0 _14127_/Q _09537_/S VDD VSS sg13g2_mux2_1
XFILLER_52_660 VDD VSS sg13g2_decap_8
XFILLER_24_351 VDD VSS sg13g2_decap_8
X_09459_ _14060_/D _09558_/A0 _14060_/Q _09461_/S VDD VSS sg13g2_mux2_1
XFILLER_101_74 VDD VSS sg13g2_fill_2
XFILLER_12_546 VDD VSS sg13g2_decap_8
X_12470_ _12471_/B _13685_/Q _12693_/A2 _12469_/X _12415_/A _12763_/C1 VDD VSS sg13g2_a221oi_1
XFILLER_40_888 VDD VSS sg13g2_decap_8
XFILLER_8_539 VDD VSS sg13g2_decap_8
XFILLER_71_1173 VDD VSS sg13g2_decap_4
XFILLER_32_1124 VDD VSS sg13g2_fill_1
XFILLER_177_56 VDD VSS sg13g2_decap_8
X_11421_ _11422_/A _13951_/Q _13983_/Q _14015_/Q _14047_/Q _11415_/S _11401_/C VDD
+ VSS sg13g2_mux4_1
XFILLER_36_1293 VDD VSS sg13g2_decap_8
X_14557__1715 _14557_/RESET_B VDD VSS sg13g2_tiehi
X_15125__2802 _15125_/RESET_B VDD VSS sg13g2_tiehi
XFILLER_126_905 VDD VSS sg13g2_decap_4
XFILLER_10_1400 VDD VSS sg13g2_decap_8
XFILLER_138_787 VDD VSS sg13g2_decap_8
X_14140_ _14140_/Q _14652_/CLK _14140_/D _14140_/RESET_B VDD VSS sg13g2_dfrbpq_1
XFILLER_126_938 VDD VSS sg13g2_decap_8
X_11352_ _11361_/B _11346_/Y _11351_/Y _11831_/B1 VDD VSS sg13g2_o21ai_1
XFILLER_137_286 VDD VSS sg13g2_decap_8
XFILLER_153_735 VDD VSS sg13g2_fill_1
XFILLER_180_532 VDD VSS sg13g2_decap_8
X_10303_ _10306_/C _14794_/Q _10299_/Y hold3245/X VDD VSS sg13g2_a21oi_1
X_14071_ _14071_/Q clkload47/A _14071_/D _14071_/RESET_B VDD VSS sg13g2_dfrbpq_1
X_11283_ _11283_/Y _11283_/A _12324_/B VDD VSS sg13g2_nand2_1
XFILLER_4_756 VDD VSS sg13g2_decap_8
XFILLER_106_651 VDD VSS sg13g2_decap_4
XFILLER_153_779 VDD VSS sg13g2_decap_4
XFILLER_10_1477 VDD VSS sg13g2_fill_2
X_13022_ _13042_/A _14908_/Q _13679_/Q VDD VSS sg13g2_nand2_1
XFILLER_105_150 VDD VSS sg13g2_fill_2
X_10234_ _10234_/Y _14771_/Q _14772_/Q _14773_/Q _10234_/D VDD VSS sg13g2_nand4_1
XFILLER_3_266 VDD VSS sg13g2_decap_8
XFILLER_106_695 VDD VSS sg13g2_fill_2
XFILLER_133_470 VDD VSS sg13g2_decap_8
XFILLER_121_632 VDD VSS sg13g2_decap_8
XFILLER_133_492 VDD VSS sg13g2_decap_8
Xfanout1001 _13448_/B _15200_/Q VDD VSS sg13g2_buf_1
Xfanout1012 _13506_/A _15128_/Q VDD VSS sg13g2_buf_1
X_10165_ _14742_/D _14742_/Q _10165_/A1 _10167_/S VDD VSS sg13g2_mux2_1
XFILLER_120_131 VDD VSS sg13g2_decap_8
Xfanout1023 _07727_/B _13260_/B VDD VSS sg13g2_buf_1
XFILLER_86_42 VDD VSS sg13g2_decap_8
Xfanout1034 _08497_/A _08552_/A1 VDD VSS sg13g2_buf_1
XFILLER_43_1220 VDD VSS sg13g2_decap_4
Xfanout1045 _10924_/B1 _10898_/B1 VDD VSS sg13g2_buf_1
XFILLER_86_53 VDD VSS sg13g2_fill_1
XFILLER_121_687 VDD VSS sg13g2_decap_8
Xfanout1056 _07720_/B _15068_/Q VDD VSS sg13g2_buf_1
XFILLER_0_995 VDD VSS sg13g2_decap_8
XFILLER_134_1370 VDD VSS sg13g2_decap_8
XFILLER_86_75 VDD VSS sg13g2_decap_8
XFILLER_43_1253 VDD VSS sg13g2_decap_8
X_14973_ _14973_/Q clkload57/A _14973_/D _14973_/RESET_B VDD VSS sg13g2_dfrbpq_1
Xfanout1067 _10004_/B _09707_/B VDD VSS sg13g2_buf_1
X_10096_ _14676_/D _10096_/A0 _14676_/Q _10096_/S VDD VSS sg13g2_mux2_1
XFILLER_102_890 VDD VSS sg13g2_fill_2
XFILLER_120_186 VDD VSS sg13g2_decap_8
XFILLER_19_112 VDD VSS sg13g2_decap_8
Xfanout1078 _09009_/S _13305_/A VDD VSS sg13g2_buf_1
XFILLER_59_281 VDD VSS sg13g2_decap_8
XFILLER_169_1400 VDD VSS sg13g2_decap_8
Xfanout1089 _11241_/C _08831_/B VDD VSS sg13g2_buf_1
X_13924_ _13924_/Q _14744_/CLK _13924_/D _13924_/RESET_B VDD VSS sg13g2_dfrbpq_1
XFILLER_78_1305 VDD VSS sg13g2_decap_8
XFILLER_130_1267 VDD VSS sg13g2_decap_8
XFILLER_19_91 VDD VSS sg13g2_decap_8
XFILLER_48_999 VDD VSS sg13g2_fill_2
XFILLER_62_402 VDD VSS sg13g2_decap_8
XFILLER_34_104 VDD VSS sg13g2_fill_1
XFILLER_19_189 VDD VSS sg13g2_decap_8
X_13855_ _13855_/Q _14540_/CLK _13855_/D _13855_/RESET_B VDD VSS sg13g2_dfrbpq_1
XFILLER_34_115 VDD VSS sg13g2_decap_8
XFILLER_16_830 VDD VSS sg13g2_fill_2
XFILLER_63_958 VDD VSS sg13g2_decap_8
X_12806_ _12806_/Y _14863_/Q _12895_/B VDD VSS sg13g2_nand2_1
XFILLER_90_766 VDD VSS sg13g2_decap_4
XFILLER_90_777 VDD VSS sg13g2_decap_8
X_13786_ _13786_/Q _14620_/CLK _13786_/D _13786_/RESET_B VDD VSS sg13g2_dfrbpq_1
X_10998_ _10998_/Y _11027_/B1 _10992_/X _10997_/Y VDD VSS sg13g2_a21oi_1
XFILLER_76_1073 VDD VSS sg13g2_decap_8
X_12737_ _12750_/A _12779_/A1 _12737_/A2 _15017_/Q VDD VSS sg13g2_a21oi_1
XFILLER_124_1038 VDD VSS sg13g2_decap_8
XFILLER_148_529 VDD VSS sg13g2_decap_8
X_12668_ _12668_/X _14258_/Q _14290_/Q _14322_/Q _14354_/Q _12668_/S0 _12668_/S1 VDD
+ VSS sg13g2_mux4_1
XFILLER_50_1202 VDD VSS sg13g2_decap_8
XFILLER_15_1333 VDD VSS sg13g2_decap_8
X_15208__3069 _15208_/RESET_B VDD VSS sg13g2_tiehi
XFILLER_30_376 VDD VSS sg13g2_decap_8
XFILLER_175_348 VDD VSS sg13g2_decap_8
X_14407_ _14407_/Q _14503_/CLK _14407_/D _14407_/RESET_B VDD VSS sg13g2_dfrbpq_1
XFILLER_141_1352 VDD VSS sg13g2_decap_8
X_11619_ _11619_/Y _11741_/A _13926_/Q _11802_/B VDD VSS sg13g2_a21oi_1
XFILLER_89_1412 VDD VSS sg13g2_decap_8
XFILLER_117_905 VDD VSS sg13g2_fill_2
X_12599_ _12599_/X _14573_/Q _14605_/Q _14637_/Q _14669_/Q _12600_/S0 _12600_/S1 VDD
+ VSS sg13g2_mux4_1
X_14338_ _14338_/Q clkload40/A _14338_/D _14338_/RESET_B VDD VSS sg13g2_dfrbpq_1
XFILLER_183_392 VDD VSS sg13g2_decap_8
XFILLER_116_448 VDD VSS sg13g2_decap_8
XFILLER_144_768 VDD VSS sg13g2_decap_8
X_14269_ _14269_/Q clkload59/A _14269_/D _14269_/RESET_B VDD VSS sg13g2_dfrbpq_1
XFILLER_143_256 VDD VSS sg13g2_decap_8
XFILLER_100_1082 VDD VSS sg13g2_decap_8
XFILLER_125_982 VDD VSS sg13g2_decap_8
XFILLER_143_278 VDD VSS sg13g2_decap_8
XFILLER_125_993 VDD VSS sg13g2_fill_2
XFILLER_83_1033 VDD VSS sg13g2_fill_2
XFILLER_48_1153 VDD VSS sg13g2_fill_2
XFILLER_97_310 VDD VSS sg13g2_decap_8
XFILLER_140_941 VDD VSS sg13g2_decap_8
XFILLER_135_1134 VDD VSS sg13g2_decap_8
XFILLER_97_332 VDD VSS sg13g2_decap_8
XFILLER_111_120 VDD VSS sg13g2_decap_4
XFILLER_170_1025 VDD VSS sg13g2_decap_8
X_08830_ _08830_/X _13613_/B _13613_/C _08830_/C VDD VSS sg13g2_or3_1
XFILLER_48_1197 VDD VSS sg13g2_decap_8
XFILLER_44_1039 VDD VSS sg13g2_decap_8
XFILLER_39_900 VDD VSS sg13g2_decap_8
XFILLER_140_985 VDD VSS sg13g2_decap_8
XFILLER_112_687 VDD VSS sg13g2_decap_8
XFILLER_61_1331 VDD VSS sg13g2_fill_1
XFILLER_25_0 VDD VSS sg13g2_decap_8
XFILLER_100_838 VDD VSS sg13g2_fill_2
X_08761_ _08761_/Y _13129_/B _08781_/B VDD VSS sg13g2_nor2_1
XFILLER_111_175 VDD VSS sg13g2_decap_8
X_14031__2241 _14031_/RESET_B VDD VSS sg13g2_tiehi
X_07712_ _07713_/A _08831_/B _11241_/A VDD VSS sg13g2_nor2_1
XFILLER_38_443 VDD VSS sg13g2_decap_4
X_08692_ _08693_/C _08692_/A _08692_/B _08692_/C VDD VSS sg13g2_nand3_1
XFILLER_61_1397 VDD VSS sg13g2_decap_8
XFILLER_22_1359 VDD VSS sg13g2_decap_8
XFILLER_66_774 VDD VSS sg13g2_fill_1
XFILLER_0_1100 VDD VSS sg13g2_decap_8
X_07643_ _10299_/A _14785_/Q VDD VSS sg13g2_inv_1
X_14635__1637 _14635_/RESET_B VDD VSS sg13g2_tiehi
XFILLER_81_733 VDD VSS sg13g2_decap_8
XFILLER_65_284 VDD VSS sg13g2_fill_2
XFILLER_54_947 VDD VSS sg13g2_decap_8
XFILLER_26_638 VDD VSS sg13g2_decap_8
XFILLER_20_1050 VDD VSS sg13g2_decap_8
XFILLER_20_1061 VDD VSS sg13g2_fill_2
XFILLER_25_159 VDD VSS sg13g2_decap_8
XFILLER_81_788 VDD VSS sg13g2_decap_8
XFILLER_0_1177 VDD VSS sg13g2_decap_8
X_09313_ _13920_/D _10143_/A1 _13920_/Q _09338_/S VDD VSS sg13g2_mux2_1
XFILLER_81_799 VDD VSS sg13g2_fill_1
XFILLER_146_1241 VDD VSS sg13g2_fill_2
XFILLER_15_49 VDD VSS sg13g2_decap_8
XFILLER_142_1105 VDD VSS sg13g2_decap_8
XFILLER_181_1176 VDD VSS sg13g2_decap_8
X_09244_ _13853_/D _13853_/Q _09875_/A0 _09261_/S VDD VSS sg13g2_mux2_1
XFILLER_166_315 VDD VSS sg13g2_decap_8
XFILLER_178_175 VDD VSS sg13g2_decap_8
XFILLER_21_354 VDD VSS sg13g2_decap_4
XFILLER_107_1269 VDD VSS sg13g2_decap_4
XFILLER_142_1149 VDD VSS sg13g2_decap_8
XFILLER_72_1471 VDD VSS sg13g2_decap_8
X_09175_ _13791_/D _13791_/Q _10142_/A1 _09202_/S VDD VSS sg13g2_mux2_1
XFILLER_33_1455 VDD VSS sg13g2_decap_8
X_15003__2677 _15003_/RESET_B VDD VSS sg13g2_tiehi
XFILLER_119_253 VDD VSS sg13g2_decap_8
XFILLER_119_264 VDD VSS sg13g2_fill_2
X_08126_ _08126_/Y _08621_/A _08126_/B VDD VSS sg13g2_nand2_1
XFILLER_181_329 VDD VSS sg13g2_decap_8
XFILLER_134_201 VDD VSS sg13g2_decap_4
XFILLER_123_908 VDD VSS sg13g2_decap_8
X_08057_ _08057_/Y _08431_/D _08052_/Y _08056_/Y VDD VSS sg13g2_o21ai_1
XFILLER_103_7 VDD VSS sg13g2_decap_8
XFILLER_135_779 VDD VSS sg13g2_decap_8
XFILLER_122_407 VDD VSS sg13g2_decap_8
XFILLER_162_576 VDD VSS sg13g2_decap_8
XFILLER_66_1220 VDD VSS sg13g2_decap_8
XFILLER_150_738 VDD VSS sg13g2_decap_8
XFILLER_0_203 VDD VSS sg13g2_decap_8
XFILLER_116_993 VDD VSS sg13g2_decap_8
XFILLER_162_598 VDD VSS sg13g2_decap_8
Xoutput48 mem_axi_araddr[19] _13710_/Q VDD VSS sg13g2_buf_1
XFILLER_163_14 VDD VSS sg13g2_decap_8
Xoutput59 mem_axi_araddr[2] _16855_/A VDD VSS sg13g2_buf_1
XFILLER_157_1381 VDD VSS sg13g2_decap_8
Xhold3120 input15/A mem_axi_rdata[1] VDD VSS sg13g2_dlygate4sd3_1
XFILLER_88_321 VDD VSS sg13g2_decap_8
XFILLER_118_1343 VDD VSS sg13g2_decap_8
Xhold3131 hold3131/X input26/X VDD VSS sg13g2_dlygate4sd3_1
XFILLER_118_1354 VDD VSS sg13g2_decap_4
Xhold3142 _10209_/C _10207_/Y VDD VSS sg13g2_dlygate4sd3_1
XFILLER_7_1309 VDD VSS sg13g2_decap_8
XFILLER_27_1237 VDD VSS sg13g2_decap_8
XFILLER_103_654 VDD VSS sg13g2_fill_1
Xhold3153 _15194_/D _10187_/X VDD VSS sg13g2_dlygate4sd3_1
XFILLER_89_877 VDD VSS sg13g2_decap_4
XFILLER_66_1297 VDD VSS sg13g2_decap_8
XFILLER_131_985 VDD VSS sg13g2_decap_8
Xhold3164 hold3164/X input25/X VDD VSS sg13g2_dlygate4sd3_1
XFILLER_89_899 VDD VSS sg13g2_decap_8
XFILLER_88_365 VDD VSS sg13g2_fill_1
XFILLER_118_1387 VDD VSS sg13g2_decap_8
Xhold3175 hold3175/X input18/X VDD VSS sg13g2_dlygate4sd3_1
XFILLER_114_1229 VDD VSS sg13g2_decap_8
Xhold3186 _10216_/B _14765_/Q VDD VSS sg13g2_dlygate4sd3_1
XFILLER_48_218 VDD VSS sg13g2_decap_8
XFILLER_102_175 VDD VSS sg13g2_decap_8
Xhold3197 _13617_/A _13725_/Q VDD VSS sg13g2_dlygate4sd3_1
X_15154__2742 _15154_/RESET_B VDD VSS sg13g2_tiehi
X_08959_ _09204_/D _10793_/A _09016_/C VDD VSS sg13g2_nor2_1
XFILLER_5_1022 VDD VSS sg13g2_decap_8
XFILLER_40_1404 VDD VSS sg13g2_fill_1
XFILLER_40_1426 VDD VSS sg13g2_decap_8
X_14274__1998 _14274_/RESET_B VDD VSS sg13g2_tiehi
XFILLER_45_903 VDD VSS sg13g2_decap_8
X_11970_ _11971_/B _11970_/A _11970_/B _11970_/C VDD VSS sg13g2_nand3_1
XFILLER_45_914 VDD VSS sg13g2_fill_1
XFILLER_17_616 VDD VSS sg13g2_decap_8
XFILLER_45_936 VDD VSS sg13g2_decap_8
XFILLER_17_638 VDD VSS sg13g2_decap_8
X_10921_ _10921_/Y _10920_/A _10920_/B _10924_/B1 VDD VSS sg13g2_o21ai_1
XFILLER_5_1099 VDD VSS sg13g2_decap_8
XFILLER_56_89 VDD VSS sg13g2_decap_8
XFILLER_16_126 VDD VSS sg13g2_decap_8
XFILLER_72_755 VDD VSS sg13g2_decap_8
X_13640_ _13748_/D _13640_/A VDD VSS sg13g2_buf_1
X_10852_ _10852_/X _10870_/A _10897_/D VDD VSS sg13g2_xor2_1
XFILLER_72_11 VDD VSS sg13g2_fill_1
XFILLER_71_254 VDD VSS sg13g2_decap_8
XFILLER_25_660 VDD VSS sg13g2_decap_8
XFILLER_77_1393 VDD VSS sg13g2_decap_8
XFILLER_13_833 VDD VSS sg13g2_decap_8
X_13571_ _13571_/Y _14997_/Q _13555_/B _13569_/S _15013_/Q _13517_/X VDD VSS sg13g2_a221oi_1
X_10783_ _10783_/Y _13245_/A _11156_/B VDD VSS sg13g2_nand2_1
XFILLER_38_1366 VDD VSS sg13g2_decap_8
XFILLER_185_602 VDD VSS sg13g2_decap_8
XFILLER_160_1216 VDD VSS sg13g2_decap_8
XFILLER_12_343 VDD VSS sg13g2_decap_8
X_12522_ _12522_/X _13959_/Q _13991_/Q _14023_/Q _14055_/Q _12522_/S0 _12522_/S1 VDD
+ VSS sg13g2_mux4_1
XFILLER_9_826 VDD VSS sg13g2_decap_8
XFILLER_184_112 VDD VSS sg13g2_decap_8
XFILLER_173_808 VDD VSS sg13g2_decap_8
X_15241_ _15241_/Q clkload43/A _15241_/D _15241_/RESET_B VDD VSS sg13g2_dfrbpq_1
XFILLER_8_336 VDD VSS sg13g2_decap_8
X_12453_ _12453_/X _12448_/X _12452_/X _12447_/X _12451_/X _12692_/S _12691_/S1 VDD
+ VSS sg13g2_mux4_1
XFILLER_185_679 VDD VSS sg13g2_decap_8
X_11404_ _11404_/Y _11402_/Y _11401_/Y _11422_/B _11403_/X VDD VSS sg13g2_a22oi_1
XFILLER_153_510 VDD VSS sg13g2_decap_4
X_15172_ _15172_/Q clkload85/A _15172_/D _15172_/RESET_B VDD VSS sg13g2_dfrbpq_1
X_12384_ _12384_/X _12378_/X _12382_/X _12377_/X _12381_/X _12705_/S1 _12622_/S0 VDD
+ VSS sg13g2_mux4_1
XFILLER_125_234 VDD VSS sg13g2_decap_8
XFILLER_21_70 VDD VSS sg13g2_decap_8
X_14123_ _14123_/Q clkload11/A _14123_/D _14123_/RESET_B VDD VSS sg13g2_dfrbpq_1
X_11335_ _11335_/X _11335_/A _13691_/Q VDD VSS sg13g2_or2_1
XFILLER_153_554 VDD VSS sg13g2_decap_8
XFILLER_181_863 VDD VSS sg13g2_decap_8
XFILLER_107_960 VDD VSS sg13g2_decap_8
XFILLER_114_919 VDD VSS sg13g2_decap_8
XFILLER_126_779 VDD VSS sg13g2_fill_1
XFILLER_4_553 VDD VSS sg13g2_decap_8
XFILLER_10_1274 VDD VSS sg13g2_decap_8
XFILLER_141_738 VDD VSS sg13g2_fill_2
X_14054_ _14054_/Q _14662_/CLK _14054_/D _14054_/RESET_B VDD VSS sg13g2_dfrbpq_1
X_14713__1559 _14713_/RESET_B VDD VSS sg13g2_tiehi
X_11266_ _11266_/Y _11266_/A _12324_/B VDD VSS sg13g2_nand2_1
XFILLER_122_930 VDD VSS sg13g2_fill_1
XFILLER_80_1206 VDD VSS sg13g2_decap_4
XFILLER_122_952 VDD VSS sg13g2_decap_8
X_13005_ _15033_/D _13005_/A _13005_/B _13427_/B VDD VSS sg13g2_nand3_1
X_10217_ _14765_/D _10187_/S _13316_/B _10216_/Y VDD VSS sg13g2_a21oi_1
X_11197_ _11197_/X _11197_/A _11197_/B VDD VSS sg13g2_and2_1
XFILLER_80_1228 VDD VSS sg13g2_decap_8
XFILLER_121_451 VDD VSS sg13g2_fill_1
XFILLER_95_825 VDD VSS sg13g2_decap_8
XFILLER_94_302 VDD VSS sg13g2_decap_8
XFILLER_39_218 VDD VSS sg13g2_decap_8
XFILLER_121_484 VDD VSS sg13g2_decap_8
X_10148_ _14725_/D _14725_/Q _09025_/X _10160_/S VDD VSS sg13g2_mux2_1
XFILLER_0_792 VDD VSS sg13g2_decap_8
XFILLER_82_508 VDD VSS sg13g2_decap_8
X_14956_ _14956_/Q clkload75/A _14956_/D _14956_/RESET_B VDD VSS sg13g2_dfrbpq_1
X_10079_ _14659_/D _10079_/A0 _14659_/Q _10097_/S VDD VSS sg13g2_mux2_1
XFILLER_94_379 VDD VSS sg13g2_fill_1
XFILLER_78_1102 VDD VSS sg13g2_decap_8
XFILLER_130_1053 VDD VSS sg13g2_decap_8
X_13907_ _13907_/Q clkload41/A _13907_/D _13907_/RESET_B VDD VSS sg13g2_dfrbpq_1
XFILLER_75_582 VDD VSS sg13g2_decap_8
XFILLER_169_1252 VDD VSS sg13g2_decap_8
XFILLER_47_284 VDD VSS sg13g2_decap_8
XFILLER_169_1263 VDD VSS sg13g2_fill_1
X_14887_ _14887_/Q clkload61/A _14887_/D _14887_/RESET_B VDD VSS sg13g2_dfrbpq_1
XFILLER_1_1442 VDD VSS sg13g2_decap_8
XFILLER_36_969 VDD VSS sg13g2_decap_8
XFILLER_165_1116 VDD VSS sg13g2_decap_4
XFILLER_90_552 VDD VSS sg13g2_decap_8
X_13838_ _13838_/Q clkload51/A _13838_/D _13838_/RESET_B VDD VSS sg13g2_dfrbpq_1
XFILLER_90_563 VDD VSS sg13g2_fill_1
XFILLER_90_574 VDD VSS sg13g2_decap_4
XFILLER_95_1471 VDD VSS sg13g2_decap_8
XFILLER_51_939 VDD VSS sg13g2_decap_8
XFILLER_90_585 VDD VSS sg13g2_decap_8
XFILLER_56_1433 VDD VSS sg13g2_decap_8
XFILLER_56_1444 VDD VSS sg13g2_fill_1
XFILLER_143_1403 VDD VSS sg13g2_fill_1
XFILLER_16_693 VDD VSS sg13g2_decap_8
XFILLER_182_1452 VDD VSS sg13g2_decap_8
X_13769_ _13769_/Q _14729_/CLK _13769_/D _13769_/RESET_B VDD VSS sg13g2_dfrbpq_1
XFILLER_56_1477 VDD VSS sg13g2_fill_2
XFILLER_17_1439 VDD VSS sg13g2_decap_8
XFILLER_31_663 VDD VSS sg13g2_decap_8
X_14931__2775 _14931_/RESET_B VDD VSS sg13g2_tiehi
XFILLER_175_112 VDD VSS sg13g2_decap_8
XFILLER_15_1130 VDD VSS sg13g2_decap_8
X_14802__3004 _14802_/RESET_B VDD VSS sg13g2_tiehi
XFILLER_176_679 VDD VSS sg13g2_fill_2
XFILLER_175_189 VDD VSS sg13g2_decap_8
X_14049__2223 _14049_/RESET_B VDD VSS sg13g2_tiehi
XFILLER_176_1201 VDD VSS sg13g2_decap_8
XFILLER_89_1253 VDD VSS sg13g2_decap_8
XFILLER_85_1106 VDD VSS sg13g2_fill_2
XFILLER_172_852 VDD VSS sg13g2_decap_8
XFILLER_116_245 VDD VSS sg13g2_fill_2
XFILLER_117_779 VDD VSS sg13g2_decap_8
XFILLER_85_1139 VDD VSS sg13g2_decap_8
XFILLER_171_362 VDD VSS sg13g2_decap_8
XFILLER_89_107 VDD VSS sg13g2_decap_8
XFILLER_132_727 VDD VSS sg13g2_decap_8
XFILLER_172_896 VDD VSS sg13g2_decap_8
XFILLER_116_289 VDD VSS sg13g2_decap_8
X_09931_ _14516_/D _14516_/Q _09931_/A1 _09937_/S VDD VSS sg13g2_mux2_1
XFILLER_131_226 VDD VSS sg13g2_decap_8
Xfanout805 _08236_/S _08070_/B VDD VSS sg13g2_buf_1
Xfanout816 _08070_/C _07629_/Y VDD VSS sg13g2_buf_1
Xfanout827 _11044_/C _11109_/B VDD VSS sg13g2_buf_1
X_09862_ _14449_/D _14449_/Q _10093_/A0 _09862_/S VDD VSS sg13g2_mux2_1
Xfanout838 _12789_/S1 _15214_/Q VDD VSS sg13g2_buf_1
XFILLER_98_674 VDD VSS sg13g2_decap_8
XFILLER_86_814 VDD VSS sg13g2_decap_8
XFILLER_58_505 VDD VSS sg13g2_decap_8
X_08813_ _08813_/Y _13279_/B _12347_/B _08727_/D _15180_/Q _08825_/C1 VDD VSS sg13g2_a221oi_1
XFILLER_85_313 VDD VSS sg13g2_fill_1
XFILLER_133_28 VDD VSS sg13g2_decap_8
X_09793_ _14382_/D _09925_/A1 _14382_/Q _09793_/S VDD VSS sg13g2_mux2_1
XFILLER_58_549 VDD VSS sg13g2_fill_1
XFILLER_86_869 VDD VSS sg13g2_decap_4
XFILLER_26_1292 VDD VSS sg13g2_decap_8
X_08744_ _13666_/D _08753_/A1 _08742_/Y _08743_/Y VDD VSS sg13g2_a21oi_1
XFILLER_6_1386 VDD VSS sg13g2_decap_8
XFILLER_22_1156 VDD VSS sg13g2_decap_8
XFILLER_2_1239 VDD VSS sg13g2_decap_8
X_08675_ _08675_/Y _08675_/A1 _08671_/Y _08674_/Y VDD VSS sg13g2_o21ai_1
XFILLER_53_210 VDD VSS sg13g2_fill_2
XFILLER_54_755 VDD VSS sg13g2_decap_8
XFILLER_96_1268 VDD VSS sg13g2_decap_8
X_07626_ _07626_/Y _08009_/S VDD VSS sg13g2_inv_1
XFILLER_179_462 VDD VSS sg13g2_decap_8
XFILLER_70_1408 VDD VSS sg13g2_decap_8
XFILLER_42_14 VDD VSS sg13g2_decap_8
XFILLER_107_1022 VDD VSS sg13g2_decap_8
XFILLER_139_315 VDD VSS sg13g2_decap_8
XFILLER_146_1082 VDD VSS sg13g2_decap_8
XFILLER_146_1093 VDD VSS sg13g2_fill_1
XFILLER_167_635 VDD VSS sg13g2_decap_8
XFILLER_21_140 VDD VSS sg13g2_decap_8
XFILLER_158_14 VDD VSS sg13g2_decap_8
XFILLER_166_112 VDD VSS sg13g2_decap_8
XFILLER_10_847 VDD VSS sg13g2_decap_8
XFILLER_155_808 VDD VSS sg13g2_decap_8
X_09227_ _13838_/D _09925_/A1 _13838_/Q _09227_/S VDD VSS sg13g2_mux2_1
XFILLER_155_819 VDD VSS sg13g2_fill_2
XFILLER_72_1290 VDD VSS sg13g2_decap_8
XFILLER_148_871 VDD VSS sg13g2_fill_1
XFILLER_182_616 VDD VSS sg13g2_decap_8
XFILLER_166_189 VDD VSS sg13g2_decap_8
X_09158_ _09158_/Y _09162_/A _09158_/B _09158_/C VDD VSS sg13g2_nand3_1
XFILLER_135_510 VDD VSS sg13g2_decap_8
XFILLER_107_212 VDD VSS sg13g2_fill_2
XFILLER_181_126 VDD VSS sg13g2_decap_8
XFILLER_163_841 VDD VSS sg13g2_fill_2
X_08109_ _08452_/A _08109_/A1 _08402_/B _08023_/Y _08101_/Y VDD VSS sg13g2_a22oi_1
X_09089_ _09090_/C _14911_/Q _13064_/A _09089_/C _09103_/D VDD VSS sg13g2_nand4_1
XFILLER_101_4 VDD VSS sg13g2_fill_2
XFILLER_155_1307 VDD VSS sg13g2_decap_8
XFILLER_162_362 VDD VSS sg13g2_decap_8
XFILLER_174_35 VDD VSS sg13g2_decap_8
X_11120_ _11127_/A _11012_/B _11012_/C _11119_/Y VDD VSS sg13g2_o21ai_1
XFILLER_123_738 VDD VSS sg13g2_decap_8
XFILLER_116_790 VDD VSS sg13g2_decap_8
X_11051_ _11051_/Y _11064_/D _11051_/B VDD VSS sg13g2_xnor2_1
XFILLER_104_974 VDD VSS sg13g2_fill_1
XFILLER_1_567 VDD VSS sg13g2_decap_8
XFILLER_7_1106 VDD VSS sg13g2_decap_8
XFILLER_27_1045 VDD VSS sg13g2_decap_4
X_10002_ _14585_/D _10101_/A0 _14585_/Q _10002_/S VDD VSS sg13g2_mux2_1
XFILLER_88_162 VDD VSS sg13g2_fill_1
X_13747__2525 _13747_/RESET_B VDD VSS sg13g2_tiehi
XFILLER_76_324 VDD VSS sg13g2_fill_2
XFILLER_49_538 VDD VSS sg13g2_decap_8
XFILLER_114_1037 VDD VSS sg13g2_decap_4
XFILLER_153_1086 VDD VSS sg13g2_fill_1
XFILLER_88_184 VDD VSS sg13g2_decap_8
XFILLER_88_195 VDD VSS sg13g2_fill_1
XFILLER_77_869 VDD VSS sg13g2_decap_8
XFILLER_40_1201 VDD VSS sg13g2_decap_8
X_14810_ _14810_/Q clkload61/A _14810_/D _14810_/RESET_B VDD VSS sg13g2_dfrbpq_1
X_15207__3068 _15207_/RESET_B VDD VSS sg13g2_tiehi
XFILLER_67_99 VDD VSS sg13g2_decap_4
XFILLER_131_1351 VDD VSS sg13g2_decap_8
XFILLER_92_839 VDD VSS sg13g2_fill_1
XFILLER_79_1411 VDD VSS sg13g2_decap_8
XFILLER_57_571 VDD VSS sg13g2_fill_1
XFILLER_17_413 VDD VSS sg13g2_decap_8
XFILLER_91_327 VDD VSS sg13g2_fill_1
XFILLER_57_582 VDD VSS sg13g2_decap_8
XFILLER_177_0 VDD VSS sg13g2_decap_8
X_14741_ _14741_/Q _14741_/CLK _14741_/D _14741_/RESET_B VDD VSS sg13g2_dfrbpq_1
XFILLER_40_1267 VDD VSS sg13g2_decap_8
X_11953_ _11953_/Y _11953_/A _11953_/B _11953_/C VDD VSS sg13g2_nand3_1
XFILLER_84_390 VDD VSS sg13g2_decap_8
XFILLER_29_295 VDD VSS sg13g2_decap_4
XFILLER_75_1308 VDD VSS sg13g2_fill_1
XFILLER_166_1436 VDD VSS sg13g2_fill_2
X_13962__2310 _13962_/RESET_B VDD VSS sg13g2_tiehi
X_14127__2145 _14127_/RESET_B VDD VSS sg13g2_tiehi
X_10904_ _10907_/A _10888_/Y _10904_/B VDD VSS sg13g2_nand2b_1
XFILLER_45_777 VDD VSS sg13g2_fill_1
X_14672_ _14672_/Q clkload10/A _14672_/D _14672_/RESET_B VDD VSS sg13g2_dfrbpq_1
X_11884_ _11884_/Y _11378_/S _11883_/X _11884_/B1 VDD VSS sg13g2_a21oi_1
XFILLER_166_1469 VDD VSS sg13g2_fill_1
XFILLER_60_736 VDD VSS sg13g2_fill_1
XFILLER_16_70 VDD VSS sg13g2_decap_8
X_13623_ _13731_/D _13623_/A VDD VSS sg13g2_buf_1
XFILLER_60_747 VDD VSS sg13g2_decap_8
XFILLER_32_438 VDD VSS sg13g2_decap_8
XFILLER_26_991 VDD VSS sg13g2_decap_8
X_10835_ _10835_/Y _10827_/B _10816_/Y _10834_/Y _07751_/B _13279_/D VDD VSS sg13g2_a221oi_1
XFILLER_13_630 VDD VSS sg13g2_decap_8
XFILLER_186_911 VDD VSS sg13g2_fill_1
XFILLER_12_140 VDD VSS sg13g2_decap_8
X_13554_ _15149_/D _15149_/Q _13553_/Y _13562_/S VDD VSS sg13g2_mux2_1
XFILLER_41_972 VDD VSS sg13g2_decap_8
X_10766_ _14918_/D _11045_/B1 _11115_/B _10765_/Y VDD VSS sg13g2_o21ai_1
XFILLER_9_623 VDD VSS sg13g2_decap_8
XFILLER_125_1155 VDD VSS sg13g2_decap_8
XFILLER_34_1038 VDD VSS sg13g2_decap_8
XFILLER_186_966 VDD VSS sg13g2_decap_8
XFILLER_158_668 VDD VSS sg13g2_decap_8
XFILLER_186_977 VDD VSS sg13g2_decap_8
X_12505_ _12505_/X _14566_/Q _14598_/Q _14630_/Q _14662_/Q _12606_/S0 _12606_/S1 VDD
+ VSS sg13g2_mux4_1
XFILLER_8_133 VDD VSS sg13g2_decap_8
XFILLER_160_1068 VDD VSS sg13g2_decap_8
XFILLER_16_1461 VDD VSS sg13g2_decap_8
XFILLER_173_605 VDD VSS sg13g2_decap_8
X_13485_ _13486_/A _15171_/D _13485_/B VDD VSS sg13g2_nor2_1
X_10697_ _10697_/X _10697_/A _10697_/B _15060_/Q VDD VSS sg13g2_and3_1
XFILLER_103_1420 VDD VSS sg13g2_decap_8
XFILLER_125_1199 VDD VSS sg13g2_decap_8
XFILLER_185_476 VDD VSS sg13g2_decap_8
X_13995__2277 _13995_/RESET_B VDD VSS sg13g2_tiehi
X_15224_ _15224_/Q _15224_/CLK _15224_/D _15224_/RESET_B VDD VSS sg13g2_dfrbpq_1
XFILLER_126_510 VDD VSS sg13g2_fill_1
X_12436_ _12436_/X _13953_/Q _13985_/Q _14017_/Q _14049_/Q _12550_/S0 _12550_/S1 VDD
+ VSS sg13g2_mux4_1
XFILLER_172_126 VDD VSS sg13g2_decap_8
XFILLER_173_649 VDD VSS sg13g2_decap_4
XFILLER_66_7 VDD VSS sg13g2_decap_4
XFILLER_32_91 VDD VSS sg13g2_decap_8
XFILLER_12_1358 VDD VSS sg13g2_decap_8
XFILLER_154_852 VDD VSS sg13g2_decap_8
XFILLER_5_840 VDD VSS sg13g2_decap_8
X_15155_ _15155_/Q _15216_/CLK _15155_/D _15155_/RESET_B VDD VSS sg13g2_dfrbpq_1
XFILLER_114_705 VDD VSS sg13g2_decap_8
X_12367_ _12367_/X _13820_/Q _13852_/Q _13884_/Q _13916_/Q _12368_/S0 _12368_/S1 VDD
+ VSS sg13g2_mux4_1
XFILLER_86_1437 VDD VSS sg13g2_decap_8
XFILLER_126_576 VDD VSS sg13g2_decap_8
XFILLER_173_1407 VDD VSS sg13g2_fill_1
XFILLER_4_350 VDD VSS sg13g2_decap_8
XFILLER_113_204 VDD VSS sg13g2_fill_1
XFILLER_153_373 VDD VSS sg13g2_decap_8
X_14106_ _14106_/Q clkload55/A _14106_/D _14106_/RESET_B VDD VSS sg13g2_dfrbpq_1
XFILLER_10_1071 VDD VSS sg13g2_decap_8
XFILLER_181_693 VDD VSS sg13g2_decap_8
X_11318_ _11318_/Y _11318_/A _11318_/B VDD VSS sg13g2_nand2_1
XFILLER_113_226 VDD VSS sg13g2_decap_8
X_15086_ _15086_/Q _15216_/CLK _15086_/D _15086_/RESET_B VDD VSS sg13g2_dfrbpq_1
X_12298_ _12298_/Y _12300_/A _12298_/B VDD VSS sg13g2_nor2_1
XFILLER_99_449 VDD VSS sg13g2_decap_8
XFILLER_49_1270 VDD VSS sg13g2_fill_2
XFILLER_141_557 VDD VSS sg13g2_decap_8
X_14037_ _14037_/Q clkload29/A _14037_/D _14037_/RESET_B VDD VSS sg13g2_dfrbpq_1
X_11249_ _11249_/Y _12866_/A _11249_/B VDD VSS sg13g2_nor2_1
XFILLER_80_1025 VDD VSS sg13g2_decap_8
XFILLER_95_622 VDD VSS sg13g2_fill_2
X_14337__1935 _14337_/RESET_B VDD VSS sg13g2_tiehi
XFILLER_45_1189 VDD VSS sg13g2_decap_8
XFILLER_110_955 VDD VSS sg13g2_fill_1
XFILLER_132_1148 VDD VSS sg13g2_fill_2
XFILLER_23_1421 VDD VSS sg13g2_decap_8
XFILLER_95_677 VDD VSS sg13g2_decap_8
XFILLER_67_368 VDD VSS sg13g2_decap_8
XFILLER_48_560 VDD VSS sg13g2_decap_4
XFILLER_83_839 VDD VSS sg13g2_decap_8
XFILLER_82_327 VDD VSS sg13g2_decap_8
X_14939_ _14939_/Q clkload75/A _14939_/D _14939_/RESET_B VDD VSS sg13g2_dfrbpq_1
XFILLER_35_210 VDD VSS sg13g2_decap_8
X_08460_ _08461_/D _08460_/A1 _08458_/X _08459_/Y VDD VSS sg13g2_o21ai_1
XFILLER_63_563 VDD VSS sg13g2_decap_8
X_14552__1720 _14552_/RESET_B VDD VSS sg13g2_tiehi
XFILLER_90_360 VDD VSS sg13g2_decap_8
XFILLER_17_991 VDD VSS sg13g2_decap_8
X_08391_ _08391_/Y _08391_/A _08391_/B VDD VSS sg13g2_nor2_1
XFILLER_91_1121 VDD VSS sg13g2_decap_8
XFILLER_16_490 VDD VSS sg13g2_decap_8
XFILLER_92_0 VDD VSS sg13g2_decap_8
XFILLER_52_1105 VDD VSS sg13g2_decap_8
XFILLER_91_1165 VDD VSS sg13g2_decap_8
XFILLER_50_268 VDD VSS sg13g2_decap_4
XFILLER_149_635 VDD VSS sg13g2_decap_4
XFILLER_177_944 VDD VSS sg13g2_decap_8
XFILLER_17_1236 VDD VSS sg13g2_decap_8
XFILLER_182_1282 VDD VSS sg13g2_decap_8
XFILLER_104_1217 VDD VSS sg13g2_decap_8
XFILLER_149_668 VDD VSS sg13g2_decap_8
XFILLER_148_156 VDD VSS sg13g2_decap_8
XFILLER_12_28 VDD VSS sg13g2_decap_8
XFILLER_176_476 VDD VSS sg13g2_decap_8
XFILLER_178_1307 VDD VSS sg13g2_fill_1
X_09012_ _09012_/Y _14902_/Q _09022_/D _09024_/A VDD VSS sg13g2_o21ai_1
X_13825__2447 _13825_/RESET_B VDD VSS sg13g2_tiehi
XFILLER_117_510 VDD VSS sg13g2_decap_8
X_14585__1687 _14585_/RESET_B VDD VSS sg13g2_tiehi
XFILLER_129_381 VDD VSS sg13g2_decap_8
XFILLER_157_690 VDD VSS sg13g2_decap_8
XFILLER_89_1061 VDD VSS sg13g2_decap_8
XFILLER_30_1458 VDD VSS sg13g2_decap_8
XFILLER_172_660 VDD VSS sg13g2_decap_8
XFILLER_137_1004 VDD VSS sg13g2_fill_1
XFILLER_144_373 VDD VSS sg13g2_decap_8
XFILLER_144_384 VDD VSS sg13g2_fill_1
XFILLER_105_749 VDD VSS sg13g2_fill_1
XFILLER_144_395 VDD VSS sg13g2_decap_8
XFILLER_176_1086 VDD VSS sg13g2_decap_8
XFILLER_99_950 VDD VSS sg13g2_decap_4
XFILLER_104_259 VDD VSS sg13g2_decap_8
X_14205__2067 _14205_/RESET_B VDD VSS sg13g2_tiehi
Xfanout602 _08775_/B _08781_/B VDD VSS sg13g2_buf_1
X_09914_ _14499_/D _14499_/Q _09914_/A1 _09936_/S VDD VSS sg13g2_mux2_1
XFILLER_67_1381 VDD VSS sg13g2_fill_2
Xfanout613 _08110_/D _08034_/Y VDD VSS sg13g2_buf_1
XFILLER_67_1392 VDD VSS sg13g2_fill_2
XFILLER_101_900 VDD VSS sg13g2_fill_2
Xfanout624 _13297_/A0 _12808_/Y VDD VSS sg13g2_buf_1
Xfanout635 _12294_/A2 _11655_/B VDD VSS sg13g2_buf_1
XFILLER_58_302 VDD VSS sg13g2_decap_4
Xfanout646 _13294_/B _10903_/B VDD VSS sg13g2_buf_1
Xfanout657 _08933_/S _08903_/S VDD VSS sg13g2_buf_1
X_09845_ _14432_/D _14432_/Q _10043_/A0 _09866_/S VDD VSS sg13g2_mux2_1
XFILLER_24_1218 VDD VSS sg13g2_decap_8
Xfanout668 _08937_/S _08895_/S VDD VSS sg13g2_buf_1
XFILLER_58_335 VDD VSS sg13g2_decap_8
Xfanout679 _13407_/A _13437_/A VDD VSS sg13g2_buf_1
XFILLER_101_966 VDD VSS sg13g2_decap_8
XFILLER_37_14 VDD VSS sg13g2_decap_8
XFILLER_85_143 VDD VSS sg13g2_decap_8
X_09776_ _14365_/D _09908_/A1 _14365_/Q _09805_/S VDD VSS sg13g2_mux2_1
XFILLER_39_560 VDD VSS sg13g2_fill_1
XFILLER_67_880 VDD VSS sg13g2_decap_8
XFILLER_85_187 VDD VSS sg13g2_decap_8
XFILLER_6_1183 VDD VSS sg13g2_decap_8
X_08727_ _08727_/X _15129_/Q _15124_/Q _15071_/Q _08727_/D VDD VSS sg13g2_or4_1
XFILLER_170_7 VDD VSS sg13g2_decap_8
XFILLER_2_1036 VDD VSS sg13g2_decap_8
XFILLER_96_1043 VDD VSS sg13g2_decap_8
XFILLER_15_906 VDD VSS sg13g2_decap_8
XFILLER_183_1002 VDD VSS sg13g2_decap_4
XFILLER_54_563 VDD VSS sg13g2_fill_2
X_08658_ _08659_/C _08029_/Y _08591_/X _08511_/X _08599_/A _08657_/Y VDD VSS sg13g2_a221oi_1
XFILLER_96_1065 VDD VSS sg13g2_fill_1
XFILLER_57_1016 VDD VSS sg13g2_decap_8
XFILLER_148_1144 VDD VSS sg13g2_decap_4
XFILLER_81_371 VDD VSS sg13g2_decap_8
XFILLER_14_427 VDD VSS sg13g2_decap_8
XFILLER_53_35 VDD VSS sg13g2_fill_2
XFILLER_148_1188 VDD VSS sg13g2_decap_8
X_08589_ _08596_/B _08668_/A _08252_/Y _08652_/B1 VDD VSS sg13g2_o21ai_1
XFILLER_42_769 VDD VSS sg13g2_decap_8
XFILLER_169_35 VDD VSS sg13g2_decap_8
XFILLER_35_1314 VDD VSS sg13g2_fill_2
XFILLER_23_961 VDD VSS sg13g2_decap_8
X_10620_ _10623_/B _10651_/D _10622_/C _14882_/Q VDD VSS sg13g2_a21oi_1
XFILLER_41_268 VDD VSS sg13g2_decap_8
XFILLER_161_1333 VDD VSS sg13g2_decap_8
XFILLER_168_944 VDD VSS sg13g2_fill_1
XFILLER_139_112 VDD VSS sg13g2_decap_4
XFILLER_168_966 VDD VSS sg13g2_decap_8
X_10551_ _14865_/D _14865_/Q _10556_/D _10550_/Y VDD VSS sg13g2_a21oi_1
XFILLER_70_1249 VDD VSS sg13g2_decap_8
XFILLER_10_644 VDD VSS sg13g2_decap_8
XFILLER_139_178 VDD VSS sg13g2_decap_8
XFILLER_167_487 VDD VSS sg13g2_decap_8
XFILLER_182_413 VDD VSS sg13g2_decap_8
XFILLER_183_947 VDD VSS sg13g2_decap_8
X_13270_ _13271_/B _13270_/A _13270_/B _13270_/C VDD VSS sg13g2_nand3_1
X_14415__1857 _14415_/RESET_B VDD VSS sg13g2_tiehi
X_10482_ _14848_/D _10482_/A _10481_/Y VDD VSS sg13g2_nor2b_1
XFILLER_148_690 VDD VSS sg13g2_decap_4
XFILLER_6_637 VDD VSS sg13g2_decap_8
XFILLER_154_137 VDD VSS sg13g2_decap_8
X_15052__2614 _15052_/RESET_B VDD VSS sg13g2_tiehi
XFILLER_120_1052 VDD VSS sg13g2_decap_8
XFILLER_170_608 VDD VSS sg13g2_fill_2
XFILLER_185_56 VDD VSS sg13g2_decap_8
X_12221_ _12221_/Y _12291_/A _12220_/Y _12221_/B1 VDD VSS sg13g2_o21ai_1
XFILLER_5_147 VDD VSS sg13g2_decap_8
XFILLER_151_800 VDD VSS sg13g2_decap_4
XFILLER_159_1251 VDD VSS sg13g2_decap_8
XFILLER_135_362 VDD VSS sg13g2_decap_8
XFILLER_163_671 VDD VSS sg13g2_decap_8
XFILLER_151_822 VDD VSS sg13g2_decap_4
X_12152_ _12153_/B _12152_/A _13666_/Q VDD VSS sg13g2_nand2_1
XFILLER_162_170 VDD VSS sg13g2_decap_4
XFILLER_155_1137 VDD VSS sg13g2_decap_8
XFILLER_78_32 VDD VSS sg13g2_fill_1
X_11103_ _11118_/D _11125_/A _11115_/B VDD VSS sg13g2_xnor2_1
XFILLER_81_1301 VDD VSS sg13g2_fill_1
XFILLER_78_43 VDD VSS sg13g2_decap_8
XFILLER_2_854 VDD VSS sg13g2_decap_8
X_12083_ _12198_/A _12084_/A _13668_/Q VDD VSS sg13g2_nor2_1
XFILLER_46_1443 VDD VSS sg13g2_decap_8
XFILLER_150_376 VDD VSS sg13g2_decap_8
X_14630__1642 _14630_/RESET_B VDD VSS sg13g2_tiehi
XFILLER_1_364 VDD VSS sg13g2_decap_8
X_11034_ _11034_/Y _15117_/Q _11042_/D _11023_/Y VDD VSS sg13g2_a21oi_1
XFILLER_77_633 VDD VSS sg13g2_decap_8
XFILLER_81_1367 VDD VSS sg13g2_decap_8
XFILLER_131_590 VDD VSS sg13g2_decap_8
XFILLER_133_1446 VDD VSS sg13g2_decap_8
XFILLER_81_1378 VDD VSS sg13g2_fill_1
XFILLER_49_379 VDD VSS sg13g2_decap_8
Xclkbuf_5_2__f_clk_i clkbuf_leaf_9_clk_i/A clkbuf_4_1_0_clk_i/X VDD VSS sg13g2_buf_16
XFILLER_17_210 VDD VSS sg13g2_decap_8
X_12985_ _13009_/A _14906_/Q _13681_/Q VDD VSS sg13g2_nand2_1
X_13903__2369 _13903_/RESET_B VDD VSS sg13g2_tiehi
X_14724_ _14724_/Q clkload33/A _14724_/D _14724_/RESET_B VDD VSS sg13g2_dfrbpq_1
XFILLER_79_1274 VDD VSS sg13g2_decap_8
X_11936_ _12055_/B _11936_/A _13129_/B VDD VSS sg13g2_xnor2_1
XFILLER_45_563 VDD VSS sg13g2_fill_1
XFILLER_27_91 VDD VSS sg13g2_decap_8
XFILLER_17_287 VDD VSS sg13g2_decap_8
X_14655_ _14655_/Q clkload21/A _14655_/D _14655_/RESET_B VDD VSS sg13g2_dfrbpq_1
X_11867_ _11868_/C _11867_/A _11867_/B _11910_/C VDD VSS sg13g2_nand3_1
XFILLER_166_1288 VDD VSS sg13g2_decap_4
XFILLER_92_1452 VDD VSS sg13g2_decap_8
X_13606_ _13606_/Y _12801_/Y _13600_/Y _08830_/X VDD VSS sg13g2_o21ai_1
X_10818_ _10818_/Y _10818_/A _10818_/B VDD VSS sg13g2_nor2_1
XFILLER_159_944 VDD VSS sg13g2_decap_4
X_14586_ _14586_/Q clkload55/A _14586_/D _14586_/RESET_B VDD VSS sg13g2_dfrbpq_1
XFILLER_60_588 VDD VSS sg13g2_decap_8
XFILLER_53_1436 VDD VSS sg13g2_fill_1
XFILLER_14_994 VDD VSS sg13g2_decap_8
X_11798_ _12056_/A _11798_/A _13676_/Q VDD VSS sg13g2_xor2_1
XFILLER_159_966 VDD VSS sg13g2_decap_8
XFILLER_9_420 VDD VSS sg13g2_decap_8
XFILLER_140_1406 VDD VSS sg13g2_fill_2
XFILLER_174_903 VDD VSS sg13g2_decap_8
X_13537_ _13537_/X _14994_/Q _13555_/C VDD VSS sg13g2_and2_1
X_10749_ _11068_/B _14946_/Q _10747_/A _10747_/Y VDD VSS sg13g2_a21o_1
X_15080__2926 _15080_/RESET_B VDD VSS sg13g2_tiehi
XFILLER_146_638 VDD VSS sg13g2_fill_2
XFILLER_185_273 VDD VSS sg13g2_decap_8
XFILLER_174_958 VDD VSS sg13g2_fill_1
X_13468_ wire566/A _15173_/Q _15174_/Q _15175_/Q _13468_/D VDD VSS sg13g2_nor4_1
XFILLER_9_497 VDD VSS sg13g2_decap_8
XFILLER_51_1171 VDD VSS sg13g2_fill_1
XFILLER_103_1250 VDD VSS sg13g2_fill_1
XFILLER_173_457 VDD VSS sg13g2_decap_8
XFILLER_12_1155 VDD VSS sg13g2_decap_8
X_15207_ _15207_/Q clkload88/A _15207_/D _15207_/RESET_B VDD VSS sg13g2_dfrbpq_1
X_12419_ _12419_/X _13952_/Q _13984_/Q _14016_/Q _14048_/Q _12424_/S0 _12424_/S1 VDD
+ VSS sg13g2_mux4_1
X_13399_ _15087_/D _13455_/A _13396_/D _13398_/Y VDD VSS sg13g2_o21ai_1
XFILLER_127_896 VDD VSS sg13g2_decap_8
XFILLER_47_1207 VDD VSS sg13g2_decap_8
XFILLER_126_384 VDD VSS sg13g2_fill_2
X_15138_ _15138_/Q clkload86/A _15138_/D _15138_/RESET_B VDD VSS sg13g2_dfrbpq_1
XFILLER_138_1335 VDD VSS sg13g2_decap_8
XFILLER_141_321 VDD VSS sg13g2_decap_4
XFILLER_173_1226 VDD VSS sg13g2_decap_8
XFILLER_181_490 VDD VSS sg13g2_decap_8
XFILLER_99_235 VDD VSS sg13g2_decap_8
XFILLER_173_1248 VDD VSS sg13g2_decap_8
X_15069_ _15069_/Q clkload85/A _15069_/D _15069_/RESET_B VDD VSS sg13g2_dfrbpq_1
X_07960_ _07960_/Y _07943_/Y _07906_/B _07959_/Y VDD VSS sg13g2_a21oi_1
XFILLER_68_600 VDD VSS sg13g2_decap_4
XFILLER_4_84 VDD VSS sg13g2_decap_8
XFILLER_101_229 VDD VSS sg13g2_decap_8
XFILLER_60_1407 VDD VSS sg13g2_decap_4
XFILLER_96_942 VDD VSS sg13g2_decap_8
X_07891_ _07917_/B _08142_/C _08138_/C VDD VSS sg13g2_nor2_1
XFILLER_110_741 VDD VSS sg13g2_decap_8
XFILLER_136_1092 VDD VSS sg13g2_decap_8
X_09630_ _14226_/D _09896_/A0 _14226_/Q _09630_/S VDD VSS sg13g2_mux2_1
XFILLER_56_828 VDD VSS sg13g2_decap_8
XFILLER_7_1470 VDD VSS sg13g2_decap_8
XFILLER_3_1323 VDD VSS sg13g2_decap_8
XFILLER_167_1008 VDD VSS sg13g2_decap_4
X_09561_ _14159_/D _09627_/A0 _14159_/Q _09563_/S VDD VSS sg13g2_mux2_1
XFILLER_167_1019 VDD VSS sg13g2_decap_8
XFILLER_23_1295 VDD VSS sg13g2_decap_8
XFILLER_58_1303 VDD VSS sg13g2_fill_2
X_08512_ _08512_/Y _08560_/A _08339_/Y _08675_/A1 VDD VSS sg13g2_a21oi_1
XFILLER_110_1265 VDD VSS sg13g2_decap_8
XFILLER_149_1442 VDD VSS sg13g2_decap_8
XFILLER_110_1276 VDD VSS sg13g2_fill_2
XFILLER_184_1333 VDD VSS sg13g2_decap_8
X_09492_ _14092_/D _09558_/A0 _14092_/Q _09506_/S VDD VSS sg13g2_mux2_1
XFILLER_169_708 VDD VSS sg13g2_decap_4
XFILLER_36_596 VDD VSS sg13g2_decap_8
XFILLER_23_213 VDD VSS sg13g2_decap_8
X_08443_ _08443_/Y _08443_/A _08443_/B VDD VSS sg13g2_nor2_1
XFILLER_51_544 VDD VSS sg13g2_decap_8
XFILLER_24_758 VDD VSS sg13g2_decap_8
XFILLER_145_1339 VDD VSS sg13g2_decap_8
XFILLER_90_190 VDD VSS sg13g2_decap_8
XFILLER_23_246 VDD VSS sg13g2_decap_8
X_08374_ _08374_/Y _08452_/C _08374_/B VDD VSS sg13g2_nor2_1
XFILLER_56_1082 VDD VSS sg13g2_decap_8
XFILLER_182_1090 VDD VSS sg13g2_fill_1
XFILLER_23_49 VDD VSS sg13g2_decap_8
XFILLER_143_1063 VDD VSS sg13g2_fill_2
XFILLER_165_914 VDD VSS sg13g2_fill_2
XFILLER_104_1036 VDD VSS sg13g2_decap_8
XFILLER_139_49 VDD VSS sg13g2_decap_8
XFILLER_176_273 VDD VSS sg13g2_decap_8
X_15206__3067 _15206_/RESET_B VDD VSS sg13g2_tiehi
XFILLER_69_1410 VDD VSS sg13g2_fill_1
XFILLER_30_1233 VDD VSS sg13g2_fill_1
XFILLER_136_159 VDD VSS sg13g2_decap_8
XFILLER_118_874 VDD VSS sg13g2_decap_8
XFILLER_152_619 VDD VSS sg13g2_decap_8
XFILLER_117_351 VDD VSS sg13g2_decap_8
XFILLER_105_502 VDD VSS sg13g2_decap_8
XFILLER_30_1288 VDD VSS sg13g2_fill_2
XFILLER_65_1307 VDD VSS sg13g2_fill_1
XFILLER_156_1435 VDD VSS sg13g2_fill_2
Xpicorv32_macro_1515 mem_axi_awprot[2] VDD VSS sg13g2_tielo
XFILLER_117_1419 VDD VSS sg13g2_decap_8
Xfanout410 _09193_/S _09196_/S VDD VSS sg13g2_buf_1
Xfanout1408 _12250_/A1 _12235_/A VDD VSS sg13g2_buf_1
Xfanout421 _09914_/A1 wire422/X VDD VSS sg13g2_buf_1
Xfanout1419 fanout1419/X fanout1440/X VDD VSS sg13g2_buf_1
XFILLER_28_1151 VDD VSS sg13g2_decap_8
XFILLER_63_1042 VDD VSS sg13g2_decap_8
Xfanout443 _09059_/S _09167_/S VDD VSS sg13g2_buf_1
XFILLER_58_110 VDD VSS sg13g2_fill_1
XFILLER_48_35 VDD VSS sg13g2_decap_8
XFILLER_150_1012 VDD VSS sg13g2_decap_8
XFILLER_171_14 VDD VSS sg13g2_decap_8
Xfanout454 _11181_/A _10785_/Y VDD VSS sg13g2_buf_1
XFILLER_87_953 VDD VSS sg13g2_decap_4
XFILLER_59_655 VDD VSS sg13g2_decap_4
XFILLER_58_121 VDD VSS sg13g2_fill_2
XFILLER_101_752 VDD VSS sg13g2_decap_8
XFILLER_115_1143 VDD VSS sg13g2_decap_8
Xfanout465 _10036_/S _10004_/Y VDD VSS sg13g2_buf_1
XFILLER_8_1267 VDD VSS sg13g2_decap_8
Xfanout476 _09833_/S _09837_/S VDD VSS sg13g2_buf_1
XFILLER_19_508 VDD VSS sg13g2_decap_8
Xfanout487 _09670_/S _09671_/S VDD VSS sg13g2_buf_1
X_09828_ _14416_/D _09828_/A0 _14416_/Q _09830_/S VDD VSS sg13g2_mux2_1
XFILLER_59_677 VDD VSS sg13g2_decap_8
XFILLER_111_1007 VDD VSS sg13g2_fill_2
XFILLER_150_1056 VDD VSS sg13g2_fill_2
Xfanout498 _09537_/S _09507_/Y VDD VSS sg13g2_buf_1
XFILLER_24_1059 VDD VSS sg13g2_fill_2
XFILLER_41_1340 VDD VSS sg13g2_decap_8
XFILLER_101_796 VDD VSS sg13g2_decap_8
XFILLER_86_485 VDD VSS sg13g2_decap_4
XFILLER_58_176 VDD VSS sg13g2_decap_8
XFILLER_98_1138 VDD VSS sg13g2_decap_8
XFILLER_104_63 VDD VSS sg13g2_decap_8
X_09759_ _14349_/D _14349_/Q _09759_/A1 _09764_/S VDD VSS sg13g2_mux2_1
XFILLER_74_658 VDD VSS sg13g2_decap_4
XFILLER_185_1119 VDD VSS sg13g2_fill_1
XFILLER_73_146 VDD VSS sg13g2_decap_8
XFILLER_15_714 VDD VSS sg13g2_decap_8
X_12770_ _12770_/X _14137_/Q _14169_/Q _14201_/Q _14233_/Q _12771_/S0 _12771_/S1 VDD
+ VSS sg13g2_mux4_1
XFILLER_64_56 VDD VSS sg13g2_fill_2
XFILLER_14_224 VDD VSS sg13g2_decap_8
X_11721_ _11721_/Y _14908_/Q _11655_/B _11721_/B1 VDD VSS sg13g2_a21oi_1
XFILLER_163_1428 VDD VSS sg13g2_decap_8
XFILLER_42_544 VDD VSS sg13g2_decap_8
X_13697__2575 _13697_/RESET_B VDD VSS sg13g2_tiehi
X_14440_ _14440_/Q clkload23/A _14440_/D _14440_/RESET_B VDD VSS sg13g2_dfrbpq_1
X_11652_ _11652_/X _11644_/X _11645_/X _11648_/X _11649_/X _12188_/C _12191_/B1 VDD
+ VSS sg13g2_mux4_1
XFILLER_168_730 VDD VSS sg13g2_decap_8
XFILLER_168_741 VDD VSS sg13g2_fill_2
XFILLER_11_931 VDD VSS sg13g2_decap_8
X_10603_ _10608_/C _14877_/Q _10610_/D _14878_/Q VDD VSS sg13g2_a21oi_1
XFILLER_126_1272 VDD VSS sg13g2_fill_1
X_14371_ _14371_/Q clkload30/A _14371_/D _14371_/RESET_B VDD VSS sg13g2_dfrbpq_1
X_14648__1624 _14648_/RESET_B VDD VSS sg13g2_tiehi
XFILLER_122_1114 VDD VSS sg13g2_decap_8
X_11583_ _11583_/X _11575_/X _11576_/X _11579_/X _11580_/X _12029_/B _12048_/A1 VDD
+ VSS sg13g2_mux4_1
XFILLER_10_441 VDD VSS sg13g2_decap_8
XFILLER_122_1125 VDD VSS sg13g2_fill_2
XFILLER_161_1174 VDD VSS sg13g2_decap_8
XFILLER_167_273 VDD VSS sg13g2_decap_8
XFILLER_7_924 VDD VSS sg13g2_decap_8
X_13322_ _15064_/D _13322_/A _13322_/B VDD VSS sg13g2_nand2_1
XFILLER_182_210 VDD VSS sg13g2_decap_8
X_10534_ _10535_/B _14860_/Q _14859_/Q _10558_/B _10543_/C VDD VSS sg13g2_nand4_1
XFILLER_156_969 VDD VSS sg13g2_decap_8
XFILLER_13_1442 VDD VSS sg13g2_decap_8
XFILLER_155_446 VDD VSS sg13g2_fill_2
XFILLER_6_434 VDD VSS sg13g2_decap_8
XFILLER_127_148 VDD VSS sg13g2_decap_8
X_14077__2195 _14077_/RESET_B VDD VSS sg13g2_tiehi
X_13253_ _13253_/Y _13297_/A0 _13251_/Y _13252_/X _13253_/B2 VDD VSS sg13g2_a22oi_1
X_10465_ _10468_/B _10471_/C _10471_/D _10500_/A VDD VSS sg13g2_a21oi_1
XFILLER_124_800 VDD VSS sg13g2_decap_8
XFILLER_136_671 VDD VSS sg13g2_fill_2
XFILLER_100_1445 VDD VSS sg13g2_decap_8
XFILLER_182_287 VDD VSS sg13g2_decap_8
X_12204_ _12204_/Y _12204_/A _12272_/A VDD VSS sg13g2_xnor2_1
X_13184_ _15045_/D _13324_/A _13184_/B VDD VSS sg13g2_nor2_1
X_10396_ _10397_/C _14818_/Q _14819_/Q _10396_/C _10396_/D VDD VSS sg13g2_nand4_1
XFILLER_151_641 VDD VSS sg13g2_decap_8
XFILLER_124_866 VDD VSS sg13g2_decap_4
XFILLER_83_1429 VDD VSS sg13g2_decap_8
X_12135_ _12135_/X _13845_/Q _13877_/Q _13909_/Q _13941_/Q _12138_/S0 _12138_/S1 VDD
+ VSS sg13g2_mux4_1
XFILLER_2_651 VDD VSS sg13g2_decap_8
X_15016__2664 _15016_/RESET_B VDD VSS sg13g2_tiehi
XFILLER_96_205 VDD VSS sg13g2_decap_8
XFILLER_123_376 VDD VSS sg13g2_decap_4
XFILLER_97_739 VDD VSS sg13g2_decap_8
XFILLER_1_161 VDD VSS sg13g2_decap_8
XFILLER_96_238 VDD VSS sg13g2_decap_8
X_12066_ _12066_/X _14131_/Q _14163_/Q _14195_/Q _14227_/Q _12070_/S0 _12073_/S1 VDD
+ VSS sg13g2_mux4_1
XFILLER_133_1232 VDD VSS sg13g2_decap_8
XFILLER_89_290 VDD VSS sg13g2_decap_4
XFILLER_81_1164 VDD VSS sg13g2_decap_8
XFILLER_29_7 VDD VSS sg13g2_decap_8
XFILLER_46_1295 VDD VSS sg13g2_decap_8
X_11017_ _11017_/Y _11027_/B1 _11016_/Y _11044_/C VDD VSS sg13g2_o21ai_1
XFILLER_93_912 VDD VSS sg13g2_decap_4
XFILLER_65_603 VDD VSS sg13g2_decap_8
X_16874_ _16874_/X _16874_/A VDD VSS sg13g2_buf_1
XFILLER_93_923 VDD VSS sg13g2_decap_8
XFILLER_77_485 VDD VSS sg13g2_decap_8
XFILLER_92_422 VDD VSS sg13g2_fill_1
XFILLER_37_327 VDD VSS sg13g2_decap_4
XFILLER_168_1306 VDD VSS sg13g2_decap_8
XFILLER_20_1413 VDD VSS sg13g2_decap_8
XFILLER_38_90 VDD VSS sg13g2_decap_8
XFILLER_93_978 VDD VSS sg13g2_decap_8
XFILLER_65_669 VDD VSS sg13g2_decap_8
XFILLER_80_606 VDD VSS sg13g2_decap_8
X_12968_ _12968_/Y input22/X _12795_/Y _12937_/Y VDD VSS sg13g2_o21ai_1
XFILLER_79_1093 VDD VSS sg13g2_decap_8
X_14707_ _14707_/Q _14739_/CLK _14707_/D _14707_/RESET_B VDD VSS sg13g2_dfrbpq_1
XFILLER_127_1003 VDD VSS sg13g2_decap_4
XFILLER_166_1052 VDD VSS sg13g2_decap_8
X_11919_ _11919_/X _13743_/Q _14095_/Q _14447_/Q _14543_/Q _11925_/S0 _11925_/S1 VDD
+ VSS sg13g2_mux4_1
X_12899_ _12902_/C _12899_/A _12900_/C _12899_/C input27/X VDD VSS sg13g2_nand4_1
XFILLER_166_1096 VDD VSS sg13g2_decap_8
X_14287__1985 _14287_/RESET_B VDD VSS sg13g2_tiehi
X_14638_ _14638_/Q clkload52/A _14638_/D _14638_/RESET_B VDD VSS sg13g2_dfrbpq_1
XFILLER_92_1260 VDD VSS sg13g2_decap_8
XFILLER_144_1350 VDD VSS sg13g2_decap_8
XFILLER_18_1353 VDD VSS sg13g2_decap_8
XFILLER_53_1233 VDD VSS sg13g2_fill_1
XFILLER_14_791 VDD VSS sg13g2_decap_8
XFILLER_60_396 VDD VSS sg13g2_decap_8
XFILLER_20_238 VDD VSS sg13g2_decap_8
X_14569_ _14569_/Q clkload35/A _14569_/D _14569_/RESET_B VDD VSS sg13g2_dfrbpq_1
XFILLER_53_1266 VDD VSS sg13g2_decap_8
XFILLER_105_1356 VDD VSS sg13g2_decap_8
XFILLER_147_947 VDD VSS sg13g2_fill_2
XFILLER_14_1239 VDD VSS sg13g2_decap_8
XFILLER_105_1367 VDD VSS sg13g2_fill_1
XFILLER_173_210 VDD VSS sg13g2_decap_8
X_08090_ _08090_/Y _13427_/C _08090_/B _08090_/C VDD VSS sg13g2_nor3_1
XFILLER_179_1424 VDD VSS sg13g2_decap_8
XFILLER_162_906 VDD VSS sg13g2_decap_8
Xclkload20 clkload20/Y clkload20/A VDD VSS sg13g2_inv_2
XFILLER_9_294 VDD VSS sg13g2_decap_8
XFILLER_174_777 VDD VSS sg13g2_decap_4
Xclkload31 clkload31/Y clkload31/A VDD VSS sg13g2_inv_2
XFILLER_146_479 VDD VSS sg13g2_decap_8
X_13742__2530 _13742_/RESET_B VDD VSS sg13g2_tiehi
Xclkload42 clkload42/Y clkload42/A VDD VSS sg13g2_inv_2
XFILLER_174_799 VDD VSS sg13g2_decap_8
Xclkload53 clkload53/Y clkload53/A VDD VSS sg13g2_inv_1
Xclkload64 clkload64/Y clkload64/A VDD VSS sg13g2_inv_1
Xmax_cap1283 _16875_/A _13713_/Q VDD VSS sg13g2_buf_4
XFILLER_173_287 VDD VSS sg13g2_decap_8
Xmax_cap1294 output40/A _16864_/A VDD VSS sg13g2_buf_4
XFILLER_55_0 VDD VSS sg13g2_decap_8
XFILLER_133_129 VDD VSS sg13g2_fill_1
Xclkload75 clkload75/Y clkload75/A VDD VSS sg13g2_inv_2
XFILLER_115_844 VDD VSS sg13g2_decap_8
Xclkload86 clkload86/Y clkload86/A VDD VSS sg13g2_inv_1
XFILLER_126_181 VDD VSS sg13g2_decap_8
XFILLER_138_1132 VDD VSS sg13g2_decap_8
XFILLER_142_663 VDD VSS sg13g2_decap_8
XFILLER_173_1034 VDD VSS sg13g2_fill_1
XFILLER_170_983 VDD VSS sg13g2_decap_8
XFILLER_130_825 VDD VSS sg13g2_decap_8
Xclkbuf_leaf_120_clk_i clkload27/A clkbuf_5_7__f_clk_i/X VDD VSS sg13g2_buf_8
X_08992_ _08992_/Y _08992_/A _08992_/B _10697_/B VDD VSS sg13g2_nand3_1
XFILLER_130_836 VDD VSS sg13g2_fill_2
X_07943_ _07943_/Y _07797_/X _07927_/Y _07942_/Y VDD VSS sg13g2_o21ai_1
X_14122__2150 _14122_/RESET_B VDD VSS sg13g2_tiehi
XFILLER_60_1215 VDD VSS sg13g2_fill_2
XFILLER_5_1407 VDD VSS sg13g2_decap_8
X_13775__2497 _13775_/RESET_B VDD VSS sg13g2_tiehi
XFILLER_112_1305 VDD VSS sg13g2_decap_8
XFILLER_69_986 VDD VSS sg13g2_decap_8
XFILLER_25_1357 VDD VSS sg13g2_decap_8
XFILLER_68_463 VDD VSS sg13g2_decap_8
XFILLER_112_1316 VDD VSS sg13g2_fill_1
X_07874_ _07876_/B _11454_/A _14994_/Q VDD VSS sg13g2_nand2_1
XFILLER_60_1259 VDD VSS sg13g2_decap_4
XFILLER_151_1387 VDD VSS sg13g2_fill_1
XFILLER_18_49 VDD VSS sg13g2_decap_8
X_09613_ _14209_/D _09613_/A0 _14209_/Q _09633_/S VDD VSS sg13g2_mux2_1
X_14726__1546 _14726_/RESET_B VDD VSS sg13g2_tiehi
XFILLER_3_1120 VDD VSS sg13g2_decap_8
XFILLER_28_349 VDD VSS sg13g2_decap_4
XFILLER_23_1070 VDD VSS sg13g2_decap_8
X_09544_ _14142_/D _10074_/A0 _14142_/Q _09572_/S VDD VSS sg13g2_mux2_1
XFILLER_24_500 VDD VSS sg13g2_decap_8
XFILLER_110_1073 VDD VSS sg13g2_fill_1
XFILLER_149_1250 VDD VSS sg13g2_decap_8
XFILLER_64_680 VDD VSS sg13g2_decap_4
XFILLER_3_1197 VDD VSS sg13g2_decap_8
X_13990__2282 _13990_/RESET_B VDD VSS sg13g2_tiehi
X_09475_ _14075_/D _10071_/A0 _14075_/Q _09478_/S VDD VSS sg13g2_mux2_1
XFILLER_24_555 VDD VSS sg13g2_decap_4
XFILLER_180_1005 VDD VSS sg13g2_decap_8
XFILLER_145_1136 VDD VSS sg13g2_fill_1
XFILLER_169_538 VDD VSS sg13g2_fill_1
X_08426_ _08429_/C _08426_/A _08426_/B VDD VSS sg13g2_nor2_1
XFILLER_12_728 VDD VSS sg13g2_decap_8
XFILLER_51_396 VDD VSS sg13g2_decap_8
XFILLER_11_238 VDD VSS sg13g2_decap_8
XFILLER_133_7 VDD VSS sg13g2_decap_8
X_08357_ _08357_/Y _07790_/A _15003_/Q _08674_/B1 VDD VSS sg13g2_o21ai_1
XFILLER_177_560 VDD VSS sg13g2_decap_8
Xclkload3 clkload3/X clkload3/A VDD VSS sg13g2_buf_8
XFILLER_50_14 VDD VSS sg13g2_decap_8
XFILLER_32_1328 VDD VSS sg13g2_decap_8
XFILLER_166_14 VDD VSS sg13g2_decap_8
X_08288_ _08315_/C _08258_/C _14998_/Q _08863_/A1 _08263_/B VDD VSS sg13g2_a22oi_1
XFILLER_153_906 VDD VSS sg13g2_decap_8
XFILLER_30_1041 VDD VSS sg13g2_decap_8
XFILLER_106_811 VDD VSS sg13g2_decap_8
XFILLER_180_725 VDD VSS sg13g2_decap_8
X_14332__1940 _14332_/RESET_B VDD VSS sg13g2_tiehi
XFILLER_4_938 VDD VSS sg13g2_decap_8
X_10250_ _10258_/D _14776_/Q _14777_/Q _14778_/Q _10250_/D VDD VSS sg13g2_and4_1
XFILLER_152_449 VDD VSS sg13g2_decap_8
XFILLER_3_448 VDD VSS sg13g2_decap_8
XFILLER_59_23 VDD VSS sg13g2_fill_1
XFILLER_59_34 VDD VSS sg13g2_decap_8
X_10181_ _10181_/Y _13613_/A _13508_/B _10174_/Y _14747_/Q VDD VSS sg13g2_a22oi_1
XFILLER_182_35 VDD VSS sg13g2_decap_8
XFILLER_105_387 VDD VSS sg13g2_decap_8
XFILLER_120_313 VDD VSS sg13g2_decap_8
XFILLER_121_836 VDD VSS sg13g2_decap_8
XFILLER_133_696 VDD VSS sg13g2_fill_2
Xfanout1205 _11635_/A _08879_/A1 VDD VSS sg13g2_buf_1
XFILLER_121_847 VDD VSS sg13g2_decap_8
Xfanout1216 _08867_/A1 _14966_/Q VDD VSS sg13g2_buf_1
XFILLER_78_238 VDD VSS sg13g2_decap_8
XFILLER_120_335 VDD VSS sg13g2_decap_8
Xfanout1227 _11428_/A _07912_/B VDD VSS sg13g2_buf_1
Xfanout240 _10085_/A0 _09953_/A1 VDD VSS sg13g2_buf_1
Xfanout1238 _11290_/A _11291_/A VDD VSS sg13g2_buf_1
XFILLER_82_1473 VDD VSS sg13g2_decap_4
Xfanout251 _11723_/A2 _12195_/B1 VDD VSS sg13g2_buf_1
Xfanout1249 _10760_/A _14917_/Q VDD VSS sg13g2_buf_1
XFILLER_87_750 VDD VSS sg13g2_decap_8
X_13940_ _13940_/Q clkload55/A _13940_/D _13940_/RESET_B VDD VSS sg13g2_dfrbpq_1
Xfanout273 _09719_/A0 _09032_/X VDD VSS sg13g2_buf_1
XFILLER_8_1064 VDD VSS sg13g2_decap_8
XFILLER_120_379 VDD VSS sg13g2_decap_8
Xclkbuf_5_20__f_clk_i clkbuf_leaf_99_clk_i/A clkbuf_4_10_0_clk_i/X VDD VSS sg13g2_buf_16
Xfanout284 _09901_/S _09902_/S VDD VSS sg13g2_buf_1
XFILLER_115_84 VDD VSS sg13g2_fill_2
XFILLER_130_1427 VDD VSS sg13g2_fill_1
Xfanout295 _09427_/S _09440_/S VDD VSS sg13g2_buf_1
XFILLER_46_113 VDD VSS sg13g2_decap_8
XFILLER_47_647 VDD VSS sg13g2_decap_8
X_13871_ _13871_/Q clkload13/A _13871_/D _13871_/RESET_B VDD VSS sg13g2_dfrbpq_1
XFILLER_41_1170 VDD VSS sg13g2_decap_8
X_12822_ _12822_/X _14895_/Q _12836_/B VDD VSS sg13g2_xor2_1
XFILLER_15_511 VDD VSS sg13g2_decap_8
XFILLER_43_831 VDD VSS sg13g2_fill_1
XFILLER_91_21 VDD VSS sg13g2_decap_8
XFILLER_43_842 VDD VSS sg13g2_decap_8
XFILLER_131_83 VDD VSS sg13g2_decap_8
X_12753_ _12753_/X _14712_/Q _14744_/Q _13784_/Q _13816_/Q _12757_/S0 _12757_/S1 VDD
+ VSS sg13g2_mux4_1
X_13820__2452 _13820_/RESET_B VDD VSS sg13g2_tiehi
XFILLER_61_149 VDD VSS sg13g2_decap_8
X_14580__1692 _14580_/RESET_B VDD VSS sg13g2_tiehi
XFILLER_76_1266 VDD VSS sg13g2_decap_4
X_11704_ _11707_/A _11663_/B _11771_/B _11771_/A VDD VSS sg13g2_a21o_1
XFILLER_30_503 VDD VSS sg13g2_decap_8
XFILLER_128_1367 VDD VSS sg13g2_decap_4
XFILLER_15_588 VDD VSS sg13g2_decap_8
XFILLER_163_1247 VDD VSS sg13g2_decap_8
X_14836__2965 _14836_/RESET_B VDD VSS sg13g2_tiehi
X_12684_ _12684_/X _14131_/Q _14163_/Q _14195_/Q _14227_/Q _12689_/S0 _12689_/S1 VDD
+ VSS sg13g2_mux4_1
XFILLER_42_374 VDD VSS sg13g2_fill_1
X_14423_ _14423_/Q clkload42/A _14423_/D _14423_/RESET_B VDD VSS sg13g2_dfrbpq_1
XFILLER_129_914 VDD VSS sg13g2_decap_4
XFILLER_175_519 VDD VSS sg13g2_decap_8
X_11635_ _11773_/A _11635_/A _13681_/Q VDD VSS sg13g2_xnor2_1
XFILLER_24_70 VDD VSS sg13g2_decap_8
X_14164__2108 _14164_/RESET_B VDD VSS sg13g2_tiehi
XFILLER_30_569 VDD VSS sg13g2_decap_8
XFILLER_50_1428 VDD VSS sg13g2_decap_8
XFILLER_128_424 VDD VSS sg13g2_decap_8
X_14354_ _14354_/Q clkload22/A _14354_/D _14354_/RESET_B VDD VSS sg13g2_dfrbpq_1
XFILLER_7_721 VDD VSS sg13g2_decap_8
XFILLER_156_744 VDD VSS sg13g2_decap_8
X_14200__2072 _14200_/RESET_B VDD VSS sg13g2_tiehi
X_11566_ _14966_/D _11566_/A _11566_/B VDD VSS sg13g2_nor2_1
XFILLER_144_906 VDD VSS sg13g2_fill_2
XFILLER_156_777 VDD VSS sg13g2_decap_4
X_13305_ _13306_/C _13305_/A _13305_/B VDD VSS sg13g2_nor2_1
XFILLER_6_231 VDD VSS sg13g2_decap_8
XFILLER_116_619 VDD VSS sg13g2_decap_8
X_14869__2899 _14869_/RESET_B VDD VSS sg13g2_tiehi
X_10517_ _10519_/B _10521_/C _10521_/D _14855_/Q VDD VSS sg13g2_a21oi_1
XFILLER_183_574 VDD VSS sg13g2_decap_8
X_14285_ _14285_/Q _14669_/CLK _14285_/D _14285_/RESET_B VDD VSS sg13g2_dfrbpq_1
XFILLER_155_276 VDD VSS sg13g2_decap_8
XFILLER_157_1007 VDD VSS sg13g2_decap_8
XFILLER_171_725 VDD VSS sg13g2_fill_2
X_11497_ _11497_/Y _11498_/A1 _11495_/Y _12292_/A VDD VSS sg13g2_a21oi_1
XFILLER_157_1018 VDD VSS sg13g2_fill_2
XFILLER_87_1340 VDD VSS sg13g2_decap_8
XFILLER_7_798 VDD VSS sg13g2_decap_8
XFILLER_100_1242 VDD VSS sg13g2_decap_8
XFILLER_87_1351 VDD VSS sg13g2_decap_8
X_13236_ _13236_/Y _14795_/Q _13236_/A2 _13236_/B1 VDD VSS sg13g2_o21ai_1
XFILLER_136_490 VDD VSS sg13g2_fill_2
X_10448_ _10450_/B _10453_/C _10514_/A _14839_/Q VDD VSS sg13g2_a21oi_1
XFILLER_152_950 VDD VSS sg13g2_fill_2
XFILLER_48_1324 VDD VSS sg13g2_fill_2
XFILLER_124_652 VDD VSS sg13g2_decap_8
XFILLER_152_961 VDD VSS sg13g2_decap_8
XFILLER_48_1346 VDD VSS sg13g2_fill_2
XFILLER_83_1237 VDD VSS sg13g2_decap_8
XFILLER_174_1354 VDD VSS sg13g2_decap_8
X_13167_ _15044_/D _13160_/Y _13166_/Y _13127_/A VDD VSS sg13g2_a21oi_1
XFILLER_174_1365 VDD VSS sg13g2_decap_8
X_10379_ _14817_/D _10379_/A _10633_/A _10379_/C VDD VSS sg13g2_nor3_1
XFILLER_111_313 VDD VSS sg13g2_decap_8
XFILLER_112_847 VDD VSS sg13g2_fill_2
XFILLER_151_482 VDD VSS sg13g2_decap_4
XFILLER_170_1218 VDD VSS sg13g2_decap_4
X_12118_ _12118_/Y _12116_/Y _12118_/B _12334_/C VDD VSS sg13g2_nand3b_1
XFILLER_69_238 VDD VSS sg13g2_decap_8
X_13098_ _13098_/X input13/X _13161_/A2 _13161_/B1 VDD VSS sg13g2_a21o_1
Xclkbuf_leaf_52_clk_i clkload69/A clkbuf_leaf_81_clk_i/A VDD VSS sg13g2_buf_8
XFILLER_38_603 VDD VSS sg13g2_decap_8
X_12049_ _12049_/Y _12048_/Y _11975_/A _12001_/A VDD VSS sg13g2_a21oi_1
XFILLER_84_219 VDD VSS sg13g2_decap_8
X_14971__2709 _14971_/RESET_B VDD VSS sg13g2_tiehi
XFILLER_66_934 VDD VSS sg13g2_fill_2
XFILLER_133_1084 VDD VSS sg13g2_fill_1
XFILLER_133_1095 VDD VSS sg13g2_decap_8
XFILLER_20_1210 VDD VSS sg13g2_decap_8
X_16857_ _16857_/X _16857_/A VDD VSS sg13g2_buf_1
XFILLER_1_63 VDD VSS sg13g2_decap_8
X_15205__3066 _15205_/RESET_B VDD VSS sg13g2_tiehi
XFILLER_53_628 VDD VSS sg13g2_decap_8
XFILLER_18_371 VDD VSS sg13g2_decap_8
XFILLER_81_948 VDD VSS sg13g2_decap_8
Xclkbuf_leaf_67_clk_i clkload91/A clkbuf_leaf_68_clk_i/A VDD VSS sg13g2_buf_8
XFILLER_20_1287 VDD VSS sg13g2_decap_8
XFILLER_0_1359 VDD VSS sg13g2_decap_8
XFILLER_94_1355 VDD VSS sg13g2_decap_8
X_14410__1862 _14410_/RESET_B VDD VSS sg13g2_tiehi
XFILLER_181_1325 VDD VSS sg13g2_decap_8
X_09260_ _13869_/D _13869_/Q _10156_/A1 _09265_/S VDD VSS sg13g2_mux2_1
XFILLER_107_1429 VDD VSS sg13g2_fill_1
XFILLER_178_357 VDD VSS sg13g2_decap_8
XFILLER_181_1369 VDD VSS sg13g2_decap_4
XFILLER_18_1150 VDD VSS sg13g2_decap_8
X_08211_ _15224_/D _08211_/A _08211_/B _08211_/C _08211_/D VDD VSS sg13g2_nand4_1
X_09191_ _13807_/D _13807_/Q _10158_/A1 _09193_/S VDD VSS sg13g2_mux2_1
XFILLER_60_193 VDD VSS sg13g2_decap_8
XFILLER_140_1011 VDD VSS sg13g2_decap_8
XFILLER_14_1036 VDD VSS sg13g2_decap_8
X_08142_ _08142_/Y _08142_/A _08142_/B _08142_/C VDD VSS sg13g2_nand3_1
XFILLER_186_390 VDD VSS sg13g2_decap_4
XFILLER_105_1186 VDD VSS sg13g2_decap_8
XFILLER_140_1077 VDD VSS sg13g2_decap_8
XFILLER_162_703 VDD VSS sg13g2_decap_8
X_08073_ _08074_/C _08073_/A _08073_/B _08073_/C VDD VSS sg13g2_nand3_1
XFILLER_107_619 VDD VSS sg13g2_decap_8
XFILLER_88_1137 VDD VSS sg13g2_decap_4
XFILLER_20_28 VDD VSS sg13g2_decap_8
XFILLER_174_596 VDD VSS sg13g2_decap_8
Xmax_cap930 _12755_/S0 _12758_/S0 VDD VSS sg13g2_buf_8
XFILLER_115_641 VDD VSS sg13g2_decap_4
XFILLER_136_39 VDD VSS sg13g2_decap_4
XFILLER_143_950 VDD VSS sg13g2_fill_1
XFILLER_66_1435 VDD VSS sg13g2_decap_8
XFILLER_115_674 VDD VSS sg13g2_decap_8
XFILLER_130_600 VDD VSS sg13g2_decap_8
XFILLER_161_279 VDD VSS sg13g2_decap_8
XFILLER_115_685 VDD VSS sg13g2_fill_1
XFILLER_143_994 VDD VSS sg13g2_decap_8
XFILLER_88_514 VDD VSS sg13g2_decap_8
XFILLER_102_324 VDD VSS sg13g2_fill_1
XFILLER_102_335 VDD VSS sg13g2_decap_8
XFILLER_153_1449 VDD VSS sg13g2_decap_8
XFILLER_130_655 VDD VSS sg13g2_fill_2
X_08975_ _10675_/C _15220_/Q _13305_/A VDD VSS sg13g2_nor2b_1
XFILLER_9_1351 VDD VSS sg13g2_decap_8
XFILLER_29_1290 VDD VSS sg13g2_decap_8
XFILLER_75_208 VDD VSS sg13g2_decap_8
XFILLER_5_1204 VDD VSS sg13g2_decap_8
X_07926_ _07926_/X _07926_/A _07926_/B VDD VSS sg13g2_or2_1
XFILLER_99_1200 VDD VSS sg13g2_decap_8
XFILLER_57_912 VDD VSS sg13g2_decap_8
XFILLER_99_1211 VDD VSS sg13g2_fill_2
XFILLER_69_783 VDD VSS sg13g2_decap_8
XFILLER_25_1154 VDD VSS sg13g2_decap_8
XFILLER_56_433 VDD VSS sg13g2_decap_8
XFILLER_28_124 VDD VSS sg13g2_decap_4
X_07857_ _07857_/X _15014_/Q _07859_/B VDD VSS sg13g2_or2_1
XFILLER_57_967 VDD VSS sg13g2_decap_4
XFILLER_28_146 VDD VSS sg13g2_decap_8
XFILLER_28_157 VDD VSS sg13g2_fill_1
XFILLER_16_308 VDD VSS sg13g2_decap_8
XFILLER_45_14 VDD VSS sg13g2_decap_8
XFILLER_44_617 VDD VSS sg13g2_decap_8
XFILLER_186_1236 VDD VSS sg13g2_decap_8
XFILLER_186_1247 VDD VSS sg13g2_decap_8
XFILLER_43_105 VDD VSS sg13g2_fill_1
X_07788_ _07797_/C _08414_/A _08414_/B _08414_/D VDD VSS sg13g2_o21ai_1
XFILLER_72_948 VDD VSS sg13g2_decap_8
XFILLER_25_820 VDD VSS sg13g2_decap_8
X_09527_ _14126_/D _09727_/A0 _14126_/Q _09539_/S VDD VSS sg13g2_mux2_1
XFILLER_71_469 VDD VSS sg13g2_decap_4
XFILLER_24_341 VDD VSS sg13g2_decap_4
X_09458_ _14059_/D _09922_/A1 _14059_/Q wire504/X VDD VSS sg13g2_mux2_1
XFILLER_80_992 VDD VSS sg13g2_decap_4
XFILLER_12_525 VDD VSS sg13g2_decap_8
XFILLER_160_1409 VDD VSS sg13g2_fill_2
X_08409_ _08410_/B _08070_/C _08407_/Y _08408_/Y VDD VSS sg13g2_a21o_1
XFILLER_51_193 VDD VSS sg13g2_decap_8
XFILLER_101_97 VDD VSS sg13g2_decap_8
X_09389_ _13992_/D _09620_/A0 _13992_/Q _09394_/S VDD VSS sg13g2_mux2_1
XFILLER_8_518 VDD VSS sg13g2_decap_8
XFILLER_61_57 VDD VSS sg13g2_decap_8
XFILLER_123_1220 VDD VSS sg13g2_decap_4
XFILLER_138_711 VDD VSS sg13g2_decap_4
XFILLER_178_880 VDD VSS sg13g2_fill_2
XFILLER_177_35 VDD VSS sg13g2_decap_8
XFILLER_184_327 VDD VSS sg13g2_decap_8
XFILLER_123_1242 VDD VSS sg13g2_decap_8
XFILLER_184_338 VDD VSS sg13g2_decap_8
X_11420_ _11420_/Y _11420_/A _11420_/B _11898_/C VDD VSS sg13g2_nand3_1
XFILLER_137_254 VDD VSS sg13g2_decap_8
X_11351_ _11351_/Y _11347_/Y _11348_/Y _11350_/Y _11349_/Y _11898_/C VDD VSS sg13g2_a221oi_1
XFILLER_180_511 VDD VSS sg13g2_decap_8
XFILLER_119_991 VDD VSS sg13g2_decap_8
XFILLER_152_224 VDD VSS sg13g2_fill_1
X_10302_ _14794_/D _14794_/Q _10299_/Y _10301_/Y VDD VSS sg13g2_a21oi_1
XFILLER_4_735 VDD VSS sg13g2_decap_8
X_14070_ _14070_/Q clkload41/A _14070_/D _14070_/RESET_B VDD VSS sg13g2_dfrbpq_1
XFILLER_106_630 VDD VSS sg13g2_decap_8
XFILLER_10_1456 VDD VSS sg13g2_decap_8
X_11282_ _11283_/A _13948_/Q _13980_/Q _14012_/Q _14044_/Q _11218_/S _12319_/B1 VDD
+ VSS sg13g2_mux4_1
XFILLER_3_245 VDD VSS sg13g2_decap_8
X_13021_ _15034_/D _13021_/A _13021_/B VDD VSS sg13g2_nor2_1
XFILLER_140_419 VDD VSS sg13g2_decap_8
XFILLER_152_279 VDD VSS sg13g2_decap_8
XFILLER_180_588 VDD VSS sg13g2_decap_8
X_10233_ _10237_/D _14772_/Q _14773_/Q VDD VSS sg13g2_nand2_1
XFILLER_106_674 VDD VSS sg13g2_decap_8
XFILLER_156_1051 VDD VSS sg13g2_fill_1
XFILLER_134_994 VDD VSS sg13g2_decap_8
X_13838__2434 _13838_/RESET_B VDD VSS sg13g2_tiehi
X_14598__1674 _14598_/RESET_B VDD VSS sg13g2_tiehi
Xfanout1002 _13438_/B _13396_/C VDD VSS sg13g2_buf_1
X_10164_ _14741_/D _14741_/Q _10164_/A1 _10168_/S VDD VSS sg13g2_mux2_1
XFILLER_105_195 VDD VSS sg13g2_decap_8
XFILLER_117_1046 VDD VSS sg13g2_decap_8
Xfanout1013 _13481_/A _15127_/Q VDD VSS sg13g2_buf_1
Xfanout1024 _13218_/B _13260_/B VDD VSS sg13g2_buf_1
Xfanout1035 _08552_/A1 _08698_/B VDD VSS sg13g2_buf_1
XFILLER_43_1232 VDD VSS sg13g2_decap_8
XFILLER_0_974 VDD VSS sg13g2_decap_8
Xfanout1046 _08788_/A1 _13345_/B VDD VSS sg13g2_buf_1
XFILLER_120_165 VDD VSS sg13g2_decap_8
X_14972_ _14972_/Q _15237_/CLK _14972_/D _14972_/RESET_B VDD VSS sg13g2_dfrbpq_1
Xfanout1057 _09905_/A _09938_/A VDD VSS sg13g2_buf_1
X_10095_ _14675_/D _10095_/A0 _14675_/Q _10097_/S VDD VSS sg13g2_mux2_1
XFILLER_130_1202 VDD VSS sg13g2_fill_1
Xfanout1068 _09240_/A _09707_/B VDD VSS sg13g2_buf_1
XFILLER_48_934 VDD VSS sg13g2_fill_1
Xfanout1079 _13305_/A _15059_/Q VDD VSS sg13g2_buf_1
XFILLER_87_591 VDD VSS sg13g2_decap_8
XFILLER_86_98 VDD VSS sg13g2_fill_1
XFILLER_130_1235 VDD VSS sg13g2_fill_1
X_13923_ _13923_/Q clkload30/A _13923_/D _13923_/RESET_B VDD VSS sg13g2_dfrbpq_1
XFILLER_59_293 VDD VSS sg13g2_decap_8
XFILLER_48_956 VDD VSS sg13g2_decap_8
XFILLER_19_70 VDD VSS sg13g2_decap_8
XFILLER_75_753 VDD VSS sg13g2_decap_8
XFILLER_48_967 VDD VSS sg13g2_fill_1
XFILLER_19_168 VDD VSS sg13g2_decap_8
X_14218__2054 _14218_/RESET_B VDD VSS sg13g2_tiehi
XFILLER_75_786 VDD VSS sg13g2_decap_8
X_13854_ _13854_/Q _14734_/CLK _13854_/D _13854_/RESET_B VDD VSS sg13g2_dfrbpq_1
XFILLER_90_745 VDD VSS sg13g2_decap_8
X_12805_ _12805_/Y _12914_/A _12802_/Y _12804_/Y VDD VSS sg13g2_o21ai_1
X_13785_ _13785_/Q _14745_/CLK _13785_/D _13785_/RESET_B VDD VSS sg13g2_dfrbpq_1
X_10997_ _10997_/Y _10995_/Y _10996_/Y _11044_/C VDD VSS sg13g2_o21ai_1
XFILLER_76_1052 VDD VSS sg13g2_fill_2
XFILLER_31_812 VDD VSS sg13g2_fill_1
X_12736_ _15016_/D _12736_/A _12736_/B VDD VSS sg13g2_nor2_1
XFILLER_37_1036 VDD VSS sg13g2_fill_2
XFILLER_43_683 VDD VSS sg13g2_decap_8
XFILLER_128_1164 VDD VSS sg13g2_decap_8
XFILLER_15_385 VDD VSS sg13g2_decap_8
XFILLER_96_7 VDD VSS sg13g2_decap_8
XFILLER_124_1017 VDD VSS sg13g2_decap_8
XFILLER_15_1312 VDD VSS sg13g2_decap_8
X_12667_ _12680_/A _12751_/A1 _12737_/A2 _15012_/Q VDD VSS sg13g2_a21oi_1
XFILLER_31_878 VDD VSS sg13g2_fill_2
XFILLER_30_355 VDD VSS sg13g2_decap_8
XFILLER_175_327 VDD VSS sg13g2_decap_8
XFILLER_129_733 VDD VSS sg13g2_decap_8
XFILLER_180_1380 VDD VSS sg13g2_fill_2
X_14406_ _14406_/Q clkload20/A _14406_/D _14406_/RESET_B VDD VSS sg13g2_dfrbpq_1
X_11618_ _11618_/Y _11741_/A _13894_/Q VDD VSS sg13g2_nand2b_1
XFILLER_102_1315 VDD VSS sg13g2_decap_4
X_12598_ _12611_/A _12751_/A1 _12737_/A2 _07805_/B VDD VSS sg13g2_a21oi_1
XFILLER_50_1247 VDD VSS sg13g2_decap_8
XFILLER_15_1389 VDD VSS sg13g2_decap_8
X_14337_ _14337_/Q _14745_/CLK _14337_/D _14337_/RESET_B VDD VSS sg13g2_dfrbpq_1
XFILLER_117_939 VDD VSS sg13g2_decap_8
X_11549_ _11549_/X _11549_/A _12239_/B VDD VSS sg13g2_and2_1
XFILLER_171_511 VDD VSS sg13g2_decap_8
XFILLER_183_371 VDD VSS sg13g2_decap_8
XFILLER_116_427 VDD VSS sg13g2_decap_8
XFILLER_144_747 VDD VSS sg13g2_decap_8
XFILLER_176_1427 VDD VSS sg13g2_decap_8
XFILLER_176_1438 VDD VSS sg13g2_fill_2
XFILLER_7_595 VDD VSS sg13g2_decap_8
XFILLER_143_235 VDD VSS sg13g2_decap_8
X_14268_ _14268_/Q _14716_/CLK _14268_/D _14268_/RESET_B VDD VSS sg13g2_dfrbpq_1
XFILLER_100_1061 VDD VSS sg13g2_decap_8
XFILLER_125_961 VDD VSS sg13g2_fill_2
X_13219_ _13219_/Y _14826_/Q _13206_/B _07727_/C _14890_/Q _13274_/C1 VDD VSS sg13g2_a221oi_1
XFILLER_87_1181 VDD VSS sg13g2_fill_1
X_14199_ _14199_/Q clkload46/A _14199_/D _14199_/RESET_B VDD VSS sg13g2_dfrbpq_1
XFILLER_135_1113 VDD VSS sg13g2_decap_8
XFILLER_174_1162 VDD VSS sg13g2_decap_8
XFILLER_135_1124 VDD VSS sg13g2_fill_1
XFILLER_152_791 VDD VSS sg13g2_fill_1
XFILLER_170_1004 VDD VSS sg13g2_decap_8
XFILLER_174_1173 VDD VSS sg13g2_fill_2
XFILLER_98_845 VDD VSS sg13g2_decap_8
XFILLER_44_1007 VDD VSS sg13g2_decap_8
XFILLER_111_110 VDD VSS sg13g2_fill_2
XFILLER_112_644 VDD VSS sg13g2_decap_8
XFILLER_174_1184 VDD VSS sg13g2_decap_8
X_14428__1844 _14428_/RESET_B VDD VSS sg13g2_tiehi
XFILLER_100_817 VDD VSS sg13g2_decap_8
XFILLER_111_143 VDD VSS sg13g2_decap_8
XFILLER_112_677 VDD VSS sg13g2_fill_1
XFILLER_85_517 VDD VSS sg13g2_fill_1
XFILLER_140_997 VDD VSS sg13g2_decap_8
X_08760_ _08760_/Y _07720_/A _07720_/B _15190_/Q VDD VSS sg13g2_o21ai_1
XFILLER_57_219 VDD VSS sg13g2_fill_1
XFILLER_39_923 VDD VSS sg13g2_fill_1
X_13666__2633 _13666_/RESET_B VDD VSS sg13g2_tiehi
XFILLER_61_1354 VDD VSS sg13g2_decap_8
XFILLER_26_1474 VDD VSS sg13g2_decap_4
XFILLER_61_1365 VDD VSS sg13g2_fill_1
XFILLER_111_198 VDD VSS sg13g2_decap_4
XFILLER_18_0 VDD VSS sg13g2_decap_8
X_07711_ _07748_/B _13438_/A _07754_/B VDD VSS sg13g2_and2_1
XFILLER_61_1376 VDD VSS sg13g2_decap_8
XFILLER_22_1338 VDD VSS sg13g2_decap_8
XFILLER_39_967 VDD VSS sg13g2_fill_1
X_08691_ _08693_/B _08692_/C _08692_/B _08690_/X VDD VSS sg13g2_o21ai_1
XFILLER_66_753 VDD VSS sg13g2_decap_8
XFILLER_81_712 VDD VSS sg13g2_decap_8
XFILLER_66_786 VDD VSS sg13g2_decap_8
XFILLER_26_617 VDD VSS sg13g2_fill_2
X_07642_ _10265_/C _14783_/Q VDD VSS sg13g2_inv_1
XFILLER_4_1281 VDD VSS sg13g2_decap_8
X_14917__2803 _14917_/RESET_B VDD VSS sg13g2_tiehi
XFILLER_0_1156 VDD VSS sg13g2_decap_8
XFILLER_20_1084 VDD VSS sg13g2_decap_8
XFILLER_53_469 VDD VSS sg13g2_fill_2
XFILLER_15_28 VDD VSS sg13g2_decap_8
XFILLER_59_1272 VDD VSS sg13g2_fill_1
X_09312_ _13919_/D _10109_/A0 _13919_/Q _09327_/S VDD VSS sg13g2_mux2_1
XFILLER_181_1122 VDD VSS sg13g2_decap_8
XFILLER_185_1291 VDD VSS sg13g2_decap_8
XFILLER_179_644 VDD VSS sg13g2_decap_8
XFILLER_62_992 VDD VSS sg13g2_decap_8
XFILLER_94_1196 VDD VSS sg13g2_decap_8
XFILLER_146_1264 VDD VSS sg13g2_fill_2
XFILLER_90_1038 VDD VSS sg13g2_decap_8
XFILLER_181_1155 VDD VSS sg13g2_decap_8
XFILLER_33_182 VDD VSS sg13g2_decap_8
XFILLER_139_519 VDD VSS sg13g2_decap_8
XFILLER_146_1286 VDD VSS sg13g2_decap_8
XFILLER_178_154 VDD VSS sg13g2_decap_8
XFILLER_21_333 VDD VSS sg13g2_decap_8
X_09243_ _13852_/D _13852_/Q _09907_/A1 _09261_/S VDD VSS sg13g2_mux2_1
XFILLER_72_1450 VDD VSS sg13g2_decap_8
XFILLER_179_699 VDD VSS sg13g2_fill_2
X_13916__2356 _13916_/RESET_B VDD VSS sg13g2_tiehi
X_14676__1596 _14676_/RESET_B VDD VSS sg13g2_tiehi
XFILLER_33_1434 VDD VSS sg13g2_decap_8
X_09174_ _13790_/D _13790_/Q _10141_/A1 _09202_/S VDD VSS sg13g2_mux2_1
XFILLER_119_232 VDD VSS sg13g2_decap_8
XFILLER_181_308 VDD VSS sg13g2_decap_8
XFILLER_31_49 VDD VSS sg13g2_decap_8
X_08125_ _08126_/B _08688_/D _08124_/X _08452_/D VDD VSS sg13g2_mux2_1
XFILLER_135_714 VDD VSS sg13g2_decap_8
XFILLER_179_1073 VDD VSS sg13g2_decap_8
XFILLER_31_1180 VDD VSS sg13g2_decap_8
XFILLER_135_758 VDD VSS sg13g2_fill_2
X_14820__2986 _14820_/RESET_B VDD VSS sg13g2_tiehi
X_08056_ _08056_/Y _08167_/B _08428_/S VDD VSS sg13g2_nand2b_1
XFILLER_150_717 VDD VSS sg13g2_decap_8
Xoutput49 mem_axi_araddr[20] _13711_/Q VDD VSS sg13g2_buf_1
Xhold3110 input37/A mem_axi_wready VDD VSS sg13g2_dlygate4sd3_1
XFILLER_115_482 VDD VSS sg13g2_decap_8
Xhold3121 hold3121/X input15/X VDD VSS sg13g2_dlygate4sd3_1
XFILLER_27_1216 VDD VSS sg13g2_decap_8
XFILLER_1_749 VDD VSS sg13g2_decap_8
XFILLER_89_856 VDD VSS sg13g2_decap_8
Xhold3132 input35/A mem_axi_rdata[9] VDD VSS sg13g2_dlygate4sd3_1
XFILLER_131_964 VDD VSS sg13g2_decap_8
Xhold3143 input6/A mem_axi_rdata[11] VDD VSS sg13g2_dlygate4sd3_1
Xhold3154 input24/A mem_axi_rdata[28] VDD VSS sg13g2_dlygate4sd3_1
XFILLER_0_259 VDD VSS sg13g2_decap_8
XFILLER_103_666 VDD VSS sg13g2_fill_1
Xhold3165 _13343_/B _15069_/Q VDD VSS sg13g2_dlygate4sd3_1
XFILLER_102_154 VDD VSS sg13g2_decap_8
Xhold3176 input11/A mem_axi_rdata[16] VDD VSS sg13g2_dlygate4sd3_1
XFILLER_88_377 VDD VSS sg13g2_decap_8
XFILLER_76_517 VDD VSS sg13g2_decap_8
XFILLER_103_688 VDD VSS sg13g2_decap_8
XFILLER_153_1279 VDD VSS sg13g2_decap_8
Xhold3187 input1/A mem_axi_arready VDD VSS sg13g2_dlygate4sd3_1
X_08958_ _10105_/D _09905_/A _10004_/A VDD VSS sg13g2_nor2_1
XFILLER_88_388 VDD VSS sg13g2_fill_2
XFILLER_5_1001 VDD VSS sg13g2_decap_8
Xhold3198 _13631_/A _13739_/Q VDD VSS sg13g2_dlygate4sd3_1
X_07909_ _07909_/Y _14994_/Q _07909_/B VDD VSS sg13g2_nor2_1
XFILLER_56_35 VDD VSS sg13g2_decap_8
XFILLER_56_230 VDD VSS sg13g2_decap_4
X_14282__1990 _14282_/RESET_B VDD VSS sg13g2_tiehi
X_08889_ _13705_/D _08941_/S _08887_/Y _08888_/Y VDD VSS sg13g2_a21oi_1
XFILLER_99_1063 VDD VSS sg13g2_fill_2
XFILLER_5_1078 VDD VSS sg13g2_decap_8
XFILLER_186_1022 VDD VSS sg13g2_fill_1
X_10920_ _10934_/B _10920_/A _10920_/B VDD VSS sg13g2_nand2_1
XFILLER_56_263 VDD VSS sg13g2_fill_1
XFILLER_16_105 VDD VSS sg13g2_decap_8
XFILLER_72_734 VDD VSS sg13g2_decap_8
XFILLER_147_1006 VDD VSS sg13g2_decap_8
X_14765__3041 _14765_/RESET_B VDD VSS sg13g2_tiehi
X_10851_ _10871_/B _10851_/A _10870_/A _10851_/C _10851_/D VDD VSS sg13g2_nand4_1
XFILLER_32_609 VDD VSS sg13g2_decap_8
XFILLER_112_85 VDD VSS sg13g2_decap_4
XFILLER_77_1372 VDD VSS sg13g2_decap_8
XFILLER_13_812 VDD VSS sg13g2_decap_8
XFILLER_164_1331 VDD VSS sg13g2_decap_8
XFILLER_73_1214 VDD VSS sg13g2_decap_8
X_13570_ _15155_/D _15155_/Q _13569_/X _13570_/S VDD VSS sg13g2_mux2_1
XFILLER_73_1225 VDD VSS sg13g2_decap_4
XFILLER_38_1345 VDD VSS sg13g2_decap_8
X_10782_ _11164_/C _14953_/Q _10716_/A _10781_/X VDD VSS sg13g2_a21oi_1
XFILLER_73_1236 VDD VSS sg13g2_decap_8
XFILLER_71_299 VDD VSS sg13g2_decap_8
XFILLER_12_322 VDD VSS sg13g2_decap_8
XFILLER_125_1326 VDD VSS sg13g2_decap_8
X_12521_ _12521_/X _14119_/Q _14151_/Q _14183_/Q _14215_/Q _12522_/S0 _12522_/S1 VDD
+ VSS sg13g2_mux4_1
XFILLER_9_805 VDD VSS sg13g2_decap_8
XFILLER_158_839 VDD VSS sg13g2_decap_8
XFILLER_164_1397 VDD VSS sg13g2_decap_8
XFILLER_125_1359 VDD VSS sg13g2_decap_8
XFILLER_13_889 VDD VSS sg13g2_decap_8
XFILLER_8_315 VDD VSS sg13g2_decap_8
X_15240_ _15240_/Q _15249_/CLK _15240_/D _15240_/RESET_B VDD VSS sg13g2_dfrbpq_1
XFILLER_185_658 VDD VSS sg13g2_decap_8
X_12452_ _12452_/X _14242_/Q _14274_/Q _14306_/Q _14338_/Q _12452_/S0 _12452_/S1 VDD
+ VSS sg13g2_mux4_1
XFILLER_12_399 VDD VSS sg13g2_decap_8
X_14506__1766 _14506_/RESET_B VDD VSS sg13g2_tiehi
XFILLER_122_0 VDD VSS sg13g2_decap_8
XFILLER_184_168 VDD VSS sg13g2_fill_2
X_11403_ _11403_/X _13727_/Q _14079_/Q _14431_/Q _14527_/Q _11415_/S _11401_/C VDD
+ VSS sg13g2_mux4_1
XFILLER_166_883 VDD VSS sg13g2_decap_4
X_15171_ _15171_/Q clkload85/A _15171_/D _15171_/RESET_B VDD VSS sg13g2_dfrbpq_1
X_12383_ _12383_/X _12376_/X _12380_/X _12375_/X _12379_/X _12355_/S _12622_/S0 VDD
+ VSS sg13g2_mux4_1
XFILLER_138_585 VDD VSS sg13g2_decap_8
XFILLER_125_213 VDD VSS sg13g2_decap_8
XFILLER_165_382 VDD VSS sg13g2_decap_8
XFILLER_181_842 VDD VSS sg13g2_decap_8
X_14122_ _14122_/Q clkload27/A _14122_/D _14122_/RESET_B VDD VSS sg13g2_dfrbpq_1
X_15204__3065 _15204_/RESET_B VDD VSS sg13g2_tiehi
X_11334_ _11336_/A _11335_/A _13691_/Q VDD VSS sg13g2_and2_1
XFILLER_4_532 VDD VSS sg13g2_decap_8
XFILLER_10_1253 VDD VSS sg13g2_decap_8
XFILLER_158_1146 VDD VSS sg13g2_fill_2
XFILLER_119_1119 VDD VSS sg13g2_decap_8
XFILLER_137_71 VDD VSS sg13g2_fill_1
XFILLER_181_886 VDD VSS sg13g2_decap_8
X_14053_ _14053_/Q clkload8/A _14053_/D _14053_/RESET_B VDD VSS sg13g2_dfrbpq_1
X_11265_ _11266_/A _14684_/Q _14716_/Q _13756_/Q _13788_/Q _11279_/A1 _11262_/B VDD
+ VSS sg13g2_mux4_1
XFILLER_180_385 VDD VSS sg13g2_decap_8
X_14721__1551 _14721_/RESET_B VDD VSS sg13g2_tiehi
XFILLER_175_1471 VDD VSS sg13g2_decap_8
XFILLER_45_1305 VDD VSS sg13g2_decap_8
X_13004_ _13005_/B _12999_/Y _07683_/A _13003_/Y VDD VSS sg13g2_a21oi_1
XFILLER_106_493 VDD VSS sg13g2_decap_8
X_10216_ _10216_/Y _13316_/B _10216_/B VDD VSS sg13g2_nor2_1
X_11196_ _11209_/A _14956_/Q _11196_/B VDD VSS sg13g2_nand2_1
XFILLER_84_1398 VDD VSS sg13g2_fill_1
XFILLER_121_463 VDD VSS sg13g2_decap_8
XFILLER_0_771 VDD VSS sg13g2_decap_8
XFILLER_171_1379 VDD VSS sg13g2_decap_8
X_10147_ _14724_/D _14724_/Q _10147_/A1 _10167_/S VDD VSS sg13g2_mux2_1
XFILLER_79_388 VDD VSS sg13g2_decap_8
XFILLER_95_848 VDD VSS sg13g2_fill_1
XFILLER_11_7 VDD VSS sg13g2_decap_8
XFILLER_48_742 VDD VSS sg13g2_decap_8
X_14955_ _14955_/Q clkload75/A _14955_/D _14955_/RESET_B VDD VSS sg13g2_dfrbpq_1
XFILLER_94_358 VDD VSS sg13g2_decap_8
XFILLER_48_753 VDD VSS sg13g2_fill_1
XFILLER_130_1032 VDD VSS sg13g2_decap_8
X_10078_ _14658_/D _10078_/A0 _14658_/Q _10097_/S VDD VSS sg13g2_mux2_1
XFILLER_75_561 VDD VSS sg13g2_decap_8
XFILLER_47_263 VDD VSS sg13g2_decap_8
X_13906_ _13906_/Q clkload15/A _13906_/D _13906_/RESET_B VDD VSS sg13g2_dfrbpq_1
XFILLER_1_1421 VDD VSS sg13g2_decap_8
X_14886_ _14886_/Q _14886_/CLK _14886_/D _14886_/RESET_B VDD VSS sg13g2_dfrbpq_1
XFILLER_36_948 VDD VSS sg13g2_decap_8
XFILLER_35_425 VDD VSS sg13g2_decap_8
XFILLER_21_1382 VDD VSS sg13g2_decap_8
XFILLER_39_1109 VDD VSS sg13g2_fill_2
X_13837_ _13837_/Q _14733_/CLK _13837_/D _13837_/RESET_B VDD VSS sg13g2_dfrbpq_1
XFILLER_95_1450 VDD VSS sg13g2_decap_8
XFILLER_56_1401 VDD VSS sg13g2_decap_8
XFILLER_51_918 VDD VSS sg13g2_decap_8
XFILLER_62_255 VDD VSS sg13g2_decap_8
XFILLER_16_672 VDD VSS sg13g2_decap_8
XFILLER_22_119 VDD VSS sg13g2_decap_8
XFILLER_50_428 VDD VSS sg13g2_decap_4
X_13768_ _13768_/Q clkload23/A _13768_/D _13768_/RESET_B VDD VSS sg13g2_dfrbpq_1
XFILLER_15_182 VDD VSS sg13g2_decap_8
XFILLER_17_1418 VDD VSS sg13g2_decap_8
XFILLER_91_1347 VDD VSS sg13g2_decap_8
X_12719_ _12719_/X _12710_/X _12711_/X _12717_/X _12716_/X _12732_/S0 _12762_/S VDD
+ VSS sg13g2_mux4_1
X_13699_ _16861_/A _15226_/CLK _13699_/D _13699_/RESET_B VDD VSS sg13g2_dfrbpq_1
XFILLER_129_541 VDD VSS sg13g2_decap_4
XFILLER_54_1191 VDD VSS sg13g2_fill_2
XFILLER_175_168 VDD VSS sg13g2_decap_8
XFILLER_102_1134 VDD VSS sg13g2_decap_4
XFILLER_144_500 VDD VSS sg13g2_decap_8
XFILLER_15_1186 VDD VSS sg13g2_decap_8
XFILLER_157_894 VDD VSS sg13g2_decap_8
XFILLER_8_882 VDD VSS sg13g2_decap_8
XFILLER_117_747 VDD VSS sg13g2_decap_4
XFILLER_7_84 VDD VSS sg13g2_decap_8
XFILLER_7_392 VDD VSS sg13g2_decap_8
XFILLER_171_341 VDD VSS sg13g2_decap_8
XFILLER_176_1257 VDD VSS sg13g2_decap_8
XFILLER_104_419 VDD VSS sg13g2_decap_8
XFILLER_137_1219 VDD VSS sg13g2_decap_8
X_09930_ _14515_/D _14515_/Q _09930_/A1 _09935_/S VDD VSS sg13g2_mux2_1
XFILLER_144_588 VDD VSS sg13g2_decap_8
XFILLER_63_1405 VDD VSS sg13g2_decap_8
Xfanout806 _08223_/S _08138_/B VDD VSS sg13g2_buf_1
XFILLER_124_290 VDD VSS sg13g2_fill_2
Xfanout817 _08079_/S _07627_/Y VDD VSS sg13g2_buf_1
X_09861_ _14448_/D _14448_/Q _10159_/A1 _09871_/S VDD VSS sg13g2_mux2_1
XFILLER_98_653 VDD VSS sg13g2_decap_8
XFILLER_112_441 VDD VSS sg13g2_decap_8
XFILLER_140_750 VDD VSS sg13g2_fill_1
Xfanout828 _11109_/B _11082_/A1 VDD VSS sg13g2_buf_1
XFILLER_113_975 VDD VSS sg13g2_fill_2
XFILLER_113_986 VDD VSS sg13g2_fill_1
Xfanout839 _12553_/S _12692_/S VDD VSS sg13g2_buf_1
X_08812_ _08812_/Y _13482_/A _15193_/Q VDD VSS sg13g2_nand2_1
XFILLER_140_783 VDD VSS sg13g2_decap_8
X_09792_ _14381_/D _09924_/A1 _14381_/Q _09797_/S VDD VSS sg13g2_mux2_1
XFILLER_97_196 VDD VSS sg13g2_decap_8
XFILLER_26_1271 VDD VSS sg13g2_decap_8
XFILLER_100_658 VDD VSS sg13g2_decap_8
X_08743_ _08743_/Y _13666_/Q _08775_/B VDD VSS sg13g2_nor2_1
XFILLER_6_1365 VDD VSS sg13g2_decap_8
XFILLER_38_230 VDD VSS sg13g2_fill_2
XFILLER_22_1135 VDD VSS sg13g2_decap_8
XFILLER_39_764 VDD VSS sg13g2_fill_1
XFILLER_2_1218 VDD VSS sg13g2_decap_8
X_08674_ _08674_/Y _08684_/A _08037_/C _08674_/B1 _08673_/X _08672_/X VDD VSS sg13g2_a221oi_1
XFILLER_38_274 VDD VSS sg13g2_fill_2
X_15029__2651 _15029_/RESET_B VDD VSS sg13g2_tiehi
XFILLER_54_734 VDD VSS sg13g2_decap_8
XFILLER_81_531 VDD VSS sg13g2_decap_8
X_07625_ _07625_/Y _13316_/B VDD VSS sg13g2_inv_1
XFILLER_81_542 VDD VSS sg13g2_fill_2
XFILLER_26_49 VDD VSS sg13g2_decap_8
XFILLER_14_609 VDD VSS sg13g2_decap_8
XFILLER_26_469 VDD VSS sg13g2_decap_8
XFILLER_81_575 VDD VSS sg13g2_decap_8
XFILLER_81_586 VDD VSS sg13g2_fill_1
XFILLER_53_277 VDD VSS sg13g2_decap_8
XFILLER_13_119 VDD VSS sg13g2_decap_8
XFILLER_59_1080 VDD VSS sg13g2_fill_2
XFILLER_179_441 VDD VSS sg13g2_decap_8
XFILLER_41_439 VDD VSS sg13g2_decap_8
X_14753__3056 _14753_/RESET_B VDD VSS sg13g2_tiehi
X_15157__2736 _15157_/RESET_B VDD VSS sg13g2_tiehi
XFILLER_167_614 VDD VSS sg13g2_decap_8
XFILLER_50_973 VDD VSS sg13g2_decap_8
XFILLER_22_675 VDD VSS sg13g2_decap_8
XFILLER_10_826 VDD VSS sg13g2_decap_8
X_09226_ _13837_/D _10156_/A1 _13837_/Q _09231_/S VDD VSS sg13g2_mux2_1
XFILLER_22_686 VDD VSS sg13g2_fill_1
XFILLER_21_196 VDD VSS sg13g2_decap_8
XFILLER_6_819 VDD VSS sg13g2_decap_8
XFILLER_33_1253 VDD VSS sg13g2_decap_4
XFILLER_108_703 VDD VSS sg13g2_decap_8
XFILLER_166_168 VDD VSS sg13g2_decap_8
XFILLER_124_1392 VDD VSS sg13g2_fill_2
XFILLER_148_883 VDD VSS sg13g2_decap_8
XFILLER_181_105 VDD VSS sg13g2_decap_8
X_09157_ _09158_/C _14924_/Q _14923_/Q _09157_/C _09157_/D VDD VSS sg13g2_nand4_1
XFILLER_163_820 VDD VSS sg13g2_decap_8
XFILLER_147_371 VDD VSS sg13g2_decap_8
XFILLER_5_329 VDD VSS sg13g2_decap_8
XFILLER_159_1422 VDD VSS sg13g2_decap_8
XFILLER_175_691 VDD VSS sg13g2_decap_8
XFILLER_135_533 VDD VSS sg13g2_fill_1
X_08108_ _08112_/C _15104_/Q _15091_/Q _08105_/Y VDD VSS sg13g2_o21ai_1
XFILLER_108_769 VDD VSS sg13g2_decap_8
XFILLER_174_14 VDD VSS sg13g2_decap_8
X_09088_ _09103_/D _14914_/Q _14913_/Q _13088_/A VDD VSS sg13g2_and3_1
XFILLER_162_341 VDD VSS sg13g2_decap_8
XFILLER_163_875 VDD VSS sg13g2_decap_8
XFILLER_159_1477 VDD VSS sg13g2_fill_2
XFILLER_150_514 VDD VSS sg13g2_decap_4
X_08039_ _08039_/Y _08039_/A _08039_/B _08039_/C _08039_/D VDD VSS sg13g2_nand4_1
XFILLER_104_920 VDD VSS sg13g2_decap_8
XFILLER_150_536 VDD VSS sg13g2_fill_2
XFILLER_104_942 VDD VSS sg13g2_decap_8
XFILLER_104_953 VDD VSS sg13g2_decap_8
XFILLER_1_546 VDD VSS sg13g2_decap_8
X_11050_ _11051_/B _11036_/Y _11064_/C _11032_/Y VDD VSS sg13g2_a21oi_1
XFILLER_153_1021 VDD VSS sg13g2_decap_4
XFILLER_157_1190 VDD VSS sg13g2_fill_1
XFILLER_77_804 VDD VSS sg13g2_decap_8
XFILLER_153_1054 VDD VSS sg13g2_fill_1
X_10001_ _14584_/D _10067_/A0 _14584_/Q _10002_/S VDD VSS sg13g2_mux2_1
XFILLER_107_96 VDD VSS sg13g2_fill_1
XFILLER_118_1174 VDD VSS sg13g2_decap_8
XFILLER_76_303 VDD VSS sg13g2_decap_8
XFILLER_114_1016 VDD VSS sg13g2_decap_8
XFILLER_153_1065 VDD VSS sg13g2_fill_2
XFILLER_77_848 VDD VSS sg13g2_decap_8
XFILLER_130_282 VDD VSS sg13g2_decap_8
XFILLER_114_1049 VDD VSS sg13g2_fill_1
XFILLER_170_1390 VDD VSS sg13g2_decap_8
XFILLER_92_818 VDD VSS sg13g2_decap_8
XFILLER_79_1401 VDD VSS sg13g2_decap_4
XFILLER_45_701 VDD VSS sg13g2_decap_8
XFILLER_85_870 VDD VSS sg13g2_fill_2
XFILLER_40_1246 VDD VSS sg13g2_decap_8
X_14740_ _14740_/Q _14740_/CLK _14740_/D _14740_/RESET_B VDD VSS sg13g2_dfrbpq_1
X_11952_ _11953_/B _11952_/A _11952_/B _11952_/C VDD VSS sg13g2_nand3_1
XFILLER_44_211 VDD VSS sg13g2_fill_1
XFILLER_166_1404 VDD VSS sg13g2_decap_8
XFILLER_83_44 VDD VSS sg13g2_decap_8
XFILLER_79_1467 VDD VSS sg13g2_decap_8
X_10903_ _10903_/Y _10903_/A _10903_/B VDD VSS sg13g2_nand2_1
XFILLER_79_1478 VDD VSS sg13g2_fill_1
X_14671_ _14671_/Q clkload12/A _14671_/D _14671_/RESET_B VDD VSS sg13g2_dfrbpq_1
XFILLER_17_469 VDD VSS sg13g2_decap_8
X_11883_ _11883_/X _11900_/B _11882_/X _11881_/Y VDD VSS sg13g2_a21o_1
XFILLER_33_918 VDD VSS sg13g2_decap_8
X_13622_ _13730_/D _13622_/A VDD VSS sg13g2_buf_1
X_13788__2484 _13788_/RESET_B VDD VSS sg13g2_tiehi
XFILLER_83_99 VDD VSS sg13g2_fill_2
XFILLER_32_417 VDD VSS sg13g2_decap_8
X_10834_ _10834_/Y _10869_/A _10876_/D _10830_/X _10832_/X VDD VSS sg13g2_a22oi_1
XFILLER_77_1180 VDD VSS sg13g2_decap_8
X_15169__2584 _15169_/RESET_B VDD VSS sg13g2_tiehi
XFILLER_41_951 VDD VSS sg13g2_decap_8
XFILLER_186_923 VDD VSS sg13g2_decap_8
X_13553_ _13553_/Y _07913_/A _13564_/A2 _13552_/Y VDD VSS sg13g2_a21oi_1
XFILLER_9_602 VDD VSS sg13g2_decap_8
XFILLER_73_1055 VDD VSS sg13g2_decap_8
XFILLER_125_1134 VDD VSS sg13g2_decap_8
X_14739__1533 _14739_/RESET_B VDD VSS sg13g2_tiehi
X_10765_ _10765_/Y _14918_/Q _11113_/B VDD VSS sg13g2_nand2_1
XFILLER_160_1025 VDD VSS sg13g2_fill_1
XFILLER_13_686 VDD VSS sg13g2_decap_8
XFILLER_158_647 VDD VSS sg13g2_decap_8
X_12504_ _12504_/X _14694_/Q _14726_/Q _13766_/Q _13798_/Q _12606_/S0 _12606_/S1 VDD
+ VSS sg13g2_mux4_1
XFILLER_8_112 VDD VSS sg13g2_decap_8
XFILLER_16_1440 VDD VSS sg13g2_decap_8
XFILLER_185_455 VDD VSS sg13g2_decap_8
X_13484_ _15123_/D _13484_/A _13484_/B _13484_/C VDD VSS sg13g2_nand3_1
X_10696_ _14901_/D _10696_/A VDD VSS sg13g2_inv_1
XFILLER_12_196 VDD VSS sg13g2_decap_8
XFILLER_157_168 VDD VSS sg13g2_decap_8
X_14901__2835 _14901_/RESET_B VDD VSS sg13g2_tiehi
X_15223_ _15223_/Q clkload86/A _15223_/D _15223_/RESET_B VDD VSS sg13g2_dfrbpq_1
XFILLER_9_679 VDD VSS sg13g2_decap_8
XFILLER_172_105 VDD VSS sg13g2_decap_8
XFILLER_173_628 VDD VSS sg13g2_decap_8
X_12435_ _12435_/X _14113_/Q _14145_/Q _14177_/Q _14209_/Q _12450_/S0 _12450_/S1 VDD
+ VSS sg13g2_mux4_1
XFILLER_32_70 VDD VSS sg13g2_decap_8
XFILLER_51_1375 VDD VSS sg13g2_decap_8
XFILLER_12_1337 VDD VSS sg13g2_decap_8
XFILLER_154_820 VDD VSS sg13g2_fill_2
X_13683__2599 _13683_/RESET_B VDD VSS sg13g2_tiehi
XFILLER_103_1465 VDD VSS sg13g2_decap_8
XFILLER_8_189 VDD VSS sg13g2_decap_8
X_15154_ _15154_/Q clkload86/A _15154_/D _15154_/RESET_B VDD VSS sg13g2_dfrbpq_1
XFILLER_165_190 VDD VSS sg13g2_decap_8
X_12366_ _12366_/X _13724_/Q _14076_/Q _14428_/Q _14524_/Q _12366_/S0 _12366_/S1 VDD
+ VSS sg13g2_mux4_1
XFILLER_126_555 VDD VSS sg13g2_decap_8
XFILLER_59_7 VDD VSS sg13g2_decap_8
XFILLER_10_1050 VDD VSS sg13g2_decap_8
XFILLER_181_672 VDD VSS sg13g2_decap_8
X_14105_ _14105_/Q clkload37/A _14105_/D _14105_/RESET_B VDD VSS sg13g2_dfrbpq_1
X_11317_ _11318_/A _11317_/A1 _14493_/Q _11894_/B VDD VSS sg13g2_a21oi_1
X_15085_ _15085_/Q clkload90/A _15085_/D _15085_/RESET_B VDD VSS sg13g2_dfrbpq_1
XFILLER_99_428 VDD VSS sg13g2_decap_8
X_12297_ _14987_/D _12297_/A _12297_/B VDD VSS sg13g2_nand2_1
XFILLER_5_896 VDD VSS sg13g2_decap_8
XFILLER_180_182 VDD VSS sg13g2_decap_8
X_14934__2769 _14934_/RESET_B VDD VSS sg13g2_tiehi
XFILLER_45_1102 VDD VSS sg13g2_decap_4
X_14036_ _14036_/Q clkload25/A _14036_/D _14036_/RESET_B VDD VSS sg13g2_dfrbpq_1
X_11248_ _11248_/Y _11248_/A _11248_/B VDD VSS sg13g2_nor2_1
XFILLER_136_1252 VDD VSS sg13g2_fill_1
XFILLER_132_1105 VDD VSS sg13g2_fill_2
XFILLER_121_260 VDD VSS sg13g2_fill_2
XFILLER_136_1285 VDD VSS sg13g2_decap_8
X_11179_ _11179_/X _11186_/B _11191_/A VDD VSS sg13g2_and2_1
XFILLER_23_1400 VDD VSS sg13g2_decap_8
XFILLER_79_196 VDD VSS sg13g2_decap_8
XFILLER_67_336 VDD VSS sg13g2_decap_8
XFILLER_95_656 VDD VSS sg13g2_fill_2
XFILLER_94_144 VDD VSS sg13g2_decap_8
XFILLER_83_818 VDD VSS sg13g2_decap_8
XFILLER_48_550 VDD VSS sg13g2_decap_4
XFILLER_94_166 VDD VSS sg13g2_decap_8
XFILLER_82_306 VDD VSS sg13g2_decap_8
XFILLER_110_1425 VDD VSS sg13g2_decap_8
XFILLER_23_1477 VDD VSS sg13g2_fill_2
X_14938_ _14938_/Q clkload75/A _14938_/D _14938_/RESET_B VDD VSS sg13g2_dfrbpq_1
XFILLER_63_542 VDD VSS sg13g2_decap_8
X_14869_ _14869_/Q clkload67/A _14869_/D _14869_/RESET_B VDD VSS sg13g2_dfrbpq_1
XFILLER_169_1094 VDD VSS sg13g2_fill_2
XFILLER_17_970 VDD VSS sg13g2_decap_8
X_15112__2828 _15112_/RESET_B VDD VSS sg13g2_tiehi
XFILLER_91_1100 VDD VSS sg13g2_decap_8
XFILLER_1_1295 VDD VSS sg13g2_decap_8
X_14378__1894 _14378_/RESET_B VDD VSS sg13g2_tiehi
X_08390_ _08390_/Y _07790_/A _08422_/S _08412_/A VDD VSS sg13g2_o21ai_1
XFILLER_95_1280 VDD VSS sg13g2_decap_4
XFILLER_17_1215 VDD VSS sg13g2_decap_8
XFILLER_182_1261 VDD VSS sg13g2_decap_8
XFILLER_108_1343 VDD VSS sg13g2_fill_2
XFILLER_32_962 VDD VSS sg13g2_fill_1
XFILLER_85_0 VDD VSS sg13g2_decap_4
XFILLER_108_1376 VDD VSS sg13g2_fill_2
XFILLER_149_658 VDD VSS sg13g2_fill_2
XFILLER_148_135 VDD VSS sg13g2_decap_8
XFILLER_31_483 VDD VSS sg13g2_decap_8
XFILLER_176_455 VDD VSS sg13g2_decap_8
XFILLER_164_617 VDD VSS sg13g2_fill_2
X_09011_ wire584/A _09011_/A _09011_/B _09011_/C _09011_/D VDD VSS sg13g2_nor4_1
XFILLER_128_18 VDD VSS sg13g2_fill_1
XFILLER_128_29 VDD VSS sg13g2_decap_8
XFILLER_89_1040 VDD VSS sg13g2_decap_8
XFILLER_30_1437 VDD VSS sg13g2_decap_8
XFILLER_105_706 VDD VSS sg13g2_fill_1
XFILLER_132_503 VDD VSS sg13g2_fill_2
XFILLER_145_886 VDD VSS sg13g2_fill_1
XFILLER_105_739 VDD VSS sg13g2_decap_4
XFILLER_176_1065 VDD VSS sg13g2_decap_8
XFILLER_104_238 VDD VSS sg13g2_decap_8
XFILLER_137_1049 VDD VSS sg13g2_decap_8
X_09913_ _14498_/D _14498_/Q _09913_/A1 _09935_/S VDD VSS sg13g2_mux2_1
Xfanout603 _08781_/B _08723_/Y VDD VSS sg13g2_buf_1
XFILLER_28_1333 VDD VSS sg13g2_decap_4
XFILLER_144_28 VDD VSS sg13g2_fill_1
Xfanout614 _08246_/A1 _08381_/A VDD VSS sg13g2_buf_1
Xfanout625 _12900_/A _13564_/A2 VDD VSS sg13g2_buf_1
XFILLER_98_461 VDD VSS sg13g2_decap_4
XFILLER_59_815 VDD VSS sg13g2_fill_2
XFILLER_28_1355 VDD VSS sg13g2_decap_8
Xfanout636 _11655_/B _11433_/B VDD VSS sg13g2_buf_1
Xfanout647 _10903_/B _10670_/Y VDD VSS sg13g2_buf_1
X_09844_ _14431_/D _14431_/Q _09976_/A0 _09865_/S VDD VSS sg13g2_mux2_1
Xfanout658 _08903_/S _08838_/Y VDD VSS sg13g2_buf_1
XFILLER_8_1449 VDD VSS sg13g2_decap_8
Xfanout669 _08955_/S _08895_/S VDD VSS sg13g2_buf_1
XFILLER_85_122 VDD VSS sg13g2_decap_8
X_09775_ _14364_/D _09907_/A1 _14364_/Q _09805_/S VDD VSS sg13g2_mux2_1
XFILLER_101_989 VDD VSS sg13g2_decap_8
XFILLER_74_829 VDD VSS sg13g2_decap_8
XFILLER_6_1162 VDD VSS sg13g2_decap_8
X_08726_ _08727_/D _13499_/C _13481_/A VDD VSS sg13g2_or2_1
XFILLER_73_328 VDD VSS sg13g2_decap_8
XFILLER_2_1015 VDD VSS sg13g2_decap_8
XFILLER_113_1082 VDD VSS sg13g2_decap_8
XFILLER_160_49 VDD VSS sg13g2_decap_8
XFILLER_73_339 VDD VSS sg13g2_fill_1
XFILLER_148_1101 VDD VSS sg13g2_fill_1
XFILLER_27_756 VDD VSS sg13g2_decap_8
X_15203__3064 _15203_/RESET_B VDD VSS sg13g2_tiehi
XFILLER_82_851 VDD VSS sg13g2_decap_8
X_08657_ _08657_/Y _08079_/S _08655_/Y _08656_/X VDD VSS sg13g2_a21oi_1
XFILLER_163_7 VDD VSS sg13g2_decap_8
XFILLER_82_873 VDD VSS sg13g2_decap_8
XFILLER_14_406 VDD VSS sg13g2_decap_8
XFILLER_82_884 VDD VSS sg13g2_fill_1
XFILLER_27_789 VDD VSS sg13g2_decap_4
XFILLER_53_14 VDD VSS sg13g2_fill_2
XFILLER_109_1107 VDD VSS sg13g2_decap_8
XFILLER_148_1156 VDD VSS sg13g2_fill_1
XFILLER_96_1088 VDD VSS sg13g2_decap_8
XFILLER_109_1118 VDD VSS sg13g2_fill_1
XFILLER_148_1167 VDD VSS sg13g2_decap_8
X_08588_ _08596_/A _08587_/Y _08588_/B _08588_/C VDD VSS sg13g2_nand3b_1
XFILLER_74_1331 VDD VSS sg13g2_decap_8
XFILLER_42_748 VDD VSS sg13g2_decap_8
XFILLER_39_1451 VDD VSS sg13g2_decap_4
XFILLER_169_14 VDD VSS sg13g2_decap_8
XFILLER_23_940 VDD VSS sg13g2_decap_8
XFILLER_41_247 VDD VSS sg13g2_decap_8
XFILLER_39_1473 VDD VSS sg13g2_decap_4
XFILLER_161_1312 VDD VSS sg13g2_decap_8
XFILLER_168_923 VDD VSS sg13g2_decap_8
XFILLER_74_1364 VDD VSS sg13g2_fill_2
XFILLER_126_1443 VDD VSS sg13g2_decap_4
XFILLER_167_422 VDD VSS sg13g2_decap_8
XFILLER_35_1337 VDD VSS sg13g2_fill_2
XFILLER_70_1228 VDD VSS sg13g2_decap_8
XFILLER_10_623 VDD VSS sg13g2_decap_8
X_10550_ _10550_/Y _14865_/Q _10556_/D _13499_/B VDD VSS sg13g2_o21ai_1
X_09209_ _13820_/D _09907_/A1 _13820_/Q _09227_/S VDD VSS sg13g2_mux2_1
XFILLER_6_616 VDD VSS sg13g2_decap_8
XFILLER_154_116 VDD VSS sg13g2_decap_8
X_10481_ _10481_/Y _10489_/C _14847_/Q _10486_/D _10492_/C VDD VSS sg13g2_nand4_1
XFILLER_136_831 VDD VSS sg13g2_decap_4
XFILLER_185_35 VDD VSS sg13g2_decap_8
X_12220_ _12220_/Y _12219_/S _12215_/X _12214_/Y VDD VSS sg13g2_o21ai_1
XFILLER_68_1102 VDD VSS sg13g2_fill_2
XFILLER_5_126 VDD VSS sg13g2_decap_8
XFILLER_108_544 VDD VSS sg13g2_decap_8
XFILLER_182_469 VDD VSS sg13g2_decap_8
XFILLER_136_875 VDD VSS sg13g2_decap_4
XFILLER_163_650 VDD VSS sg13g2_decap_8
XFILLER_108_588 VDD VSS sg13g2_decap_8
XFILLER_159_1274 VDD VSS sg13g2_fill_1
X_12151_ _12151_/Y _12152_/A _13666_/Q VDD VSS sg13g2_nor2_1
XFILLER_108_599 VDD VSS sg13g2_fill_2
XFILLER_123_525 VDD VSS sg13g2_decap_8
XFILLER_163_694 VDD VSS sg13g2_fill_1
XFILLER_2_833 VDD VSS sg13g2_decap_8
X_11102_ _11102_/Y _14949_/Q _11113_/B VDD VSS sg13g2_nand2_1
XFILLER_46_1422 VDD VSS sg13g2_decap_8
XFILLER_150_355 VDD VSS sg13g2_decap_8
X_12082_ _12125_/A _12084_/A _12082_/B VDD VSS sg13g2_nor2_1
XFILLER_151_889 VDD VSS sg13g2_fill_1
XFILLER_1_343 VDD VSS sg13g2_decap_8
XFILLER_89_450 VDD VSS sg13g2_decap_4
XFILLER_78_88 VDD VSS sg13g2_decap_8
XFILLER_77_612 VDD VSS sg13g2_decap_8
XFILLER_133_1414 VDD VSS sg13g2_decap_8
X_11033_ _11064_/C _14760_/Q _11033_/B VDD VSS sg13g2_xor2_1
XFILLER_81_1346 VDD VSS sg13g2_decap_8
XFILLER_65_818 VDD VSS sg13g2_decap_8
XFILLER_94_54 VDD VSS sg13g2_decap_4
X_12984_ _15032_/D _13211_/A _12984_/B VDD VSS sg13g2_nor2_1
XFILLER_92_648 VDD VSS sg13g2_fill_2
XFILLER_40_1054 VDD VSS sg13g2_decap_8
X_13911__2361 _13911_/RESET_B VDD VSS sg13g2_tiehi
X_14723_ _14723_/Q _14723_/CLK _14723_/D _14723_/RESET_B VDD VSS sg13g2_dfrbpq_1
X_11935_ _11986_/A _11936_/A _13129_/B VDD VSS sg13g2_nor2_1
XFILLER_40_1098 VDD VSS sg13g2_decap_8
XFILLER_27_70 VDD VSS sg13g2_decap_8
XFILLER_17_266 VDD VSS sg13g2_decap_8
XFILLER_73_895 VDD VSS sg13g2_decap_8
X_14654_ _14654_/Q clkload49/A _14654_/D _14654_/RESET_B VDD VSS sg13g2_dfrbpq_1
XFILLER_127_1218 VDD VSS sg13g2_decap_8
X_11866_ _11868_/B _11867_/A _11867_/B _11910_/C VDD VSS sg13g2_a21o_1
XFILLER_33_748 VDD VSS sg13g2_fill_1
XFILLER_159_901 VDD VSS sg13g2_fill_1
XFILLER_92_1431 VDD VSS sg13g2_decap_8
XFILLER_72_394 VDD VSS sg13g2_fill_1
X_13605_ _13605_/Y _13600_/A _08834_/B hold3242/X VDD VSS sg13g2_a21oi_1
XFILLER_159_923 VDD VSS sg13g2_decap_8
X_10817_ _10821_/A _10818_/B _10818_/A VDD VSS sg13g2_nand2_1
XFILLER_53_1415 VDD VSS sg13g2_decap_8
XFILLER_14_973 VDD VSS sg13g2_decap_8
X_14585_ _14585_/Q clkload35/A _14585_/D _14585_/RESET_B VDD VSS sg13g2_dfrbpq_1
X_14255__2017 _14255_/RESET_B VDD VSS sg13g2_tiehi
X_11797_ _11907_/A _11798_/A _13676_/Q VDD VSS sg13g2_nor2_1
XFILLER_41_781 VDD VSS sg13g2_decap_8
XFILLER_13_483 VDD VSS sg13g2_decap_8
X_13536_ _15144_/D _13535_/B _13534_/Y _13535_/Y VDD VSS sg13g2_a21oi_1
X_10748_ _11078_/B _14946_/Q _10747_/A _10747_/Y VDD VSS sg13g2_a21oi_1
XFILLER_43_91 VDD VSS sg13g2_decap_8
XFILLER_185_252 VDD VSS sg13g2_decap_8
XFILLER_158_477 VDD VSS sg13g2_decap_4
XFILLER_186_786 VDD VSS sg13g2_decap_8
XFILLER_146_628 VDD VSS sg13g2_fill_2
XFILLER_174_937 VDD VSS sg13g2_decap_8
XFILLER_186_797 VDD VSS sg13g2_decap_4
XFILLER_9_476 VDD VSS sg13g2_decap_8
X_13467_ _13468_/D _15169_/Q _15170_/Q _15171_/Q _15172_/Q VDD VSS sg13g2_nand4_1
X_10679_ _10818_/B _08980_/X _08848_/A _08844_/Y VDD VSS sg13g2_a21oi_1
XFILLER_12_1134 VDD VSS sg13g2_decap_8
XFILLER_173_436 VDD VSS sg13g2_decap_8
X_15206_ _15206_/Q clkload91/A _15206_/D _15206_/RESET_B VDD VSS sg13g2_dfrbpq_1
X_12418_ _12418_/X _14112_/Q _14144_/Q _14176_/Q _14208_/Q _12450_/S0 _12450_/S1 VDD
+ VSS sg13g2_mux4_1
X_13398_ _13398_/Y _13407_/A _13469_/A _15087_/Q VDD VSS sg13g2_nand3_1
XFILLER_126_363 VDD VSS sg13g2_decap_8
XFILLER_182_981 VDD VSS sg13g2_decap_8
XFILLER_138_1314 VDD VSS sg13g2_decap_8
XFILLER_160_119 VDD VSS sg13g2_decap_4
X_15137_ _15137_/Q clkload77/A _15137_/D _15137_/RESET_B VDD VSS sg13g2_dfrbpq_1
X_15141__2768 _15141_/RESET_B VDD VSS sg13g2_tiehi
XFILLER_99_203 VDD VSS sg13g2_fill_1
XFILLER_138_1325 VDD VSS sg13g2_fill_2
XFILLER_141_300 VDD VSS sg13g2_decap_8
XFILLER_154_683 VDD VSS sg13g2_decap_8
X_12349_ _12349_/X _13819_/Q _13851_/Q _13883_/Q _13915_/Q _12366_/S0 _12366_/S1 VDD
+ VSS sg13g2_mux4_1
XFILLER_154_694 VDD VSS sg13g2_fill_1
XFILLER_5_693 VDD VSS sg13g2_decap_8
XFILLER_142_856 VDD VSS sg13g2_decap_8
XFILLER_138_1358 VDD VSS sg13g2_fill_1
X_15068_ _15068_/Q clkload85/A _15068_/D _15068_/RESET_B VDD VSS sg13g2_dfrbpq_1
XFILLER_99_258 VDD VSS sg13g2_fill_1
XFILLER_141_355 VDD VSS sg13g2_decap_8
XFILLER_141_366 VDD VSS sg13g2_decap_8
XFILLER_4_63 VDD VSS sg13g2_decap_8
XFILLER_101_219 VDD VSS sg13g2_decap_4
X_14019_ _14019_/Q _14723_/CLK _14019_/D _14019_/RESET_B VDD VSS sg13g2_dfrbpq_1
XFILLER_110_720 VDD VSS sg13g2_decap_8
X_07890_ _07904_/A _07924_/C _07890_/B VDD VSS sg13g2_nor2_1
XFILLER_55_306 VDD VSS sg13g2_decap_8
XFILLER_3_1302 VDD VSS sg13g2_decap_8
XFILLER_110_1211 VDD VSS sg13g2_fill_2
X_14878__2881 _14878_/RESET_B VDD VSS sg13g2_tiehi
X_09560_ _14158_/D _09727_/A0 _14158_/Q _09572_/S VDD VSS sg13g2_mux2_1
XFILLER_97_1331 VDD VSS sg13g2_decap_8
XFILLER_23_1274 VDD VSS sg13g2_decap_8
XFILLER_110_1244 VDD VSS sg13g2_decap_8
X_14465__1807 _14465_/RESET_B VDD VSS sg13g2_tiehi
X_08511_ _08511_/X _08427_/X _08510_/X _08511_/S VDD VSS sg13g2_mux2_1
XFILLER_36_553 VDD VSS sg13g2_decap_8
X_09491_ _14091_/D _10087_/A0 _14091_/Q _09493_/S VDD VSS sg13g2_mux2_1
XFILLER_3_1379 VDD VSS sg13g2_decap_8
X_14501__1771 _14501_/RESET_B VDD VSS sg13g2_tiehi
XFILLER_24_715 VDD VSS sg13g2_fill_1
XFILLER_149_1465 VDD VSS sg13g2_fill_1
XFILLER_64_895 VDD VSS sg13g2_fill_1
XFILLER_58_1348 VDD VSS sg13g2_fill_1
X_08442_ _08443_/B _08574_/A _08442_/B VDD VSS sg13g2_nor2_1
XFILLER_93_1239 VDD VSS sg13g2_decap_8
XFILLER_51_523 VDD VSS sg13g2_decap_8
XFILLER_145_1318 VDD VSS sg13g2_decap_8
XFILLER_1_1092 VDD VSS sg13g2_decap_8
X_08373_ _15232_/D _08372_/Y _08373_/B _08373_/C VDD VSS sg13g2_nand3b_1
XFILLER_23_28 VDD VSS sg13g2_decap_8
XFILLER_143_1042 VDD VSS sg13g2_decap_8
XFILLER_149_444 VDD VSS sg13g2_decap_8
XFILLER_32_781 VDD VSS sg13g2_decap_8
XFILLER_108_1173 VDD VSS sg13g2_decap_8
XFILLER_139_28 VDD VSS sg13g2_decap_8
XFILLER_176_252 VDD VSS sg13g2_decap_8
XFILLER_17_1089 VDD VSS sg13g2_decap_8
XFILLER_165_948 VDD VSS sg13g2_decap_4
XFILLER_34_1381 VDD VSS sg13g2_fill_2
XFILLER_30_1212 VDD VSS sg13g2_decap_8
XFILLER_136_127 VDD VSS sg13g2_decap_4
XFILLER_165_959 VDD VSS sg13g2_decap_4
XFILLER_129_190 VDD VSS sg13g2_fill_1
XFILLER_121_1384 VDD VSS sg13g2_decap_8
XFILLER_156_1414 VDD VSS sg13g2_decap_8
XFILLER_69_1466 VDD VSS sg13g2_decap_8
XFILLER_145_694 VDD VSS sg13g2_fill_2
XFILLER_69_1477 VDD VSS sg13g2_fill_2
XFILLER_155_49 VDD VSS sg13g2_decap_8
X_13953__2319 _13953_/RESET_B VDD VSS sg13g2_tiehi
XFILLER_133_856 VDD VSS sg13g2_decap_4
Xfanout400 _09305_/S fanout402/X VDD VSS sg13g2_buf_1
XFILLER_28_1130 VDD VSS sg13g2_decap_8
Xfanout411 _09201_/S _09196_/S VDD VSS sg13g2_buf_1
Xfanout1409 _12235_/A fanout1410/X VDD VSS sg13g2_buf_1
XFILLER_63_1021 VDD VSS sg13g2_decap_8
XFILLER_48_14 VDD VSS sg13g2_decap_8
XFILLER_132_388 VDD VSS sg13g2_decap_8
XFILLER_115_1111 VDD VSS sg13g2_decap_4
XFILLER_120_539 VDD VSS sg13g2_fill_1
Xfanout433 _09842_/A1 _09941_/A1 VDD VSS sg13g2_buf_1
XFILLER_115_1122 VDD VSS sg13g2_decap_8
XFILLER_119_1291 VDD VSS sg13g2_decap_8
XFILLER_154_1171 VDD VSS sg13g2_decap_8
Xfanout444 _09127_/S _09167_/S VDD VSS sg13g2_buf_1
XFILLER_8_1246 VDD VSS sg13g2_decap_8
XFILLER_59_634 VDD VSS sg13g2_decap_8
Xfanout455 _11163_/A _11164_/A VDD VSS sg13g2_buf_1
Xfanout466 _10031_/S _10035_/S VDD VSS sg13g2_buf_1
XFILLER_87_965 VDD VSS sg13g2_fill_1
XFILLER_24_1027 VDD VSS sg13g2_decap_8
Xfanout477 _09837_/S _09826_/S VDD VSS sg13g2_buf_1
X_09827_ _14415_/D _10158_/A1 _14415_/Q _09833_/S VDD VSS sg13g2_mux2_1
XFILLER_47_807 VDD VSS sg13g2_decap_8
XFILLER_24_1038 VDD VSS sg13g2_decap_8
XFILLER_63_1098 VDD VSS sg13g2_decap_8
XFILLER_101_775 VDD VSS sg13g2_decap_8
Xfanout488 _09671_/S _09661_/S VDD VSS sg13g2_buf_1
XFILLER_58_155 VDD VSS sg13g2_decap_8
XFILLER_115_1177 VDD VSS sg13g2_decap_8
Xfanout499 _09534_/S _09538_/S VDD VSS sg13g2_buf_1
XFILLER_98_1117 VDD VSS sg13g2_decap_8
XFILLER_46_317 VDD VSS sg13g2_decap_8
XFILLER_104_42 VDD VSS sg13g2_decap_8
X_09758_ _14348_/D _14348_/Q _09923_/A1 _09766_/S VDD VSS sg13g2_mux2_1
X_08709_ _15187_/D input13/X _15187_/Q _08719_/S VDD VSS sg13g2_mux2_1
XFILLER_41_1396 VDD VSS sg13g2_decap_8
X_09689_ _14281_/D _10152_/A1 _14281_/Q _09705_/S VDD VSS sg13g2_mux2_1
XFILLER_55_884 VDD VSS sg13g2_decap_8
XFILLER_14_203 VDD VSS sg13g2_decap_8
X_11720_ _11720_/Y _11654_/S _11718_/X _11719_/Y VDD VSS sg13g2_o21ai_1
XFILLER_76_1459 VDD VSS sg13g2_decap_8
XFILLER_42_523 VDD VSS sg13g2_decap_4
XFILLER_70_843 VDD VSS sg13g2_decap_8
X_11651_ _11651_/X _13959_/Q _13991_/Q _14023_/Q _14055_/Q _11528_/S _11532_/C VDD
+ VSS sg13g2_mux4_1
XFILLER_39_1270 VDD VSS sg13g2_decap_8
XFILLER_11_910 VDD VSS sg13g2_decap_8
XFILLER_126_1251 VDD VSS sg13g2_decap_8
X_10602_ _14877_/D _10608_/B _10602_/B _10602_/C VDD VSS sg13g2_nor3_1
XFILLER_80_45 VDD VSS sg13g2_decap_8
XFILLER_74_1183 VDD VSS sg13g2_fill_2
X_14370_ _14370_/Q clkload31/A _14370_/D _14370_/RESET_B VDD VSS sg13g2_dfrbpq_1
XFILLER_10_420 VDD VSS sg13g2_decap_8
X_11582_ _11584_/B _12000_/A _11582_/B VDD VSS sg13g2_nor2_1
XFILLER_7_903 VDD VSS sg13g2_decap_8
XFILLER_156_937 VDD VSS sg13g2_decap_8
X_13321_ _13322_/A _15111_/Q _13306_/B _13324_/A VDD VSS sg13g2_a21oi_1
XFILLER_127_105 VDD VSS sg13g2_decap_4
XFILLER_161_1186 VDD VSS sg13g2_decap_8
XFILLER_168_797 VDD VSS sg13g2_decap_8
X_10533_ _10535_/A _14860_/Q _10533_/B VDD VSS sg13g2_nand2b_1
XFILLER_11_987 VDD VSS sg13g2_decap_8
XFILLER_13_1421 VDD VSS sg13g2_decap_8
XFILLER_155_425 VDD VSS sg13g2_decap_4
XFILLER_183_734 VDD VSS sg13g2_decap_8
XFILLER_6_413 VDD VSS sg13g2_decap_8
XFILLER_52_1470 VDD VSS sg13g2_decap_8
XFILLER_127_127 VDD VSS sg13g2_decap_8
Xwire856 wire856/X wire856/A VDD VSS sg13g2_buf_8
XFILLER_10_497 VDD VSS sg13g2_decap_8
X_13252_ _13252_/X input25/X _12914_/A _13264_/B1 VDD VSS sg13g2_a21o_1
XFILLER_136_650 VDD VSS sg13g2_decap_8
X_10464_ _14843_/D _10471_/C _10459_/Y _10463_/Y VDD VSS sg13g2_a21oi_1
XFILLER_89_21 VDD VSS sg13g2_decap_8
XFILLER_129_83 VDD VSS sg13g2_fill_1
XFILLER_171_929 VDD VSS sg13g2_decap_4
XFILLER_182_266 VDD VSS sg13g2_decap_8
XFILLER_164_970 VDD VSS sg13g2_decap_8
XFILLER_109_886 VDD VSS sg13g2_decap_8
X_12203_ _12272_/A _12203_/A _13665_/Q VDD VSS sg13g2_xnor2_1
XFILLER_136_694 VDD VSS sg13g2_decap_4
X_13183_ _13184_/B _13253_/B2 _13178_/X _13177_/X _13303_/A _13182_/Y VDD VSS sg13g2_a221oi_1
XFILLER_124_845 VDD VSS sg13g2_decap_8
X_10395_ _10396_/D _10395_/A _10400_/C _10395_/C VDD VSS sg13g2_nor3_1
XFILLER_83_1408 VDD VSS sg13g2_fill_1
XFILLER_108_396 VDD VSS sg13g2_decap_8
X_14543__1729 _14543_/RESET_B VDD VSS sg13g2_tiehi
XFILLER_2_630 VDD VSS sg13g2_decap_8
X_13929__2343 _13929_/RESET_B VDD VSS sg13g2_tiehi
X_12134_ _12134_/X _13749_/Q _14101_/Q _14453_/Q _14549_/Q _12140_/S0 _12140_/S1 VDD
+ VSS sg13g2_mux4_1
XFILLER_150_130 VDD VSS sg13g2_decap_8
X_14689__1583 _14689_/RESET_B VDD VSS sg13g2_tiehi
XFILLER_97_718 VDD VSS sg13g2_decap_4
XFILLER_1_140 VDD VSS sg13g2_decap_8
XFILLER_96_217 VDD VSS sg13g2_decap_8
XFILLER_111_528 VDD VSS sg13g2_decap_8
XFILLER_133_1211 VDD VSS sg13g2_decap_8
XFILLER_145_82 VDD VSS sg13g2_decap_8
X_12065_ _12065_/Y _12065_/A _12065_/B VDD VSS sg13g2_nand2_1
XFILLER_81_1143 VDD VSS sg13g2_decap_8
XFILLER_150_196 VDD VSS sg13g2_decap_8
XFILLER_46_1274 VDD VSS sg13g2_decap_4
XFILLER_78_965 VDD VSS sg13g2_decap_8
X_11016_ _11016_/Y _11042_/D _10995_/Y _11052_/D VDD VSS sg13g2_o21ai_1
XFILLER_42_1127 VDD VSS sg13g2_decap_8
X_16873_ _16873_/X _16873_/A VDD VSS sg13g2_buf_1
XFILLER_77_464 VDD VSS sg13g2_decap_8
XFILLER_78_998 VDD VSS sg13g2_fill_2
XFILLER_49_166 VDD VSS sg13g2_decap_4
XFILLER_37_306 VDD VSS sg13g2_decap_8
XFILLER_93_968 VDD VSS sg13g2_fill_2
XFILLER_64_136 VDD VSS sg13g2_fill_1
XFILLER_18_553 VDD VSS sg13g2_decap_8
XFILLER_92_467 VDD VSS sg13g2_fill_2
XFILLER_18_564 VDD VSS sg13g2_fill_2
X_12967_ _12967_/Y _12900_/A _12814_/C input5/X VDD VSS sg13g2_a21oi_1
XFILLER_20_1469 VDD VSS sg13g2_decap_8
XFILLER_61_810 VDD VSS sg13g2_fill_1
XFILLER_61_821 VDD VSS sg13g2_fill_2
X_14706_ _14706_/Q clkload15/A _14706_/D _14706_/RESET_B VDD VSS sg13g2_dfrbpq_1
X_11918_ _11918_/X _14575_/Q _14607_/Q _14639_/Q _14671_/Q _11925_/S0 _11925_/S1 VDD
+ VSS sg13g2_mux4_1
X_12898_ _12898_/Y _12895_/Y _12896_/Y _12897_/Y VDD VSS sg13g2_a21oi_1
XFILLER_60_331 VDD VSS sg13g2_decap_8
XFILLER_60_342 VDD VSS sg13g2_fill_2
XFILLER_54_90 VDD VSS sg13g2_decap_8
XFILLER_159_720 VDD VSS sg13g2_decap_8
XFILLER_178_539 VDD VSS sg13g2_decap_8
X_14637_ _14637_/Q _14669_/CLK _14637_/D _14637_/RESET_B VDD VSS sg13g2_dfrbpq_1
X_11849_ _11849_/X _13837_/Q _13869_/Q _13901_/Q _13933_/Q _11738_/S _11963_/S1 VDD
+ VSS sg13g2_mux4_1
XFILLER_61_887 VDD VSS sg13g2_decap_8
XFILLER_53_1201 VDD VSS sg13g2_fill_2
XFILLER_127_1059 VDD VSS sg13g2_decap_8
XFILLER_18_1332 VDD VSS sg13g2_decap_8
XFILLER_60_364 VDD VSS sg13g2_decap_8
XFILLER_53_1212 VDD VSS sg13g2_fill_1
XFILLER_14_770 VDD VSS sg13g2_decap_8
XFILLER_57_1392 VDD VSS sg13g2_fill_1
XFILLER_20_217 VDD VSS sg13g2_decap_8
X_14568_ _14568_/Q _14664_/CLK _14568_/D _14568_/RESET_B VDD VSS sg13g2_dfrbpq_1
XFILLER_53_1245 VDD VSS sg13g2_decap_8
XFILLER_13_280 VDD VSS sg13g2_decap_8
XFILLER_147_915 VDD VSS sg13g2_decap_8
XFILLER_105_1335 VDD VSS sg13g2_decap_8
XFILLER_14_1218 VDD VSS sg13g2_decap_8
XFILLER_147_926 VDD VSS sg13g2_fill_1
XFILLER_158_263 VDD VSS sg13g2_fill_1
XFILLER_147_937 VDD VSS sg13g2_decap_4
XFILLER_119_639 VDD VSS sg13g2_decap_8
X_13519_ _13519_/Y _13519_/A _13519_/B VDD VSS sg13g2_nor2_1
X_14499_ _14499_/Q clkload30/A _14499_/D _14499_/RESET_B VDD VSS sg13g2_dfrbpq_1
XFILLER_9_273 VDD VSS sg13g2_decap_8
XFILLER_88_1319 VDD VSS sg13g2_decap_4
XFILLER_174_756 VDD VSS sg13g2_decap_8
Xclkload10 clkload10/Y clkload10/A VDD VSS sg13g2_inv_1
XFILLER_146_458 VDD VSS sg13g2_decap_8
Xclkload21 clkload21/Y clkload21/A VDD VSS sg13g2_inv_1
Xclkload32 clkload32/Y clkload32/A VDD VSS sg13g2_inv_1
XFILLER_173_266 VDD VSS sg13g2_decap_8
Xclkload43 clkload43/X clkload43/A VDD VSS sg13g2_buf_8
XFILLER_133_108 VDD VSS sg13g2_decap_8
Xclkload54 clkload54/X clkload54/A VDD VSS sg13g2_buf_8
Xmax_cap1284 _16874_/A _13712_/Q VDD VSS sg13g2_buf_4
XFILLER_103_1092 VDD VSS sg13g2_decap_8
Xclkload65 clkload65/Y clkload65/A VDD VSS sg13g2_inv_1
XFILLER_126_160 VDD VSS sg13g2_decap_8
Xclkload76 clkload76/Y clkload76/A VDD VSS sg13g2_inv_8
Xmax_cap1295 _16863_/A _13701_/Q VDD VSS sg13g2_buf_4
XFILLER_6_980 VDD VSS sg13g2_decap_8
X_15202__3063 _15202_/RESET_B VDD VSS sg13g2_tiehi
Xclkload87 clkload87/Y clkload87/A VDD VSS sg13g2_inv_1
XFILLER_142_642 VDD VSS sg13g2_decap_8
XFILLER_170_962 VDD VSS sg13g2_decap_8
XFILLER_5_490 VDD VSS sg13g2_decap_8
XFILLER_48_0 VDD VSS sg13g2_decap_8
X_14519__1753 _14519_/RESET_B VDD VSS sg13g2_tiehi
X_08991_ _08992_/B _15026_/Q _15223_/Q _09009_/S VDD VSS sg13g2_mux2_1
XFILLER_138_1166 VDD VSS sg13g2_decap_8
XFILLER_173_1046 VDD VSS sg13g2_decap_8
XFILLER_64_1330 VDD VSS sg13g2_decap_8
X_07942_ _07942_/Y _07942_/A VDD VSS sg13g2_inv_1
XFILLER_87_228 VDD VSS sg13g2_decap_8
XFILLER_29_1472 VDD VSS sg13g2_decap_8
XFILLER_116_1431 VDD VSS sg13g2_decap_8
XFILLER_64_1363 VDD VSS sg13g2_decap_8
XFILLER_69_965 VDD VSS sg13g2_decap_8
XFILLER_68_442 VDD VSS sg13g2_decap_8
XFILLER_25_1336 VDD VSS sg13g2_decap_8
X_07873_ _08188_/B _07909_/B _07910_/A VDD VSS sg13g2_nor2_1
XFILLER_28_306 VDD VSS sg13g2_fill_2
XFILLER_112_1328 VDD VSS sg13g2_fill_2
XFILLER_18_28 VDD VSS sg13g2_decap_8
X_09612_ _14208_/D _10076_/A0 _14208_/Q _09633_/S VDD VSS sg13g2_mux2_1
XFILLER_95_283 VDD VSS sg13g2_fill_2
X_09543_ _14141_/D _09842_/A1 _14141_/Q _09572_/S VDD VSS sg13g2_mux2_1
XFILLER_83_467 VDD VSS sg13g2_decap_8
XFILLER_110_1052 VDD VSS sg13g2_decap_8
XFILLER_3_1176 VDD VSS sg13g2_decap_8
XFILLER_36_361 VDD VSS sg13g2_decap_8
XFILLER_52_821 VDD VSS sg13g2_fill_1
XFILLER_58_1134 VDD VSS sg13g2_fill_1
X_09474_ _09474_/X _09938_/A _10105_/C _09938_/C _10137_/C VDD VSS sg13g2_or4_1
XFILLER_97_1194 VDD VSS sg13g2_fill_2
XFILLER_70_139 VDD VSS sg13g2_decap_8
XFILLER_93_1058 VDD VSS sg13g2_decap_4
XFILLER_52_865 VDD VSS sg13g2_decap_8
XFILLER_51_342 VDD VSS sg13g2_decap_8
XFILLER_12_707 VDD VSS sg13g2_decap_8
XFILLER_149_1295 VDD VSS sg13g2_decap_8
X_08425_ _08441_/C _08659_/A _08058_/X _08688_/C VDD VSS sg13g2_o21ai_1
XFILLER_34_49 VDD VSS sg13g2_decap_8
XFILLER_51_353 VDD VSS sg13g2_fill_1
XFILLER_145_1148 VDD VSS sg13g2_decap_8
XFILLER_51_375 VDD VSS sg13g2_decap_8
XFILLER_11_217 VDD VSS sg13g2_decap_8
XFILLER_71_1334 VDD VSS sg13g2_decap_4
X_08356_ _08668_/B _08599_/A _08196_/Y _08241_/Y VDD VSS sg13g2_o21ai_1
XFILLER_36_1476 VDD VSS sg13g2_fill_2
Xclkload4 clkload4/X clkload4/A VDD VSS sg13g2_buf_8
XFILLER_138_937 VDD VSS sg13g2_decap_8
XFILLER_138_948 VDD VSS sg13g2_fill_1
XFILLER_165_734 VDD VSS sg13g2_decap_8
X_08287_ _08287_/Y _07797_/A _07927_/Y _07932_/Y VDD VSS sg13g2_o21ai_1
XFILLER_126_7 VDD VSS sg13g2_decap_8
XFILLER_20_784 VDD VSS sg13g2_decap_8
XFILLER_137_447 VDD VSS sg13g2_fill_2
XFILLER_30_1020 VDD VSS sg13g2_decap_8
XFILLER_164_255 VDD VSS sg13g2_decap_8
XFILLER_180_715 VDD VSS sg13g2_fill_1
XFILLER_4_917 VDD VSS sg13g2_decap_8
XFILLER_69_1252 VDD VSS sg13g2_decap_8
XFILLER_117_171 VDD VSS sg13g2_decap_4
XFILLER_69_1263 VDD VSS sg13g2_fill_2
XFILLER_3_427 VDD VSS sg13g2_decap_8
XFILLER_65_1105 VDD VSS sg13g2_decap_8
XFILLER_156_1233 VDD VSS sg13g2_fill_2
XFILLER_105_344 VDD VSS sg13g2_decap_4
XFILLER_117_1206 VDD VSS sg13g2_decap_8
X_10180_ _14747_/D _10173_/Y _10176_/Y _10179_/Y VDD VSS sg13g2_o21ai_1
XFILLER_105_366 VDD VSS sg13g2_decap_8
XFILLER_117_1217 VDD VSS sg13g2_fill_2
XFILLER_133_675 VDD VSS sg13g2_decap_8
XFILLER_182_14 VDD VSS sg13g2_decap_8
XFILLER_161_995 VDD VSS sg13g2_decap_8
XFILLER_82_1430 VDD VSS sg13g2_decap_8
XFILLER_160_472 VDD VSS sg13g2_decap_8
XFILLER_78_217 VDD VSS sg13g2_decap_8
XFILLER_132_174 VDD VSS sg13g2_decap_8
Xfanout1206 _07786_/A _08879_/A1 VDD VSS sg13g2_buf_1
XFILLER_156_1299 VDD VSS sg13g2_fill_1
XFILLER_160_494 VDD VSS sg13g2_decap_8
Xfanout1217 _11502_/A _08863_/A1 VDD VSS sg13g2_buf_1
XFILLER_82_1452 VDD VSS sg13g2_fill_2
Xfanout230 _09922_/A1 _09063_/X VDD VSS sg13g2_buf_1
Xfanout1228 _07912_/B _14961_/Q VDD VSS sg13g2_buf_1
Xfanout241 _09953_/A1 _09621_/A0 VDD VSS sg13g2_buf_1
XFILLER_115_41 VDD VSS sg13g2_decap_8
Xfanout1239 _11291_/A _14958_/Q VDD VSS sg13g2_buf_1
XFILLER_8_1043 VDD VSS sg13g2_decap_8
Xfanout252 _11248_/B _12195_/B1 VDD VSS sg13g2_buf_1
Xfanout263 _09951_/A1 _10117_/A0 VDD VSS sg13g2_buf_1
XFILLER_115_63 VDD VSS sg13g2_decap_8
Xfanout285 _09902_/S fanout285/A VDD VSS sg13g2_buf_1
XFILLER_101_583 VDD VSS sg13g2_decap_8
XFILLER_115_96 VDD VSS sg13g2_decap_8
X_13870_ _13870_/Q clkload60/A _13870_/D _13870_/RESET_B VDD VSS sg13g2_dfrbpq_1
XFILLER_86_283 VDD VSS sg13g2_decap_8
XFILLER_75_56 VDD VSS sg13g2_fill_2
XFILLER_75_968 VDD VSS sg13g2_decap_8
X_12821_ _12821_/Y _14895_/Q _12836_/B VDD VSS sg13g2_nand2_1
XFILLER_61_117 VDD VSS sg13g2_decap_8
X_12752_ _12752_/X _13848_/Q _13880_/Q _13912_/Q _13944_/Q _12759_/S0 _12759_/S1 VDD
+ VSS sg13g2_mux4_1
XFILLER_167_1362 VDD VSS sg13g2_decap_8
XFILLER_76_1245 VDD VSS sg13g2_decap_8
XFILLER_163_1204 VDD VSS sg13g2_decap_8
XFILLER_152_0 VDD VSS sg13g2_decap_8
X_11703_ _11771_/B _11635_/A _13681_/Q _13680_/Q _11661_/A VDD VSS sg13g2_a22oi_1
XFILLER_15_567 VDD VSS sg13g2_decap_8
XFILLER_42_353 VDD VSS sg13g2_decap_8
X_12683_ _12683_/X _13747_/Q _14099_/Q _14451_/Q _14547_/Q _12717_/S0 _12717_/S1 VDD
+ VSS sg13g2_mux4_1
XFILLER_91_66 VDD VSS sg13g2_decap_8
X_14422_ _14422_/Q _14518_/CLK _14422_/D _14422_/RESET_B VDD VSS sg13g2_dfrbpq_1
XFILLER_42_386 VDD VSS sg13g2_decap_8
X_11634_ _11643_/A _11635_/A _13681_/Q VDD VSS sg13g2_xor2_1
XFILLER_50_1407 VDD VSS sg13g2_decap_8
XFILLER_128_403 VDD VSS sg13g2_decap_8
X_14172__2100 _14172_/RESET_B VDD VSS sg13g2_tiehi
XFILLER_7_700 VDD VSS sg13g2_decap_8
X_14353_ _14353_/Q _14513_/CLK _14353_/D _14353_/RESET_B VDD VSS sg13g2_dfrbpq_1
XFILLER_168_594 VDD VSS sg13g2_decap_8
X_11565_ _11566_/B _11527_/Y _12225_/B2 _11564_/Y VDD VSS sg13g2_a21oi_1
XFILLER_11_784 VDD VSS sg13g2_decap_8
XFILLER_156_756 VDD VSS sg13g2_decap_8
XFILLER_6_210 VDD VSS sg13g2_decap_8
X_13304_ _13320_/A _13303_/A _13304_/B VDD VSS sg13g2_nand2b_1
XFILLER_183_553 VDD VSS sg13g2_decap_8
X_10516_ _14854_/D _10453_/C _10521_/D _10499_/B _07623_/Y _10580_/B VDD VSS sg13g2_a221oi_1
XFILLER_109_650 VDD VSS sg13g2_decap_8
XFILLER_10_294 VDD VSS sg13g2_decap_8
XFILLER_155_255 VDD VSS sg13g2_decap_8
X_14284_ _14284_/Q _14540_/CLK _14284_/D _14284_/RESET_B VDD VSS sg13g2_dfrbpq_1
X_11496_ _11496_/X _11486_/X _11487_/X _11490_/X _11491_/X _11443_/A _12192_/A VDD
+ VSS sg13g2_mux4_1
XFILLER_7_777 VDD VSS sg13g2_decap_8
XFILLER_109_683 VDD VSS sg13g2_decap_8
X_13235_ _13235_/Y _14827_/Q _13206_/B _07727_/C _14891_/Q _13274_/C1 VDD VSS sg13g2_a221oi_1
XFILLER_40_70 VDD VSS sg13g2_decap_8
XFILLER_139_1420 VDD VSS sg13g2_fill_1
XFILLER_13_1295 VDD VSS sg13g2_decap_8
XFILLER_174_1300 VDD VSS sg13g2_decap_8
X_10447_ _14838_/D _10453_/C _10514_/A _10444_/B _07624_/Y _10577_/B VDD VSS sg13g2_a221oi_1
XFILLER_6_287 VDD VSS sg13g2_decap_8
XFILLER_48_1303 VDD VSS sg13g2_decap_8
XFILLER_87_1363 VDD VSS sg13g2_fill_2
XFILLER_124_631 VDD VSS sg13g2_decap_8
XFILLER_108_193 VDD VSS sg13g2_decap_8
XFILLER_174_1333 VDD VSS sg13g2_decap_8
XFILLER_87_1385 VDD VSS sg13g2_fill_1
XFILLER_112_804 VDD VSS sg13g2_fill_1
XFILLER_139_1464 VDD VSS sg13g2_decap_4
X_13166_ _13166_/Y _13166_/A1 _13161_/X _13165_/Y VDD VSS sg13g2_a21oi_1
XFILLER_87_1396 VDD VSS sg13g2_decap_8
XFILLER_41_7 VDD VSS sg13g2_decap_8
X_10378_ _10379_/A _14815_/Q _14816_/Q _14817_/Q _10378_/D VDD VSS sg13g2_and4_1
XFILLER_151_461 VDD VSS sg13g2_decap_8
XFILLER_112_826 VDD VSS sg13g2_decap_8
XFILLER_69_217 VDD VSS sg13g2_decap_8
X_12117_ _12118_/B _12106_/Y _12108_/X _11224_/A VDD VSS sg13g2_o21ai_1
XFILLER_3_994 VDD VSS sg13g2_decap_8
XFILLER_123_185 VDD VSS sg13g2_decap_8
X_13097_ _13097_/Y _13094_/Y _13095_/Y _13096_/Y VDD VSS sg13g2_a21oi_1
XFILLER_111_369 VDD VSS sg13g2_decap_8
X_12048_ _12048_/Y _12048_/A1 _12043_/X _12047_/Y VDD VSS sg13g2_a21oi_1
XFILLER_66_913 VDD VSS sg13g2_decap_8
XFILLER_93_710 VDD VSS sg13g2_fill_1
XFILLER_172_91 VDD VSS sg13g2_decap_8
XFILLER_77_272 VDD VSS sg13g2_decap_8
XFILLER_65_412 VDD VSS sg13g2_fill_2
XFILLER_1_42 VDD VSS sg13g2_decap_8
X_16856_ _16856_/X _16856_/A VDD VSS sg13g2_buf_1
XFILLER_168_1115 VDD VSS sg13g2_fill_1
XFILLER_4_1463 VDD VSS sg13g2_decap_8
XFILLER_59_1410 VDD VSS sg13g2_fill_2
XFILLER_18_350 VDD VSS sg13g2_decap_8
XFILLER_93_798 VDD VSS sg13g2_decap_8
XFILLER_81_938 VDD VSS sg13g2_decap_4
XFILLER_52_106 VDD VSS sg13g2_fill_2
X_13999_ _13999_/Q _14607_/CLK _13999_/D _13999_/RESET_B VDD VSS sg13g2_dfrbpq_1
XFILLER_0_1338 VDD VSS sg13g2_decap_8
XFILLER_20_1266 VDD VSS sg13g2_decap_8
XFILLER_46_681 VDD VSS sg13g2_decap_8
XFILLER_146_1424 VDD VSS sg13g2_decap_8
XFILLER_146_1435 VDD VSS sg13g2_fill_1
XFILLER_179_837 VDD VSS sg13g2_decap_8
XFILLER_55_1329 VDD VSS sg13g2_decap_8
XFILLER_178_336 VDD VSS sg13g2_decap_8
XFILLER_33_375 VDD VSS sg13g2_fill_1
X_08210_ _08211_/A _08246_/A1 _08197_/X _08209_/X _08110_/D _08193_/Y VDD VSS sg13g2_a221oi_1
XFILLER_33_397 VDD VSS sg13g2_decap_8
XFILLER_21_548 VDD VSS sg13g2_decap_8
X_09190_ _13806_/D _13806_/Q _09925_/A1 _09202_/S VDD VSS sg13g2_mux2_1
XFILLER_53_1042 VDD VSS sg13g2_fill_2
XFILLER_53_1053 VDD VSS sg13g2_fill_2
XFILLER_14_1015 VDD VSS sg13g2_decap_8
XFILLER_119_414 VDD VSS sg13g2_fill_1
XFILLER_159_583 VDD VSS sg13g2_decap_8
X_08141_ _08141_/Y _08037_/C _08140_/Y _08404_/B1 VDD VSS sg13g2_a21oi_1
XFILLER_144_1192 VDD VSS sg13g2_decap_8
XFILLER_159_594 VDD VSS sg13g2_decap_8
XFILLER_105_1165 VDD VSS sg13g2_decap_4
XFILLER_147_756 VDD VSS sg13g2_fill_2
XFILLER_101_1018 VDD VSS sg13g2_decap_8
XFILLER_140_1067 VDD VSS sg13g2_fill_2
X_08072_ _08078_/B _07882_/Y _08142_/A _08071_/Y _08073_/A _08070_/X VDD VSS sg13g2_a221oi_1
XFILLER_101_1029 VDD VSS sg13g2_fill_2
XFILLER_146_255 VDD VSS sg13g2_fill_1
XFILLER_179_1255 VDD VSS sg13g2_decap_8
XFILLER_174_575 VDD VSS sg13g2_decap_8
XFILLER_146_277 VDD VSS sg13g2_fill_2
XFILLER_179_1277 VDD VSS sg13g2_fill_2
XFILLER_134_439 VDD VSS sg13g2_decap_8
XFILLER_146_299 VDD VSS sg13g2_decap_8
XFILLER_161_236 VDD VSS sg13g2_fill_1
XFILLER_66_1414 VDD VSS sg13g2_decap_8
XFILLER_161_258 VDD VSS sg13g2_decap_8
XFILLER_114_130 VDD VSS sg13g2_fill_1
XFILLER_142_450 VDD VSS sg13g2_decap_8
XFILLER_114_152 VDD VSS sg13g2_decap_8
XFILLER_153_1417 VDD VSS sg13g2_fill_1
X_14035__2237 _14035_/RESET_B VDD VSS sg13g2_tiehi
X_13870__2402 _13870_/RESET_B VDD VSS sg13g2_tiehi
XFILLER_170_792 VDD VSS sg13g2_decap_8
XFILLER_130_634 VDD VSS sg13g2_decap_8
X_08974_ _10675_/B _09009_/S _15023_/Q VDD VSS sg13g2_nor2_1
XFILLER_9_1330 VDD VSS sg13g2_decap_8
XFILLER_114_196 VDD VSS sg13g2_decap_8
XFILLER_25_1100 VDD VSS sg13g2_fill_2
XFILLER_116_1250 VDD VSS sg13g2_decap_8
X_07925_ _07925_/Y _07926_/A _07926_/B VDD VSS sg13g2_nor2_1
XFILLER_29_49 VDD VSS sg13g2_decap_8
XFILLER_25_1133 VDD VSS sg13g2_decap_8
XFILLER_29_604 VDD VSS sg13g2_decap_8
XFILLER_68_261 VDD VSS sg13g2_decap_4
XFILLER_112_1114 VDD VSS sg13g2_decap_4
XFILLER_56_412 VDD VSS sg13g2_decap_8
XFILLER_28_103 VDD VSS sg13g2_decap_8
XFILLER_68_283 VDD VSS sg13g2_decap_8
XFILLER_112_1136 VDD VSS sg13g2_decap_8
X_07856_ _07856_/Y _07855_/A _07855_/B _08641_/A VDD VSS sg13g2_o21ai_1
XFILLER_151_1196 VDD VSS sg13g2_decap_8
X_14250__2022 _14250_/RESET_B VDD VSS sg13g2_tiehi
XFILLER_99_1289 VDD VSS sg13g2_fill_1
XFILLER_84_787 VDD VSS sg13g2_decap_4
XFILLER_72_927 VDD VSS sg13g2_decap_8
X_07787_ _07796_/B _08414_/A _08414_/B VDD VSS sg13g2_nor2_1
X_09526_ _14125_/D _09625_/A0 _14125_/Q _09530_/S VDD VSS sg13g2_mux2_1
XFILLER_37_692 VDD VSS sg13g2_decap_8
XFILLER_80_960 VDD VSS sg13g2_fill_2
XFILLER_101_43 VDD VSS sg13g2_decap_4
XFILLER_149_1092 VDD VSS sg13g2_decap_8
X_09457_ _14058_/D _09622_/A0 _14058_/Q _09473_/S VDD VSS sg13g2_mux2_1
XFILLER_80_971 VDD VSS sg13g2_decap_8
XFILLER_73_1429 VDD VSS sg13g2_decap_8
XFILLER_12_504 VDD VSS sg13g2_decap_8
XFILLER_169_347 VDD VSS sg13g2_fill_2
XFILLER_61_14 VDD VSS sg13g2_decap_8
XFILLER_52_695 VDD VSS sg13g2_decap_8
X_08408_ _08408_/Y _08070_/C _08236_/X _08034_/Y VDD VSS sg13g2_o21ai_1
XFILLER_61_25 VDD VSS sg13g2_fill_1
XFILLER_51_172 VDD VSS sg13g2_decap_8
X_14988__2692 _14988_/RESET_B VDD VSS sg13g2_tiehi
XFILLER_61_36 VDD VSS sg13g2_decap_8
X_09388_ _13991_/D _09951_/A1 _13991_/Q _09396_/S VDD VSS sg13g2_mux2_1
XFILLER_123_1210 VDD VSS sg13g2_fill_2
XFILLER_177_14 VDD VSS sg13g2_decap_8
XFILLER_36_1273 VDD VSS sg13g2_decap_8
X_08339_ _08339_/Y _08338_/B _08337_/X _08338_/Y VDD VSS sg13g2_o21ai_1
XFILLER_137_233 VDD VSS sg13g2_decap_8
XFILLER_138_756 VDD VSS sg13g2_decap_8
XFILLER_138_767 VDD VSS sg13g2_fill_2
X_11350_ _11350_/Y _11819_/A1 _13790_/Q _12304_/B VDD VSS sg13g2_a21oi_1
XFILLER_119_970 VDD VSS sg13g2_decap_8
XFILLER_123_1298 VDD VSS sg13g2_decap_8
XFILLER_125_417 VDD VSS sg13g2_decap_8
XFILLER_153_726 VDD VSS sg13g2_decap_8
XFILLER_4_714 VDD VSS sg13g2_decap_8
X_10301_ _10301_/Y _14794_/Q _10299_/Y _10350_/C VDD VSS sg13g2_o21ai_1
XFILLER_10_1435 VDD VSS sg13g2_decap_8
X_11281_ _11281_/Y _12319_/B1 _11277_/X _11280_/Y VDD VSS sg13g2_o21ai_1
X_14839__2959 _14839_/RESET_B VDD VSS sg13g2_tiehi
XFILLER_3_224 VDD VSS sg13g2_decap_8
X_13020_ _13021_/B _11236_/A _13019_/Y _13012_/Y _13009_/Y _13016_/Y VDD VSS sg13g2_a221oi_1
XFILLER_180_567 VDD VSS sg13g2_decap_8
X_10232_ _14772_/D _10232_/A _10232_/B _10441_/C VDD VSS sg13g2_and3_1
XFILLER_134_973 VDD VSS sg13g2_decap_8
XFILLER_69_1093 VDD VSS sg13g2_fill_2
XFILLER_105_152 VDD VSS sg13g2_fill_1
XFILLER_161_770 VDD VSS sg13g2_decap_4
XFILLER_10_84 VDD VSS sg13g2_decap_8
XFILLER_156_1085 VDD VSS sg13g2_decap_4
X_14460__1812 _14460_/RESET_B VDD VSS sg13g2_tiehi
Xfanout1003 _13396_/C _13414_/A VDD VSS sg13g2_buf_1
X_10163_ _14740_/D _14740_/Q _10163_/A1 _10163_/S VDD VSS sg13g2_mux2_1
XFILLER_160_280 VDD VSS sg13g2_decap_8
XFILLER_126_84 VDD VSS sg13g2_decap_8
Xfanout1014 _12348_/A _15125_/Q VDD VSS sg13g2_buf_1
XFILLER_0_953 VDD VSS sg13g2_decap_8
XFILLER_126_95 VDD VSS sg13g2_fill_2
Xfanout1025 _13260_/B _15107_/Q VDD VSS sg13g2_buf_1
Xfanout1036 _08698_/B _08369_/B VDD VSS sg13g2_buf_1
Xfanout1047 _13345_/B _10898_/B1 VDD VSS sg13g2_buf_1
XFILLER_82_1282 VDD VSS sg13g2_decap_8
X_14971_ _14971_/Q clkload71/A _14971_/D _14971_/RESET_B VDD VSS sg13g2_dfrbpq_1
X_10094_ _14674_/D _10161_/A1 _14674_/Q _10102_/S VDD VSS sg13g2_mux2_1
Xfanout1058 _09938_/A _15067_/Q VDD VSS sg13g2_buf_1
XFILLER_59_261 VDD VSS sg13g2_decap_8
Xfanout1069 _09707_/B _15063_/Q VDD VSS sg13g2_buf_1
XFILLER_102_892 VDD VSS sg13g2_fill_1
XFILLER_130_1214 VDD VSS sg13g2_decap_8
X_13922_ _13922_/Q clkload45/A _13922_/D _13922_/RESET_B VDD VSS sg13g2_dfrbpq_1
XFILLER_142_50 VDD VSS sg13g2_fill_2
XFILLER_47_445 VDD VSS sg13g2_decap_8
XFILLER_19_147 VDD VSS sg13g2_decap_8
X_13853_ _13853_/Q _14883_/CLK _13853_/D _13853_/RESET_B VDD VSS sg13g2_dfrbpq_1
XFILLER_74_264 VDD VSS sg13g2_decap_8
X_13733__2539 _13733_/RESET_B VDD VSS sg13g2_tiehi
XFILLER_90_724 VDD VSS sg13g2_decap_8
XFILLER_35_629 VDD VSS sg13g2_decap_4
X_14493__1779 _14493_/RESET_B VDD VSS sg13g2_tiehi
X_13879__2393 _13879_/RESET_B VDD VSS sg13g2_tiehi
XFILLER_16_832 VDD VSS sg13g2_fill_1
X_12804_ _12804_/Y input4/X _12841_/B _12803_/X input34/X _12800_/X VDD VSS sg13g2_a221oi_1
XFILLER_76_1020 VDD VSS sg13g2_decap_8
X_13784_ _13784_/Q _14744_/CLK _13784_/D _13784_/RESET_B VDD VSS sg13g2_dfrbpq_1
X_10996_ _10996_/Y _11043_/A _10996_/B VDD VSS sg13g2_nand2_1
XFILLER_62_459 VDD VSS sg13g2_fill_2
X_15201__3062 _15201_/RESET_B VDD VSS sg13g2_tiehi
XFILLER_163_1012 VDD VSS sg13g2_fill_2
XFILLER_167_1181 VDD VSS sg13g2_decap_8
XFILLER_43_662 VDD VSS sg13g2_decap_8
XFILLER_35_70 VDD VSS sg13g2_fill_2
XFILLER_15_364 VDD VSS sg13g2_decap_8
XFILLER_163_1023 VDD VSS sg13g2_decap_4
X_12735_ _12736_/B _13666_/Q _12791_/A2 _12734_/X _12763_/B2 _12763_/C1 VDD VSS sg13g2_a221oi_1
XFILLER_42_150 VDD VSS sg13g2_decap_8
XFILLER_30_301 VDD VSS sg13g2_decap_8
XFILLER_70_492 VDD VSS sg13g2_decap_8
XFILLER_31_846 VDD VSS sg13g2_decap_4
X_12666_ _15011_/D _12666_/A _12666_/B VDD VSS sg13g2_nor2_1
XFILLER_42_194 VDD VSS sg13g2_decap_8
XFILLER_30_334 VDD VSS sg13g2_decap_8
XFILLER_163_1078 VDD VSS sg13g2_decap_8
XFILLER_175_306 VDD VSS sg13g2_decap_8
XFILLER_129_712 VDD VSS sg13g2_decap_8
X_14113__2159 _14113_/RESET_B VDD VSS sg13g2_tiehi
XFILLER_89_7 VDD VSS sg13g2_decap_8
XFILLER_141_1321 VDD VSS sg13g2_decap_8
XFILLER_54_1373 VDD VSS sg13g2_decap_8
X_14405_ _14405_/Q clkload14/A _14405_/D _14405_/RESET_B VDD VSS sg13g2_dfrbpq_1
X_11617_ _11617_/Y _11741_/A _13862_/Q _11963_/S1 VDD VSS sg13g2_a21oi_1
XFILLER_168_380 VDD VSS sg13g2_decap_8
X_12597_ _15006_/D _12597_/A _12597_/B VDD VSS sg13g2_nor2_1
XFILLER_129_756 VDD VSS sg13g2_decap_8
XFILLER_50_1237 VDD VSS sg13g2_fill_1
XFILLER_11_581 VDD VSS sg13g2_decap_8
XFILLER_15_1368 VDD VSS sg13g2_decap_8
XFILLER_156_553 VDD VSS sg13g2_decap_4
XFILLER_50_1259 VDD VSS sg13g2_decap_8
X_14336_ _14336_/Q _14720_/CLK _14336_/D _14336_/RESET_B VDD VSS sg13g2_dfrbpq_1
X_11548_ _11549_/A _14244_/Q _14276_/Q _14308_/Q _14340_/Q _12238_/S0 _12245_/S1 VDD
+ VSS sg13g2_mux4_1
XFILLER_116_406 VDD VSS sg13g2_decap_8
XFILLER_129_789 VDD VSS sg13g2_decap_8
XFILLER_183_350 VDD VSS sg13g2_decap_8
XFILLER_89_1447 VDD VSS sg13g2_fill_2
XFILLER_144_726 VDD VSS sg13g2_decap_8
XFILLER_176_1406 VDD VSS sg13g2_decap_8
XFILLER_143_203 VDD VSS sg13g2_decap_8
XFILLER_7_574 VDD VSS sg13g2_decap_8
XFILLER_167_91 VDD VSS sg13g2_decap_8
X_14267_ _14267_/Q clkload58/A _14267_/D _14267_/RESET_B VDD VSS sg13g2_dfrbpq_1
XFILLER_13_1092 VDD VSS sg13g2_decap_8
X_11479_ _11479_/Y _14900_/Q _11433_/B _07684_/B VDD VSS sg13g2_a21oi_1
X_13218_ _13218_/Y _14858_/Q _13218_/B VDD VSS sg13g2_nand2_1
X_14198_ _14198_/Q _14518_/CLK _14198_/D _14198_/RESET_B VDD VSS sg13g2_dfrbpq_1
XFILLER_152_770 VDD VSS sg13g2_fill_2
XFILLER_98_824 VDD VSS sg13g2_decap_8
XFILLER_139_1272 VDD VSS sg13g2_decap_8
XFILLER_48_1155 VDD VSS sg13g2_fill_1
XFILLER_83_1046 VDD VSS sg13g2_fill_1
XFILLER_124_494 VDD VSS sg13g2_decap_8
X_13149_ _13149_/X input18/X _13161_/A2 _13161_/B1 VDD VSS sg13g2_a21o_1
XFILLER_151_280 VDD VSS sg13g2_decap_8
XFILLER_3_791 VDD VSS sg13g2_decap_8
XFILLER_151_291 VDD VSS sg13g2_fill_2
XFILLER_83_1079 VDD VSS sg13g2_decap_8
XFILLER_98_879 VDD VSS sg13g2_decap_8
XFILLER_97_367 VDD VSS sg13g2_decap_8
XFILLER_61_1322 VDD VSS sg13g2_decap_8
XFILLER_152_1450 VDD VSS sg13g2_fill_1
XFILLER_26_1453 VDD VSS sg13g2_decap_8
XFILLER_39_935 VDD VSS sg13g2_fill_2
XFILLER_22_1317 VDD VSS sg13g2_decap_8
X_07710_ _07710_/Y _13281_/B _13281_/C VDD VSS sg13g2_nor2_1
XFILLER_66_732 VDD VSS sg13g2_decap_8
X_08690_ _08690_/X _15103_/Q _15090_/Q _08690_/C VDD VSS sg13g2_or3_1
X_13692__2581 _13692_/RESET_B VDD VSS sg13g2_tiehi
XFILLER_113_1467 VDD VSS sg13g2_fill_2
XFILLER_96_1407 VDD VSS sg13g2_decap_8
XFILLER_39_979 VDD VSS sg13g2_decap_8
XFILLER_93_551 VDD VSS sg13g2_fill_2
X_07641_ _10265_/B _14782_/Q VDD VSS sg13g2_inv_1
XFILLER_38_467 VDD VSS sg13g2_decap_4
XFILLER_4_1260 VDD VSS sg13g2_decap_8
X_14323__1949 _14323_/RESET_B VDD VSS sg13g2_tiehi
XFILLER_65_286 VDD VSS sg13g2_fill_1
X_13709__2563 _13709_/RESET_B VDD VSS sg13g2_tiehi
XFILLER_0_1135 VDD VSS sg13g2_decap_8
XFILLER_81_768 VDD VSS sg13g2_decap_8
XFILLER_80_245 VDD VSS sg13g2_decap_8
X_14943__2751 _14943_/RESET_B VDD VSS sg13g2_tiehi
X_09311_ _13918_/D _09909_/A1 _13918_/Q _09327_/S VDD VSS sg13g2_mux2_1
XFILLER_34_651 VDD VSS sg13g2_decap_8
XFILLER_179_623 VDD VSS sg13g2_decap_8
XFILLER_62_971 VDD VSS sg13g2_decap_8
XFILLER_146_1243 VDD VSS sg13g2_fill_1
XFILLER_94_1175 VDD VSS sg13g2_decap_8
XFILLER_80_289 VDD VSS sg13g2_decap_8
XFILLER_107_1205 VDD VSS sg13g2_decap_4
XFILLER_90_1017 VDD VSS sg13g2_decap_8
XFILLER_55_1137 VDD VSS sg13g2_decap_8
XFILLER_178_133 VDD VSS sg13g2_decap_8
XFILLER_61_481 VDD VSS sg13g2_decap_8
X_09242_ _13851_/D _13851_/Q _09939_/A1 _09261_/S VDD VSS sg13g2_mux2_1
XFILLER_22_879 VDD VSS sg13g2_decap_8
XFILLER_33_1413 VDD VSS sg13g2_decap_8
X_09173_ _13789_/D _13789_/Q _09908_/A1 _09202_/S VDD VSS sg13g2_mux2_1
XFILLER_119_211 VDD VSS sg13g2_decap_8
XFILLER_147_520 VDD VSS sg13g2_decap_8
XFILLER_147_531 VDD VSS sg13g2_fill_2
XFILLER_175_840 VDD VSS sg13g2_decap_4
XFILLER_31_28 VDD VSS sg13g2_decap_8
XFILLER_108_907 VDD VSS sg13g2_decap_4
X_08124_ _08124_/X _14984_/Q _07972_/B _08653_/B _08673_/B _08686_/S0 _13510_/A1 VDD
+ VSS sg13g2_mux4_1
XFILLER_107_406 VDD VSS sg13g2_decap_8
XFILLER_120_1438 VDD VSS sg13g2_decap_8
XFILLER_147_28 VDD VSS sg13g2_decap_8
XFILLER_147_586 VDD VSS sg13g2_decap_8
XFILLER_179_1052 VDD VSS sg13g2_decap_4
XFILLER_135_737 VDD VSS sg13g2_fill_1
X_08055_ _08167_/B _07859_/B _07853_/B _07965_/B _12203_/A _08635_/S0 _08669_/B1 VDD
+ VSS sg13g2_mux4_1
XFILLER_174_394 VDD VSS sg13g2_decap_8
X_14268__2004 _14268_/RESET_B VDD VSS sg13g2_tiehi
X_15121__2810 _15121_/RESET_B VDD VSS sg13g2_tiehi
XFILLER_103_601 VDD VSS sg13g2_decap_8
XFILLER_115_461 VDD VSS sg13g2_decap_8
Xoutput39 mem_axi_araddr[10] _13701_/Q VDD VSS sg13g2_buf_1
XFILLER_1_728 VDD VSS sg13g2_decap_8
XFILLER_89_835 VDD VSS sg13g2_decap_8
XFILLER_88_301 VDD VSS sg13g2_decap_8
Xhold3111 _10213_/B input37/X VDD VSS sg13g2_dlygate4sd3_1
XFILLER_153_1214 VDD VSS sg13g2_decap_8
Xhold3122 _15170_/D _13486_/B VDD VSS sg13g2_dlygate4sd3_1
XFILLER_130_420 VDD VSS sg13g2_decap_8
Xhold3133 hold3133/X input35/X VDD VSS sg13g2_dlygate4sd3_1
XFILLER_0_238 VDD VSS sg13g2_decap_8
XFILLER_103_645 VDD VSS sg13g2_decap_8
XFILLER_142_291 VDD VSS sg13g2_decap_8
Xhold3144 hold3144/X input6/X VDD VSS sg13g2_dlygate4sd3_1
XFILLER_62_1119 VDD VSS sg13g2_decap_8
XFILLER_102_133 VDD VSS sg13g2_decap_8
XFILLER_163_49 VDD VSS sg13g2_decap_8
Xhold3155 hold3155/X input24/X VDD VSS sg13g2_dlygate4sd3_1
XFILLER_114_1209 VDD VSS sg13g2_decap_4
Xhold3166 input17/A mem_axi_rdata[21] VDD VSS sg13g2_dlygate4sd3_1
Xhold3177 hold3177/X input11/X VDD VSS sg13g2_dlygate4sd3_1
Xhold3188 hold3188/X _10211_/Y VDD VSS sg13g2_dlygate4sd3_1
X_08957_ _10137_/B _09905_/A _10105_/C VDD VSS sg13g2_nand2b_1
Xhold3199 _13623_/A _13731_/Q VDD VSS sg13g2_dlygate4sd3_1
XFILLER_56_14 VDD VSS sg13g2_decap_8
X_07908_ _13290_/A _07908_/A _07908_/B VDD VSS sg13g2_nand2_1
XFILLER_116_1091 VDD VSS sg13g2_decap_8
X_08888_ _08888_/Y _13608_/A1 _08835_/B _16867_/A VDD VSS sg13g2_a21oi_1
XFILLER_5_1057 VDD VSS sg13g2_decap_8
X_07839_ _07969_/A _07979_/C _07981_/C _08697_/B _08698_/A VDD VSS sg13g2_nand4_1
XFILLER_72_713 VDD VSS sg13g2_decap_8
XFILLER_44_426 VDD VSS sg13g2_decap_4
XFILLER_186_1056 VDD VSS sg13g2_decap_8
X_10850_ _10850_/Y _10850_/A _10850_/B VDD VSS sg13g2_nand2_1
XFILLER_186_1067 VDD VSS sg13g2_decap_8
XFILLER_38_1324 VDD VSS sg13g2_decap_8
X_09509_ _14108_/D _10072_/A0 _14108_/Q _09539_/S VDD VSS sg13g2_mux2_1
X_10781_ _10781_/X _10781_/A _10781_/B _10781_/C VDD VSS sg13g2_and3_1
XFILLER_12_301 VDD VSS sg13g2_decap_8
XFILLER_129_1474 VDD VSS sg13g2_fill_1
XFILLER_169_133 VDD VSS sg13g2_decap_8
X_12520_ _12520_/X _13735_/Q _14087_/Q _14439_/Q _14535_/Q _12522_/S0 _12522_/S1 VDD
+ VSS sg13g2_mux4_1
XFILLER_164_1376 VDD VSS sg13g2_decap_8
XFILLER_125_1338 VDD VSS sg13g2_decap_8
XFILLER_13_868 VDD VSS sg13g2_decap_8
XFILLER_40_654 VDD VSS sg13g2_decap_8
XFILLER_125_1349 VDD VSS sg13g2_fill_1
XFILLER_185_637 VDD VSS sg13g2_decap_8
XFILLER_157_339 VDD VSS sg13g2_decap_8
X_12451_ _12451_/X _14370_/Q _14402_/Q _14466_/Q _14498_/Q _12452_/S0 _12452_/S1 VDD
+ VSS sg13g2_mux4_1
XFILLER_12_378 VDD VSS sg13g2_decap_8
XFILLER_36_1081 VDD VSS sg13g2_decap_8
Xclkbuf_leaf_51_clk_i clkload43/A clkbuf_leaf_51_clk_i/A VDD VSS sg13g2_buf_8
XFILLER_166_851 VDD VSS sg13g2_decap_8
XFILLER_184_147 VDD VSS sg13g2_decap_8
X_11402_ _11402_/Y _11397_/Y _11398_/Y _11422_/B VDD VSS sg13g2_a21oi_1
X_15170_ _15170_/Q clkload85/A _15170_/D _15170_/RESET_B VDD VSS sg13g2_dfrbpq_1
X_12382_ _12382_/X _14237_/Q _14269_/Q _14301_/Q _14333_/Q _12382_/S0 _12382_/S1 VDD
+ VSS sg13g2_mux4_1
XFILLER_123_1084 VDD VSS sg13g2_decap_4
XFILLER_181_821 VDD VSS sg13g2_decap_8
X_14121_ _14121_/Q clkload35/A _14121_/D _14121_/RESET_B VDD VSS sg13g2_dfrbpq_1
XFILLER_115_0 VDD VSS sg13g2_decap_8
X_11333_ _11333_/Y _12835_/A _11433_/B _11340_/A1 VDD VSS sg13g2_a21oi_1
XFILLER_4_511 VDD VSS sg13g2_decap_8
XFILLER_10_1232 VDD VSS sg13g2_decap_8
X_14052_ _14052_/Q _14503_/CLK _14052_/D _14052_/RESET_B VDD VSS sg13g2_dfrbpq_1
XFILLER_125_269 VDD VSS sg13g2_decap_8
XFILLER_180_364 VDD VSS sg13g2_decap_8
Xclkbuf_leaf_66_clk_i clkload88/A clkbuf_leaf_66_clk_i/A VDD VSS sg13g2_buf_8
X_11264_ _11264_/X _11259_/Y _11260_/Y _12324_/B VDD VSS sg13g2_a21o_1
XFILLER_97_21 VDD VSS sg13g2_fill_2
XFILLER_153_589 VDD VSS sg13g2_decap_8
XFILLER_136_1412 VDD VSS sg13g2_decap_8
XFILLER_106_472 VDD VSS sg13g2_decap_8
XFILLER_134_781 VDD VSS sg13g2_decap_8
X_13003_ _13003_/Y _13000_/Y _13001_/Y _13002_/Y VDD VSS sg13g2_a21oi_1
XFILLER_4_588 VDD VSS sg13g2_decap_8
X_10215_ _14764_/D _10213_/A _10209_/B hold3112/X VDD VSS sg13g2_a21oi_1
X_11195_ _14955_/D _07614_/Y _10671_/Y _11194_/Y VDD VSS sg13g2_o21ai_1
XFILLER_133_291 VDD VSS sg13g2_decap_8
XFILLER_0_750 VDD VSS sg13g2_decap_8
XFILLER_171_1358 VDD VSS sg13g2_decap_8
X_15069__2960 _15069_/RESET_B VDD VSS sg13g2_tiehi
XFILLER_79_367 VDD VSS sg13g2_decap_8
XFILLER_67_507 VDD VSS sg13g2_decap_8
X_10146_ _14723_/D _14723_/Q _10146_/A1 _10168_/S VDD VSS sg13g2_mux2_1
XFILLER_88_890 VDD VSS sg13g2_decap_8
XFILLER_48_721 VDD VSS sg13g2_decap_8
XFILLER_43_1052 VDD VSS sg13g2_decap_8
XFILLER_130_1011 VDD VSS sg13g2_decap_8
X_14954_ _14954_/Q clkload72/A _14954_/D _14954_/RESET_B VDD VSS sg13g2_dfrbpq_1
X_10077_ _14657_/D _10077_/A0 _14657_/Q _10097_/S VDD VSS sg13g2_mux2_1
X_13966__2306 _13966_/RESET_B VDD VSS sg13g2_tiehi
XFILLER_47_242 VDD VSS sg13g2_decap_8
XFILLER_36_905 VDD VSS sg13g2_decap_8
XFILLER_1_1400 VDD VSS sg13g2_decap_8
X_13905_ _13905_/Q clkload8/A _13905_/D _13905_/RESET_B VDD VSS sg13g2_dfrbpq_1
XFILLER_48_787 VDD VSS sg13g2_decap_8
XFILLER_169_1232 VDD VSS sg13g2_decap_8
XFILLER_63_713 VDD VSS sg13g2_decap_8
X_14885_ _14885_/Q _14886_/CLK _14885_/D _14885_/RESET_B VDD VSS sg13g2_dfrbpq_1
XFILLER_78_1137 VDD VSS sg13g2_fill_2
XFILLER_21_1361 VDD VSS sg13g2_decap_8
XFILLER_130_1099 VDD VSS sg13g2_decap_8
X_13836_ _13836_/Q _14540_/CLK _13836_/D _13836_/RESET_B VDD VSS sg13g2_dfrbpq_1
XFILLER_62_234 VDD VSS sg13g2_decap_8
XFILLER_169_1298 VDD VSS sg13g2_decap_8
XFILLER_16_651 VDD VSS sg13g2_decap_8
XFILLER_50_407 VDD VSS sg13g2_decap_8
XFILLER_182_1421 VDD VSS sg13g2_fill_2
XFILLER_44_982 VDD VSS sg13g2_decap_8
X_13767_ _13767_/Q _14741_/CLK _13767_/D _13767_/RESET_B VDD VSS sg13g2_dfrbpq_1
X_10979_ _10979_/Y _14759_/Q _10722_/Y _11009_/D VDD VSS sg13g2_o21ai_1
XFILLER_91_1326 VDD VSS sg13g2_decap_8
XFILLER_15_161 VDD VSS sg13g2_decap_8
X_13669__2627 _13669_/RESET_B VDD VSS sg13g2_tiehi
XFILLER_143_1427 VDD VSS sg13g2_decap_8
X_12718_ _12718_/X _12713_/X _12715_/X _12712_/X _12714_/X _12762_/S _12732_/S0 VDD
+ VSS sg13g2_mux4_1
XFILLER_31_643 VDD VSS sg13g2_fill_2
XFILLER_143_1438 VDD VSS sg13g2_fill_2
XFILLER_143_1449 VDD VSS sg13g2_decap_8
X_13698_ _16860_/A _15226_/CLK _13698_/D _13698_/RESET_B VDD VSS sg13g2_dfrbpq_1
Xclkbuf_leaf_19_clk_i _14518_/CLK clkbuf_leaf_51_clk_i/A VDD VSS sg13g2_buf_8
XFILLER_129_520 VDD VSS sg13g2_decap_8
XFILLER_176_648 VDD VSS sg13g2_decap_4
X_12649_ _12649_/X _12647_/X _12646_/X _12643_/X _12642_/X _12761_/S0 _12761_/S1 VDD
+ VSS sg13g2_mux4_1
XFILLER_31_698 VDD VSS sg13g2_decap_8
XFILLER_30_175 VDD VSS sg13g2_decap_8
XFILLER_175_147 VDD VSS sg13g2_decap_8
XFILLER_50_1045 VDD VSS sg13g2_fill_1
XFILLER_157_873 VDD VSS sg13g2_decap_8
XFILLER_15_1165 VDD VSS sg13g2_decap_8
XFILLER_8_861 VDD VSS sg13g2_decap_8
XFILLER_89_1222 VDD VSS sg13g2_decap_8
XFILLER_106_1293 VDD VSS sg13g2_decap_8
XFILLER_172_810 VDD VSS sg13g2_decap_8
XFILLER_89_1233 VDD VSS sg13g2_fill_1
XFILLER_117_726 VDD VSS sg13g2_decap_8
XFILLER_156_361 VDD VSS sg13g2_decap_4
XFILLER_116_203 VDD VSS sg13g2_decap_8
XFILLER_11_1029 VDD VSS sg13g2_decap_8
XFILLER_7_63 VDD VSS sg13g2_decap_8
XFILLER_156_383 VDD VSS sg13g2_decap_8
X_14319_ _14319_/Q _14610_/CLK _14319_/D _14319_/RESET_B VDD VSS sg13g2_dfrbpq_1
XFILLER_7_371 VDD VSS sg13g2_decap_8
XFILLER_176_1236 VDD VSS sg13g2_decap_8
XFILLER_89_1288 VDD VSS sg13g2_decap_8
XFILLER_144_556 VDD VSS sg13g2_decap_8
XFILLER_116_258 VDD VSS sg13g2_decap_8
XFILLER_113_910 VDD VSS sg13g2_decap_8
XFILLER_125_781 VDD VSS sg13g2_fill_2
Xfanout807 _08138_/B _08070_/B VDD VSS sg13g2_buf_1
X_09860_ _14447_/D _14447_/Q _10091_/A0 _09862_/S VDD VSS sg13g2_mux2_1
XFILLER_98_632 VDD VSS sg13g2_decap_8
XFILLER_113_954 VDD VSS sg13g2_decap_8
Xfanout818 _07913_/A _07627_/Y VDD VSS sg13g2_buf_1
XFILLER_63_1428 VDD VSS sg13g2_fill_1
Xfanout829 _11082_/A1 _10647_/D VDD VSS sg13g2_buf_1
XFILLER_98_665 VDD VSS sg13g2_decap_4
XFILLER_30_0 VDD VSS sg13g2_decap_8
XFILLER_140_762 VDD VSS sg13g2_decap_8
X_08811_ _13688_/D _08811_/A _08811_/B VDD VSS sg13g2_nor2_1
XFILLER_113_998 VDD VSS sg13g2_decap_8
X_09791_ _14380_/D _09923_/A1 _14380_/Q _09805_/S VDD VSS sg13g2_mux2_1
XFILLER_85_304 VDD VSS sg13g2_decap_8
XFILLER_140_795 VDD VSS sg13g2_decap_8
XFILLER_86_849 VDD VSS sg13g2_decap_8
XFILLER_26_1250 VDD VSS sg13g2_decap_8
XFILLER_113_1220 VDD VSS sg13g2_decap_8
X_08742_ _08742_/Y _07719_/A _11288_/A _15196_/Q VDD VSS sg13g2_o21ai_1
XFILLER_6_1344 VDD VSS sg13g2_decap_8
XFILLER_39_732 VDD VSS sg13g2_fill_1
XFILLER_152_1280 VDD VSS sg13g2_decap_8
XFILLER_22_1114 VDD VSS sg13g2_decap_8
XFILLER_61_1174 VDD VSS sg13g2_decap_8
X_14556__1716 _14556_/RESET_B VDD VSS sg13g2_tiehi
XFILLER_94_871 VDD VSS sg13g2_decap_8
X_08673_ _08673_/X _15019_/Q _08673_/B VDD VSS sg13g2_or2_1
XFILLER_66_573 VDD VSS sg13g2_fill_1
XFILLER_113_1297 VDD VSS sg13g2_decap_4
XFILLER_27_949 VDD VSS sg13g2_fill_2
X_15150__2750 _15150_/RESET_B VDD VSS sg13g2_tiehi
XFILLER_26_28 VDD VSS sg13g2_decap_8
X_07624_ _07624_/Y _14838_/Q VDD VSS sg13g2_inv_1
XFILLER_53_223 VDD VSS sg13g2_decap_8
XFILLER_26_448 VDD VSS sg13g2_decap_8
XFILLER_81_554 VDD VSS sg13g2_decap_8
XFILLER_179_420 VDD VSS sg13g2_decap_8
XFILLER_41_418 VDD VSS sg13g2_decap_8
XFILLER_35_993 VDD VSS sg13g2_decap_8
XFILLER_50_930 VDD VSS sg13g2_decap_8
XFILLER_146_1073 VDD VSS sg13g2_fill_2
XFILLER_10_805 VDD VSS sg13g2_decap_8
XFILLER_179_497 VDD VSS sg13g2_decap_8
X_09225_ _13836_/D _09558_/A0 _13836_/Q _09227_/S VDD VSS sg13g2_mux2_1
XFILLER_42_49 VDD VSS sg13g2_decap_8
XFILLER_37_1390 VDD VSS sg13g2_decap_8
XFILLER_21_175 VDD VSS sg13g2_decap_8
XFILLER_33_1232 VDD VSS sg13g2_decap_8
XFILLER_166_147 VDD VSS sg13g2_decap_8
X_09156_ _09158_/B _14924_/Q _09156_/B VDD VSS sg13g2_nand2b_1
XFILLER_159_1401 VDD VSS sg13g2_decap_8
XFILLER_175_670 VDD VSS sg13g2_decap_8
XFILLER_5_308 VDD VSS sg13g2_decap_8
XFILLER_148_895 VDD VSS sg13g2_decap_8
XFILLER_120_1246 VDD VSS sg13g2_decap_8
X_08107_ _08112_/D _07879_/A _08103_/B _08106_/Y VDD VSS sg13g2_o21ai_1
XFILLER_68_1306 VDD VSS sg13g2_fill_1
XFILLER_107_225 VDD VSS sg13g2_decap_8
X_09087_ _09090_/B _14914_/Q _09087_/B VDD VSS sg13g2_nand2b_1
XFILLER_163_854 VDD VSS sg13g2_decap_8
XFILLER_120_1279 VDD VSS sg13g2_decap_8
X_08038_ _08039_/D _08470_/A _07896_/X _08037_/A _08674_/B1 VDD VSS sg13g2_a22oi_1
XFILLER_89_610 VDD VSS sg13g2_decap_4
XFILLER_162_397 VDD VSS sg13g2_decap_8
X_15200__3061 _15200_/RESET_B VDD VSS sg13g2_tiehi
XFILLER_66_1041 VDD VSS sg13g2_decap_4
XFILLER_1_525 VDD VSS sg13g2_decap_8
XFILLER_118_1153 VDD VSS sg13g2_fill_2
X_10000_ _14583_/D _10066_/A0 _14583_/Q _10002_/S VDD VSS sg13g2_mux2_1
XFILLER_104_998 VDD VSS sg13g2_fill_2
XFILLER_130_261 VDD VSS sg13g2_decap_8
XFILLER_131_784 VDD VSS sg13g2_decap_8
XFILLER_27_1069 VDD VSS sg13g2_decap_8
X_09989_ _14572_/D _10122_/A0 _14572_/Q _09997_/S VDD VSS sg13g2_mux2_1
XFILLER_40_1236 VDD VSS sg13g2_decap_4
XFILLER_18_916 VDD VSS sg13g2_decap_4
XFILLER_91_318 VDD VSS sg13g2_decap_8
X_11951_ _11952_/B _11951_/A _14672_/Q VDD VSS sg13g2_nand2_1
XFILLER_18_949 VDD VSS sg13g2_fill_2
XFILLER_29_275 VDD VSS sg13g2_fill_2
XFILLER_17_448 VDD VSS sg13g2_decap_8
X_10902_ _14934_/D _14934_/Q _10875_/B _10901_/Y VDD VSS sg13g2_a21o_1
X_14670_ _14670_/Q clkload52/A _14670_/D _14670_/RESET_B VDD VSS sg13g2_dfrbpq_1
X_11882_ _11882_/X _13742_/Q _14094_/Q _14446_/Q _14542_/Q _11896_/A _11897_/C VDD
+ VSS sg13g2_mux4_1
XFILLER_166_1438 VDD VSS sg13g2_fill_1
XFILLER_83_78 VDD VSS sg13g2_decap_8
X_13621_ _13729_/D _13621_/A VDD VSS sg13g2_buf_1
X_10833_ _10876_/D _10844_/A _10844_/B _10851_/D VDD VSS sg13g2_nand3_1
XFILLER_60_727 VDD VSS sg13g2_decap_8
XFILLER_53_790 VDD VSS sg13g2_decap_8
XFILLER_41_930 VDD VSS sg13g2_fill_2
XFILLER_41_941 VDD VSS sg13g2_decap_4
XFILLER_125_1113 VDD VSS sg13g2_decap_8
X_13552_ _13552_/Y _15006_/Q _13558_/B _13566_/C VDD VSS sg13g2_nor3_1
X_10764_ _10764_/X _14949_/Q _10767_/A _10762_/Y VDD VSS sg13g2_a21o_1
XFILLER_158_615 VDD VSS sg13g2_decap_4
XFILLER_160_1004 VDD VSS sg13g2_decap_8
XFILLER_13_665 VDD VSS sg13g2_decap_8
XFILLER_158_626 VDD VSS sg13g2_decap_8
XFILLER_160_1015 VDD VSS sg13g2_fill_1
X_12503_ _12503_/X _13830_/Q _13862_/Q _13894_/Q _13926_/Q _12605_/S0 _12643_/S1 VDD
+ VSS sg13g2_mux4_1
XFILLER_185_434 VDD VSS sg13g2_decap_8
X_13483_ _13484_/C _13412_/B _13412_/C _15123_/Q VDD VSS sg13g2_o21ai_1
XFILLER_12_175 VDD VSS sg13g2_decap_8
X_10695_ _10696_/A _14901_/Q _10875_/B _07753_/B _10871_/A VDD VSS sg13g2_a22oi_1
XFILLER_9_658 VDD VSS sg13g2_decap_8
XFILLER_51_1332 VDD VSS sg13g2_decap_8
X_14030__2242 _14030_/RESET_B VDD VSS sg13g2_tiehi
X_15222_ _15222_/Q _15224_/CLK _15222_/D _15222_/RESET_B VDD VSS sg13g2_dfrbpq_1
X_12434_ _12434_/X _14689_/Q _14721_/Q _13761_/Q _13793_/Q _12452_/S0 _12452_/S1 VDD
+ VSS sg13g2_mux4_1
XFILLER_12_1316 VDD VSS sg13g2_decap_8
XFILLER_8_168 VDD VSS sg13g2_decap_8
XFILLER_138_372 VDD VSS sg13g2_decap_8
X_15153_ _15153_/Q clkload86/A _15153_/D _15153_/RESET_B VDD VSS sg13g2_dfrbpq_1
X_12365_ _12365_/X _14556_/Q _14588_/Q _14620_/Q _14652_/Q _12366_/S0 _12366_/S1 VDD
+ VSS sg13g2_mux4_1
XFILLER_181_651 VDD VSS sg13g2_decap_8
X_14634__1638 _14634_/RESET_B VDD VSS sg13g2_tiehi
X_14104_ _14104_/Q _14518_/CLK _14104_/D _14104_/RESET_B VDD VSS sg13g2_dfrbpq_1
X_11316_ _11318_/B _11317_/A1 _14461_/Q VDD VSS sg13g2_nand2b_1
XFILLER_99_407 VDD VSS sg13g2_decap_8
X_15084_ _15084_/Q clkload89/A _15084_/D _15084_/RESET_B VDD VSS sg13g2_dfrbpq_1
XFILLER_5_875 VDD VSS sg13g2_decap_8
X_12296_ _12297_/B _12301_/B1 _12280_/Y _12295_/Y VDD VSS sg13g2_o21ai_1
XFILLER_101_1190 VDD VSS sg13g2_decap_8
XFILLER_180_161 VDD VSS sg13g2_decap_8
XFILLER_84_1130 VDD VSS sg13g2_decap_8
X_14035_ _14035_/Q clkload31/A _14035_/D _14035_/RESET_B VDD VSS sg13g2_dfrbpq_1
XFILLER_4_385 VDD VSS sg13g2_decap_8
XFILLER_171_1100 VDD VSS sg13g2_decap_8
X_11247_ _11247_/X _13293_/D _07690_/X _11245_/Y VDD VSS sg13g2_a21o_1
XFILLER_171_1133 VDD VSS sg13g2_decap_4
XFILLER_84_1185 VDD VSS sg13g2_decap_8
XFILLER_110_902 VDD VSS sg13g2_fill_2
XFILLER_164_81 VDD VSS sg13g2_decap_8
XFILLER_136_1264 VDD VSS sg13g2_fill_1
XFILLER_171_1144 VDD VSS sg13g2_fill_2
XFILLER_84_1196 VDD VSS sg13g2_fill_1
XFILLER_122_784 VDD VSS sg13g2_fill_1
X_11178_ _11186_/B _11177_/B _11177_/C _11197_/A VDD VSS sg13g2_o21ai_1
XFILLER_171_1166 VDD VSS sg13g2_decap_8
XFILLER_79_175 VDD VSS sg13g2_decap_8
XFILLER_67_315 VDD VSS sg13g2_decap_8
XFILLER_121_272 VDD VSS sg13g2_fill_2
XFILLER_95_635 VDD VSS sg13g2_fill_2
XFILLER_110_946 VDD VSS sg13g2_decap_8
X_10129_ _14707_/D _10162_/A1 _14707_/Q _10134_/S VDD VSS sg13g2_mux2_1
XFILLER_94_123 VDD VSS sg13g2_decap_8
XFILLER_23_1456 VDD VSS sg13g2_decap_8
X_15002__2678 _15002_/RESET_B VDD VSS sg13g2_tiehi
X_14937_ _14937_/Q clkload74/A _14937_/D _14937_/RESET_B VDD VSS sg13g2_dfrbpq_1
XFILLER_94_178 VDD VSS sg13g2_decap_8
XFILLER_76_893 VDD VSS sg13g2_fill_1
XFILLER_63_521 VDD VSS sg13g2_decap_8
XFILLER_36_735 VDD VSS sg13g2_decap_8
XFILLER_180_91 VDD VSS sg13g2_decap_8
X_14868_ _14868_/Q clkload67/A _14868_/D _14868_/RESET_B VDD VSS sg13g2_dfrbpq_1
XFILLER_35_245 VDD VSS sg13g2_decap_8
XFILLER_91_874 VDD VSS sg13g2_decap_8
XFILLER_24_919 VDD VSS sg13g2_decap_8
XFILLER_1_1274 VDD VSS sg13g2_decap_8
X_13819_ _13819_/Q clkload58/A _13819_/D _13819_/RESET_B VDD VSS sg13g2_dfrbpq_1
XFILLER_63_598 VDD VSS sg13g2_decap_8
X_14799_ _14799_/Q _14864_/CLK _14799_/D _14799_/RESET_B VDD VSS sg13g2_dfrbpq_1
XFILLER_182_1240 VDD VSS sg13g2_decap_8
XFILLER_44_790 VDD VSS sg13g2_fill_1
XFILLER_56_1265 VDD VSS sg13g2_decap_8
XFILLER_32_974 VDD VSS sg13g2_fill_1
XFILLER_31_462 VDD VSS sg13g2_decap_8
XFILLER_176_434 VDD VSS sg13g2_decap_8
X_09010_ _09010_/Y _09141_/A _10697_/A _09016_/C VDD VSS sg13g2_nand3_1
XFILLER_78_0 VDD VSS sg13g2_decap_8
XFILLER_145_832 VDD VSS sg13g2_fill_2
XFILLER_163_128 VDD VSS sg13g2_decap_4
X_14273__1999 _14273_/RESET_B VDD VSS sg13g2_tiehi
XFILLER_117_567 VDD VSS sg13g2_fill_2
XFILLER_144_353 VDD VSS sg13g2_fill_2
XFILLER_160_802 VDD VSS sg13g2_decap_8
XFILLER_176_1044 VDD VSS sg13g2_decap_8
XFILLER_89_1096 VDD VSS sg13g2_decap_4
XFILLER_171_161 VDD VSS sg13g2_decap_8
XFILLER_132_537 VDD VSS sg13g2_decap_8
X_09912_ _14497_/D _14497_/Q _09912_/A1 _09936_/S VDD VSS sg13g2_mux2_1
XFILLER_28_1312 VDD VSS sg13g2_decap_8
XFILLER_132_559 VDD VSS sg13g2_decap_8
XFILLER_160_868 VDD VSS sg13g2_decap_8
Xfanout604 _08801_/B _13482_/B VDD VSS sg13g2_buf_1
XFILLER_67_1383 VDD VSS sg13g2_fill_1
Xfanout615 _08381_/A _08004_/Y VDD VSS sg13g2_buf_1
XFILLER_101_902 VDD VSS sg13g2_fill_1
Xfanout626 _12842_/A _13564_/A2 VDD VSS sg13g2_buf_1
XFILLER_8_1428 VDD VSS sg13g2_decap_8
XFILLER_101_924 VDD VSS sg13g2_decap_8
Xfanout637 _11433_/B _11288_/Y VDD VSS sg13g2_buf_1
X_09843_ _14430_/D _14430_/Q _10041_/A0 _09859_/S VDD VSS sg13g2_mux2_1
XFILLER_86_613 VDD VSS sg13g2_fill_2
XFILLER_100_401 VDD VSS sg13g2_fill_1
XFILLER_154_1375 VDD VSS sg13g2_decap_4
Xfanout648 _10453_/C _10521_/C VDD VSS sg13g2_buf_1
XFILLER_98_484 VDD VSS sg13g2_decap_8
XFILLER_113_795 VDD VSS sg13g2_decap_8
Xfanout659 _10716_/A _10675_/A VDD VSS sg13g2_buf_1
XFILLER_63_1269 VDD VSS sg13g2_fill_2
XFILLER_59_849 VDD VSS sg13g2_decap_8
XFILLER_100_445 VDD VSS sg13g2_decap_8
X_09774_ _14363_/D _09906_/A1 _14363_/Q _09805_/S VDD VSS sg13g2_mux2_1
XFILLER_6_1141 VDD VSS sg13g2_decap_8
XFILLER_86_679 VDD VSS sg13g2_decap_4
XFILLER_100_467 VDD VSS sg13g2_decap_4
XFILLER_39_551 VDD VSS sg13g2_decap_8
XFILLER_113_1050 VDD VSS sg13g2_fill_1
XFILLER_37_49 VDD VSS sg13g2_decap_8
XFILLER_27_702 VDD VSS sg13g2_fill_2
XFILLER_160_28 VDD VSS sg13g2_decap_8
X_08725_ _13482_/A _15129_/Q _15124_/Q _15071_/Q VDD VSS sg13g2_or3_1
XFILLER_100_489 VDD VSS sg13g2_decap_8
XFILLER_27_735 VDD VSS sg13g2_decap_8
XFILLER_94_690 VDD VSS sg13g2_fill_1
XFILLER_82_830 VDD VSS sg13g2_decap_8
XFILLER_66_381 VDD VSS sg13g2_fill_2
XFILLER_26_212 VDD VSS sg13g2_decap_8
X_08656_ _08656_/X _08669_/B1 _08619_/Y _08402_/C VDD VSS sg13g2_a21o_1
XFILLER_54_554 VDD VSS sg13g2_fill_1
XFILLER_26_245 VDD VSS sg13g2_fill_2
XFILLER_54_565 VDD VSS sg13g2_fill_1
XFILLER_42_727 VDD VSS sg13g2_decap_8
XFILLER_39_1430 VDD VSS sg13g2_decap_8
XFILLER_26_278 VDD VSS sg13g2_fill_2
XFILLER_183_1048 VDD VSS sg13g2_fill_1
X_08587_ _08587_/Y _08586_/B _08586_/C _08641_/C VDD VSS sg13g2_a21oi_1
XFILLER_54_598 VDD VSS sg13g2_decap_8
XFILLER_156_7 VDD VSS sg13g2_decap_8
XFILLER_53_37 VDD VSS sg13g2_fill_1
XFILLER_41_226 VDD VSS sg13g2_decap_8
XFILLER_126_1422 VDD VSS sg13g2_decap_8
XFILLER_35_1305 VDD VSS sg13g2_fill_2
XFILLER_35_1316 VDD VSS sg13g2_fill_1
XFILLER_167_401 VDD VSS sg13g2_decap_8
XFILLER_70_1207 VDD VSS sg13g2_decap_8
XFILLER_10_602 VDD VSS sg13g2_decap_8
XFILLER_179_294 VDD VSS sg13g2_decap_8
XFILLER_167_445 VDD VSS sg13g2_fill_1
XFILLER_161_1368 VDD VSS sg13g2_decap_8
X_09208_ _10070_/C _09905_/A _10105_/C VDD VSS sg13g2_nor2_1
X_10480_ _10482_/A _10489_/C _10489_/D _10626_/B VDD VSS sg13g2_o21ai_1
XFILLER_120_1010 VDD VSS sg13g2_decap_4
XFILLER_185_14 VDD VSS sg13g2_decap_8
XFILLER_10_679 VDD VSS sg13g2_decap_8
XFILLER_5_105 VDD VSS sg13g2_decap_8
XFILLER_33_1084 VDD VSS sg13g2_decap_8
XFILLER_182_448 VDD VSS sg13g2_decap_8
X_09139_ _13782_/D _13782_/Q _10165_/A1 _09153_/S VDD VSS sg13g2_mux2_1
XFILLER_136_854 VDD VSS sg13g2_decap_8
XFILLER_135_342 VDD VSS sg13g2_fill_2
Xclkbuf_5_14__f_clk_i clkbuf_leaf_47_clk_i/A clkbuf_4_7_0_clk_i/X VDD VSS sg13g2_buf_16
XFILLER_163_662 VDD VSS sg13g2_decap_4
XFILLER_123_504 VDD VSS sg13g2_decap_8
X_12150_ _12150_/Y _12152_/A _12227_/B VDD VSS sg13g2_nor2_1
XFILLER_2_812 VDD VSS sg13g2_decap_8
XFILLER_68_1169 VDD VSS sg13g2_decap_8
XFILLER_11_1393 VDD VSS sg13g2_decap_8
XFILLER_135_397 VDD VSS sg13g2_decap_8
XFILLER_151_846 VDD VSS sg13g2_decap_8
X_11101_ _14948_/D _11100_/Y _11099_/Y _11084_/Y VDD VSS sg13g2_o21ai_1
XFILLER_150_334 VDD VSS sg13g2_decap_8
XFILLER_1_322 VDD VSS sg13g2_decap_8
X_12081_ _14981_/D _12061_/A _12126_/A _12080_/Y VDD VSS sg13g2_a21o_1
XFILLER_81_1314 VDD VSS sg13g2_fill_2
XFILLER_81_1325 VDD VSS sg13g2_decap_8
X_11032_ _11032_/Y _11052_/B _14760_/Q VDD VSS sg13g2_nor2b_1
XFILLER_103_250 VDD VSS sg13g2_decap_8
XFILLER_2_889 VDD VSS sg13g2_decap_8
XFILLER_104_784 VDD VSS sg13g2_decap_8
XFILLER_172_1464 VDD VSS sg13g2_decap_8
X_14904__2829 _14904_/RESET_B VDD VSS sg13g2_tiehi
XFILLER_1_399 VDD VSS sg13g2_decap_8
XFILLER_49_337 VDD VSS sg13g2_decap_4
XFILLER_77_668 VDD VSS sg13g2_fill_2
X_14801__3005 _14801_/RESET_B VDD VSS sg13g2_tiehi
XFILLER_76_156 VDD VSS sg13g2_decap_8
XFILLER_44_1180 VDD VSS sg13g2_decap_8
XFILLER_182_0 VDD VSS sg13g2_decap_8
XFILLER_92_627 VDD VSS sg13g2_decap_8
XFILLER_40_1033 VDD VSS sg13g2_decap_8
XFILLER_131_1172 VDD VSS sg13g2_decap_8
X_12983_ _12984_/B _12983_/A1 _12982_/Y _12975_/X _12878_/D _12979_/Y VDD VSS sg13g2_a221oi_1
X_14048__2224 _14048_/RESET_B VDD VSS sg13g2_tiehi
XFILLER_45_521 VDD VSS sg13g2_fill_2
XFILLER_131_1183 VDD VSS sg13g2_fill_2
XFILLER_94_88 VDD VSS sg13g2_decap_8
XFILLER_166_1202 VDD VSS sg13g2_fill_1
X_14722_ _14722_/Q clkload44/A _14722_/D _14722_/RESET_B VDD VSS sg13g2_dfrbpq_1
XFILLER_40_1077 VDD VSS sg13g2_decap_8
XFILLER_18_768 VDD VSS sg13g2_decap_8
X_11934_ _11934_/Y _11936_/A _12082_/B VDD VSS sg13g2_nor2_1
XFILLER_17_245 VDD VSS sg13g2_decap_8
XFILLER_45_554 VDD VSS sg13g2_decap_8
XFILLER_75_1118 VDD VSS sg13g2_fill_2
XFILLER_60_502 VDD VSS sg13g2_decap_4
X_14653_ _14653_/Q clkload59/A _14653_/D _14653_/RESET_B VDD VSS sg13g2_dfrbpq_1
XFILLER_92_1410 VDD VSS sg13g2_decap_8
XFILLER_150_94 VDD VSS sg13g2_decap_8
X_11865_ _11910_/C _11865_/A _13674_/Q VDD VSS sg13g2_xnor2_1
XFILLER_72_384 VDD VSS sg13g2_decap_4
XFILLER_60_524 VDD VSS sg13g2_fill_2
X_13604_ _15165_/D _13603_/Y _08834_/B _13599_/Y VDD VSS sg13g2_a21oi_1
XFILLER_14_952 VDD VSS sg13g2_decap_8
X_10816_ _10816_/Y _10823_/B _10851_/A _07751_/B VDD VSS sg13g2_o21ai_1
X_14584_ _14584_/Q _14982_/CLK _14584_/D _14584_/RESET_B VDD VSS sg13g2_dfrbpq_1
X_11796_ _11839_/A _11798_/A _12082_/B VDD VSS sg13g2_nor2_1
XFILLER_41_760 VDD VSS sg13g2_fill_2
XFILLER_158_423 VDD VSS sg13g2_decap_8
XFILLER_186_732 VDD VSS sg13g2_decap_4
XFILLER_13_462 VDD VSS sg13g2_decap_8
X_13535_ _13535_/Y _13535_/A _13535_/B VDD VSS sg13g2_nor2_1
XFILLER_185_231 VDD VSS sg13g2_decap_8
X_10747_ _10747_/Y _10747_/A _10747_/B VDD VSS sg13g2_nor2_1
XFILLER_140_1419 VDD VSS sg13g2_decap_8
XFILLER_159_70 VDD VSS sg13g2_fill_1
XFILLER_9_455 VDD VSS sg13g2_decap_8
XFILLER_71_7 VDD VSS sg13g2_decap_8
XFILLER_127_810 VDD VSS sg13g2_decap_8
XFILLER_159_92 VDD VSS sg13g2_decap_8
XFILLER_173_415 VDD VSS sg13g2_decap_8
X_13466_ _15108_/D _13459_/Y _13463_/X _13465_/Y VDD VSS sg13g2_o21ai_1
X_10678_ _14896_/D _07705_/B _10813_/A _10674_/Y VDD VSS sg13g2_o21ai_1
XFILLER_12_1113 VDD VSS sg13g2_decap_8
XFILLER_145_117 VDD VSS sg13g2_decap_4
XFILLER_16_1293 VDD VSS sg13g2_decap_8
X_15205_ _15205_/Q clkload91/A _15205_/D _15205_/RESET_B VDD VSS sg13g2_dfrbpq_1
XFILLER_51_1184 VDD VSS sg13g2_decap_8
X_12417_ _14993_/D _12415_/Y _12416_/Y _12403_/Y VDD VSS sg13g2_a21oi_1
XFILLER_154_640 VDD VSS sg13g2_fill_1
XFILLER_177_1320 VDD VSS sg13g2_decap_8
X_13397_ _15086_/D _15086_/Q _13470_/A2 _13396_/Y VDD VSS sg13g2_a21o_1
XFILLER_86_1214 VDD VSS sg13g2_decap_8
XFILLER_86_1225 VDD VSS sg13g2_fill_1
XFILLER_154_662 VDD VSS sg13g2_decap_8
X_15136_ _15136_/Q clkload77/A _15136_/D _15136_/RESET_B VDD VSS sg13g2_dfrbpq_1
X_12348_ _12348_/Y _12348_/A _15217_/Q _15126_/Q _12348_/D VDD VSS sg13g2_nor4_1
XFILLER_126_386 VDD VSS sg13g2_fill_1
XFILLER_142_835 VDD VSS sg13g2_decap_8
XFILLER_153_161 VDD VSS sg13g2_fill_2
XFILLER_177_1375 VDD VSS sg13g2_decap_8
XFILLER_5_672 VDD VSS sg13g2_decap_8
XFILLER_175_91 VDD VSS sg13g2_decap_8
XFILLER_114_559 VDD VSS sg13g2_decap_8
X_15067_ _15067_/Q _15113_/CLK _15067_/D _15067_/RESET_B VDD VSS sg13g2_dfrbpq_1
X_12279_ _12280_/B _12277_/X _12279_/B VDD VSS sg13g2_nand2b_1
XFILLER_4_42 VDD VSS sg13g2_decap_8
XFILLER_4_182 VDD VSS sg13g2_decap_8
X_14018_ _14018_/Q clkload45/A _14018_/D _14018_/RESET_B VDD VSS sg13g2_dfrbpq_1
XFILLER_150_890 VDD VSS sg13g2_decap_8
XFILLER_96_977 VDD VSS sg13g2_fill_2
XFILLER_97_1310 VDD VSS sg13g2_decap_8
XFILLER_95_487 VDD VSS sg13g2_decap_8
XFILLER_23_1253 VDD VSS sg13g2_decap_8
XFILLER_48_370 VDD VSS sg13g2_decap_8
XFILLER_110_1223 VDD VSS sg13g2_decap_8
X_08510_ _08510_/X _14978_/Q _08510_/A1 _08510_/A2 _08510_/A3 _08009_/S _07627_/A
+ VDD VSS sg13g2_mux4_1
XFILLER_76_690 VDD VSS sg13g2_decap_8
XFILLER_97_1343 VDD VSS sg13g2_decap_4
XFILLER_3_1358 VDD VSS sg13g2_decap_8
XFILLER_36_532 VDD VSS sg13g2_decap_8
X_09490_ _14090_/D _10086_/A0 _14090_/Q _09493_/S VDD VSS sg13g2_mux2_1
XFILLER_97_1365 VDD VSS sg13g2_decap_8
XFILLER_64_874 VDD VSS sg13g2_decap_8
XFILLER_93_1218 VDD VSS sg13g2_decap_8
X_08441_ _15235_/D _08441_/A _08441_/B _08441_/C _08441_/D VDD VSS sg13g2_nand4_1
XFILLER_97_1398 VDD VSS sg13g2_decap_8
XFILLER_1_1071 VDD VSS sg13g2_decap_8
XFILLER_63_384 VDD VSS sg13g2_decap_8
XFILLER_184_1368 VDD VSS sg13g2_decap_8
XFILLER_184_1379 VDD VSS sg13g2_fill_1
X_08372_ _08372_/Y _07795_/A _08370_/Y _08371_/Y VDD VSS sg13g2_a21oi_1
XFILLER_177_721 VDD VSS sg13g2_decap_8
XFILLER_143_1021 VDD VSS sg13g2_decap_8
Xclkbuf_4_15_0_clk_i clkbuf_4_15_0_clk_i/X clkbuf_0_clk_i/X VDD VSS sg13g2_buf_8
XFILLER_32_760 VDD VSS sg13g2_decap_8
XFILLER_182_1081 VDD VSS sg13g2_decap_8
XFILLER_176_231 VDD VSS sg13g2_decap_8
XFILLER_20_933 VDD VSS sg13g2_fill_1
XFILLER_165_916 VDD VSS sg13g2_fill_1
XFILLER_17_1068 VDD VSS sg13g2_decap_8
X_13746__2526 _13746_/RESET_B VDD VSS sg13g2_tiehi
XFILLER_165_927 VDD VSS sg13g2_fill_2
XFILLER_177_787 VDD VSS sg13g2_decap_8
XFILLER_137_629 VDD VSS sg13g2_decap_8
XFILLER_178_1106 VDD VSS sg13g2_fill_2
XFILLER_34_1393 VDD VSS sg13g2_decap_8
XFILLER_121_1363 VDD VSS sg13g2_decap_8
XFILLER_180_919 VDD VSS sg13g2_decap_8
XFILLER_173_960 VDD VSS sg13g2_decap_8
XFILLER_3_609 VDD VSS sg13g2_decap_8
XFILLER_155_28 VDD VSS sg13g2_decap_8
XFILLER_173_993 VDD VSS sg13g2_decap_8
XFILLER_133_835 VDD VSS sg13g2_decap_8
XFILLER_144_161 VDD VSS sg13g2_fill_1
XFILLER_117_386 VDD VSS sg13g2_decap_8
XFILLER_2_119 VDD VSS sg13g2_decap_8
XFILLER_144_183 VDD VSS sg13g2_decap_8
XFILLER_156_1437 VDD VSS sg13g2_fill_1
X_13961__2311 _13961_/RESET_B VDD VSS sg13g2_tiehi
X_14126__2146 _14126_/RESET_B VDD VSS sg13g2_tiehi
XFILLER_132_345 VDD VSS sg13g2_decap_4
XFILLER_63_1000 VDD VSS sg13g2_decap_8
Xfanout401 _09303_/S fanout402/X VDD VSS sg13g2_buf_1
XFILLER_67_1180 VDD VSS sg13g2_decap_8
Xfanout412 _09200_/S _09196_/S VDD VSS sg13g2_buf_1
XFILLER_87_911 VDD VSS sg13g2_decap_8
XFILLER_115_1101 VDD VSS sg13g2_decap_4
Xfanout423 _09913_/A1 _09946_/A1 VDD VSS sg13g2_buf_1
XFILLER_8_1225 VDD VSS sg13g2_decap_8
XFILLER_59_613 VDD VSS sg13g2_decap_8
Xfanout434 _09941_/A1 fanout438/X VDD VSS sg13g2_buf_1
Xfanout445 _09167_/S _08965_/Y VDD VSS sg13g2_buf_1
XFILLER_86_421 VDD VSS sg13g2_fill_1
Xfanout456 _11015_/C _10722_/Y VDD VSS sg13g2_buf_1
XFILLER_58_123 VDD VSS sg13g2_fill_1
XFILLER_28_1186 VDD VSS sg13g2_decap_8
Xfanout467 _10035_/S fanout467/A VDD VSS sg13g2_buf_1
X_09826_ _14414_/D _09925_/A1 _14414_/Q _09826_/S VDD VSS sg13g2_mux2_1
XFILLER_63_1077 VDD VSS sg13g2_decap_8
XFILLER_58_134 VDD VSS sg13g2_decap_8
Xfanout478 _09838_/S _09826_/S VDD VSS sg13g2_buf_1
XFILLER_171_49 VDD VSS sg13g2_decap_8
Xfanout489 _09673_/S _09661_/S VDD VSS sg13g2_buf_1
XFILLER_104_21 VDD VSS sg13g2_decap_8
XFILLER_111_1009 VDD VSS sg13g2_fill_1
XFILLER_80_1380 VDD VSS sg13g2_decap_8
XFILLER_132_1470 VDD VSS sg13g2_decap_4
X_09757_ _14347_/D _14347_/Q _09922_/A1 _09764_/S VDD VSS sg13g2_mux2_1
X_13994__2278 _13994_/RESET_B VDD VSS sg13g2_tiehi
XFILLER_64_14 VDD VSS sg13g2_decap_8
X_08708_ _13659_/D _15186_/D _15117_/Q _13652_/S VDD VSS sg13g2_mux2_1
XFILLER_55_863 VDD VSS sg13g2_decap_8
XFILLER_27_554 VDD VSS sg13g2_decap_8
XFILLER_104_98 VDD VSS sg13g2_decap_8
X_09688_ _14280_/D _10151_/A1 _14280_/Q _09704_/S VDD VSS sg13g2_mux2_1
XFILLER_64_58 VDD VSS sg13g2_fill_1
XFILLER_27_565 VDD VSS sg13g2_fill_1
XFILLER_70_822 VDD VSS sg13g2_decap_8
X_08639_ _08640_/B _08678_/B _08674_/B1 _08037_/C _08650_/A VDD VSS sg13g2_a22oi_1
XFILLER_15_749 VDD VSS sg13g2_decap_8
XFILLER_54_384 VDD VSS sg13g2_decap_8
X_11650_ _11650_/X _14119_/Q _14151_/Q _14183_/Q _14215_/Q _11528_/S _11532_/C VDD
+ VSS sg13g2_mux4_1
XFILLER_120_53 VDD VSS sg13g2_fill_1
XFILLER_14_259 VDD VSS sg13g2_decap_8
XFILLER_168_710 VDD VSS sg13g2_fill_1
XFILLER_23_760 VDD VSS sg13g2_decap_4
XFILLER_165_1290 VDD VSS sg13g2_decap_8
XFILLER_120_86 VDD VSS sg13g2_decap_4
X_10601_ _10602_/C _14877_/Q _14876_/Q _14875_/Q _10607_/C VDD VSS sg13g2_and4_1
XFILLER_161_1143 VDD VSS sg13g2_decap_8
X_11581_ _11582_/B _11573_/X _11574_/X _11577_/X _11578_/X _12029_/B _12048_/A1 VDD
+ VSS sg13g2_mux4_1
XFILLER_74_1195 VDD VSS sg13g2_decap_8
XFILLER_156_905 VDD VSS sg13g2_decap_4
XFILLER_168_776 VDD VSS sg13g2_decap_8
XFILLER_11_966 VDD VSS sg13g2_decap_8
XFILLER_13_1400 VDD VSS sg13g2_decap_8
XFILLER_155_404 VDD VSS sg13g2_decap_8
X_13320_ _13322_/B _13320_/A _15064_/Q _13320_/C VDD VSS sg13g2_nand3_1
X_14336__1936 _14336_/RESET_B VDD VSS sg13g2_tiehi
X_10532_ _14859_/D _10533_/B _10544_/C _10532_/C VDD VSS sg13g2_and3_1
XFILLER_35_1179 VDD VSS sg13g2_decap_8
XFILLER_183_724 VDD VSS sg13g2_fill_1
XFILLER_161_1198 VDD VSS sg13g2_decap_8
XFILLER_10_476 VDD VSS sg13g2_decap_8
XFILLER_13_84 VDD VSS sg13g2_decap_8
XFILLER_155_448 VDD VSS sg13g2_fill_1
XFILLER_7_959 VDD VSS sg13g2_decap_8
X_13251_ _13251_/Y _13251_/A _13251_/B _13251_/C VDD VSS sg13g2_nand3_1
X_10463_ _10463_/Y _10471_/C _10459_/Y _10626_/B VDD VSS sg13g2_o21ai_1
XFILLER_182_245 VDD VSS sg13g2_decap_8
XFILLER_13_1477 VDD VSS sg13g2_fill_2
XFILLER_6_469 VDD VSS sg13g2_decap_8
X_12202_ _12274_/A _12203_/A _13665_/Q VDD VSS sg13g2_nand2_1
XFILLER_136_673 VDD VSS sg13g2_fill_1
XFILLER_159_1050 VDD VSS sg13g2_decap_8
X_13182_ _13182_/Y _13179_/Y _13180_/Y _13181_/Y VDD VSS sg13g2_a21oi_1
XFILLER_124_824 VDD VSS sg13g2_decap_8
X_10394_ _10395_/C _14820_/Q _14821_/Q _14822_/Q VDD VSS sg13g2_nand3_1
XFILLER_89_77 VDD VSS sg13g2_fill_2
XFILLER_11_1190 VDD VSS sg13g2_decap_8
X_12133_ _12133_/X _14581_/Q _14613_/Q _14645_/Q _14677_/Q _12140_/S0 _12140_/S1 VDD
+ VSS sg13g2_mux4_1
X_14551__1721 _14551_/RESET_B VDD VSS sg13g2_tiehi
XFILLER_8_0 VDD VSS sg13g2_decap_8
XFILLER_111_507 VDD VSS sg13g2_decap_8
XFILLER_150_153 VDD VSS sg13g2_decap_8
XFILLER_78_911 VDD VSS sg13g2_fill_2
X_12064_ _12065_/B _12062_/A _12062_/B _12197_/A VDD VSS sg13g2_a21o_1
XFILLER_85_1291 VDD VSS sg13g2_decap_8
XFILLER_137_1370 VDD VSS sg13g2_fill_1
XFILLER_172_1250 VDD VSS sg13g2_decap_8
XFILLER_78_933 VDD VSS sg13g2_fill_2
XFILLER_46_1253 VDD VSS sg13g2_decap_8
XFILLER_2_686 VDD VSS sg13g2_decap_8
XFILLER_78_944 VDD VSS sg13g2_decap_8
X_11015_ _11052_/D _11015_/A _11042_/B _11015_/C _11042_/D VDD VSS sg13g2_nand4_1
XFILLER_1_196 VDD VSS sg13g2_decap_8
X_16872_ _16872_/X _16872_/A VDD VSS sg13g2_buf_1
XFILLER_81_1199 VDD VSS sg13g2_decap_8
Xfanout990 _10647_/A _13304_/B VDD VSS sg13g2_buf_1
XFILLER_64_104 VDD VSS sg13g2_decap_4
XFILLER_65_638 VDD VSS sg13g2_decap_4
XFILLER_38_70 VDD VSS sg13g2_decap_8
X_13824__2448 _13824_/RESET_B VDD VSS sg13g2_tiehi
XFILLER_18_532 VDD VSS sg13g2_decap_8
X_14584__1688 _14584_/RESET_B VDD VSS sg13g2_tiehi
XFILLER_92_446 VDD VSS sg13g2_decap_8
XFILLER_20_1448 VDD VSS sg13g2_decap_8
X_12966_ _12966_/Y _12963_/Y _12964_/Y _12965_/Y VDD VSS sg13g2_a21oi_1
X_14848__2941 _14848_/RESET_B VDD VSS sg13g2_tiehi
XFILLER_73_660 VDD VSS sg13g2_decap_8
XFILLER_166_1021 VDD VSS sg13g2_decap_8
X_14705_ _14705_/Q clkload8/A _14705_/D _14705_/RESET_B VDD VSS sg13g2_dfrbpq_1
X_11917_ _11917_/Y _11917_/A _12055_/A VDD VSS sg13g2_xnor2_1
XFILLER_45_384 VDD VSS sg13g2_fill_1
X_12897_ _12897_/Y _14773_/Q _12918_/A2 _13275_/B1 VDD VSS sg13g2_o21ai_1
XFILLER_61_844 VDD VSS sg13g2_fill_1
XFILLER_178_518 VDD VSS sg13g2_decap_8
XFILLER_61_866 VDD VSS sg13g2_decap_8
XFILLER_166_1087 VDD VSS sg13g2_decap_4
XFILLER_18_1311 VDD VSS sg13g2_decap_8
X_14636_ _14636_/Q clkload26/A _14636_/D _14636_/RESET_B VDD VSS sg13g2_dfrbpq_1
X_11848_ _11848_/X _13741_/Q _14093_/Q _14445_/Q _14541_/Q _11850_/S0 _07654_/A VDD
+ VSS sg13g2_mux4_1
X_14204__2068 _14204_/RESET_B VDD VSS sg13g2_tiehi
XFILLER_105_1314 VDD VSS sg13g2_decap_8
X_14567_ _14567_/Q _14727_/CLK _14567_/D _14567_/RESET_B VDD VSS sg13g2_dfrbpq_1
XFILLER_158_242 VDD VSS sg13g2_fill_1
X_11779_ _11779_/Y _11910_/A _11912_/A VDD VSS sg13g2_nor2_1
XFILLER_119_618 VDD VSS sg13g2_decap_8
XFILLER_144_1385 VDD VSS sg13g2_decap_8
XFILLER_159_787 VDD VSS sg13g2_fill_1
XFILLER_18_1388 VDD VSS sg13g2_decap_8
X_13518_ _13518_/Y _13518_/A1 _13533_/B _08263_/B _13546_/B2 VDD VSS sg13g2_a22oi_1
XFILLER_9_252 VDD VSS sg13g2_decap_8
XFILLER_53_1279 VDD VSS sg13g2_fill_1
XFILLER_146_426 VDD VSS sg13g2_fill_1
XFILLER_147_949 VDD VSS sg13g2_fill_1
XFILLER_174_735 VDD VSS sg13g2_decap_8
X_14498_ _14498_/Q clkload40/A _14498_/D _14498_/RESET_B VDD VSS sg13g2_dfrbpq_1
XFILLER_146_437 VDD VSS sg13g2_decap_8
XFILLER_16_1090 VDD VSS sg13g2_decap_8
Xclkload11 clkload11/X clkload11/A VDD VSS sg13g2_buf_8
XFILLER_173_245 VDD VSS sg13g2_decap_8
X_13449_ _13449_/X _15196_/Q _13449_/B VDD VSS sg13g2_or2_1
Xclkload22 clkload22/Y clkload22/A VDD VSS sg13g2_inv_1
Xclkload33 clkload33/Y clkload33/A VDD VSS sg13g2_inv_2
XFILLER_161_407 VDD VSS sg13g2_decap_8
XFILLER_186_90 VDD VSS sg13g2_fill_1
Xclkload44 clkload44/Y clkload44/A VDD VSS sg13g2_inv_1
Xclkload55 clkload55/Y clkload55/A VDD VSS sg13g2_inv_1
XFILLER_155_982 VDD VSS sg13g2_decap_8
Xmax_cap1285 _16873_/A _13711_/Q VDD VSS sg13g2_buf_4
XFILLER_86_1022 VDD VSS sg13g2_decap_8
XFILLER_115_824 VDD VSS sg13g2_decap_8
Xclkload66 clkload66/X clkload66/A VDD VSS sg13g2_buf_8
Xmax_cap1296 output68/A _16862_/A VDD VSS sg13g2_buf_4
XFILLER_138_1112 VDD VSS sg13g2_decap_8
Xclkload77 clkload77/Y clkload77/A VDD VSS sg13g2_inv_1
XFILLER_86_1044 VDD VSS sg13g2_decap_8
Xclkload88 clkload88/Y clkload88/A VDD VSS sg13g2_inv_1
XFILLER_142_632 VDD VSS sg13g2_decap_4
XFILLER_173_1014 VDD VSS sg13g2_fill_2
X_15119_ _15119_/Q _15200_/CLK _15119_/D _15119_/RESET_B VDD VSS sg13g2_dfrbpq_1
XFILLER_177_1194 VDD VSS sg13g2_decap_8
XFILLER_114_356 VDD VSS sg13g2_decap_4
XFILLER_115_879 VDD VSS sg13g2_fill_1
X_08990_ _13759_/D _13759_/Q _10142_/A1 _09127_/S VDD VSS sg13g2_mux2_1
XFILLER_29_1451 VDD VSS sg13g2_decap_8
XFILLER_141_164 VDD VSS sg13g2_decap_4
XFILLER_116_1410 VDD VSS sg13g2_decap_8
XFILLER_142_698 VDD VSS sg13g2_decap_8
XFILLER_173_1069 VDD VSS sg13g2_decap_4
X_07941_ _07942_/A _07796_/Y _07940_/Y _07938_/Y VDD VSS sg13g2_a21o_1
XFILLER_130_849 VDD VSS sg13g2_decap_4
XFILLER_123_890 VDD VSS sg13g2_decap_8
XFILLER_151_1312 VDD VSS sg13g2_decap_4
XFILLER_68_421 VDD VSS sg13g2_decap_8
XFILLER_25_1315 VDD VSS sg13g2_decap_8
XFILLER_60_1217 VDD VSS sg13g2_fill_1
X_07872_ _07876_/A _07909_/B _07910_/A VDD VSS sg13g2_nand2_1
XFILLER_116_1465 VDD VSS sg13g2_fill_2
XFILLER_84_903 VDD VSS sg13g2_fill_1
XFILLER_64_1397 VDD VSS sg13g2_decap_8
XFILLER_151_1356 VDD VSS sg13g2_decap_8
XFILLER_96_774 VDD VSS sg13g2_decap_8
X_09611_ _14207_/D _10075_/A0 _14207_/Q _09638_/S VDD VSS sg13g2_mux2_1
XFILLER_84_958 VDD VSS sg13g2_fill_2
XFILLER_83_446 VDD VSS sg13g2_decap_8
X_14414__1858 _14414_/RESET_B VDD VSS sg13g2_tiehi
XFILLER_110_1031 VDD VSS sg13g2_fill_2
X_09542_ _14140_/D _10072_/A0 _14140_/Q _09570_/S VDD VSS sg13g2_mux2_1
XFILLER_3_1155 VDD VSS sg13g2_decap_8
XFILLER_36_340 VDD VSS sg13g2_decap_8
XFILLER_97_1162 VDD VSS sg13g2_decap_8
XFILLER_24_513 VDD VSS sg13g2_decap_8
X_09473_ _14074_/D _09638_/A0 _14074_/Q _09473_/S VDD VSS sg13g2_mux2_1
XFILLER_93_1037 VDD VSS sg13g2_decap_8
XFILLER_63_170 VDD VSS sg13g2_decap_8
XFILLER_52_844 VDD VSS sg13g2_decap_8
XFILLER_34_28 VDD VSS sg13g2_decap_8
XFILLER_145_1116 VDD VSS sg13g2_decap_8
XFILLER_169_518 VDD VSS sg13g2_decap_8
XFILLER_19_1119 VDD VSS sg13g2_decap_8
X_08424_ _15234_/D _08039_/A _08423_/X _08410_/X VDD VSS sg13g2_o21ai_1
XFILLER_36_1400 VDD VSS sg13g2_fill_2
XFILLER_169_529 VDD VSS sg13g2_decap_8
XFILLER_75_1471 VDD VSS sg13g2_fill_1
X_08355_ _15231_/D _08395_/A _08354_/Y _08347_/Y VDD VSS sg13g2_o21ai_1
XFILLER_162_1463 VDD VSS sg13g2_decap_8
XFILLER_149_242 VDD VSS sg13g2_decap_8
XFILLER_162_1474 VDD VSS sg13g2_fill_1
XFILLER_32_590 VDD VSS sg13g2_fill_1
XFILLER_71_1368 VDD VSS sg13g2_decap_8
Xclkload5 clkload5/X clkload5/A VDD VSS sg13g2_buf_8
XFILLER_137_415 VDD VSS sg13g2_fill_1
XFILLER_20_763 VDD VSS sg13g2_decap_8
X_08286_ _08286_/Y _08286_/A _08286_/B _08286_/C VDD VSS sg13g2_nor3_1
XFILLER_149_286 VDD VSS sg13g2_decap_8
XFILLER_177_595 VDD VSS sg13g2_decap_8
XFILLER_109_128 VDD VSS sg13g2_decap_8
XFILLER_165_779 VDD VSS sg13g2_decap_8
XFILLER_119_7 VDD VSS sg13g2_decap_4
XFILLER_121_1160 VDD VSS sg13g2_fill_2
XFILLER_166_49 VDD VSS sg13g2_decap_8
XFILLER_69_1231 VDD VSS sg13g2_decap_8
XFILLER_124_109 VDD VSS sg13g2_decap_8
XFILLER_3_406 VDD VSS sg13g2_decap_8
XFILLER_118_684 VDD VSS sg13g2_decap_8
XFILLER_121_1193 VDD VSS sg13g2_decap_8
XFILLER_133_610 VDD VSS sg13g2_fill_1
XFILLER_145_481 VDD VSS sg13g2_decap_8
XFILLER_105_323 VDD VSS sg13g2_decap_8
XFILLER_59_14 VDD VSS sg13g2_decap_8
XFILLER_1_7 VDD VSS sg13g2_decap_8
XFILLER_69_1297 VDD VSS sg13g2_decap_8
XFILLER_161_974 VDD VSS sg13g2_fill_2
XFILLER_121_816 VDD VSS sg13g2_decap_4
XFILLER_132_153 VDD VSS sg13g2_decap_8
XFILLER_133_698 VDD VSS sg13g2_fill_1
XFILLER_59_69 VDD VSS sg13g2_decap_8
Xfanout1207 _08879_/A1 _14969_/Q VDD VSS sg13g2_buf_1
Xfanout1218 _07929_/B _08863_/A1 VDD VSS sg13g2_buf_1
XFILLER_8_1022 VDD VSS sg13g2_decap_8
XFILLER_115_20 VDD VSS sg13g2_decap_8
Xfanout1229 _08142_/C _14960_/Q VDD VSS sg13g2_buf_1
Xfanout242 _09621_/A0 wire243/X VDD VSS sg13g2_buf_1
Xfanout253 _11501_/A2 _12195_/B1 VDD VSS sg13g2_buf_1
Xfanout264 _09619_/A0 _10117_/A0 VDD VSS sg13g2_buf_1
XFILLER_47_605 VDD VSS sg13g2_decap_4
XFILLER_43_1459 VDD VSS sg13g2_decap_8
XFILLER_130_1418 VDD VSS sg13g2_decap_8
Xfanout286 _09904_/S wire288/X VDD VSS sg13g2_buf_1
XFILLER_87_785 VDD VSS sg13g2_decap_8
X_15199__2834 _15199_/RESET_B VDD VSS sg13g2_tiehi
Xfanout297 _09438_/S _09437_/S VDD VSS sg13g2_buf_1
X_09809_ _14397_/D _09908_/A1 _14397_/Q _09838_/S VDD VSS sg13g2_mux2_1
XFILLER_8_1099 VDD VSS sg13g2_decap_8
XFILLER_75_35 VDD VSS sg13g2_decap_8
XFILLER_74_413 VDD VSS sg13g2_decap_8
XFILLER_59_487 VDD VSS sg13g2_decap_8
XFILLER_19_329 VDD VSS sg13g2_decap_8
X_12820_ _12820_/Y _12817_/Y _12818_/Y _12819_/Y VDD VSS sg13g2_a21oi_1
XFILLER_90_928 VDD VSS sg13g2_decap_4
XFILLER_90_939 VDD VSS sg13g2_decap_8
XFILLER_76_1224 VDD VSS sg13g2_decap_8
XFILLER_55_682 VDD VSS sg13g2_decap_4
XFILLER_27_373 VDD VSS sg13g2_fill_2
X_12751_ _12764_/A _12751_/A1 _12779_/A2 _15018_/Q VDD VSS sg13g2_a21oi_1
XFILLER_128_1325 VDD VSS sg13g2_decap_4
XFILLER_15_546 VDD VSS sg13g2_decap_8
XFILLER_70_641 VDD VSS sg13g2_decap_8
XFILLER_42_332 VDD VSS sg13g2_decap_8
X_11702_ _14970_/D _11702_/A _11702_/B VDD VSS sg13g2_nor2_1
X_12682_ _12682_/X _14579_/Q _14611_/Q _14643_/Q _14675_/Q _12689_/S0 _12689_/S1 VDD
+ VSS sg13g2_mux4_1
XFILLER_145_0 VDD VSS sg13g2_decap_8
X_14421_ _14421_/Q clkload32/A _14421_/D _14421_/RESET_B VDD VSS sg13g2_dfrbpq_1
X_14569__1703 _14569_/RESET_B VDD VSS sg13g2_tiehi
XFILLER_70_696 VDD VSS sg13g2_decap_8
X_11633_ _11663_/A _11635_/A _13681_/Q VDD VSS sg13g2_nand2_1
XFILLER_168_551 VDD VSS sg13g2_fill_2
XFILLER_126_1082 VDD VSS sg13g2_decap_8
X_14352_ _14352_/Q clkload19/A _14352_/D _14352_/RESET_B VDD VSS sg13g2_dfrbpq_1
XFILLER_11_763 VDD VSS sg13g2_decap_8
X_11564_ _11564_/Y _12225_/B2 _11563_/Y _12227_/B VDD VSS sg13g2_o21ai_1
XFILLER_156_735 VDD VSS sg13g2_decap_4
XFILLER_183_532 VDD VSS sg13g2_decap_8
XFILLER_155_234 VDD VSS sg13g2_decap_8
X_13303_ _13306_/B _13303_/A _13304_/B VDD VSS sg13g2_nor2b_1
XFILLER_10_273 VDD VSS sg13g2_decap_8
X_10515_ _10579_/B _10538_/A _10538_/B VDD VSS sg13g2_nor2_1
X_14283_ _14283_/Q clkload11/A _14283_/D _14283_/RESET_B VDD VSS sg13g2_dfrbpq_1
X_11495_ _11495_/Y _11495_/A VDD VSS sg13g2_inv_1
XFILLER_7_756 VDD VSS sg13g2_decap_8
XFILLER_137_960 VDD VSS sg13g2_decap_8
XFILLER_104_1380 VDD VSS sg13g2_decap_8
XFILLER_137_971 VDD VSS sg13g2_fill_1
XFILLER_13_1274 VDD VSS sg13g2_decap_8
X_13234_ _13234_/Y _14859_/Q _13260_/B VDD VSS sg13g2_nand2_1
X_10446_ _10514_/A _10459_/B _10459_/C VDD VSS sg13g2_nor2_1
XFILLER_6_266 VDD VSS sg13g2_decap_8
XFILLER_108_172 VDD VSS sg13g2_decap_8
XFILLER_152_930 VDD VSS sg13g2_decap_4
XFILLER_48_1326 VDD VSS sg13g2_fill_1
XFILLER_100_1277 VDD VSS sg13g2_decap_8
XFILLER_152_952 VDD VSS sg13g2_fill_1
XFILLER_151_440 VDD VSS sg13g2_decap_8
X_13165_ _13165_/Y _13162_/Y _13163_/Y _13164_/Y VDD VSS sg13g2_a21oi_1
X_10377_ _10396_/C _14815_/Q _14816_/Q _14817_/Q VDD VSS sg13g2_and3_1
XFILLER_48_1348 VDD VSS sg13g2_fill_1
XFILLER_124_687 VDD VSS sg13g2_decap_8
XFILLER_3_973 VDD VSS sg13g2_decap_8
X_12116_ _12116_/Y _12092_/Y _12094_/Y _12046_/C VDD VSS sg13g2_a21oi_1
X_13096_ _13096_/Y _14785_/Q _13208_/A2 _13208_/B1 VDD VSS sg13g2_o21ai_1
XFILLER_34_7 VDD VSS sg13g2_decap_8
XFILLER_46_1050 VDD VSS sg13g2_decap_8
XFILLER_2_483 VDD VSS sg13g2_decap_8
XFILLER_111_348 VDD VSS sg13g2_decap_8
X_12047_ _12047_/Y _12027_/Y _12029_/Y _12048_/A1 VDD VSS sg13g2_a21oi_1
XFILLER_78_763 VDD VSS sg13g2_decap_8
XFILLER_49_91 VDD VSS sg13g2_decap_8
XFILLER_172_70 VDD VSS sg13g2_decap_8
XFILLER_1_21 VDD VSS sg13g2_decap_8
X_16855_ _16855_/X _16855_/A VDD VSS sg13g2_buf_1
XFILLER_93_733 VDD VSS sg13g2_decap_4
XFILLER_38_649 VDD VSS sg13g2_decap_8
XFILLER_77_295 VDD VSS sg13g2_decap_8
XFILLER_4_1442 VDD VSS sg13g2_decap_8
XFILLER_37_137 VDD VSS sg13g2_fill_2
XFILLER_93_777 VDD VSS sg13g2_decap_8
XFILLER_81_917 VDD VSS sg13g2_decap_8
XFILLER_65_468 VDD VSS sg13g2_fill_1
XFILLER_111_1351 VDD VSS sg13g2_decap_8
XFILLER_0_1317 VDD VSS sg13g2_decap_8
XFILLER_19_874 VDD VSS sg13g2_decap_4
XFILLER_20_1245 VDD VSS sg13g2_decap_8
X_13998_ _13998_/Q _14222_/CLK _13998_/D _13998_/RESET_B VDD VSS sg13g2_dfrbpq_1
XFILLER_80_405 VDD VSS sg13g2_decap_8
XFILLER_1_98 VDD VSS sg13g2_decap_8
XFILLER_80_416 VDD VSS sg13g2_fill_1
XFILLER_94_1324 VDD VSS sg13g2_decap_8
XFILLER_65_90 VDD VSS sg13g2_decap_8
X_12949_ _12949_/Y _14776_/Q _13236_/A2 _13236_/B1 VDD VSS sg13g2_o21ai_1
XFILLER_94_1335 VDD VSS sg13g2_fill_1
XFILLER_92_298 VDD VSS sg13g2_fill_2
XFILLER_45_181 VDD VSS sg13g2_fill_2
XFILLER_181_1305 VDD VSS sg13g2_decap_8
XFILLER_55_1308 VDD VSS sg13g2_decap_8
XFILLER_178_315 VDD VSS sg13g2_decap_8
XFILLER_61_674 VDD VSS sg13g2_decap_8
XFILLER_21_527 VDD VSS sg13g2_fill_2
X_14619_ _14619_/Q _14652_/CLK _14619_/D _14619_/RESET_B VDD VSS sg13g2_dfrbpq_1
XFILLER_57_1190 VDD VSS sg13g2_fill_1
XFILLER_105_1111 VDD VSS sg13g2_fill_1
XFILLER_159_562 VDD VSS sg13g2_decap_8
XFILLER_144_1171 VDD VSS sg13g2_decap_8
X_08140_ _08140_/Y _08843_/A _08142_/B VDD VSS sg13g2_nand2_1
XFILLER_18_1185 VDD VSS sg13g2_decap_8
XFILLER_146_201 VDD VSS sg13g2_fill_1
XFILLER_147_724 VDD VSS sg13g2_decap_4
XFILLER_105_1144 VDD VSS sg13g2_decap_8
XFILLER_146_212 VDD VSS sg13g2_fill_2
X_15054__2608 _15054_/RESET_B VDD VSS sg13g2_tiehi
XFILLER_53_1087 VDD VSS sg13g2_decap_8
XFILLER_140_1046 VDD VSS sg13g2_decap_8
X_08071_ _08071_/Y _07882_/Y _08001_/A _08238_/B VDD VSS sg13g2_o21ai_1
XFILLER_174_554 VDD VSS sg13g2_decap_8
XFILLER_60_0 VDD VSS sg13g2_decap_8
XFILLER_134_418 VDD VSS sg13g2_decap_8
XFILLER_161_204 VDD VSS sg13g2_decap_8
XFILLER_115_621 VDD VSS sg13g2_decap_8
XFILLER_127_481 VDD VSS sg13g2_decap_8
XFILLER_103_838 VDD VSS sg13g2_decap_8
X_08973_ _13756_/D _13756_/Q _10139_/A1 _09127_/S VDD VSS sg13g2_mux2_1
X_13696__2576 _13696_/RESET_B VDD VSS sg13g2_tiehi
XFILLER_29_28 VDD VSS sg13g2_decap_8
X_07924_ _07926_/B _08203_/A _14995_/Q _07924_/C VDD VSS sg13g2_nor3_1
XFILLER_130_679 VDD VSS sg13g2_decap_8
XFILLER_68_240 VDD VSS sg13g2_decap_8
XFILLER_60_1014 VDD VSS sg13g2_decap_4
XFILLER_151_1142 VDD VSS sg13g2_decap_8
XFILLER_112_1104 VDD VSS sg13g2_fill_1
XFILLER_9_1386 VDD VSS sg13g2_decap_8
XFILLER_111_882 VDD VSS sg13g2_fill_2
XFILLER_151_1164 VDD VSS sg13g2_decap_4
X_14647__1625 _14647_/RESET_B VDD VSS sg13g2_tiehi
XFILLER_5_1239 VDD VSS sg13g2_decap_8
XFILLER_57_947 VDD VSS sg13g2_fill_2
X_07855_ _08641_/B _07855_/A _07855_/B VDD VSS sg13g2_or2_1
XFILLER_96_593 VDD VSS sg13g2_decap_8
XFILLER_99_1246 VDD VSS sg13g2_decap_8
XFILLER_25_1189 VDD VSS sg13g2_decap_8
XFILLER_110_392 VDD VSS sg13g2_decap_8
XFILLER_42_1470 VDD VSS sg13g2_decap_4
XFILLER_83_243 VDD VSS sg13g2_fill_1
XFILLER_56_468 VDD VSS sg13g2_fill_2
X_07786_ _08414_/B _07786_/A _08351_/B VDD VSS sg13g2_and2_1
X_14076__2196 _14076_/RESET_B VDD VSS sg13g2_tiehi
XFILLER_37_671 VDD VSS sg13g2_decap_8
X_09525_ _14124_/D _09558_/A0 _14124_/Q _09539_/S VDD VSS sg13g2_mux2_1
XFILLER_36_192 VDD VSS sg13g2_decap_8
X_09456_ _14057_/D _09621_/A0 _14057_/Q _09462_/S VDD VSS sg13g2_mux2_1
XFILLER_52_674 VDD VSS sg13g2_decap_8
XFILLER_51_151 VDD VSS sg13g2_decap_8
X_15015__2665 _15015_/RESET_B VDD VSS sg13g2_tiehi
X_08407_ _08407_/Y _08599_/B _08327_/X _08406_/X VDD VSS sg13g2_a21oi_1
XFILLER_24_387 VDD VSS sg13g2_decap_8
XFILLER_24_398 VDD VSS sg13g2_fill_2
X_09387_ _13990_/D _09618_/A0 _13990_/Q _09395_/S VDD VSS sg13g2_mux2_1
XFILLER_178_860 VDD VSS sg13g2_decap_8
XFILLER_36_1252 VDD VSS sg13g2_decap_8
XFILLER_178_882 VDD VSS sg13g2_fill_1
XFILLER_137_201 VDD VSS sg13g2_decap_4
XFILLER_178_893 VDD VSS sg13g2_decap_8
X_08338_ _08338_/Y _08253_/X _08338_/B VDD VSS sg13g2_nand2b_1
XFILLER_165_532 VDD VSS sg13g2_decap_8
XFILLER_177_392 VDD VSS sg13g2_decap_8
X_14832__2973 _14832_/RESET_B VDD VSS sg13g2_tiehi
XFILLER_32_1149 VDD VSS sg13g2_fill_2
XFILLER_165_554 VDD VSS sg13g2_decap_8
X_08269_ _15227_/D _08039_/A _08268_/Y _08262_/Y VDD VSS sg13g2_o21ai_1
XFILLER_153_705 VDD VSS sg13g2_decap_8
XFILLER_10_1414 VDD VSS sg13g2_decap_8
X_10300_ _14793_/D _10311_/A _10311_/B _10295_/B _10297_/B _10655_/B VDD VSS sg13g2_a221oi_1
XFILLER_158_1329 VDD VSS sg13g2_fill_2
X_11280_ _11280_/Y _11279_/Y _11278_/Y _12094_/B VDD VSS sg13g2_a21oi_1
XFILLER_3_203 VDD VSS sg13g2_decap_8
XFILLER_146_790 VDD VSS sg13g2_fill_1
XFILLER_180_546 VDD VSS sg13g2_decap_8
X_10231_ _10232_/B _14771_/Q _14772_/Q _10234_/D VDD VSS sg13g2_nand3_1
XFILLER_69_1061 VDD VSS sg13g2_decap_8
XFILLER_105_120 VDD VSS sg13g2_decap_8
XFILLER_10_63 VDD VSS sg13g2_decap_8
XFILLER_105_164 VDD VSS sg13g2_decap_8
XFILLER_156_1064 VDD VSS sg13g2_decap_8
X_10162_ _14739_/D _14739_/Q _10162_/A1 _10167_/S VDD VSS sg13g2_mux2_1
XFILLER_126_63 VDD VSS sg13g2_decap_8
XFILLER_0_932 VDD VSS sg13g2_decap_8
XFILLER_105_186 VDD VSS sg13g2_decap_4
Xfanout1004 _13414_/A _15183_/Q VDD VSS sg13g2_buf_1
XFILLER_121_646 VDD VSS sg13g2_decap_8
Xfanout1015 _12346_/A _15120_/Q VDD VSS sg13g2_buf_1
XFILLER_82_1250 VDD VSS sg13g2_fill_2
X_14286__1986 _14286_/RESET_B VDD VSS sg13g2_tiehi
Xfanout1026 _07728_/B _13273_/B VDD VSS sg13g2_buf_1
XFILLER_120_145 VDD VSS sg13g2_decap_8
X_14970_ _14970_/Q clkload71/A _14970_/D _14970_/RESET_B VDD VSS sg13g2_dfrbpq_1
Xfanout1037 _08369_/B _08391_/A VDD VSS sg13g2_buf_1
X_10093_ _14673_/D _10093_/A0 _14673_/Q _10093_/S VDD VSS sg13g2_mux2_1
XFILLER_47_1392 VDD VSS sg13g2_fill_1
Xfanout1048 _10823_/B _13310_/B2 VDD VSS sg13g2_buf_1
Xfanout1059 _10105_/C _09872_/B VDD VSS sg13g2_buf_1
XFILLER_75_711 VDD VSS sg13g2_decap_8
XFILLER_134_1384 VDD VSS sg13g2_fill_2
X_13921_ _13921_/Q clkload44/A _13921_/D _13921_/RESET_B VDD VSS sg13g2_dfrbpq_1
XFILLER_86_89 VDD VSS sg13g2_decap_8
XFILLER_43_1267 VDD VSS sg13g2_decap_4
X_14769__3037 _14769_/RESET_B VDD VSS sg13g2_tiehi
XFILLER_19_126 VDD VSS sg13g2_decap_8
XFILLER_169_1414 VDD VSS sg13g2_decap_8
XFILLER_78_1319 VDD VSS sg13g2_decap_8
XFILLER_74_243 VDD VSS sg13g2_decap_8
X_13852_ _13852_/Q clkload64/A _13852_/D _13852_/RESET_B VDD VSS sg13g2_dfrbpq_1
XFILLER_90_703 VDD VSS sg13g2_decap_8
XFILLER_35_608 VDD VSS sg13g2_decap_8
XFILLER_142_84 VDD VSS sg13g2_decap_8
XFILLER_142_95 VDD VSS sg13g2_fill_1
XFILLER_62_416 VDD VSS sg13g2_decap_8
X_12803_ _12803_/X _13609_/A _12899_/C _12899_/A VDD VSS sg13g2_and3_1
X_13741__2531 _13741_/RESET_B VDD VSS sg13g2_tiehi
XFILLER_56_991 VDD VSS sg13g2_decap_8
XFILLER_62_438 VDD VSS sg13g2_decap_8
XFILLER_34_129 VDD VSS sg13g2_decap_8
X_13783_ _13783_/Q _15017_/CLK _13783_/D _13783_/RESET_B VDD VSS sg13g2_dfrbpq_1
X_10995_ _10995_/Y _10995_/A _10995_/B _10995_/C VDD VSS sg13g2_nor3_1
XFILLER_167_1160 VDD VSS sg13g2_decap_8
XFILLER_27_192 VDD VSS sg13g2_decap_8
XFILLER_128_1122 VDD VSS sg13g2_decap_8
XFILLER_15_343 VDD VSS sg13g2_decap_8
XFILLER_76_1054 VDD VSS sg13g2_fill_1
XFILLER_16_877 VDD VSS sg13g2_decap_8
X_12734_ _12734_/X _12733_/X _12732_/X _12776_/S VDD VSS sg13g2_mux2_1
XFILLER_31_803 VDD VSS sg13g2_decap_8
XFILLER_16_888 VDD VSS sg13g2_fill_2
XFILLER_76_1087 VDD VSS sg13g2_fill_2
XFILLER_70_471 VDD VSS sg13g2_fill_2
XFILLER_37_1038 VDD VSS sg13g2_fill_1
XFILLER_31_825 VDD VSS sg13g2_decap_8
XFILLER_163_1057 VDD VSS sg13g2_decap_8
XFILLER_176_808 VDD VSS sg13g2_decap_8
X_12665_ _12666_/B _13671_/Q _12707_/A2 _12664_/X _12707_/B2 _12707_/C1 VDD VSS sg13g2_a221oi_1
XFILLER_141_1300 VDD VSS sg13g2_decap_8
XFILLER_54_1352 VDD VSS sg13g2_decap_8
XFILLER_169_882 VDD VSS sg13g2_decap_8
X_14404_ _14404_/Q _14744_/CLK _14404_/D _14404_/RESET_B VDD VSS sg13g2_dfrbpq_1
X_14121__2151 _14121_/RESET_B VDD VSS sg13g2_tiehi
X_11616_ _11616_/Y _11741_/A _13830_/Q VDD VSS sg13g2_nand2b_1
XFILLER_180_1382 VDD VSS sg13g2_fill_1
XFILLER_50_1216 VDD VSS sg13g2_decap_8
XFILLER_11_560 VDD VSS sg13g2_decap_8
XFILLER_15_1347 VDD VSS sg13g2_decap_8
XFILLER_180_1393 VDD VSS sg13g2_fill_1
X_13774__2498 _13774_/RESET_B VDD VSS sg13g2_tiehi
X_12596_ _12597_/B _13676_/Q _12707_/A2 _12595_/X _12707_/B2 _12707_/C1 VDD VSS sg13g2_a221oi_1
X_14335_ _14335_/Q clkload21/A _14335_/D _14335_/RESET_B VDD VSS sg13g2_dfrbpq_1
XFILLER_89_1426 VDD VSS sg13g2_decap_8
X_11547_ _11547_/Y _11543_/Y _11544_/Y _11546_/Y _11545_/Y _12239_/B VDD VSS sg13g2_a221oi_1
XFILLER_102_1339 VDD VSS sg13g2_decap_4
XFILLER_7_553 VDD VSS sg13g2_decap_8
XFILLER_167_70 VDD VSS sg13g2_decap_8
X_14725__1547 _14725_/RESET_B VDD VSS sg13g2_tiehi
XFILLER_13_1071 VDD VSS sg13g2_decap_8
Xmax_cap217 _08434_/B _07943_/Y VDD VSS sg13g2_buf_2
X_14266_ _14266_/Q _14620_/CLK _14266_/D _14266_/RESET_B VDD VSS sg13g2_dfrbpq_1
Xwire495 wire495/X wire495/A VDD VSS sg13g2_buf_2
XFILLER_100_1030 VDD VSS sg13g2_decap_8
X_11478_ _11478_/Y _11654_/S _11476_/X _11477_/Y VDD VSS sg13g2_o21ai_1
XFILLER_100_1041 VDD VSS sg13g2_fill_2
XFILLER_109_492 VDD VSS sg13g2_fill_2
XFILLER_171_557 VDD VSS sg13g2_decap_8
X_13217_ _13217_/X input23/X _13272_/A2 _13264_/B1 VDD VSS sg13g2_a21o_1
X_10429_ _10434_/C _10647_/A _14832_/Q _14831_/Q _10647_/D VDD VSS sg13g2_and4_1
XFILLER_87_1172 VDD VSS sg13g2_decap_8
XFILLER_174_1131 VDD VSS sg13g2_decap_8
X_14197_ _14197_/Q clkload28/A _14197_/D _14197_/RESET_B VDD VSS sg13g2_dfrbpq_1
XFILLER_174_1142 VDD VSS sg13g2_fill_2
XFILLER_100_1096 VDD VSS sg13g2_fill_1
XFILLER_3_770 VDD VSS sg13g2_decap_8
X_13148_ _13148_/Y _13170_/C _13148_/B VDD VSS sg13g2_xnor2_1
XFILLER_83_1058 VDD VSS sg13g2_decap_8
XFILLER_140_955 VDD VSS sg13g2_decap_8
XFILLER_135_1148 VDD VSS sg13g2_decap_8
XFILLER_97_346 VDD VSS sg13g2_decap_8
XFILLER_61_1301 VDD VSS sg13g2_decap_8
XFILLER_2_280 VDD VSS sg13g2_decap_8
XFILLER_170_1039 VDD VSS sg13g2_decap_8
XFILLER_183_91 VDD VSS sg13g2_decap_8
XFILLER_26_1432 VDD VSS sg13g2_decap_8
XFILLER_85_508 VDD VSS sg13g2_decap_8
X_13079_ _13079_/Y _13077_/X _13092_/A _13160_/B VDD VSS sg13g2_nand3b_1
XFILLER_39_914 VDD VSS sg13g2_decap_8
XFILLER_113_1413 VDD VSS sg13g2_decap_8
XFILLER_66_711 VDD VSS sg13g2_decap_8
XFILLER_113_1424 VDD VSS sg13g2_fill_1
XFILLER_152_1473 VDD VSS sg13g2_fill_2
XFILLER_111_189 VDD VSS sg13g2_decap_4
XFILLER_93_530 VDD VSS sg13g2_decap_8
X_07640_ _10265_/A _14781_/Q VDD VSS sg13g2_inv_1
XFILLER_26_619 VDD VSS sg13g2_fill_1
XFILLER_19_671 VDD VSS sg13g2_decap_4
XFILLER_53_416 VDD VSS sg13g2_fill_1
XFILLER_0_1114 VDD VSS sg13g2_decap_8
XFILLER_81_747 VDD VSS sg13g2_decap_8
X_14331__1941 _14331_/RESET_B VDD VSS sg13g2_tiehi
XFILLER_80_224 VDD VSS sg13g2_decap_8
XFILLER_179_602 VDD VSS sg13g2_decap_8
XFILLER_62_950 VDD VSS sg13g2_decap_8
X_09310_ _13917_/D _09875_/A0 _13917_/Q _09327_/S VDD VSS sg13g2_mux2_1
XFILLER_59_1263 VDD VSS sg13g2_decap_8
XFILLER_146_1222 VDD VSS sg13g2_decap_4
XFILLER_33_140 VDD VSS sg13g2_decap_8
XFILLER_178_112 VDD VSS sg13g2_decap_8
XFILLER_22_825 VDD VSS sg13g2_decap_4
XFILLER_146_1266 VDD VSS sg13g2_fill_1
X_09241_ _09273_/S _09307_/B _10137_/C VDD VSS sg13g2_nor2_1
XFILLER_146_1299 VDD VSS sg13g2_decap_8
XFILLER_166_329 VDD VSS sg13g2_decap_8
X_09172_ _13788_/D _13788_/Q _10139_/A1 _09202_/S VDD VSS sg13g2_mux2_1
XFILLER_178_189 VDD VSS sg13g2_decap_8
X_08123_ _08688_/D _13510_/A1 _08048_/Y _08242_/A VDD VSS sg13g2_o21ai_1
XFILLER_30_880 VDD VSS sg13g2_fill_1
XFILLER_120_1417 VDD VSS sg13g2_decap_8
XFILLER_33_1469 VDD VSS sg13g2_fill_2
XFILLER_147_565 VDD VSS sg13g2_decap_4
XFILLER_175_874 VDD VSS sg13g2_decap_8
XFILLER_174_373 VDD VSS sg13g2_decap_8
X_08054_ _08054_/Y _12203_/A _08054_/B VDD VSS sg13g2_nand2b_1
XFILLER_134_215 VDD VSS sg13g2_fill_2
XFILLER_135_749 VDD VSS sg13g2_decap_4
XFILLER_128_790 VDD VSS sg13g2_fill_2
XFILLER_116_941 VDD VSS sg13g2_decap_8
XFILLER_116_963 VDD VSS sg13g2_decap_4
XFILLER_1_707 VDD VSS sg13g2_decap_8
XFILLER_115_451 VDD VSS sg13g2_decap_4
XFILLER_118_1302 VDD VSS sg13g2_decap_8
XFILLER_66_1234 VDD VSS sg13g2_decap_8
XFILLER_143_771 VDD VSS sg13g2_fill_1
Xhold3112 hold3112/X _10214_/Y VDD VSS sg13g2_dlygate4sd3_1
XFILLER_66_1256 VDD VSS sg13g2_decap_4
XFILLER_0_217 VDD VSS sg13g2_decap_8
XFILLER_103_624 VDD VSS sg13g2_decap_8
XFILLER_118_1335 VDD VSS sg13g2_fill_2
XFILLER_131_933 VDD VSS sg13g2_decap_8
XFILLER_163_28 VDD VSS sg13g2_decap_8
Xhold3123 input29/A mem_axi_rdata[3] VDD VSS sg13g2_dlygate4sd3_1
XFILLER_102_112 VDD VSS sg13g2_decap_4
Xhold3134 input8/A mem_axi_rdata[13] VDD VSS sg13g2_dlygate4sd3_1
XFILLER_88_335 VDD VSS sg13g2_decap_8
Xhold3145 input9/A mem_axi_rdata[14] VDD VSS sg13g2_dlygate4sd3_1
XFILLER_88_346 VDD VSS sg13g2_fill_1
Xhold3156 input23/A mem_axi_rdata[27] VDD VSS sg13g2_dlygate4sd3_1
Xhold3167 hold3167/X input17/X VDD VSS sg13g2_dlygate4sd3_1
X_08956_ _13722_/D _16884_/A _08955_/X _08956_/S VDD VSS sg13g2_mux2_1
XFILLER_131_999 VDD VSS sg13g2_decap_4
Xhold3178 input27/A mem_axi_rdata[30] VDD VSS sg13g2_dlygate4sd3_1
XFILLER_57_700 VDD VSS sg13g2_decap_8
Xhold3189 _13618_/A _13726_/Q VDD VSS sg13g2_dlygate4sd3_1
XFILLER_57_711 VDD VSS sg13g2_fill_1
XFILLER_9_1183 VDD VSS sg13g2_decap_8
XFILLER_102_189 VDD VSS sg13g2_decap_8
X_07907_ _07908_/B _15073_/Q _15216_/Q _15215_/Q _07907_/D VDD VSS sg13g2_nor4_1
XFILLER_69_582 VDD VSS sg13g2_decap_8
XFILLER_29_413 VDD VSS sg13g2_decap_8
X_14163__2109 _14163_/RESET_B VDD VSS sg13g2_tiehi
XFILLER_5_1036 VDD VSS sg13g2_decap_8
X_08887_ _08887_/Y _08887_/A1 _08850_/S _08886_/Y VDD VSS sg13g2_a21oi_1
XFILLER_186_7 VDD VSS sg13g2_decap_8
XFILLER_99_1032 VDD VSS sg13g2_fill_2
XFILLER_99_1043 VDD VSS sg13g2_fill_1
XFILLER_186_1002 VDD VSS sg13g2_decap_8
XFILLER_84_552 VDD VSS sg13g2_fill_1
XFILLER_186_1013 VDD VSS sg13g2_decap_8
X_07838_ _08684_/A _08697_/B _08698_/A VDD VSS sg13g2_nand2_1
XFILLER_99_1065 VDD VSS sg13g2_fill_1
XFILLER_84_585 VDD VSS sg13g2_decap_4
XFILLER_99_1087 VDD VSS sg13g2_decap_8
X_07769_ _08318_/A _08265_/A _08265_/B VDD VSS sg13g2_nor2_1
XFILLER_77_1352 VDD VSS sg13g2_fill_2
XFILLER_38_1303 VDD VSS sg13g2_decap_8
X_09508_ _14107_/D _10138_/A1 _14107_/Q _09539_/S VDD VSS sg13g2_mux2_1
XFILLER_169_112 VDD VSS sg13g2_decap_8
X_10780_ _14921_/D _11168_/B1 _11164_/B _10779_/Y VDD VSS sg13g2_o21ai_1
XFILLER_40_600 VDD VSS sg13g2_decap_8
XFILLER_25_674 VDD VSS sg13g2_decap_8
XFILLER_13_847 VDD VSS sg13g2_decap_8
X_09439_ _14041_/D _09472_/A0 _14041_/Q _09439_/S VDD VSS sg13g2_mux2_1
XFILLER_40_633 VDD VSS sg13g2_decap_8
XFILLER_185_616 VDD VSS sg13g2_decap_8
XFILLER_12_357 VDD VSS sg13g2_decap_8
X_12450_ _12450_/X _13954_/Q _13986_/Q _14018_/Q _14050_/Q _12450_/S0 _12450_/S1 VDD
+ VSS sg13g2_mux4_1
XFILLER_184_126 VDD VSS sg13g2_decap_8
XFILLER_178_690 VDD VSS sg13g2_fill_2
X_11401_ _11401_/Y _11401_/A _11401_/B _11401_/C VDD VSS sg13g2_nand3_1
XFILLER_138_554 VDD VSS sg13g2_decap_8
X_12381_ _12381_/X _14365_/Q _14397_/Q _14461_/Q _14493_/Q _12382_/S0 _12382_/S1 VDD
+ VSS sg13g2_mux4_1
XFILLER_181_800 VDD VSS sg13g2_decap_8
XFILLER_158_1104 VDD VSS sg13g2_decap_8
X_14120_ _14120_/Q clkload22/A _14120_/D _14120_/RESET_B VDD VSS sg13g2_dfrbpq_1
XFILLER_10_1211 VDD VSS sg13g2_decap_8
XFILLER_126_738 VDD VSS sg13g2_decap_8
X_11332_ wire232/A _11884_/B1 _11313_/Y _11331_/Y VDD VSS sg13g2_o21ai_1
XFILLER_107_930 VDD VSS sg13g2_decap_4
XFILLER_158_1126 VDD VSS sg13g2_fill_2
XFILLER_107_941 VDD VSS sg13g2_fill_1
XFILLER_125_248 VDD VSS sg13g2_decap_8
XFILLER_180_343 VDD VSS sg13g2_decap_8
XFILLER_21_84 VDD VSS sg13g2_decap_8
XFILLER_84_1301 VDD VSS sg13g2_fill_1
XFILLER_108_0 VDD VSS sg13g2_decap_8
XFILLER_153_568 VDD VSS sg13g2_decap_8
XFILLER_158_1159 VDD VSS sg13g2_decap_8
X_14051_ _14051_/Q _14723_/CLK _14051_/D _14051_/RESET_B VDD VSS sg13g2_dfrbpq_1
XFILLER_107_974 VDD VSS sg13g2_decap_8
X_11263_ _11263_/Y _11279_/A1 _13916_/Q _11262_/Y VDD VSS sg13g2_a21oi_1
XFILLER_106_451 VDD VSS sg13g2_decap_8
XFILLER_134_760 VDD VSS sg13g2_decap_8
XFILLER_84_1334 VDD VSS sg13g2_decap_4
XFILLER_4_567 VDD VSS sg13g2_decap_8
XFILLER_10_1288 VDD VSS sg13g2_decap_8
X_13759__2513 _13759_/RESET_B VDD VSS sg13g2_tiehi
XFILLER_97_33 VDD VSS sg13g2_decap_8
X_13002_ _13002_/Y _14779_/Q _13236_/A2 _13236_/B1 VDD VSS sg13g2_o21ai_1
X_10214_ _10214_/Y _07661_/Y _10213_/X _14764_/Q VDD VSS sg13g2_a21oi_1
X_11194_ _11194_/Y _11192_/X _11188_/Y _11193_/Y VDD VSS sg13g2_o21ai_1
XFILLER_122_966 VDD VSS sg13g2_decap_8
XFILLER_136_1457 VDD VSS sg13g2_decap_8
XFILLER_84_1389 VDD VSS sg13g2_decap_4
X_10145_ _14722_/D _14722_/Q _10145_/A1 _10167_/S VDD VSS sg13g2_mux2_1
XFILLER_95_839 VDD VSS sg13g2_decap_8
XFILLER_94_316 VDD VSS sg13g2_decap_8
XFILLER_82_1080 VDD VSS sg13g2_decap_8
X_14953_ _14953_/Q clkload70/A _14953_/D _14953_/RESET_B VDD VSS sg13g2_dfrbpq_1
X_10076_ _14656_/D _10076_/A0 _14656_/Q _10101_/S VDD VSS sg13g2_mux2_1
XFILLER_134_1192 VDD VSS sg13g2_decap_8
XFILLER_153_94 VDD VSS sg13g2_decap_8
XFILLER_47_221 VDD VSS sg13g2_decap_8
X_14139__2133 _14139_/RESET_B VDD VSS sg13g2_tiehi
X_13904_ _13904_/Q clkload22/A _13904_/D _13904_/RESET_B VDD VSS sg13g2_dfrbpq_1
XFILLER_48_766 VDD VSS sg13g2_decap_8
X_14884_ _14884_/Q _14886_/CLK _14884_/D _14884_/RESET_B VDD VSS sg13g2_dfrbpq_1
XFILLER_78_1116 VDD VSS sg13g2_decap_8
XFILLER_35_405 VDD VSS sg13g2_fill_2
XFILLER_21_1340 VDD VSS sg13g2_decap_8
XFILLER_62_202 VDD VSS sg13g2_decap_8
XFILLER_29_980 VDD VSS sg13g2_decap_8
X_13662__2641 _13662_/RESET_B VDD VSS sg13g2_tiehi
X_13835_ _13835_/Q clkload6/A _13835_/D _13835_/RESET_B VDD VSS sg13g2_dfrbpq_1
XFILLER_47_298 VDD VSS sg13g2_fill_2
XFILLER_16_630 VDD VSS sg13g2_decap_8
XFILLER_1_1456 VDD VSS sg13g2_decap_8
XFILLER_46_92 VDD VSS sg13g2_decap_8
XFILLER_91_1305 VDD VSS sg13g2_decap_8
XFILLER_15_140 VDD VSS sg13g2_decap_8
X_13766_ _13766_/Q _14726_/CLK _13766_/D _13766_/RESET_B VDD VSS sg13g2_dfrbpq_1
X_10978_ _10978_/Y _10978_/A _10978_/B VDD VSS sg13g2_nor2_1
XFILLER_90_599 VDD VSS sg13g2_decap_8
XFILLER_71_791 VDD VSS sg13g2_decap_8
XFILLER_43_482 VDD VSS sg13g2_decap_8
XFILLER_31_622 VDD VSS sg13g2_decap_8
XFILLER_182_1466 VDD VSS sg13g2_decap_4
X_12717_ _12717_/X _14261_/Q _14293_/Q _14325_/Q _14357_/Q _12717_/S0 _12717_/S1 VDD
+ VSS sg13g2_mux4_1
X_14913__2811 _14913_/RESET_B VDD VSS sg13g2_tiehi
XFILLER_30_110 VDD VSS sg13g2_fill_2
X_13697_ _16859_/A clkload79/A _13697_/D _13697_/RESET_B VDD VSS sg13g2_dfrbpq_1
XFILLER_19_1280 VDD VSS sg13g2_decap_8
XFILLER_31_677 VDD VSS sg13g2_decap_8
X_12648_ _12648_/X _12645_/X _12644_/X _12641_/X _12640_/X wire853/X _12663_/S0 VDD
+ VSS sg13g2_mux4_1
XFILLER_30_154 VDD VSS sg13g2_decap_8
XFILLER_175_126 VDD VSS sg13g2_decap_8
XFILLER_54_1182 VDD VSS sg13g2_fill_1
XFILLER_157_852 VDD VSS sg13g2_decap_8
XFILLER_15_1144 VDD VSS sg13g2_decap_8
XFILLER_89_1201 VDD VSS sg13g2_fill_2
XFILLER_50_1024 VDD VSS sg13g2_decap_8
XFILLER_178_91 VDD VSS sg13g2_decap_8
XFILLER_8_840 VDD VSS sg13g2_decap_8
XFILLER_117_705 VDD VSS sg13g2_decap_8
XFILLER_156_340 VDD VSS sg13g2_decap_8
XFILLER_11_1008 VDD VSS sg13g2_decap_8
X_12579_ _12579_/X _12574_/X _12578_/X _12573_/X _12577_/X _12663_/S0 _12663_/S1 VDD
+ VSS sg13g2_mux4_1
XFILLER_7_42 VDD VSS sg13g2_decap_8
XFILLER_50_1057 VDD VSS sg13g2_fill_1
XFILLER_7_350 VDD VSS sg13g2_decap_8
XFILLER_141_1196 VDD VSS sg13g2_fill_2
XFILLER_184_682 VDD VSS sg13g2_decap_8
X_14318_ _14318_/Q _14685_/CLK _14318_/D _14318_/RESET_B VDD VSS sg13g2_dfrbpq_1
XFILLER_50_1079 VDD VSS sg13g2_decap_8
X_14946__2745 _14946_/RESET_B VDD VSS sg13g2_tiehi
XFILLER_89_1267 VDD VSS sg13g2_decap_8
XFILLER_144_535 VDD VSS sg13g2_decap_8
XFILLER_171_321 VDD VSS sg13g2_fill_2
XFILLER_172_866 VDD VSS sg13g2_decap_8
X_14249_ _14249_/Q clkload34/A _14249_/D _14249_/RESET_B VDD VSS sg13g2_dfrbpq_1
XFILLER_171_376 VDD VSS sg13g2_decap_8
X_14349__1923 _14349_/RESET_B VDD VSS sg13g2_tiehi
XFILLER_113_933 VDD VSS sg13g2_decap_8
XFILLER_139_1070 VDD VSS sg13g2_fill_1
XFILLER_171_398 VDD VSS sg13g2_fill_2
Xfanout808 _08070_/B _08301_/S VDD VSS sg13g2_buf_1
Xfanout819 _08063_/A _12360_/A1 VDD VSS sg13g2_buf_1
XFILLER_113_977 VDD VSS sg13g2_fill_1
X_08810_ _08811_/B _13688_/Q _08822_/B VDD VSS sg13g2_nor2_1
XFILLER_97_143 VDD VSS sg13g2_fill_2
X_09790_ _14379_/D _09922_/A1 _14379_/Q _09797_/S VDD VSS sg13g2_mux2_1
XFILLER_98_688 VDD VSS sg13g2_decap_8
XFILLER_86_828 VDD VSS sg13g2_decap_8
XFILLER_58_519 VDD VSS sg13g2_decap_4
XFILLER_23_0 VDD VSS sg13g2_decap_8
XFILLER_6_1323 VDD VSS sg13g2_decap_8
X_08741_ _13665_/D _08765_/A1 _08739_/Y _08740_/Y VDD VSS sg13g2_a21oi_1
XFILLER_61_1153 VDD VSS sg13g2_decap_8
XFILLER_39_755 VDD VSS sg13g2_decap_8
XFILLER_38_232 VDD VSS sg13g2_fill_1
Xfanout1390 _11854_/S0 fanout1395/X VDD VSS sg13g2_buf_1
X_15124__2804 _15124_/RESET_B VDD VSS sg13g2_tiehi
X_08672_ _08672_/X _08692_/A _08673_/B _15019_/Q VDD VSS sg13g2_and3_1
XFILLER_27_928 VDD VSS sg13g2_decap_8
XFILLER_113_1276 VDD VSS sg13g2_decap_8
XFILLER_81_500 VDD VSS sg13g2_decap_4
XFILLER_54_714 VDD VSS sg13g2_fill_1
XFILLER_66_585 VDD VSS sg13g2_decap_8
XFILLER_38_276 VDD VSS sg13g2_fill_1
XFILLER_38_287 VDD VSS sg13g2_decap_8
X_07623_ _07623_/Y _14854_/Q VDD VSS sg13g2_inv_1
XFILLER_54_769 VDD VSS sg13g2_decap_8
XFILLER_53_246 VDD VSS sg13g2_decap_8
XFILLER_35_972 VDD VSS sg13g2_decap_8
XFILLER_59_1093 VDD VSS sg13g2_decap_8
XFILLER_34_471 VDD VSS sg13g2_fill_2
XFILLER_179_476 VDD VSS sg13g2_decap_8
X_13837__2435 _13837_/RESET_B VDD VSS sg13g2_tiehi
XFILLER_42_28 VDD VSS sg13g2_decap_8
XFILLER_107_1036 VDD VSS sg13g2_fill_1
X_14597__1675 _14597_/RESET_B VDD VSS sg13g2_tiehi
XFILLER_139_329 VDD VSS sg13g2_decap_8
X_09224_ _13835_/D _10154_/A1 _13835_/Q _09231_/S VDD VSS sg13g2_mux2_1
XFILLER_21_154 VDD VSS sg13g2_decap_8
XFILLER_158_28 VDD VSS sg13g2_decap_8
XFILLER_166_126 VDD VSS sg13g2_decap_8
XFILLER_167_649 VDD VSS sg13g2_decap_4
XFILLER_124_1361 VDD VSS sg13g2_fill_2
X_09155_ _09155_/Y _09161_/S _15051_/Q _09154_/Y VDD VSS sg13g2_o21ai_1
XFILLER_33_1266 VDD VSS sg13g2_decap_8
XFILLER_124_1394 VDD VSS sg13g2_fill_1
XFILLER_33_1288 VDD VSS sg13g2_decap_8
X_08106_ _08106_/Y _08001_/A _08105_/Y _08238_/B VDD VSS sg13g2_o21ai_1
X_09086_ _09086_/Y _09134_/S _15041_/Q _09085_/Y VDD VSS sg13g2_o21ai_1
XFILLER_135_557 VDD VSS sg13g2_decap_8
X_14217__2055 _14217_/RESET_B VDD VSS sg13g2_tiehi
X_08037_ _08039_/C _08037_/A _08037_/B _08037_/C VDD VSS sg13g2_nand3_1
XFILLER_162_376 VDD VSS sg13g2_decap_8
XFILLER_174_49 VDD VSS sg13g2_decap_8
XFILLER_1_504 VDD VSS sg13g2_decap_8
Xmax_cap581 _10471_/D _10459_/Y VDD VSS sg13g2_buf_2
XFILLER_115_270 VDD VSS sg13g2_decap_8
XFILLER_150_549 VDD VSS sg13g2_decap_8
XFILLER_157_1170 VDD VSS sg13g2_fill_1
XFILLER_115_281 VDD VSS sg13g2_fill_2
XFILLER_118_1132 VDD VSS sg13g2_decap_4
XFILLER_157_1181 VDD VSS sg13g2_decap_8
XFILLER_103_432 VDD VSS sg13g2_decap_8
XFILLER_88_132 VDD VSS sg13g2_fill_2
XFILLER_27_1037 VDD VSS sg13g2_fill_2
XFILLER_89_677 VDD VSS sg13g2_fill_1
XFILLER_130_240 VDD VSS sg13g2_decap_8
X_09988_ _14571_/D _10087_/A0 _14571_/Q _09990_/S VDD VSS sg13g2_mux2_1
XFILLER_89_688 VDD VSS sg13g2_fill_1
XFILLER_131_1321 VDD VSS sg13g2_decap_8
X_08939_ _08939_/X _15049_/Q _14953_/Q _10716_/A VDD VSS sg13g2_mux2_1
XFILLER_40_1215 VDD VSS sg13g2_decap_8
XFILLER_85_850 VDD VSS sg13g2_decap_4
XFILLER_131_1365 VDD VSS sg13g2_decap_8
X_11950_ _11952_/A _11948_/S _14640_/Q VDD VSS sg13g2_nand2b_1
XFILLER_85_872 VDD VSS sg13g2_fill_1
XFILLER_85_883 VDD VSS sg13g2_fill_2
XFILLER_79_1425 VDD VSS sg13g2_decap_8
XFILLER_131_1387 VDD VSS sg13g2_decap_8
XFILLER_17_427 VDD VSS sg13g2_decap_8
XFILLER_72_511 VDD VSS sg13g2_fill_2
XFILLER_45_736 VDD VSS sg13g2_decap_4
XFILLER_123_86 VDD VSS sg13g2_decap_8
X_10901_ _10901_/Y _08723_/B _10923_/A _10900_/Y VDD VSS sg13g2_a21oi_1
XFILLER_57_596 VDD VSS sg13g2_decap_8
Xclkbuf_leaf_133_clk_i clkload9/A clkbuf_leaf_5_clk_i/A VDD VSS sg13g2_buf_8
X_11881_ _11881_/Y _11877_/Y _11878_/Y _11880_/Y _11879_/Y _11900_/B VDD VSS sg13g2_a221oi_1
XFILLER_60_706 VDD VSS sg13g2_decap_8
X_13620_ _13728_/D _13620_/A VDD VSS sg13g2_buf_1
X_10832_ _10832_/X _10832_/A _10843_/C VDD VSS sg13g2_and2_1
XFILLER_38_1133 VDD VSS sg13g2_fill_2
XFILLER_129_1261 VDD VSS sg13g2_decap_8
XFILLER_16_84 VDD VSS sg13g2_decap_8
XFILLER_73_1024 VDD VSS sg13g2_decap_8
X_13551_ _15148_/D _15148_/Q _13550_/Y _13562_/S VDD VSS sg13g2_mux2_1
XFILLER_73_1035 VDD VSS sg13g2_fill_2
XFILLER_25_493 VDD VSS sg13g2_decap_4
XFILLER_13_644 VDD VSS sg13g2_decap_8
XFILLER_164_1163 VDD VSS sg13g2_decap_8
X_10763_ _11115_/B _14949_/Q _10767_/A _10762_/Y VDD VSS sg13g2_a21oi_1
XFILLER_185_413 VDD VSS sg13g2_decap_8
X_14427__1845 _14427_/RESET_B VDD VSS sg13g2_tiehi
X_12502_ _12502_/X _14374_/Q _14406_/Q _14470_/Q _14502_/Q _12606_/S0 _12606_/S1 VDD
+ VSS sg13g2_mux4_1
XFILLER_12_154 VDD VSS sg13g2_decap_8
XFILLER_41_986 VDD VSS sg13g2_decap_8
XFILLER_160_1038 VDD VSS sg13g2_fill_2
X_13482_ _13484_/B _13482_/A _13482_/B _15189_/Q VDD VSS sg13g2_nand3_1
XFILLER_9_637 VDD VSS sg13g2_decap_8
XFILLER_90_1360 VDD VSS sg13g2_fill_2
X_10694_ _10871_/A _14932_/Q _09003_/X _10694_/S VDD VSS sg13g2_mux2_1
X_15221_ _15221_/Q _15224_/CLK _15221_/D _15221_/RESET_B VDD VSS sg13g2_dfrbpq_1
XFILLER_90_1393 VDD VSS sg13g2_decap_8
XFILLER_139_863 VDD VSS sg13g2_fill_1
XFILLER_142_1461 VDD VSS sg13g2_decap_8
X_12433_ _12433_/X _13825_/Q _13857_/Q _13889_/Q _13921_/Q _12450_/S0 _12450_/S1 VDD
+ VSS sg13g2_mux4_1
XFILLER_8_147 VDD VSS sg13g2_decap_8
XFILLER_16_1475 VDD VSS sg13g2_decap_4
XFILLER_103_1434 VDD VSS sg13g2_decap_8
XFILLER_139_885 VDD VSS sg13g2_decap_8
XFILLER_166_671 VDD VSS sg13g2_decap_8
XFILLER_154_822 VDD VSS sg13g2_fill_1
X_15152_ _15152_/Q clkload86/A _15152_/D _15152_/RESET_B VDD VSS sg13g2_dfrbpq_1
X_12364_ _12364_/X _13948_/Q _13980_/Q _14012_/Q _14044_/Q _12366_/S0 _12366_/S1 VDD
+ VSS sg13g2_mux4_1
XFILLER_86_1407 VDD VSS sg13g2_decap_8
XFILLER_153_321 VDD VSS sg13g2_decap_4
XFILLER_181_630 VDD VSS sg13g2_decap_8
XFILLER_86_1418 VDD VSS sg13g2_fill_1
XFILLER_126_546 VDD VSS sg13g2_decap_4
XFILLER_154_866 VDD VSS sg13g2_decap_4
X_14103_ _14103_/Q clkload46/A _14103_/D _14103_/RESET_B VDD VSS sg13g2_dfrbpq_1
XFILLER_5_854 VDD VSS sg13g2_decap_8
X_11315_ _11315_/Y _11317_/A1 _14397_/Q _11897_/C VDD VSS sg13g2_a21oi_1
XFILLER_180_140 VDD VSS sg13g2_decap_8
X_14642__1630 _14642_/RESET_B VDD VSS sg13g2_tiehi
X_15083_ _15083_/Q clkload89/A _15083_/D _15083_/RESET_B VDD VSS sg13g2_dfrbpq_1
X_12295_ _12295_/Y _12293_/Y _12294_/Y _12271_/A VDD VSS sg13g2_a21oi_1
XFILLER_4_364 VDD VSS sg13g2_decap_8
XFILLER_107_782 VDD VSS sg13g2_decap_8
XFILLER_10_1085 VDD VSS sg13g2_decap_8
X_14034_ _14034_/Q _14674_/CLK _14034_/D _14034_/RESET_B VDD VSS sg13g2_dfrbpq_1
X_11246_ _11249_/B _13293_/D _07690_/X _11245_/Y VDD VSS sg13g2_a21oi_1
XFILLER_175_1281 VDD VSS sg13g2_decap_8
XFILLER_79_132 VDD VSS sg13g2_decap_8
X_11177_ _11177_/X _11197_/A _11177_/B _11177_/C VDD VSS sg13g2_or3_1
XFILLER_110_925 VDD VSS sg13g2_decap_8
XFILLER_94_102 VDD VSS sg13g2_decap_8
XFILLER_62_1440 VDD VSS sg13g2_fill_2
XFILLER_0_581 VDD VSS sg13g2_decap_8
X_10128_ _14706_/D _10128_/A0 _14706_/Q _10134_/S VDD VSS sg13g2_mux2_1
X_13915__2357 _13915_/RESET_B VDD VSS sg13g2_tiehi
XFILLER_23_1435 VDD VSS sg13g2_decap_8
X_14675__1597 _14675_/RESET_B VDD VSS sg13g2_tiehi
X_14936_ _14936_/Q clkload75/A _14936_/D _14936_/RESET_B VDD VSS sg13g2_dfrbpq_1
X_10059_ _14640_/D _10159_/A1 _14640_/Q _10060_/S VDD VSS sg13g2_mux2_1
XFILLER_76_872 VDD VSS sg13g2_decap_8
XFILLER_36_703 VDD VSS sg13g2_fill_1
X_15010__2670 _15010_/RESET_B VDD VSS sg13g2_tiehi
XFILLER_180_70 VDD VSS sg13g2_decap_8
XFILLER_169_1030 VDD VSS sg13g2_decap_4
XFILLER_91_842 VDD VSS sg13g2_decap_4
XFILLER_35_224 VDD VSS sg13g2_decap_8
XFILLER_169_1063 VDD VSS sg13g2_decap_8
X_14867_ _14867_/Q clkload64/A _14867_/D _14867_/RESET_B VDD VSS sg13g2_dfrbpq_1
XFILLER_36_769 VDD VSS sg13g2_decap_8
XFILLER_1_1253 VDD VSS sg13g2_decap_8
XFILLER_51_706 VDD VSS sg13g2_decap_8
X_13818_ _13818_/Q _14620_/CLK _13818_/D _13818_/RESET_B VDD VSS sg13g2_dfrbpq_1
XFILLER_63_577 VDD VSS sg13g2_decap_8
XFILLER_56_1211 VDD VSS sg13g2_decap_8
X_14798_ _14798_/Q _14864_/CLK _14798_/D _14798_/RESET_B VDD VSS sg13g2_dfrbpq_1
XFILLER_90_374 VDD VSS sg13g2_decap_8
XFILLER_56_1222 VDD VSS sg13g2_fill_2
XFILLER_177_903 VDD VSS sg13g2_decap_8
XFILLER_95_1293 VDD VSS sg13g2_decap_4
XFILLER_177_914 VDD VSS sg13g2_fill_1
X_13749_ _13749_/Q clkload28/A _13749_/D _13749_/RESET_B VDD VSS sg13g2_dfrbpq_1
XFILLER_91_1135 VDD VSS sg13g2_fill_2
XFILLER_147_1383 VDD VSS sg13g2_decap_8
XFILLER_143_1225 VDD VSS sg13g2_decap_8
XFILLER_31_441 VDD VSS sg13g2_decap_8
XFILLER_143_1236 VDD VSS sg13g2_fill_1
XFILLER_176_413 VDD VSS sg13g2_decap_8
XFILLER_56_1288 VDD VSS sg13g2_decap_8
XFILLER_52_1119 VDD VSS sg13g2_decap_8
XFILLER_91_1179 VDD VSS sg13g2_fill_2
XFILLER_177_958 VDD VSS sg13g2_decap_4
XFILLER_182_1296 VDD VSS sg13g2_decap_8
XFILLER_56_1299 VDD VSS sg13g2_fill_2
XFILLER_32_997 VDD VSS sg13g2_decap_8
XFILLER_108_1389 VDD VSS sg13g2_decap_8
X_15153__2744 _15153_/RESET_B VDD VSS sg13g2_tiehi
XFILLER_145_811 VDD VSS sg13g2_fill_2
XFILLER_117_524 VDD VSS sg13g2_decap_8
X_14281__1991 _14281_/RESET_B VDD VSS sg13g2_tiehi
XFILLER_117_535 VDD VSS sg13g2_fill_1
XFILLER_129_395 VDD VSS sg13g2_decap_8
XFILLER_145_866 VDD VSS sg13g2_decap_8
XFILLER_176_1023 VDD VSS sg13g2_decap_8
XFILLER_89_1075 VDD VSS sg13g2_decap_8
XFILLER_171_140 VDD VSS sg13g2_decap_8
XFILLER_172_674 VDD VSS sg13g2_decap_8
XFILLER_145_899 VDD VSS sg13g2_decap_4
XFILLER_171_173 VDD VSS sg13g2_decap_8
X_09911_ _14496_/D _14496_/Q _09911_/A1 _09935_/S VDD VSS sg13g2_mux2_1
XFILLER_63_1204 VDD VSS sg13g2_decap_4
XFILLER_119_1441 VDD VSS sg13g2_fill_2
XFILLER_154_1332 VDD VSS sg13g2_decap_8
Xfanout605 _13482_/B _08723_/Y VDD VSS sg13g2_buf_1
XFILLER_99_964 VDD VSS sg13g2_fill_1
XFILLER_8_1407 VDD VSS sg13g2_decap_8
Xfanout616 _13161_/B1 _13264_/B1 VDD VSS sg13g2_buf_1
XFILLER_112_240 VDD VSS sg13g2_fill_1
XFILLER_154_1354 VDD VSS sg13g2_decap_8
Xclkbuf_4_11_0_clk_i clkbuf_4_11_0_clk_i/X clkbuf_0_clk_i/X VDD VSS sg13g2_buf_8
Xfanout627 _13564_/A2 _13600_/B VDD VSS sg13g2_buf_1
X_09842_ _14429_/D _14429_/Q _09842_/A1 _09859_/S VDD VSS sg13g2_mux2_1
XFILLER_59_817 VDD VSS sg13g2_fill_1
XFILLER_113_774 VDD VSS sg13g2_decap_8
Xfanout638 _11113_/B _11170_/B VDD VSS sg13g2_buf_1
XFILLER_63_1248 VDD VSS sg13g2_decap_8
XFILLER_59_828 VDD VSS sg13g2_decap_8
Xfanout649 _09057_/A _09137_/A VDD VSS sg13g2_buf_1
XFILLER_100_424 VDD VSS sg13g2_decap_8
XFILLER_6_1120 VDD VSS sg13g2_decap_8
X_09773_ _09773_/Y _09905_/A _10105_/C _10004_/A _10105_/B VDD VSS sg13g2_nand4_1
XFILLER_86_658 VDD VSS sg13g2_decap_8
XFILLER_58_349 VDD VSS sg13g2_decap_8
XFILLER_37_28 VDD VSS sg13g2_decap_8
XFILLER_26_1081 VDD VSS sg13g2_decap_8
X_14505__1767 _14505_/RESET_B VDD VSS sg13g2_tiehi
Xclkbuf_leaf_50_clk_i clkload42/A clkbuf_leaf_51_clk_i/A VDD VSS sg13g2_buf_8
XFILLER_85_157 VDD VSS sg13g2_decap_4
X_08724_ _08724_/Y _13412_/B _10797_/C VDD VSS sg13g2_nand2b_1
XFILLER_96_1002 VDD VSS sg13g2_decap_8
XFILLER_27_714 VDD VSS sg13g2_decap_8
XFILLER_67_894 VDD VSS sg13g2_decap_8
XFILLER_6_1197 VDD VSS sg13g2_decap_8
X_08655_ _08655_/Y _08054_/B _12229_/A _08054_/Y VDD VSS sg13g2_o21ai_1
XFILLER_96_1057 VDD VSS sg13g2_decap_4
XFILLER_26_257 VDD VSS sg13g2_decap_8
XFILLER_54_577 VDD VSS sg13g2_decap_8
XFILLER_53_16 VDD VSS sg13g2_fill_1
X_08586_ _08588_/C _08641_/C _08586_/B _08586_/C VDD VSS sg13g2_nand3_1
XFILLER_41_205 VDD VSS sg13g2_decap_8
Xclkbuf_leaf_65_clk_i clkload90/A clkbuf_leaf_68_clk_i/A VDD VSS sg13g2_buf_8
XFILLER_35_780 VDD VSS sg13g2_decap_8
X_14720__1552 _14720_/RESET_B VDD VSS sg13g2_tiehi
XFILLER_169_49 VDD VSS sg13g2_decap_8
XFILLER_149_7 VDD VSS sg13g2_decap_8
XFILLER_50_750 VDD VSS sg13g2_fill_2
XFILLER_23_975 VDD VSS sg13g2_decap_8
XFILLER_179_273 VDD VSS sg13g2_decap_8
XFILLER_22_452 VDD VSS sg13g2_fill_1
XFILLER_161_1347 VDD VSS sg13g2_decap_8
XFILLER_183_917 VDD VSS sg13g2_decap_4
X_09207_ _13819_/D _09939_/A1 _13819_/Q _09227_/S VDD VSS sg13g2_mux2_1
XFILLER_33_1041 VDD VSS sg13g2_decap_8
XFILLER_10_658 VDD VSS sg13g2_decap_8
XFILLER_33_1052 VDD VSS sg13g2_fill_1
XFILLER_182_427 VDD VSS sg13g2_decap_8
XFILLER_176_991 VDD VSS sg13g2_decap_8
X_09138_ _09138_/X _09057_/A _10776_/A _09137_/Y VDD VSS sg13g2_a21o_1
XFILLER_147_181 VDD VSS sg13g2_decap_8
XFILLER_108_557 VDD VSS sg13g2_decap_8
XFILLER_120_1066 VDD VSS sg13g2_decap_8
XFILLER_108_568 VDD VSS sg13g2_fill_2
XFILLER_120_1088 VDD VSS sg13g2_decap_4
X_09069_ _09069_/X _09137_/A _09069_/B _09103_/C VDD VSS sg13g2_or3_1
XFILLER_68_1148 VDD VSS sg13g2_decap_8
XFILLER_11_1372 VDD VSS sg13g2_decap_8
XFILLER_120_1099 VDD VSS sg13g2_decap_8
XFILLER_135_376 VDD VSS sg13g2_decap_8
XFILLER_159_1265 VDD VSS sg13g2_decap_8
XFILLER_163_685 VDD VSS sg13g2_fill_2
XFILLER_155_1107 VDD VSS sg13g2_decap_8
XFILLER_150_313 VDD VSS sg13g2_decap_8
XFILLER_1_301 VDD VSS sg13g2_decap_8
X_11100_ _11100_/Y _11109_/B _10759_/X _11154_/B1 VDD VSS sg13g2_o21ai_1
X_12080_ _12080_/Y _12079_/Y _12078_/Y _12065_/Y _12156_/A _12126_/A VDD VSS sg13g2_a221oi_1
XFILLER_78_57 VDD VSS sg13g2_fill_2
XFILLER_2_868 VDD VSS sg13g2_decap_8
X_11031_ _14943_/D _11029_/Y _11030_/Y _11021_/X VDD VSS sg13g2_a21o_1
XFILLER_103_262 VDD VSS sg13g2_decap_8
XFILLER_1_378 VDD VSS sg13g2_decap_8
XFILLER_89_485 VDD VSS sg13g2_decap_8
XFILLER_134_41 VDD VSS sg13g2_decap_4
XFILLER_77_647 VDD VSS sg13g2_decap_8
XFILLER_134_63 VDD VSS sg13g2_decap_8
X_14930__2777 _14930_/RESET_B VDD VSS sg13g2_tiehi
Xclkbuf_leaf_18_clk_i _14982_/CLK clkbuf_leaf_18_clk_i/A VDD VSS sg13g2_buf_8
XFILLER_40_1012 VDD VSS sg13g2_decap_8
XFILLER_131_1140 VDD VSS sg13g2_decap_8
X_12982_ _12982_/Y _12980_/Y _12981_/Y _12933_/Y VDD VSS sg13g2_o21ai_1
XFILLER_45_500 VDD VSS sg13g2_decap_8
XFILLER_175_0 VDD VSS sg13g2_decap_8
XFILLER_18_747 VDD VSS sg13g2_decap_8
X_14721_ _14721_/Q _14745_/CLK _14721_/D _14721_/RESET_B VDD VSS sg13g2_dfrbpq_1
XFILLER_131_1195 VDD VSS sg13g2_decap_4
XFILLER_17_224 VDD VSS sg13g2_decap_8
X_11933_ _14977_/D _11914_/A _12126_/A _11932_/Y VDD VSS sg13g2_a21o_1
XFILLER_79_1244 VDD VSS sg13g2_decap_8
XFILLER_45_533 VDD VSS sg13g2_decap_8
XFILLER_91_149 VDD VSS sg13g2_fill_2
XFILLER_72_330 VDD VSS sg13g2_fill_2
XFILLER_79_1266 VDD VSS sg13g2_decap_4
XFILLER_79_1288 VDD VSS sg13g2_decap_8
X_14652_ _14652_/Q _14652_/CLK _14652_/D _14652_/RESET_B VDD VSS sg13g2_dfrbpq_1
XFILLER_33_717 VDD VSS sg13g2_decap_8
X_11864_ _11864_/Y _11865_/A _13674_/Q VDD VSS sg13g2_nor2_1
XFILLER_127_1209 VDD VSS sg13g2_decap_4
XFILLER_166_1258 VDD VSS sg13g2_decap_8
XFILLER_45_599 VDD VSS sg13g2_decap_8
XFILLER_33_739 VDD VSS sg13g2_decap_8
XFILLER_26_780 VDD VSS sg13g2_decap_8
XFILLER_14_931 VDD VSS sg13g2_decap_8
X_13603_ _13603_/Y _13602_/Y _13600_/Y _08830_/X VDD VSS sg13g2_o21ai_1
X_10815_ _10815_/Y _10869_/A _10814_/Y _13307_/B VDD VSS sg13g2_a21oi_1
X_14583_ _14583_/Q clkload47/A _14583_/D _14583_/RESET_B VDD VSS sg13g2_dfrbpq_1
XFILLER_32_249 VDD VSS sg13g2_decap_8
X_11795_ _14973_/D _11770_/A _11980_/A _11794_/Y VDD VSS sg13g2_a21o_1
XFILLER_25_290 VDD VSS sg13g2_decap_8
XFILLER_13_441 VDD VSS sg13g2_decap_8
XFILLER_92_1466 VDD VSS sg13g2_decap_8
XFILLER_92_1477 VDD VSS sg13g2_fill_2
XFILLER_185_210 VDD VSS sg13g2_decap_8
X_13534_ _13534_/Y _13533_/A _13555_/C _08351_/B _13546_/B2 VDD VSS sg13g2_a22oi_1
X_10746_ _14914_/D _09204_/C _11078_/A _10745_/Y VDD VSS sg13g2_o21ai_1
X_14089__2183 _14089_/RESET_B VDD VSS sg13g2_tiehi
XFILLER_9_434 VDD VSS sg13g2_decap_8
XFILLER_174_917 VDD VSS sg13g2_fill_1
X_13465_ _13465_/Y _13412_/B _08723_/B _07729_/D VDD VSS sg13g2_o21ai_1
XFILLER_51_1141 VDD VSS sg13g2_decap_8
XFILLER_16_1272 VDD VSS sg13g2_decap_8
X_10677_ _10844_/A _08977_/B _10669_/S _10805_/B VDD VSS sg13g2_a21o_1
XFILLER_167_980 VDD VSS sg13g2_decap_8
XFILLER_185_287 VDD VSS sg13g2_decap_8
X_15204_ _15204_/Q clkload88/A _15204_/D _15204_/RESET_B VDD VSS sg13g2_dfrbpq_1
X_12416_ _12416_/Y _12347_/B _12348_/A _12442_/A2 _13689_/Q _13282_/A1 VDD VSS sg13g2_a221oi_1
X_13396_ _13396_/Y _13396_/A _13396_/B _13396_/C _13396_/D VDD VSS sg13g2_nor4_1
XFILLER_86_1204 VDD VSS sg13g2_decap_4
XFILLER_64_7 VDD VSS sg13g2_decap_8
XFILLER_12_1169 VDD VSS sg13g2_decap_8
X_15135_ _15135_/Q clkload77/A _15135_/D _15135_/RESET_B VDD VSS sg13g2_dfrbpq_1
X_15028__2652 _15028_/RESET_B VDD VSS sg13g2_tiehi
X_12347_ _12348_/D _15122_/Q _12347_/B _15119_/Q _12347_/D VDD VSS sg13g2_nor4_1
XFILLER_5_651 VDD VSS sg13g2_decap_8
XFILLER_86_1259 VDD VSS sg13g2_decap_8
XFILLER_175_70 VDD VSS sg13g2_decap_8
XFILLER_126_398 VDD VSS sg13g2_decap_8
XFILLER_4_161 VDD VSS sg13g2_decap_8
XFILLER_138_1349 VDD VSS sg13g2_fill_1
X_15066_ _15066_/Q _15113_/CLK _15066_/D _15066_/RESET_B VDD VSS sg13g2_dfrbpq_1
XFILLER_4_21 VDD VSS sg13g2_decap_8
XFILLER_153_195 VDD VSS sg13g2_decap_8
X_12278_ _12279_/B _12278_/A _13663_/Q VDD VSS sg13g2_or2_1
XFILLER_99_249 VDD VSS sg13g2_decap_8
X_14017_ _14017_/Q clkload44/A _14017_/D _14017_/RESET_B VDD VSS sg13g2_dfrbpq_1
X_11229_ _11229_/X _13819_/Q _13851_/Q _13883_/Q _13915_/Q _11277_/S _11262_/B VDD
+ VSS sg13g2_mux4_1
XFILLER_96_912 VDD VSS sg13g2_decap_4
XFILLER_122_560 VDD VSS sg13g2_decap_4
XFILLER_96_923 VDD VSS sg13g2_decap_8
XFILLER_95_400 VDD VSS sg13g2_decap_8
X_14752__3057 _14752_/RESET_B VDD VSS sg13g2_tiehi
XFILLER_136_1073 VDD VSS sg13g2_decap_8
XFILLER_95_411 VDD VSS sg13g2_fill_2
XFILLER_4_98 VDD VSS sg13g2_decap_8
XFILLER_96_956 VDD VSS sg13g2_decap_8
XFILLER_68_658 VDD VSS sg13g2_decap_8
XFILLER_67_146 VDD VSS sg13g2_fill_1
XFILLER_62_1270 VDD VSS sg13g2_decap_8
XFILLER_110_777 VDD VSS sg13g2_fill_1
XFILLER_23_1232 VDD VSS sg13g2_decap_8
XFILLER_67_168 VDD VSS sg13g2_decap_8
XFILLER_62_1292 VDD VSS sg13g2_decap_8
XFILLER_110_788 VDD VSS sg13g2_decap_8
XFILLER_97_1300 VDD VSS sg13g2_decap_4
XFILLER_3_1337 VDD VSS sg13g2_decap_8
XFILLER_36_511 VDD VSS sg13g2_decap_8
X_14919_ _14919_/Q clkload54/A _14919_/D _14919_/RESET_B VDD VSS sg13g2_dfrbpq_1
XFILLER_64_864 VDD VSS sg13g2_fill_1
XFILLER_91_661 VDD VSS sg13g2_decap_4
XFILLER_149_1456 VDD VSS sg13g2_decap_8
XFILLER_1_1050 VDD VSS sg13g2_decap_8
X_14299__1973 _14299_/RESET_B VDD VSS sg13g2_tiehi
X_08440_ _08441_/B _08574_/A _08438_/Y _08439_/Y VDD VSS sg13g2_o21ai_1
XFILLER_63_363 VDD VSS sg13g2_decap_8
XFILLER_58_1339 VDD VSS sg13g2_decap_8
XFILLER_184_1347 VDD VSS sg13g2_decap_8
XFILLER_91_683 VDD VSS sg13g2_decap_8
X_08371_ _08371_/Y _07795_/A _08370_/Y _08588_/B VDD VSS sg13g2_o21ai_1
XFILLER_95_1090 VDD VSS sg13g2_fill_1
XFILLER_51_558 VDD VSS sg13g2_decap_4
XFILLER_108_1131 VDD VSS sg13g2_decap_8
XFILLER_90_0 VDD VSS sg13g2_decap_8
XFILLER_108_1142 VDD VSS sg13g2_fill_1
XFILLER_176_210 VDD VSS sg13g2_decap_8
XFILLER_56_1096 VDD VSS sg13g2_decap_4
XFILLER_137_608 VDD VSS sg13g2_decap_8
XFILLER_31_282 VDD VSS sg13g2_decap_8
XFILLER_164_427 VDD VSS sg13g2_fill_1
XFILLER_176_287 VDD VSS sg13g2_decap_8
XFILLER_34_1383 VDD VSS sg13g2_fill_1
XFILLER_178_1118 VDD VSS sg13g2_decap_8
XFILLER_121_1342 VDD VSS sg13g2_decap_8
XFILLER_160_1391 VDD VSS sg13g2_decap_4
XFILLER_164_449 VDD VSS sg13g2_decap_8
XFILLER_118_855 VDD VSS sg13g2_decap_8
XFILLER_118_888 VDD VSS sg13g2_decap_8
XFILLER_173_972 VDD VSS sg13g2_decap_8
XFILLER_117_365 VDD VSS sg13g2_decap_8
XFILLER_133_814 VDD VSS sg13g2_decap_8
XFILLER_105_516 VDD VSS sg13g2_decap_8
XFILLER_132_313 VDD VSS sg13g2_decap_8
XFILLER_145_696 VDD VSS sg13g2_fill_1
XFILLER_172_493 VDD VSS sg13g2_decap_8
X_13787__2485 _13787_/RESET_B VDD VSS sg13g2_tiehi
Xfanout402 fanout402/X _09294_/S VDD VSS sg13g2_buf_1
Xfanout413 _09196_/S wire416/X VDD VSS sg13g2_buf_1
XFILLER_8_1204 VDD VSS sg13g2_decap_8
XFILLER_120_519 VDD VSS sg13g2_decap_8
XFILLER_154_1151 VDD VSS sg13g2_decap_4
Xfanout424 _10145_/A1 _09946_/A1 VDD VSS sg13g2_buf_1
XFILLER_99_783 VDD VSS sg13g2_decap_8
Xfanout435 _09908_/A1 fanout438/X VDD VSS sg13g2_buf_1
XFILLER_98_271 VDD VSS sg13g2_decap_8
XFILLER_28_1165 VDD VSS sg13g2_decap_8
X_14738__1534 _14738_/RESET_B VDD VSS sg13g2_tiehi
Xfanout446 _13435_/B _13444_/B VDD VSS sg13g2_buf_1
XFILLER_98_282 VDD VSS sg13g2_fill_1
XFILLER_63_1056 VDD VSS sg13g2_decap_8
XFILLER_113_593 VDD VSS sg13g2_decap_8
Xfanout457 _10127_/S _10120_/S VDD VSS sg13g2_buf_1
X_09825_ _14413_/D _09924_/A1 _14413_/Q _09830_/S VDD VSS sg13g2_mux2_1
XFILLER_48_49 VDD VSS sg13g2_decap_8
XFILLER_150_1026 VDD VSS sg13g2_decap_4
XFILLER_171_28 VDD VSS sg13g2_decap_8
XFILLER_115_1157 VDD VSS sg13g2_decap_8
Xfanout479 _09826_/S _09806_/Y VDD VSS sg13g2_buf_1
XFILLER_87_989 VDD VSS sg13g2_decap_8
X_09756_ _14346_/D _14346_/Q _09921_/A1 _09770_/S VDD VSS sg13g2_mux2_1
XFILLER_41_1354 VDD VSS sg13g2_decap_8
XFILLER_55_820 VDD VSS sg13g2_decap_8
XFILLER_39_371 VDD VSS sg13g2_decap_8
XFILLER_55_831 VDD VSS sg13g2_fill_1
X_08707_ _15186_/D hold3169/X _15186_/Q _08719_/S VDD VSS sg13g2_mux2_1
XFILLER_27_533 VDD VSS sg13g2_decap_8
XFILLER_104_77 VDD VSS sg13g2_decap_8
X_09687_ _14279_/D _09885_/A0 _14279_/Q _09705_/S VDD VSS sg13g2_mux2_1
XFILLER_76_1417 VDD VSS sg13g2_fill_2
XFILLER_70_801 VDD VSS sg13g2_decap_8
XFILLER_15_728 VDD VSS sg13g2_decap_8
X_08638_ _08640_/A _07844_/X _08653_/A _08544_/B _08330_/Y VDD VSS sg13g2_a22oi_1
XFILLER_14_238 VDD VSS sg13g2_decap_8
X_08569_ _08569_/Y _07808_/Y _08568_/Y _08567_/X VDD VSS sg13g2_o21ai_1
XFILLER_74_1141 VDD VSS sg13g2_fill_1
XFILLER_42_558 VDD VSS sg13g2_fill_1
XFILLER_35_1103 VDD VSS sg13g2_fill_1
XFILLER_120_65 VDD VSS sg13g2_decap_8
X_10600_ _10602_/B _10607_/C _10607_/D _14877_/Q VDD VSS sg13g2_a21oi_1
XFILLER_167_210 VDD VSS sg13g2_decap_8
XFILLER_35_1125 VDD VSS sg13g2_fill_2
XFILLER_167_221 VDD VSS sg13g2_fill_2
X_11580_ _11580_/X _14245_/Q _14277_/Q _14309_/Q _14341_/Q _11996_/S0 _11996_/S1 VDD
+ VSS sg13g2_mux4_1
XFILLER_168_755 VDD VSS sg13g2_fill_2
XFILLER_11_945 VDD VSS sg13g2_decap_8
XFILLER_70_1049 VDD VSS sg13g2_decap_8
XFILLER_50_591 VDD VSS sg13g2_decap_8
X_10531_ _10533_/B _14859_/Q _10558_/B _10558_/C _10531_/D VDD VSS sg13g2_nand4_1
XFILLER_10_455 VDD VSS sg13g2_decap_8
XFILLER_13_63 VDD VSS sg13g2_decap_8
XFILLER_167_287 VDD VSS sg13g2_decap_8
XFILLER_7_938 VDD VSS sg13g2_decap_8
XFILLER_109_833 VDD VSS sg13g2_decap_8
XFILLER_182_224 VDD VSS sg13g2_decap_8
X_13250_ _13251_/C _14828_/Q _13250_/A2 _13260_/B _14860_/Q VDD VSS sg13g2_a22oi_1
X_10462_ _10473_/D _10471_/C _14842_/Q _14841_/Q _10462_/D VDD VSS sg13g2_and4_1
XFILLER_13_1456 VDD VSS sg13g2_decap_8
XFILLER_6_448 VDD VSS sg13g2_decap_8
XFILLER_109_866 VDD VSS sg13g2_fill_1
XFILLER_129_74 VDD VSS sg13g2_decap_8
X_12201_ _12204_/A _12060_/Y _12197_/Y _12200_/X VDD VSS sg13g2_a21oi_1
XFILLER_124_814 VDD VSS sg13g2_decap_4
X_13181_ _13181_/Y _14791_/Q _13220_/A2 _13220_/B1 VDD VSS sg13g2_o21ai_1
XFILLER_135_151 VDD VSS sg13g2_decap_8
X_10393_ _10401_/C _14822_/Q _10392_/A VDD VSS sg13g2_nor2b_1
XFILLER_100_1459 VDD VSS sg13g2_decap_8
XFILLER_163_471 VDD VSS sg13g2_decap_4
X_12132_ _12132_/Y _12198_/B _12132_/B VDD VSS sg13g2_xnor2_1
XFILLER_78_901 VDD VSS sg13g2_fill_2
XFILLER_151_677 VDD VSS sg13g2_decap_4
X_14377__1895 _14377_/RESET_B VDD VSS sg13g2_tiehi
XFILLER_85_1281 VDD VSS sg13g2_fill_1
XFILLER_46_1232 VDD VSS sg13g2_fill_2
XFILLER_2_665 VDD VSS sg13g2_decap_8
X_12063_ _12063_/Y _12062_/A _12062_/B _12197_/A VDD VSS sg13g2_a21oi_1
XFILLER_1_175 VDD VSS sg13g2_decap_8
XFILLER_49_113 VDD VSS sg13g2_fill_2
X_11014_ _11014_/Y _11043_/A _11014_/B VDD VSS sg13g2_nor2_1
XFILLER_133_1246 VDD VSS sg13g2_decap_8
X_16871_ _16871_/X _16871_/A VDD VSS sg13g2_buf_1
XFILLER_81_1178 VDD VSS sg13g2_decap_8
XFILLER_38_809 VDD VSS sg13g2_decap_8
Xfanout980 _12878_/D _13293_/B VDD VSS sg13g2_buf_1
XFILLER_65_617 VDD VSS sg13g2_decap_8
Xfanout991 _13304_/B _15205_/Q VDD VSS sg13g2_buf_1
XFILLER_93_937 VDD VSS sg13g2_decap_4
XFILLER_18_511 VDD VSS sg13g2_decap_8
XFILLER_77_499 VDD VSS sg13g2_decap_8
XFILLER_92_436 VDD VSS sg13g2_fill_1
XFILLER_20_1427 VDD VSS sg13g2_decap_8
X_13832__2440 _13832_/RESET_B VDD VSS sg13g2_tiehi
X_14592__1680 _14592_/RESET_B VDD VSS sg13g2_tiehi
XFILLER_161_83 VDD VSS sg13g2_decap_8
X_12965_ _12965_/Y _14777_/Q _13236_/A2 _13236_/B1 VDD VSS sg13g2_o21ai_1
XFILLER_166_1000 VDD VSS sg13g2_decap_8
XFILLER_46_875 VDD VSS sg13g2_decap_4
X_14704_ _14704_/Q clkload14/A _14704_/D _14704_/RESET_B VDD VSS sg13g2_dfrbpq_1
X_11916_ _11916_/Y _12055_/A _11917_/A VDD VSS sg13g2_nor2_1
XFILLER_46_897 VDD VSS sg13g2_decap_8
X_12896_ _12896_/Y _14805_/Q _12851_/B _07728_/B _14837_/Q _12917_/B1 VDD VSS sg13g2_a221oi_1
XFILLER_166_1066 VDD VSS sg13g2_decap_8
X_14635_ _14635_/Q clkload9/A _14635_/D _14635_/RESET_B VDD VSS sg13g2_dfrbpq_1
XFILLER_72_193 VDD VSS sg13g2_fill_2
X_11847_ _11847_/X _14573_/Q _14605_/Q _14637_/Q _14669_/Q _11854_/S0 _11598_/C VDD
+ VSS sg13g2_mux4_1
XFILLER_21_709 VDD VSS sg13g2_decap_8
XFILLER_109_1440 VDD VSS sg13g2_decap_8
XFILLER_57_1383 VDD VSS sg13g2_decap_8
X_14212__2060 _14212_/RESET_B VDD VSS sg13g2_tiehi
XFILLER_92_1274 VDD VSS sg13g2_fill_1
XFILLER_144_1342 VDD VSS sg13g2_decap_4
X_14566_ _14566_/Q clkload18/A _14566_/D _14566_/RESET_B VDD VSS sg13g2_dfrbpq_1
X_11778_ _11912_/A _11778_/A _11778_/B VDD VSS sg13g2_nor2_1
XFILLER_144_1364 VDD VSS sg13g2_decap_8
XFILLER_18_1367 VDD VSS sg13g2_decap_8
XFILLER_140_1206 VDD VSS sg13g2_decap_8
XFILLER_159_766 VDD VSS sg13g2_decap_8
XFILLER_186_552 VDD VSS sg13g2_decap_8
XFILLER_9_231 VDD VSS sg13g2_decap_8
XFILLER_158_254 VDD VSS sg13g2_decap_8
XFILLER_186_563 VDD VSS sg13g2_decap_8
X_13517_ _13517_/X _13517_/A _13555_/C VDD VSS sg13g2_and2_1
XFILLER_146_405 VDD VSS sg13g2_decap_8
XFILLER_174_714 VDD VSS sg13g2_decap_8
X_10729_ _10995_/B _09060_/X _10743_/S _08893_/Y VDD VSS sg13g2_a21oi_1
X_14497_ _14497_/Q clkload31/A _14497_/D _14497_/RESET_B VDD VSS sg13g2_dfrbpq_1
XFILLER_173_224 VDD VSS sg13g2_decap_8
XFILLER_179_1438 VDD VSS sg13g2_decap_8
X_13448_ _13449_/B _15199_/Q _13448_/B _13448_/C _13459_/D VDD VSS sg13g2_nand4_1
Xclkload12 clkload12/Y clkload12/A VDD VSS sg13g2_inv_1
Xclkload23 clkload23/X clkload23/A VDD VSS sg13g2_buf_8
XFILLER_127_641 VDD VSS sg13g2_decap_4
XFILLER_155_961 VDD VSS sg13g2_decap_8
Xclkload34 clkload34/Y clkload34/A VDD VSS sg13g2_inv_1
XFILLER_86_1001 VDD VSS sg13g2_decap_8
Xclkload45 clkload45/Y clkload45/A VDD VSS sg13g2_inv_4
Xclkload56 clkload56/Y clkload56/A VDD VSS sg13g2_inv_1
X_13379_ _15079_/D _15079_/Q _13407_/A _13378_/Y VDD VSS sg13g2_a21o_1
Xclkload67 clkload67/X clkload67/A VDD VSS sg13g2_buf_8
Xmax_cap1286 _16872_/A _13710_/Q VDD VSS sg13g2_buf_4
XFILLER_142_611 VDD VSS sg13g2_decap_8
XFILLER_154_471 VDD VSS sg13g2_decap_8
XFILLER_170_920 VDD VSS sg13g2_decap_8
XFILLER_177_1151 VDD VSS sg13g2_decap_8
Xclkload78 clkload78/X clkload78/A VDD VSS sg13g2_buf_8
Xmax_cap1297 output67/A _16861_/A VDD VSS sg13g2_buf_4
X_15118_ _15118_/Q clkload65/A _15118_/D _15118_/RESET_B VDD VSS sg13g2_dfrbpq_1
Xclkload89 clkload89/Y clkload89/A VDD VSS sg13g2_inv_1
XFILLER_115_858 VDD VSS sg13g2_decap_8
XFILLER_126_195 VDD VSS sg13g2_fill_2
XFILLER_141_121 VDD VSS sg13g2_decap_8
XFILLER_170_953 VDD VSS sg13g2_fill_1
XFILLER_141_132 VDD VSS sg13g2_fill_2
XFILLER_86_1089 VDD VSS sg13g2_decap_4
XFILLER_29_1430 VDD VSS sg13g2_decap_8
XFILLER_142_677 VDD VSS sg13g2_decap_8
XFILLER_102_519 VDD VSS sg13g2_fill_1
X_15049_ _15049_/Q clkload71/A _15049_/D _15049_/RESET_B VDD VSS sg13g2_dfrbpq_1
X_07940_ _07940_/Y _07797_/B _07932_/Y _07939_/Y VDD VSS sg13g2_o21ai_1
XFILLER_68_400 VDD VSS sg13g2_decap_8
XFILLER_141_187 VDD VSS sg13g2_decap_8
XFILLER_151_1335 VDD VSS sg13g2_decap_8
X_07871_ _07871_/X _08183_/B _08188_/A VDD VSS sg13g2_or2_1
XFILLER_60_1229 VDD VSS sg13g2_decap_8
X_09610_ _14206_/D _10074_/A0 _14206_/Q _09638_/S VDD VSS sg13g2_mux2_1
XFILLER_110_563 VDD VSS sg13g2_fill_2
XFILLER_99_1428 VDD VSS sg13g2_decap_8
XFILLER_68_477 VDD VSS sg13g2_fill_2
XFILLER_99_1439 VDD VSS sg13g2_fill_1
XFILLER_110_585 VDD VSS sg13g2_decap_8
XFILLER_84_948 VDD VSS sg13g2_fill_1
XFILLER_7_1281 VDD VSS sg13g2_decap_8
XFILLER_110_1021 VDD VSS sg13g2_fill_1
X_09541_ _14139_/D _10138_/A1 _14139_/Q _09572_/S VDD VSS sg13g2_mux2_1
XFILLER_3_1134 VDD VSS sg13g2_decap_8
X_14422__1850 _14422_/RESET_B VDD VSS sg13g2_tiehi
XFILLER_37_853 VDD VSS sg13g2_decap_8
XFILLER_97_1141 VDD VSS sg13g2_decap_8
XFILLER_71_609 VDD VSS sg13g2_decap_8
X_15051__2616 _15051_/RESET_B VDD VSS sg13g2_tiehi
XFILLER_52_801 VDD VSS sg13g2_decap_8
XFILLER_70_108 VDD VSS sg13g2_decap_8
X_09472_ _14073_/D _09472_/A0 _14073_/Q _09472_/S VDD VSS sg13g2_mux2_1
XFILLER_97_1196 VDD VSS sg13g2_fill_1
XFILLER_145_1106 VDD VSS sg13g2_fill_1
X_08423_ _08423_/X _08574_/B _08423_/B VDD VSS sg13g2_xor2_1
XFILLER_184_1177 VDD VSS sg13g2_fill_2
XFILLER_71_1303 VDD VSS sg13g2_fill_1
XFILLER_162_1431 VDD VSS sg13g2_decap_4
X_08354_ _08354_/Y _08414_/D _08354_/B VDD VSS sg13g2_xnor2_1
XFILLER_149_221 VDD VSS sg13g2_decap_8
XFILLER_123_1415 VDD VSS sg13g2_decap_8
XFILLER_36_1478 VDD VSS sg13g2_fill_1
XFILLER_20_742 VDD VSS sg13g2_decap_8
XFILLER_177_574 VDD VSS sg13g2_decap_8
Xclkload6 clkload6/X clkload6/A VDD VSS sg13g2_buf_8
X_08285_ _08286_/C _07923_/Y _07925_/Y _07797_/A VDD VSS sg13g2_a21oi_1
XFILLER_50_28 VDD VSS sg13g2_decap_8
XFILLER_149_298 VDD VSS sg13g2_decap_8
XFILLER_165_758 VDD VSS sg13g2_decap_8
XFILLER_166_28 VDD VSS sg13g2_decap_8
XFILLER_180_706 VDD VSS sg13g2_decap_4
XFILLER_118_663 VDD VSS sg13g2_fill_1
XFILLER_121_1172 VDD VSS sg13g2_decap_8
XFILLER_146_972 VDD VSS sg13g2_fill_1
XFILLER_30_1055 VDD VSS sg13g2_decap_8
XFILLER_30_1066 VDD VSS sg13g2_fill_2
XFILLER_106_825 VDD VSS sg13g2_decap_8
XFILLER_146_994 VDD VSS sg13g2_decap_8
XFILLER_180_739 VDD VSS sg13g2_fill_2
X_13910__2362 _13910_/RESET_B VDD VSS sg13g2_tiehi
XFILLER_161_953 VDD VSS sg13g2_decap_4
XFILLER_106_869 VDD VSS sg13g2_decap_8
XFILLER_132_132 VDD VSS sg13g2_decap_8
XFILLER_59_48 VDD VSS sg13g2_decap_8
XFILLER_8_1001 VDD VSS sg13g2_decap_8
XFILLER_114_880 VDD VSS sg13g2_decap_8
XFILLER_182_49 VDD VSS sg13g2_decap_8
Xfanout210 fanout210/X _09083_/Y VDD VSS sg13g2_buf_1
Xfanout1208 _11591_/A _08306_/C VDD VSS sg13g2_buf_1
X_15192__2870 _15192_/RESET_B VDD VSS sg13g2_tiehi
Xfanout221 _10414_/B _10313_/X VDD VSS sg13g2_buf_1
Xfanout1219 _08863_/A1 _14965_/Q VDD VSS sg13g2_buf_1
XFILLER_82_1454 VDD VSS sg13g2_fill_1
XFILLER_87_731 VDD VSS sg13g2_decap_8
X_14959__2721 _14959_/RESET_B VDD VSS sg13g2_tiehi
XFILLER_120_349 VDD VSS sg13g2_decap_8
X_14254__2018 _14254_/RESET_B VDD VSS sg13g2_tiehi
Xfanout254 _12195_/B1 _11247_/X VDD VSS sg13g2_buf_1
XFILLER_43_1438 VDD VSS sg13g2_decap_4
Xfanout265 _10117_/A0 _10150_/A1 VDD VSS sg13g2_buf_1
XFILLER_87_764 VDD VSS sg13g2_decap_8
XFILLER_101_552 VDD VSS sg13g2_fill_2
XFILLER_75_14 VDD VSS sg13g2_decap_8
XFILLER_59_466 VDD VSS sg13g2_decap_8
XFILLER_19_308 VDD VSS sg13g2_decap_8
X_09808_ _14396_/D _09907_/A1 _14396_/Q _09838_/S VDD VSS sg13g2_mux2_1
XFILLER_8_1078 VDD VSS sg13g2_decap_8
XFILLER_86_296 VDD VSS sg13g2_decap_8
XFILLER_75_58 VDD VSS sg13g2_fill_1
XFILLER_28_831 VDD VSS sg13g2_decap_8
XFILLER_74_447 VDD VSS sg13g2_decap_8
X_09739_ _14330_/D _09739_/A0 _14330_/Q _09739_/S VDD VSS sg13g2_mux2_1
XFILLER_90_907 VDD VSS sg13g2_decap_8
XFILLER_46_149 VDD VSS sg13g2_decap_8
XFILLER_131_31 VDD VSS sg13g2_decap_8
XFILLER_76_1203 VDD VSS sg13g2_decap_8
XFILLER_28_886 VDD VSS sg13g2_decap_8
X_12750_ _15017_/D _12750_/A _12750_/B VDD VSS sg13g2_nor2_1
XFILLER_128_1304 VDD VSS sg13g2_decap_8
XFILLER_15_525 VDD VSS sg13g2_decap_8
X_11701_ _11702_/B _12301_/B1 _11700_/X _11664_/Y _11663_/Y _11723_/A2 VDD VSS sg13g2_a221oi_1
XFILLER_91_35 VDD VSS sg13g2_decap_4
XFILLER_43_856 VDD VSS sg13g2_decap_8
XFILLER_131_97 VDD VSS sg13g2_fill_1
X_12681_ _12694_/A _12956_/B _12765_/A2 _15013_/Q VDD VSS sg13g2_a21oi_1
XFILLER_43_867 VDD VSS sg13g2_fill_2
X_14420_ _14420_/Q clkload55/A _14420_/D _14420_/RESET_B VDD VSS sg13g2_dfrbpq_1
XFILLER_30_517 VDD VSS sg13g2_decap_8
X_11632_ _14968_/D _11632_/A _11632_/B VDD VSS sg13g2_nor2_1
XFILLER_39_1091 VDD VSS sg13g2_decap_8
XFILLER_30_528 VDD VSS sg13g2_fill_1
XFILLER_23_580 VDD VSS sg13g2_decap_4
XFILLER_11_742 VDD VSS sg13g2_decap_8
XFILLER_138_0 VDD VSS sg13g2_decap_8
X_14351_ _14351_/Q _14674_/CLK _14351_/D _14351_/RESET_B VDD VSS sg13g2_dfrbpq_1
XFILLER_24_84 VDD VSS sg13g2_decap_4
X_11563_ _11563_/Y _10702_/A _12294_/A2 _11559_/Y _11562_/Y VDD VSS sg13g2_a22oi_1
XFILLER_183_511 VDD VSS sg13g2_decap_8
XFILLER_10_252 VDD VSS sg13g2_decap_8
XFILLER_128_438 VDD VSS sg13g2_decap_8
XFILLER_155_213 VDD VSS sg13g2_decap_8
X_13302_ _15058_/D _13299_/Y _13302_/B _13427_/B VDD VSS sg13g2_nand3b_1
X_10514_ _10538_/B _10514_/A _10514_/B _10514_/C VDD VSS sg13g2_nand3_1
XFILLER_7_735 VDD VSS sg13g2_decap_8
X_14282_ _14282_/Q clkload16/A _14282_/D _14282_/RESET_B VDD VSS sg13g2_dfrbpq_1
X_11494_ _11495_/A _11488_/X _11489_/X _11493_/X _11492_/X _11494_/S0 _12192_/A VDD
+ VSS sg13g2_mux4_1
XFILLER_13_1253 VDD VSS sg13g2_decap_8
XFILLER_171_706 VDD VSS sg13g2_decap_8
XFILLER_6_245 VDD VSS sg13g2_decap_8
X_13233_ _13233_/X input24/X _12914_/A _13264_/B1 VDD VSS sg13g2_a21o_1
XFILLER_183_588 VDD VSS sg13g2_decap_8
X_10445_ _10459_/C _14838_/Q _14837_/Q _14832_/Q _14831_/Q VDD VSS sg13g2_nand4_1
XFILLER_139_1411 VDD VSS sg13g2_fill_1
X_14464__1808 _14464_/RESET_B VDD VSS sg13g2_tiehi
XFILLER_100_1256 VDD VSS sg13g2_decap_8
XFILLER_164_791 VDD VSS sg13g2_decap_4
XFILLER_87_1365 VDD VSS sg13g2_fill_1
X_13164_ _13164_/Y _14790_/Q _13208_/A2 _13208_/B1 VDD VSS sg13g2_o21ai_1
X_14500__1772 _14500_/RESET_B VDD VSS sg13g2_tiehi
XFILLER_156_83 VDD VSS sg13g2_decap_8
X_10376_ _10379_/C _14817_/Q _10375_/B VDD VSS sg13g2_nor2b_1
XFILLER_3_952 VDD VSS sg13g2_decap_8
XFILLER_124_666 VDD VSS sg13g2_decap_8
XFILLER_135_1308 VDD VSS sg13g2_decap_4
XFILLER_152_975 VDD VSS sg13g2_decap_8
X_12115_ _12115_/X _12115_/A1 _12114_/X _12113_/Y VDD VSS sg13g2_a21o_1
XFILLER_174_1379 VDD VSS sg13g2_decap_8
X_13095_ _13095_/Y _14881_/Q _13180_/B1 _13193_/B VDD VSS sg13g2_a21oi_1
XFILLER_2_462 VDD VSS sg13g2_decap_8
XFILLER_111_327 VDD VSS sg13g2_decap_8
X_12046_ _12046_/Y _12044_/Y _12046_/B _12046_/C VDD VSS sg13g2_nand3b_1
XFILLER_49_70 VDD VSS sg13g2_decap_8
XFILLER_104_390 VDD VSS sg13g2_fill_1
XFILLER_27_7 VDD VSS sg13g2_decap_8
XFILLER_93_701 VDD VSS sg13g2_decap_8
XFILLER_120_872 VDD VSS sg13g2_fill_1
XFILLER_38_617 VDD VSS sg13g2_fill_1
X_16854_ _16854_/X _16854_/A VDD VSS sg13g2_buf_1
XFILLER_19_820 VDD VSS sg13g2_decap_8
XFILLER_4_1421 VDD VSS sg13g2_decap_8
XFILLER_168_1106 VDD VSS sg13g2_decap_8
XFILLER_19_831 VDD VSS sg13g2_fill_1
XFILLER_111_1330 VDD VSS sg13g2_decap_8
XFILLER_92_233 VDD VSS sg13g2_decap_8
XFILLER_19_853 VDD VSS sg13g2_decap_8
XFILLER_20_1224 VDD VSS sg13g2_decap_8
XFILLER_24_1393 VDD VSS sg13g2_decap_8
XFILLER_168_1128 VDD VSS sg13g2_decap_8
XFILLER_1_77 VDD VSS sg13g2_decap_8
X_13997_ _13997_/Q clkload18/A _13997_/D _13997_/RESET_B VDD VSS sg13g2_dfrbpq_1
XFILLER_59_1412 VDD VSS sg13g2_fill_1
XFILLER_52_108 VDD VSS sg13g2_fill_1
XFILLER_111_1385 VDD VSS sg13g2_decap_8
X_12948_ _12948_/Y _14808_/Q _13274_/A2 _13218_/B _14840_/Q _13248_/B VDD VSS sg13g2_a221oi_1
XFILLER_52_119 VDD VSS sg13g2_decap_8
XFILLER_18_385 VDD VSS sg13g2_decap_8
XFILLER_45_160 VDD VSS sg13g2_decap_8
XFILLER_185_1453 VDD VSS sg13g2_decap_8
XFILLER_94_1369 VDD VSS sg13g2_decap_8
XFILLER_61_653 VDD VSS sg13g2_decap_4
X_12879_ _12879_/Y _14836_/Q _13273_/B VDD VSS sg13g2_nand2_1
XFILLER_181_1339 VDD VSS sg13g2_decap_8
XFILLER_21_506 VDD VSS sg13g2_decap_8
XFILLER_34_889 VDD VSS sg13g2_decap_8
XFILLER_60_152 VDD VSS sg13g2_decap_4
XFILLER_159_530 VDD VSS sg13g2_decap_4
X_14618_ _14618_/Q clkload53/A _14618_/D _14618_/RESET_B VDD VSS sg13g2_dfrbpq_1
XFILLER_92_1060 VDD VSS sg13g2_fill_2
XFILLER_109_1270 VDD VSS sg13g2_decap_8
XFILLER_53_1044 VDD VSS sg13g2_fill_1
XFILLER_18_1164 VDD VSS sg13g2_decap_8
XFILLER_105_1123 VDD VSS sg13g2_decap_8
X_14549_ _14549_/Q _14727_/CLK _14549_/D _14549_/RESET_B VDD VSS sg13g2_dfrbpq_1
XFILLER_53_1055 VDD VSS sg13g2_fill_1
XFILLER_53_1066 VDD VSS sg13g2_decap_8
XFILLER_140_1025 VDD VSS sg13g2_decap_8
XFILLER_174_533 VDD VSS sg13g2_decap_8
XFILLER_179_1224 VDD VSS sg13g2_decap_4
X_08070_ _08070_/X _08431_/A _08070_/B _08070_/C _08110_/D VDD VSS sg13g2_and4_1
XFILLER_134_408 VDD VSS sg13g2_decap_4
XFILLER_162_717 VDD VSS sg13g2_decap_8
XFILLER_128_983 VDD VSS sg13g2_fill_1
XFILLER_115_600 VDD VSS sg13g2_decap_8
Xmax_cap922 _12605_/S0 _12643_/S0 VDD VSS sg13g2_buf_4
XFILLER_155_780 VDD VSS sg13g2_decap_8
XFILLER_53_0 VDD VSS sg13g2_decap_8
XFILLER_143_964 VDD VSS sg13g2_fill_2
XFILLER_170_761 VDD VSS sg13g2_decap_8
XFILLER_66_1449 VDD VSS sg13g2_decap_8
XFILLER_103_817 VDD VSS sg13g2_decap_8
XFILLER_130_614 VDD VSS sg13g2_fill_2
X_08972_ _10105_/A _14895_/Q _08971_/X _09057_/A VDD VSS sg13g2_mux2_1
XFILLER_88_528 VDD VSS sg13g2_decap_8
XFILLER_102_349 VDD VSS sg13g2_decap_4
X_07923_ _07923_/Y _07909_/Y _07921_/Y _07904_/A VDD VSS sg13g2_o21ai_1
XFILLER_151_1121 VDD VSS sg13g2_decap_8
XFILLER_9_1365 VDD VSS sg13g2_decap_8
XFILLER_111_861 VDD VSS sg13g2_decap_8
XFILLER_5_1218 VDD VSS sg13g2_decap_8
XFILLER_96_572 VDD VSS sg13g2_decap_8
XFILLER_57_926 VDD VSS sg13g2_decap_8
X_07854_ _08643_/D _07855_/A _07855_/B VDD VSS sg13g2_nor2_1
XFILLER_84_723 VDD VSS sg13g2_fill_2
XFILLER_29_628 VDD VSS sg13g2_decap_8
XFILLER_25_1168 VDD VSS sg13g2_decap_8
XFILLER_29_639 VDD VSS sg13g2_fill_1
XFILLER_83_222 VDD VSS sg13g2_decap_8
XFILLER_56_447 VDD VSS sg13g2_decap_8
X_07785_ _08414_/A _07786_/A _08351_/B VDD VSS sg13g2_nor2_1
XFILLER_83_255 VDD VSS sg13g2_decap_8
XFILLER_45_28 VDD VSS sg13g2_decap_8
X_09524_ _14123_/D _09724_/A0 _14123_/Q _09530_/S VDD VSS sg13g2_mux2_1
XFILLER_65_981 VDD VSS sg13g2_fill_2
XFILLER_43_119 VDD VSS sg13g2_decap_8
XFILLER_24_300 VDD VSS sg13g2_decap_4
XFILLER_36_171 VDD VSS sg13g2_decap_8
XFILLER_80_940 VDD VSS sg13g2_fill_2
XFILLER_64_491 VDD VSS sg13g2_fill_1
X_09455_ _14056_/D _09620_/A0 _14056_/Q wire504/X VDD VSS sg13g2_mux2_1
XFILLER_80_962 VDD VSS sg13g2_fill_1
XFILLER_52_653 VDD VSS sg13g2_decap_8
XFILLER_51_130 VDD VSS sg13g2_decap_8
X_13928__2344 _13928_/RESET_B VDD VSS sg13g2_tiehi
X_14688__1584 _14688_/RESET_B VDD VSS sg13g2_tiehi
X_08406_ _08406_/X _08406_/A _08511_/S VDD VSS sg13g2_and2_1
XFILLER_12_539 VDD VSS sg13g2_decap_8
X_09386_ _13989_/D _09949_/A1 _13989_/Q _09399_/S VDD VSS sg13g2_mux2_1
XFILLER_36_1231 VDD VSS sg13g2_decap_8
X_08337_ _08337_/X _11661_/A _08879_/A1 _11591_/A _11570_/A _08009_/S _07627_/A VDD
+ VSS sg13g2_mux4_1
XFILLER_131_7 VDD VSS sg13g2_decap_4
XFILLER_165_511 VDD VSS sg13g2_decap_8
XFILLER_177_371 VDD VSS sg13g2_decap_8
XFILLER_71_1166 VDD VSS sg13g2_decap_8
XFILLER_36_1286 VDD VSS sg13g2_decap_8
XFILLER_32_1117 VDD VSS sg13g2_decap_8
XFILLER_177_49 VDD VSS sg13g2_decap_8
XFILLER_20_561 VDD VSS sg13g2_fill_2
XFILLER_32_1139 VDD VSS sg13g2_fill_1
X_08268_ _08268_/Y _08318_/B _08268_/B VDD VSS sg13g2_xnor2_1
XFILLER_137_268 VDD VSS sg13g2_fill_1
XFILLER_118_460 VDD VSS sg13g2_decap_8
XFILLER_165_599 VDD VSS sg13g2_decap_8
XFILLER_180_525 VDD VSS sg13g2_decap_8
X_08199_ _08201_/C _08244_/B _08223_/S _08199_/C VDD VSS sg13g2_nor3_1
XFILLER_69_1040 VDD VSS sg13g2_decap_8
XFILLER_4_749 VDD VSS sg13g2_decap_8
XFILLER_118_493 VDD VSS sg13g2_decap_4
X_10230_ _10232_/A _14771_/Q _10234_/D _14772_/Q VDD VSS sg13g2_a21o_1
XFILLER_106_644 VDD VSS sg13g2_decap_8
XFILLER_10_42 VDD VSS sg13g2_decap_8
XFILLER_156_1032 VDD VSS sg13g2_decap_8
XFILLER_3_259 VDD VSS sg13g2_decap_8
XFILLER_156_1043 VDD VSS sg13g2_fill_1
XFILLER_69_1095 VDD VSS sg13g2_fill_1
XFILLER_0_911 VDD VSS sg13g2_decap_8
XFILLER_106_688 VDD VSS sg13g2_decap_8
XFILLER_126_42 VDD VSS sg13g2_decap_8
X_10161_ _14738_/D _14738_/Q _10161_/A1 _10168_/S VDD VSS sg13g2_mux2_1
XFILLER_121_625 VDD VSS sg13g2_decap_8
XFILLER_133_485 VDD VSS sg13g2_decap_8
Xfanout1005 _13396_/B _10201_/A1 VDD VSS sg13g2_buf_1
XFILLER_120_124 VDD VSS sg13g2_decap_8
Xfanout1016 _13180_/B1 _07727_/C VDD VSS sg13g2_buf_1
XFILLER_47_1371 VDD VSS sg13g2_decap_8
Xfanout1027 _13273_/B _15107_/Q VDD VSS sg13g2_buf_1
XFILLER_82_1262 VDD VSS sg13g2_decap_8
Xfanout1038 _08248_/A _08391_/A VDD VSS sg13g2_buf_1
X_10092_ _14672_/D _10092_/A0 _14672_/Q _10093_/S VDD VSS sg13g2_mux2_1
XFILLER_94_509 VDD VSS sg13g2_decap_8
Xfanout1049 _10843_/C _13310_/B2 VDD VSS sg13g2_buf_1
XFILLER_43_1246 VDD VSS sg13g2_decap_8
XFILLER_0_988 VDD VSS sg13g2_decap_8
XFILLER_134_1363 VDD VSS sg13g2_decap_8
XFILLER_102_883 VDD VSS sg13g2_decap_8
XFILLER_120_179 VDD VSS sg13g2_decap_8
XFILLER_19_105 VDD VSS sg13g2_decap_8
X_13920_ _13920_/Q _14720_/CLK _13920_/D _13920_/RESET_B VDD VSS sg13g2_dfrbpq_1
XFILLER_59_274 VDD VSS sg13g2_decap_8
XFILLER_101_371 VDD VSS sg13g2_decap_8
XFILLER_74_222 VDD VSS sg13g2_decap_8
XFILLER_142_52 VDD VSS sg13g2_fill_1
XFILLER_19_84 VDD VSS sg13g2_decap_8
X_13851_ _13851_/Q clkload58/A _13851_/D _13851_/RESET_B VDD VSS sg13g2_dfrbpq_1
X_12802_ _12802_/Y _12900_/B input11/X _12900_/C VDD VSS sg13g2_nand3_1
X_13782_ _13782_/Q clkload39/A _13782_/D _13782_/RESET_B VDD VSS sg13g2_dfrbpq_1
X_10994_ _11042_/B _10995_/A _10995_/B VDD VSS sg13g2_nor2_1
XFILLER_128_1101 VDD VSS sg13g2_decap_8
XFILLER_15_322 VDD VSS sg13g2_decap_8
XFILLER_90_759 VDD VSS sg13g2_decap_8
X_12733_ _12733_/X _12729_/X _12728_/X _12727_/X _12726_/X _12760_/S0 _12762_/S VDD
+ VSS sg13g2_mux4_1
XFILLER_76_1066 VDD VSS sg13g2_decap_8
XFILLER_35_72 VDD VSS sg13g2_fill_1
X_14518__1754 _14518_/RESET_B VDD VSS sg13g2_tiehi
XFILLER_71_995 VDD VSS sg13g2_fill_2
X_12664_ _12664_/X _12662_/X _12663_/X _12664_/S VDD VSS sg13g2_mux2_1
XFILLER_70_483 VDD VSS sg13g2_fill_1
XFILLER_43_697 VDD VSS sg13g2_decap_8
XFILLER_128_1178 VDD VSS sg13g2_decap_4
XFILLER_15_399 VDD VSS sg13g2_decap_8
XFILLER_93_1380 VDD VSS sg13g2_decap_8
XFILLER_19_1462 VDD VSS sg13g2_decap_8
XFILLER_93_1391 VDD VSS sg13g2_fill_2
XFILLER_19_1473 VDD VSS sg13g2_fill_2
X_14403_ _14403_/Q clkload30/A _14403_/D _14403_/RESET_B VDD VSS sg13g2_dfrbpq_1
X_11615_ _11615_/X _11615_/A _11615_/B VDD VSS sg13g2_and2_1
XFILLER_15_1326 VDD VSS sg13g2_decap_8
X_12595_ _12595_/X _12594_/X _12593_/X _12790_/S VDD VSS sg13g2_mux2_1
XFILLER_141_1345 VDD VSS sg13g2_decap_8
XFILLER_89_1405 VDD VSS sg13g2_fill_2
X_13782__2490 _13782_/RESET_B VDD VSS sg13g2_tiehi
X_14334_ _14334_/Q clkload49/A _14334_/D _14334_/RESET_B VDD VSS sg13g2_dfrbpq_1
X_11546_ _11546_/Y _12238_/S0 _14500_/Q _12184_/B VDD VSS sg13g2_a21oi_1
XFILLER_7_532 VDD VSS sg13g2_decap_8
XFILLER_89_1449 VDD VSS sg13g2_fill_1
XFILLER_128_268 VDD VSS sg13g2_fill_2
XFILLER_13_1050 VDD VSS sg13g2_decap_8
X_14265_ _14265_/Q clkload36/A _14265_/D _14265_/RESET_B VDD VSS sg13g2_dfrbpq_1
XFILLER_183_385 VDD VSS sg13g2_decap_8
X_11477_ _11477_/Y _12292_/A _11477_/B VDD VSS sg13g2_nor2_1
XFILLER_125_931 VDD VSS sg13g2_decap_8
X_13216_ _13216_/Y _13271_/C _13216_/B VDD VSS sg13g2_nand2_1
XFILLER_139_1230 VDD VSS sg13g2_fill_1
XFILLER_143_249 VDD VSS sg13g2_decap_8
X_10428_ _10430_/C _14831_/Q _10453_/C _14832_/Q VDD VSS sg13g2_a21oi_1
X_14196_ _14196_/Q clkload54/A _14196_/D _14196_/RESET_B VDD VSS sg13g2_dfrbpq_1
XFILLER_125_975 VDD VSS sg13g2_decap_8
XFILLER_140_901 VDD VSS sg13g2_decap_8
XFILLER_152_772 VDD VSS sg13g2_fill_1
XFILLER_48_1146 VDD VSS sg13g2_decap_8
X_13147_ _13158_/B _13146_/B _13145_/Y _13170_/C VDD VSS sg13g2_a21o_1
X_10359_ _10359_/Y wire220/X _10400_/B VDD VSS sg13g2_nor2_1
XFILLER_97_325 VDD VSS sg13g2_decap_8
XFILLER_170_1018 VDD VSS sg13g2_decap_8
XFILLER_183_70 VDD VSS sg13g2_decap_8
XFILLER_26_1411 VDD VSS sg13g2_decap_8
XFILLER_111_124 VDD VSS sg13g2_fill_2
XFILLER_174_1198 VDD VSS sg13g2_decap_4
X_13078_ _13092_/A _13078_/A _13172_/A _13172_/B VDD VSS sg13g2_nand3_1
XFILLER_111_157 VDD VSS sg13g2_decap_8
XFILLER_111_168 VDD VSS sg13g2_decap_8
X_12029_ _12029_/Y _12029_/A _12029_/B VDD VSS sg13g2_nand2_1
XFILLER_38_436 VDD VSS sg13g2_decap_8
XFILLER_38_447 VDD VSS sg13g2_fill_2
XFILLER_113_1469 VDD VSS sg13g2_fill_1
XFILLER_66_767 VDD VSS sg13g2_decap_8
XFILLER_65_244 VDD VSS sg13g2_decap_4
XFILLER_19_650 VDD VSS sg13g2_decap_8
XFILLER_24_1190 VDD VSS sg13g2_decap_8
XFILLER_81_726 VDD VSS sg13g2_decap_8
XFILLER_20_1043 VDD VSS sg13g2_decap_8
XFILLER_65_277 VDD VSS sg13g2_decap_8
XFILLER_4_1295 VDD VSS sg13g2_decap_8
XFILLER_94_1122 VDD VSS sg13g2_fill_1
XFILLER_18_182 VDD VSS sg13g2_decap_8
XFILLER_20_1098 VDD VSS sg13g2_decap_8
XFILLER_94_1155 VDD VSS sg13g2_fill_2
XFILLER_185_1272 VDD VSS sg13g2_decap_4
XFILLER_181_1136 VDD VSS sg13g2_fill_1
X_09240_ _10137_/C _09240_/A _10004_/C VDD VSS sg13g2_nand2_1
XFILLER_22_848 VDD VSS sg13g2_fill_2
XFILLER_181_1169 VDD VSS sg13g2_decap_8
XFILLER_166_308 VDD VSS sg13g2_decap_8
XFILLER_178_168 VDD VSS sg13g2_decap_8
XFILLER_21_347 VDD VSS sg13g2_decap_8
X_09171_ _13787_/D _13787_/Q _09939_/A1 _09202_/S VDD VSS sg13g2_mux2_1
XFILLER_72_1464 VDD VSS sg13g2_decap_8
X_08122_ _08122_/Y _08452_/D _08121_/X _08120_/Y VDD VSS sg13g2_o21ai_1
XFILLER_33_1448 VDD VSS sg13g2_decap_8
XFILLER_119_246 VDD VSS sg13g2_decap_8
XFILLER_174_352 VDD VSS sg13g2_decap_8
XFILLER_179_1043 VDD VSS sg13g2_decap_4
XFILLER_175_897 VDD VSS sg13g2_decap_8
X_08053_ _08053_/Y _12128_/A _08054_/B VDD VSS sg13g2_nand2b_1
XFILLER_115_430 VDD VSS sg13g2_decap_8
XFILLER_162_569 VDD VSS sg13g2_decap_8
XFILLER_66_1213 VDD VSS sg13g2_decap_8
XFILLER_143_750 VDD VSS sg13g2_decap_8
XFILLER_157_1352 VDD VSS sg13g2_decap_8
XFILLER_116_986 VDD VSS sg13g2_decap_8
XFILLER_131_912 VDD VSS sg13g2_decap_8
Xhold3113 input32/A mem_axi_rdata[6] VDD VSS sg13g2_dlygate4sd3_1
XFILLER_88_314 VDD VSS sg13g2_fill_2
Xhold3124 hold3124/X input29/X VDD VSS sg13g2_dlygate4sd3_1
XFILLER_115_496 VDD VSS sg13g2_decap_8
Xhold3135 hold3135/X input8/X VDD VSS sg13g2_dlygate4sd3_1
XFILLER_118_1358 VDD VSS sg13g2_fill_2
Xhold3146 hold3146/X input9/X VDD VSS sg13g2_dlygate4sd3_1
X_14835__2967 _14835_/RESET_B VDD VSS sg13g2_tiehi
Xhold3157 hold3157/X input23/X VDD VSS sg13g2_dlygate4sd3_1
X_08955_ _08955_/X _08954_/X _12300_/A _08955_/S VDD VSS sg13g2_mux2_1
Xhold3168 input12/A mem_axi_rdata[17] VDD VSS sg13g2_dlygate4sd3_1
Xhold3179 hold3179/X input27/X VDD VSS sg13g2_dlygate4sd3_1
XFILLER_9_1162 VDD VSS sg13g2_decap_8
XFILLER_102_168 VDD VSS sg13g2_decap_8
X_07906_ _07908_/A _07797_/X _07906_/B _07906_/C VDD VSS sg13g2_nand3b_1
XFILLER_5_1015 VDD VSS sg13g2_decap_8
XFILLER_116_1071 VDD VSS sg13g2_decap_4
X_08886_ _08886_/Y _08884_/Y _08885_/Y _08850_/S VDD VSS sg13g2_a21oi_1
X_14171__2101 _14171_/RESET_B VDD VSS sg13g2_tiehi
XFILLER_40_1419 VDD VSS sg13g2_decap_8
XFILLER_84_531 VDD VSS sg13g2_decap_4
XFILLER_57_745 VDD VSS sg13g2_fill_2
XFILLER_56_49 VDD VSS sg13g2_decap_4
X_07837_ _08698_/A _08673_/B _15019_/Q VDD VSS sg13g2_nand2b_1
XFILLER_17_609 VDD VSS sg13g2_decap_8
XFILLER_45_929 VDD VSS sg13g2_decap_8
XFILLER_179_7 VDD VSS sg13g2_decap_8
XFILLER_16_119 VDD VSS sg13g2_decap_8
X_07768_ _08265_/B _07929_/B _08263_/B VDD VSS sg13g2_and2_1
XFILLER_72_748 VDD VSS sg13g2_decap_8
XFILLER_77_1342 VDD VSS sg13g2_fill_2
X_09507_ _09507_/Y _10070_/A _10105_/B _09606_/C VDD VSS sg13g2_nand3_1
XFILLER_129_1432 VDD VSS sg13g2_decap_8
XFILLER_164_1312 VDD VSS sg13g2_decap_8
XFILLER_25_653 VDD VSS sg13g2_decap_8
XFILLER_129_1443 VDD VSS sg13g2_fill_2
X_07699_ _07700_/C _15078_/Q _15081_/Q _07694_/Y VDD VSS sg13g2_o21ai_1
XFILLER_77_1386 VDD VSS sg13g2_decap_8
XFILLER_13_826 VDD VSS sg13g2_decap_8
XFILLER_164_1345 VDD VSS sg13g2_decap_4
X_09438_ _14040_/D _10134_/A0 _14040_/Q _09438_/S VDD VSS sg13g2_mux2_1
XFILLER_38_1359 VDD VSS sg13g2_decap_8
XFILLER_52_494 VDD VSS sg13g2_fill_1
XFILLER_12_336 VDD VSS sg13g2_decap_8
XFILLER_9_819 VDD VSS sg13g2_decap_8
XFILLER_184_105 VDD VSS sg13g2_decap_8
X_09369_ _13973_/D _09998_/A0 _13973_/Q _09373_/S VDD VSS sg13g2_mux2_1
XFILLER_138_511 VDD VSS sg13g2_decap_4
XFILLER_123_1031 VDD VSS sg13g2_decap_8
XFILLER_8_329 VDD VSS sg13g2_decap_8
X_11400_ _11401_/B _11415_/S _14655_/Q VDD VSS sg13g2_nand2_1
X_12380_ _12380_/X _13949_/Q _13981_/Q _14013_/Q _14045_/Q _12618_/S0 _12618_/S1 VDD
+ VSS sg13g2_mux4_1
XFILLER_165_341 VDD VSS sg13g2_decap_4
X_11331_ _11331_/Y _11832_/C _11330_/X _12223_/A VDD VSS sg13g2_a21oi_1
XFILLER_123_1097 VDD VSS sg13g2_decap_4
XFILLER_153_514 VDD VSS sg13g2_fill_1
XFILLER_138_599 VDD VSS sg13g2_decap_8
XFILLER_125_227 VDD VSS sg13g2_decap_8
XFILLER_180_322 VDD VSS sg13g2_decap_8
XFILLER_21_63 VDD VSS sg13g2_decap_8
XFILLER_181_856 VDD VSS sg13g2_decap_8
XFILLER_137_41 VDD VSS sg13g2_fill_1
X_14050_ _14050_/Q clkload45/A _14050_/D _14050_/RESET_B VDD VSS sg13g2_dfrbpq_1
XFILLER_107_953 VDD VSS sg13g2_decap_8
XFILLER_141_709 VDD VSS sg13g2_fill_2
X_11262_ _11262_/Y _11262_/A _11262_/B VDD VSS sg13g2_nand2_1
XFILLER_4_546 VDD VSS sg13g2_decap_8
XFILLER_49_1422 VDD VSS sg13g2_fill_2
XFILLER_101_1384 VDD VSS sg13g2_fill_2
XFILLER_10_1267 VDD VSS sg13g2_decap_8
X_13001_ _13001_/Y _14875_/Q _13028_/B _13082_/B VDD VSS sg13g2_a21oi_1
X_10213_ _10213_/X _10213_/A _10213_/B VDD VSS sg13g2_and2_1
XFILLER_121_400 VDD VSS sg13g2_decap_8
XFILLER_180_399 VDD VSS sg13g2_decap_8
X_11193_ _11193_/Y _11199_/B _11193_/A2 _11207_/B1 VDD VSS sg13g2_a21oi_1
XFILLER_49_1477 VDD VSS sg13g2_fill_2
XFILLER_122_945 VDD VSS sg13g2_decap_8
X_10144_ _14721_/D _14721_/Q _10144_/A1 _10168_/S VDD VSS sg13g2_mux2_1
XFILLER_97_89 VDD VSS sg13g2_fill_2
XFILLER_121_477 VDD VSS sg13g2_decap_8
XFILLER_0_785 VDD VSS sg13g2_decap_8
X_14952_ _14952_/Q clkload70/A _14952_/D _14952_/RESET_B VDD VSS sg13g2_dfrbpq_1
X_10075_ _14655_/D _10075_/A0 _14655_/Q _10096_/S VDD VSS sg13g2_mux2_1
XFILLER_47_200 VDD VSS sg13g2_fill_1
X_13903_ _13903_/Q clkload13/A _13903_/D _13903_/RESET_B VDD VSS sg13g2_dfrbpq_1
XFILLER_130_1046 VDD VSS sg13g2_decap_8
XFILLER_43_1098 VDD VSS sg13g2_fill_1
X_14883_ _14883_/Q _14883_/CLK _14883_/D _14883_/RESET_B VDD VSS sg13g2_dfrbpq_1
XFILLER_75_575 VDD VSS sg13g2_decap_8
XFILLER_47_277 VDD VSS sg13g2_decap_8
XFILLER_78_1139 VDD VSS sg13g2_fill_1
XFILLER_1_1435 VDD VSS sg13g2_decap_8
X_13834_ _13834_/Q clkload27/A _13834_/D _13834_/RESET_B VDD VSS sg13g2_dfrbpq_1
Xclkbuf_5_5__f_clk_i clkload1/A clkbuf_4_2_0_clk_i/X VDD VSS sg13g2_buf_16
XFILLER_90_545 VDD VSS sg13g2_decap_8
XFILLER_63_759 VDD VSS sg13g2_fill_1
XFILLER_21_1396 VDD VSS sg13g2_decap_8
X_13765_ _13765_/Q _14725_/CLK _13765_/D _13765_/RESET_B VDD VSS sg13g2_dfrbpq_1
XFILLER_95_1464 VDD VSS sg13g2_decap_8
XFILLER_44_962 VDD VSS sg13g2_fill_1
XFILLER_182_1423 VDD VSS sg13g2_fill_1
X_10977_ _10978_/B _10949_/Y _11004_/A _11009_/B VDD VSS sg13g2_a21oi_1
XFILLER_90_578 VDD VSS sg13g2_fill_2
XFILLER_62_269 VDD VSS sg13g2_decap_8
XFILLER_56_1426 VDD VSS sg13g2_decap_8
XFILLER_44_973 VDD VSS sg13g2_fill_1
XFILLER_16_686 VDD VSS sg13g2_decap_8
XFILLER_71_770 VDD VSS sg13g2_fill_2
XFILLER_43_461 VDD VSS sg13g2_decap_8
XFILLER_182_1445 VDD VSS sg13g2_decap_8
XFILLER_149_809 VDD VSS sg13g2_decap_4
X_12716_ _12716_/X _14389_/Q _14421_/Q _14485_/Q _14517_/Q _12717_/S0 _12717_/S1 VDD
+ VSS sg13g2_mux4_1
X_13696_ _16858_/A _15224_/CLK _13696_/D _13696_/RESET_B VDD VSS sg13g2_dfrbpq_1
X_14034__2238 _14034_/RESET_B VDD VSS sg13g2_tiehi
XFILLER_94_7 VDD VSS sg13g2_decap_8
XFILLER_15_196 VDD VSS sg13g2_decap_8
XFILLER_176_606 VDD VSS sg13g2_fill_1
XFILLER_31_656 VDD VSS sg13g2_decap_8
XFILLER_30_122 VDD VSS sg13g2_fill_1
XFILLER_175_105 VDD VSS sg13g2_decap_8
X_12647_ _12647_/X _13968_/Q _14000_/Q _14032_/Q _14064_/Q _12661_/S0 _12661_/S1 VDD
+ VSS sg13g2_mux4_1
XFILLER_169_680 VDD VSS sg13g2_decap_8
XFILLER_157_831 VDD VSS sg13g2_decap_8
XFILLER_15_1123 VDD VSS sg13g2_decap_8
XFILLER_141_1131 VDD VSS sg13g2_decap_8
XFILLER_178_70 VDD VSS sg13g2_decap_8
XFILLER_180_1180 VDD VSS sg13g2_decap_8
XFILLER_106_1262 VDD VSS sg13g2_decap_8
XFILLER_7_21 VDD VSS sg13g2_decap_8
XFILLER_184_650 VDD VSS sg13g2_decap_8
X_12578_ _12578_/X _14251_/Q _14283_/Q _14315_/Q _14347_/Q _12600_/S0 _12600_/S1 VDD
+ VSS sg13g2_mux4_1
XFILLER_30_199 VDD VSS sg13g2_decap_8
XFILLER_106_1284 VDD VSS sg13g2_fill_2
XFILLER_172_801 VDD VSS sg13g2_fill_1
XFILLER_184_661 VDD VSS sg13g2_decap_8
XFILLER_144_514 VDD VSS sg13g2_fill_1
X_14317_ _14317_/Q _14669_/CLK _14317_/D _14317_/RESET_B VDD VSS sg13g2_dfrbpq_1
X_11529_ _11533_/A _11528_/X _12233_/B VDD VSS sg13g2_nand2b_1
XFILLER_89_1246 VDD VSS sg13g2_decap_8
XFILLER_8_896 VDD VSS sg13g2_decap_8
XFILLER_172_845 VDD VSS sg13g2_decap_8
XFILLER_176_1216 VDD VSS sg13g2_fill_1
XFILLER_183_182 VDD VSS sg13g2_decap_8
XFILLER_7_98 VDD VSS sg13g2_decap_8
X_14248_ _14248_/Q clkload27/A _14248_/D _14248_/RESET_B VDD VSS sg13g2_dfrbpq_1
XFILLER_125_750 VDD VSS sg13g2_fill_2
XFILLER_172_889 VDD VSS sg13g2_decap_8
XFILLER_125_772 VDD VSS sg13g2_fill_1
XFILLER_131_219 VDD VSS sg13g2_decap_8
X_15194__2862 _15194_/RESET_B VDD VSS sg13g2_tiehi
X_14179_ _14179_/Q clkload29/A _14179_/D _14179_/RESET_B VDD VSS sg13g2_dfrbpq_1
XFILLER_140_720 VDD VSS sg13g2_decap_8
XFILLER_152_591 VDD VSS sg13g2_decap_8
Xfanout809 _08301_/S _07631_/Y VDD VSS sg13g2_buf_1
XFILLER_97_122 VDD VSS sg13g2_decap_8
XFILLER_86_807 VDD VSS sg13g2_decap_8
XFILLER_6_1302 VDD VSS sg13g2_decap_8
X_14987__2693 _14987_/RESET_B VDD VSS sg13g2_tiehi
X_08740_ _08740_/Y _13665_/Q _08801_/B VDD VSS sg13g2_nor2_1
XFILLER_61_1132 VDD VSS sg13g2_decap_8
XFILLER_112_499 VDD VSS sg13g2_decap_8
XFILLER_26_1285 VDD VSS sg13g2_decap_8
XFILLER_16_0 VDD VSS sg13g2_decap_8
Xfanout1380 _11444_/S1 fanout1381/X VDD VSS sg13g2_buf_1
Xfanout1391 _11738_/S _11963_/S0 VDD VSS sg13g2_buf_1
X_08671_ _08671_/Y _08599_/C _08029_/Y _08520_/X _08599_/A _08670_/Y VDD VSS sg13g2_a221oi_1
XFILLER_6_1379 VDD VSS sg13g2_decap_8
XFILLER_22_1149 VDD VSS sg13g2_decap_8
X_07622_ _07622_/Y _14861_/Q VDD VSS sg13g2_inv_1
XFILLER_53_203 VDD VSS sg13g2_decap_8
XFILLER_54_748 VDD VSS sg13g2_decap_8
XFILLER_19_480 VDD VSS sg13g2_decap_8
XFILLER_4_1092 VDD VSS sg13g2_decap_8
XFILLER_35_951 VDD VSS sg13g2_decap_8
XFILLER_185_1080 VDD VSS sg13g2_decap_8
XFILLER_185_1091 VDD VSS sg13g2_fill_1
XFILLER_179_455 VDD VSS sg13g2_decap_8
XFILLER_107_1015 VDD VSS sg13g2_decap_8
XFILLER_21_133 VDD VSS sg13g2_decap_8
X_09223_ _13834_/D _10153_/A1 _13834_/Q _09233_/S VDD VSS sg13g2_mux2_1
XFILLER_166_105 VDD VSS sg13g2_decap_8
XFILLER_167_628 VDD VSS sg13g2_fill_2
XFILLER_148_831 VDD VSS sg13g2_decap_8
XFILLER_33_1223 VDD VSS sg13g2_fill_1
XFILLER_72_1283 VDD VSS sg13g2_decap_8
X_09154_ _09154_/Y _15248_/Q _09161_/S VDD VSS sg13g2_nand2b_1
XFILLER_182_609 VDD VSS sg13g2_decap_8
XFILLER_124_1384 VDD VSS sg13g2_fill_2
XFILLER_135_503 VDD VSS sg13g2_decap_8
X_08105_ _08105_/Y _08105_/A _08138_/B VDD VSS sg13g2_nor2_1
XFILLER_107_205 VDD VSS sg13g2_decap_8
XFILLER_181_119 VDD VSS sg13g2_decap_8
XFILLER_108_739 VDD VSS sg13g2_decap_8
XFILLER_163_834 VDD VSS sg13g2_decap_8
X_09085_ _09085_/Y _15238_/Q _09147_/B VDD VSS sg13g2_nand2b_1
XFILLER_159_1436 VDD VSS sg13g2_decap_8
XFILLER_174_182 VDD VSS sg13g2_decap_8
XFILLER_68_1319 VDD VSS sg13g2_fill_1
X_08036_ _08039_/B _08036_/A _08110_/D _08234_/B _08236_/S VDD VSS sg13g2_nand4_1
XFILLER_174_28 VDD VSS sg13g2_decap_8
XFILLER_162_355 VDD VSS sg13g2_decap_8
XFILLER_104_901 VDD VSS sg13g2_decap_8
XFILLER_163_889 VDD VSS sg13g2_fill_2
X_13878__2394 _13878_/RESET_B VDD VSS sg13g2_tiehi
XFILLER_116_783 VDD VSS sg13g2_decap_8
XFILLER_118_1111 VDD VSS sg13g2_decap_8
XFILLER_104_934 VDD VSS sg13g2_decap_4
XFILLER_153_1002 VDD VSS sg13g2_fill_1
Xmax_cap582 _10247_/D _10237_/Y VDD VSS sg13g2_buf_2
XFILLER_107_44 VDD VSS sg13g2_fill_1
XFILLER_88_111 VDD VSS sg13g2_decap_8
XFILLER_131_742 VDD VSS sg13g2_fill_2
XFILLER_104_967 VDD VSS sg13g2_decap_8
XFILLER_89_656 VDD VSS sg13g2_decap_4
XFILLER_118_1155 VDD VSS sg13g2_fill_1
XFILLER_130_230 VDD VSS sg13g2_fill_1
XFILLER_103_455 VDD VSS sg13g2_fill_2
X_09987_ _14570_/D _10086_/A0 _14570_/Q _09990_/S VDD VSS sg13g2_mux2_1
XFILLER_88_155 VDD VSS sg13g2_decap_8
XFILLER_27_1049 VDD VSS sg13g2_fill_1
XFILLER_67_48 VDD VSS sg13g2_decap_4
XFILLER_118_1188 VDD VSS sg13g2_fill_2
XFILLER_76_317 VDD VSS sg13g2_decap_8
X_08938_ _13718_/D _16880_/A _08937_/X _08938_/S VDD VSS sg13g2_mux2_1
XFILLER_131_1311 VDD VSS sg13g2_decap_4
XFILLER_130_296 VDD VSS sg13g2_fill_1
XFILLER_123_21 VDD VSS sg13g2_fill_1
XFILLER_131_1344 VDD VSS sg13g2_fill_2
XFILLER_57_553 VDD VSS sg13g2_decap_4
X_08869_ _08869_/Y _10788_/S _14935_/Q VDD VSS sg13g2_nor2b_1
XFILLER_29_255 VDD VSS sg13g2_fill_2
XFILLER_17_406 VDD VSS sg13g2_decap_8
XFILLER_83_14 VDD VSS sg13g2_decap_4
X_10900_ _10900_/Y _10899_/Y _10896_/Y _07702_/X VDD VSS sg13g2_o21ai_1
X_11880_ _11880_/Y _11880_/A1 _14670_/Q _11894_/B VDD VSS sg13g2_a21oi_1
XFILLER_29_299 VDD VSS sg13g2_fill_1
XFILLER_166_1429 VDD VSS sg13g2_decap_8
XFILLER_83_58 VDD VSS sg13g2_fill_2
X_10831_ _10832_/A _10831_/A _10831_/B _10831_/C VDD VSS sg13g2_nand3_1
XFILLER_38_1112 VDD VSS sg13g2_decap_8
XFILLER_26_984 VDD VSS sg13g2_decap_8
XFILLER_16_63 VDD VSS sg13g2_decap_8
XFILLER_13_623 VDD VSS sg13g2_decap_8
XFILLER_164_1142 VDD VSS sg13g2_decap_8
X_13550_ _13550_/Y _08063_/A _13564_/A2 _13549_/Y VDD VSS sg13g2_a21oi_1
XFILLER_77_1194 VDD VSS sg13g2_decap_8
XFILLER_41_932 VDD VSS sg13g2_fill_1
X_10762_ _10762_/Y _10767_/A _10762_/B VDD VSS sg13g2_nor2_1
XFILLER_52_280 VDD VSS sg13g2_decap_8
XFILLER_129_1284 VDD VSS sg13g2_decap_4
XFILLER_40_431 VDD VSS sg13g2_decap_8
XFILLER_12_133 VDD VSS sg13g2_decap_8
X_12501_ _12501_/X _14246_/Q _14278_/Q _14310_/Q _14342_/Q _12606_/S0 _12606_/S1 VDD
+ VSS sg13g2_mux4_1
XFILLER_41_965 VDD VSS sg13g2_decap_8
XFILLER_40_442 VDD VSS sg13g2_fill_2
XFILLER_9_616 VDD VSS sg13g2_decap_8
XFILLER_125_1148 VDD VSS sg13g2_decap_8
XFILLER_186_948 VDD VSS sg13g2_decap_8
X_13481_ _13484_/A _13481_/A _15176_/Q _13482_/B VDD VSS sg13g2_nand3_1
XFILLER_186_959 VDD VSS sg13g2_decap_8
X_10693_ _14900_/D _10693_/A VDD VSS sg13g2_inv_1
XFILLER_157_138 VDD VSS sg13g2_fill_2
X_15220_ _15220_/Q _15224_/CLK _15220_/D _15220_/RESET_B VDD VSS sg13g2_dfrbpq_1
XFILLER_8_126 VDD VSS sg13g2_decap_8
XFILLER_16_1454 VDD VSS sg13g2_decap_8
X_12432_ _12432_/X _13729_/Q _14081_/Q _14433_/Q _14529_/Q _12550_/S0 _12550_/S1 VDD
+ VSS sg13g2_mux4_1
XFILLER_103_1413 VDD VSS sg13g2_decap_8
XFILLER_185_469 VDD VSS sg13g2_decap_8
XFILLER_166_650 VDD VSS sg13g2_decap_8
X_13665__2635 _13665_/RESET_B VDD VSS sg13g2_tiehi
XFILLER_120_0 VDD VSS sg13g2_decap_8
XFILLER_126_503 VDD VSS sg13g2_decap_8
XFILLER_172_119 VDD VSS sg13g2_decap_8
X_15151_ _15151_/Q clkload86/A _15151_/D _15151_/RESET_B VDD VSS sg13g2_dfrbpq_1
XFILLER_32_84 VDD VSS sg13g2_decap_8
X_12363_ _12363_/X _14108_/Q _14140_/Q _14172_/Q _14204_/Q _12366_/S0 _12366_/S1 VDD
+ VSS sg13g2_mux4_1
XFILLER_5_833 VDD VSS sg13g2_decap_8
X_14102_ _14102_/Q clkload41/A _14102_/D _14102_/RESET_B VDD VSS sg13g2_dfrbpq_1
X_11314_ _11314_/Y _11317_/A1 _14365_/Q VDD VSS sg13g2_nand2b_1
X_15082_ _15082_/Q clkload88/A _15082_/D _15082_/RESET_B VDD VSS sg13g2_dfrbpq_1
XFILLER_107_750 VDD VSS sg13g2_decap_8
XFILLER_126_569 VDD VSS sg13g2_decap_8
X_12294_ _12294_/Y _14924_/Q _12294_/A2 _12294_/B1 VDD VSS sg13g2_a21oi_1
XFILLER_4_343 VDD VSS sg13g2_decap_8
XFILLER_10_1064 VDD VSS sg13g2_decap_8
XFILLER_181_686 VDD VSS sg13g2_decap_8
X_13708__2564 _13708_/RESET_B VDD VSS sg13g2_tiehi
X_14916__2805 _14916_/RESET_B VDD VSS sg13g2_tiehi
X_14033_ _14033_/Q clkload6/A _14033_/D _14033_/RESET_B VDD VSS sg13g2_dfrbpq_1
X_11245_ _11245_/Y _11245_/A _11245_/B _11245_/C VDD VSS sg13g2_nand3_1
XFILLER_175_1260 VDD VSS sg13g2_decap_8
XFILLER_49_1263 VDD VSS sg13g2_decap_8
XFILLER_180_196 VDD VSS sg13g2_decap_8
XFILLER_136_1233 VDD VSS sg13g2_decap_4
XFILLER_80_1018 VDD VSS sg13g2_decap_8
X_11176_ _11177_/B _11171_/B _11147_/Y _11175_/Y VDD VSS sg13g2_a21o_1
XFILLER_68_818 VDD VSS sg13g2_fill_2
XFILLER_171_1146 VDD VSS sg13g2_fill_1
XFILLER_95_604 VDD VSS sg13g2_fill_2
XFILLER_0_560 VDD VSS sg13g2_decap_8
XFILLER_121_274 VDD VSS sg13g2_fill_1
XFILLER_122_797 VDD VSS sg13g2_decap_8
X_10127_ _14705_/D _10160_/A1 _14705_/Q _10127_/S VDD VSS sg13g2_mux2_1
XFILLER_23_1414 VDD VSS sg13g2_decap_8
XFILLER_121_296 VDD VSS sg13g2_decap_8
X_14949__2739 _14949_/RESET_B VDD VSS sg13g2_tiehi
X_14935_ _14935_/Q clkload75/A _14935_/D _14935_/RESET_B VDD VSS sg13g2_dfrbpq_1
X_10058_ _14639_/D _10091_/A0 _14639_/Q _10069_/S VDD VSS sg13g2_mux2_1
XFILLER_91_821 VDD VSS sg13g2_decap_8
XFILLER_110_1439 VDD VSS sg13g2_decap_4
X_14866_ _14866_/Q clkload65/A _14866_/D _14866_/RESET_B VDD VSS sg13g2_dfrbpq_1
XFILLER_1_1232 VDD VSS sg13g2_decap_8
XFILLER_63_556 VDD VSS sg13g2_decap_8
XFILLER_17_962 VDD VSS sg13g2_decap_4
XFILLER_21_1193 VDD VSS sg13g2_decap_8
X_13817_ _13817_/Q _14745_/CLK _13817_/D _13817_/RESET_B VDD VSS sg13g2_dfrbpq_1
XFILLER_90_353 VDD VSS sg13g2_decap_8
X_14267__2005 _14267_/RESET_B VDD VSS sg13g2_tiehi
XFILLER_17_984 VDD VSS sg13g2_decap_8
X_14797_ _14797_/Q _14864_/CLK _14797_/D _14797_/RESET_B VDD VSS sg13g2_dfrbpq_1
XFILLER_32_910 VDD VSS sg13g2_decap_4
XFILLER_91_1114 VDD VSS sg13g2_decap_8
XFILLER_44_781 VDD VSS sg13g2_decap_8
XFILLER_16_483 VDD VSS sg13g2_decap_8
XFILLER_50_228 VDD VSS sg13g2_decap_4
X_13748_ _13748_/Q clkload25/A _13748_/D _13748_/RESET_B VDD VSS sg13g2_dfrbpq_1
XFILLER_17_1229 VDD VSS sg13g2_decap_8
XFILLER_182_1275 VDD VSS sg13g2_decap_8
X_13679_ _13679_/Q _15212_/CLK _13679_/D _13679_/RESET_B VDD VSS sg13g2_dfrbpq_1
XFILLER_148_149 VDD VSS sg13g2_decap_8
XFILLER_31_497 VDD VSS sg13g2_fill_1
XFILLER_176_469 VDD VSS sg13g2_decap_8
XFILLER_117_503 VDD VSS sg13g2_decap_8
XFILLER_106_1092 VDD VSS sg13g2_decap_4
XFILLER_157_683 VDD VSS sg13g2_fill_2
X_15058__2594 _15058_/RESET_B VDD VSS sg13g2_tiehi
XFILLER_89_1054 VDD VSS sg13g2_decap_8
XFILLER_156_182 VDD VSS sg13g2_decap_8
XFILLER_8_693 VDD VSS sg13g2_decap_8
XFILLER_172_653 VDD VSS sg13g2_decap_8
XFILLER_144_366 VDD VSS sg13g2_decap_8
X_14764__3043 _14764_/RESET_B VDD VSS sg13g2_tiehi
X_09910_ _14495_/D _14495_/Q _08989_/X _09937_/S VDD VSS sg13g2_mux2_1
XFILLER_176_1079 VDD VSS sg13g2_decap_8
XFILLER_154_1311 VDD VSS sg13g2_decap_8
XFILLER_99_943 VDD VSS sg13g2_decap_8
XFILLER_98_420 VDD VSS sg13g2_decap_8
XFILLER_113_731 VDD VSS sg13g2_decap_8
XFILLER_99_954 VDD VSS sg13g2_fill_1
XFILLER_98_431 VDD VSS sg13g2_fill_1
XFILLER_67_1374 VDD VSS sg13g2_decap_8
Xfanout606 _13507_/B _08822_/B VDD VSS sg13g2_buf_1
Xfanout617 _13264_/B1 _13049_/X VDD VSS sg13g2_buf_1
X_09841_ _14428_/D _14428_/Q _10072_/A0 _09865_/S VDD VSS sg13g2_mux2_1
Xfanout628 _13161_/A2 _13272_/A2 VDD VSS sg13g2_buf_1
Xfanout639 _11156_/B _11170_/B VDD VSS sg13g2_buf_1
XFILLER_86_615 VDD VSS sg13g2_fill_1
XFILLER_58_306 VDD VSS sg13g2_fill_1
XFILLER_28_1369 VDD VSS sg13g2_decap_4
XFILLER_58_328 VDD VSS sg13g2_decap_8
X_09772_ _14362_/D _14362_/Q _09772_/A1 _09772_/S VDD VSS sg13g2_mux2_1
XFILLER_101_959 VDD VSS sg13g2_decap_8
XFILLER_85_136 VDD VSS sg13g2_decap_8
X_08723_ _08723_/Y _13412_/B _08723_/B VDD VSS sg13g2_nor2_1
XFILLER_6_1176 VDD VSS sg13g2_decap_8
XFILLER_113_1063 VDD VSS sg13g2_decap_4
XFILLER_2_1029 VDD VSS sg13g2_decap_8
X_08654_ _08654_/Y _08654_/A _08654_/B VDD VSS sg13g2_nor2_1
XFILLER_113_1096 VDD VSS sg13g2_decap_8
XFILLER_183_1006 VDD VSS sg13g2_fill_2
XFILLER_148_1137 VDD VSS sg13g2_decap_8
X_08585_ _08586_/C _08608_/B _08576_/Y _08584_/Y VDD VSS sg13g2_o21ai_1
XFILLER_74_1312 VDD VSS sg13g2_fill_1
XFILLER_53_28 VDD VSS sg13g2_decap_8
XFILLER_74_1345 VDD VSS sg13g2_decap_4
XFILLER_165_1473 VDD VSS sg13g2_fill_2
XFILLER_169_28 VDD VSS sg13g2_decap_8
XFILLER_35_1307 VDD VSS sg13g2_fill_1
XFILLER_179_252 VDD VSS sg13g2_decap_8
XFILLER_23_954 VDD VSS sg13g2_decap_8
XFILLER_22_431 VDD VSS sg13g2_decap_8
XFILLER_139_105 VDD VSS sg13g2_decap_8
XFILLER_161_1326 VDD VSS sg13g2_decap_8
XFILLER_168_937 VDD VSS sg13g2_decap_8
X_09206_ _09239_/S _09441_/A _09307_/B _09707_/B _09641_/D VDD VSS sg13g2_or4_1
XFILLER_10_637 VDD VSS sg13g2_decap_8
XFILLER_182_406 VDD VSS sg13g2_decap_8
XFILLER_148_683 VDD VSS sg13g2_decap_8
X_09137_ _09137_/Y _09137_/A _09137_/B _09137_/C VDD VSS sg13g2_nor3_1
XFILLER_159_1200 VDD VSS sg13g2_decap_8
X_13965__2307 _13965_/RESET_B VDD VSS sg13g2_tiehi
XFILLER_148_694 VDD VSS sg13g2_fill_2
XFILLER_159_1211 VDD VSS sg13g2_fill_1
XFILLER_185_49 VDD VSS sg13g2_decap_8
XFILLER_68_1116 VDD VSS sg13g2_fill_2
XFILLER_135_344 VDD VSS sg13g2_fill_1
XFILLER_11_1351 VDD VSS sg13g2_decap_8
XFILLER_151_804 VDD VSS sg13g2_fill_1
XFILLER_159_1244 VDD VSS sg13g2_decap_8
X_09068_ _09103_/C _14911_/Q _13064_/A _09089_/C VDD VSS sg13g2_and3_1
XFILLER_135_355 VDD VSS sg13g2_decap_8
XFILLER_151_826 VDD VSS sg13g2_fill_1
XFILLER_162_163 VDD VSS sg13g2_decap_8
X_08019_ _08019_/X _08236_/S _08019_/B VDD VSS sg13g2_and2_1
XFILLER_78_14 VDD VSS sg13g2_decap_4
XFILLER_123_539 VDD VSS sg13g2_fill_2
XFILLER_116_591 VDD VSS sg13g2_decap_8
XFILLER_2_847 VDD VSS sg13g2_decap_8
X_11030_ _11030_/Y _11040_/A _11207_/A2 _09204_/C VDD VSS sg13g2_a21oi_1
XFILLER_81_1316 VDD VSS sg13g2_fill_1
XFILLER_46_1436 VDD VSS sg13g2_decap_8
XFILLER_150_369 VDD VSS sg13g2_decap_8
XFILLER_1_357 VDD VSS sg13g2_decap_8
XFILLER_49_306 VDD VSS sg13g2_fill_2
XFILLER_133_1428 VDD VSS sg13g2_decap_4
XFILLER_77_626 VDD VSS sg13g2_decap_8
XFILLER_131_583 VDD VSS sg13g2_decap_8
XFILLER_133_1439 VDD VSS sg13g2_decap_8
XFILLER_76_125 VDD VSS sg13g2_decap_4
XFILLER_103_296 VDD VSS sg13g2_fill_2
XFILLER_18_704 VDD VSS sg13g2_decap_4
X_12981_ _12981_/Y input23/X _12795_/Y _12937_/Y VDD VSS sg13g2_o21ai_1
Xclkbuf_5_23__f_clk_i clkbuf_leaf_93_clk_i/A clkbuf_4_11_0_clk_i/X VDD VSS sg13g2_buf_16
XFILLER_100_981 VDD VSS sg13g2_decap_8
XFILLER_17_203 VDD VSS sg13g2_decap_8
X_14720_ _14720_/Q _14720_/CLK _14720_/D _14720_/RESET_B VDD VSS sg13g2_dfrbpq_1
X_11932_ _11932_/Y _11931_/Y _11930_/Y _11917_/Y _12124_/A2 _11980_/A VDD VSS sg13g2_a221oi_1
XFILLER_40_1068 VDD VSS sg13g2_decap_4
XFILLER_27_84 VDD VSS sg13g2_decap_8
XFILLER_150_63 VDD VSS sg13g2_decap_8
XFILLER_168_0 VDD VSS sg13g2_decap_8
X_14651_ _14651_/Q clkload60/A _14651_/D _14651_/RESET_B VDD VSS sg13g2_dfrbpq_1
X_11863_ _11863_/Y _11865_/A _12082_/B VDD VSS sg13g2_nor2_1
XFILLER_45_578 VDD VSS sg13g2_decap_4
XFILLER_14_910 VDD VSS sg13g2_decap_8
XFILLER_60_526 VDD VSS sg13g2_fill_1
XFILLER_32_217 VDD VSS sg13g2_decap_4
X_13602_ _13602_/Y _13602_/A _13609_/B VDD VSS sg13g2_nor2_1
X_10814_ _10814_/Y _10805_/B _10805_/C _10844_/B VDD VSS sg13g2_o21ai_1
XFILLER_13_420 VDD VSS sg13g2_decap_8
X_14582_ _14582_/Q clkload69/A _14582_/D _14582_/RESET_B VDD VSS sg13g2_dfrbpq_1
X_11794_ _11794_/Y _11793_/Y _11792_/Y _11780_/Y _11868_/A _11980_/A VDD VSS sg13g2_a221oi_1
XFILLER_92_1445 VDD VSS sg13g2_decap_8
XFILLER_159_937 VDD VSS sg13g2_decap_8
XFILLER_53_1429 VDD VSS sg13g2_decap_8
XFILLER_14_987 VDD VSS sg13g2_decap_8
XFILLER_159_948 VDD VSS sg13g2_fill_2
X_13533_ _13533_/X _13533_/A _13533_/B VDD VSS sg13g2_and2_1
X_10745_ _10745_/Y _14914_/Q _11048_/B VDD VSS sg13g2_nand2_1
XFILLER_41_762 VDD VSS sg13g2_fill_1
XFILLER_9_413 VDD VSS sg13g2_decap_8
XFILLER_186_756 VDD VSS sg13g2_fill_1
XFILLER_41_795 VDD VSS sg13g2_decap_8
XFILLER_13_497 VDD VSS sg13g2_decap_8
XFILLER_40_272 VDD VSS sg13g2_decap_8
XFILLER_16_1251 VDD VSS sg13g2_decap_8
X_13464_ _15107_/D _13449_/X _13463_/X _13461_/Y VDD VSS sg13g2_o21ai_1
XFILLER_40_283 VDD VSS sg13g2_decap_4
X_10676_ _10813_/A _08977_/B _10669_/S _10805_/B VDD VSS sg13g2_a21oi_1
XFILLER_185_266 VDD VSS sg13g2_decap_8
X_15203_ _15203_/Q clkload90/A _15203_/D _15203_/RESET_B VDD VSS sg13g2_dfrbpq_1
X_12415_ _12415_/Y _12415_/A _12415_/B VDD VSS sg13g2_nand2_1
XFILLER_51_1164 VDD VSS sg13g2_decap_8
XFILLER_138_160 VDD VSS sg13g2_decap_8
XFILLER_142_1292 VDD VSS sg13g2_decap_8
XFILLER_126_311 VDD VSS sg13g2_decap_8
X_13395_ _13396_/D _13438_/A _15129_/Q _13507_/B VDD VSS sg13g2_nand3_1
XFILLER_177_1311 VDD VSS sg13g2_decap_4
X_14555__1717 _14555_/RESET_B VDD VSS sg13g2_tiehi
XFILLER_12_1148 VDD VSS sg13g2_decap_8
XFILLER_5_630 VDD VSS sg13g2_decap_8
X_15134_ _15134_/Q clkload77/A _15134_/D _15134_/RESET_B VDD VSS sg13g2_dfrbpq_1
X_12346_ _12347_/D _12346_/A _15121_/Q VDD VSS sg13g2_or2_1
XFILLER_127_889 VDD VSS sg13g2_decap_8
XFILLER_86_1238 VDD VSS sg13g2_fill_2
XFILLER_57_7 VDD VSS sg13g2_decap_8
XFILLER_126_377 VDD VSS sg13g2_decap_8
XFILLER_4_140 VDD VSS sg13g2_decap_8
XFILLER_153_163 VDD VSS sg13g2_fill_1
XFILLER_141_314 VDD VSS sg13g2_decap_8
XFILLER_181_483 VDD VSS sg13g2_decap_8
X_15065_ _15065_/Q _15113_/CLK _15065_/D _15065_/RESET_B VDD VSS sg13g2_dfrbpq_1
XFILLER_141_325 VDD VSS sg13g2_fill_2
X_12277_ _12277_/X _12278_/A _13663_/Q VDD VSS sg13g2_and2_1
X_14016_ _14016_/Q _14720_/CLK _14016_/D _14016_/RESET_B VDD VSS sg13g2_dfrbpq_1
X_11228_ _11228_/X _14683_/Q _14715_/Q _13755_/Q _13787_/Q _11277_/S _11262_/B VDD
+ VSS sg13g2_mux4_1
XFILLER_68_604 VDD VSS sg13g2_fill_2
XFILLER_4_77 VDD VSS sg13g2_decap_8
X_15156__2738 _15156_/RESET_B VDD VSS sg13g2_tiehi
XFILLER_96_935 VDD VSS sg13g2_decap_8
XFILLER_95_423 VDD VSS sg13g2_fill_1
XFILLER_67_114 VDD VSS sg13g2_decap_8
XFILLER_110_734 VDD VSS sg13g2_decap_8
X_11159_ _11159_/Y _11171_/B _11180_/C _11173_/C VDD VSS sg13g2_a21oi_1
XFILLER_23_1211 VDD VSS sg13g2_decap_8
XFILLER_96_979 VDD VSS sg13g2_fill_1
XFILLER_7_1463 VDD VSS sg13g2_decap_8
XFILLER_27_1391 VDD VSS sg13g2_decap_8
XFILLER_3_1316 VDD VSS sg13g2_decap_8
XFILLER_110_1203 VDD VSS sg13g2_decap_4
X_14918_ _14918_/Q clkload54/A _14918_/D _14918_/RESET_B VDD VSS sg13g2_dfrbpq_1
XFILLER_64_832 VDD VSS sg13g2_decap_8
XFILLER_149_1413 VDD VSS sg13g2_decap_4
XFILLER_23_1288 VDD VSS sg13g2_decap_8
XFILLER_91_640 VDD VSS sg13g2_decap_8
XFILLER_110_1258 VDD VSS sg13g2_decap_8
XFILLER_149_1435 VDD VSS sg13g2_decap_8
XFILLER_36_567 VDD VSS sg13g2_fill_2
X_14849_ _14849_/Q _14876_/CLK _14849_/D _14849_/RESET_B VDD VSS sg13g2_dfrbpq_1
XFILLER_17_770 VDD VSS sg13g2_decap_8
XFILLER_23_206 VDD VSS sg13g2_decap_8
XFILLER_51_537 VDD VSS sg13g2_decap_8
X_08370_ _08370_/Y _08369_/B _08367_/Y _08389_/B VDD VSS sg13g2_o21ai_1
XFILLER_23_239 VDD VSS sg13g2_decap_8
XFILLER_108_1110 VDD VSS sg13g2_decap_8
XFILLER_16_280 VDD VSS sg13g2_decap_8
XFILLER_143_1001 VDD VSS sg13g2_decap_4
XFILLER_147_1170 VDD VSS sg13g2_decap_8
XFILLER_149_414 VDD VSS sg13g2_decap_4
XFILLER_56_1075 VDD VSS sg13g2_decap_8
XFILLER_108_1154 VDD VSS sg13g2_fill_1
XFILLER_31_261 VDD VSS sg13g2_decap_8
XFILLER_143_1056 VDD VSS sg13g2_decap_8
XFILLER_165_907 VDD VSS sg13g2_decap_8
XFILLER_83_0 VDD VSS sg13g2_decap_8
XFILLER_32_795 VDD VSS sg13g2_decap_8
XFILLER_149_458 VDD VSS sg13g2_decap_8
XFILLER_176_266 VDD VSS sg13g2_decap_8
XFILLER_20_979 VDD VSS sg13g2_decap_4
XFILLER_9_980 VDD VSS sg13g2_decap_8
XFILLER_30_1226 VDD VSS sg13g2_decap_8
XFILLER_8_490 VDD VSS sg13g2_decap_8
XFILLER_117_344 VDD VSS sg13g2_decap_8
XFILLER_121_1398 VDD VSS sg13g2_decap_8
Xclkbuf_leaf_132_clk_i clkload11/A clkload0/A VDD VSS sg13g2_buf_8
XFILLER_160_612 VDD VSS sg13g2_decap_4
XFILLER_172_472 VDD VSS sg13g2_decap_8
XFILLER_156_1428 VDD VSS sg13g2_decap_8
Xpicorv32_macro_1508 mem_axi_araddr[1] VDD VSS sg13g2_tielo
XFILLER_154_1130 VDD VSS sg13g2_decap_8
Xfanout403 _09294_/S _09274_/Y VDD VSS sg13g2_buf_1
Xfanout414 _09202_/S wire416/A VDD VSS sg13g2_buf_1
XFILLER_98_250 VDD VSS sg13g2_decap_8
XFILLER_28_1144 VDD VSS sg13g2_decap_8
Xfanout425 _10045_/A0 _10078_/A0 VDD VSS sg13g2_buf_1
XFILLER_63_1035 VDD VSS sg13g2_decap_8
XFILLER_154_1163 VDD VSS sg13g2_decap_4
Xfanout436 _09875_/A0 fanout438/X VDD VSS sg13g2_buf_1
XFILLER_48_28 VDD VSS sg13g2_decap_8
XFILLER_141_892 VDD VSS sg13g2_decap_8
XFILLER_150_1005 VDD VSS sg13g2_decap_8
XFILLER_87_946 VDD VSS sg13g2_decap_8
XFILLER_86_412 VDD VSS sg13g2_decap_8
Xfanout447 _13470_/A2 _13353_/Y VDD VSS sg13g2_buf_1
X_09824_ _14412_/D _09923_/A1 _14412_/Q _09838_/S VDD VSS sg13g2_mux2_1
XFILLER_115_1136 VDD VSS sg13g2_decap_8
XFILLER_140_380 VDD VSS sg13g2_decap_8
XFILLER_154_1185 VDD VSS sg13g2_decap_4
Xfanout458 _10135_/S _10120_/S VDD VSS sg13g2_buf_1
XFILLER_87_957 VDD VSS sg13g2_fill_2
XFILLER_59_648 VDD VSS sg13g2_decap_8
Xfanout469 _09994_/S _10003_/S VDD VSS sg13g2_buf_1
XFILLER_59_659 VDD VSS sg13g2_fill_2
XFILLER_80_1371 VDD VSS sg13g2_fill_1
XFILLER_101_789 VDD VSS sg13g2_decap_8
X_09755_ _14345_/D _14345_/Q _10152_/A1 _09771_/S VDD VSS sg13g2_mux2_1
XFILLER_86_478 VDD VSS sg13g2_decap_8
XFILLER_86_489 VDD VSS sg13g2_fill_2
XFILLER_104_56 VDD VSS sg13g2_decap_8
X_14900__2837 _14900_/RESET_B VDD VSS sg13g2_tiehi
XFILLER_27_512 VDD VSS sg13g2_decap_8
XFILLER_100_299 VDD VSS sg13g2_decap_4
X_08706_ _13658_/D _15185_/D _15116_/Q _13652_/S VDD VSS sg13g2_mux2_1
X_09686_ _14278_/D _09917_/A1 _14278_/Q _09698_/S VDD VSS sg13g2_mux2_1
XFILLER_73_139 VDD VSS sg13g2_decap_8
Xclkbuf_4_9_0_clk_i clkbuf_4_9_0_clk_i/X clkbuf_0_clk_i/X VDD VSS sg13g2_buf_8
XFILLER_64_49 VDD VSS sg13g2_decap_8
XFILLER_15_707 VDD VSS sg13g2_decap_8
X_08637_ _08640_/D _08637_/A _08637_/B VDD VSS sg13g2_nand2_1
XFILLER_54_353 VDD VSS sg13g2_fill_2
XFILLER_161_7 VDD VSS sg13g2_decap_8
X_14633__1639 _14633_/RESET_B VDD VSS sg13g2_tiehi
XFILLER_55_898 VDD VSS sg13g2_fill_2
XFILLER_120_11 VDD VSS sg13g2_fill_1
XFILLER_14_217 VDD VSS sg13g2_decap_8
XFILLER_42_537 VDD VSS sg13g2_decap_8
X_08568_ _08568_/Y _15012_/Q _08541_/B _07956_/A _07812_/B VDD VSS sg13g2_a22oi_1
XFILLER_70_857 VDD VSS sg13g2_decap_4
XFILLER_39_1251 VDD VSS sg13g2_decap_8
XFILLER_168_701 VDD VSS sg13g2_fill_2
XFILLER_168_723 VDD VSS sg13g2_decap_8
XFILLER_39_1284 VDD VSS sg13g2_decap_4
XFILLER_161_1123 VDD VSS sg13g2_fill_1
XFILLER_11_924 VDD VSS sg13g2_decap_8
X_08499_ _08499_/Y _08527_/B _08498_/Y _08588_/B VDD VSS sg13g2_o21ai_1
XFILLER_35_1137 VDD VSS sg13g2_fill_1
XFILLER_126_1265 VDD VSS sg13g2_decap_8
XFILLER_167_233 VDD VSS sg13g2_decap_4
X_10530_ _10532_/C _10558_/B _10543_/C _14859_/Q VDD VSS sg13g2_a21o_1
XFILLER_161_1167 VDD VSS sg13g2_decap_8
XFILLER_10_434 VDD VSS sg13g2_decap_8
XFILLER_13_42 VDD VSS sg13g2_decap_8
XFILLER_7_917 VDD VSS sg13g2_decap_8
XFILLER_109_801 VDD VSS sg13g2_fill_1
XFILLER_149_970 VDD VSS sg13g2_fill_1
XFILLER_167_266 VDD VSS sg13g2_decap_8
XFILLER_149_981 VDD VSS sg13g2_decap_8
XFILLER_182_203 VDD VSS sg13g2_decap_8
XFILLER_13_1435 VDD VSS sg13g2_decap_8
X_10461_ _10502_/A _10471_/C _14842_/Q _14841_/Q VDD VSS sg13g2_nand3_1
XFILLER_6_427 VDD VSS sg13g2_decap_8
XFILLER_100_1405 VDD VSS sg13g2_decap_4
XFILLER_109_845 VDD VSS sg13g2_fill_2
X_15001__2679 _15001_/RESET_B VDD VSS sg13g2_tiehi
X_12200_ _12200_/X _12200_/A _12200_/B VDD VSS sg13g2_or2_1
X_13180_ _13180_/Y _14823_/Q _13068_/B _13180_/B1 _14887_/Q _13193_/B VDD VSS sg13g2_a221oi_1
XFILLER_89_35 VDD VSS sg13g2_fill_1
XFILLER_100_1438 VDD VSS sg13g2_decap_8
XFILLER_136_664 VDD VSS sg13g2_decap_8
XFILLER_163_450 VDD VSS sg13g2_fill_2
X_10392_ _14821_/D _10392_/A _10611_/B _10392_/C VDD VSS sg13g2_and3_1
XFILLER_164_984 VDD VSS sg13g2_decap_4
X_15196__2854 _15196_/RESET_B VDD VSS sg13g2_tiehi
X_12131_ _12155_/B _12198_/B _12132_/B VDD VSS sg13g2_nand2b_1
XFILLER_124_859 VDD VSS sg13g2_decap_8
XFILLER_151_634 VDD VSS sg13g2_decap_8
XFILLER_151_656 VDD VSS sg13g2_fill_1
XFILLER_2_644 VDD VSS sg13g2_decap_8
XFILLER_123_369 VDD VSS sg13g2_decap_8
XFILLER_150_144 VDD VSS sg13g2_decap_4
X_12062_ _12065_/A _12062_/A _12062_/B _12197_/A VDD VSS sg13g2_nand3_1
XFILLER_145_63 VDD VSS sg13g2_fill_1
XFILLER_78_913 VDD VSS sg13g2_fill_1
XFILLER_1_154 VDD VSS sg13g2_decap_8
X_11013_ _11022_/B _11012_/B _11012_/C _11064_/A VDD VSS sg13g2_o21ai_1
XFILLER_133_1225 VDD VSS sg13g2_decap_8
XFILLER_145_96 VDD VSS sg13g2_decap_8
XFILLER_81_1157 VDD VSS sg13g2_decap_8
XFILLER_172_1274 VDD VSS sg13g2_decap_4
X_16870_ _16870_/X _16870_/A VDD VSS sg13g2_buf_1
XFILLER_46_1288 VDD VSS sg13g2_decap_8
XFILLER_78_979 VDD VSS sg13g2_fill_2
Xfanout970 _07683_/A _13048_/B VDD VSS sg13g2_buf_1
XFILLER_93_905 VDD VSS sg13g2_decap_8
Xfanout981 _13293_/B _13308_/A VDD VSS sg13g2_buf_1
XFILLER_93_916 VDD VSS sg13g2_fill_2
XFILLER_92_404 VDD VSS sg13g2_fill_1
XFILLER_77_478 VDD VSS sg13g2_decap_8
Xfanout992 _13555_/B _13558_/B VDD VSS sg13g2_buf_1
XFILLER_92_415 VDD VSS sg13g2_decap_8
XFILLER_20_1406 VDD VSS sg13g2_decap_8
X_12964_ _12964_/Y _14809_/Q _13274_/A2 _13218_/B _14841_/Q _13248_/B VDD VSS sg13g2_a221oi_1
X_14703_ _14703_/Q clkload13/A _14703_/D _14703_/RESET_B VDD VSS sg13g2_dfrbpq_1
X_11915_ _12055_/A _11915_/A VDD VSS sg13g2_inv_1
XFILLER_72_150 VDD VSS sg13g2_decap_8
X_12895_ _12895_/Y _14869_/Q _12895_/B VDD VSS sg13g2_nand2_1
XFILLER_79_1086 VDD VSS sg13g2_decap_8
XFILLER_166_1045 VDD VSS sg13g2_decap_8
XFILLER_73_695 VDD VSS sg13g2_decap_8
XFILLER_72_172 VDD VSS sg13g2_fill_2
XFILLER_127_1007 VDD VSS sg13g2_fill_2
X_14609__1663 _14609_/RESET_B VDD VSS sg13g2_tiehi
XFILLER_2_1393 VDD VSS sg13g2_decap_8
X_14634_ _14634_/Q _14726_/CLK _14634_/D _14634_/RESET_B VDD VSS sg13g2_dfrbpq_1
X_11846_ _11846_/Y _11846_/A _11867_/B VDD VSS sg13g2_nand2_1
XFILLER_92_1253 VDD VSS sg13g2_decap_8
XFILLER_159_734 VDD VSS sg13g2_decap_4
XFILLER_18_1346 VDD VSS sg13g2_decap_8
X_14565_ _14565_/Q _14725_/CLK _14565_/D _14565_/RESET_B VDD VSS sg13g2_dfrbpq_1
X_11777_ _11778_/B _11777_/A _11777_/B _11777_/C VDD VSS sg13g2_nor3_1
XFILLER_14_784 VDD VSS sg13g2_decap_8
XFILLER_60_389 VDD VSS sg13g2_decap_8
XFILLER_9_210 VDD VSS sg13g2_decap_8
X_13516_ _15139_/D _15139_/Q _13545_/A _13519_/B VDD VSS sg13g2_mux2_1
X_10728_ _14909_/D _11207_/B1 _10995_/A _10727_/Y VDD VSS sg13g2_o21ai_1
XFILLER_53_1259 VDD VSS sg13g2_decap_8
XFILLER_13_294 VDD VSS sg13g2_decap_8
XFILLER_105_1349 VDD VSS sg13g2_decap_8
X_14496_ _14496_/Q clkload41/A _14496_/D _14496_/RESET_B VDD VSS sg13g2_dfrbpq_1
XFILLER_173_203 VDD VSS sg13g2_decap_8
XFILLER_179_1417 VDD VSS sg13g2_decap_8
XFILLER_70_70 VDD VSS sg13g2_decap_8
X_13447_ _13459_/D _15193_/Q _15194_/Q _15195_/Q _15197_/Q VDD VSS sg13g2_nor4_1
X_10659_ _10661_/B _14891_/Q _10663_/D _14892_/Q VDD VSS sg13g2_a21oi_1
XFILLER_9_287 VDD VSS sg13g2_decap_8
XFILLER_139_491 VDD VSS sg13g2_decap_8
Xclkload13 clkload13/Y clkload13/A VDD VSS sg13g2_inv_1
XFILLER_155_951 VDD VSS sg13g2_decap_4
Xclkload24 clkload24/Y clkload24/A VDD VSS sg13g2_inv_2
Xclkload35 clkload35/Y clkload35/A VDD VSS sg13g2_inv_1
Xclkload46 clkload46/Y clkload46/A VDD VSS sg13g2_inv_1
XFILLER_126_141 VDD VSS sg13g2_decap_8
XFILLER_177_1130 VDD VSS sg13g2_decap_8
X_13378_ _13378_/Y _13396_/C _13494_/B _13378_/C VDD VSS sg13g2_nor3_1
Xclkload57 clkload57/Y clkload57/A VDD VSS sg13g2_inv_2
Xmax_cap1287 _16871_/A _13709_/Q VDD VSS sg13g2_buf_8
Xclkload68 clkload68/Y clkload68/A VDD VSS sg13g2_inv_1
Xmax_cap1298 output66/A _16860_/A VDD VSS sg13g2_buf_4
XFILLER_115_837 VDD VSS sg13g2_decap_8
Xclkload79 clkload79/Y clkload79/A VDD VSS sg13g2_inv_2
XFILLER_114_314 VDD VSS sg13g2_decap_8
XFILLER_126_174 VDD VSS sg13g2_decap_8
X_15117_ _15117_/Q clkload82/A _15117_/D _15117_/RESET_B VDD VSS sg13g2_dfrbpq_1
XFILLER_6_994 VDD VSS sg13g2_decap_8
XFILLER_181_280 VDD VSS sg13g2_decap_8
X_12329_ _12329_/Y _12325_/Y _12326_/Y _12328_/Y _12327_/Y _12329_/C1 VDD VSS sg13g2_a221oi_1
XFILLER_142_656 VDD VSS sg13g2_decap_8
XFILLER_141_144 VDD VSS sg13g2_fill_2
XFILLER_170_976 VDD VSS sg13g2_decap_8
XFILLER_130_818 VDD VSS sg13g2_decap_8
X_15048_ _15048_/Q clkload70/A _15048_/D _15048_/RESET_B VDD VSS sg13g2_dfrbpq_1
Xclkbuf_leaf_64_clk_i clkload89/A clkbuf_leaf_68_clk_i/A VDD VSS sg13g2_buf_8
XFILLER_123_870 VDD VSS sg13g2_decap_8
XFILLER_64_1344 VDD VSS sg13g2_decap_4
XFILLER_123_881 VDD VSS sg13g2_fill_2
X_07870_ _08188_/A _07912_/B _08201_/A VDD VSS sg13g2_and2_1
XFILLER_60_1208 VDD VSS sg13g2_decap_8
XFILLER_69_979 VDD VSS sg13g2_decap_8
XFILLER_68_456 VDD VSS sg13g2_decap_8
XFILLER_7_1260 VDD VSS sg13g2_decap_8
XFILLER_56_629 VDD VSS sg13g2_fill_1
XFILLER_55_106 VDD VSS sg13g2_fill_2
XFILLER_3_1113 VDD VSS sg13g2_decap_8
Xclkbuf_leaf_79_clk_i clkload74/A clkload5/A VDD VSS sg13g2_buf_8
X_09540_ wire495/A _10070_/A _10004_/B _10004_/C _09606_/C VDD VSS sg13g2_nand4_1
XFILLER_97_1120 VDD VSS sg13g2_decap_8
XFILLER_37_832 VDD VSS sg13g2_decap_8
XFILLER_23_1063 VDD VSS sg13g2_decap_8
XFILLER_58_1104 VDD VSS sg13g2_decap_4
X_09471_ _14072_/D _10134_/A0 _14072_/Q _09471_/S VDD VSS sg13g2_mux2_1
XFILLER_110_1066 VDD VSS sg13g2_decap_8
XFILLER_149_1243 VDD VSS sg13g2_decap_8
XFILLER_93_1006 VDD VSS sg13g2_decap_4
XFILLER_64_673 VDD VSS sg13g2_decap_8
XFILLER_92_993 VDD VSS sg13g2_decap_8
XFILLER_36_375 VDD VSS sg13g2_decap_8
X_08422_ _08423_/B _08434_/B _08421_/Y _08422_/S VDD VSS sg13g2_mux2_1
XFILLER_63_194 VDD VSS sg13g2_decap_8
XFILLER_75_1462 VDD VSS sg13g2_decap_8
XFILLER_149_200 VDD VSS sg13g2_decap_8
X_08353_ _08354_/B _08353_/A _08353_/B VDD VSS sg13g2_nand2_1
XFILLER_51_389 VDD VSS sg13g2_decap_8
XFILLER_20_721 VDD VSS sg13g2_decap_8
XFILLER_177_553 VDD VSS sg13g2_decap_8
X_08284_ _08293_/B _08270_/Y _08271_/Y _08273_/Y _08381_/A _08283_/Y VDD VSS sg13g2_a221oi_1
XFILLER_149_266 VDD VSS sg13g2_fill_2
Xclkload7 clkload7/X clkload7/A VDD VSS sg13g2_buf_8
Xclkbuf_leaf_17_clk_i clkload25/A clkbuf_5_7__f_clk_i/X VDD VSS sg13g2_buf_8
XFILLER_20_798 VDD VSS sg13g2_decap_8
X_14800__3006 _14800_/RESET_B VDD VSS sg13g2_tiehi
XFILLER_146_951 VDD VSS sg13g2_decap_8
XFILLER_30_1034 VDD VSS sg13g2_decap_8
XFILLER_69_1222 VDD VSS sg13g2_fill_1
XFILLER_106_804 VDD VSS sg13g2_decap_8
X_14047__2225 _14047_/RESET_B VDD VSS sg13g2_tiehi
XFILLER_133_601 VDD VSS sg13g2_decap_8
XFILLER_156_1203 VDD VSS sg13g2_decap_8
XFILLER_161_932 VDD VSS sg13g2_decap_8
XFILLER_30_1089 VDD VSS sg13g2_decap_4
XFILLER_132_111 VDD VSS sg13g2_decap_8
XFILLER_133_645 VDD VSS sg13g2_decap_4
XFILLER_160_420 VDD VSS sg13g2_fill_1
XFILLER_161_976 VDD VSS sg13g2_fill_1
XFILLER_82_1422 VDD VSS sg13g2_decap_4
XFILLER_120_306 VDD VSS sg13g2_decap_8
XFILLER_121_829 VDD VSS sg13g2_decap_8
XFILLER_133_689 VDD VSS sg13g2_decap_8
XFILLER_182_28 VDD VSS sg13g2_decap_8
Xfanout200 _10026_/A0 _10092_/A0 VDD VSS sg13g2_buf_1
Xfanout211 _09625_/A0 _10089_/A0 VDD VSS sg13g2_buf_1
Xfanout1209 _08304_/A _08306_/C VDD VSS sg13g2_buf_1
XFILLER_82_1444 VDD VSS sg13g2_decap_4
XFILLER_132_188 VDD VSS sg13g2_fill_1
Xfanout222 _09558_/A0 _10155_/A1 VDD VSS sg13g2_buf_1
Xfanout233 _10086_/A0 fanout237/X VDD VSS sg13g2_buf_1
XFILLER_82_1466 VDD VSS sg13g2_decap_8
XFILLER_87_743 VDD VSS sg13g2_decap_8
XFILLER_82_1477 VDD VSS sg13g2_fill_2
XFILLER_101_531 VDD VSS sg13g2_decap_8
Xfanout255 _12082_/B _12298_/B VDD VSS sg13g2_buf_1
XFILLER_115_55 VDD VSS sg13g2_decap_4
X_14262__2010 _14262_/RESET_B VDD VSS sg13g2_tiehi
XFILLER_8_1057 VDD VSS sg13g2_decap_8
Xfanout266 _09885_/A0 _10150_/A1 VDD VSS sg13g2_buf_1
Xfanout277 _10060_/S _10069_/S VDD VSS sg13g2_buf_1
X_09807_ _14395_/D _09906_/A1 _14395_/Q _09838_/S VDD VSS sg13g2_mux2_1
XFILLER_115_77 VDD VSS sg13g2_decap_8
Xfanout299 _09439_/S _09437_/S VDD VSS sg13g2_buf_1
X_07999_ _08001_/D _15097_/Q _15092_/Q _15131_/Q _08027_/B VDD VSS sg13g2_nor4_1
XFILLER_46_106 VDD VSS sg13g2_decap_8
XFILLER_101_597 VDD VSS sg13g2_fill_2
XFILLER_68_990 VDD VSS sg13g2_decap_8
X_09738_ _14329_/D _09936_/A1 _14329_/Q _09738_/S VDD VSS sg13g2_mux2_1
XFILLER_55_662 VDD VSS sg13g2_fill_2
XFILLER_15_504 VDD VSS sg13g2_decap_8
X_09669_ _14262_/D _10165_/A1 _14262_/Q _09670_/S VDD VSS sg13g2_mux2_1
XFILLER_43_824 VDD VSS sg13g2_decap_8
XFILLER_91_14 VDD VSS sg13g2_decap_8
XFILLER_131_76 VDD VSS sg13g2_decap_8
X_11700_ _11700_/X _14907_/Q _12294_/A2 wire246/X VDD VSS sg13g2_a21o_1
XFILLER_167_1376 VDD VSS sg13g2_decap_4
X_12680_ _15012_/D _12680_/A _12680_/B VDD VSS sg13g2_nor2_1
XFILLER_76_1259 VDD VSS sg13g2_decap_8
XFILLER_163_1218 VDD VSS sg13g2_decap_4
X_11631_ _11632_/B _11593_/Y _12225_/B2 _11630_/Y VDD VSS sg13g2_a21oi_1
XFILLER_42_367 VDD VSS sg13g2_decap_8
XFILLER_11_721 VDD VSS sg13g2_decap_8
XFILLER_24_63 VDD VSS sg13g2_decap_8
XFILLER_126_1062 VDD VSS sg13g2_decap_8
XFILLER_129_907 VDD VSS sg13g2_decap_8
XFILLER_156_704 VDD VSS sg13g2_decap_4
X_14350_ _14350_/Q _14685_/CLK _14350_/D _14350_/RESET_B VDD VSS sg13g2_dfrbpq_1
X_11562_ _11562_/Y _11560_/Y _11561_/Y _12292_/A VDD VSS sg13g2_a21oi_1
XFILLER_10_231 VDD VSS sg13g2_decap_8
XFILLER_128_417 VDD VSS sg13g2_decap_8
XFILLER_7_714 VDD VSS sg13g2_decap_8
X_13301_ _13302_/B _07744_/C _13300_/Y _10781_/B VDD VSS sg13g2_o21ai_1
X_10513_ _10514_/C _14854_/Q _14853_/Q _14852_/Q _14851_/Q VDD VSS sg13g2_and4_1
XFILLER_17_1390 VDD VSS sg13g2_decap_8
X_14281_ _14281_/Q clkload34/A _14281_/D _14281_/RESET_B VDD VSS sg13g2_dfrbpq_1
XFILLER_52_1270 VDD VSS sg13g2_decap_8
XFILLER_13_1232 VDD VSS sg13g2_decap_8
X_11493_ _11493_/X _13954_/Q _13986_/Q _14018_/Q _14050_/Q _11493_/S0 _11493_/S1 VDD
+ VSS sg13g2_mux4_1
XFILLER_11_798 VDD VSS sg13g2_decap_8
XFILLER_6_224 VDD VSS sg13g2_decap_8
XFILLER_100_1202 VDD VSS sg13g2_decap_4
XFILLER_183_567 VDD VSS sg13g2_decap_8
X_13232_ _13232_/Y _13232_/A _13244_/B VDD VSS sg13g2_xnor2_1
X_14877__2883 _14877_/RESET_B VDD VSS sg13g2_tiehi
XFILLER_87_1311 VDD VSS sg13g2_decap_4
XFILLER_108_130 VDD VSS sg13g2_decap_8
XFILLER_155_269 VDD VSS sg13g2_decap_8
XFILLER_171_718 VDD VSS sg13g2_decap_8
X_10444_ _14837_/D _10444_/A _10444_/B _10544_/C VDD VSS sg13g2_and3_1
XFILLER_87_1333 VDD VSS sg13g2_decap_8
XFILLER_100_1235 VDD VSS sg13g2_decap_8
XFILLER_164_770 VDD VSS sg13g2_decap_8
XFILLER_137_995 VDD VSS sg13g2_decap_8
XFILLER_109_697 VDD VSS sg13g2_decap_8
XFILLER_156_51 VDD VSS sg13g2_fill_1
X_14472__1800 _14472_/RESET_B VDD VSS sg13g2_tiehi
XFILLER_123_100 VDD VSS sg13g2_decap_8
XFILLER_156_62 VDD VSS sg13g2_decap_8
X_13163_ _13163_/Y _14822_/Q _13068_/B _13193_/B VDD VSS sg13g2_a21oi_1
XFILLER_48_1317 VDD VSS sg13g2_fill_2
XFILLER_123_111 VDD VSS sg13g2_fill_1
X_10375_ _14816_/D _10375_/A _10375_/B _10630_/C VDD VSS sg13g2_and3_1
XFILLER_3_931 VDD VSS sg13g2_decap_8
XFILLER_124_645 VDD VSS sg13g2_decap_8
XFILLER_48_1339 VDD VSS sg13g2_decap_8
X_12114_ _12114_/X _14708_/Q _14740_/Q _13780_/Q _13812_/Q _12114_/S0 _11760_/C VDD
+ VSS sg13g2_mux4_1
XFILLER_2_441 VDD VSS sg13g2_decap_8
X_13094_ _13094_/Y _14817_/Q _13206_/B _13150_/B _14849_/Q VDD VSS sg13g2_a22oi_1
XFILLER_111_306 VDD VSS sg13g2_decap_8
XFILLER_151_475 VDD VSS sg13g2_decap_8
XFILLER_151_486 VDD VSS sg13g2_fill_1
XFILLER_105_892 VDD VSS sg13g2_decap_8
X_12045_ _12046_/B _12034_/Y _12036_/X _12263_/C VDD VSS sg13g2_o21ai_1
XFILLER_78_732 VDD VSS sg13g2_fill_1
XFILLER_66_905 VDD VSS sg13g2_decap_4
XFILLER_172_1093 VDD VSS sg13g2_decap_8
XFILLER_66_927 VDD VSS sg13g2_decap_8
XFILLER_4_1400 VDD VSS sg13g2_decap_8
XFILLER_133_1066 VDD VSS sg13g2_fill_1
X_13745__2527 _13745_/RESET_B VDD VSS sg13g2_tiehi
XFILLER_133_1077 VDD VSS sg13g2_decap_8
XFILLER_77_286 VDD VSS sg13g2_fill_2
XFILLER_20_1203 VDD VSS sg13g2_decap_8
XFILLER_24_1372 VDD VSS sg13g2_decap_8
XFILLER_1_56 VDD VSS sg13g2_decap_8
XFILLER_150_1380 VDD VSS sg13g2_decap_8
X_13996_ _13996_/Q clkload17/A _13996_/D _13996_/RESET_B VDD VSS sg13g2_dfrbpq_1
XFILLER_46_640 VDD VSS sg13g2_decap_8
XFILLER_4_1477 VDD VSS sg13g2_fill_2
XFILLER_46_651 VDD VSS sg13g2_fill_2
XFILLER_185_1432 VDD VSS sg13g2_decap_8
XFILLER_18_364 VDD VSS sg13g2_decap_8
X_12947_ _12947_/Y _14872_/Q _13249_/B VDD VSS sg13g2_nand2_1
XFILLER_74_993 VDD VSS sg13g2_decap_8
XFILLER_46_695 VDD VSS sg13g2_decap_4
XFILLER_45_183 VDD VSS sg13g2_fill_1
X_14125__2147 _14125_/RESET_B VDD VSS sg13g2_tiehi
XFILLER_34_868 VDD VSS sg13g2_decap_4
XFILLER_2_1190 VDD VSS sg13g2_decap_8
X_12878_ _12878_/Y _12878_/A _12878_/B _12878_/C _12878_/D VDD VSS sg13g2_nand4_1
X_13960__2312 _13960_/RESET_B VDD VSS sg13g2_tiehi
XFILLER_33_345 VDD VSS sg13g2_fill_2
X_14617_ _14617_/Q clkload35/A _14617_/D _14617_/RESET_B VDD VSS sg13g2_dfrbpq_1
XFILLER_53_1001 VDD VSS sg13g2_decap_8
X_11829_ _11829_/X _12317_/B _11828_/X _11827_/Y VDD VSS sg13g2_a21o_1
XFILLER_21_529 VDD VSS sg13g2_fill_1
XFILLER_18_1143 VDD VSS sg13g2_decap_8
XFILLER_14_581 VDD VSS sg13g2_decap_8
XFILLER_140_1004 VDD VSS sg13g2_decap_8
X_14548_ _14548_/Q clkload25/A _14548_/D _14548_/RESET_B VDD VSS sg13g2_dfrbpq_1
XFILLER_174_512 VDD VSS sg13g2_decap_8
XFILLER_186_372 VDD VSS sg13g2_decap_8
XFILLER_14_1029 VDD VSS sg13g2_decap_8
XFILLER_186_383 VDD VSS sg13g2_decap_8
X_14479_ _14479_/Q _14610_/CLK _14479_/D _14479_/RESET_B VDD VSS sg13g2_dfrbpq_1
XFILLER_128_962 VDD VSS sg13g2_decap_8
XFILLER_31_1354 VDD VSS sg13g2_decap_4
XFILLER_179_1269 VDD VSS sg13g2_fill_1
X_13993__2279 _13993_/RESET_B VDD VSS sg13g2_tiehi
XFILLER_174_589 VDD VSS sg13g2_decap_8
XFILLER_31_1387 VDD VSS sg13g2_decap_4
XFILLER_143_932 VDD VSS sg13g2_decap_8
XFILLER_6_791 VDD VSS sg13g2_decap_8
XFILLER_66_1428 VDD VSS sg13g2_decap_8
XFILLER_115_667 VDD VSS sg13g2_decap_8
XFILLER_88_507 VDD VSS sg13g2_decap_8
XFILLER_46_0 VDD VSS sg13g2_decap_8
XFILLER_143_987 VDD VSS sg13g2_decap_8
X_08971_ _08971_/X _15022_/Q _15219_/Q _09009_/S VDD VSS sg13g2_mux2_1
XFILLER_114_177 VDD VSS sg13g2_fill_1
XFILLER_29_1250 VDD VSS sg13g2_decap_8
XFILLER_130_648 VDD VSS sg13g2_decap_8
X_07922_ _07922_/Y _07905_/A _07920_/Y _07910_/Y VDD VSS sg13g2_o21ai_1
XFILLER_9_1344 VDD VSS sg13g2_decap_8
XFILLER_29_1283 VDD VSS sg13g2_decap_8
XFILLER_111_840 VDD VSS sg13g2_decap_8
XFILLER_96_551 VDD VSS sg13g2_decap_8
XFILLER_57_905 VDD VSS sg13g2_decap_8
XFILLER_116_1264 VDD VSS sg13g2_decap_8
XFILLER_84_702 VDD VSS sg13g2_decap_8
XFILLER_69_776 VDD VSS sg13g2_decap_8
XFILLER_25_1147 VDD VSS sg13g2_decap_8
X_07853_ _07855_/B _15015_/Q _07853_/B VDD VSS sg13g2_and2_1
X_14335__1937 _14335_/RESET_B VDD VSS sg13g2_tiehi
XFILLER_57_949 VDD VSS sg13g2_fill_1
XFILLER_56_426 VDD VSS sg13g2_decap_8
XFILLER_28_117 VDD VSS sg13g2_decap_8
XFILLER_68_297 VDD VSS sg13g2_decap_8
XFILLER_28_128 VDD VSS sg13g2_fill_2
X_07784_ _08414_/D _08411_/A _07784_/B VDD VSS sg13g2_or2_1
XFILLER_99_1259 VDD VSS sg13g2_decap_4
XFILLER_186_1218 VDD VSS sg13g2_decap_8
XFILLER_186_1229 VDD VSS sg13g2_decap_8
X_09523_ _14122_/D _09622_/A0 _14122_/Q _09530_/S VDD VSS sg13g2_mux2_1
XFILLER_36_150 VDD VSS sg13g2_decap_8
X_09454_ _14055_/D _09951_/A1 _14055_/Q _09462_/S VDD VSS sg13g2_mux2_1
X_15177__2952 _15177_/RESET_B VDD VSS sg13g2_tiehi
XFILLER_24_334 VDD VSS sg13g2_decap_8
XFILLER_24_345 VDD VSS sg13g2_fill_2
X_14550__1722 _14550_/RESET_B VDD VSS sg13g2_tiehi
X_08405_ _08406_/A _11726_/A _11661_/A _07946_/B _11706_/A _08635_/S1 _08048_/A VDD
+ VSS sg13g2_mux4_1
XFILLER_80_985 VDD VSS sg13g2_decap_8
XFILLER_36_1210 VDD VSS sg13g2_decap_8
XFILLER_12_518 VDD VSS sg13g2_decap_8
X_09385_ _13988_/D _09616_/A0 _13988_/Q _09396_/S VDD VSS sg13g2_mux2_1
XFILLER_75_1270 VDD VSS sg13g2_fill_2
XFILLER_75_1292 VDD VSS sg13g2_decap_8
XFILLER_51_186 VDD VSS sg13g2_decap_8
XFILLER_33_890 VDD VSS sg13g2_decap_8
X_08336_ _08336_/Y _08270_/B _08169_/Y _08241_/Y VDD VSS sg13g2_o21ai_1
XFILLER_127_1382 VDD VSS sg13g2_decap_8
XFILLER_138_704 VDD VSS sg13g2_decap_8
XFILLER_177_350 VDD VSS sg13g2_decap_8
XFILLER_178_873 VDD VSS sg13g2_decap_8
XFILLER_184_309 VDD VSS sg13g2_decap_8
XFILLER_71_1145 VDD VSS sg13g2_decap_4
XFILLER_177_28 VDD VSS sg13g2_decap_8
XFILLER_123_1235 VDD VSS sg13g2_decap_8
X_08267_ _08268_/B _08266_/Y _08265_/X _08263_/Y _08264_/Y VDD VSS sg13g2_a22oi_1
XFILLER_124_7 VDD VSS sg13g2_decap_8
XFILLER_137_247 VDD VSS sg13g2_decap_8
XFILLER_180_504 VDD VSS sg13g2_decap_8
XFILLER_119_984 VDD VSS sg13g2_decap_8
X_13823__2449 _13823_/RESET_B VDD VSS sg13g2_tiehi
X_08198_ _08198_/X _08086_/B _08094_/X _08223_/S VDD VSS sg13g2_mux2_1
X_14583__1689 _14583_/RESET_B VDD VSS sg13g2_tiehi
XFILLER_4_728 VDD VSS sg13g2_decap_8
XFILLER_106_623 VDD VSS sg13g2_decap_8
XFILLER_10_1449 VDD VSS sg13g2_decap_8
XFILLER_134_932 VDD VSS sg13g2_fill_2
XFILLER_10_21 VDD VSS sg13g2_decap_8
XFILLER_156_1011 VDD VSS sg13g2_decap_8
XFILLER_3_238 VDD VSS sg13g2_decap_8
XFILLER_106_667 VDD VSS sg13g2_decap_8
XFILLER_126_21 VDD VSS sg13g2_decap_8
XFILLER_134_987 VDD VSS sg13g2_decap_8
X_10160_ _14737_/D _14737_/Q _10160_/A1 _10160_/S VDD VSS sg13g2_mux2_1
XFILLER_161_795 VDD VSS sg13g2_decap_8
XFILLER_47_1350 VDD VSS sg13g2_decap_8
XFILLER_10_98 VDD VSS sg13g2_decap_8
XFILLER_117_1039 VDD VSS sg13g2_decap_8
Xfanout1006 _13401_/B _10201_/A1 VDD VSS sg13g2_buf_1
XFILLER_160_294 VDD VSS sg13g2_decap_8
Xfanout1017 _07727_/C _13249_/B VDD VSS sg13g2_buf_1
X_10091_ _14671_/D _10091_/A0 _14671_/Q _10102_/S VDD VSS sg13g2_mux2_1
X_14203__2069 _14203_/RESET_B VDD VSS sg13g2_tiehi
Xfanout1028 _13068_/B _13206_/B VDD VSS sg13g2_buf_1
XFILLER_0_967 VDD VSS sg13g2_decap_8
XFILLER_134_1342 VDD VSS sg13g2_decap_8
Xfanout1039 _13427_/C _08391_/A VDD VSS sg13g2_buf_1
XFILLER_82_1274 VDD VSS sg13g2_decap_4
XFILLER_102_862 VDD VSS sg13g2_decap_8
XFILLER_120_158 VDD VSS sg13g2_decap_8
XFILLER_87_562 VDD VSS sg13g2_fill_2
XFILLER_48_927 VDD VSS sg13g2_decap_8
XFILLER_74_201 VDD VSS sg13g2_decap_8
XFILLER_130_1228 VDD VSS sg13g2_decap_8
XFILLER_19_63 VDD VSS sg13g2_decap_8
XFILLER_75_746 VDD VSS sg13g2_decap_8
X_13850_ _13850_/Q clkload51/A _13850_/D _13850_/RESET_B VDD VSS sg13g2_dfrbpq_1
XFILLER_47_459 VDD VSS sg13g2_fill_2
XFILLER_75_779 VDD VSS sg13g2_decap_8
XFILLER_16_802 VDD VSS sg13g2_fill_1
X_12801_ _12801_/Y _13609_/A _12801_/B VDD VSS sg13g2_nor2_1
XFILLER_74_278 VDD VSS sg13g2_decap_8
X_13781_ _13781_/Q _14503_/CLK _13781_/D _13781_/RESET_B VDD VSS sg13g2_dfrbpq_1
X_10993_ _10996_/B _10995_/A _10995_/C _10995_/B VDD VSS sg13g2_o21ai_1
XFILLER_90_738 VDD VSS sg13g2_decap_8
XFILLER_15_301 VDD VSS sg13g2_decap_8
XFILLER_76_1034 VDD VSS sg13g2_decap_4
XFILLER_71_941 VDD VSS sg13g2_fill_1
X_12732_ _12732_/X _12731_/X _12730_/X _12724_/X _12725_/X _12732_/S0 _12762_/S VDD
+ VSS sg13g2_mux4_1
XFILLER_43_643 VDD VSS sg13g2_fill_1
XFILLER_150_0 VDD VSS sg13g2_decap_8
XFILLER_167_1195 VDD VSS sg13g2_decap_8
XFILLER_43_676 VDD VSS sg13g2_decap_8
XFILLER_37_1029 VDD VSS sg13g2_decap_8
XFILLER_128_1157 VDD VSS sg13g2_decap_8
XFILLER_15_378 VDD VSS sg13g2_decap_8
XFILLER_76_1089 VDD VSS sg13g2_fill_1
XFILLER_54_1310 VDD VSS sg13g2_decap_8
XFILLER_19_1441 VDD VSS sg13g2_decap_8
X_12663_ _12663_/X _12657_/X _12661_/X _12656_/X _12660_/X _12663_/S0 _12663_/S1 VDD
+ VSS sg13g2_mux4_1
XFILLER_54_1321 VDD VSS sg13g2_fill_1
XFILLER_42_164 VDD VSS sg13g2_fill_2
X_14402_ _14402_/Q clkload40/A _14402_/D _14402_/RESET_B VDD VSS sg13g2_dfrbpq_1
XFILLER_15_1305 VDD VSS sg13g2_decap_8
X_11614_ _11615_/A _14246_/Q _14278_/Q _14310_/Q _14342_/Q _11597_/A _11742_/C VDD
+ VSS sg13g2_mux4_1
XFILLER_30_348 VDD VSS sg13g2_decap_8
XFILLER_156_501 VDD VSS sg13g2_decap_8
XFILLER_180_1373 VDD VSS sg13g2_decap_8
XFILLER_184_810 VDD VSS sg13g2_fill_1
X_12594_ _12594_/X _12590_/X _12589_/X _12586_/X _12585_/X wire856/X _12355_/S VDD
+ VSS sg13g2_mux4_1
XFILLER_129_726 VDD VSS sg13g2_decap_8
XFILLER_54_1387 VDD VSS sg13g2_fill_2
X_14333_ _14333_/Q _14886_/CLK _14333_/D _14333_/RESET_B VDD VSS sg13g2_dfrbpq_1
XFILLER_7_511 VDD VSS sg13g2_decap_8
XFILLER_102_1308 VDD VSS sg13g2_decap_8
XFILLER_168_394 VDD VSS sg13g2_fill_2
X_11545_ _11545_/Y _12238_/S0 _14468_/Q VDD VSS sg13g2_nand2b_1
X_15066__2970 _15066_/RESET_B VDD VSS sg13g2_tiehi
XFILLER_11_595 VDD VSS sg13g2_decap_8
XFILLER_184_865 VDD VSS sg13g2_decap_8
XFILLER_128_258 VDD VSS sg13g2_fill_2
XFILLER_171_504 VDD VSS sg13g2_decap_8
XFILLER_183_364 VDD VSS sg13g2_decap_8
X_14264_ _14264_/Q _14664_/CLK _14264_/D _14264_/RESET_B VDD VSS sg13g2_dfrbpq_1
X_11476_ _11476_/X _11473_/X _11472_/X _11468_/X _11469_/X _11494_/S0 _11498_/A1 VDD
+ VSS sg13g2_mux4_1
X_14413__1859 _14413_/RESET_B VDD VSS sg13g2_tiehi
XFILLER_7_588 VDD VSS sg13g2_decap_8
XFILLER_143_228 VDD VSS sg13g2_decap_8
XFILLER_87_1141 VDD VSS sg13g2_fill_1
X_13215_ _13216_/B _13215_/A _13215_/B VDD VSS sg13g2_xnor2_1
X_10427_ _14831_/D _14831_/Q _10453_/C _10426_/Y VDD VSS sg13g2_a21oi_1
XFILLER_48_1103 VDD VSS sg13g2_fill_2
XFILLER_100_1054 VDD VSS sg13g2_decap_8
XFILLER_109_494 VDD VSS sg13g2_fill_1
XFILLER_125_954 VDD VSS sg13g2_decap_8
XFILLER_136_291 VDD VSS sg13g2_decap_8
X_14195_ _14195_/Q clkload33/A _14195_/D _14195_/RESET_B VDD VSS sg13g2_dfrbpq_1
XFILLER_135_1106 VDD VSS sg13g2_decap_8
X_13146_ _13148_/B _13146_/A _13146_/B _13146_/C VDD VSS sg13g2_nand3_1
X_10358_ _10400_/B _14809_/Q _14810_/Q _10358_/C VDD VSS sg13g2_nand3_1
XFILLER_174_1155 VDD VSS sg13g2_decap_8
XFILLER_98_838 VDD VSS sg13g2_decap_8
XFILLER_139_1286 VDD VSS sg13g2_decap_8
XFILLER_112_637 VDD VSS sg13g2_decap_8
XFILLER_65_1461 VDD VSS sg13g2_decap_8
X_13077_ _13077_/X _14910_/Q _13677_/Q _13172_/B VDD VSS sg13g2_and3_1
XFILLER_111_136 VDD VSS sg13g2_decap_8
X_10289_ _14790_/D _10281_/D _10298_/D _10284_/Y _10297_/A _10667_/A VDD VSS sg13g2_a221oi_1
X_12028_ _12029_/A _13746_/Q _14098_/Q _14450_/Q _14546_/Q _12025_/A _12026_/C VDD
+ VSS sg13g2_mux4_1
XFILLER_61_1347 VDD VSS sg13g2_decap_8
XFILLER_26_1467 VDD VSS sg13g2_decap_8
XFILLER_26_1478 VDD VSS sg13g2_fill_1
XFILLER_65_201 VDD VSS sg13g2_decap_4
XFILLER_66_746 VDD VSS sg13g2_decap_8
XFILLER_76_91 VDD VSS sg13g2_decap_8
XFILLER_66_779 VDD VSS sg13g2_decap_8
XFILLER_20_1022 VDD VSS sg13g2_decap_8
XFILLER_81_705 VDD VSS sg13g2_decap_8
XFILLER_59_1210 VDD VSS sg13g2_fill_2
XFILLER_4_1274 VDD VSS sg13g2_decap_8
XFILLER_18_161 VDD VSS sg13g2_decap_8
X_13979_ _13979_/Q clkload60/A _13979_/D _13979_/RESET_B VDD VSS sg13g2_dfrbpq_1
XFILLER_47_993 VDD VSS sg13g2_fill_2
XFILLER_20_1077 VDD VSS sg13g2_decap_8
XFILLER_0_1149 VDD VSS sg13g2_decap_8
XFILLER_80_259 VDD VSS sg13g2_fill_2
XFILLER_181_1115 VDD VSS sg13g2_decap_8
XFILLER_59_1287 VDD VSS sg13g2_decap_4
XFILLER_179_637 VDD VSS sg13g2_decap_8
XFILLER_62_985 VDD VSS sg13g2_decap_8
XFILLER_61_462 VDD VSS sg13g2_decap_8
XFILLER_146_1257 VDD VSS sg13g2_decap_8
XFILLER_179_659 VDD VSS sg13g2_fill_2
XFILLER_21_304 VDD VSS sg13g2_fill_2
XFILLER_94_1189 VDD VSS sg13g2_decap_8
XFILLER_72_1410 VDD VSS sg13g2_decap_8
XFILLER_181_1148 VDD VSS sg13g2_decap_8
XFILLER_146_1279 VDD VSS sg13g2_decap_8
XFILLER_178_147 VDD VSS sg13g2_decap_8
XFILLER_61_495 VDD VSS sg13g2_decap_4
XFILLER_72_1443 VDD VSS sg13g2_decap_8
X_09170_ wire416/A _09938_/C _10137_/B _09938_/D VDD VSS sg13g2_nor3_1
XFILLER_33_1427 VDD VSS sg13g2_decap_8
X_08121_ _08121_/X _08598_/A3 _08620_/A3 _08620_/A2 _08627_/A2 _08686_/S0 _13510_/A1
+ VDD VSS sg13g2_mux4_1
XFILLER_119_225 VDD VSS sg13g2_decap_8
XFILLER_174_331 VDD VSS sg13g2_decap_8
XFILLER_179_1022 VDD VSS sg13g2_decap_8
XFILLER_135_707 VDD VSS sg13g2_fill_2
X_15198__2846 _15198_/RESET_B VDD VSS sg13g2_tiehi
X_08052_ _08052_/Y _08079_/S _08047_/Y _08048_/Y _08051_/Y VDD VSS sg13g2_a22oi_1
XFILLER_175_887 VDD VSS sg13g2_fill_1
XFILLER_162_515 VDD VSS sg13g2_decap_4
XFILLER_134_217 VDD VSS sg13g2_fill_1
XFILLER_179_1066 VDD VSS sg13g2_decap_8
XFILLER_31_1173 VDD VSS sg13g2_decap_8
XFILLER_66_1203 VDD VSS sg13g2_decap_4
XFILLER_115_475 VDD VSS sg13g2_decap_8
XFILLER_27_1209 VDD VSS sg13g2_decap_8
XFILLER_170_570 VDD VSS sg13g2_decap_8
Xhold3114 hold3114/X input32/X VDD VSS sg13g2_dlygate4sd3_1
XFILLER_89_849 VDD VSS sg13g2_decap_8
XFILLER_118_1337 VDD VSS sg13g2_fill_1
Xhold3125 _15172_/D _13485_/B VDD VSS sg13g2_dlygate4sd3_1
Xhold3136 input34/A hold3183/X VDD VSS sg13g2_dlygate4sd3_1
XFILLER_130_434 VDD VSS sg13g2_fill_2
XFILLER_131_957 VDD VSS sg13g2_decap_8
Xhold3147 input31/A mem_axi_rdata[5] VDD VSS sg13g2_dlygate4sd3_1
XFILLER_103_659 VDD VSS sg13g2_decap_8
Xhold3158 input20/A mem_axi_rdata[24] VDD VSS sg13g2_dlygate4sd3_1
X_08954_ _08954_/X _15052_/Q _14956_/Q _10716_/A VDD VSS sg13g2_mux2_1
XFILLER_88_359 VDD VSS sg13g2_fill_2
XFILLER_102_147 VDD VSS sg13g2_decap_8
XFILLER_9_1141 VDD VSS sg13g2_decap_8
X_14568__1704 _14568_/RESET_B VDD VSS sg13g2_tiehi
Xhold3169 hold3169/X input12/X VDD VSS sg13g2_dlygate4sd3_1
X_07905_ _07906_/C _07905_/A _07905_/B _07905_/C _07905_/D VDD VSS sg13g2_nor4_1
XFILLER_69_562 VDD VSS sg13g2_decap_8
XFILLER_97_882 VDD VSS sg13g2_decap_8
X_08885_ _08885_/Y _10725_/A _14939_/Q VDD VSS sg13g2_nand2_1
XFILLER_84_521 VDD VSS sg13g2_fill_2
XFILLER_99_1023 VDD VSS sg13g2_fill_2
XFILLER_99_1034 VDD VSS sg13g2_fill_1
XFILLER_56_223 VDD VSS sg13g2_decap_8
X_07836_ _08697_/B _15019_/Q _08673_/B VDD VSS sg13g2_nand2b_1
XFILLER_56_234 VDD VSS sg13g2_fill_2
XFILLER_99_1056 VDD VSS sg13g2_decap_8
XFILLER_42_1291 VDD VSS sg13g2_decap_8
XFILLER_72_727 VDD VSS sg13g2_decap_8
X_07767_ _08265_/A _07929_/B _08263_/B VDD VSS sg13g2_nor2_1
XFILLER_112_45 VDD VSS sg13g2_decap_4
XFILLER_65_790 VDD VSS sg13g2_decap_8
X_09506_ _14106_/D _10102_/A0 _14106_/Q _09506_/S VDD VSS sg13g2_mux2_1
XFILLER_37_492 VDD VSS sg13g2_decap_8
XFILLER_25_632 VDD VSS sg13g2_decap_8
XFILLER_112_78 VDD VSS sg13g2_decap_8
X_07698_ _07700_/B _15083_/Q _07701_/B VDD VSS sg13g2_nand2_1
XFILLER_77_1365 VDD VSS sg13g2_decap_8
XFILLER_112_89 VDD VSS sg13g2_fill_2
XFILLER_13_805 VDD VSS sg13g2_decap_8
XFILLER_73_1207 VDD VSS sg13g2_decap_8
XFILLER_38_1338 VDD VSS sg13g2_decap_8
XFILLER_73_1229 VDD VSS sg13g2_fill_2
X_09437_ _14039_/D _10066_/A0 _14039_/Q _09437_/S VDD VSS sg13g2_mux2_1
XFILLER_12_315 VDD VSS sg13g2_decap_8
XFILLER_125_1319 VDD VSS sg13g2_decap_8
XFILLER_36_1051 VDD VSS sg13g2_decap_8
X_09368_ _13972_/D _09997_/A0 _13972_/Q _09371_/S VDD VSS sg13g2_mux2_1
XFILLER_8_308 VDD VSS sg13g2_decap_8
XFILLER_36_1062 VDD VSS sg13g2_fill_2
XFILLER_166_821 VDD VSS sg13g2_fill_2
XFILLER_178_692 VDD VSS sg13g2_fill_1
XFILLER_162_1092 VDD VSS sg13g2_decap_4
XFILLER_165_320 VDD VSS sg13g2_decap_8
X_08319_ _08420_/A _08319_/A _08319_/B _08319_/C VDD VSS sg13g2_nor3_1
XFILLER_36_1095 VDD VSS sg13g2_fill_2
XFILLER_21_893 VDD VSS sg13g2_decap_8
X_09299_ _13907_/D _13907_/Q _10162_/A1 _09303_/S VDD VSS sg13g2_mux2_1
XFILLER_166_865 VDD VSS sg13g2_fill_2
XFILLER_166_876 VDD VSS sg13g2_decap_8
XFILLER_20_392 VDD VSS sg13g2_decap_8
X_11330_ _11330_/X _11321_/Y _11329_/Y _11378_/S VDD VSS sg13g2_mux2_1
XFILLER_166_887 VDD VSS sg13g2_fill_1
XFILLER_125_206 VDD VSS sg13g2_decap_8
XFILLER_126_729 VDD VSS sg13g2_fill_2
XFILLER_165_375 VDD VSS sg13g2_decap_8
XFILLER_180_301 VDD VSS sg13g2_decap_8
XFILLER_181_835 VDD VSS sg13g2_decap_8
XFILLER_21_42 VDD VSS sg13g2_decap_8
XFILLER_14_1393 VDD VSS sg13g2_decap_8
XFILLER_4_525 VDD VSS sg13g2_decap_8
XFILLER_158_1139 VDD VSS sg13g2_decap_8
X_11261_ _11262_/A _11275_/S0 _13884_/Q VDD VSS sg13g2_nand2b_1
XFILLER_10_1246 VDD VSS sg13g2_decap_8
XFILLER_181_879 VDD VSS sg13g2_decap_8
X_13000_ _13000_/Y _14811_/Q _13274_/A2 _13218_/B _10511_/D VDD VSS sg13g2_a22oi_1
X_10212_ _14763_/D _13316_/B _10209_/B hold3188/X VDD VSS sg13g2_a21oi_1
XFILLER_140_209 VDD VSS sg13g2_fill_2
XFILLER_180_378 VDD VSS sg13g2_decap_8
X_11192_ _11192_/X _11191_/Y _11189_/Y _11193_/A2 VDD VSS sg13g2_a21o_1
XFILLER_136_1426 VDD VSS sg13g2_decap_8
XFILLER_171_1306 VDD VSS sg13g2_decap_4
XFILLER_106_486 VDD VSS sg13g2_decap_8
XFILLER_134_795 VDD VSS sg13g2_decap_8
X_10143_ _14720_/D _14720_/Q _10143_/A1 _10168_/S VDD VSS sg13g2_mux2_1
XFILLER_121_456 VDD VSS sg13g2_decap_8
XFILLER_0_764 VDD VSS sg13g2_decap_8
X_14951_ _14951_/Q clkload72/A _14951_/D _14951_/RESET_B VDD VSS sg13g2_dfrbpq_1
X_10074_ _14654_/D _10074_/A0 _14654_/Q _10096_/S VDD VSS sg13g2_mux2_1
XFILLER_130_990 VDD VSS sg13g2_decap_8
XFILLER_48_735 VDD VSS sg13g2_decap_8
XFILLER_102_692 VDD VSS sg13g2_decap_8
XFILLER_130_1025 VDD VSS sg13g2_decap_8
X_13902_ _13902_/Q _14620_/CLK _13902_/D _13902_/RESET_B VDD VSS sg13g2_dfrbpq_1
XFILLER_101_191 VDD VSS sg13g2_decap_8
X_14882_ _14882_/Q _14883_/CLK _14882_/D _14882_/RESET_B VDD VSS sg13g2_dfrbpq_1
XFILLER_75_554 VDD VSS sg13g2_decap_8
XFILLER_47_256 VDD VSS sg13g2_decap_8
XFILLER_36_919 VDD VSS sg13g2_fill_2
XFILLER_1_1414 VDD VSS sg13g2_decap_8
XFILLER_29_971 VDD VSS sg13g2_fill_1
X_13833_ _13833_/Q _14729_/CLK _13833_/D _13833_/RESET_B VDD VSS sg13g2_dfrbpq_1
XFILLER_63_727 VDD VSS sg13g2_decap_4
XFILLER_35_418 VDD VSS sg13g2_decap_8
XFILLER_21_1375 VDD VSS sg13g2_decap_8
XFILLER_95_1443 VDD VSS sg13g2_decap_8
X_13764_ _13764_/Q clkload33/A _13764_/D _13764_/RESET_B VDD VSS sg13g2_dfrbpq_1
XFILLER_90_568 VDD VSS sg13g2_fill_2
X_10976_ _11009_/B _14759_/Q _10722_/Y _10942_/Y VDD VSS sg13g2_a21o_1
XFILLER_16_665 VDD VSS sg13g2_decap_8
XFILLER_182_1435 VDD VSS sg13g2_decap_8
X_12715_ _12715_/X _13973_/Q _14005_/Q _14037_/Q _14069_/Q _12715_/S0 _12715_/S1 VDD
+ VSS sg13g2_mux4_1
XFILLER_44_996 VDD VSS sg13g2_fill_2
XFILLER_143_1408 VDD VSS sg13g2_fill_1
XFILLER_15_175 VDD VSS sg13g2_decap_8
X_13695_ _16857_/A _15224_/CLK _13695_/D _13695_/RESET_B VDD VSS sg13g2_dfrbpq_1
X_14042__2230 _14042_/RESET_B VDD VSS sg13g2_tiehi
XFILLER_62_60 VDD VSS sg13g2_fill_2
XFILLER_15_1102 VDD VSS sg13g2_decap_8
X_13695__2577 _13695_/RESET_B VDD VSS sg13g2_tiehi
X_12646_ _12646_/X _14128_/Q _14160_/Q _14192_/Q _14224_/Q _12661_/S0 _12661_/S1 VDD
+ VSS sg13g2_mux4_1
XFILLER_87_7 VDD VSS sg13g2_decap_8
XFILLER_129_534 VDD VSS sg13g2_decap_8
XFILLER_129_545 VDD VSS sg13g2_fill_2
XFILLER_12_882 VDD VSS sg13g2_decap_8
XFILLER_89_1203 VDD VSS sg13g2_fill_1
XFILLER_102_1105 VDD VSS sg13g2_decap_4
X_12577_ _12577_/X _14379_/Q _14411_/Q _14475_/Q _14507_/Q _12659_/S0 _12659_/S1 VDD
+ VSS sg13g2_mux4_1
XFILLER_30_189 VDD VSS sg13g2_decap_4
X_14646__1626 _14646_/RESET_B VDD VSS sg13g2_tiehi
XFILLER_102_1127 VDD VSS sg13g2_decap_8
XFILLER_11_392 VDD VSS sg13g2_decap_8
XFILLER_157_887 VDD VSS sg13g2_decap_8
XFILLER_15_1179 VDD VSS sg13g2_decap_8
X_14316_ _14316_/Q clkload50/A _14316_/D _14316_/RESET_B VDD VSS sg13g2_dfrbpq_1
X_11528_ _11528_/X _14116_/Q _14148_/Q _11528_/S VDD VSS sg13g2_mux2_1
XFILLER_8_875 VDD VSS sg13g2_decap_8
XFILLER_172_824 VDD VSS sg13g2_decap_4
XFILLER_183_161 VDD VSS sg13g2_decap_8
XFILLER_116_217 VDD VSS sg13g2_fill_2
XFILLER_7_77 VDD VSS sg13g2_decap_8
XFILLER_156_397 VDD VSS sg13g2_decap_8
XFILLER_7_385 VDD VSS sg13g2_decap_8
XFILLER_171_334 VDD VSS sg13g2_decap_8
X_14247_ _14247_/Q clkload13/A _14247_/D _14247_/RESET_B VDD VSS sg13g2_dfrbpq_1
X_14075__2197 _14075_/RESET_B VDD VSS sg13g2_tiehi
X_11459_ _11459_/Y _11457_/Y _11458_/Y _11451_/Y _11458_/A _11501_/A2 VDD VSS sg13g2_a221oi_1
XFILLER_131_209 VDD VSS sg13g2_decap_4
XFILLER_98_613 VDD VSS sg13g2_fill_1
X_14178_ _14178_/Q _14656_/CLK _14178_/D _14178_/RESET_B VDD VSS sg13g2_dfrbpq_1
XFILLER_124_272 VDD VSS sg13g2_decap_8
XFILLER_139_1083 VDD VSS sg13g2_decap_8
XFILLER_98_646 VDD VSS sg13g2_decap_8
XFILLER_112_434 VDD VSS sg13g2_decap_8
XFILLER_113_968 VDD VSS sg13g2_decap_8
XFILLER_139_1094 VDD VSS sg13g2_decap_8
X_13129_ _13133_/C _14915_/Q _13129_/B VDD VSS sg13g2_xor2_1
XFILLER_140_776 VDD VSS sg13g2_decap_8
X_15014__2666 _15014_/RESET_B VDD VSS sg13g2_tiehi
XFILLER_61_1111 VDD VSS sg13g2_decap_8
XFILLER_97_189 VDD VSS sg13g2_decap_8
XFILLER_79_893 VDD VSS sg13g2_fill_2
XFILLER_78_370 VDD VSS sg13g2_decap_8
XFILLER_66_510 VDD VSS sg13g2_decap_8
XFILLER_26_1264 VDD VSS sg13g2_decap_8
XFILLER_113_1234 VDD VSS sg13g2_fill_1
Xfanout1370 _12073_/S1 _12259_/S1 VDD VSS sg13g2_buf_1
XFILLER_6_1358 VDD VSS sg13g2_decap_8
XFILLER_22_1128 VDD VSS sg13g2_decap_8
X_08670_ _08670_/Y _08080_/Y _08012_/Y _08010_/Y _08669_/Y _08402_/C VDD VSS sg13g2_a221oi_1
Xfanout1381 fanout1381/X _12215_/S1 VDD VSS sg13g2_buf_1
Xfanout1392 _11741_/A _11963_/S0 VDD VSS sg13g2_buf_1
XFILLER_94_885 VDD VSS sg13g2_decap_8
X_07621_ _07621_/Y _14868_/Q VDD VSS sg13g2_inv_1
XFILLER_54_727 VDD VSS sg13g2_decap_8
XFILLER_93_373 VDD VSS sg13g2_fill_1
XFILLER_81_524 VDD VSS sg13g2_decap_8
XFILLER_4_1071 VDD VSS sg13g2_decap_8
XFILLER_53_237 VDD VSS sg13g2_decap_4
XFILLER_59_1040 VDD VSS sg13g2_decap_8
XFILLER_81_568 VDD VSS sg13g2_decap_8
XFILLER_179_434 VDD VSS sg13g2_decap_8
XFILLER_34_473 VDD VSS sg13g2_fill_1
XFILLER_21_112 VDD VSS sg13g2_decap_8
XFILLER_50_944 VDD VSS sg13g2_fill_1
X_09222_ _13833_/D _09953_/A1 _13833_/Q _09238_/S VDD VSS sg13g2_mux2_1
XFILLER_50_966 VDD VSS sg13g2_decap_8
XFILLER_148_810 VDD VSS sg13g2_decap_8
XFILLER_22_668 VDD VSS sg13g2_decap_8
XFILLER_10_819 VDD VSS sg13g2_decap_8
X_14285__1987 _14285_/RESET_B VDD VSS sg13g2_tiehi
XFILLER_72_1262 VDD VSS sg13g2_decap_8
X_09153_ _13784_/D _13784_/Q _10134_/A0 _09153_/S VDD VSS sg13g2_mux2_1
XFILLER_124_1363 VDD VSS sg13g2_fill_1
XFILLER_21_189 VDD VSS sg13g2_decap_8
XFILLER_33_1246 VDD VSS sg13g2_decap_8
XFILLER_33_1257 VDD VSS sg13g2_fill_2
XFILLER_148_876 VDD VSS sg13g2_decap_8
X_08104_ _08104_/Y _08201_/A _08104_/B _08104_/C _08104_/D VDD VSS sg13g2_nor4_1
X_14768__3038 _14768_/RESET_B VDD VSS sg13g2_tiehi
XFILLER_147_364 VDD VSS sg13g2_decap_8
XFILLER_163_813 VDD VSS sg13g2_decap_8
X_09084_ _13774_/D _13774_/Q _09925_/A1 _09127_/S VDD VSS sg13g2_mux2_1
XFILLER_159_1415 VDD VSS sg13g2_decap_8
XFILLER_174_161 VDD VSS sg13g2_decap_8
XFILLER_175_684 VDD VSS sg13g2_decap_8
XFILLER_107_239 VDD VSS sg13g2_fill_1
X_08035_ _08035_/X _08035_/A _08659_/B VDD VSS sg13g2_or2_1
XFILLER_162_334 VDD VSS sg13g2_decap_8
XFILLER_116_740 VDD VSS sg13g2_decap_8
XFILLER_163_868 VDD VSS sg13g2_decap_8
XFILLER_150_507 VDD VSS sg13g2_decap_8
X_13740__2532 _13740_/RESET_B VDD VSS sg13g2_tiehi
XFILLER_116_762 VDD VSS sg13g2_decap_8
XFILLER_104_913 VDD VSS sg13g2_decap_8
XFILLER_150_518 VDD VSS sg13g2_fill_1
XFILLER_118_1101 VDD VSS sg13g2_decap_4
Xmax_cap583 _10105_/B _09342_/A VDD VSS sg13g2_buf_2
XFILLER_1_539 VDD VSS sg13g2_decap_8
XFILLER_153_1025 VDD VSS sg13g2_fill_1
XFILLER_66_1077 VDD VSS sg13g2_fill_1
XFILLER_27_1039 VDD VSS sg13g2_fill_1
XFILLER_104_979 VDD VSS sg13g2_fill_1
X_09986_ _14569_/D _10085_/A0 _14569_/Q _09998_/S VDD VSS sg13g2_mux2_1
XFILLER_107_89 VDD VSS sg13g2_decap_8
XFILLER_118_1167 VDD VSS sg13g2_decap_8
XFILLER_114_1009 VDD VSS sg13g2_decap_8
XFILLER_130_275 VDD VSS sg13g2_decap_8
X_08937_ _08937_/X _08936_/X _12152_/A _08937_/S VDD VSS sg13g2_mux2_1
X_14120__2152 _14120_/RESET_B VDD VSS sg13g2_tiehi
XFILLER_29_212 VDD VSS sg13g2_decap_8
XFILLER_85_841 VDD VSS sg13g2_decap_4
XFILLER_170_1383 VDD VSS sg13g2_decap_8
X_13773__2499 _13773_/RESET_B VDD VSS sg13g2_tiehi
XFILLER_79_1405 VDD VSS sg13g2_fill_2
X_08868_ _13700_/D _16862_/A _08867_/X _08941_/S VDD VSS sg13g2_mux2_1
XFILLER_85_863 VDD VSS sg13g2_decap_8
XFILLER_57_565 VDD VSS sg13g2_fill_1
X_07819_ _07822_/A _15009_/Q _07821_/B VDD VSS sg13g2_nor2_1
XFILLER_72_513 VDD VSS sg13g2_fill_1
XFILLER_84_384 VDD VSS sg13g2_fill_2
XFILLER_83_37 VDD VSS sg13g2_decap_8
X_14724__1548 _14724_/RESET_B VDD VSS sg13g2_tiehi
X_08799_ _13684_/D _08799_/A _08799_/B VDD VSS sg13g2_nor2_1
XFILLER_26_930 VDD VSS sg13g2_fill_2
X_10830_ _10830_/X _10831_/A _10831_/B _10831_/C VDD VSS sg13g2_a21o_1
XFILLER_16_42 VDD VSS sg13g2_decap_8
XFILLER_73_1004 VDD VSS sg13g2_decap_4
XFILLER_13_602 VDD VSS sg13g2_decap_8
XFILLER_164_1121 VDD VSS sg13g2_decap_8
XFILLER_168_1290 VDD VSS sg13g2_decap_4
XFILLER_77_1173 VDD VSS sg13g2_decap_8
XFILLER_73_1015 VDD VSS sg13g2_fill_1
XFILLER_38_1135 VDD VSS sg13g2_fill_1
X_10761_ _14917_/D _11045_/B1 _11115_/A _10760_/Y VDD VSS sg13g2_o21ai_1
XFILLER_40_410 VDD VSS sg13g2_decap_8
XFILLER_12_112 VDD VSS sg13g2_decap_8
XFILLER_186_916 VDD VSS sg13g2_fill_2
XFILLER_80_590 VDD VSS sg13g2_decap_4
X_12500_ _12513_/A _12765_/A1 _07737_/B _08306_/B VDD VSS sg13g2_a21oi_1
XFILLER_125_1127 VDD VSS sg13g2_decap_8
X_13480_ _15114_/D _15180_/D _15114_/Q _13480_/S VDD VSS sg13g2_mux2_1
X_10692_ _10693_/A _14900_/Q _10875_/B _07753_/B _10870_/A VDD VSS sg13g2_a22oi_1
XFILLER_13_679 VDD VSS sg13g2_decap_8
XFILLER_164_1198 VDD VSS sg13g2_decap_8
XFILLER_16_1433 VDD VSS sg13g2_decap_8
XFILLER_90_1362 VDD VSS sg13g2_fill_1
XFILLER_8_105 VDD VSS sg13g2_decap_8
XFILLER_139_832 VDD VSS sg13g2_fill_1
XFILLER_185_448 VDD VSS sg13g2_decap_8
X_12431_ _12431_/X _14561_/Q _14593_/Q _14625_/Q _14657_/Q _12550_/S0 _12550_/S1 VDD
+ VSS sg13g2_mux4_1
XFILLER_12_189 VDD VSS sg13g2_decap_8
XFILLER_142_1452 VDD VSS sg13g2_fill_1
XFILLER_40_498 VDD VSS sg13g2_fill_2
XFILLER_32_63 VDD VSS sg13g2_decap_8
XFILLER_154_813 VDD VSS sg13g2_decap_8
X_15150_ _15150_/Q clkload78/A _15150_/D _15150_/RESET_B VDD VSS sg13g2_dfrbpq_1
X_13691__2583 _13691_/RESET_B VDD VSS sg13g2_tiehi
X_12362_ _12362_/X _14364_/Q _14396_/Q _14460_/Q _14492_/Q _12368_/S0 _12368_/S1 VDD
+ VSS sg13g2_mux4_1
XFILLER_103_1458 VDD VSS sg13g2_decap_8
XFILLER_5_812 VDD VSS sg13g2_decap_8
XFILLER_138_386 VDD VSS sg13g2_decap_4
XFILLER_165_172 VDD VSS sg13g2_decap_8
XFILLER_166_695 VDD VSS sg13g2_decap_8
XFILLER_113_0 VDD VSS sg13g2_fill_2
XFILLER_165_183 VDD VSS sg13g2_decap_8
X_14101_ _14101_/Q _14727_/CLK _14101_/D _14101_/RESET_B VDD VSS sg13g2_dfrbpq_1
XFILLER_14_1190 VDD VSS sg13g2_decap_8
X_11313_ _11313_/Y _11378_/S _11301_/Y _11312_/Y VDD VSS sg13g2_o21ai_1
X_15081_ _15081_/Q clkload87/A _15081_/D _15081_/RESET_B VDD VSS sg13g2_dfrbpq_1
X_12293_ _12293_/Y _11654_/S _12289_/X _12292_/Y VDD VSS sg13g2_o21ai_1
XFILLER_4_322 VDD VSS sg13g2_decap_8
XFILLER_10_1043 VDD VSS sg13g2_decap_8
XFILLER_181_665 VDD VSS sg13g2_decap_8
XFILLER_49_1231 VDD VSS sg13g2_decap_8
X_14032_ _14032_/Q _14513_/CLK _14032_/D _14032_/RESET_B VDD VSS sg13g2_dfrbpq_1
X_14330__1942 _14330_/RESET_B VDD VSS sg13g2_tiehi
X_11244_ _11245_/C _13293_/A _11243_/C _07687_/B VDD VSS sg13g2_a21oi_1
XFILLER_5_889 VDD VSS sg13g2_decap_8
XFILLER_136_1201 VDD VSS sg13g2_decap_8
XFILLER_180_175 VDD VSS sg13g2_decap_8
XFILLER_84_1144 VDD VSS sg13g2_decap_4
X_14942__2753 _14942_/RESET_B VDD VSS sg13g2_tiehi
XFILLER_122_732 VDD VSS sg13g2_decap_4
XFILLER_4_399 VDD VSS sg13g2_decap_8
XFILLER_45_1106 VDD VSS sg13g2_fill_1
XFILLER_171_1114 VDD VSS sg13g2_fill_2
X_11175_ _11175_/Y _11164_/B _11164_/C _11185_/A VDD VSS sg13g2_a21oi_1
XFILLER_110_916 VDD VSS sg13g2_decap_4
XFILLER_121_253 VDD VSS sg13g2_decap_8
XFILLER_136_1278 VDD VSS sg13g2_decap_8
X_10126_ _14704_/D _10159_/A1 _14704_/Q _10127_/S VDD VSS sg13g2_mux2_1
XFILLER_62_1442 VDD VSS sg13g2_fill_1
XFILLER_79_189 VDD VSS sg13g2_decap_8
XFILLER_67_329 VDD VSS sg13g2_decap_8
XFILLER_95_649 VDD VSS sg13g2_decap_8
XFILLER_94_137 VDD VSS sg13g2_decap_8
X_14934_ _14934_/Q _15226_/CLK _14934_/D _14934_/RESET_B VDD VSS sg13g2_dfrbpq_1
X_10057_ _14638_/D _10090_/A0 _14638_/Q _10063_/S VDD VSS sg13g2_mux2_1
XFILLER_48_543 VDD VSS sg13g2_decap_8
XFILLER_94_159 VDD VSS sg13g2_decap_8
XFILLER_48_554 VDD VSS sg13g2_fill_1
XFILLER_75_362 VDD VSS sg13g2_decap_8
XFILLER_1_1211 VDD VSS sg13g2_decap_8
X_14865_ _14865_/Q clkload64/A _14865_/D _14865_/RESET_B VDD VSS sg13g2_dfrbpq_1
XFILLER_48_598 VDD VSS sg13g2_decap_8
XFILLER_63_535 VDD VSS sg13g2_decap_8
X_15179__2944 _15179_/RESET_B VDD VSS sg13g2_tiehi
XFILLER_90_321 VDD VSS sg13g2_decap_8
XFILLER_17_941 VDD VSS sg13g2_decap_8
XFILLER_21_1172 VDD VSS sg13g2_decap_8
X_13816_ _13816_/Q _14744_/CLK _13816_/D _13816_/RESET_B VDD VSS sg13g2_dfrbpq_1
XFILLER_91_866 VDD VSS sg13g2_decap_4
XFILLER_35_259 VDD VSS sg13g2_decap_4
X_14796_ _14796_/Q _14864_/CLK _14796_/D _14796_/RESET_B VDD VSS sg13g2_dfrbpq_1
XFILLER_91_888 VDD VSS sg13g2_decap_4
XFILLER_16_462 VDD VSS sg13g2_decap_8
XFILLER_1_1288 VDD VSS sg13g2_decap_8
X_15120__2812 _15120_/RESET_B VDD VSS sg13g2_tiehi
XFILLER_95_1273 VDD VSS sg13g2_decap_8
XFILLER_73_70 VDD VSS sg13g2_decap_8
X_13747_ _13747_/Q clkload32/A _13747_/D _13747_/RESET_B VDD VSS sg13g2_dfrbpq_1
XFILLER_95_1284 VDD VSS sg13g2_fill_1
XFILLER_90_398 VDD VSS sg13g2_decap_8
XFILLER_73_81 VDD VSS sg13g2_fill_2
XFILLER_108_1314 VDD VSS sg13g2_fill_2
X_10959_ _10959_/Y _10959_/A _11021_/B VDD VSS sg13g2_nand2_1
XFILLER_17_1208 VDD VSS sg13g2_decap_8
XFILLER_182_1254 VDD VSS sg13g2_decap_8
XFILLER_91_1137 VDD VSS sg13g2_fill_1
XFILLER_149_607 VDD VSS sg13g2_decap_8
XFILLER_32_955 VDD VSS sg13g2_decap_8
X_13678_ _13678_/Q _15212_/CLK _13678_/D _13678_/RESET_B VDD VSS sg13g2_dfrbpq_1
XFILLER_148_128 VDD VSS sg13g2_decap_8
XFILLER_85_4 VDD VSS sg13g2_fill_1
XFILLER_31_476 VDD VSS sg13g2_decap_8
XFILLER_176_448 VDD VSS sg13g2_decap_8
X_12629_ _12629_/X _14255_/Q _14287_/Q _14319_/Q _14351_/Q _12675_/S0 _12675_/S1 VDD
+ VSS sg13g2_mux4_1
XFILLER_129_331 VDD VSS sg13g2_decap_4
XFILLER_157_662 VDD VSS sg13g2_decap_8
XFILLER_185_982 VDD VSS sg13g2_decap_8
XFILLER_89_1033 VDD VSS sg13g2_decap_8
XFILLER_156_161 VDD VSS sg13g2_decap_8
XFILLER_8_672 VDD VSS sg13g2_decap_8
XFILLER_7_182 VDD VSS sg13g2_decap_8
XFILLER_160_816 VDD VSS sg13g2_decap_8
XFILLER_137_1009 VDD VSS sg13g2_fill_2
XFILLER_176_1058 VDD VSS sg13g2_decap_8
XFILLER_99_922 VDD VSS sg13g2_decap_8
XFILLER_28_1326 VDD VSS sg13g2_decap_8
Xfanout607 _08822_/B _08723_/Y VDD VSS sg13g2_buf_1
X_09840_ _14427_/D _14427_/Q _10071_/A0 _09859_/S VDD VSS sg13g2_mux2_1
XFILLER_112_231 VDD VSS sg13g2_decap_8
XFILLER_140_540 VDD VSS sg13g2_decap_8
Xfanout618 _13546_/B2 _12936_/Y VDD VSS sg13g2_buf_1
XFILLER_98_454 VDD VSS sg13g2_decap_8
XFILLER_59_808 VDD VSS sg13g2_decap_8
XFILLER_28_1348 VDD VSS sg13g2_decap_8
Xfanout629 _13272_/A2 _12914_/A VDD VSS sg13g2_buf_1
XFILLER_98_465 VDD VSS sg13g2_fill_2
XFILLER_101_938 VDD VSS sg13g2_decap_4
XFILLER_58_318 VDD VSS sg13g2_fill_2
X_09771_ _14361_/D _14361_/Q _09936_/A1 _09771_/S VDD VSS sg13g2_mux2_1
XFILLER_85_115 VDD VSS sg13g2_decap_8
XFILLER_26_1072 VDD VSS sg13g2_decap_4
X_08722_ _15214_/D _15193_/D _12347_/B _13501_/A VDD VSS sg13g2_mux2_1
XFILLER_100_459 VDD VSS sg13g2_decap_4
XFILLER_6_1155 VDD VSS sg13g2_decap_8
XFILLER_66_340 VDD VSS sg13g2_decap_4
XFILLER_2_1008 VDD VSS sg13g2_decap_8
XFILLER_113_1075 VDD VSS sg13g2_decap_8
X_08653_ _08661_/B _08653_/A _08653_/B _15018_/Q VDD VSS sg13g2_nand3_1
XFILLER_27_749 VDD VSS sg13g2_decap_8
XFILLER_82_844 VDD VSS sg13g2_decap_8
XFILLER_26_226 VDD VSS sg13g2_decap_4
XFILLER_82_866 VDD VSS sg13g2_fill_2
XFILLER_42_708 VDD VSS sg13g2_fill_1
X_08584_ _08584_/Y _08698_/B _08608_/A VDD VSS sg13g2_nor2_1
XFILLER_78_1471 VDD VSS sg13g2_decap_4
XFILLER_39_1444 VDD VSS sg13g2_decap_8
XFILLER_126_1403 VDD VSS sg13g2_fill_1
XFILLER_179_231 VDD VSS sg13g2_decap_8
X_13758__2514 _13758_/RESET_B VDD VSS sg13g2_tiehi
XFILLER_23_933 VDD VSS sg13g2_decap_8
XFILLER_22_410 VDD VSS sg13g2_decap_8
XFILLER_165_1463 VDD VSS sg13g2_decap_4
XFILLER_39_1466 VDD VSS sg13g2_decap_8
XFILLER_161_1305 VDD VSS sg13g2_decap_8
XFILLER_168_916 VDD VSS sg13g2_decap_8
XFILLER_74_1357 VDD VSS sg13g2_decap_8
XFILLER_39_1477 VDD VSS sg13g2_fill_2
XFILLER_126_1436 VDD VSS sg13g2_fill_2
XFILLER_167_415 VDD VSS sg13g2_decap_8
XFILLER_10_616 VDD VSS sg13g2_decap_8
X_15068__2962 _15068_/RESET_B VDD VSS sg13g2_tiehi
X_15218__3079 _15218_/RESET_B VDD VSS sg13g2_tiehi
X_09205_ _09307_/B _09938_/A _09938_/B _09938_/C VDD VSS sg13g2_nand3b_1
XFILLER_37_1190 VDD VSS sg13g2_decap_8
XFILLER_124_1160 VDD VSS sg13g2_fill_1
XFILLER_6_609 VDD VSS sg13g2_decap_8
XFILLER_148_662 VDD VSS sg13g2_decap_8
XFILLER_154_109 VDD VSS sg13g2_decap_8
XFILLER_176_982 VDD VSS sg13g2_decap_4
X_09136_ _09137_/C _13142_/A _09136_/B _09150_/C _09164_/C VDD VSS sg13g2_and4_1
XFILLER_124_1193 VDD VSS sg13g2_decap_8
XFILLER_136_824 VDD VSS sg13g2_decap_8
XFILLER_185_28 VDD VSS sg13g2_decap_8
XFILLER_136_835 VDD VSS sg13g2_fill_1
XFILLER_163_621 VDD VSS sg13g2_fill_2
X_14138__2134 _14138_/RESET_B VDD VSS sg13g2_tiehi
XFILLER_5_119 VDD VSS sg13g2_decap_8
XFILLER_175_481 VDD VSS sg13g2_decap_4
X_15129__2792 _15129_/RESET_B VDD VSS sg13g2_tiehi
XFILLER_33_1098 VDD VSS sg13g2_fill_2
XFILLER_11_1330 VDD VSS sg13g2_decap_8
XFILLER_163_643 VDD VSS sg13g2_decap_8
X_09067_ _09069_/B _13064_/A _09089_/C _14911_/Q VDD VSS sg13g2_a21oi_1
XFILLER_136_868 VDD VSS sg13g2_decap_8
XFILLER_136_879 VDD VSS sg13g2_fill_1
Xclkbuf_4_5_0_clk_i clkbuf_4_5_0_clk_i/X clkbuf_0_clk_i/X VDD VSS sg13g2_buf_8
XFILLER_85_1420 VDD VSS sg13g2_fill_2
XFILLER_123_518 VDD VSS sg13g2_decap_8
X_08018_ _08018_/X _11635_/A _11661_/A _11706_/A _08457_/A3 _08253_/S0 _08033_/A VDD
+ VSS sg13g2_mux4_1
XFILLER_116_570 VDD VSS sg13g2_fill_1
XFILLER_85_1442 VDD VSS sg13g2_decap_8
XFILLER_2_826 VDD VSS sg13g2_decap_8
XFILLER_46_1415 VDD VSS sg13g2_decap_8
XFILLER_150_348 VDD VSS sg13g2_decap_8
XFILLER_172_1423 VDD VSS sg13g2_fill_2
XFILLER_1_336 VDD VSS sg13g2_decap_8
XFILLER_78_59 VDD VSS sg13g2_fill_1
XFILLER_89_443 VDD VSS sg13g2_decap_8
XFILLER_89_454 VDD VSS sg13g2_fill_2
XFILLER_133_1407 VDD VSS sg13g2_decap_8
XFILLER_81_1339 VDD VSS sg13g2_decap_8
XFILLER_131_562 VDD VSS sg13g2_decap_8
X_13668__2629 _13668_/RESET_B VDD VSS sg13g2_tiehi
XFILLER_89_476 VDD VSS sg13g2_decap_4
X_09969_ _14553_/D _14553_/Q _10101_/A0 _09969_/S VDD VSS sg13g2_mux2_1
XFILLER_44_1150 VDD VSS sg13g2_fill_1
XFILLER_94_14 VDD VSS sg13g2_decap_4
XFILLER_58_852 VDD VSS sg13g2_fill_1
X_12980_ _12980_/Y _12842_/A _11290_/A input6/X VDD VSS sg13g2_a21oi_1
XFILLER_58_863 VDD VSS sg13g2_fill_2
XFILLER_94_47 VDD VSS sg13g2_decap_8
XFILLER_79_1202 VDD VSS sg13g2_fill_2
XFILLER_44_1194 VDD VSS sg13g2_decap_8
XFILLER_94_58 VDD VSS sg13g2_fill_2
XFILLER_91_118 VDD VSS sg13g2_decap_4
XFILLER_40_1047 VDD VSS sg13g2_decap_8
X_11931_ _11931_/Y _14914_/Q _12122_/A2 _12124_/A2 VDD VSS sg13g2_a21oi_1
XFILLER_85_693 VDD VSS sg13g2_fill_1
XFILLER_84_181 VDD VSS sg13g2_decap_8
XFILLER_27_63 VDD VSS sg13g2_decap_8
XFILLER_150_42 VDD VSS sg13g2_decap_8
XFILLER_72_332 VDD VSS sg13g2_fill_1
X_14650_ _14650_/Q clkload55/A _14650_/D _14650_/RESET_B VDD VSS sg13g2_dfrbpq_1
XFILLER_17_259 VDD VSS sg13g2_decap_8
X_11862_ _14975_/D _11843_/A _11980_/A _11861_/Y VDD VSS sg13g2_a21o_1
XFILLER_73_888 VDD VSS sg13g2_decap_8
X_13601_ _13609_/B _13601_/A _13601_/B VDD VSS sg13g2_nor2_1
X_10813_ _10851_/A _10813_/A _10818_/B VDD VSS sg13g2_nor2_1
XFILLER_92_1424 VDD VSS sg13g2_decap_8
X_14581_ _14581_/Q clkload28/A _14581_/D _14581_/RESET_B VDD VSS sg13g2_dfrbpq_1
X_11793_ _11793_/Y _11793_/A1 _11791_/X _12124_/A2 VDD VSS sg13g2_a21oi_1
X_14348__1924 _14348_/RESET_B VDD VSS sg13g2_tiehi
XFILLER_14_966 VDD VSS sg13g2_decap_8
X_13532_ _15143_/D _13535_/B _13530_/Y _13531_/Y VDD VSS sg13g2_a21oi_1
X_10744_ _11068_/C _10747_/A _09086_/Y _08913_/Y VDD VSS sg13g2_o21ai_1
XFILLER_158_437 VDD VSS sg13g2_fill_2
XFILLER_40_251 VDD VSS sg13g2_decap_8
XFILLER_13_476 VDD VSS sg13g2_decap_8
XFILLER_16_1230 VDD VSS sg13g2_decap_8
XFILLER_43_84 VDD VSS sg13g2_decap_8
XFILLER_185_245 VDD VSS sg13g2_decap_8
XFILLER_186_768 VDD VSS sg13g2_decap_8
X_13463_ _13463_/X _15191_/Q _13463_/B _15192_/Q _13463_/D VDD VSS sg13g2_or4_1
XFILLER_103_1200 VDD VSS sg13g2_decap_8
XFILLER_186_779 VDD VSS sg13g2_decap_8
X_10675_ _10805_/C _10675_/A _10675_/B _10675_/C VDD VSS sg13g2_nor3_1
X_15202_ _15202_/Q clkload90/A _15202_/D _15202_/RESET_B VDD VSS sg13g2_dfrbpq_1
XFILLER_9_469 VDD VSS sg13g2_decap_8
X_12414_ _12415_/B _12413_/X _12412_/X _12790_/S VDD VSS sg13g2_mux2_1
XFILLER_127_824 VDD VSS sg13g2_decap_4
XFILLER_173_429 VDD VSS sg13g2_decap_8
XFILLER_12_1127 VDD VSS sg13g2_decap_8
X_13394_ _15085_/D _13455_/A _13391_/C _13393_/Y VDD VSS sg13g2_o21ai_1
XFILLER_182_930 VDD VSS sg13g2_fill_2
XFILLER_166_492 VDD VSS sg13g2_decap_8
XFILLER_51_1198 VDD VSS sg13g2_decap_4
XFILLER_182_952 VDD VSS sg13g2_decap_4
X_15133_ _15133_/Q clkload77/A _15133_/D _15133_/RESET_B VDD VSS sg13g2_dfrbpq_1
XFILLER_153_120 VDD VSS sg13g2_fill_1
XFILLER_177_1334 VDD VSS sg13g2_decap_8
X_12345_ _12345_/X _13723_/Q _14075_/Q _14427_/Q _14523_/Q wire940/X _12620_/S1 VDD
+ VSS sg13g2_mux4_1
XFILLER_138_1307 VDD VSS sg13g2_decap_8
XFILLER_182_974 VDD VSS sg13g2_decap_8
XFILLER_154_676 VDD VSS sg13g2_decap_8
XFILLER_181_462 VDD VSS sg13g2_decap_8
X_15064_ _15064_/Q _15113_/CLK _15064_/D _15064_/RESET_B VDD VSS sg13g2_dfrbpq_1
X_12276_ _12280_/A _12273_/Y _12204_/A _12275_/Y VDD VSS sg13g2_o21ai_1
XFILLER_5_686 VDD VSS sg13g2_decap_8
XFILLER_141_348 VDD VSS sg13g2_decap_8
X_14015_ _14015_/Q clkload21/A _14015_/D _14015_/RESET_B VDD VSS sg13g2_dfrbpq_1
X_11227_ _11227_/X _11225_/X _11226_/X _11875_/B VDD VSS sg13g2_mux2_1
XFILLER_4_56 VDD VSS sg13g2_decap_8
XFILLER_4_196 VDD VSS sg13g2_decap_8
XFILLER_136_1053 VDD VSS sg13g2_decap_8
XFILLER_110_713 VDD VSS sg13g2_decap_8
X_13836__2436 _13836_/RESET_B VDD VSS sg13g2_tiehi
X_11158_ _11158_/Y _11144_/Y _11151_/B _11173_/C VDD VSS sg13g2_o21ai_1
X_14596__1676 _14596_/RESET_B VDD VSS sg13g2_tiehi
XFILLER_7_1442 VDD VSS sg13g2_decap_8
XFILLER_27_1370 VDD VSS sg13g2_decap_8
X_10109_ _14687_/D _10109_/A0 _14687_/Q _10130_/S VDD VSS sg13g2_mux2_1
XFILLER_49_852 VDD VSS sg13g2_decap_8
X_11089_ _11091_/B _11125_/A _10754_/X _11058_/Y VDD VSS sg13g2_a21oi_1
XFILLER_64_811 VDD VSS sg13g2_decap_8
X_14917_ _14917_/Q _14947_/CLK _14917_/D _14917_/RESET_B VDD VSS sg13g2_dfrbpq_1
XFILLER_97_1324 VDD VSS sg13g2_decap_8
XFILLER_23_1267 VDD VSS sg13g2_decap_8
XFILLER_48_384 VDD VSS sg13g2_fill_2
XFILLER_110_1237 VDD VSS sg13g2_decap_8
XFILLER_36_546 VDD VSS sg13g2_decap_8
X_14848_ _14848_/Q _14883_/CLK _14848_/D _14848_/RESET_B VDD VSS sg13g2_dfrbpq_1
XFILLER_24_708 VDD VSS sg13g2_decap_8
X_14216__2056 _14216_/RESET_B VDD VSS sg13g2_tiehi
XFILLER_64_888 VDD VSS sg13g2_decap_8
XFILLER_90_162 VDD VSS sg13g2_decap_8
XFILLER_51_516 VDD VSS sg13g2_decap_8
XFILLER_1_1085 VDD VSS sg13g2_decap_8
XFILLER_56_1021 VDD VSS sg13g2_decap_8
X_14779_ _14779_/Q clkload62/A _14779_/D _14779_/RESET_B VDD VSS sg13g2_dfrbpq_1
XFILLER_17_1005 VDD VSS sg13g2_fill_2
XFILLER_177_735 VDD VSS sg13g2_fill_2
XFILLER_31_240 VDD VSS sg13g2_decap_8
XFILLER_143_1035 VDD VSS sg13g2_decap_8
XFILLER_32_774 VDD VSS sg13g2_decap_8
XFILLER_108_1166 VDD VSS sg13g2_decap_8
XFILLER_176_245 VDD VSS sg13g2_decap_8
XFILLER_76_0 VDD VSS sg13g2_decap_8
XFILLER_30_1205 VDD VSS sg13g2_decap_8
XFILLER_117_312 VDD VSS sg13g2_decap_8
XFILLER_173_930 VDD VSS sg13g2_decap_8
XFILLER_129_183 VDD VSS sg13g2_fill_2
XFILLER_157_492 VDD VSS sg13g2_decap_8
XFILLER_121_1377 VDD VSS sg13g2_decap_8
XFILLER_144_131 VDD VSS sg13g2_decap_4
XFILLER_172_451 VDD VSS sg13g2_decap_8
XFILLER_69_1448 VDD VSS sg13g2_fill_2
XFILLER_156_1407 VDD VSS sg13g2_decap_8
XFILLER_69_1459 VDD VSS sg13g2_decap_8
XFILLER_133_849 VDD VSS sg13g2_decap_8
XFILLER_144_197 VDD VSS sg13g2_decap_8
Xpicorv32_macro_1509 mem_axi_arprot[0] VDD VSS sg13g2_tielo
XFILLER_67_1161 VDD VSS sg13g2_decap_8
XFILLER_67_1172 VDD VSS sg13g2_fill_1
XFILLER_28_1123 VDD VSS sg13g2_decap_8
XFILLER_63_1014 VDD VSS sg13g2_decap_8
Xfanout426 _10078_/A0 _09946_/A1 VDD VSS sg13g2_buf_1
XFILLER_113_573 VDD VSS sg13g2_fill_1
XFILLER_115_1115 VDD VSS sg13g2_fill_2
XFILLER_119_1284 VDD VSS sg13g2_decap_8
Xfanout437 _10140_/A1 fanout438/X VDD VSS sg13g2_buf_1
X_09823_ _14411_/D _09922_/A1 _14411_/Q _09830_/S VDD VSS sg13g2_mux2_1
XFILLER_8_1239 VDD VSS sg13g2_decap_8
XFILLER_59_627 VDD VSS sg13g2_decap_8
Xfanout448 _12707_/B2 _12791_/B2 VDD VSS sg13g2_buf_1
Xfanout459 _10134_/S _10120_/S VDD VSS sg13g2_buf_1
X_14426__1846 _14426_/RESET_B VDD VSS sg13g2_tiehi
XFILLER_58_148 VDD VSS sg13g2_decap_8
XFILLER_101_768 VDD VSS sg13g2_decap_8
X_09754_ _14344_/D _14344_/Q _09919_/A1 _09770_/S VDD VSS sg13g2_mux2_1
XFILLER_80_1394 VDD VSS sg13g2_fill_2
XFILLER_104_35 VDD VSS sg13g2_decap_8
X_08705_ _15185_/D hold3177/X _15185_/Q _08719_/S VDD VSS sg13g2_mux2_1
X_09685_ _14277_/D _09916_/A1 _14277_/Q _09698_/S VDD VSS sg13g2_mux2_1
XFILLER_41_1389 VDD VSS sg13g2_decap_8
XFILLER_64_28 VDD VSS sg13g2_decap_4
XFILLER_54_332 VDD VSS sg13g2_decap_8
X_08636_ _08637_/A _08406_/A _08488_/B _08560_/C _08635_/X _08511_/S _08329_/B VDD
+ VSS sg13g2_mux4_1
XFILLER_55_877 VDD VSS sg13g2_decap_8
XFILLER_42_516 VDD VSS sg13g2_decap_8
X_14641__1631 _14641_/RESET_B VDD VSS sg13g2_tiehi
XFILLER_70_836 VDD VSS sg13g2_decap_8
X_08567_ _08567_/X _08567_/A _08567_/B _08567_/C VDD VSS sg13g2_or3_1
XFILLER_54_398 VDD VSS sg13g2_decap_8
XFILLER_126_1200 VDD VSS sg13g2_decap_8
XFILLER_154_7 VDD VSS sg13g2_decap_8
XFILLER_11_903 VDD VSS sg13g2_decap_8
XFILLER_126_1244 VDD VSS sg13g2_fill_2
X_08498_ _08498_/Y _08497_/A _08495_/Y _08497_/Y VDD VSS sg13g2_o21ai_1
XFILLER_70_1029 VDD VSS sg13g2_decap_4
XFILLER_10_413 VDD VSS sg13g2_decap_8
XFILLER_161_1157 VDD VSS sg13g2_decap_4
XFILLER_13_21 VDD VSS sg13g2_decap_8
XFILLER_13_1414 VDD VSS sg13g2_decap_8
XFILLER_155_418 VDD VSS sg13g2_decap_8
XFILLER_52_1463 VDD VSS sg13g2_decap_8
XFILLER_155_429 VDD VSS sg13g2_fill_1
X_10460_ _14842_/D _10471_/D _10633_/A _10460_/C VDD VSS sg13g2_nor3_1
XFILLER_6_406 VDD VSS sg13g2_decap_8
X_13914__2358 _13914_/RESET_B VDD VSS sg13g2_tiehi
X_14674__1598 _14674_/RESET_B VDD VSS sg13g2_tiehi
XFILLER_109_857 VDD VSS sg13g2_fill_1
XFILLER_13_98 VDD VSS sg13g2_decap_8
XFILLER_89_14 VDD VSS sg13g2_decap_8
XFILLER_136_643 VDD VSS sg13g2_decap_8
X_09119_ _13779_/D _13779_/Q _09831_/A0 _09153_/S VDD VSS sg13g2_mux2_1
XFILLER_164_963 VDD VSS sg13g2_decap_8
XFILLER_182_259 VDD VSS sg13g2_decap_8
X_10391_ _10392_/A _14820_/Q _14821_/Q _10391_/C _10398_/D VDD VSS sg13g2_nand4_1
XFILLER_159_1031 VDD VSS sg13g2_fill_2
XFILLER_151_602 VDD VSS sg13g2_decap_8
XFILLER_136_687 VDD VSS sg13g2_decap_8
XFILLER_159_1064 VDD VSS sg13g2_fill_1
X_12130_ _12132_/B _12065_/B _12198_/C _12198_/A VDD VSS sg13g2_a21oi_1
XFILLER_124_838 VDD VSS sg13g2_decap_8
XFILLER_150_101 VDD VSS sg13g2_decap_4
XFILLER_123_337 VDD VSS sg13g2_decap_4
XFILLER_2_623 VDD VSS sg13g2_decap_8
XFILLER_145_42 VDD VSS sg13g2_decap_8
X_12061_ _12197_/A _12061_/A _13190_/B VDD VSS sg13g2_xnor2_1
XFILLER_85_1272 VDD VSS sg13g2_decap_8
XFILLER_1_133 VDD VSS sg13g2_decap_8
XFILLER_46_1245 VDD VSS sg13g2_fill_2
XFILLER_104_562 VDD VSS sg13g2_fill_1
XFILLER_137_1362 VDD VSS sg13g2_fill_2
XFILLER_145_75 VDD VSS sg13g2_decap_8
XFILLER_150_167 VDD VSS sg13g2_fill_1
XFILLER_104_573 VDD VSS sg13g2_fill_1
XFILLER_133_1204 VDD VSS sg13g2_decap_8
X_11012_ _11014_/B _11064_/A _11012_/B _11012_/C VDD VSS sg13g2_nor3_1
XFILLER_137_1384 VDD VSS sg13g2_decap_8
XFILLER_150_189 VDD VSS sg13g2_decap_8
XFILLER_172_1264 VDD VSS sg13g2_decap_4
XFILLER_89_273 VDD VSS sg13g2_fill_2
XFILLER_46_1267 VDD VSS sg13g2_decap_8
XFILLER_49_115 VDD VSS sg13g2_fill_1
XFILLER_46_1278 VDD VSS sg13g2_fill_2
XFILLER_104_595 VDD VSS sg13g2_fill_2
XFILLER_78_958 VDD VSS sg13g2_decap_8
Xfanout960 _12771_/S0 _12773_/S0 VDD VSS sg13g2_buf_1
XFILLER_77_457 VDD VSS sg13g2_decap_8
Xfanout971 _13048_/B _12983_/A1 VDD VSS sg13g2_buf_1
Xfanout982 _13308_/A _13271_/C VDD VSS sg13g2_buf_1
XFILLER_49_159 VDD VSS sg13g2_decap_8
Xfanout993 _13558_/B _13601_/B VDD VSS sg13g2_buf_1
XFILLER_180_0 VDD VSS sg13g2_decap_8
XFILLER_86_980 VDD VSS sg13g2_decap_8
X_12963_ _12963_/Y _14873_/Q _13249_/B VDD VSS sg13g2_nand2_1
XFILLER_58_693 VDD VSS sg13g2_decap_8
XFILLER_79_1032 VDD VSS sg13g2_decap_4
XFILLER_18_546 VDD VSS sg13g2_decap_8
XFILLER_85_490 VDD VSS sg13g2_fill_1
X_14280__1992 _14280_/RESET_B VDD VSS sg13g2_tiehi
X_14702_ _14702_/Q clkload51/A _14702_/D _14702_/RESET_B VDD VSS sg13g2_dfrbpq_1
X_11914_ _11915_/A _11914_/A _13673_/Q VDD VSS sg13g2_xor2_1
XFILLER_79_1054 VDD VSS sg13g2_fill_2
XFILLER_45_343 VDD VSS sg13g2_fill_2
X_12894_ _12894_/X _12894_/A _12894_/B VDD VSS sg13g2_xor2_1
XFILLER_2_1372 VDD VSS sg13g2_decap_8
X_14633_ _14633_/Q clkload35/A _14633_/D _14633_/RESET_B VDD VSS sg13g2_dfrbpq_1
X_11845_ _11867_/B _11907_/A _11910_/B _11845_/C VDD VSS sg13g2_or3_1
XFILLER_60_324 VDD VSS sg13g2_decap_8
XFILLER_92_1232 VDD VSS sg13g2_decap_8
XFILLER_159_713 VDD VSS sg13g2_decap_8
XFILLER_18_1325 VDD VSS sg13g2_decap_8
XFILLER_14_763 VDD VSS sg13g2_decap_8
X_14564_ _14564_/Q clkload33/A _14564_/D _14564_/RESET_B VDD VSS sg13g2_dfrbpq_1
XFILLER_144_1333 VDD VSS sg13g2_fill_1
X_11776_ _11777_/B _11776_/A _11776_/B VDD VSS sg13g2_nand2_1
XFILLER_109_1464 VDD VSS sg13g2_fill_2
XFILLER_53_1238 VDD VSS sg13g2_decap_8
XFILLER_13_273 VDD VSS sg13g2_decap_8
X_13515_ _15138_/D _15138_/Q _14995_/Q _13562_/S VDD VSS sg13g2_mux2_1
XFILLER_41_582 VDD VSS sg13g2_decap_8
XFILLER_105_1328 VDD VSS sg13g2_decap_8
XFILLER_147_908 VDD VSS sg13g2_decap_8
X_10727_ _10727_/Y _14909_/Q _11196_/B VDD VSS sg13g2_nand2_1
X_14495_ _14495_/Q clkload49/A _14495_/D _14495_/RESET_B VDD VSS sg13g2_dfrbpq_1
XFILLER_144_1399 VDD VSS sg13g2_decap_4
XFILLER_179_1407 VDD VSS sg13g2_decap_4
XFILLER_9_266 VDD VSS sg13g2_decap_8
X_13446_ _13446_/Y _13412_/B _08723_/B hold3228/X VDD VSS sg13g2_o21ai_1
XFILLER_139_470 VDD VSS sg13g2_decap_8
XFILLER_174_749 VDD VSS sg13g2_decap_8
X_10658_ _14891_/D _10667_/A _10658_/B _10666_/D VDD VSS sg13g2_nor3_1
XFILLER_127_621 VDD VSS sg13g2_fill_2
XFILLER_155_930 VDD VSS sg13g2_decap_8
X_14504__1768 _14504_/RESET_B VDD VSS sg13g2_tiehi
Xclkload14 clkload14/Y clkload14/A VDD VSS sg13g2_inv_2
XFILLER_10_980 VDD VSS sg13g2_decap_8
XFILLER_103_1052 VDD VSS sg13g2_decap_8
XFILLER_126_120 VDD VSS sg13g2_decap_8
Xclkload25 clkload25/Y clkload25/A VDD VSS sg13g2_inv_1
XFILLER_173_259 VDD VSS sg13g2_decap_8
Xclkload36 clkload36/Y clkload36/A VDD VSS sg13g2_inv_2
X_13377_ _15078_/D _15078_/Q _13407_/A _13376_/Y VDD VSS sg13g2_a21o_1
Xclkload47 clkload47/X clkload47/A VDD VSS sg13g2_buf_8
XFILLER_103_1085 VDD VSS sg13g2_decap_8
Xclkload58 clkload58/Y clkload58/A VDD VSS sg13g2_inv_1
X_10589_ _10592_/B _10649_/B _10594_/D _14874_/Q VDD VSS sg13g2_a21oi_1
Xclkload69 clkload69/Y clkload69/A VDD VSS sg13g2_inv_4
Xmax_cap1288 _16870_/A _13708_/Q VDD VSS sg13g2_buf_4
XFILLER_6_973 VDD VSS sg13g2_decap_8
XFILLER_155_996 VDD VSS sg13g2_decap_8
XFILLER_182_782 VDD VSS sg13g2_decap_8
X_15116_ _15116_/Q _15212_/CLK _15116_/D _15116_/RESET_B VDD VSS sg13g2_dfrbpq_1
Xmax_cap1299 output65/A _16859_/A VDD VSS sg13g2_buf_4
XFILLER_127_698 VDD VSS sg13g2_decap_8
X_12328_ _12328_/Y _12328_/A1 _13946_/Q _12328_/B1 VDD VSS sg13g2_a21oi_1
XFILLER_86_1058 VDD VSS sg13g2_fill_1
XFILLER_5_483 VDD VSS sg13g2_decap_8
XFILLER_138_1159 VDD VSS sg13g2_decap_8
XFILLER_173_1039 VDD VSS sg13g2_decap_8
X_15047_ _15047_/Q _15200_/CLK _15047_/D _15047_/RESET_B VDD VSS sg13g2_dfrbpq_1
X_12259_ _12259_/X _14712_/Q _14744_/Q _13784_/Q _13816_/Q _12259_/S0 _12259_/S1 VDD
+ VSS sg13g2_mux4_1
XFILLER_64_1323 VDD VSS sg13g2_decap_8
XFILLER_69_925 VDD VSS sg13g2_decap_4
XFILLER_29_1465 VDD VSS sg13g2_decap_8
XFILLER_64_1356 VDD VSS sg13g2_decap_8
XFILLER_116_1424 VDD VSS sg13g2_decap_8
XFILLER_122_370 VDD VSS sg13g2_decap_8
XFILLER_110_521 VDD VSS sg13g2_fill_2
XFILLER_69_958 VDD VSS sg13g2_decap_8
XFILLER_68_435 VDD VSS sg13g2_decap_8
XFILLER_25_1329 VDD VSS sg13g2_decap_8
Xclkbuf_0_clk_i clkbuf_0_clk_i/X clk_i VDD VSS sg13g2_buf_16
XFILLER_99_1408 VDD VSS sg13g2_fill_2
XFILLER_96_766 VDD VSS sg13g2_fill_2
X_15217__3078 _15217_/RESET_B VDD VSS sg13g2_tiehi
XFILLER_96_788 VDD VSS sg13g2_decap_4
XFILLER_68_479 VDD VSS sg13g2_fill_1
XFILLER_95_276 VDD VSS sg13g2_decap_8
XFILLER_62_1091 VDD VSS sg13g2_decap_8
XFILLER_37_811 VDD VSS sg13g2_decap_8
XFILLER_110_1012 VDD VSS sg13g2_fill_2
XFILLER_114_1181 VDD VSS sg13g2_decap_8
XFILLER_92_950 VDD VSS sg13g2_decap_8
XFILLER_110_1045 VDD VSS sg13g2_decap_8
XFILLER_3_1169 VDD VSS sg13g2_decap_8
XFILLER_149_1222 VDD VSS sg13g2_decap_8
X_09470_ _14071_/D _10066_/A0 _14071_/Q _09472_/S VDD VSS sg13g2_mux2_1
XFILLER_92_972 VDD VSS sg13g2_decap_8
XFILLER_36_354 VDD VSS sg13g2_decap_8
XFILLER_97_1187 VDD VSS sg13g2_decap_8
X_08421_ _08421_/Y _08419_/Y _08420_/A _08417_/Y VDD VSS sg13g2_o21ai_1
XFILLER_24_527 VDD VSS sg13g2_fill_1
XFILLER_149_1277 VDD VSS sg13g2_fill_2
XFILLER_52_858 VDD VSS sg13g2_decap_8
XFILLER_149_1288 VDD VSS sg13g2_decap_8
XFILLER_51_335 VDD VSS sg13g2_decap_8
XFILLER_162_1400 VDD VSS sg13g2_decap_8
X_08352_ _08353_/B _08352_/A _08352_/B _08369_/B VDD VSS sg13g2_nand3_1
XFILLER_36_1425 VDD VSS sg13g2_decap_8
XFILLER_177_532 VDD VSS sg13g2_decap_8
XFILLER_60_880 VDD VSS sg13g2_decap_8
XFILLER_36_1447 VDD VSS sg13g2_fill_2
XFILLER_71_1338 VDD VSS sg13g2_fill_2
X_08283_ _08283_/Y _08675_/A1 _08282_/Y _08277_/Y VDD VSS sg13g2_o21ai_1
Xclkload8 clkload8/Y clkload8/A VDD VSS sg13g2_inv_1
XFILLER_109_109 VDD VSS sg13g2_fill_2
XFILLER_149_278 VDD VSS sg13g2_decap_4
XFILLER_165_727 VDD VSS sg13g2_decap_8
XFILLER_20_777 VDD VSS sg13g2_decap_8
XFILLER_34_1171 VDD VSS sg13g2_decap_4
XFILLER_30_1002 VDD VSS sg13g2_decap_8
XFILLER_30_1013 VDD VSS sg13g2_decap_8
XFILLER_164_248 VDD VSS sg13g2_decap_8
XFILLER_173_760 VDD VSS sg13g2_fill_2
XFILLER_161_911 VDD VSS sg13g2_decap_8
XFILLER_69_1245 VDD VSS sg13g2_decap_8
XFILLER_117_164 VDD VSS sg13g2_decap_8
XFILLER_118_698 VDD VSS sg13g2_decap_4
XFILLER_117_175 VDD VSS sg13g2_fill_2
XFILLER_145_495 VDD VSS sg13g2_decap_8
XFILLER_105_337 VDD VSS sg13g2_decap_8
XFILLER_105_348 VDD VSS sg13g2_fill_1
XFILLER_105_359 VDD VSS sg13g2_decap_8
XFILLER_160_465 VDD VSS sg13g2_decap_8
XFILLER_161_988 VDD VSS sg13g2_decap_8
XFILLER_132_167 VDD VSS sg13g2_decap_8
X_14659__1613 _14659_/RESET_B VDD VSS sg13g2_tiehi
Xfanout201 _10092_/A0 _09828_/A0 VDD VSS sg13g2_buf_1
XFILLER_160_487 VDD VSS sg13g2_decap_8
Xfanout212 _10089_/A0 _09759_/A1 VDD VSS sg13g2_buf_1
Xfanout223 _09956_/A1 _10155_/A1 VDD VSS sg13g2_buf_1
Xfanout234 _10153_/A1 fanout237/X VDD VSS sg13g2_buf_1
XFILLER_8_1036 VDD VSS sg13g2_decap_8
XFILLER_113_381 VDD VSS sg13g2_decap_4
XFILLER_115_34 VDD VSS sg13g2_decap_8
XFILLER_141_690 VDD VSS sg13g2_fill_2
XFILLER_43_1429 VDD VSS sg13g2_decap_4
Xfanout256 _12227_/B _12298_/B VDD VSS sg13g2_buf_1
Xfanout267 _09918_/A1 _10150_/A1 VDD VSS sg13g2_buf_1
X_09806_ _09806_/Y _10137_/A _10004_/B _10004_/C _09806_/D VDD VSS sg13g2_nand4_1
XFILLER_101_554 VDD VSS sg13g2_fill_1
Xfanout278 _10063_/S _10069_/S VDD VSS sg13g2_buf_1
X_14088__2184 _14088_/RESET_B VDD VSS sg13g2_tiehi
XFILLER_101_576 VDD VSS sg13g2_decap_8
Xfanout289 _09596_/S _09603_/S VDD VSS sg13g2_buf_1
X_07998_ _07998_/X _15103_/Q _15090_/Q VDD VSS sg13g2_or2_1
XFILLER_87_799 VDD VSS sg13g2_decap_8
XFILLER_86_276 VDD VSS sg13g2_decap_8
XFILLER_41_1131 VDD VSS sg13g2_fill_2
XFILLER_75_49 VDD VSS sg13g2_decap_8
XFILLER_74_427 VDD VSS sg13g2_fill_2
XFILLER_132_1270 VDD VSS sg13g2_fill_1
X_09737_ _14328_/D _09770_/A1 _14328_/Q _09737_/S VDD VSS sg13g2_mux2_1
XFILLER_131_11 VDD VSS sg13g2_fill_2
X_09668_ _14261_/D _10164_/A1 _14261_/Q _09672_/S VDD VSS sg13g2_mux2_1
XFILLER_83_983 VDD VSS sg13g2_fill_2
XFILLER_54_151 VDD VSS sg13g2_fill_1
XFILLER_167_1344 VDD VSS sg13g2_decap_4
X_15027__2653 _15027_/RESET_B VDD VSS sg13g2_tiehi
XFILLER_42_302 VDD VSS sg13g2_decap_8
XFILLER_167_1355 VDD VSS sg13g2_decap_8
XFILLER_76_1238 VDD VSS sg13g2_decap_8
X_08619_ _08619_/Y _08054_/B _12152_/A _08053_/Y VDD VSS sg13g2_o21ai_1
X_09599_ _14196_/D _14196_/Q _09799_/A0 _09603_/S VDD VSS sg13g2_mux2_1
XFILLER_70_655 VDD VSS sg13g2_decap_8
XFILLER_42_346 VDD VSS sg13g2_decap_8
X_11630_ _11630_/Y _12225_/B2 _11629_/Y _12227_/B VDD VSS sg13g2_o21ai_1
XFILLER_11_700 VDD VSS sg13g2_decap_8
XFILLER_42_379 VDD VSS sg13g2_decap_8
XFILLER_24_42 VDD VSS sg13g2_decap_8
XFILLER_10_210 VDD VSS sg13g2_decap_8
X_14751__3058 _14751_/RESET_B VDD VSS sg13g2_tiehi
X_11561_ _11561_/Y _11556_/X _12046_/C _11559_/C VDD VSS sg13g2_a21oi_1
XFILLER_168_587 VDD VSS sg13g2_decap_8
X_13300_ _13300_/Y _13308_/A _15205_/Q _13300_/C _13312_/A VDD VSS sg13g2_nor4_1
XFILLER_126_1096 VDD VSS sg13g2_decap_8
XFILLER_13_1211 VDD VSS sg13g2_decap_8
X_10512_ _10514_/B _10512_/A _10512_/B _10512_/C VDD VSS sg13g2_nor3_1
XFILLER_11_777 VDD VSS sg13g2_decap_8
X_14280_ _14280_/Q clkload27/A _14280_/D _14280_/RESET_B VDD VSS sg13g2_dfrbpq_1
XFILLER_6_203 VDD VSS sg13g2_decap_8
X_11492_ _11492_/X _14114_/Q _14146_/Q _14178_/Q _14210_/Q _11493_/S0 _11493_/S1 VDD
+ VSS sg13g2_mux4_1
XFILLER_183_546 VDD VSS sg13g2_decap_8
XFILLER_155_248 VDD VSS sg13g2_decap_8
XFILLER_109_643 VDD VSS sg13g2_decap_8
XFILLER_10_287 VDD VSS sg13g2_decap_8
X_13231_ _13242_/A _13232_/A _13244_/B VDD VSS sg13g2_nand2b_1
X_10443_ _10444_/B _14837_/Q _14836_/Q _14835_/Q _10443_/D VDD VSS sg13g2_nand4_1
XFILLER_152_900 VDD VSS sg13g2_decap_8
XFILLER_104_1394 VDD VSS sg13g2_decap_8
XFILLER_109_676 VDD VSS sg13g2_decap_8
XFILLER_139_1402 VDD VSS sg13g2_decap_8
XFILLER_40_63 VDD VSS sg13g2_decap_8
XFILLER_13_1288 VDD VSS sg13g2_decap_8
XFILLER_178_1462 VDD VSS sg13g2_fill_2
XFILLER_3_910 VDD VSS sg13g2_decap_8
X_13162_ _13162_/Y _14854_/Q _13150_/B _07727_/C _14886_/Q VDD VSS sg13g2_a22oi_1
XFILLER_108_186 VDD VSS sg13g2_decap_8
XFILLER_174_1315 VDD VSS sg13g2_decap_4
X_10374_ _10375_/B _14815_/Q _14816_/Q _10391_/C VDD VSS sg13g2_nand3_1
XFILLER_151_421 VDD VSS sg13g2_fill_2
XFILLER_174_1326 VDD VSS sg13g2_decap_8
XFILLER_87_1378 VDD VSS sg13g2_decap_8
XFILLER_139_1457 VDD VSS sg13g2_decap_8
X_14298__1974 _14298_/RESET_B VDD VSS sg13g2_tiehi
XFILLER_2_420 VDD VSS sg13g2_decap_8
X_12113_ _12113_/Y _12109_/Y _12110_/Y _12112_/Y _12111_/Y _12101_/B VDD VSS sg13g2_a221oi_1
XFILLER_139_1468 VDD VSS sg13g2_fill_2
XFILLER_151_454 VDD VSS sg13g2_decap_8
XFILLER_6_0 VDD VSS sg13g2_decap_8
XFILLER_112_819 VDD VSS sg13g2_decap_8
X_13093_ _13093_/Y _13091_/Y _13093_/B _13160_/B VDD VSS sg13g2_nand3b_1
XFILLER_105_871 VDD VSS sg13g2_decap_8
XFILLER_78_711 VDD VSS sg13g2_decap_8
XFILLER_3_987 VDD VSS sg13g2_decap_8
XFILLER_123_178 VDD VSS sg13g2_decap_8
XFILLER_151_498 VDD VSS sg13g2_decap_8
XFILLER_172_1050 VDD VSS sg13g2_fill_2
X_12044_ _12044_/Y _12019_/Y _12021_/Y _12263_/C VDD VSS sg13g2_a21oi_1
XFILLER_46_1064 VDD VSS sg13g2_decap_4
XFILLER_137_1181 VDD VSS sg13g2_decap_8
XFILLER_2_497 VDD VSS sg13g2_decap_8
XFILLER_120_841 VDD VSS sg13g2_decap_8
XFILLER_172_1072 VDD VSS sg13g2_decap_8
XFILLER_78_777 VDD VSS sg13g2_fill_2
XFILLER_172_84 VDD VSS sg13g2_decap_8
XFILLER_1_35 VDD VSS sg13g2_decap_8
Xfanout790 _08723_/B _13412_/C VDD VSS sg13g2_buf_1
XFILLER_24_1351 VDD VSS sg13g2_decap_8
X_13995_ _13995_/Q clkload11/A _13995_/D _13995_/RESET_B VDD VSS sg13g2_dfrbpq_1
XFILLER_150_1392 VDD VSS sg13g2_decap_8
XFILLER_4_1456 VDD VSS sg13g2_decap_8
XFILLER_59_1403 VDD VSS sg13g2_decap_8
XFILLER_185_1411 VDD VSS sg13g2_decap_8
XFILLER_18_343 VDD VSS sg13g2_decap_8
X_12946_ _12946_/Y _12946_/A _13308_/A _12961_/A VDD VSS sg13g2_nand3_1
XFILLER_74_972 VDD VSS sg13g2_decap_8
XFILLER_59_1425 VDD VSS sg13g2_decap_4
XFILLER_20_1259 VDD VSS sg13g2_decap_8
XFILLER_46_674 VDD VSS sg13g2_decap_8
Xclkbuf_leaf_131_clk_i _14669_/CLK clkload0/A VDD VSS sg13g2_buf_8
XFILLER_146_1417 VDD VSS sg13g2_decap_8
XFILLER_59_1469 VDD VSS sg13g2_fill_2
X_12877_ _12878_/C _14898_/Q _13689_/Q _12877_/C VDD VSS sg13g2_nand3_1
XFILLER_181_1319 VDD VSS sg13g2_fill_2
X_14616_ _14616_/Q _14982_/CLK _14616_/D _14616_/RESET_B VDD VSS sg13g2_dfrbpq_1
XFILLER_178_329 VDD VSS sg13g2_decap_8
X_11828_ _11828_/X _14700_/Q _14732_/Q _13772_/Q _13804_/Q _12103_/A1 _12307_/C VDD
+ VSS sg13g2_mux4_1
XFILLER_92_1040 VDD VSS sg13g2_decap_4
XFILLER_18_1122 VDD VSS sg13g2_decap_8
X_13786__2486 _13786_/RESET_B VDD VSS sg13g2_tiehi
XFILLER_14_560 VDD VSS sg13g2_decap_8
XFILLER_144_1141 VDD VSS sg13g2_decap_8
XFILLER_42_891 VDD VSS sg13g2_decap_8
XFILLER_105_1103 VDD VSS sg13g2_fill_2
X_14547_ _14547_/Q clkload31/A _14547_/D _14547_/RESET_B VDD VSS sg13g2_dfrbpq_1
X_11759_ _11760_/B _11759_/A _13930_/Q VDD VSS sg13g2_nand2_1
XFILLER_14_1008 VDD VSS sg13g2_decap_8
XFILLER_159_576 VDD VSS sg13g2_decap_8
X_14737__1535 _14737_/RESET_B VDD VSS sg13g2_tiehi
XFILLER_144_1185 VDD VSS sg13g2_decap_8
XFILLER_174_502 VDD VSS sg13g2_fill_1
XFILLER_18_1199 VDD VSS sg13g2_decap_8
XFILLER_105_1158 VDD VSS sg13g2_decap_8
X_14478_ _14478_/Q _14734_/CLK _14478_/D _14478_/RESET_B VDD VSS sg13g2_dfrbpq_1
XFILLER_122_1472 VDD VSS sg13g2_fill_2
XFILLER_174_568 VDD VSS sg13g2_decap_8
X_13429_ _13429_/Y _13438_/B _13494_/B _13435_/B _13444_/C VDD VSS sg13g2_nor4_1
XFILLER_143_911 VDD VSS sg13g2_decap_8
XFILLER_161_218 VDD VSS sg13g2_fill_1
XFILLER_161_229 VDD VSS sg13g2_decap_8
XFILLER_6_770 VDD VSS sg13g2_decap_8
XFILLER_66_1407 VDD VSS sg13g2_decap_8
XFILLER_142_410 VDD VSS sg13g2_fill_2
XFILLER_127_495 VDD VSS sg13g2_decap_8
XFILLER_114_123 VDD VSS sg13g2_decap_8
Xmax_cap968 _12742_/S0 _12756_/S0 VDD VSS sg13g2_buf_8
XFILLER_115_657 VDD VSS sg13g2_fill_2
XFILLER_5_280 VDD VSS sg13g2_decap_8
XFILLER_114_145 VDD VSS sg13g2_decap_8
X_08970_ _13755_/D _13755_/Q _09939_/A1 _09127_/S VDD VSS sg13g2_mux2_1
XFILLER_170_785 VDD VSS sg13g2_decap_8
XFILLER_130_627 VDD VSS sg13g2_decap_8
XFILLER_9_1323 VDD VSS sg13g2_decap_8
XFILLER_114_189 VDD VSS sg13g2_decap_8
X_07921_ _07921_/Y _07876_/A _07876_/B _07912_/Y _07919_/Y VDD VSS sg13g2_a22oi_1
XFILLER_39_0 VDD VSS sg13g2_decap_8
XFILLER_151_1101 VDD VSS sg13g2_decap_8
XFILLER_116_1243 VDD VSS sg13g2_decap_8
XFILLER_155_1292 VDD VSS sg13g2_fill_2
X_07852_ _07855_/A _15015_/Q _07853_/B VDD VSS sg13g2_nor2_1
XFILLER_68_254 VDD VSS sg13g2_decap_8
XFILLER_56_405 VDD VSS sg13g2_decap_8
XFILLER_84_725 VDD VSS sg13g2_fill_1
XFILLER_112_1129 VDD VSS sg13g2_decap_8
XFILLER_68_276 VDD VSS sg13g2_decap_8
XFILLER_151_1189 VDD VSS sg13g2_decap_8
Xinput1 input1/X input1/A VDD VSS sg13g2_buf_1
X_07783_ _07796_/A _08411_/A _07784_/B VDD VSS sg13g2_nor2_1
XFILLER_49_490 VDD VSS sg13g2_decap_8
X_09522_ _14121_/D _10085_/A0 _14121_/Q _09538_/S VDD VSS sg13g2_mux2_1
XFILLER_25_814 VDD VSS sg13g2_fill_2
XFILLER_65_983 VDD VSS sg13g2_fill_1
XFILLER_37_685 VDD VSS sg13g2_decap_8
XFILLER_149_1041 VDD VSS sg13g2_decap_8
XFILLER_52_622 VDD VSS sg13g2_fill_2
X_09453_ _14054_/D _09618_/A0 _14054_/Q _09461_/S VDD VSS sg13g2_mux2_1
XFILLER_80_953 VDD VSS sg13g2_decap_8
XFILLER_25_869 VDD VSS sg13g2_fill_2
X_08404_ _08410_/A _07826_/X _08470_/A _08404_/B1 _08436_/B _08402_/Y VDD VSS sg13g2_a221oi_1
XFILLER_101_47 VDD VSS sg13g2_fill_2
X_09384_ _13987_/D _09582_/A1 _13987_/Q _09396_/S VDD VSS sg13g2_mux2_1
XFILLER_75_1260 VDD VSS sg13g2_fill_2
XFILLER_52_688 VDD VSS sg13g2_decap_8
XFILLER_51_165 VDD VSS sg13g2_decap_8
X_14376__1896 _14376_/RESET_B VDD VSS sg13g2_tiehi
XFILLER_127_1361 VDD VSS sg13g2_decap_8
XFILLER_123_1203 VDD VSS sg13g2_decap_8
X_08335_ _15230_/D _08335_/A _08335_/B _08335_/C _08335_/D VDD VSS sg13g2_nand4_1
XFILLER_71_1135 VDD VSS sg13g2_decap_4
XFILLER_162_1263 VDD VSS sg13g2_decap_8
XFILLER_36_1266 VDD VSS sg13g2_decap_8
XFILLER_162_1296 VDD VSS sg13g2_decap_8
XFILLER_138_749 VDD VSS sg13g2_decap_8
X_08266_ _08266_/Y _07929_/B _08263_/B _08248_/A VDD VSS sg13g2_a21oi_1
XFILLER_137_226 VDD VSS sg13g2_decap_8
XFILLER_119_941 VDD VSS sg13g2_decap_4
XFILLER_119_952 VDD VSS sg13g2_decap_4
XFILLER_119_963 VDD VSS sg13g2_decap_8
XFILLER_165_568 VDD VSS sg13g2_decap_4
XFILLER_153_719 VDD VSS sg13g2_decap_8
XFILLER_117_7 VDD VSS sg13g2_decap_4
X_08197_ _08197_/X _08397_/B _08079_/X _08081_/X _08085_/A _08452_/D _08452_/C VDD
+ VSS sg13g2_mux4_1
XFILLER_4_707 VDD VSS sg13g2_decap_8
XFILLER_10_1428 VDD VSS sg13g2_decap_8
XFILLER_134_911 VDD VSS sg13g2_decap_8
X_13831__2441 _13831_/RESET_B VDD VSS sg13g2_tiehi
X_14591__1681 _14591_/RESET_B VDD VSS sg13g2_tiehi
XFILLER_3_217 VDD VSS sg13g2_decap_8
X_14847__2943 _14847_/RESET_B VDD VSS sg13g2_tiehi
XFILLER_134_966 VDD VSS sg13g2_decap_8
XFILLER_145_292 VDD VSS sg13g2_decap_8
XFILLER_69_1086 VDD VSS sg13g2_decap_8
XFILLER_161_763 VDD VSS sg13g2_decap_8
XFILLER_10_77 VDD VSS sg13g2_decap_8
XFILLER_105_178 VDD VSS sg13g2_decap_4
XFILLER_156_1078 VDD VSS sg13g2_decap_8
XFILLER_160_273 VDD VSS sg13g2_decap_8
XFILLER_126_77 VDD VSS sg13g2_decap_8
Xfanout1007 _10201_/A1 _15182_/Q VDD VSS sg13g2_buf_1
X_10090_ _14670_/D _10090_/A0 _14670_/Q _10096_/S VDD VSS sg13g2_mux2_1
XFILLER_0_946 VDD VSS sg13g2_decap_8
XFILLER_134_1321 VDD VSS sg13g2_decap_8
Xfanout1018 _13249_/B _13028_/B VDD VSS sg13g2_buf_1
Xfanout1029 _13206_/B _13274_/A2 VDD VSS sg13g2_buf_1
X_14211__2061 _14211_/RESET_B VDD VSS sg13g2_tiehi
XFILLER_87_541 VDD VSS sg13g2_decap_8
XFILLER_82_1297 VDD VSS sg13g2_decap_8
XFILLER_130_1207 VDD VSS sg13g2_decap_8
XFILLER_19_42 VDD VSS sg13g2_decap_8
XFILLER_75_736 VDD VSS sg13g2_fill_2
XFILLER_47_438 VDD VSS sg13g2_decap_8
XFILLER_169_1428 VDD VSS sg13g2_fill_2
X_12800_ _12800_/X _12899_/A _12900_/C _12899_/C input20/X VDD VSS sg13g2_and4_1
XFILLER_74_257 VDD VSS sg13g2_decap_8
XFILLER_90_717 VDD VSS sg13g2_decap_8
X_13780_ _13780_/Q _14740_/CLK _13780_/D _13780_/RESET_B VDD VSS sg13g2_dfrbpq_1
XFILLER_56_972 VDD VSS sg13g2_fill_2
X_10992_ _10992_/X _11009_/C _10992_/B VDD VSS sg13g2_xor2_1
XFILLER_167_1130 VDD VSS sg13g2_decap_4
XFILLER_76_1013 VDD VSS sg13g2_decap_8
XFILLER_43_622 VDD VSS sg13g2_decap_8
X_12731_ _12731_/X _14710_/Q _14742_/Q _13782_/Q _13814_/Q _12759_/S0 _12759_/S1 VDD
+ VSS sg13g2_mux4_1
XFILLER_55_482 VDD VSS sg13g2_decap_8
XFILLER_76_1046 VDD VSS sg13g2_fill_2
XFILLER_163_1005 VDD VSS sg13g2_decap_8
XFILLER_167_1174 VDD VSS sg13g2_decap_8
XFILLER_43_655 VDD VSS sg13g2_fill_2
XFILLER_35_63 VDD VSS sg13g2_decap_8
XFILLER_15_357 VDD VSS sg13g2_decap_8
XFILLER_163_1027 VDD VSS sg13g2_fill_2
XFILLER_19_1420 VDD VSS sg13g2_decap_8
X_12662_ _12662_/X _12655_/X _12659_/X _12654_/X _12658_/X _12663_/S0 _12663_/S1 VDD
+ VSS sg13g2_mux4_1
XFILLER_71_997 VDD VSS sg13g2_fill_1
Xclkbuf_leaf_63_clk_i clkload87/A clkbuf_leaf_66_clk_i/A VDD VSS sg13g2_buf_8
XFILLER_31_839 VDD VSS sg13g2_decap_8
X_14401_ _14401_/Q clkload36/A _14401_/D _14401_/RESET_B VDD VSS sg13g2_dfrbpq_1
X_11613_ _11613_/Y _11609_/Y _11610_/Y _11612_/Y _11611_/Y _11615_/B VDD VSS sg13g2_a221oi_1
XFILLER_24_891 VDD VSS sg13g2_decap_8
XFILLER_180_1352 VDD VSS sg13g2_decap_4
XFILLER_141_1314 VDD VSS sg13g2_decap_8
X_12593_ _12593_/X _12592_/X _12591_/X _12588_/X _12587_/X wire856/X _12355_/S VDD
+ VSS sg13g2_mux4_1
XFILLER_54_1366 VDD VSS sg13g2_decap_8
XFILLER_23_390 VDD VSS sg13g2_decap_8
XFILLER_169_896 VDD VSS sg13g2_fill_2
XFILLER_168_373 VDD VSS sg13g2_decap_8
X_14332_ _14332_/Q _14716_/CLK _14332_/D _14332_/RESET_B VDD VSS sg13g2_dfrbpq_1
X_11544_ _11544_/Y _12238_/S0 _14404_/Q _12245_/S1 VDD VSS sg13g2_a21oi_1
XFILLER_89_1407 VDD VSS sg13g2_fill_1
XFILLER_11_574 VDD VSS sg13g2_decap_8
XFILLER_129_749 VDD VSS sg13g2_decap_8
X_15216__3077 _15216_/RESET_B VDD VSS sg13g2_tiehi
Xwire432 wire432/X wire432/A VDD VSS sg13g2_buf_2
XFILLER_156_557 VDD VSS sg13g2_fill_1
XFILLER_183_343 VDD VSS sg13g2_decap_8
XFILLER_109_440 VDD VSS sg13g2_decap_8
X_14263_ _14263_/Q clkload42/A _14263_/D _14263_/RESET_B VDD VSS sg13g2_dfrbpq_1
XFILLER_144_719 VDD VSS sg13g2_decap_8
Xclkbuf_leaf_78_clk_i _15226_/CLK clkbuf_leaf_78_clk_i/A VDD VSS sg13g2_buf_8
X_11475_ _11477_/B _12291_/A _11475_/B VDD VSS sg13g2_nor2_1
XFILLER_7_567 VDD VSS sg13g2_decap_8
XFILLER_167_84 VDD VSS sg13g2_decap_8
XFILLER_184_899 VDD VSS sg13g2_fill_1
XFILLER_87_1120 VDD VSS sg13g2_decap_8
XFILLER_13_1085 VDD VSS sg13g2_decap_8
X_13214_ _13215_/B _13200_/A _13667_/Q _13203_/Y VDD VSS sg13g2_a21oi_1
X_14421__1851 _14421_/RESET_B VDD VSS sg13g2_tiehi
X_10426_ _10426_/Y _14831_/Q _10453_/C _13499_/B VDD VSS sg13g2_o21ai_1
X_14194_ _14194_/Q _14674_/CLK _14194_/D _14194_/RESET_B VDD VSS sg13g2_dfrbpq_1
XFILLER_164_590 VDD VSS sg13g2_fill_2
XFILLER_178_1281 VDD VSS sg13g2_decap_4
XFILLER_98_806 VDD VSS sg13g2_decap_8
XFILLER_83_1017 VDD VSS sg13g2_fill_2
XFILLER_152_763 VDD VSS sg13g2_decap_8
X_13145_ _13145_/Y _13145_/A VDD VSS sg13g2_inv_1
XFILLER_98_817 VDD VSS sg13g2_decap_8
XFILLER_139_1265 VDD VSS sg13g2_decap_8
X_10357_ _10358_/C _14807_/Q _14808_/Q _14811_/Q _10357_/D VDD VSS sg13g2_and4_1
XFILLER_83_1039 VDD VSS sg13g2_decap_8
XFILLER_152_785 VDD VSS sg13g2_fill_1
XFILLER_151_273 VDD VSS sg13g2_decap_8
XFILLER_3_784 VDD VSS sg13g2_decap_8
XFILLER_139_1298 VDD VSS sg13g2_decap_8
X_13076_ _13076_/Y _14910_/Q _13064_/B _13172_/B VDD VSS sg13g2_a21oi_1
XFILLER_32_7 VDD VSS sg13g2_decap_8
X_10288_ _10294_/C _10297_/A _10288_/B VDD VSS sg13g2_nor2_1
XFILLER_152_1432 VDD VSS sg13g2_decap_8
XFILLER_61_1315 VDD VSS sg13g2_decap_8
XFILLER_2_294 VDD VSS sg13g2_decap_8
XFILLER_26_1446 VDD VSS sg13g2_decap_8
X_12027_ _12027_/Y _12027_/A _12027_/B _12237_/C VDD VSS sg13g2_nand3_1
XFILLER_39_928 VDD VSS sg13g2_decap_8
XFILLER_66_725 VDD VSS sg13g2_decap_8
XFILLER_113_1438 VDD VSS sg13g2_fill_2
XFILLER_120_693 VDD VSS sg13g2_decap_8
XFILLER_76_70 VDD VSS sg13g2_decap_8
Xclkbuf_leaf_16_clk_i clkload24/A clkbuf_5_6__f_clk_i/X VDD VSS sg13g2_buf_8
XFILLER_93_544 VDD VSS sg13g2_decap_8
XFILLER_4_1253 VDD VSS sg13g2_decap_8
XFILLER_47_961 VDD VSS sg13g2_decap_8
XFILLER_18_140 VDD VSS sg13g2_decap_8
X_13978_ _13978_/Q clkload53/A _13978_/D _13978_/RESET_B VDD VSS sg13g2_dfrbpq_1
XFILLER_0_1128 VDD VSS sg13g2_decap_8
XFILLER_20_1067 VDD VSS sg13g2_fill_2
XFILLER_74_791 VDD VSS sg13g2_decap_8
X_12929_ _12929_/Y _14871_/Q _13249_/B VDD VSS sg13g2_nand2_1
XFILLER_80_238 VDD VSS sg13g2_decap_8
XFILLER_34_644 VDD VSS sg13g2_decap_8
XFILLER_179_616 VDD VSS sg13g2_decap_8
XFILLER_62_964 VDD VSS sg13g2_decap_8
XFILLER_94_1157 VDD VSS sg13g2_fill_1
XFILLER_61_441 VDD VSS sg13g2_decap_8
XFILLER_94_1168 VDD VSS sg13g2_decap_8
XFILLER_33_154 VDD VSS sg13g2_fill_1
XFILLER_107_1209 VDD VSS sg13g2_fill_1
XFILLER_178_126 VDD VSS sg13g2_decap_8
XFILLER_61_474 VDD VSS sg13g2_decap_8
XFILLER_15_891 VDD VSS sg13g2_decap_4
XFILLER_33_1406 VDD VSS sg13g2_decap_8
XFILLER_159_351 VDD VSS sg13g2_decap_4
X_14958__2722 _14958_/RESET_B VDD VSS sg13g2_tiehi
XFILLER_119_204 VDD VSS sg13g2_decap_8
X_14253__2019 _14253_/RESET_B VDD VSS sg13g2_tiehi
X_08120_ _08120_/Y _08119_/X _08452_/D VDD VSS sg13g2_nand2b_1
XFILLER_175_833 VDD VSS sg13g2_decap_8
XFILLER_179_1001 VDD VSS sg13g2_decap_8
XFILLER_186_192 VDD VSS sg13g2_decap_8
X_08051_ _08051_/Y _08079_/S _08397_/B VDD VSS sg13g2_nor2_1
XFILLER_147_579 VDD VSS sg13g2_decap_8
XFILLER_31_1152 VDD VSS sg13g2_decap_8
XFILLER_174_387 VDD VSS sg13g2_decap_8
XFILLER_116_933 VDD VSS sg13g2_decap_4
XFILLER_157_1332 VDD VSS sg13g2_decap_8
Xmax_cap776 _11443_/A _11515_/S0 VDD VSS sg13g2_buf_8
XFILLER_118_1316 VDD VSS sg13g2_decap_4
XFILLER_89_828 VDD VSS sg13g2_decap_8
XFILLER_153_1207 VDD VSS sg13g2_decap_8
Xhold3115 input33/A mem_axi_rdata[7] VDD VSS sg13g2_dlygate4sd3_1
XFILLER_88_316 VDD VSS sg13g2_fill_1
Xhold3126 input7/A mem_axi_rdata[12] VDD VSS sg13g2_dlygate4sd3_1
XFILLER_103_638 VDD VSS sg13g2_decap_8
XFILLER_142_284 VDD VSS sg13g2_decap_8
Xhold3137 hold3137/X input34/X VDD VSS sg13g2_dlygate4sd3_1
X_08953_ _13721_/D _08956_/S _08951_/Y _08952_/Y VDD VSS sg13g2_a21oi_1
XFILLER_9_1120 VDD VSS sg13g2_decap_8
XFILLER_102_126 VDD VSS sg13g2_decap_8
Xhold3148 hold3148/X input31/X VDD VSS sg13g2_dlygate4sd3_1
Xhold3159 hold3159/X input20/X VDD VSS sg13g2_dlygate4sd3_1
XFILLER_69_541 VDD VSS sg13g2_decap_8
XFILLER_116_1040 VDD VSS sg13g2_decap_4
XFILLER_130_468 VDD VSS sg13g2_decap_8
X_07904_ _07905_/C _07904_/A _07904_/B _07904_/C _08402_/B VDD VSS sg13g2_nand4_1
X_08884_ _08884_/Y _10781_/C _09016_/C _15035_/Q VDD VSS sg13g2_nand3_1
XFILLER_99_1002 VDD VSS sg13g2_decap_8
XFILLER_84_500 VDD VSS sg13g2_decap_8
XFILLER_9_1197 VDD VSS sg13g2_decap_8
XFILLER_116_1084 VDD VSS sg13g2_decap_8
XFILLER_96_382 VDD VSS sg13g2_decap_8
XFILLER_69_596 VDD VSS sg13g2_decap_4
X_07835_ _07835_/Y _07979_/C _07981_/C VDD VSS sg13g2_nand2_1
XFILLER_72_706 VDD VSS sg13g2_decap_8
XFILLER_186_1038 VDD VSS sg13g2_decap_8
X_07766_ _07766_/Y _14762_/Q _07766_/B VDD VSS sg13g2_nor2_1
XFILLER_44_419 VDD VSS sg13g2_decap_8
XFILLER_186_1049 VDD VSS sg13g2_decap_8
XFILLER_37_471 VDD VSS sg13g2_decap_8
XFILLER_25_611 VDD VSS sg13g2_decap_8
X_09505_ _14105_/D _10101_/A0 _14105_/Q _09505_/S VDD VSS sg13g2_mux2_1
XFILLER_77_1344 VDD VSS sg13g2_fill_1
X_14463__1809 _14463_/RESET_B VDD VSS sg13g2_tiehi
X_13849__2423 _13849_/RESET_B VDD VSS sg13g2_tiehi
X_07697_ _07700_/A _07697_/A _12936_/B VDD VSS sg13g2_nand2_1
XFILLER_38_1317 VDD VSS sg13g2_decap_8
XFILLER_164_1325 VDD VSS sg13g2_fill_1
XFILLER_72_39 VDD VSS sg13g2_decap_4
X_09436_ _14038_/D _09966_/A1 _14038_/Q _09439_/S VDD VSS sg13g2_mux2_1
XFILLER_169_126 VDD VSS sg13g2_decap_8
XFILLER_80_772 VDD VSS sg13g2_decap_8
XFILLER_25_688 VDD VSS sg13g2_decap_4
XFILLER_40_614 VDD VSS sg13g2_fill_2
XFILLER_164_1369 VDD VSS sg13g2_decap_8
XFILLER_36_1030 VDD VSS sg13g2_decap_8
XFILLER_40_647 VDD VSS sg13g2_decap_8
X_09367_ _13971_/D _10029_/A0 _13971_/Q _09373_/S VDD VSS sg13g2_mux2_1
XFILLER_123_1000 VDD VSS sg13g2_fill_2
XFILLER_21_850 VDD VSS sg13g2_fill_2
XFILLER_162_1071 VDD VSS sg13g2_decap_8
XFILLER_36_1074 VDD VSS sg13g2_decap_8
X_08318_ _08319_/B _08318_/A _08318_/B _08318_/C _08318_/D VDD VSS sg13g2_nand4_1
XFILLER_166_844 VDD VSS sg13g2_decap_8
X_14229__2043 _14229_/RESET_B VDD VSS sg13g2_tiehi
X_09298_ _13906_/D _13906_/Q _10128_/A0 _09298_/S VDD VSS sg13g2_mux2_1
XFILLER_20_371 VDD VSS sg13g2_decap_8
XFILLER_138_568 VDD VSS sg13g2_decap_8
XFILLER_21_21 VDD VSS sg13g2_decap_8
X_08249_ _08250_/B _08248_/A _07927_/Y _08248_/Y VDD VSS sg13g2_a21oi_1
XFILLER_107_900 VDD VSS sg13g2_fill_1
XFILLER_123_1088 VDD VSS sg13g2_fill_2
XFILLER_181_814 VDD VSS sg13g2_decap_8
XFILLER_14_1372 VDD VSS sg13g2_decap_8
XFILLER_166_899 VDD VSS sg13g2_decap_8
XFILLER_4_504 VDD VSS sg13g2_decap_8
XFILLER_10_1225 VDD VSS sg13g2_decap_8
XFILLER_49_1402 VDD VSS sg13g2_fill_1
X_11260_ _11260_/Y _11275_/S0 _13852_/Q _11262_/B VDD VSS sg13g2_a21oi_1
XFILLER_88_1462 VDD VSS sg13g2_decap_8
XFILLER_88_1473 VDD VSS sg13g2_fill_2
XFILLER_180_357 VDD VSS sg13g2_decap_8
XFILLER_21_98 VDD VSS sg13g2_decap_8
XFILLER_97_14 VDD VSS sg13g2_decap_8
XFILLER_49_1435 VDD VSS sg13g2_fill_1
XFILLER_134_752 VDD VSS sg13g2_decap_4
Xclkbuf_5_17__f_clk_i clkload3/A clkbuf_4_8_0_clk_i/X VDD VSS sg13g2_buf_16
X_10211_ _10211_/Y _14763_/Q _10210_/Y VDD VSS sg13g2_nor2b_1
XFILLER_106_465 VDD VSS sg13g2_decap_8
XFILLER_134_774 VDD VSS sg13g2_decap_8
XFILLER_136_1405 VDD VSS sg13g2_decap_8
X_11191_ _11191_/Y _11191_/A _11205_/B VDD VSS sg13g2_nor2_1
XFILLER_97_47 VDD VSS sg13g2_decap_4
XFILLER_133_262 VDD VSS sg13g2_fill_2
XFILLER_161_571 VDD VSS sg13g2_fill_2
XFILLER_136_1438 VDD VSS sg13g2_fill_2
XFILLER_79_327 VDD VSS sg13g2_decap_4
XFILLER_0_721 VDD VSS sg13g2_decap_8
XFILLER_121_424 VDD VSS sg13g2_decap_4
X_10142_ _14719_/D _14719_/Q _10142_/A1 _10169_/S VDD VSS sg13g2_mux2_1
XFILLER_0_743 VDD VSS sg13g2_decap_8
XFILLER_153_31 VDD VSS sg13g2_fill_2
XFILLER_47_1181 VDD VSS sg13g2_decap_8
X_14950_ _14950_/Q clkload54/A _14950_/D _14950_/RESET_B VDD VSS sg13g2_dfrbpq_1
X_10073_ _14653_/D _10140_/A1 _14653_/Q _10096_/S VDD VSS sg13g2_mux2_1
XFILLER_48_714 VDD VSS sg13g2_decap_8
XFILLER_153_64 VDD VSS sg13g2_fill_2
XFILLER_88_883 VDD VSS sg13g2_decap_8
XFILLER_82_1094 VDD VSS sg13g2_decap_8
XFILLER_130_1004 VDD VSS sg13g2_decap_8
XFILLER_101_170 VDD VSS sg13g2_decap_8
X_13901_ _13901_/Q _14733_/CLK _13901_/D _13901_/RESET_B VDD VSS sg13g2_dfrbpq_1
X_14881_ _14881_/Q _14883_/CLK _14881_/D _14881_/RESET_B VDD VSS sg13g2_dfrbpq_1
XFILLER_47_235 VDD VSS sg13g2_decap_8
XFILLER_169_1225 VDD VSS sg13g2_decap_8
X_13832_ _13832_/Q _14664_/CLK _13832_/D _13832_/RESET_B VDD VSS sg13g2_dfrbpq_1
XFILLER_21_1354 VDD VSS sg13g2_decap_8
XFILLER_29_994 VDD VSS sg13g2_decap_8
XFILLER_62_227 VDD VSS sg13g2_decap_8
X_13763_ _13763_/Q _14723_/CLK _13763_/D _13763_/RESET_B VDD VSS sg13g2_dfrbpq_1
XFILLER_16_644 VDD VSS sg13g2_decap_8
X_10975_ _11009_/D _15115_/Q _10995_/A VDD VSS sg13g2_xnor2_1
XFILLER_182_1414 VDD VSS sg13g2_decap_8
XFILLER_71_750 VDD VSS sg13g2_decap_8
X_14439__1833 _14439_/RESET_B VDD VSS sg13g2_tiehi
X_12714_ _12714_/X _14133_/Q _14165_/Q _14197_/Q _14229_/Q _12715_/S0 _12715_/S1 VDD
+ VSS sg13g2_mux4_1
XFILLER_91_1319 VDD VSS sg13g2_decap_8
XFILLER_15_154 VDD VSS sg13g2_decap_8
X_13694_ _16856_/A _15219_/CLK _13694_/D _13694_/RESET_B VDD VSS sg13g2_dfrbpq_1
X_13677__2611 _13677_/RESET_B VDD VSS sg13g2_tiehi
XFILLER_31_636 VDD VSS sg13g2_decap_8
X_12645_ _12645_/X _13744_/Q _14096_/Q _14448_/Q _14544_/Q _12674_/S0 _12674_/S1 VDD
+ VSS sg13g2_mux4_1
XFILLER_169_660 VDD VSS sg13g2_fill_1
XFILLER_129_513 VDD VSS sg13g2_decap_8
XFILLER_145_1280 VDD VSS sg13g2_decap_8
XFILLER_12_861 VDD VSS sg13g2_decap_8
XFILLER_19_1294 VDD VSS sg13g2_decap_8
XFILLER_50_1005 VDD VSS sg13g2_decap_8
XFILLER_30_168 VDD VSS sg13g2_decap_8
X_12576_ _12576_/X _14699_/Q _14731_/Q _13771_/Q _13803_/Q _12600_/S0 _12600_/S1 VDD
+ VSS sg13g2_mux4_1
XFILLER_11_371 VDD VSS sg13g2_decap_8
XFILLER_157_866 VDD VSS sg13g2_fill_2
XFILLER_15_1158 VDD VSS sg13g2_decap_8
XFILLER_89_1215 VDD VSS sg13g2_decap_8
XFILLER_50_1038 VDD VSS sg13g2_decap_8
X_14315_ _14315_/Q clkload11/A _14315_/D _14315_/RESET_B VDD VSS sg13g2_dfrbpq_1
XFILLER_8_854 VDD VSS sg13g2_decap_8
XFILLER_156_354 VDD VSS sg13g2_decap_8
XFILLER_183_140 VDD VSS sg13g2_decap_8
X_11527_ _11527_/Y _11527_/A _11636_/B VDD VSS sg13g2_xnor2_1
XFILLER_117_719 VDD VSS sg13g2_decap_8
XFILLER_156_365 VDD VSS sg13g2_fill_1
XFILLER_7_56 VDD VSS sg13g2_decap_8
XFILLER_32_1461 VDD VSS sg13g2_decap_8
XFILLER_156_376 VDD VSS sg13g2_decap_8
Xwire262 wire262/X wire262/A VDD VSS sg13g2_buf_2
XFILLER_171_302 VDD VSS sg13g2_fill_1
XFILLER_7_364 VDD VSS sg13g2_decap_8
XFILLER_184_696 VDD VSS sg13g2_fill_2
XFILLER_176_1229 VDD VSS sg13g2_decap_8
X_14246_ _14246_/Q _14662_/CLK _14246_/D _14246_/RESET_B VDD VSS sg13g2_dfrbpq_1
XFILLER_144_549 VDD VSS sg13g2_decap_8
X_11458_ _11458_/Y _11458_/A _11458_/B VDD VSS sg13g2_nor2_1
XFILLER_125_752 VDD VSS sg13g2_fill_1
XFILLER_113_903 VDD VSS sg13g2_decap_8
X_10409_ _14825_/D _14825_/Q _10406_/A _10408_/Y VDD VSS sg13g2_a21oi_1
X_14177_ _14177_/Q clkload37/A _14177_/D _14177_/RESET_B VDD VSS sg13g2_dfrbpq_1
XFILLER_124_251 VDD VSS sg13g2_decap_8
X_11389_ _11389_/Y _11804_/A _13855_/Q _11805_/C VDD VSS sg13g2_a21oi_1
XFILLER_180_891 VDD VSS sg13g2_decap_8
XFILLER_113_947 VDD VSS sg13g2_decap_8
X_13128_ _13146_/A _14915_/Q _13129_/B VDD VSS sg13g2_nand2_1
XFILLER_3_581 VDD VSS sg13g2_decap_8
X_13927__2345 _13927_/RESET_B VDD VSS sg13g2_tiehi
XFILLER_140_755 VDD VSS sg13g2_decap_8
X_14687__1585 _14687_/RESET_B VDD VSS sg13g2_tiehi
XFILLER_98_669 VDD VSS sg13g2_fill_1
X_13059_ _13066_/C _12993_/B _12993_/C _13058_/Y VDD VSS sg13g2_a21oi_1
XFILLER_26_1243 VDD VSS sg13g2_decap_8
XFILLER_113_1213 VDD VSS sg13g2_decap_8
XFILLER_152_1273 VDD VSS sg13g2_decap_8
XFILLER_22_1107 VDD VSS sg13g2_decap_8
XFILLER_6_1337 VDD VSS sg13g2_decap_8
Xfanout1360 _12330_/S1 _12091_/C VDD VSS sg13g2_buf_1
XFILLER_94_831 VDD VSS sg13g2_fill_1
XFILLER_61_1167 VDD VSS sg13g2_decap_8
Xfanout1371 _12187_/C _12259_/S1 VDD VSS sg13g2_buf_1
Xfanout1382 _12169_/C _12215_/S1 VDD VSS sg13g2_buf_1
XFILLER_94_853 VDD VSS sg13g2_fill_2
X_14831__2975 _14831_/RESET_B VDD VSS sg13g2_tiehi
Xfanout1393 _11753_/S0 _11963_/S0 VDD VSS sg13g2_buf_1
XFILLER_94_864 VDD VSS sg13g2_decap_8
XFILLER_66_566 VDD VSS sg13g2_decap_8
X_07620_ _07620_/Y _14880_/Q VDD VSS sg13g2_inv_1
XFILLER_93_352 VDD VSS sg13g2_decap_8
XFILLER_4_1050 VDD VSS sg13g2_decap_8
XFILLER_94_897 VDD VSS sg13g2_decap_8
XFILLER_66_599 VDD VSS sg13g2_decap_8
XFILLER_53_216 VDD VSS sg13g2_decap_8
XFILLER_179_413 VDD VSS sg13g2_decap_8
XFILLER_62_761 VDD VSS sg13g2_decap_4
XFILLER_35_986 VDD VSS sg13g2_decap_8
XFILLER_22_603 VDD VSS sg13g2_decap_8
XFILLER_146_1033 VDD VSS sg13g2_decap_4
XFILLER_50_923 VDD VSS sg13g2_decap_8
XFILLER_146_1066 VDD VSS sg13g2_decap_8
X_09221_ _13832_/D _10051_/A0 _13832_/Q _09233_/S VDD VSS sg13g2_mux2_1
XFILLER_163_1380 VDD VSS sg13g2_decap_8
XFILLER_37_1383 VDD VSS sg13g2_decap_8
XFILLER_147_310 VDD VSS sg13g2_fill_2
XFILLER_163_1391 VDD VSS sg13g2_fill_1
XFILLER_21_168 VDD VSS sg13g2_decap_8
X_09152_ _09152_/Y _09162_/A _09148_/Y _09151_/Y VDD VSS sg13g2_o21ai_1
XFILLER_175_641 VDD VSS sg13g2_decap_8
XFILLER_148_866 VDD VSS sg13g2_fill_1
X_08103_ _08104_/D _08154_/A _08103_/B _08103_/C VDD VSS sg13g2_nor3_1
XFILLER_124_1386 VDD VSS sg13g2_fill_1
XFILLER_163_803 VDD VSS sg13g2_fill_2
XFILLER_174_140 VDD VSS sg13g2_decap_8
X_09083_ _09083_/Y _09090_/A _09079_/Y _09082_/Y VDD VSS sg13g2_o21ai_1
X_14776__3030 _14776_/RESET_B VDD VSS sg13g2_tiehi
XFILLER_163_847 VDD VSS sg13g2_decap_8
X_08034_ _08034_/Y _08174_/A _08659_/B VDD VSS sg13g2_nor2_1
XFILLER_89_603 VDD VSS sg13g2_decap_8
XFILLER_1_518 VDD VSS sg13g2_decap_8
XFILLER_66_1045 VDD VSS sg13g2_fill_1
XFILLER_103_413 VDD VSS sg13g2_decap_4
XFILLER_143_593 VDD VSS sg13g2_decap_8
XFILLER_118_1146 VDD VSS sg13g2_decap_8
XFILLER_131_744 VDD VSS sg13g2_fill_1
X_09985_ _14568_/D _10051_/A0 _14568_/Q _09994_/S VDD VSS sg13g2_mux2_1
XFILLER_103_446 VDD VSS sg13g2_fill_1
XFILLER_153_1037 VDD VSS sg13g2_decap_4
X_14517__1755 _14517_/RESET_B VDD VSS sg13g2_tiehi
XFILLER_44_1332 VDD VSS sg13g2_decap_8
XFILLER_130_254 VDD VSS sg13g2_decap_8
X_08936_ _08936_/X _15048_/Q _14952_/Q _10716_/A VDD VSS sg13g2_mux2_1
XFILLER_170_1340 VDD VSS sg13g2_fill_1
XFILLER_85_820 VDD VSS sg13g2_decap_8
XFILLER_97_691 VDD VSS sg13g2_decap_8
XFILLER_44_1376 VDD VSS sg13g2_decap_8
XFILLER_131_1335 VDD VSS sg13g2_fill_1
X_08867_ _08867_/X _08866_/X _08867_/A1 _08940_/S VDD VSS sg13g2_mux2_1
XFILLER_40_1229 VDD VSS sg13g2_decap_8
XFILLER_184_7 VDD VSS sg13g2_decap_8
XFILLER_18_909 VDD VSS sg13g2_decap_8
X_13781__2491 _13781_/RESET_B VDD VSS sg13g2_tiehi
X_15215__3076 _15215_/RESET_B VDD VSS sg13g2_tiehi
XFILLER_123_56 VDD VSS sg13g2_fill_2
XFILLER_131_1379 VDD VSS sg13g2_fill_2
X_07818_ _07818_/Y _15010_/Q _07818_/B VDD VSS sg13g2_xnor2_1
XFILLER_29_268 VDD VSS sg13g2_decap_8
XFILLER_79_1439 VDD VSS sg13g2_fill_2
X_08798_ _08799_/B _12942_/B _08801_/B VDD VSS sg13g2_nor2_1
X_14732__1540 _14732_/RESET_B VDD VSS sg13g2_tiehi
Xclkbuf_4_1_0_clk_i clkbuf_4_1_0_clk_i/X clkbuf_0_clk_i/X VDD VSS sg13g2_buf_8
XFILLER_38_791 VDD VSS sg13g2_fill_1
XFILLER_16_21 VDD VSS sg13g2_decap_8
X_07749_ _07750_/A _07738_/Y _07744_/D _07748_/Y VDD VSS sg13g2_o21ai_1
XFILLER_26_953 VDD VSS sg13g2_fill_2
XFILLER_25_452 VDD VSS sg13g2_decap_8
XFILLER_25_463 VDD VSS sg13g2_decap_4
X_10760_ _10760_/Y _10760_/A _11113_/B VDD VSS sg13g2_nand2_1
XFILLER_41_923 VDD VSS sg13g2_decap_8
XFILLER_129_1253 VDD VSS sg13g2_decap_4
XFILLER_53_783 VDD VSS sg13g2_decap_8
XFILLER_125_1106 VDD VSS sg13g2_decap_8
XFILLER_16_98 VDD VSS sg13g2_decap_8
XFILLER_41_945 VDD VSS sg13g2_fill_1
XFILLER_158_608 VDD VSS sg13g2_decap_8
X_09419_ _14021_/D _09949_/A1 _14021_/Q _09432_/S VDD VSS sg13g2_mux2_1
XFILLER_13_658 VDD VSS sg13g2_decap_8
XFILLER_158_619 VDD VSS sg13g2_fill_2
XFILLER_164_1177 VDD VSS sg13g2_fill_1
XFILLER_16_1412 VDD VSS sg13g2_decap_8
X_10691_ _10691_/X _14931_/Q _08998_/X _10691_/S VDD VSS sg13g2_mux2_1
XFILLER_139_811 VDD VSS sg13g2_decap_8
XFILLER_179_980 VDD VSS sg13g2_decap_8
XFILLER_185_427 VDD VSS sg13g2_decap_8
XFILLER_12_168 VDD VSS sg13g2_decap_8
XFILLER_142_1431 VDD VSS sg13g2_decap_8
X_12430_ _14994_/D _07910_/A _12443_/A2 _12429_/Y VDD VSS sg13g2_a21oi_1
XFILLER_51_1325 VDD VSS sg13g2_decap_8
XFILLER_138_321 VDD VSS sg13g2_decap_8
XFILLER_178_490 VDD VSS sg13g2_decap_8
XFILLER_32_42 VDD VSS sg13g2_decap_8
XFILLER_21_680 VDD VSS sg13g2_decap_4
XFILLER_51_1347 VDD VSS sg13g2_fill_1
XFILLER_12_1309 VDD VSS sg13g2_decap_8
XFILLER_148_42 VDD VSS sg13g2_decap_8
XFILLER_166_663 VDD VSS sg13g2_fill_2
X_12361_ _12361_/X _14236_/Q _14268_/Q _14300_/Q _14332_/Q _12366_/S0 _12366_/S1 VDD
+ VSS sg13g2_mux4_1
XFILLER_165_151 VDD VSS sg13g2_decap_8
XFILLER_139_899 VDD VSS sg13g2_decap_8
X_14100_ _14100_/Q clkload25/A _14100_/D _14100_/RESET_B VDD VSS sg13g2_dfrbpq_1
X_11312_ _11312_/Y _11306_/Y _11311_/Y _11378_/S VDD VSS sg13g2_o21ai_1
XFILLER_4_301 VDD VSS sg13g2_decap_8
XFILLER_10_1022 VDD VSS sg13g2_decap_8
X_15080_ _15080_/Q clkload88/A _15080_/D _15080_/RESET_B VDD VSS sg13g2_dfrbpq_1
XFILLER_181_644 VDD VSS sg13g2_decap_8
X_12292_ _12292_/Y _12292_/A _12292_/B VDD VSS sg13g2_nor2_1
XFILLER_5_868 VDD VSS sg13g2_decap_8
XFILLER_106_0 VDD VSS sg13g2_decap_8
XFILLER_141_508 VDD VSS sg13g2_decap_4
X_14031_ _14031_/Q _14607_/CLK _14031_/D _14031_/RESET_B VDD VSS sg13g2_dfrbpq_1
XFILLER_180_154 VDD VSS sg13g2_decap_8
X_11243_ _11245_/B _13293_/C _13293_/D _11243_/C VDD VSS sg13g2_or3_1
XFILLER_101_1183 VDD VSS sg13g2_decap_8
XFILLER_84_1123 VDD VSS sg13g2_decap_8
XFILLER_122_711 VDD VSS sg13g2_decap_8
XFILLER_4_378 VDD VSS sg13g2_decap_8
XFILLER_107_796 VDD VSS sg13g2_decap_4
XFILLER_106_273 VDD VSS sg13g2_decap_4
XFILLER_10_1099 VDD VSS sg13g2_decap_8
XFILLER_164_63 VDD VSS sg13g2_decap_4
X_11174_ _11177_/C _11127_/A _11127_/B _11173_/Y VDD VSS sg13g2_a21oi_1
XFILLER_175_1295 VDD VSS sg13g2_decap_8
XFILLER_136_1257 VDD VSS sg13g2_decap_8
XFILLER_171_1137 VDD VSS sg13g2_fill_2
XFILLER_79_146 VDD VSS sg13g2_decap_4
XFILLER_122_777 VDD VSS sg13g2_decap_8
XFILLER_171_1159 VDD VSS sg13g2_decap_8
X_10125_ _14703_/D _10158_/A1 _14703_/Q _10127_/S VDD VSS sg13g2_mux2_1
XFILLER_67_308 VDD VSS sg13g2_decap_8
XFILLER_95_628 VDD VSS sg13g2_decap_8
XFILLER_110_939 VDD VSS sg13g2_decap_8
XFILLER_94_116 VDD VSS sg13g2_decap_8
XFILLER_0_595 VDD VSS sg13g2_decap_8
XFILLER_76_842 VDD VSS sg13g2_decap_8
XFILLER_57_50 VDD VSS sg13g2_fill_1
X_14933_ _14933_/Q _15226_/CLK _14933_/D _14933_/RESET_B VDD VSS sg13g2_dfrbpq_1
X_10056_ _14637_/D _10089_/A0 _14637_/Q _10060_/S VDD VSS sg13g2_mux2_1
XFILLER_23_1449 VDD VSS sg13g2_decap_8
XFILLER_91_801 VDD VSS sg13g2_decap_4
XFILLER_76_886 VDD VSS sg13g2_decap_8
XFILLER_180_84 VDD VSS sg13g2_decap_8
X_14864_ _14864_/Q _14864_/CLK _14864_/D _14864_/RESET_B VDD VSS sg13g2_dfrbpq_1
XFILLER_90_300 VDD VSS sg13g2_decap_8
XFILLER_63_514 VDD VSS sg13g2_decap_8
XFILLER_21_1151 VDD VSS sg13g2_decap_8
XFILLER_35_238 VDD VSS sg13g2_decap_8
XFILLER_169_1077 VDD VSS sg13g2_decap_8
X_13815_ _13815_/Q _15017_/CLK _13815_/D _13815_/RESET_B VDD VSS sg13g2_dfrbpq_1
X_14795_ _14795_/Q clkload62/A _14795_/D _14795_/RESET_B VDD VSS sg13g2_dfrbpq_1
XFILLER_16_441 VDD VSS sg13g2_decap_8
XFILLER_1_1267 VDD VSS sg13g2_decap_8
XFILLER_147_1331 VDD VSS sg13g2_decap_8
XFILLER_186_1380 VDD VSS sg13g2_decap_8
XFILLER_186_1391 VDD VSS sg13g2_decap_8
X_13746_ _13746_/Q _14610_/CLK _13746_/D _13746_/RESET_B VDD VSS sg13g2_dfrbpq_1
X_10958_ _14938_/D _10956_/Y _10957_/Y _10941_/X VDD VSS sg13g2_a21o_1
XFILLER_90_388 VDD VSS sg13g2_decap_4
XFILLER_56_1258 VDD VSS sg13g2_decap_8
X_13677_ _13677_/Q clkload82/A _13677_/D _13677_/RESET_B VDD VSS sg13g2_dfrbpq_1
XFILLER_32_967 VDD VSS sg13g2_decap_8
X_10889_ _10948_/A _14755_/Q _10923_/A VDD VSS sg13g2_xor2_1
XFILLER_31_455 VDD VSS sg13g2_decap_8
XFILLER_176_427 VDD VSS sg13g2_decap_8
X_12628_ _12628_/X _14383_/Q _14415_/Q _14479_/Q _14511_/Q _12633_/S0 _12633_/S1 VDD
+ VSS sg13g2_mux4_1
XFILLER_19_1091 VDD VSS sg13g2_decap_8
XFILLER_157_641 VDD VSS sg13g2_decap_8
XFILLER_185_961 VDD VSS sg13g2_fill_2
XFILLER_8_651 VDD VSS sg13g2_decap_8
X_14170__2102 _14170_/RESET_B VDD VSS sg13g2_tiehi
X_12559_ _12559_/X _14378_/Q _14410_/Q _14474_/Q _14506_/Q _12605_/S0 _12643_/S1 VDD
+ VSS sg13g2_mux4_1
XFILLER_145_825 VDD VSS sg13g2_decap_8
XFILLER_184_471 VDD VSS sg13g2_decap_8
XFILLER_184_482 VDD VSS sg13g2_decap_8
XFILLER_7_161 VDD VSS sg13g2_decap_8
XFILLER_144_324 VDD VSS sg13g2_decap_4
XFILLER_184_493 VDD VSS sg13g2_fill_2
XFILLER_176_1037 VDD VSS sg13g2_decap_8
XFILLER_89_1089 VDD VSS sg13g2_decap_8
XFILLER_171_154 VDD VSS sg13g2_decap_8
X_14229_ _14229_/Q clkload28/A _14229_/D _14229_/RESET_B VDD VSS sg13g2_dfrbpq_1
XFILLER_67_1354 VDD VSS sg13g2_fill_1
XFILLER_28_1305 VDD VSS sg13g2_decap_8
XFILLER_125_582 VDD VSS sg13g2_decap_8
XFILLER_171_187 VDD VSS sg13g2_decap_4
Xfanout608 _08544_/B _08400_/Y VDD VSS sg13g2_buf_1
Xfanout619 _13208_/B1 _13220_/B1 VDD VSS sg13g2_buf_1
XFILLER_63_1229 VDD VSS sg13g2_decap_4
XFILLER_140_552 VDD VSS sg13g2_decap_8
XFILLER_86_606 VDD VSS sg13g2_decap_8
XFILLER_154_1368 VDD VSS sg13g2_decap_8
XFILLER_98_477 VDD VSS sg13g2_decap_8
XFILLER_113_788 VDD VSS sg13g2_decap_8
XFILLER_154_1379 VDD VSS sg13g2_fill_2
X_09770_ _14360_/D _14360_/Q _09770_/A1 _09770_/S VDD VSS sg13g2_mux2_1
XFILLER_112_276 VDD VSS sg13g2_decap_4
XFILLER_21_0 VDD VSS sg13g2_decap_8
XFILLER_100_438 VDD VSS sg13g2_decap_8
X_08721_ _08721_/X hold3159/X _15193_/Q _10187_/S VDD VSS sg13g2_mux2_1
XFILLER_6_1134 VDD VSS sg13g2_decap_8
XFILLER_152_1070 VDD VSS sg13g2_fill_2
XFILLER_113_1043 VDD VSS sg13g2_decap_8
XFILLER_78_190 VDD VSS sg13g2_fill_2
Xfanout1190 _07945_/B _08487_/A3 VDD VSS sg13g2_buf_1
X_08652_ _08661_/A _08668_/A _08336_/Y _08652_/B1 VDD VSS sg13g2_o21ai_1
XFILLER_96_1016 VDD VSS sg13g2_decap_8
XFILLER_94_683 VDD VSS sg13g2_decap_8
XFILLER_27_728 VDD VSS sg13g2_fill_2
XFILLER_26_205 VDD VSS sg13g2_decap_8
XFILLER_81_322 VDD VSS sg13g2_decap_8
XFILLER_81_333 VDD VSS sg13g2_fill_1
X_08583_ _08586_/B _07963_/Y _08583_/B VDD VSS sg13g2_nand2b_1
XFILLER_78_1450 VDD VSS sg13g2_decap_8
XFILLER_39_1423 VDD VSS sg13g2_decap_8
XFILLER_179_210 VDD VSS sg13g2_decap_8
XFILLER_41_219 VDD VSS sg13g2_decap_8
XFILLER_126_1415 VDD VSS sg13g2_decap_8
XFILLER_35_794 VDD VSS sg13g2_fill_1
XFILLER_23_989 VDD VSS sg13g2_decap_8
XFILLER_179_287 VDD VSS sg13g2_decap_8
X_09204_ _09342_/A _09441_/A _10004_/B _09204_/C _09204_/D VDD VSS sg13g2_nor4_1
XFILLER_176_961 VDD VSS sg13g2_fill_1
XFILLER_120_1003 VDD VSS sg13g2_decap_8
X_09135_ _09164_/C _14921_/Q _13200_/A VDD VSS sg13g2_and2_1
XFILLER_147_151 VDD VSS sg13g2_decap_8
XFILLER_163_600 VDD VSS sg13g2_decap_8
XFILLER_175_460 VDD VSS sg13g2_decap_8
XFILLER_135_302 VDD VSS sg13g2_decap_4
XFILLER_33_1077 VDD VSS sg13g2_decap_8
XFILLER_135_335 VDD VSS sg13g2_decap_8
X_09066_ _09066_/Y _09072_/B _15038_/Q _09065_/Y VDD VSS sg13g2_o21ai_1
XFILLER_50_1380 VDD VSS sg13g2_decap_4
XFILLER_147_195 VDD VSS sg13g2_decap_4
X_13799__2473 _13799_/RESET_B VDD VSS sg13g2_tiehi
XFILLER_68_1118 VDD VSS sg13g2_fill_1
XFILLER_102_1470 VDD VSS sg13g2_decap_4
XFILLER_118_45 VDD VSS sg13g2_fill_2
X_08017_ _08019_/B _11502_/A _11526_/A _11570_/A _11591_/A _08253_/S0 _08033_/A VDD
+ VSS sg13g2_mux4_1
XFILLER_2_805 VDD VSS sg13g2_decap_8
XFILLER_11_1386 VDD VSS sg13g2_decap_8
XFILLER_151_839 VDD VSS sg13g2_decap_8
XFILLER_150_327 VDD VSS sg13g2_decap_8
XFILLER_1_315 VDD VSS sg13g2_decap_8
XFILLER_104_733 VDD VSS sg13g2_decap_4
XFILLER_81_1307 VDD VSS sg13g2_fill_2
XFILLER_131_541 VDD VSS sg13g2_decap_4
XFILLER_104_777 VDD VSS sg13g2_decap_8
XFILLER_172_1457 VDD VSS sg13g2_decap_8
X_14033__2239 _14033_/RESET_B VDD VSS sg13g2_tiehi
X_14912__2813 _14912_/RESET_B VDD VSS sg13g2_tiehi
XFILLER_49_308 VDD VSS sg13g2_fill_1
X_09968_ _14552_/D _14552_/Q _10067_/A0 _09969_/S VDD VSS sg13g2_mux2_1
XFILLER_103_276 VDD VSS sg13g2_decap_4
X_14179__2093 _14179_/RESET_B VDD VSS sg13g2_tiehi
XFILLER_89_499 VDD VSS sg13g2_fill_2
XFILLER_103_298 VDD VSS sg13g2_fill_1
XFILLER_58_831 VDD VSS sg13g2_decap_8
X_08919_ _08919_/X _08918_/X _11936_/A _08937_/S VDD VSS sg13g2_mux2_1
XFILLER_134_77 VDD VSS sg13g2_fill_2
XFILLER_44_1173 VDD VSS sg13g2_decap_8
XFILLER_100_950 VDD VSS sg13g2_fill_1
XFILLER_170_1181 VDD VSS sg13g2_decap_8
X_09899_ _14485_/D _09899_/A0 _14485_/Q _09903_/S VDD VSS sg13g2_mux2_1
XFILLER_100_961 VDD VSS sg13g2_decap_8
XFILLER_40_1026 VDD VSS sg13g2_decap_8
XFILLER_131_1154 VDD VSS sg13g2_fill_1
XFILLER_57_352 VDD VSS sg13g2_decap_4
X_11930_ _11930_/Y _11975_/A _11928_/X _11929_/Y VDD VSS sg13g2_o21ai_1
XFILLER_131_1165 VDD VSS sg13g2_decap_8
XFILLER_85_683 VDD VSS sg13g2_fill_2
XFILLER_57_374 VDD VSS sg13g2_decap_4
XFILLER_45_514 VDD VSS sg13g2_decap_8
XFILLER_84_160 VDD VSS sg13g2_decap_8
XFILLER_27_42 VDD VSS sg13g2_decap_8
XFILLER_150_21 VDD VSS sg13g2_decap_8
XFILLER_22_1471 VDD VSS sg13g2_decap_4
XFILLER_17_238 VDD VSS sg13g2_decap_8
X_14945__2747 _14945_/RESET_B VDD VSS sg13g2_tiehi
XFILLER_79_1258 VDD VSS sg13g2_decap_4
XFILLER_45_547 VDD VSS sg13g2_decap_8
XFILLER_166_1217 VDD VSS sg13g2_fill_1
X_11861_ _11861_/Y _11860_/Y _11859_/Y _11846_/Y _11868_/A _11980_/A VDD VSS sg13g2_a221oi_1
X_13600_ _13600_/Y _13600_/A _13600_/B _13600_/C VDD VSS sg13g2_nand3_1
XFILLER_92_1403 VDD VSS sg13g2_decap_8
X_10812_ _14927_/D _10811_/Y _10810_/Y _10800_/Y VDD VSS sg13g2_o21ai_1
XFILLER_72_377 VDD VSS sg13g2_decap_8
XFILLER_60_517 VDD VSS sg13g2_decap_8
XFILLER_150_87 VDD VSS sg13g2_decap_8
X_14580_ _14580_/Q _14982_/CLK _14580_/D _14580_/RESET_B VDD VSS sg13g2_dfrbpq_1
X_11792_ _11792_/Y _13064_/A _11792_/B VDD VSS sg13g2_nand2_1
XFILLER_129_1050 VDD VSS sg13g2_fill_2
XFILLER_26_794 VDD VSS sg13g2_decap_8
XFILLER_14_945 VDD VSS sg13g2_decap_8
XFILLER_53_591 VDD VSS sg13g2_decap_8
XFILLER_41_731 VDD VSS sg13g2_decap_8
X_13531_ _13531_/Y _13531_/A _13535_/B VDD VSS sg13g2_nor2_1
XFILLER_186_714 VDD VSS sg13g2_decap_8
X_10743_ _11078_/A _07615_/Y _09086_/Y _10743_/S VDD VSS sg13g2_mux2_1
XFILLER_41_753 VDD VSS sg13g2_decap_8
XFILLER_40_230 VDD VSS sg13g2_decap_8
XFILLER_13_455 VDD VSS sg13g2_decap_8
XFILLER_158_416 VDD VSS sg13g2_decap_8
XFILLER_186_725 VDD VSS sg13g2_decap_8
XFILLER_43_63 VDD VSS sg13g2_decap_4
XFILLER_185_224 VDD VSS sg13g2_decap_8
X_13462_ _13463_/B _15189_/Q _15190_/Q VDD VSS sg13g2_nand2b_1
XFILLER_139_630 VDD VSS sg13g2_fill_1
X_10674_ _10674_/Y _10674_/A _13294_/B VDD VSS sg13g2_nand2_1
XFILLER_139_641 VDD VSS sg13g2_decap_8
XFILLER_167_950 VDD VSS sg13g2_decap_8
X_14986__2694 _14986_/RESET_B VDD VSS sg13g2_tiehi
XFILLER_9_448 VDD VSS sg13g2_decap_8
XFILLER_142_1250 VDD VSS sg13g2_decap_8
XFILLER_167_961 VDD VSS sg13g2_fill_2
X_15201_ _15201_/Q clkload88/A _15201_/D _15201_/RESET_B VDD VSS sg13g2_dfrbpq_1
XFILLER_90_1182 VDD VSS sg13g2_decap_8
XFILLER_173_408 VDD VSS sg13g2_decap_8
X_12413_ _12413_/X _12409_/X _12408_/X _12405_/X _12404_/X wire856/X _12355_/S VDD
+ VSS sg13g2_mux4_1
XFILLER_12_1106 VDD VSS sg13g2_decap_8
XFILLER_51_1155 VDD VSS sg13g2_decap_4
XFILLER_16_1286 VDD VSS sg13g2_decap_8
X_13393_ _13393_/Y _13493_/A1 _13493_/A2 _15085_/Q VDD VSS sg13g2_o21ai_1
XFILLER_167_994 VDD VSS sg13g2_decap_8
XFILLER_51_1177 VDD VSS sg13g2_decap_8
XFILLER_139_696 VDD VSS sg13g2_decap_8
X_15132_ _15132_/Q clkload77/A _15132_/D _15132_/RESET_B VDD VSS sg13g2_dfrbpq_1
X_15123__2806 _15123_/RESET_B VDD VSS sg13g2_tiehi
X_12344_ _12344_/X _14555_/Q _14587_/Q _14619_/Q _14651_/Q _12366_/S0 _12366_/S1 VDD
+ VSS sg13g2_mux4_1
XFILLER_154_655 VDD VSS sg13g2_decap_8
XFILLER_181_441 VDD VSS sg13g2_decap_8
XFILLER_182_964 VDD VSS sg13g2_fill_1
X_14389__1883 _14389_/RESET_B VDD VSS sg13g2_tiehi
XFILLER_142_828 VDD VSS sg13g2_decap_8
X_15063_ _15063_/Q _15113_/CLK _15063_/D _15063_/RESET_B VDD VSS sg13g2_dfrbpq_1
XFILLER_5_665 VDD VSS sg13g2_decap_8
XFILLER_107_560 VDD VSS sg13g2_fill_1
XFILLER_182_997 VDD VSS sg13g2_decap_8
X_12275_ _12275_/Y _12229_/A _13664_/Q _12274_/Y VDD VSS sg13g2_a21oi_1
XFILLER_49_1040 VDD VSS sg13g2_fill_1
XFILLER_175_84 VDD VSS sg13g2_decap_8
X_14014_ _14014_/Q clkload48/A _14014_/D _14014_/RESET_B VDD VSS sg13g2_dfrbpq_1
XFILLER_4_175 VDD VSS sg13g2_decap_8
XFILLER_107_593 VDD VSS sg13g2_fill_1
X_11226_ _11226_/X _14235_/Q _14267_/Q _14299_/Q _14331_/Q _11226_/S0 _11300_/S1 VDD
+ VSS sg13g2_mux4_1
XFILLER_4_35 VDD VSS sg13g2_decap_8
XFILLER_136_1032 VDD VSS sg13g2_decap_8
XFILLER_175_1081 VDD VSS sg13g2_decap_4
XFILLER_150_883 VDD VSS sg13g2_decap_8
X_11157_ _11173_/C _11171_/B _11164_/C VDD VSS sg13g2_xnor2_1
XFILLER_7_1421 VDD VSS sg13g2_decap_8
XFILLER_136_1087 VDD VSS sg13g2_fill_1
XFILLER_1_882 VDD VSS sg13g2_decap_8
X_14009__2263 _14009_/RESET_B VDD VSS sg13g2_tiehi
XFILLER_49_831 VDD VSS sg13g2_decap_8
X_10108_ _14686_/D _10141_/A1 _14686_/Q _10130_/S VDD VSS sg13g2_mux2_1
XFILLER_0_392 VDD VSS sg13g2_decap_8
XFILLER_153_1390 VDD VSS sg13g2_fill_1
X_11088_ _11091_/A _11088_/A _11118_/B _11118_/A VDD VSS sg13g2_nand3_1
XFILLER_23_1246 VDD VSS sg13g2_decap_8
X_14916_ _14916_/Q clkload57/A _14916_/D _14916_/RESET_B VDD VSS sg13g2_dfrbpq_1
X_10039_ _14620_/D _10039_/A0 _14620_/Q _10063_/S VDD VSS sg13g2_mux2_1
XFILLER_76_683 VDD VSS sg13g2_fill_2
XFILLER_114_1396 VDD VSS sg13g2_decap_8
XFILLER_36_525 VDD VSS sg13g2_decap_8
XFILLER_63_322 VDD VSS sg13g2_fill_2
XFILLER_97_1358 VDD VSS sg13g2_decap_8
X_14847_ _14847_/Q _14883_/CLK _14847_/D _14847_/RESET_B VDD VSS sg13g2_dfrbpq_1
XFILLER_90_141 VDD VSS sg13g2_decap_8
XFILLER_36_569 VDD VSS sg13g2_fill_1
XFILLER_1_1064 VDD VSS sg13g2_decap_8
XFILLER_63_377 VDD VSS sg13g2_decap_8
X_13877__2395 _13877_/RESET_B VDD VSS sg13g2_tiehi
XFILLER_91_697 VDD VSS sg13g2_decap_8
XFILLER_17_794 VDD VSS sg13g2_fill_1
X_14778_ _14778_/Q clkload67/A _14778_/D _14778_/RESET_B VDD VSS sg13g2_dfrbpq_1
XFILLER_182_1052 VDD VSS sg13g2_decap_4
XFILLER_177_714 VDD VSS sg13g2_decap_8
X_13729_ _13729_/Q clkload37/A _13729_/D _13729_/RESET_B VDD VSS sg13g2_dfrbpq_1
XFILLER_32_753 VDD VSS sg13g2_decap_8
XFILLER_182_1074 VDD VSS sg13g2_decap_8
XFILLER_176_224 VDD VSS sg13g2_decap_8
XFILLER_34_1353 VDD VSS sg13g2_decap_4
XFILLER_31_296 VDD VSS sg13g2_decap_8
XFILLER_121_1323 VDD VSS sg13g2_fill_2
XFILLER_121_1356 VDD VSS sg13g2_decap_8
XFILLER_144_110 VDD VSS sg13g2_decap_8
X_15214__3075 _15214_/RESET_B VDD VSS sg13g2_tiehi
XFILLER_69_0 VDD VSS sg13g2_decap_8
XFILLER_173_953 VDD VSS sg13g2_decap_8
XFILLER_144_154 VDD VSS sg13g2_decap_8
XFILLER_173_986 VDD VSS sg13g2_decap_8
XFILLER_117_379 VDD VSS sg13g2_decap_8
XFILLER_133_828 VDD VSS sg13g2_decap_8
XFILLER_67_1140 VDD VSS sg13g2_decap_8
XFILLER_126_891 VDD VSS sg13g2_decap_8
XFILLER_28_1102 VDD VSS sg13g2_decap_8
XFILLER_132_338 VDD VSS sg13g2_decap_8
XFILLER_160_647 VDD VSS sg13g2_decap_4
XFILLER_132_349 VDD VSS sg13g2_fill_2
XFILLER_99_742 VDD VSS sg13g2_decap_8
XFILLER_154_1121 VDD VSS sg13g2_decap_4
XFILLER_119_1252 VDD VSS sg13g2_decap_8
Xfanout405 _09265_/S _09267_/S VDD VSS sg13g2_buf_1
XFILLER_87_904 VDD VSS sg13g2_decap_8
XFILLER_119_1263 VDD VSS sg13g2_fill_2
XFILLER_59_606 VDD VSS sg13g2_decap_8
XFILLER_115_1105 VDD VSS sg13g2_fill_1
Xfanout427 _09946_/A1 _09007_/X VDD VSS sg13g2_buf_1
X_09822_ _14410_/D _09921_/A1 _14410_/Q _09826_/S VDD VSS sg13g2_mux2_1
XFILLER_8_1218 VDD VSS sg13g2_decap_8
Xfanout438 fanout438/X wire439/X VDD VSS sg13g2_buf_1
XFILLER_99_797 VDD VSS sg13g2_fill_1
Xfanout449 _12763_/B2 _12791_/B2 VDD VSS sg13g2_buf_1
XFILLER_28_1179 VDD VSS sg13g2_decap_8
XFILLER_101_736 VDD VSS sg13g2_decap_8
XFILLER_80_1351 VDD VSS sg13g2_decap_8
X_09753_ _14343_/D _14343_/Q _09885_/A0 _09771_/S VDD VSS sg13g2_mux2_1
XFILLER_80_1362 VDD VSS sg13g2_fill_2
XFILLER_104_14 VDD VSS sg13g2_decap_8
XFILLER_74_609 VDD VSS sg13g2_decap_8
XFILLER_67_650 VDD VSS sg13g2_decap_8
XFILLER_132_1463 VDD VSS sg13g2_decap_8
X_08704_ _13657_/D _15184_/D _15115_/Q _13652_/S VDD VSS sg13g2_mux2_1
XFILLER_132_1474 VDD VSS sg13g2_fill_1
X_09684_ _14276_/D _09882_/A0 _14276_/Q _09705_/S VDD VSS sg13g2_mux2_1
XFILLER_95_992 VDD VSS sg13g2_decap_8
XFILLER_66_160 VDD VSS sg13g2_decap_8
XFILLER_54_311 VDD VSS sg13g2_decap_8
XFILLER_82_631 VDD VSS sg13g2_fill_1
X_08635_ _08635_/X _12203_/A _07965_/B _07853_/B _07859_/B _08635_/S0 _08635_/S1 VDD
+ VSS sg13g2_mux4_1
XFILLER_27_547 VDD VSS sg13g2_decap_8
XFILLER_81_130 VDD VSS sg13g2_decap_8
XFILLER_54_355 VDD VSS sg13g2_fill_1
XFILLER_70_815 VDD VSS sg13g2_decap_8
XFILLER_82_686 VDD VSS sg13g2_fill_2
XFILLER_54_377 VDD VSS sg13g2_decap_8
X_08566_ _08574_/D _08567_/A _08567_/B _08566_/C VDD VSS sg13g2_nor3_1
X_13707__2565 _13707_/RESET_B VDD VSS sg13g2_tiehi
XFILLER_78_1291 VDD VSS sg13g2_decap_8
XFILLER_120_46 VDD VSS sg13g2_decap_8
XFILLER_165_1250 VDD VSS sg13g2_decap_8
XFILLER_161_1103 VDD VSS sg13g2_fill_2
XFILLER_165_1283 VDD VSS sg13g2_fill_2
X_08497_ _08497_/Y _08497_/A _08497_/B VDD VSS sg13g2_nand2_1
XFILLER_23_764 VDD VSS sg13g2_fill_2
XFILLER_120_79 VDD VSS sg13g2_decap_8
XFILLER_147_7 VDD VSS sg13g2_decap_8
XFILLER_22_252 VDD VSS sg13g2_decap_8
XFILLER_161_1136 VDD VSS sg13g2_decap_8
XFILLER_23_797 VDD VSS sg13g2_fill_1
XFILLER_168_769 VDD VSS sg13g2_decap_8
XFILLER_11_959 VDD VSS sg13g2_decap_8
XFILLER_149_961 VDD VSS sg13g2_decap_8
XFILLER_129_11 VDD VSS sg13g2_fill_1
XFILLER_10_469 VDD VSS sg13g2_decap_8
XFILLER_13_77 VDD VSS sg13g2_decap_8
XFILLER_164_920 VDD VSS sg13g2_fill_2
X_13922__2350 _13922_/RESET_B VDD VSS sg13g2_tiehi
XFILLER_182_238 VDD VSS sg13g2_decap_8
X_14682__1590 _14682_/RESET_B VDD VSS sg13g2_tiehi
X_09118_ _09118_/Y _09162_/A _10762_/B _09117_/Y VDD VSS sg13g2_o21ai_1
X_10390_ _10392_/C _10378_/D _10387_/X _14821_/Q VDD VSS sg13g2_a21o_1
XFILLER_163_452 VDD VSS sg13g2_fill_1
XFILLER_108_368 VDD VSS sg13g2_fill_2
X_09049_ _09049_/Y _14908_/Q _09056_/C _09024_/A VDD VSS sg13g2_o21ai_1
XFILLER_135_165 VDD VSS sg13g2_decap_4
XFILLER_2_602 VDD VSS sg13g2_decap_8
XFILLER_11_1183 VDD VSS sg13g2_decap_8
XFILLER_145_21 VDD VSS sg13g2_decap_8
XFILLER_159_1098 VDD VSS sg13g2_fill_2
XFILLER_1_112 VDD VSS sg13g2_decap_8
X_14266__2006 _14266_/RESET_B VDD VSS sg13g2_tiehi
X_12060_ _12060_/Y _12062_/A _12062_/B VDD VSS sg13g2_nand2_1
XFILLER_137_1330 VDD VSS sg13g2_decap_8
XFILLER_137_1341 VDD VSS sg13g2_fill_1
XFILLER_81_1115 VDD VSS sg13g2_decap_4
XFILLER_172_1243 VDD VSS sg13g2_decap_8
X_11011_ _11011_/Y _11012_/B _11012_/C VDD VSS sg13g2_nor2_1
XFILLER_89_252 VDD VSS sg13g2_decap_8
XFILLER_78_926 VDD VSS sg13g2_decap_8
XFILLER_2_679 VDD VSS sg13g2_decap_8
XFILLER_132_894 VDD VSS sg13g2_fill_2
XFILLER_1_189 VDD VSS sg13g2_decap_8
Xfanout950 _12710_/S0 fanout953/X VDD VSS sg13g2_buf_1
Xfanout961 _12773_/S0 fanout966/X VDD VSS sg13g2_buf_1
Xfanout972 _13293_/D _13312_/A VDD VSS sg13g2_buf_1
Xfanout983 _13271_/C _15207_/Q VDD VSS sg13g2_buf_1
Xfanout994 _12997_/B _13601_/B VDD VSS sg13g2_buf_1
XFILLER_38_63 VDD VSS sg13g2_decap_8
XFILLER_161_42 VDD VSS sg13g2_decap_8
XFILLER_79_1000 VDD VSS sg13g2_fill_1
XFILLER_64_108 VDD VSS sg13g2_fill_1
XFILLER_58_672 VDD VSS sg13g2_decap_8
X_12962_ _12962_/Y _12960_/Y _12962_/B _13308_/A VDD VSS sg13g2_nand3b_1
X_15152__2746 _15152_/RESET_B VDD VSS sg13g2_tiehi
XFILLER_79_1011 VDD VSS sg13g2_decap_8
XFILLER_18_525 VDD VSS sg13g2_decap_8
XFILLER_57_182 VDD VSS sg13g2_decap_8
XFILLER_173_0 VDD VSS sg13g2_decap_8
X_14701_ _14701_/Q _14733_/CLK _14701_/D _14701_/RESET_B VDD VSS sg13g2_dfrbpq_1
X_11913_ _11917_/A _11913_/A _11913_/B VDD VSS sg13g2_nor2_1
XFILLER_161_97 VDD VSS sg13g2_decap_8
XFILLER_73_653 VDD VSS sg13g2_fill_2
XFILLER_166_1014 VDD VSS sg13g2_decap_8
X_12893_ _12925_/B _12894_/A _12894_/B VDD VSS sg13g2_nand2_1
XFILLER_2_1351 VDD VSS sg13g2_decap_8
XFILLER_45_377 VDD VSS sg13g2_decap_8
XFILLER_33_517 VDD VSS sg13g2_decap_4
X_14632_ _14632_/Q _14664_/CLK _14632_/D _14632_/RESET_B VDD VSS sg13g2_dfrbpq_1
X_11844_ _11846_/A _11907_/A _11845_/C _11910_/B VDD VSS sg13g2_o21ai_1
XFILLER_57_1320 VDD VSS sg13g2_decap_8
XFILLER_92_1211 VDD VSS sg13g2_decap_8
XFILLER_14_742 VDD VSS sg13g2_decap_8
XFILLER_18_1304 VDD VSS sg13g2_decap_8
XFILLER_183_1361 VDD VSS sg13g2_decap_8
X_14563_ _14563_/Q _14723_/CLK _14563_/D _14563_/RESET_B VDD VSS sg13g2_dfrbpq_1
XFILLER_144_1323 VDD VSS sg13g2_fill_1
XFILLER_183_1372 VDD VSS sg13g2_fill_2
X_11775_ _11778_/A _11725_/Y _11772_/Y _11774_/Y VDD VSS sg13g2_o21ai_1
XFILLER_13_252 VDD VSS sg13g2_decap_8
XFILLER_105_1307 VDD VSS sg13g2_decap_8
XFILLER_109_1476 VDD VSS sg13g2_fill_2
X_13514_ _15137_/D _15137_/Q _14994_/Q _13519_/B VDD VSS sg13g2_mux2_1
X_10726_ _10995_/A _14940_/Q _10725_/A _10725_/Y VDD VSS sg13g2_a21oi_1
X_14494_ _14494_/Q _14734_/CLK _14494_/D _14494_/RESET_B VDD VSS sg13g2_dfrbpq_1
XFILLER_144_1378 VDD VSS sg13g2_decap_8
XFILLER_9_245 VDD VSS sg13g2_decap_8
XFILLER_146_419 VDD VSS sg13g2_decap_8
XFILLER_174_728 VDD VSS sg13g2_decap_8
XFILLER_186_588 VDD VSS sg13g2_decap_8
X_13445_ _15104_/D _15104_/Q _13470_/A2 _13444_/Y VDD VSS sg13g2_a21o_1
X_10657_ _10666_/D _14891_/Q _10663_/D VDD VSS sg13g2_and2_1
XFILLER_186_599 VDD VSS sg13g2_decap_8
XFILLER_16_1083 VDD VSS sg13g2_decap_8
XFILLER_173_238 VDD VSS sg13g2_decap_8
Xclkload15 clkload15/Y clkload15/A VDD VSS sg13g2_inv_2
X_14512__1760 _14512_/RESET_B VDD VSS sg13g2_tiehi
Xclkload26 clkload26/Y clkload26/A VDD VSS sg13g2_inv_1
X_13376_ _13376_/Y _13401_/C _13401_/B _13396_/C _13378_/C VDD VSS sg13g2_nor4_1
Xclkload37 clkload37/X clkload37/A VDD VSS sg13g2_buf_8
XFILLER_62_7 VDD VSS sg13g2_decap_8
XFILLER_186_83 VDD VSS sg13g2_decap_8
X_10588_ _14873_/D _10649_/B _10594_/D _10587_/Y VDD VSS sg13g2_a21oi_1
XFILLER_6_952 VDD VSS sg13g2_decap_8
XFILLER_155_975 VDD VSS sg13g2_decap_8
XFILLER_182_761 VDD VSS sg13g2_decap_8
Xclkload48 clkload48/Y clkload48/A VDD VSS sg13g2_inv_1
XFILLER_86_1015 VDD VSS sg13g2_decap_8
XFILLER_115_817 VDD VSS sg13g2_fill_2
Xclkload59 clkload59/Y clkload59/A VDD VSS sg13g2_inv_2
Xmax_cap1289 _16869_/A _13707_/Q VDD VSS sg13g2_buf_4
X_15115_ _15115_/Q _15212_/CLK _15115_/D _15115_/RESET_B VDD VSS sg13g2_dfrbpq_1
X_12327_ _12327_/Y _12306_/A _13914_/Q VDD VSS sg13g2_nand2b_1
XFILLER_86_1037 VDD VSS sg13g2_decap_8
XFILLER_5_462 VDD VSS sg13g2_decap_8
XFILLER_142_625 VDD VSS sg13g2_decap_8
XFILLER_170_934 VDD VSS sg13g2_decap_4
XFILLER_177_1165 VDD VSS sg13g2_fill_2
XFILLER_142_636 VDD VSS sg13g2_fill_1
XFILLER_173_1007 VDD VSS sg13g2_decap_8
X_15046_ _15046_/Q clkload54/A _15046_/D _15046_/RESET_B VDD VSS sg13g2_dfrbpq_1
XFILLER_64_1302 VDD VSS sg13g2_decap_8
X_12258_ _12258_/Y _12254_/Y _12255_/Y _12257_/Y _12256_/Y _12239_/B VDD VSS sg13g2_a221oi_1
XFILLER_141_146 VDD VSS sg13g2_fill_1
XFILLER_141_157 VDD VSS sg13g2_decap_8
XFILLER_29_1444 VDD VSS sg13g2_decap_8
XFILLER_116_1403 VDD VSS sg13g2_decap_8
XFILLER_141_168 VDD VSS sg13g2_fill_2
X_11209_ _14956_/D _11209_/A _11209_/B VDD VSS sg13g2_nand2_1
XFILLER_96_712 VDD VSS sg13g2_decap_8
XFILLER_110_500 VDD VSS sg13g2_decap_4
XFILLER_68_414 VDD VSS sg13g2_decap_8
XFILLER_25_1308 VDD VSS sg13g2_decap_8
X_12189_ _12190_/A _14710_/Q _14742_/Q _13782_/Q _13814_/Q _12245_/S0 _12245_/S1 VDD
+ VSS sg13g2_mux4_1
XFILLER_151_1327 VDD VSS sg13g2_fill_2
XFILLER_151_1349 VDD VSS sg13g2_decap_8
XFILLER_114_1160 VDD VSS sg13g2_decap_8
XFILLER_95_80 VDD VSS sg13g2_decap_8
XFILLER_83_428 VDD VSS sg13g2_decap_8
XFILLER_110_599 VDD VSS sg13g2_decap_8
XFILLER_7_1295 VDD VSS sg13g2_decap_8
XFILLER_95_299 VDD VSS sg13g2_decap_8
XFILLER_83_439 VDD VSS sg13g2_decap_8
XFILLER_49_694 VDD VSS sg13g2_fill_1
X_13964__2308 _13964_/RESET_B VDD VSS sg13g2_tiehi
XFILLER_3_1148 VDD VSS sg13g2_decap_8
XFILLER_64_642 VDD VSS sg13g2_decap_8
XFILLER_37_867 VDD VSS sg13g2_decap_8
XFILLER_36_333 VDD VSS sg13g2_decap_8
XFILLER_97_1155 VDD VSS sg13g2_decap_8
XFILLER_63_130 VDD VSS sg13g2_fill_1
XFILLER_52_815 VDD VSS sg13g2_fill_2
XFILLER_40_1390 VDD VSS sg13g2_decap_8
X_08420_ _08575_/C _08420_/A _08419_/A VDD VSS sg13g2_nor2b_1
XFILLER_63_163 VDD VSS sg13g2_decap_8
XFILLER_52_837 VDD VSS sg13g2_decap_8
XFILLER_75_1442 VDD VSS sg13g2_decap_8
X_14749__1521 _14749_/RESET_B VDD VSS sg13g2_tiehi
X_08351_ _08352_/B _08879_/A1 _08351_/B VDD VSS sg13g2_nand2b_1
XFILLER_177_511 VDD VSS sg13g2_decap_8
XFILLER_32_550 VDD VSS sg13g2_fill_1
XFILLER_32_572 VDD VSS sg13g2_decap_8
XFILLER_149_235 VDD VSS sg13g2_decap_8
X_08282_ _08282_/Y _08452_/A _08234_/Y _08452_/C _08280_/X VDD VSS sg13g2_a22oi_1
Xclkload9 clkload9/Y clkload9/A VDD VSS sg13g2_inv_1
XFILLER_20_756 VDD VSS sg13g2_decap_8
XFILLER_177_588 VDD VSS sg13g2_decap_8
XFILLER_69_1202 VDD VSS sg13g2_decap_8
XFILLER_118_677 VDD VSS sg13g2_fill_2
XFILLER_121_1186 VDD VSS sg13g2_decap_8
XFILLER_173_772 VDD VSS sg13g2_fill_1
XFILLER_12_1470 VDD VSS sg13g2_decap_8
XFILLER_145_474 VDD VSS sg13g2_decap_8
XFILLER_105_316 VDD VSS sg13g2_decap_8
XFILLER_173_794 VDD VSS sg13g2_decap_8
XFILLER_172_282 VDD VSS sg13g2_decap_8
XFILLER_161_967 VDD VSS sg13g2_decap_8
XFILLER_121_809 VDD VSS sg13g2_decap_8
XFILLER_132_146 VDD VSS sg13g2_decap_8
XFILLER_133_669 VDD VSS sg13g2_fill_2
XFILLER_114_850 VDD VSS sg13g2_fill_1
XFILLER_87_701 VDD VSS sg13g2_fill_1
Xfanout202 _10159_/A1 _09828_/A0 VDD VSS sg13g2_buf_1
Xfanout213 _10156_/A1 _09759_/A1 VDD VSS sg13g2_buf_1
XFILLER_8_1015 VDD VSS sg13g2_decap_8
Xfanout224 _10122_/A0 _10155_/A1 VDD VSS sg13g2_buf_1
XFILLER_114_894 VDD VSS sg13g2_decap_8
Xfanout235 _09921_/A1 fanout237/X VDD VSS sg13g2_buf_1
XFILLER_119_1093 VDD VSS sg13g2_fill_2
X_15174__2972 _15174_/RESET_B VDD VSS sg13g2_tiehi
XFILLER_86_222 VDD VSS sg13g2_decap_8
Xfanout257 _12298_/B _11249_/B VDD VSS sg13g2_buf_1
X_09805_ _14394_/D _10169_/A1 _14394_/Q _09805_/S VDD VSS sg13g2_mux2_1
Xfanout268 _10150_/A1 _09037_/X VDD VSS sg13g2_buf_1
Xfanout279 _10069_/S _10037_/Y VDD VSS sg13g2_buf_1
X_07997_ _07997_/Y _15103_/Q _15090_/Q VDD VSS sg13g2_nor2_1
XFILLER_87_778 VDD VSS sg13g2_decap_8
XFILLER_101_566 VDD VSS sg13g2_decap_4
XFILLER_75_28 VDD VSS sg13g2_decap_8
XFILLER_74_406 VDD VSS sg13g2_decap_8
XFILLER_80_1192 VDD VSS sg13g2_decap_8
XFILLER_101_599 VDD VSS sg13g2_fill_1
X_09736_ _14327_/D _09934_/A1 _14327_/Q _09737_/S VDD VSS sg13g2_mux2_1
XFILLER_28_845 VDD VSS sg13g2_decap_8
X_14554__1718 _14554_/RESET_B VDD VSS sg13g2_tiehi
X_09667_ _14260_/D _10163_/A1 _14260_/Q _09673_/S VDD VSS sg13g2_mux2_1
XFILLER_27_355 VDD VSS sg13g2_fill_1
XFILLER_131_45 VDD VSS sg13g2_fill_2
XFILLER_76_1217 VDD VSS sg13g2_fill_2
XFILLER_43_815 VDD VSS sg13g2_decap_4
XFILLER_55_675 VDD VSS sg13g2_decap_8
XFILLER_27_366 VDD VSS sg13g2_decap_8
X_08618_ _08622_/A _08030_/Y _08537_/X _08637_/B VDD VSS sg13g2_o21ai_1
XFILLER_55_686 VDD VSS sg13g2_fill_1
XFILLER_128_1318 VDD VSS sg13g2_decap_8
XFILLER_15_539 VDD VSS sg13g2_decap_8
X_09598_ _14195_/D _14195_/Q _10095_/A0 _09601_/S VDD VSS sg13g2_mux2_1
XFILLER_70_634 VDD VSS sg13g2_decap_8
XFILLER_42_325 VDD VSS sg13g2_decap_8
X_08549_ _08549_/Y _08522_/A _08529_/Y _08548_/Y VDD VSS sg13g2_a21oi_1
XFILLER_24_21 VDD VSS sg13g2_decap_8
XFILLER_70_689 VDD VSS sg13g2_decap_8
X_11560_ _11560_/Y _11540_/Y _11542_/X _11654_/S VDD VSS sg13g2_o21ai_1
XFILLER_126_1075 VDD VSS sg13g2_decap_8
XFILLER_11_756 VDD VSS sg13g2_decap_8
X_10511_ _10512_/C _14850_/Q _14845_/Q _14844_/Q _10511_/D VDD VSS sg13g2_nand4_1
XFILLER_156_728 VDD VSS sg13g2_decap_8
XFILLER_183_525 VDD VSS sg13g2_decap_8
X_11491_ _11491_/X _13730_/Q _14082_/Q _14434_/Q _14530_/Q _11493_/S0 _11493_/S1 VDD
+ VSS sg13g2_mux4_1
XFILLER_10_266 VDD VSS sg13g2_decap_8
XFILLER_155_227 VDD VSS sg13g2_decap_8
X_13230_ _13244_/B _13245_/A _13665_/Q VDD VSS sg13g2_xor2_1
XFILLER_7_749 VDD VSS sg13g2_decap_8
XFILLER_137_953 VDD VSS sg13g2_decap_8
X_10442_ _10444_/A _14837_/Q _10442_/B VDD VSS sg13g2_nand2b_1
XFILLER_87_1302 VDD VSS sg13g2_decap_4
XFILLER_104_1373 VDD VSS sg13g2_decap_8
XFILLER_40_42 VDD VSS sg13g2_decap_8
XFILLER_13_1267 VDD VSS sg13g2_decap_8
XFILLER_6_259 VDD VSS sg13g2_decap_8
XFILLER_152_923 VDD VSS sg13g2_decap_8
XFILLER_156_42 VDD VSS sg13g2_decap_8
X_13161_ _13161_/X input19/X _13161_/A2 _13161_/B1 VDD VSS sg13g2_a21o_1
XFILLER_108_165 VDD VSS sg13g2_decap_8
XFILLER_151_400 VDD VSS sg13g2_decap_8
XFILLER_178_1474 VDD VSS sg13g2_fill_1
X_10373_ _10375_/A _14815_/Q _10378_/D _14816_/Q VDD VSS sg13g2_a21o_1
XFILLER_151_433 VDD VSS sg13g2_decap_8
X_12112_ _12112_/Y _12090_/A _13940_/Q _12166_/B VDD VSS sg13g2_a21oi_1
XFILLER_156_97 VDD VSS sg13g2_fill_2
X_13092_ _13093_/B _13092_/A _13112_/A _13092_/C VDD VSS sg13g2_nand3_1
XFILLER_3_966 VDD VSS sg13g2_decap_8
X_12043_ _12043_/X _12115_/A1 _12042_/X _12041_/Y VDD VSS sg13g2_a21o_1
XFILLER_85_1092 VDD VSS sg13g2_decap_8
XFILLER_46_1043 VDD VSS sg13g2_decap_8
XFILLER_2_476 VDD VSS sg13g2_decap_8
XFILLER_77_211 VDD VSS sg13g2_decap_8
XFILLER_78_756 VDD VSS sg13g2_decap_8
XFILLER_49_84 VDD VSS sg13g2_decap_8
XFILLER_172_63 VDD VSS sg13g2_decap_8
XFILLER_46_1098 VDD VSS sg13g2_decap_8
XFILLER_1_14 VDD VSS sg13g2_decap_8
XFILLER_24_1330 VDD VSS sg13g2_decap_8
Xfanout780 _12233_/B _12184_/B VDD VSS sg13g2_buf_1
Xfanout791 _13412_/C _07653_/Y VDD VSS sg13g2_buf_1
XFILLER_93_726 VDD VSS sg13g2_decap_8
XFILLER_59_981 VDD VSS sg13g2_fill_1
XFILLER_120_897 VDD VSS sg13g2_decap_8
XFILLER_150_1360 VDD VSS sg13g2_decap_4
XFILLER_93_737 VDD VSS sg13g2_fill_2
XFILLER_4_1435 VDD VSS sg13g2_decap_8
X_13994_ _13994_/Q clkload16/A _13994_/D _13994_/RESET_B VDD VSS sg13g2_dfrbpq_1
XFILLER_18_322 VDD VSS sg13g2_decap_8
XFILLER_111_1344 VDD VSS sg13g2_decap_8
XFILLER_74_951 VDD VSS sg13g2_decap_8
XFILLER_19_867 VDD VSS sg13g2_decap_8
XFILLER_20_1238 VDD VSS sg13g2_decap_8
XFILLER_19_878 VDD VSS sg13g2_fill_2
X_12945_ _12945_/Y _12945_/A _12988_/B VDD VSS sg13g2_nor2_1
X_15213__3074 _15213_/RESET_B VDD VSS sg13g2_tiehi
XFILLER_94_1317 VDD VSS sg13g2_decap_8
XFILLER_65_83 VDD VSS sg13g2_decap_8
XFILLER_111_1399 VDD VSS sg13g2_decap_4
XFILLER_179_809 VDD VSS sg13g2_decap_4
XFILLER_18_399 VDD VSS sg13g2_decap_8
XFILLER_45_174 VDD VSS sg13g2_decap_8
XFILLER_185_1467 VDD VSS sg13g2_fill_2
X_12876_ _12878_/B _12876_/A _12877_/C VDD VSS sg13g2_nand2_1
XFILLER_178_308 VDD VSS sg13g2_decap_8
XFILLER_33_347 VDD VSS sg13g2_fill_1
XFILLER_18_1101 VDD VSS sg13g2_decap_8
X_14615_ _14615_/Q clkload47/A _14615_/D _14615_/RESET_B VDD VSS sg13g2_dfrbpq_1
X_11827_ _11827_/Y _11823_/Y _11824_/Y _11826_/Y _11825_/Y _12329_/C1 VDD VSS sg13g2_a221oi_1
XFILLER_144_1120 VDD VSS sg13g2_decap_8
X_15096__2880 _15096_/RESET_B VDD VSS sg13g2_tiehi
XFILLER_57_1183 VDD VSS sg13g2_decap_8
X_14546_ _14546_/Q _14610_/CLK _14546_/D _14546_/RESET_B VDD VSS sg13g2_dfrbpq_1
X_11758_ _11760_/A _11759_/A _13898_/Q VDD VSS sg13g2_nand2b_1
XFILLER_159_555 VDD VSS sg13g2_fill_2
X_15167__2598 _15167_/RESET_B VDD VSS sg13g2_tiehi
XFILLER_109_1284 VDD VSS sg13g2_decap_4
XFILLER_147_717 VDD VSS sg13g2_decap_8
XFILLER_18_1178 VDD VSS sg13g2_decap_8
XFILLER_105_1137 VDD VSS sg13g2_decap_8
XFILLER_147_728 VDD VSS sg13g2_fill_2
X_10709_ _10954_/A _09027_/X _10743_/S _08873_/Y VDD VSS sg13g2_a21oi_1
XFILLER_140_1039 VDD VSS sg13g2_decap_8
X_14477_ _14477_/Q _14726_/CLK _14477_/D _14477_/RESET_B VDD VSS sg13g2_dfrbpq_1
X_11689_ _11689_/X _14120_/Q _14152_/Q _11969_/A VDD VSS sg13g2_mux2_1
XFILLER_31_1312 VDD VSS sg13g2_decap_8
XFILLER_128_931 VDD VSS sg13g2_decap_8
XFILLER_128_942 VDD VSS sg13g2_fill_2
XFILLER_174_547 VDD VSS sg13g2_decap_8
XFILLER_70_1383 VDD VSS sg13g2_decap_4
X_13428_ _15096_/D _13421_/Y _13425_/Y _13427_/Y VDD VSS sg13g2_o21ai_1
XFILLER_70_1394 VDD VSS sg13g2_decap_8
XFILLER_127_452 VDD VSS sg13g2_fill_2
XFILLER_115_614 VDD VSS sg13g2_decap_8
XFILLER_127_474 VDD VSS sg13g2_decap_8
X_13359_ _13438_/D _13396_/B _13396_/A VDD VSS sg13g2_nor2b_1
Xmax_cap936 _12591_/S0 _12585_/S0 VDD VSS sg13g2_buf_4
XFILLER_155_794 VDD VSS sg13g2_decap_8
XFILLER_170_731 VDD VSS sg13g2_decap_8
XFILLER_170_775 VDD VSS sg13g2_decap_4
XFILLER_9_1302 VDD VSS sg13g2_decap_8
X_07920_ _07920_/Y _07918_/Y _07871_/X _07911_/Y VDD VSS sg13g2_a21oi_1
X_15029_ _15029_/Q _15226_/CLK _15029_/D _15029_/RESET_B VDD VSS sg13g2_dfrbpq_1
XFILLER_116_1211 VDD VSS sg13g2_fill_1
XFILLER_64_1154 VDD VSS sg13g2_fill_2
XFILLER_60_1007 VDD VSS sg13g2_decap_8
XFILLER_151_1135 VDD VSS sg13g2_decap_8
X_07851_ _08641_/A _08643_/C _08646_/A VDD VSS sg13g2_nand2_1
XFILLER_60_1018 VDD VSS sg13g2_fill_2
XFILLER_9_1379 VDD VSS sg13g2_decap_8
XFILLER_64_1198 VDD VSS sg13g2_decap_8
XFILLER_111_875 VDD VSS sg13g2_decap_8
XFILLER_151_1157 VDD VSS sg13g2_decap_8
XFILLER_99_1217 VDD VSS sg13g2_decap_4
XFILLER_110_363 VDD VSS sg13g2_fill_1
XFILLER_151_1168 VDD VSS sg13g2_fill_1
XFILLER_96_586 VDD VSS sg13g2_decap_8
XFILLER_99_1239 VDD VSS sg13g2_decap_8
XFILLER_110_385 VDD VSS sg13g2_decap_8
Xinput2 input2/X input2/A VDD VSS sg13g2_buf_1
X_07782_ _07784_/B _07782_/A _15002_/Q VDD VSS sg13g2_and2_1
XFILLER_42_1463 VDD VSS sg13g2_decap_8
XFILLER_42_1474 VDD VSS sg13g2_fill_1
XFILLER_83_236 VDD VSS sg13g2_decap_8
XFILLER_7_1092 VDD VSS sg13g2_decap_8
X_09521_ _14120_/D _09620_/A0 _14120_/Q _09530_/S VDD VSS sg13g2_mux2_1
XFILLER_65_962 VDD VSS sg13g2_decap_4
XFILLER_83_269 VDD VSS sg13g2_fill_2
XFILLER_37_664 VDD VSS sg13g2_decap_8
XFILLER_92_770 VDD VSS sg13g2_decap_8
XFILLER_64_461 VDD VSS sg13g2_decap_4
X_09452_ _14053_/D _09949_/A1 _14053_/Q wire504/X VDD VSS sg13g2_mux2_1
XFILLER_80_921 VDD VSS sg13g2_fill_2
XFILLER_36_185 VDD VSS sg13g2_decap_8
X_08403_ _08410_/D _15100_/Q _15089_/Q _08574_/B VDD VSS sg13g2_o21ai_1
X_09383_ _13986_/D _10045_/A0 _13986_/Q _09396_/S VDD VSS sg13g2_mux2_1
XFILLER_52_667 VDD VSS sg13g2_decap_8
XFILLER_51_144 VDD VSS sg13g2_decap_8
XFILLER_24_358 VDD VSS sg13g2_decap_4
XFILLER_178_842 VDD VSS sg13g2_decap_8
X_08334_ _08335_/D _08381_/A _08333_/Y _08637_/B _08330_/Y VDD VSS sg13g2_a22oi_1
XFILLER_178_853 VDD VSS sg13g2_fill_1
XFILLER_36_1245 VDD VSS sg13g2_decap_8
XFILLER_137_205 VDD VSS sg13g2_fill_1
X_08265_ _08265_/X _08265_/A _08265_/B _08319_/A _08319_/C VDD VSS sg13g2_or4_1
XFILLER_165_525 VDD VSS sg13g2_decap_8
XFILLER_177_385 VDD VSS sg13g2_decap_8
XFILLER_165_547 VDD VSS sg13g2_decap_8
X_08196_ _08196_/Y _08194_/B _08079_/X _08688_/A VDD VSS sg13g2_o21ai_1
XFILLER_10_1407 VDD VSS sg13g2_decap_8
XFILLER_106_603 VDD VSS sg13g2_fill_2
XFILLER_118_474 VDD VSS sg13g2_fill_1
XFILLER_146_783 VDD VSS sg13g2_decap_8
XFILLER_146_794 VDD VSS sg13g2_decap_8
XFILLER_180_539 VDD VSS sg13g2_decap_8
XFILLER_145_271 VDD VSS sg13g2_decap_8
XFILLER_69_1054 VDD VSS sg13g2_decap_8
XFILLER_105_113 VDD VSS sg13g2_decap_8
XFILLER_173_591 VDD VSS sg13g2_decap_8
XFILLER_10_56 VDD VSS sg13g2_decap_8
XFILLER_121_606 VDD VSS sg13g2_decap_4
X_14873__2891 _14873_/RESET_B VDD VSS sg13g2_tiehi
XFILLER_105_157 VDD VSS sg13g2_decap_8
XFILLER_156_1057 VDD VSS sg13g2_decap_8
XFILLER_160_252 VDD VSS sg13g2_decap_8
X_14608__1664 _14608_/RESET_B VDD VSS sg13g2_tiehi
XFILLER_133_477 VDD VSS sg13g2_decap_4
XFILLER_0_925 VDD VSS sg13g2_decap_8
XFILLER_126_56 VDD VSS sg13g2_decap_8
XFILLER_134_1300 VDD VSS sg13g2_decap_8
XFILLER_82_1232 VDD VSS sg13g2_decap_8
XFILLER_121_639 VDD VSS sg13g2_decap_8
XFILLER_133_499 VDD VSS sg13g2_decap_8
Xfanout1008 _13396_/A _10199_/A1 VDD VSS sg13g2_buf_1
XFILLER_114_691 VDD VSS sg13g2_decap_8
Xfanout1019 _12895_/B _07729_/D VDD VSS sg13g2_buf_1
XFILLER_120_138 VDD VSS sg13g2_decap_8
XFILLER_47_1385 VDD VSS sg13g2_decap_8
XFILLER_102_853 VDD VSS sg13g2_fill_2
XFILLER_86_49 VDD VSS sg13g2_decap_4
XFILLER_19_21 VDD VSS sg13g2_decap_8
XFILLER_75_704 VDD VSS sg13g2_decap_8
XFILLER_134_1377 VDD VSS sg13g2_decap_8
XFILLER_169_1407 VDD VSS sg13g2_decap_8
XFILLER_19_119 VDD VSS sg13g2_decap_8
XFILLER_59_288 VDD VSS sg13g2_fill_1
XFILLER_101_385 VDD VSS sg13g2_fill_2
XFILLER_74_236 VDD VSS sg13g2_decap_8
XFILLER_19_98 VDD VSS sg13g2_decap_8
XFILLER_56_951 VDD VSS sg13g2_decap_8
X_09719_ _14310_/D _09719_/A0 _14310_/Q _09731_/S VDD VSS sg13g2_mux2_1
X_10991_ _10992_/B _10979_/Y _10978_/B _10974_/Y VDD VSS sg13g2_o21ai_1
XFILLER_62_409 VDD VSS sg13g2_decap_8
XFILLER_56_984 VDD VSS sg13g2_decap_8
XFILLER_55_461 VDD VSS sg13g2_decap_8
XFILLER_43_601 VDD VSS sg13g2_decap_8
XFILLER_83_781 VDD VSS sg13g2_decap_8
XFILLER_71_921 VDD VSS sg13g2_decap_8
XFILLER_27_163 VDD VSS sg13g2_fill_2
X_12730_ _12730_/X _13846_/Q _13878_/Q _13910_/Q _13942_/Q _12730_/S0 _12730_/S1 VDD
+ VSS sg13g2_mux4_1
XFILLER_71_932 VDD VSS sg13g2_fill_1
XFILLER_128_1115 VDD VSS sg13g2_decap_8
XFILLER_15_336 VDD VSS sg13g2_decap_8
XFILLER_35_42 VDD VSS sg13g2_decap_8
X_12661_ _12661_/X _14257_/Q _14289_/Q _14321_/Q _14353_/Q _12661_/S0 _12661_/S1 VDD
+ VSS sg13g2_mux4_1
XFILLER_31_818 VDD VSS sg13g2_decap_8
XFILLER_42_166 VDD VSS sg13g2_fill_1
X_14400_ _14400_/Q clkload40/A _14400_/D _14400_/RESET_B VDD VSS sg13g2_dfrbpq_1
X_11612_ _11612_/Y _11597_/A _14502_/Q _11802_/B VDD VSS sg13g2_a21oi_1
XFILLER_24_881 VDD VSS sg13g2_fill_1
X_12592_ _12592_/X _14700_/Q _14732_/Q _13772_/Q _13804_/Q _12783_/S0 _12783_/S1 VDD
+ VSS sg13g2_mux4_1
XFILLER_54_1345 VDD VSS sg13g2_fill_2
XFILLER_169_875 VDD VSS sg13g2_decap_8
XFILLER_50_1209 VDD VSS sg13g2_decap_8
XFILLER_11_553 VDD VSS sg13g2_decap_8
XFILLER_136_0 VDD VSS sg13g2_fill_2
X_14331_ _14331_/Q clkload58/A _14331_/D _14331_/RESET_B VDD VSS sg13g2_dfrbpq_1
X_11543_ _11543_/Y _12238_/S0 _14372_/Q VDD VSS sg13g2_nand2b_1
XFILLER_54_1389 VDD VSS sg13g2_fill_1
XFILLER_156_525 VDD VSS sg13g2_decap_8
Xwire422 wire422/X wire422/A VDD VSS sg13g2_buf_2
XFILLER_141_1359 VDD VSS sg13g2_decap_8
XFILLER_168_396 VDD VSS sg13g2_fill_1
XFILLER_183_322 VDD VSS sg13g2_decap_8
XFILLER_89_1419 VDD VSS sg13g2_decap_8
X_14262_ _14262_/Q _14518_/CLK _14262_/D _14262_/RESET_B VDD VSS sg13g2_dfrbpq_1
XFILLER_7_546 VDD VSS sg13g2_decap_8
X_11474_ _11475_/B _11471_/X _11470_/X _11467_/X _11466_/X _11494_/S0 _11498_/A1 VDD
+ VSS sg13g2_mux4_1
XFILLER_167_63 VDD VSS sg13g2_decap_8
XFILLER_13_1064 VDD VSS sg13g2_decap_8
X_13213_ _13215_/A _14921_/Q _13666_/Q VDD VSS sg13g2_xor2_1
X_10425_ _10538_/A _10647_/A _10647_/D VDD VSS sg13g2_nand2_1
XFILLER_136_260 VDD VSS sg13g2_decap_8
XFILLER_183_399 VDD VSS sg13g2_decap_8
X_14193_ _14193_/Q clkload6/A _14193_/D _14193_/RESET_B VDD VSS sg13g2_dfrbpq_1
XFILLER_109_485 VDD VSS sg13g2_decap_8
XFILLER_152_720 VDD VSS sg13g2_decap_8
X_15050__2618 _15050_/RESET_B VDD VSS sg13g2_tiehi
XFILLER_124_422 VDD VSS sg13g2_decap_8
XFILLER_125_945 VDD VSS sg13g2_decap_4
XFILLER_48_1105 VDD VSS sg13g2_fill_1
XFILLER_174_1124 VDD VSS sg13g2_decap_8
X_13144_ _13145_/A _13146_/A _13146_/C VDD VSS sg13g2_nand2_1
X_10356_ _10364_/C wire220/X _10397_/B _10395_/A VDD VSS sg13g2_nor3_1
XFILLER_100_1089 VDD VSS sg13g2_decap_8
XFILLER_83_1029 VDD VSS sg13g2_decap_4
XFILLER_125_989 VDD VSS sg13g2_decap_4
XFILLER_140_915 VDD VSS sg13g2_fill_1
XFILLER_87_1198 VDD VSS sg13g2_fill_1
XFILLER_3_763 VDD VSS sg13g2_decap_8
XFILLER_140_948 VDD VSS sg13g2_decap_8
X_13075_ _13172_/B _14911_/Q _13676_/Q VDD VSS sg13g2_xor2_1
XFILLER_152_1411 VDD VSS sg13g2_decap_8
X_10287_ _10298_/D _14788_/Q _14789_/Q _14790_/Q _10305_/B VDD VSS sg13g2_and4_1
XFILLER_97_339 VDD VSS sg13g2_decap_8
XFILLER_2_273 VDD VSS sg13g2_decap_8
XFILLER_183_84 VDD VSS sg13g2_decap_8
XFILLER_26_1425 VDD VSS sg13g2_decap_8
XFILLER_78_531 VDD VSS sg13g2_decap_4
X_12026_ _12027_/B _12026_/A _12026_/B _12026_/C VDD VSS sg13g2_nand3_1
XFILLER_39_907 VDD VSS sg13g2_decap_8
XFILLER_113_1406 VDD VSS sg13g2_decap_8
XFILLER_66_704 VDD VSS sg13g2_decap_8
XFILLER_25_7 VDD VSS sg13g2_decap_8
XFILLER_152_1466 VDD VSS sg13g2_decap_8
X_13702__2570 _13702_/RESET_B VDD VSS sg13g2_tiehi
XFILLER_93_523 VDD VSS sg13g2_decap_8
XFILLER_19_620 VDD VSS sg13g2_decap_8
XFILLER_4_1232 VDD VSS sg13g2_decap_8
XFILLER_19_631 VDD VSS sg13g2_fill_1
XFILLER_0_1107 VDD VSS sg13g2_decap_8
XFILLER_19_664 VDD VSS sg13g2_decap_8
X_13977_ _13977_/Q clkload34/A _13977_/D _13977_/RESET_B VDD VSS sg13g2_dfrbpq_1
XFILLER_19_675 VDD VSS sg13g2_fill_2
XFILLER_20_1057 VDD VSS sg13g2_decap_4
XFILLER_47_995 VDD VSS sg13g2_fill_1
XFILLER_34_612 VDD VSS sg13g2_decap_8
X_14046__2226 _14046_/RESET_B VDD VSS sg13g2_tiehi
X_12928_ _12928_/X _12988_/A _12928_/B VDD VSS sg13g2_xor2_1
XFILLER_185_1253 VDD VSS sg13g2_fill_1
XFILLER_61_420 VDD VSS sg13g2_decap_8
XFILLER_59_1256 VDD VSS sg13g2_decap_8
XFILLER_146_1215 VDD VSS sg13g2_decap_8
XFILLER_18_196 VDD VSS sg13g2_decap_8
XFILLER_146_1226 VDD VSS sg13g2_fill_2
XFILLER_59_1278 VDD VSS sg13g2_decap_4
XFILLER_33_133 VDD VSS sg13g2_decap_8
XFILLER_178_105 VDD VSS sg13g2_decap_8
XFILLER_22_818 VDD VSS sg13g2_decap_8
X_12859_ _12861_/B _12859_/A _13689_/Q VDD VSS sg13g2_xnor2_1
XFILLER_22_829 VDD VSS sg13g2_fill_2
XFILLER_15_870 VDD VSS sg13g2_decap_8
XFILLER_175_812 VDD VSS sg13g2_fill_2
XFILLER_72_1478 VDD VSS sg13g2_fill_1
X_14529_ _14529_/Q clkload37/A _14529_/D _14529_/RESET_B VDD VSS sg13g2_dfrbpq_1
X_14261__2011 _14261_/RESET_B VDD VSS sg13g2_tiehi
XFILLER_30_873 VDD VSS sg13g2_decap_8
XFILLER_147_558 VDD VSS sg13g2_decap_8
X_08050_ _08242_/A _15102_/Q _15094_/Q _08048_/B VDD VSS sg13g2_o21ai_1
XFILLER_128_750 VDD VSS sg13g2_fill_1
XFILLER_147_569 VDD VSS sg13g2_fill_2
XFILLER_174_366 VDD VSS sg13g2_decap_8
XFILLER_128_783 VDD VSS sg13g2_decap_8
XFILLER_116_956 VDD VSS sg13g2_decap_8
XFILLER_51_0 VDD VSS sg13g2_decap_8
XFILLER_116_967 VDD VSS sg13g2_fill_2
XFILLER_115_444 VDD VSS sg13g2_decap_8
XFILLER_66_1227 VDD VSS sg13g2_decap_8
XFILLER_115_455 VDD VSS sg13g2_fill_2
XFILLER_143_764 VDD VSS sg13g2_decap_8
XFILLER_66_1249 VDD VSS sg13g2_decap_8
XFILLER_131_926 VDD VSS sg13g2_decap_8
X_14999__2681 _14999_/RESET_B VDD VSS sg13g2_tiehi
Xhold3116 hold3116/X input33/X VDD VSS sg13g2_dlygate4sd3_1
XFILLER_157_1388 VDD VSS sg13g2_decap_8
Xhold3127 hold3127/X input7/X VDD VSS sg13g2_dlygate4sd3_1
XFILLER_88_328 VDD VSS sg13g2_decap_8
XFILLER_170_594 VDD VSS sg13g2_decap_8
Xhold3138 input30/A mem_axi_rdata[4] VDD VSS sg13g2_dlygate4sd3_1
X_08952_ _08952_/Y _13608_/A1 _08835_/B _16883_/A VDD VSS sg13g2_a21oi_1
Xhold3149 input10/A mem_axi_rdata[15] VDD VSS sg13g2_dlygate4sd3_1
XFILLER_97_840 VDD VSS sg13g2_decap_8
X_07903_ _08402_/B _08063_/A _07903_/B VDD VSS sg13g2_nand2_1
X_08883_ _13704_/D _16866_/A _08882_/X _08941_/S VDD VSS sg13g2_mux2_1
XFILLER_9_1176 VDD VSS sg13g2_decap_8
XFILLER_111_661 VDD VSS sg13g2_decap_4
XFILLER_96_361 VDD VSS sg13g2_decap_8
XFILLER_69_575 VDD VSS sg13g2_decap_8
XFILLER_29_406 VDD VSS sg13g2_decap_8
X_07834_ _07974_/D _07834_/A _07834_/B VDD VSS sg13g2_nor2_1
XFILLER_5_1029 VDD VSS sg13g2_decap_8
XFILLER_99_1025 VDD VSS sg13g2_fill_1
XFILLER_110_182 VDD VSS sg13g2_fill_1
XFILLER_84_545 VDD VSS sg13g2_decap_8
XFILLER_42_1271 VDD VSS sg13g2_decap_4
X_07765_ _15215_/D _15099_/Q _15088_/Q _15076_/Q VDD VSS sg13g2_or3_1
XFILLER_84_578 VDD VSS sg13g2_decap_8
XFILLER_84_589 VDD VSS sg13g2_fill_2
XFILLER_77_1323 VDD VSS sg13g2_decap_4
X_09504_ _14104_/D _10067_/A0 _14104_/Q _09505_/S VDD VSS sg13g2_mux2_1
X_07696_ _15203_/D _07696_/A _07696_/B _07696_/C VDD VSS sg13g2_nand3_1
XFILLER_64_280 VDD VSS sg13g2_decap_4
X_14471__1801 _14471_/RESET_B VDD VSS sg13g2_tiehi
XFILLER_53_965 VDD VSS sg13g2_decap_4
X_09435_ _14037_/D _09998_/A0 _14037_/Q _09439_/S VDD VSS sg13g2_mux2_1
XFILLER_80_751 VDD VSS sg13g2_decap_8
XFILLER_169_105 VDD VSS sg13g2_decap_8
XFILLER_25_667 VDD VSS sg13g2_decap_8
XFILLER_40_626 VDD VSS sg13g2_decap_8
X_09366_ _13970_/D _09597_/A1 _13970_/Q _09366_/S VDD VSS sg13g2_mux2_1
XFILLER_75_1080 VDD VSS sg13g2_decap_8
XFILLER_185_609 VDD VSS sg13g2_decap_8
X_08317_ _08418_/A _08315_/Y _08318_/D _08316_/Y VDD VSS sg13g2_a21oi_1
XFILLER_166_823 VDD VSS sg13g2_fill_1
XFILLER_178_683 VDD VSS sg13g2_decap_8
XFILLER_184_119 VDD VSS sg13g2_decap_8
XFILLER_165_311 VDD VSS sg13g2_decap_4
X_09297_ _13905_/D _13905_/Q _09730_/A0 _09298_/S VDD VSS sg13g2_mux2_1
XFILLER_123_1045 VDD VSS sg13g2_decap_4
XFILLER_20_350 VDD VSS sg13g2_decap_8
XFILLER_36_1097 VDD VSS sg13g2_fill_1
XFILLER_177_182 VDD VSS sg13g2_decap_8
XFILLER_166_867 VDD VSS sg13g2_fill_1
X_13744__2528 _13744_/RESET_B VDD VSS sg13g2_tiehi
X_08248_ _08248_/Y _08248_/A _08319_/A _08319_/C VDD VSS sg13g2_nor3_1
XFILLER_14_1351 VDD VSS sg13g2_decap_8
XFILLER_10_1204 VDD VSS sg13g2_decap_8
XFILLER_107_912 VDD VSS sg13g2_decap_4
XFILLER_107_923 VDD VSS sg13g2_decap_8
XFILLER_140_1392 VDD VSS sg13g2_decap_8
X_08179_ _08179_/Y _08402_/C _08066_/Y _08178_/Y VDD VSS sg13g2_o21ai_1
XFILLER_180_336 VDD VSS sg13g2_decap_8
XFILLER_21_77 VDD VSS sg13g2_decap_8
X_15212__3073 _15212_/RESET_B VDD VSS sg13g2_tiehi
XFILLER_106_422 VDD VSS sg13g2_fill_2
XFILLER_134_731 VDD VSS sg13g2_decap_8
X_10210_ _10210_/Y _13316_/B _14749_/Q input1/X _10210_/D VDD VSS sg13g2_nand4_1
XFILLER_107_967 VDD VSS sg13g2_decap_8
XFILLER_175_1433 VDD VSS sg13g2_decap_8
X_11190_ _11205_/B _11190_/A _11199_/B _11190_/C VDD VSS sg13g2_nor3_1
XFILLER_84_1338 VDD VSS sg13g2_fill_1
Xclkbuf_leaf_130_clk_i _14733_/CLK clkload0/A VDD VSS sg13g2_buf_8
XFILLER_0_700 VDD VSS sg13g2_decap_8
XFILLER_122_926 VDD VSS sg13g2_decap_4
XFILLER_121_414 VDD VSS sg13g2_decap_4
X_14124__2148 _14124_/RESET_B VDD VSS sg13g2_tiehi
X_10141_ _14718_/D _14718_/Q _10141_/A1 _10169_/S VDD VSS sg13g2_mux2_1
XFILLER_122_959 VDD VSS sg13g2_decap_8
XFILLER_153_21 VDD VSS sg13g2_fill_2
X_10072_ _14652_/D _10072_/A0 _14652_/Q _10096_/S VDD VSS sg13g2_mux2_1
XFILLER_88_862 VDD VSS sg13g2_decap_8
XFILLER_82_1073 VDD VSS sg13g2_decap_8
XFILLER_94_309 VDD VSS sg13g2_decap_8
XFILLER_0_799 VDD VSS sg13g2_decap_8
X_13900_ _13900_/Q _14540_/CLK _13900_/D _13900_/RESET_B VDD VSS sg13g2_dfrbpq_1
XFILLER_134_1185 VDD VSS sg13g2_decap_8
XFILLER_153_87 VDD VSS sg13g2_decap_8
XFILLER_47_214 VDD VSS sg13g2_decap_8
X_14880_ _14880_/Q clkload61/A _14880_/D _14880_/RESET_B VDD VSS sg13g2_dfrbpq_1
XFILLER_48_759 VDD VSS sg13g2_decap_8
XFILLER_78_1109 VDD VSS sg13g2_decap_8
XFILLER_21_1333 VDD VSS sg13g2_decap_8
X_13831_ _13831_/Q _14741_/CLK _13831_/D _13831_/RESET_B VDD VSS sg13g2_dfrbpq_1
XFILLER_60_1393 VDD VSS sg13g2_decap_8
XFILLER_75_589 VDD VSS sg13g2_fill_2
XFILLER_169_1259 VDD VSS sg13g2_decap_4
XFILLER_16_623 VDD VSS sg13g2_decap_8
XFILLER_1_1449 VDD VSS sg13g2_decap_8
X_13762_ _13762_/Q clkload44/A _13762_/D _13762_/RESET_B VDD VSS sg13g2_dfrbpq_1
X_10974_ _10974_/Y _10995_/A _15115_/Q VDD VSS sg13g2_nand2b_1
XFILLER_90_559 VDD VSS sg13g2_decap_4
XFILLER_15_133 VDD VSS sg13g2_decap_8
X_12713_ _12713_/X _13749_/Q _14101_/Q _14453_/Q _14549_/Q _12715_/S0 _12715_/S1 VDD
+ VSS sg13g2_mux4_1
XFILLER_95_1478 VDD VSS sg13g2_fill_1
X_13693_ _16855_/A clkload91/A _13693_/D _13693_/RESET_B VDD VSS sg13g2_dfrbpq_1
XFILLER_31_615 VDD VSS sg13g2_decap_8
XFILLER_71_784 VDD VSS sg13g2_decap_8
XFILLER_70_261 VDD VSS sg13g2_decap_4
XFILLER_43_475 VDD VSS sg13g2_decap_8
XFILLER_182_1459 VDD VSS sg13g2_decap_8
X_12644_ _12644_/X _14576_/Q _14608_/Q _14640_/Q _14672_/Q _12644_/S0 _12659_/S1 VDD
+ VSS sg13g2_mux4_1
XFILLER_12_840 VDD VSS sg13g2_decap_8
XFILLER_157_801 VDD VSS sg13g2_decap_8
XFILLER_19_1273 VDD VSS sg13g2_decap_8
XFILLER_141_1112 VDD VSS sg13g2_decap_8
XFILLER_175_119 VDD VSS sg13g2_decap_8
XFILLER_169_694 VDD VSS sg13g2_decap_8
X_12575_ _12575_/X _13835_/Q _13867_/Q _13899_/Q _13931_/Q _12659_/S0 _12659_/S1 VDD
+ VSS sg13g2_mux4_1
XFILLER_11_350 VDD VSS sg13g2_decap_8
XFILLER_157_845 VDD VSS sg13g2_decap_8
XFILLER_15_1137 VDD VSS sg13g2_decap_8
XFILLER_50_1017 VDD VSS sg13g2_fill_2
XFILLER_141_1145 VDD VSS sg13g2_fill_1
XFILLER_178_84 VDD VSS sg13g2_decap_8
XFILLER_180_1194 VDD VSS sg13g2_fill_1
XFILLER_8_833 VDD VSS sg13g2_decap_8
XFILLER_156_333 VDD VSS sg13g2_decap_8
X_14314_ _14314_/Q clkload16/A _14314_/D _14314_/RESET_B VDD VSS sg13g2_dfrbpq_1
XFILLER_7_35 VDD VSS sg13g2_decap_8
XFILLER_32_1440 VDD VSS sg13g2_decap_8
X_11526_ _11636_/B _11526_/A _12942_/B VDD VSS sg13g2_xor2_1
X_14334__1938 _14334_/RESET_B VDD VSS sg13g2_tiehi
XFILLER_7_343 VDD VSS sg13g2_decap_8
XFILLER_184_675 VDD VSS sg13g2_decap_8
XFILLER_116_219 VDD VSS sg13g2_fill_1
XFILLER_144_528 VDD VSS sg13g2_decap_8
XFILLER_171_314 VDD VSS sg13g2_decap_8
XFILLER_176_1208 VDD VSS sg13g2_fill_1
Xwire274 wire274/X wire274/A VDD VSS sg13g2_buf_2
X_14245_ _14245_/Q clkload8/A _14245_/D _14245_/RESET_B VDD VSS sg13g2_dfrbpq_1
X_11457_ _11457_/Y _11457_/A _11457_/B _11457_/C VDD VSS sg13g2_nand3_1
XFILLER_137_580 VDD VSS sg13g2_decap_8
XFILLER_172_859 VDD VSS sg13g2_decap_8
XFILLER_183_196 VDD VSS sg13g2_decap_8
XFILLER_109_293 VDD VSS sg13g2_decap_8
X_10408_ _10408_/Y _14825_/Q _10406_/A _10611_/B VDD VSS sg13g2_o21ai_1
XFILLER_171_369 VDD VSS sg13g2_decap_8
X_14176_ _14176_/Q clkload46/A _14176_/D _14176_/RESET_B VDD VSS sg13g2_dfrbpq_1
X_11388_ _11388_/Y _11804_/A _13823_/Q VDD VSS sg13g2_nand2b_1
XFILLER_139_1063 VDD VSS sg13g2_decap_8
XFILLER_125_797 VDD VSS sg13g2_decap_8
XFILLER_3_560 VDD VSS sg13g2_decap_8
X_13127_ _15041_/D _13127_/A _13127_/B VDD VSS sg13g2_nor2_1
X_10339_ _10357_/D _10345_/C _10345_/D VDD VSS sg13g2_and2_1
X_15176__2964 _15176_/RESET_B VDD VSS sg13g2_tiehi
XFILLER_97_136 VDD VSS sg13g2_decap_8
XFILLER_26_1222 VDD VSS sg13g2_decap_8
X_13058_ _13058_/Y _13058_/A _13058_/B _13058_/C _13058_/D VDD VSS sg13g2_nand4_1
XFILLER_65_1282 VDD VSS sg13g2_decap_8
XFILLER_152_1241 VDD VSS sg13g2_fill_2
XFILLER_6_1316 VDD VSS sg13g2_decap_8
XFILLER_152_1252 VDD VSS sg13g2_fill_2
XFILLER_94_810 VDD VSS sg13g2_decap_8
Xfanout1350 fanout1350/X _13658_/Q VDD VSS sg13g2_buf_1
X_12009_ _12010_/B _12009_/A _13670_/Q VDD VSS sg13g2_nand2_1
XFILLER_79_895 VDD VSS sg13g2_fill_1
XFILLER_61_1146 VDD VSS sg13g2_decap_8
Xfanout1361 _12091_/C fanout1364/X VDD VSS sg13g2_buf_1
XFILLER_39_748 VDD VSS sg13g2_decap_8
Xfanout1372 _12259_/S1 fanout1381/X VDD VSS sg13g2_buf_1
XFILLER_26_1299 VDD VSS sg13g2_decap_8
Xfanout1383 _12215_/S1 _13658_/Q VDD VSS sg13g2_buf_1
Xfanout1394 _11963_/S0 fanout1395/X VDD VSS sg13g2_buf_1
XFILLER_113_1269 VDD VSS sg13g2_decap_8
XFILLER_66_578 VDD VSS sg13g2_fill_2
XFILLER_47_781 VDD VSS sg13g2_decap_8
XFILLER_19_494 VDD VSS sg13g2_decap_8
XFILLER_146_1001 VDD VSS sg13g2_decap_8
XFILLER_35_965 VDD VSS sg13g2_decap_8
XFILLER_59_1086 VDD VSS sg13g2_decap_8
XFILLER_34_464 VDD VSS sg13g2_decap_8
XFILLER_62_784 VDD VSS sg13g2_decap_4
X_09220_ _13831_/D _10117_/A0 _13831_/Q _09238_/S VDD VSS sg13g2_mux2_1
XFILLER_62_795 VDD VSS sg13g2_decap_8
XFILLER_61_272 VDD VSS sg13g2_decap_8
XFILLER_179_469 VDD VSS sg13g2_decap_8
XFILLER_99_0 VDD VSS sg13g2_decap_8
XFILLER_107_1029 VDD VSS sg13g2_decap_8
XFILLER_146_1089 VDD VSS sg13g2_decap_4
XFILLER_37_1362 VDD VSS sg13g2_decap_8
XFILLER_21_147 VDD VSS sg13g2_decap_8
XFILLER_166_119 VDD VSS sg13g2_decap_8
X_09151_ _09151_/Y _09162_/A _09151_/B _09156_/B VDD VSS sg13g2_nand3_1
XFILLER_124_1343 VDD VSS sg13g2_decap_4
X_08102_ _08103_/C _08142_/C _11452_/A _07879_/A _07912_/B _08109_/A1 _12360_/A1 VDD
+ VSS sg13g2_mux4_1
XFILLER_72_1297 VDD VSS sg13g2_decap_8
XFILLER_30_681 VDD VSS sg13g2_decap_8
X_09082_ _09082_/Y _09090_/A _09082_/B _09087_/B VDD VSS sg13g2_nand3_1
XFILLER_135_517 VDD VSS sg13g2_decap_4
X_08033_ _08036_/A _08033_/A _08402_/B VDD VSS sg13g2_nor2_1
XFILLER_174_196 VDD VSS sg13g2_decap_8
XFILLER_162_369 VDD VSS sg13g2_decap_8
XFILLER_103_403 VDD VSS sg13g2_decap_4
XFILLER_115_263 VDD VSS sg13g2_decap_8
XFILLER_143_572 VDD VSS sg13g2_decap_8
XFILLER_116_797 VDD VSS sg13g2_fill_2
XFILLER_118_1125 VDD VSS sg13g2_decap_8
X_09984_ _14567_/D _10117_/A0 _14567_/Q _09998_/S VDD VSS sg13g2_mux2_1
XFILLER_88_125 VDD VSS sg13g2_decap_8
XFILLER_44_1311 VDD VSS sg13g2_decap_8
Xclkbuf_leaf_62_clk_i _15216_/CLK clkbuf_leaf_66_clk_i/A VDD VSS sg13g2_buf_8
X_08935_ _13717_/D _16879_/A _08934_/X _08938_/S VDD VSS sg13g2_mux2_1
XFILLER_83_1393 VDD VSS sg13g2_decap_4
XFILLER_69_350 VDD VSS sg13g2_fill_2
XFILLER_170_1352 VDD VSS sg13g2_decap_8
XFILLER_57_523 VDD VSS sg13g2_fill_2
XFILLER_40_1208 VDD VSS sg13g2_decap_8
X_08866_ _08866_/X _15030_/Q _10694_/S _08865_/Y VDD VSS sg13g2_a21o_1
XFILLER_96_191 VDD VSS sg13g2_decap_8
XFILLER_131_1358 VDD VSS sg13g2_decap_8
XFILLER_79_1418 VDD VSS sg13g2_decap_8
X_07817_ _08527_/A _15010_/Q _07818_/B VDD VSS sg13g2_xor2_1
X_08797_ _08799_/A _13345_/B _14755_/Q _08727_/X _15198_/Q _13490_/B VDD VSS sg13g2_a221oi_1
XFILLER_177_7 VDD VSS sg13g2_decap_8
XFILLER_57_589 VDD VSS sg13g2_decap_8
Xclkbuf_leaf_77_clk_i clkload73/A clkload5/A VDD VSS sg13g2_buf_8
X_07748_ _07748_/Y _11241_/A _07748_/B _13499_/C _13293_/B VDD VSS sg13g2_nand4_1
XFILLER_84_397 VDD VSS sg13g2_decap_8
XFILLER_77_1120 VDD VSS sg13g2_fill_1
XFILLER_25_431 VDD VSS sg13g2_decap_8
XFILLER_129_1221 VDD VSS sg13g2_decap_8
XFILLER_53_762 VDD VSS sg13g2_decap_8
XFILLER_41_902 VDD VSS sg13g2_decap_8
X_15098__2872 _15098_/RESET_B VDD VSS sg13g2_tiehi
X_07679_ _07679_/Y _15084_/Q _15085_/Q _15083_/Q _07679_/D VDD VSS sg13g2_nor4_1
XFILLER_38_1126 VDD VSS sg13g2_decap_8
XFILLER_0_1471 VDD VSS sg13g2_decap_4
XFILLER_26_998 VDD VSS sg13g2_fill_1
XFILLER_16_77 VDD VSS sg13g2_decap_8
XFILLER_25_486 VDD VSS sg13g2_decap_8
XFILLER_164_1156 VDD VSS sg13g2_decap_8
XFILLER_186_907 VDD VSS sg13g2_decap_4
XFILLER_13_637 VDD VSS sg13g2_decap_8
XFILLER_186_918 VDD VSS sg13g2_fill_1
X_09418_ _14020_/D _09616_/A0 _14020_/Q _09429_/S VDD VSS sg13g2_mux2_1
XFILLER_25_497 VDD VSS sg13g2_fill_1
X_10690_ _14899_/D _07705_/B _10876_/A _10689_/Y VDD VSS sg13g2_o21ai_1
XFILLER_55_1440 VDD VSS sg13g2_decap_8
XFILLER_52_294 VDD VSS sg13g2_decap_8
XFILLER_185_406 VDD VSS sg13g2_decap_8
XFILLER_142_1410 VDD VSS sg13g2_fill_2
XFILLER_41_979 VDD VSS sg13g2_decap_8
XFILLER_12_147 VDD VSS sg13g2_decap_8
XFILLER_90_1353 VDD VSS sg13g2_decap_8
XFILLER_55_1473 VDD VSS sg13g2_decap_4
XFILLER_138_300 VDD VSS sg13g2_decap_8
XFILLER_32_21 VDD VSS sg13g2_decap_8
X_09349_ _13953_/D _09945_/A1 _13953_/Q _09363_/S VDD VSS sg13g2_mux2_1
XFILLER_139_856 VDD VSS sg13g2_decap_8
XFILLER_148_21 VDD VSS sg13g2_decap_8
XFILLER_16_1468 VDD VSS sg13g2_decap_8
XFILLER_103_1427 VDD VSS sg13g2_decap_8
X_12360_ _14989_/D _12360_/A1 _12443_/A2 _12359_/Y _12356_/Y VDD VSS sg13g2_a22oi_1
X_11311_ _11311_/Y _11307_/Y _11308_/Y _11310_/Y _11309_/Y _11898_/C VDD VSS sg13g2_a221oi_1
XFILLER_32_98 VDD VSS sg13g2_decap_8
XFILLER_10_1001 VDD VSS sg13g2_decap_8
XFILLER_181_623 VDD VSS sg13g2_decap_8
Xclkbuf_leaf_15_clk_i _14664_/CLK clkbuf_5_6__f_clk_i/X VDD VSS sg13g2_buf_8
XFILLER_113_2 VDD VSS sg13g2_fill_1
X_12291_ _12292_/B _12291_/A _12291_/B VDD VSS sg13g2_nor2_1
XFILLER_154_859 VDD VSS sg13g2_decap_8
XFILLER_5_847 VDD VSS sg13g2_decap_8
XFILLER_119_591 VDD VSS sg13g2_fill_2
XFILLER_180_133 VDD VSS sg13g2_decap_8
X_14030_ _14030_/Q _14222_/CLK _14030_/D _14030_/RESET_B VDD VSS sg13g2_dfrbpq_1
X_11242_ _13298_/B _13300_/C _13312_/A VDD VSS sg13g2_nor2_1
XFILLER_107_764 VDD VSS sg13g2_fill_1
XFILLER_4_357 VDD VSS sg13g2_decap_8
XFILLER_107_775 VDD VSS sg13g2_decap_8
XFILLER_10_1078 VDD VSS sg13g2_decap_8
XFILLER_134_583 VDD VSS sg13g2_fill_1
XFILLER_164_42 VDD VSS sg13g2_decap_8
XFILLER_175_1274 VDD VSS sg13g2_decap_8
X_11173_ _11173_/Y _11150_/B _11173_/B _11173_/C VDD VSS sg13g2_nand3b_1
XFILLER_79_125 VDD VSS sg13g2_decap_8
X_10124_ _14702_/D _10157_/A1 _14702_/Q _10130_/S VDD VSS sg13g2_mux2_1
XFILLER_62_1422 VDD VSS sg13g2_fill_2
XFILLER_62_1433 VDD VSS sg13g2_decap_8
XFILLER_0_574 VDD VSS sg13g2_decap_8
XFILLER_103_992 VDD VSS sg13g2_decap_8
X_14932_ _14932_/Q _15226_/CLK _14932_/D _14932_/RESET_B VDD VSS sg13g2_dfrbpq_1
X_10055_ _14636_/D _10122_/A0 _14636_/Q _10063_/S VDD VSS sg13g2_mux2_1
XFILLER_62_1477 VDD VSS sg13g2_fill_2
XFILLER_23_1428 VDD VSS sg13g2_decap_8
XFILLER_76_865 VDD VSS sg13g2_decap_8
XFILLER_169_1023 VDD VSS sg13g2_decap_8
XFILLER_180_63 VDD VSS sg13g2_decap_8
X_14863_ _14863_/Q clkload66/A _14863_/D _14863_/RESET_B VDD VSS sg13g2_dfrbpq_1
XFILLER_169_1034 VDD VSS sg13g2_fill_1
XFILLER_21_1130 VDD VSS sg13g2_decap_8
XFILLER_91_835 VDD VSS sg13g2_decap_8
XFILLER_35_217 VDD VSS sg13g2_decap_8
XFILLER_169_1056 VDD VSS sg13g2_decap_8
X_13814_ _13814_/Q _14744_/CLK _13814_/D _13814_/RESET_B VDD VSS sg13g2_dfrbpq_1
XFILLER_91_846 VDD VSS sg13g2_fill_1
XFILLER_5_1393 VDD VSS sg13g2_decap_8
XFILLER_16_420 VDD VSS sg13g2_decap_8
XFILLER_1_1246 VDD VSS sg13g2_decap_8
X_14794_ _14794_/Q clkload62/A _14794_/D _14794_/RESET_B VDD VSS sg13g2_dfrbpq_1
XFILLER_169_1089 VDD VSS sg13g2_fill_1
XFILLER_56_1204 VDD VSS sg13g2_decap_8
XFILLER_90_367 VDD VSS sg13g2_decap_8
X_13745_ _13745_/Q clkload7/A _13745_/D _13745_/RESET_B VDD VSS sg13g2_dfrbpq_1
XFILLER_17_998 VDD VSS sg13g2_decap_8
X_10957_ _10957_/Y _10954_/C _11207_/A2 _11207_/B1 VDD VSS sg13g2_a21oi_1
XFILLER_91_1128 VDD VSS sg13g2_decap_8
XFILLER_16_497 VDD VSS sg13g2_decap_8
XFILLER_92_7 VDD VSS sg13g2_decap_8
XFILLER_31_434 VDD VSS sg13g2_decap_8
XFILLER_176_406 VDD VSS sg13g2_decap_8
X_13676_ _13676_/Q clkload82/A _13676_/D _13676_/RESET_B VDD VSS sg13g2_dfrbpq_1
X_10888_ _10888_/Y _10923_/A _14755_/Q VDD VSS sg13g2_nor2b_1
XFILLER_32_979 VDD VSS sg13g2_fill_1
XFILLER_182_1289 VDD VSS sg13g2_decap_8
X_14834__2969 _14834_/RESET_B VDD VSS sg13g2_tiehi
X_12627_ _12627_/X _13967_/Q _13999_/Q _14031_/Q _14063_/Q _12633_/S0 _12633_/S1 VDD
+ VSS sg13g2_mux4_1
XFILLER_157_620 VDD VSS sg13g2_decap_8
X_14567__1705 _14567_/RESET_B VDD VSS sg13g2_tiehi
XFILLER_185_940 VDD VSS sg13g2_decap_8
XFILLER_8_630 VDD VSS sg13g2_decap_8
XFILLER_40_990 VDD VSS sg13g2_fill_2
X_12558_ _12558_/X _14698_/Q _14730_/Q _13770_/Q _13802_/Q _12643_/S0 _12643_/S1 VDD
+ VSS sg13g2_mux4_1
XFILLER_172_601 VDD VSS sg13g2_fill_1
XFILLER_7_140 VDD VSS sg13g2_decap_8
XFILLER_117_517 VDD VSS sg13g2_decap_8
XFILLER_129_388 VDD VSS sg13g2_decap_8
XFILLER_157_697 VDD VSS sg13g2_fill_2
XFILLER_176_1005 VDD VSS sg13g2_fill_2
X_11509_ _11509_/X _14371_/Q _14403_/Q _14467_/Q _14499_/Q _12140_/S0 _12140_/S1 VDD
+ VSS sg13g2_mux4_1
XFILLER_145_859 VDD VSS sg13g2_decap_8
XFILLER_89_1068 VDD VSS sg13g2_decap_8
X_12489_ _12489_/X _14373_/Q _14405_/Q _14469_/Q _14501_/Q _12654_/S0 _12654_/S1 VDD
+ VSS sg13g2_mux4_1
XFILLER_171_133 VDD VSS sg13g2_decap_8
XFILLER_172_667 VDD VSS sg13g2_decap_8
X_14228_ _14228_/Q clkload54/A _14228_/D _14228_/RESET_B VDD VSS sg13g2_dfrbpq_1
XFILLER_125_561 VDD VSS sg13g2_decap_8
XFILLER_153_881 VDD VSS sg13g2_decap_8
XFILLER_119_1434 VDD VSS sg13g2_decap_8
XFILLER_153_892 VDD VSS sg13g2_decap_8
XFILLER_154_1325 VDD VSS sg13g2_decap_8
X_14159_ _14159_/Q clkload12/A _14159_/D _14159_/RESET_B VDD VSS sg13g2_dfrbpq_1
XFILLER_113_745 VDD VSS sg13g2_fill_2
Xfanout609 _08652_/B1 _08688_/C VDD VSS sg13g2_buf_1
XFILLER_98_91 VDD VSS sg13g2_decap_4
XFILLER_67_1388 VDD VSS sg13g2_decap_4
XFILLER_154_1347 VDD VSS sg13g2_decap_8
XFILLER_67_1399 VDD VSS sg13g2_decap_8
XFILLER_100_417 VDD VSS sg13g2_decap_8
XFILLER_6_1113 VDD VSS sg13g2_decap_8
X_08720_ _15213_/D _15192_/D _15122_/Q _13653_/S VDD VSS sg13g2_mux2_1
X_13658__1519 _13658_/RESET_B VDD VSS sg13g2_tiehi
XFILLER_67_854 VDD VSS sg13g2_decap_4
XFILLER_14_0 VDD VSS sg13g2_decap_8
Xfanout1180 _08510_/A1 _11914_/A VDD VSS sg13g2_buf_1
XFILLER_26_1096 VDD VSS sg13g2_decap_8
Xfanout1191 _08487_/A3 _11798_/A VDD VSS sg13g2_buf_1
X_08651_ _15246_/D _08667_/A1 _08650_/X _08640_/X VDD VSS sg13g2_o21ai_1
XFILLER_82_802 VDD VSS sg13g2_decap_8
XFILLER_67_887 VDD VSS sg13g2_decap_8
XFILLER_96_1028 VDD VSS sg13g2_fill_2
XFILLER_66_397 VDD VSS sg13g2_decap_8
XFILLER_54_537 VDD VSS sg13g2_fill_2
X_08582_ _08583_/B _08641_/D _08577_/B _08577_/A VDD VSS sg13g2_a21oi_1
XFILLER_54_548 VDD VSS sg13g2_fill_1
XFILLER_19_280 VDD VSS sg13g2_decap_8
X_15211__3072 _15211_/RESET_B VDD VSS sg13g2_tiehi
XFILLER_23_902 VDD VSS sg13g2_fill_2
XFILLER_165_1432 VDD VSS sg13g2_decap_4
XFILLER_81_378 VDD VSS sg13g2_fill_2
XFILLER_35_773 VDD VSS sg13g2_decap_8
XFILLER_50_732 VDD VSS sg13g2_decap_8
XFILLER_179_266 VDD VSS sg13g2_decap_8
XFILLER_23_968 VDD VSS sg13g2_decap_8
XFILLER_22_445 VDD VSS sg13g2_decap_8
X_09203_ _10004_/C _09441_/A _09204_/C _09204_/D VDD VSS sg13g2_nor3_1
XFILLER_124_1151 VDD VSS sg13g2_decap_8
X_09134_ _10776_/A _15048_/Q _15245_/Q _09134_/S VDD VSS sg13g2_mux2_1
XFILLER_72_1094 VDD VSS sg13g2_fill_1
XFILLER_136_848 VDD VSS sg13g2_fill_2
X_09065_ _09065_/Y _15235_/Q _09072_/B VDD VSS sg13g2_nand2b_1
XFILLER_50_1370 VDD VSS sg13g2_decap_4
XFILLER_120_1059 VDD VSS sg13g2_decap_8
X_08016_ _08016_/Y _08244_/B _08015_/Y _08008_/Y VDD VSS sg13g2_a21oi_1
XFILLER_11_1365 VDD VSS sg13g2_decap_8
XFILLER_159_1258 VDD VSS sg13g2_decap_8
XFILLER_135_369 VDD VSS sg13g2_decap_8
XFILLER_163_678 VDD VSS sg13g2_decap_8
XFILLER_85_1422 VDD VSS sg13g2_fill_1
XFILLER_118_68 VDD VSS sg13g2_decap_4
XFILLER_150_306 VDD VSS sg13g2_decap_8
XFILLER_144_892 VDD VSS sg13g2_decap_8
XFILLER_89_423 VDD VSS sg13g2_fill_1
XFILLER_85_1477 VDD VSS sg13g2_fill_2
XFILLER_134_34 VDD VSS sg13g2_decap_8
X_14041__2231 _14041_/RESET_B VDD VSS sg13g2_tiehi
X_09967_ _14551_/D _14551_/Q _10099_/A0 _09969_/S VDD VSS sg13g2_mux2_1
XFILLER_58_810 VDD VSS sg13g2_decap_8
XFILLER_134_45 VDD VSS sg13g2_fill_1
XFILLER_83_1190 VDD VSS sg13g2_fill_2
XFILLER_131_597 VDD VSS sg13g2_decap_8
XFILLER_134_56 VDD VSS sg13g2_decap_8
X_13694__2578 _13694_/RESET_B VDD VSS sg13g2_tiehi
XFILLER_135_1280 VDD VSS sg13g2_decap_8
X_08918_ _08918_/X _15042_/Q _14946_/Q _10747_/A VDD VSS sg13g2_mux2_1
XFILLER_40_1005 VDD VSS sg13g2_decap_8
X_09898_ _14484_/D _09931_/A1 _14484_/Q _09904_/S VDD VSS sg13g2_mux2_1
XFILLER_131_1133 VDD VSS sg13g2_decap_8
XFILLER_58_865 VDD VSS sg13g2_fill_1
XFILLER_79_1204 VDD VSS sg13g2_fill_1
XFILLER_85_662 VDD VSS sg13g2_decap_8
X_14645__1627 _14645_/RESET_B VDD VSS sg13g2_tiehi
X_08849_ _08849_/X _15025_/Q _10691_/S _08848_/Y VDD VSS sg13g2_a21o_1
XFILLER_27_21 VDD VSS sg13g2_decap_8
XFILLER_22_1450 VDD VSS sg13g2_decap_8
XFILLER_17_217 VDD VSS sg13g2_decap_8
XFILLER_79_1237 VDD VSS sg13g2_decap_8
XFILLER_131_1188 VDD VSS sg13g2_decap_8
XFILLER_131_1199 VDD VSS sg13g2_fill_2
XFILLER_72_323 VDD VSS sg13g2_decap_8
X_11860_ _11860_/Y _13088_/A _11792_/B _11868_/A VDD VSS sg13g2_a21oi_1
XFILLER_27_98 VDD VSS sg13g2_decap_4
X_14074__2198 _14074_/RESET_B VDD VSS sg13g2_tiehi
X_10811_ _10811_/Y _10797_/C _10844_/A _07753_/B VDD VSS sg13g2_o21ai_1
X_11791_ _11791_/X _11789_/X _11790_/X _11975_/A VDD VSS sg13g2_mux2_1
XFILLER_26_773 VDD VSS sg13g2_decap_8
XFILLER_14_924 VDD VSS sg13g2_decap_8
X_13530_ _13530_/Y _13529_/A _13533_/B _08306_/B _13546_/B2 VDD VSS sg13g2_a22oi_1
XFILLER_25_283 VDD VSS sg13g2_decap_8
XFILLER_13_434 VDD VSS sg13g2_decap_8
X_10742_ _14913_/D _09204_/C _11052_/B _10741_/Y VDD VSS sg13g2_o21ai_1
XFILLER_92_1459 VDD VSS sg13g2_decap_8
XFILLER_43_42 VDD VSS sg13g2_decap_8
XFILLER_185_203 VDD VSS sg13g2_decap_8
XFILLER_159_42 VDD VSS sg13g2_decap_8
X_13461_ _13461_/Y _13412_/B _08723_/B _13273_/B VDD VSS sg13g2_o21ai_1
X_10673_ _14895_/D _10673_/A VDD VSS sg13g2_inv_1
XFILLER_9_427 VDD VSS sg13g2_decap_8
X_15013__2667 _15013_/RESET_B VDD VSS sg13g2_tiehi
XFILLER_90_1161 VDD VSS sg13g2_decap_8
XFILLER_51_1123 VDD VSS sg13g2_fill_1
X_15200_ _15200_/Q _15200_/CLK _15200_/D _15200_/RESET_B VDD VSS sg13g2_dfrbpq_1
XFILLER_51_1134 VDD VSS sg13g2_decap_8
XFILLER_107_1371 VDD VSS sg13g2_fill_2
X_12412_ _12412_/X _12411_/X _12410_/X _12407_/X _12406_/X wire856/X _12355_/S VDD
+ VSS sg13g2_mux4_1
XFILLER_103_1213 VDD VSS sg13g2_decap_4
XFILLER_138_141 VDD VSS sg13g2_fill_1
XFILLER_166_450 VDD VSS sg13g2_fill_1
XFILLER_167_973 VDD VSS sg13g2_decap_8
XFILLER_16_1265 VDD VSS sg13g2_decap_8
X_13392_ _15084_/D _15084_/Q _13407_/A _13391_/Y VDD VSS sg13g2_a21o_1
XFILLER_103_1235 VDD VSS sg13g2_fill_1
XFILLER_138_174 VDD VSS sg13g2_fill_2
X_15131_ _15131_/Q clkload86/A _15131_/D _15131_/RESET_B VDD VSS sg13g2_dfrbpq_1
XFILLER_126_325 VDD VSS sg13g2_decap_8
X_12343_ _12343_/X _14107_/Q _14139_/Q _14171_/Q _14203_/Q wire940/X _12620_/S1 VDD
+ VSS sg13g2_mux4_1
XFILLER_181_420 VDD VSS sg13g2_decap_8
XFILLER_86_1208 VDD VSS sg13g2_fill_2
XFILLER_5_644 VDD VSS sg13g2_decap_8
X_15062_ _15062_/Q clkload90/A _15062_/D _15062_/RESET_B VDD VSS sg13g2_dfrbpq_1
X_12274_ _12274_/Y _12274_/A _12274_/B VDD VSS sg13g2_nor2_1
XFILLER_175_63 VDD VSS sg13g2_decap_8
XFILLER_4_154 VDD VSS sg13g2_decap_8
XFILLER_4_14 VDD VSS sg13g2_decap_8
XFILLER_181_497 VDD VSS sg13g2_decap_8
X_14013_ _14013_/Q _14222_/CLK _14013_/D _14013_/RESET_B VDD VSS sg13g2_dfrbpq_1
X_11225_ _11225_/X _14363_/Q _14395_/Q _14459_/Q _14491_/Q _11226_/S0 _11300_/S1 VDD
+ VSS sg13g2_mux4_1
XFILLER_122_520 VDD VSS sg13g2_decap_8
XFILLER_134_380 VDD VSS sg13g2_decap_8
XFILLER_96_905 VDD VSS sg13g2_decap_8
XFILLER_122_553 VDD VSS sg13g2_decap_8
XFILLER_150_862 VDD VSS sg13g2_decap_8
XFILLER_96_916 VDD VSS sg13g2_fill_2
XFILLER_49_1096 VDD VSS sg13g2_fill_1
X_11156_ _11156_/Y _14953_/Q _11156_/B VDD VSS sg13g2_nand2_1
XFILLER_1_861 VDD VSS sg13g2_decap_8
XFILLER_7_1400 VDD VSS sg13g2_decap_8
XFILLER_49_810 VDD VSS sg13g2_decap_8
XFILLER_96_949 VDD VSS sg13g2_decap_8
X_10107_ _14685_/D _10140_/A1 _14685_/Q _10130_/S VDD VSS sg13g2_mux2_1
XFILLER_0_371 VDD VSS sg13g2_decap_8
XFILLER_110_748 VDD VSS sg13g2_decap_4
XFILLER_114_1320 VDD VSS sg13g2_fill_1
XFILLER_136_1099 VDD VSS sg13g2_fill_1
X_14284__1988 _14284_/RESET_B VDD VSS sg13g2_tiehi
X_11087_ _11087_/X _11118_/A _11118_/B VDD VSS sg13g2_and2_1
XFILLER_62_1263 VDD VSS sg13g2_decap_8
XFILLER_23_1225 VDD VSS sg13g2_decap_8
XFILLER_76_640 VDD VSS sg13g2_decap_8
XFILLER_7_1477 VDD VSS sg13g2_fill_2
XFILLER_76_651 VDD VSS sg13g2_fill_2
X_14915_ _14915_/Q clkload56/A _14915_/D _14915_/RESET_B VDD VSS sg13g2_dfrbpq_1
X_10038_ _14619_/D _10071_/A0 _14619_/Q _10063_/S VDD VSS sg13g2_mux2_1
XFILLER_97_1304 VDD VSS sg13g2_fill_2
XFILLER_114_1375 VDD VSS sg13g2_fill_2
XFILLER_36_504 VDD VSS sg13g2_decap_8
X_14767__3039 _14767_/RESET_B VDD VSS sg13g2_tiehi
XFILLER_48_386 VDD VSS sg13g2_fill_1
XFILLER_64_846 VDD VSS sg13g2_fill_1
X_14846_ _14846_/Q _14883_/CLK _14846_/D _14846_/RESET_B VDD VSS sg13g2_dfrbpq_1
XFILLER_75_194 VDD VSS sg13g2_decap_8
XFILLER_5_1190 VDD VSS sg13g2_decap_8
XFILLER_91_654 VDD VSS sg13g2_decap_8
XFILLER_84_82 VDD VSS sg13g2_decap_4
XFILLER_63_345 VDD VSS sg13g2_fill_1
XFILLER_1_1043 VDD VSS sg13g2_decap_8
XFILLER_149_1449 VDD VSS sg13g2_decap_8
XFILLER_63_356 VDD VSS sg13g2_decap_8
XFILLER_91_676 VDD VSS sg13g2_decap_8
X_14777_ _14777_/Q clkload67/A _14777_/D _14777_/RESET_B VDD VSS sg13g2_dfrbpq_1
X_11989_ _11989_/Y _11989_/A _11989_/B VDD VSS sg13g2_xnor2_1
XFILLER_95_1083 VDD VSS sg13g2_decap_8
XFILLER_90_197 VDD VSS sg13g2_decap_8
XFILLER_32_732 VDD VSS sg13g2_decap_8
XFILLER_177_704 VDD VSS sg13g2_decap_4
X_13728_ _13728_/Q clkload46/A _13728_/D _13728_/RESET_B VDD VSS sg13g2_dfrbpq_1
XFILLER_108_1124 VDD VSS sg13g2_decap_8
XFILLER_16_294 VDD VSS sg13g2_decap_8
XFILLER_147_1184 VDD VSS sg13g2_decap_4
XFILLER_176_203 VDD VSS sg13g2_decap_8
XFILLER_177_737 VDD VSS sg13g2_fill_1
XFILLER_56_1089 VDD VSS sg13g2_decap_8
X_13659_ _13659_/Q clkload82/A _13659_/D _13659_/RESET_B VDD VSS sg13g2_dfrbpq_1
XFILLER_31_275 VDD VSS sg13g2_decap_8
XFILLER_34_1343 VDD VSS sg13g2_fill_2
XFILLER_160_1362 VDD VSS sg13g2_decap_8
XFILLER_118_815 VDD VSS sg13g2_decap_4
XFILLER_129_152 VDD VSS sg13g2_fill_2
XFILLER_185_770 VDD VSS sg13g2_decap_8
XFILLER_34_1376 VDD VSS sg13g2_fill_1
XFILLER_121_1335 VDD VSS sg13g2_decap_8
XFILLER_158_995 VDD VSS sg13g2_decap_4
XFILLER_185_781 VDD VSS sg13g2_fill_1
XFILLER_160_1395 VDD VSS sg13g2_fill_2
XFILLER_9_994 VDD VSS sg13g2_decap_8
XFILLER_118_848 VDD VSS sg13g2_decap_8
XFILLER_129_185 VDD VSS sg13g2_fill_1
XFILLER_184_291 VDD VSS sg13g2_decap_4
XFILLER_117_358 VDD VSS sg13g2_decap_8
XFILLER_133_807 VDD VSS sg13g2_decap_8
XFILLER_105_509 VDD VSS sg13g2_decap_8
X_14723__1549 _14723_/RESET_B VDD VSS sg13g2_tiehi
XFILLER_132_306 VDD VSS sg13g2_decap_8
XFILLER_172_486 VDD VSS sg13g2_decap_8
XFILLER_119_1231 VDD VSS sg13g2_decap_8
XFILLER_113_531 VDD VSS sg13g2_decap_8
Xfanout406 _09272_/S _09267_/S VDD VSS sg13g2_buf_1
XFILLER_154_1144 VDD VSS sg13g2_decap_8
Xfanout417 _10079_/A0 wire422/X VDD VSS sg13g2_buf_1
X_09821_ _14409_/D _09920_/A1 _14409_/Q _09833_/S VDD VSS sg13g2_mux2_1
XFILLER_99_776 VDD VSS sg13g2_fill_2
Xfanout428 _09911_/A1 wire432/X VDD VSS sg13g2_buf_1
XFILLER_98_264 VDD VSS sg13g2_decap_8
XFILLER_28_1158 VDD VSS sg13g2_decap_8
XFILLER_63_1049 VDD VSS sg13g2_decap_8
XFILLER_58_106 VDD VSS sg13g2_decap_4
XFILLER_113_586 VDD VSS sg13g2_decap_8
XFILLER_150_1019 VDD VSS sg13g2_decap_8
XFILLER_98_297 VDD VSS sg13g2_decap_8
X_09752_ _14342_/D _14342_/Q _09917_/A1 _09764_/S VDD VSS sg13g2_mux2_1
XFILLER_101_759 VDD VSS sg13g2_fill_1
XFILLER_100_247 VDD VSS sg13g2_fill_2
XFILLER_132_1442 VDD VSS sg13g2_decap_8
X_08703_ _15184_/D hold3150/X _15184_/Q _08719_/S VDD VSS sg13g2_mux2_1
XFILLER_95_971 VDD VSS sg13g2_decap_8
XFILLER_41_1347 VDD VSS sg13g2_decap_8
X_13664__2637 _13664_/RESET_B VDD VSS sg13g2_tiehi
XFILLER_80_1396 VDD VSS sg13g2_fill_1
X_09683_ _14275_/D _09881_/A0 _14275_/Q _09705_/S VDD VSS sg13g2_mux2_1
XFILLER_94_481 VDD VSS sg13g2_decap_8
XFILLER_27_526 VDD VSS sg13g2_decap_8
X_08634_ _08640_/C _08668_/A _08333_/Y _08652_/B1 VDD VSS sg13g2_o21ai_1
X_08565_ _08581_/A _07862_/Y _08522_/C _08653_/A _08608_/B _08563_/Y VDD VSS sg13g2_a221oi_1
X_14915__2807 _14915_/RESET_B VDD VSS sg13g2_tiehi
XFILLER_23_710 VDD VSS sg13g2_decap_8
XFILLER_120_58 VDD VSS sg13g2_decap_8
X_08496_ _08497_/B _08434_/B _07829_/B _07950_/Y VDD VSS sg13g2_a21oi_1
XFILLER_22_231 VDD VSS sg13g2_decap_8
XFILLER_167_203 VDD VSS sg13g2_decap_8
XFILLER_126_1246 VDD VSS sg13g2_fill_1
XFILLER_168_737 VDD VSS sg13g2_decap_4
XFILLER_168_748 VDD VSS sg13g2_decap_8
XFILLER_74_1189 VDD VSS sg13g2_fill_2
XFILLER_50_562 VDD VSS sg13g2_decap_8
XFILLER_11_938 VDD VSS sg13g2_decap_8
XFILLER_50_584 VDD VSS sg13g2_decap_8
XFILLER_167_258 VDD VSS sg13g2_decap_4
XFILLER_52_1443 VDD VSS sg13g2_fill_2
XFILLER_10_448 VDD VSS sg13g2_decap_8
XFILLER_13_56 VDD VSS sg13g2_decap_8
X_14059__2213 _14059_/RESET_B VDD VSS sg13g2_tiehi
XFILLER_109_826 VDD VSS sg13g2_decap_8
XFILLER_149_995 VDD VSS sg13g2_decap_8
XFILLER_182_217 VDD VSS sg13g2_decap_8
XFILLER_13_1449 VDD VSS sg13g2_decap_8
X_09117_ _09117_/Y _09162_/A _09117_/B _09117_/C VDD VSS sg13g2_nand3_1
XFILLER_175_280 VDD VSS sg13g2_decap_8
XFILLER_159_1022 VDD VSS sg13g2_fill_2
XFILLER_124_807 VDD VSS sg13g2_decap_8
XFILLER_159_1033 VDD VSS sg13g2_fill_1
XFILLER_124_818 VDD VSS sg13g2_fill_2
XFILLER_135_144 VDD VSS sg13g2_decap_8
X_09048_ _10720_/B _09053_/B _15035_/Q _09047_/Y VDD VSS sg13g2_o21ai_1
XFILLER_163_464 VDD VSS sg13g2_decap_8
XFILLER_11_1162 VDD VSS sg13g2_decap_8
XFILLER_102_1290 VDD VSS sg13g2_decap_8
XFILLER_104_520 VDD VSS sg13g2_decap_8
XFILLER_151_648 VDD VSS sg13g2_decap_4
XFILLER_89_231 VDD VSS sg13g2_decap_8
XFILLER_46_1225 VDD VSS sg13g2_decap_8
XFILLER_2_658 VDD VSS sg13g2_decap_8
XFILLER_132_851 VDD VSS sg13g2_decap_8
X_11010_ _11012_/B _11010_/A _11010_/B _11010_/C VDD VSS sg13g2_nand3_1
XFILLER_1_168 VDD VSS sg13g2_decap_8
XFILLER_89_275 VDD VSS sg13g2_fill_1
XFILLER_49_106 VDD VSS sg13g2_decap_8
XFILLER_104_597 VDD VSS sg13g2_fill_1
XFILLER_133_1239 VDD VSS sg13g2_decap_8
Xfanout951 _12715_/S0 fanout953/X VDD VSS sg13g2_buf_1
Xfanout962 _12452_/S0 _12425_/S0 VDD VSS sg13g2_buf_1
Xfanout973 _13312_/A _12983_/A1 VDD VSS sg13g2_buf_1
XFILLER_38_42 VDD VSS sg13g2_decap_8
XFILLER_161_21 VDD VSS sg13g2_decap_8
Xfanout984 _12737_/A2 _12779_/A2 VDD VSS sg13g2_buf_1
XFILLER_58_651 VDD VSS sg13g2_decap_8
Xfanout995 _13601_/B _15203_/Q VDD VSS sg13g2_buf_1
XFILLER_18_504 VDD VSS sg13g2_decap_8
X_12961_ _12962_/B _12961_/A _12988_/C _12961_/C VDD VSS sg13g2_nand3_1
X_15039__2640 _15039_/RESET_B VDD VSS sg13g2_tiehi
XFILLER_57_161 VDD VSS sg13g2_decap_8
XFILLER_100_781 VDD VSS sg13g2_decap_8
XFILLER_38_97 VDD VSS sg13g2_decap_8
XFILLER_161_76 VDD VSS sg13g2_decap_8
X_14700_ _14700_/Q clkload26/A _14700_/D _14700_/RESET_B VDD VSS sg13g2_dfrbpq_1
X_15057__2596 _15057_/RESET_B VDD VSS sg13g2_tiehi
X_11912_ _11913_/B _11912_/A _11912_/B VDD VSS sg13g2_nor2_1
XFILLER_2_1330 VDD VSS sg13g2_decap_8
X_12892_ _12894_/B _14900_/Q _13687_/Q VDD VSS sg13g2_xor2_1
XFILLER_79_1056 VDD VSS sg13g2_fill_1
XFILLER_46_868 VDD VSS sg13g2_decap_8
XFILLER_45_345 VDD VSS sg13g2_fill_1
XFILLER_79_1067 VDD VSS sg13g2_fill_2
XFILLER_46_879 VDD VSS sg13g2_fill_1
XFILLER_166_0 VDD VSS sg13g2_decap_8
X_14631_ _14631_/Q _14727_/CLK _14631_/D _14631_/RESET_B VDD VSS sg13g2_dfrbpq_1
X_11843_ _11910_/B _11843_/A _13675_/Q VDD VSS sg13g2_xnor2_1
XFILLER_61_827 VDD VSS sg13g2_decap_8
XFILLER_166_1059 VDD VSS sg13g2_decap_8
XFILLER_14_721 VDD VSS sg13g2_decap_8
XFILLER_183_1340 VDD VSS sg13g2_decap_8
X_14763__3045 _14763_/RESET_B VDD VSS sg13g2_tiehi
X_14562_ _14562_/Q clkload45/A _14562_/D _14562_/RESET_B VDD VSS sg13g2_dfrbpq_1
XFILLER_109_1433 VDD VSS sg13g2_decap_8
X_11774_ _11774_/Y _11774_/A _11776_/B VDD VSS sg13g2_nand2_1
XFILLER_60_359 VDD VSS sg13g2_fill_1
XFILLER_13_231 VDD VSS sg13g2_decap_8
XFILLER_57_1376 VDD VSS sg13g2_decap_8
XFILLER_92_1267 VDD VSS sg13g2_decap_8
XFILLER_109_1466 VDD VSS sg13g2_fill_1
XFILLER_183_1395 VDD VSS sg13g2_fill_2
X_13513_ _15136_/D _15136_/Q _13533_/A _13519_/B VDD VSS sg13g2_mux2_1
XFILLER_144_1357 VDD VSS sg13g2_decap_8
XFILLER_159_748 VDD VSS sg13g2_fill_1
XFILLER_186_534 VDD VSS sg13g2_decap_8
X_10725_ _10725_/Y _10725_/A _10725_/B VDD VSS sg13g2_nor2_1
XFILLER_14_798 VDD VSS sg13g2_decap_8
XFILLER_159_759 VDD VSS sg13g2_decap_8
XFILLER_186_545 VDD VSS sg13g2_decap_8
X_14493_ _14493_/Q _14886_/CLK _14493_/D _14493_/RESET_B VDD VSS sg13g2_dfrbpq_1
XFILLER_158_247 VDD VSS sg13g2_decap_8
XFILLER_9_224 VDD VSS sg13g2_decap_8
XFILLER_110_91 VDD VSS sg13g2_decap_8
X_13444_ _13444_/Y _13444_/A _13444_/B _13444_/C VDD VSS sg13g2_nor3_1
XFILLER_16_1062 VDD VSS sg13g2_decap_8
X_10656_ _10658_/B _14891_/Q _10663_/D VDD VSS sg13g2_nor2_1
XFILLER_107_1190 VDD VSS sg13g2_fill_2
XFILLER_173_217 VDD VSS sg13g2_decap_8
X_13657__1518 _13657_/RESET_B VDD VSS sg13g2_tiehi
XFILLER_70_84 VDD VSS sg13g2_decap_8
XFILLER_127_634 VDD VSS sg13g2_decap_8
Xclkload16 clkload16/Y clkload16/A VDD VSS sg13g2_inv_2
XFILLER_6_931 VDD VSS sg13g2_decap_8
XFILLER_127_645 VDD VSS sg13g2_fill_2
XFILLER_166_280 VDD VSS sg13g2_decap_8
X_13375_ _13378_/C _15124_/Q _13507_/B VDD VSS sg13g2_nand2_1
Xclkload27 clkload27/Y clkload27/A VDD VSS sg13g2_inv_1
X_10587_ _10587_/Y _10649_/B _10594_/D _10365_/C VDD VSS sg13g2_o21ai_1
Xclkload38 clkload38/Y clkload38/A VDD VSS sg13g2_inv_1
Xclkload49 clkload49/Y clkload49/A VDD VSS sg13g2_inv_2
XFILLER_186_95 VDD VSS sg13g2_decap_8
X_15114_ _15114_/Q clkload85/A _15114_/D _15114_/RESET_B VDD VSS sg13g2_dfrbpq_1
XFILLER_126_155 VDD VSS sg13g2_fill_1
XFILLER_142_604 VDD VSS sg13g2_decap_8
XFILLER_170_913 VDD VSS sg13g2_decap_8
XFILLER_177_1144 VDD VSS sg13g2_decap_8
X_12326_ _12326_/Y _12306_/A _13882_/Q _12330_/S1 VDD VSS sg13g2_a21oi_1
XFILLER_5_441 VDD VSS sg13g2_decap_8
XFILLER_55_7 VDD VSS sg13g2_decap_8
XFILLER_108_881 VDD VSS sg13g2_decap_8
XFILLER_126_188 VDD VSS sg13g2_decap_8
XFILLER_138_1139 VDD VSS sg13g2_fill_2
X_15045_ _15045_/Q clkload82/A _15045_/D _15045_/RESET_B VDD VSS sg13g2_dfrbpq_1
X_15210__3071 _15210_/RESET_B VDD VSS sg13g2_tiehi
XFILLER_181_294 VDD VSS sg13g2_decap_8
X_12257_ _12257_/Y _12259_/S0 _13944_/Q _12184_/B VDD VSS sg13g2_a21oi_1
XFILLER_29_1423 VDD VSS sg13g2_decap_8
XFILLER_155_1431 VDD VSS sg13g2_decap_8
XFILLER_155_1442 VDD VSS sg13g2_fill_2
X_13757__2515 _13757_/RESET_B VDD VSS sg13g2_tiehi
X_11208_ _11209_/B _11206_/Y _11204_/Y _11207_/Y VDD VSS sg13g2_o21ai_1
X_12188_ _12188_/Y _12188_/A _12188_/B _12188_/C VDD VSS sg13g2_nand3_1
XFILLER_150_692 VDD VSS sg13g2_decap_4
XFILLER_110_534 VDD VSS sg13g2_fill_1
X_11139_ _11139_/Y _11190_/C _11163_/A _11140_/B2 VDD VSS sg13g2_a21oi_1
XFILLER_96_768 VDD VSS sg13g2_fill_1
XFILLER_110_556 VDD VSS sg13g2_decap_8
XFILLER_110_578 VDD VSS sg13g2_decap_8
XFILLER_7_1274 VDD VSS sg13g2_decap_8
XFILLER_3_1127 VDD VSS sg13g2_decap_8
XFILLER_110_1014 VDD VSS sg13g2_fill_1
XFILLER_64_621 VDD VSS sg13g2_decap_8
XFILLER_36_312 VDD VSS sg13g2_decap_8
XFILLER_97_1134 VDD VSS sg13g2_decap_8
XFILLER_37_846 VDD VSS sg13g2_decap_8
XFILLER_23_1077 VDD VSS sg13g2_fill_1
X_13972__2300 _13972_/RESET_B VDD VSS sg13g2_tiehi
X_14137__2135 _14137_/RESET_B VDD VSS sg13g2_tiehi
XFILLER_23_1099 VDD VSS sg13g2_decap_8
XFILLER_63_142 VDD VSS sg13g2_decap_8
XFILLER_91_462 VDD VSS sg13g2_fill_2
XFILLER_24_507 VDD VSS sg13g2_fill_2
XFILLER_149_1257 VDD VSS sg13g2_fill_2
X_14829_ _14829_/Q clkload63/A _14829_/D _14829_/RESET_B VDD VSS sg13g2_dfrbpq_1
XFILLER_17_581 VDD VSS sg13g2_decap_8
X_08350_ _08352_/A _07934_/Y _08350_/B VDD VSS sg13g2_nand2b_1
XFILLER_162_1424 VDD VSS sg13g2_decap_8
XFILLER_149_214 VDD VSS sg13g2_decap_8
X_08281_ _08281_/Y _08599_/B _08207_/X _08279_/X VDD VSS sg13g2_a21oi_1
XFILLER_123_1408 VDD VSS sg13g2_decap_8
XFILLER_20_735 VDD VSS sg13g2_decap_8
XFILLER_81_0 VDD VSS sg13g2_decap_8
XFILLER_177_567 VDD VSS sg13g2_decap_8
XFILLER_121_1143 VDD VSS sg13g2_fill_1
XFILLER_9_791 VDD VSS sg13g2_decap_8
XFILLER_146_965 VDD VSS sg13g2_decap_8
XFILLER_30_1048 VDD VSS sg13g2_decap_8
XFILLER_145_453 VDD VSS sg13g2_decap_4
XFILLER_106_818 VDD VSS sg13g2_decap_8
XFILLER_172_261 VDD VSS sg13g2_decap_8
XFILLER_161_946 VDD VSS sg13g2_decap_8
XFILLER_161_957 VDD VSS sg13g2_fill_2
XFILLER_132_125 VDD VSS sg13g2_decap_8
XFILLER_99_551 VDD VSS sg13g2_decap_8
Xfanout203 _09927_/A1 _09828_/A0 VDD VSS sg13g2_buf_1
XFILLER_114_873 VDD VSS sg13g2_decap_8
Xfanout214 _09924_/A1 _09759_/A1 VDD VSS sg13g2_buf_1
XFILLER_59_404 VDD VSS sg13g2_decap_4
XFILLER_115_14 VDD VSS sg13g2_fill_2
XFILLER_141_670 VDD VSS sg13g2_fill_2
X_14347__1925 _14347_/RESET_B VDD VSS sg13g2_tiehi
XFILLER_119_1072 VDD VSS sg13g2_fill_2
Xfanout225 _10155_/A1 _09070_/Y VDD VSS sg13g2_buf_1
Xfanout236 _09622_/A0 fanout237/X VDD VSS sg13g2_buf_1
X_09804_ _14393_/D _09936_/A1 _14393_/Q _09804_/S VDD VSS sg13g2_mux2_1
Xfanout258 _09620_/A0 _10151_/A1 VDD VSS sg13g2_buf_1
XFILLER_87_757 VDD VSS sg13g2_decap_8
XFILLER_101_545 VDD VSS sg13g2_decap_8
Xfanout269 _09618_/A0 _10082_/A0 VDD VSS sg13g2_buf_1
X_07996_ _07996_/X _15104_/Q _15091_/Q VDD VSS sg13g2_or2_1
X_09735_ _14326_/D _10165_/A1 _14326_/Q _09737_/S VDD VSS sg13g2_mux2_1
XFILLER_83_930 VDD VSS sg13g2_fill_2
XFILLER_83_941 VDD VSS sg13g2_decap_8
XFILLER_41_1177 VDD VSS sg13g2_fill_2
X_09666_ _14259_/D _09831_/A0 _14259_/Q _09670_/S VDD VSS sg13g2_mux2_1
XFILLER_39_194 VDD VSS sg13g2_decap_8
XFILLER_82_440 VDD VSS sg13g2_fill_1
X_14562__1710 _14562_/RESET_B VDD VSS sg13g2_tiehi
XFILLER_28_879 VDD VSS sg13g2_decap_8
XFILLER_83_985 VDD VSS sg13g2_fill_1
XFILLER_15_518 VDD VSS sg13g2_decap_8
X_08617_ _08622_/C _08617_/A _08617_/B VDD VSS sg13g2_nor2_1
XFILLER_83_996 VDD VSS sg13g2_fill_1
X_09597_ _14194_/D _14194_/Q _09597_/A1 _09603_/S VDD VSS sg13g2_mux2_1
XFILLER_82_484 VDD VSS sg13g2_decap_8
XFILLER_91_28 VDD VSS sg13g2_decap_8
XFILLER_43_849 VDD VSS sg13g2_decap_8
X_08548_ _08548_/Y _08577_/A _08548_/B VDD VSS sg13g2_nand2_1
XFILLER_39_1084 VDD VSS sg13g2_decap_8
XFILLER_23_573 VDD VSS sg13g2_decap_8
X_08479_ _08479_/Y _07805_/B _07949_/C _08497_/A VDD VSS sg13g2_a21oi_1
XFILLER_23_584 VDD VSS sg13g2_fill_1
XFILLER_11_735 VDD VSS sg13g2_decap_8
XFILLER_24_77 VDD VSS sg13g2_decap_8
XFILLER_24_88 VDD VSS sg13g2_fill_1
X_13835__2437 _13835_/RESET_B VDD VSS sg13g2_tiehi
X_10510_ _10576_/C _10647_/A _10647_/D _10521_/D VDD VSS sg13g2_and3_1
XFILLER_183_504 VDD VSS sg13g2_decap_8
X_14595__1677 _14595_/RESET_B VDD VSS sg13g2_tiehi
X_11490_ _11490_/X _14562_/Q _14594_/Q _14626_/Q _14658_/Q _11493_/S0 _11493_/S1 VDD
+ VSS sg13g2_mux4_1
XFILLER_10_245 VDD VSS sg13g2_decap_8
XFILLER_155_206 VDD VSS sg13g2_decap_8
XFILLER_149_781 VDD VSS sg13g2_decap_8
XFILLER_7_728 VDD VSS sg13g2_decap_8
XFILLER_137_932 VDD VSS sg13g2_decap_8
X_10441_ _14836_/D _10441_/A _10442_/B _10441_/C VDD VSS sg13g2_and3_1
XFILLER_13_1246 VDD VSS sg13g2_decap_8
XFILLER_40_21 VDD VSS sg13g2_decap_8
XFILLER_136_431 VDD VSS sg13g2_decap_8
XFILLER_6_238 VDD VSS sg13g2_decap_8
XFILLER_137_976 VDD VSS sg13g2_decap_4
XFILLER_156_21 VDD VSS sg13g2_decap_8
X_13160_ _13160_/Y _13159_/Y _13160_/B _13160_/C VDD VSS sg13g2_nand3b_1
X_10372_ _14815_/D _14815_/Q _10378_/D _10371_/Y VDD VSS sg13g2_a21oi_1
XFILLER_100_1249 VDD VSS sg13g2_decap_8
XFILLER_164_784 VDD VSS sg13g2_decap_8
XFILLER_178_1464 VDD VSS sg13g2_fill_1
XFILLER_136_486 VDD VSS sg13g2_decap_4
XFILLER_164_795 VDD VSS sg13g2_fill_2
XFILLER_156_76 VDD VSS sg13g2_decap_8
X_12111_ _12111_/Y _12100_/S0 _13908_/Q VDD VSS sg13g2_nand2b_1
X_13091_ _13091_/Y _13092_/A _13092_/C _13112_/A VDD VSS sg13g2_a21oi_1
X_14215__2057 _14215_/RESET_B VDD VSS sg13g2_tiehi
XFILLER_3_945 VDD VSS sg13g2_decap_8
XFILLER_124_659 VDD VSS sg13g2_decap_8
XFILLER_152_968 VDD VSS sg13g2_decap_8
XFILLER_46_1011 VDD VSS sg13g2_fill_2
X_12042_ _12042_/X _13970_/Q _14002_/Q _14034_/Q _14066_/Q _12025_/A _12026_/C VDD
+ VSS sg13g2_mux4_1
XFILLER_2_455 VDD VSS sg13g2_decap_8
XFILLER_172_1052 VDD VSS sg13g2_fill_1
XFILLER_104_383 VDD VSS sg13g2_decap_8
XFILLER_132_692 VDD VSS sg13g2_fill_2
XFILLER_49_63 VDD VSS sg13g2_decap_8
XFILLER_172_42 VDD VSS sg13g2_decap_8
Xfanout770 _12094_/B fanout771/X VDD VSS sg13g2_buf_1
Xfanout781 _12166_/B _12184_/B VDD VSS sg13g2_buf_1
XFILLER_4_1414 VDD VSS sg13g2_decap_8
XFILLER_19_813 VDD VSS sg13g2_decap_8
Xfanout792 _13307_/B _07653_/Y VDD VSS sg13g2_buf_1
XFILLER_18_301 VDD VSS sg13g2_decap_8
X_13993_ _13993_/Q clkload35/A _13993_/D _13993_/RESET_B VDD VSS sg13g2_dfrbpq_1
XFILLER_111_1323 VDD VSS sg13g2_decap_8
XFILLER_20_1217 VDD VSS sg13g2_decap_8
XFILLER_24_1386 VDD VSS sg13g2_decap_8
X_12944_ _12946_/A _12945_/A _12944_/B _12988_/B VDD VSS sg13g2_nand3_1
XFILLER_65_62 VDD VSS sg13g2_decap_8
XFILLER_111_1378 VDD VSS sg13g2_decap_8
XFILLER_45_153 VDD VSS sg13g2_decap_8
XFILLER_185_1446 VDD VSS sg13g2_decap_8
XFILLER_18_378 VDD VSS sg13g2_decap_8
XFILLER_73_473 VDD VSS sg13g2_decap_4
X_12875_ _12875_/Y _12861_/B _12877_/C VDD VSS sg13g2_nand2b_1
Xclkbuf_5_8__f_clk_i clkbuf_5_8__f_clk_i/X clkbuf_4_4_0_clk_i/X VDD VSS sg13g2_buf_16
XFILLER_60_112 VDD VSS sg13g2_fill_2
XFILLER_27_890 VDD VSS sg13g2_decap_8
X_14614_ _14614_/Q clkload69/A _14614_/D _14614_/RESET_B VDD VSS sg13g2_dfrbpq_1
X_11826_ _11826_/Y _11826_/A1 _13932_/Q _12304_/B VDD VSS sg13g2_a21oi_1
XFILLER_61_657 VDD VSS sg13g2_fill_2
XFILLER_57_1162 VDD VSS sg13g2_decap_8
XFILLER_60_156 VDD VSS sg13g2_fill_2
XFILLER_42_860 VDD VSS sg13g2_decap_8
XFILLER_159_523 VDD VSS sg13g2_decap_8
X_14545_ _14545_/Q clkload7/A _14545_/D _14545_/RESET_B VDD VSS sg13g2_dfrbpq_1
XFILLER_109_1263 VDD VSS sg13g2_decap_8
X_11757_ _11761_/A _11756_/X _11967_/B VDD VSS sg13g2_nand2b_1
XFILLER_18_1157 VDD VSS sg13g2_decap_8
XFILLER_105_1116 VDD VSS sg13g2_decap_8
XFILLER_14_595 VDD VSS sg13g2_decap_8
XFILLER_92_1097 VDD VSS sg13g2_decap_8
XFILLER_81_83 VDD VSS sg13g2_decap_4
XFILLER_109_1296 VDD VSS sg13g2_decap_8
XFILLER_140_1018 VDD VSS sg13g2_decap_8
X_10708_ _10708_/Y _14905_/Q _10903_/B VDD VSS sg13g2_nand2_1
X_14425__1847 _14425_/RESET_B VDD VSS sg13g2_tiehi
X_14476_ _14476_/Q clkload51/A _14476_/D _14476_/RESET_B VDD VSS sg13g2_dfrbpq_1
XFILLER_174_526 VDD VSS sg13g2_decap_8
X_11688_ _11688_/Y _11685_/Y _11687_/X _11957_/A VDD VSS sg13g2_o21ai_1
XFILLER_179_1217 VDD VSS sg13g2_decap_8
XFILLER_70_1362 VDD VSS sg13g2_decap_8
X_13427_ _13427_/Y _13440_/A _13427_/B _13427_/C VDD VSS sg13g2_nand3_1
XFILLER_31_1335 VDD VSS sg13g2_fill_2
X_10639_ _10639_/Y _14887_/Q _10642_/C _10633_/A VDD VSS sg13g2_a21oi_1
XFILLER_127_431 VDD VSS sg13g2_decap_8
XFILLER_155_740 VDD VSS sg13g2_fill_1
XFILLER_122_1474 VDD VSS sg13g2_fill_1
XFILLER_128_976 VDD VSS sg13g2_decap_8
XFILLER_143_902 VDD VSS sg13g2_decap_4
XFILLER_155_773 VDD VSS sg13g2_decap_8
X_13358_ _15072_/D _15072_/Q _13470_/A2 _13357_/Y VDD VSS sg13g2_a21o_1
XFILLER_170_710 VDD VSS sg13g2_decap_8
XFILLER_142_412 VDD VSS sg13g2_fill_1
XFILLER_154_272 VDD VSS sg13g2_decap_8
XFILLER_182_581 VDD VSS sg13g2_decap_8
XFILLER_143_946 VDD VSS sg13g2_decap_4
XFILLER_143_957 VDD VSS sg13g2_decap_8
X_12309_ _12310_/A _13978_/Q _14010_/Q _14042_/Q _14074_/Q _12306_/A _12307_/C VDD
+ VSS sg13g2_mux4_1
XFILLER_170_754 VDD VSS sg13g2_decap_8
X_13289_ _13290_/D _13300_/C _13293_/D _13289_/C _13289_/D VDD VSS sg13g2_nor4_1
X_14640__1632 _14640_/RESET_B VDD VSS sg13g2_tiehi
XFILLER_130_607 VDD VSS sg13g2_decap_8
X_15028_ _15028_/Q clkload80/A _15028_/D _15028_/RESET_B VDD VSS sg13g2_dfrbpq_1
XFILLER_29_1264 VDD VSS sg13g2_fill_1
XFILLER_123_681 VDD VSS sg13g2_decap_8
XFILLER_9_1358 VDD VSS sg13g2_decap_8
X_07850_ _08646_/A _15016_/Q _07965_/B VDD VSS sg13g2_nand2_1
XFILLER_29_1297 VDD VSS sg13g2_decap_8
XFILLER_111_854 VDD VSS sg13g2_decap_8
XFILLER_110_342 VDD VSS sg13g2_decap_8
XFILLER_99_1207 VDD VSS sg13g2_decap_4
XFILLER_96_565 VDD VSS sg13g2_decap_8
XFILLER_57_919 VDD VSS sg13g2_fill_2
XFILLER_42_1420 VDD VSS sg13g2_fill_1
XFILLER_84_716 VDD VSS sg13g2_decap_8
X_07781_ _08411_/A _07782_/A _15002_/Q VDD VSS sg13g2_nor2_1
XFILLER_83_215 VDD VSS sg13g2_decap_8
XFILLER_7_1071 VDD VSS sg13g2_decap_8
Xinput3 input3/X input3/A VDD VSS sg13g2_buf_1
XFILLER_77_790 VDD VSS sg13g2_decap_8
X_13913__2359 _13913_/RESET_B VDD VSS sg13g2_tiehi
X_09520_ _14119_/D _09619_/A0 _14119_/Q _09534_/S VDD VSS sg13g2_mux2_1
X_14673__1599 _14673_/RESET_B VDD VSS sg13g2_tiehi
XFILLER_83_248 VDD VSS sg13g2_decap_8
X_09451_ _14052_/D _09616_/A0 _14052_/Q _09462_/S VDD VSS sg13g2_mux2_1
XFILLER_36_164 VDD VSS sg13g2_decap_8
XFILLER_25_827 VDD VSS sg13g2_decap_8
XFILLER_24_304 VDD VSS sg13g2_fill_2
XFILLER_80_933 VDD VSS sg13g2_decap_8
XFILLER_52_624 VDD VSS sg13g2_fill_1
XFILLER_64_484 VDD VSS sg13g2_decap_8
X_08402_ _08402_/Y _08402_/A _08402_/B _08402_/C wire681/A VDD VSS sg13g2_nor4_1
XFILLER_52_646 VDD VSS sg13g2_decap_8
XFILLER_51_123 VDD VSS sg13g2_decap_8
X_09382_ _13985_/D _09945_/A1 _13985_/Q _09396_/S VDD VSS sg13g2_mux2_1
XFILLER_36_1224 VDD VSS sg13g2_decap_8
X_08333_ _08333_/Y _08560_/A _08149_/Y _08241_/Y VDD VSS sg13g2_o21ai_1
XFILLER_75_1284 VDD VSS sg13g2_decap_4
XFILLER_127_1396 VDD VSS sg13g2_decap_8
XFILLER_162_1276 VDD VSS sg13g2_fill_1
XFILLER_177_364 VDD VSS sg13g2_decap_8
X_08264_ _08264_/Y _07927_/Y _07930_/A _08290_/S VDD VSS sg13g2_a21oi_1
XFILLER_71_1159 VDD VSS sg13g2_decap_8
XFILLER_123_1249 VDD VSS sg13g2_decap_4
X_08195_ _08195_/Y _08194_/B _08085_/A _08194_/Y VDD VSS sg13g2_o21ai_1
XFILLER_20_598 VDD VSS sg13g2_decap_8
XFILLER_180_518 VDD VSS sg13g2_decap_8
XFILLER_119_998 VDD VSS sg13g2_fill_2
XFILLER_69_1033 VDD VSS sg13g2_decap_8
XFILLER_173_570 VDD VSS sg13g2_decap_4
XFILLER_118_486 VDD VSS sg13g2_decap_8
XFILLER_106_637 VDD VSS sg13g2_decap_8
XFILLER_118_497 VDD VSS sg13g2_fill_1
XFILLER_161_732 VDD VSS sg13g2_decap_8
XFILLER_10_35 VDD VSS sg13g2_decap_8
XFILLER_156_1025 VDD VSS sg13g2_decap_8
XFILLER_161_743 VDD VSS sg13g2_fill_1
XFILLER_160_231 VDD VSS sg13g2_decap_8
XFILLER_0_904 VDD VSS sg13g2_decap_8
XFILLER_126_35 VDD VSS sg13g2_decap_8
XFILLER_47_1331 VDD VSS sg13g2_fill_2
XFILLER_114_670 VDD VSS sg13g2_decap_8
XFILLER_120_117 VDD VSS sg13g2_decap_8
Xfanout1009 _13401_/C _10199_/A1 VDD VSS sg13g2_buf_1
XFILLER_47_1364 VDD VSS sg13g2_decap_8
XFILLER_102_832 VDD VSS sg13g2_decap_8
XFILLER_87_521 VDD VSS sg13g2_decap_8
XFILLER_173_1383 VDD VSS sg13g2_decap_8
XFILLER_101_331 VDD VSS sg13g2_fill_2
XFILLER_134_1356 VDD VSS sg13g2_decap_8
XFILLER_43_1239 VDD VSS sg13g2_decap_8
XFILLER_102_876 VDD VSS sg13g2_decap_8
XFILLER_101_364 VDD VSS sg13g2_decap_8
XFILLER_87_598 VDD VSS sg13g2_decap_4
X_07979_ _07979_/Y _07979_/A _07981_/C _07979_/C VDD VSS sg13g2_nand3_1
XFILLER_74_215 VDD VSS sg13g2_decap_8
XFILLER_19_77 VDD VSS sg13g2_decap_8
X_09718_ _14309_/D _09916_/A1 _14309_/Q _09731_/S VDD VSS sg13g2_mux2_1
XFILLER_28_643 VDD VSS sg13g2_decap_4
XFILLER_132_1091 VDD VSS sg13g2_decap_8
X_14503__1769 _14503_/RESET_B VDD VSS sg13g2_tiehi
X_10990_ _11009_/C _15116_/Q _10995_/B VDD VSS sg13g2_xnor2_1
XFILLER_55_440 VDD VSS sg13g2_decap_8
XFILLER_27_142 VDD VSS sg13g2_decap_8
X_09649_ _14242_/D _09913_/A1 _14242_/Q _09670_/S VDD VSS sg13g2_mux2_1
XFILLER_35_21 VDD VSS sg13g2_decap_8
XFILLER_28_698 VDD VSS sg13g2_fill_2
XFILLER_15_315 VDD VSS sg13g2_decap_8
XFILLER_42_112 VDD VSS sg13g2_fill_2
XFILLER_82_292 VDD VSS sg13g2_decap_8
XFILLER_76_1059 VDD VSS sg13g2_decap_8
XFILLER_43_657 VDD VSS sg13g2_fill_1
X_12660_ _12660_/X _14385_/Q _14417_/Q _14481_/Q _14513_/Q _12661_/S0 _12661_/S1 VDD
+ VSS sg13g2_mux4_1
XFILLER_58_1471 VDD VSS sg13g2_decap_8
XFILLER_169_843 VDD VSS sg13g2_decap_8
X_11611_ _11611_/Y _11621_/S0 _14470_/Q VDD VSS sg13g2_nand2b_1
XFILLER_93_1373 VDD VSS sg13g2_decap_8
XFILLER_19_1455 VDD VSS sg13g2_decap_8
XFILLER_54_1335 VDD VSS sg13g2_decap_4
XFILLER_168_331 VDD VSS sg13g2_decap_8
X_12591_ _12591_/X _13836_/Q _13868_/Q _13900_/Q _13932_/Q _12591_/S0 _12591_/S1 VDD
+ VSS sg13g2_mux4_1
XFILLER_11_532 VDD VSS sg13g2_decap_8
XFILLER_15_1319 VDD VSS sg13g2_decap_8
X_14330_ _14330_/Q _14620_/CLK _14330_/D _14330_/RESET_B VDD VSS sg13g2_dfrbpq_1
X_11542_ _11542_/X _11542_/A _11542_/B VDD VSS sg13g2_and2_1
XFILLER_51_31 VDD VSS sg13g2_decap_8
XFILLER_141_1338 VDD VSS sg13g2_decap_8
XFILLER_169_898 VDD VSS sg13g2_fill_1
XFILLER_183_301 VDD VSS sg13g2_decap_8
XFILLER_7_525 VDD VSS sg13g2_decap_8
XFILLER_52_1070 VDD VSS sg13g2_fill_2
XFILLER_129_0 VDD VSS sg13g2_decap_8
XFILLER_167_42 VDD VSS sg13g2_decap_8
X_14261_ _14261_/Q clkload30/A _14261_/D _14261_/RESET_B VDD VSS sg13g2_dfrbpq_1
X_11473_ _11473_/X _14689_/Q _14721_/Q _13761_/Q _13793_/Q _11489_/S0 _11489_/S1 VDD
+ VSS sg13g2_mux4_1
XFILLER_104_1160 VDD VSS sg13g2_decap_8
XFILLER_13_1043 VDD VSS sg13g2_decap_8
XFILLER_52_1092 VDD VSS sg13g2_decap_8
XFILLER_137_762 VDD VSS sg13g2_fill_2
XFILLER_171_518 VDD VSS sg13g2_fill_2
X_13212_ _13228_/A _14921_/Q _13666_/Q VDD VSS sg13g2_nand2_1
XFILLER_183_378 VDD VSS sg13g2_decap_8
X_10424_ _10521_/C _10647_/A _10647_/D VDD VSS sg13g2_and2_1
X_14192_ _14192_/Q clkload10/A _14192_/D _14192_/RESET_B VDD VSS sg13g2_dfrbpq_1
XFILLER_137_795 VDD VSS sg13g2_fill_1
XFILLER_139_1223 VDD VSS sg13g2_fill_2
XFILLER_100_1068 VDD VSS sg13g2_fill_2
X_13143_ _13170_/C _14916_/Q _13671_/Q VDD VSS sg13g2_xnor2_1
XFILLER_125_968 VDD VSS sg13g2_decap_8
X_10355_ _10395_/A _14809_/Q _14810_/Q _14811_/Q VDD VSS sg13g2_nand3_1
XFILLER_48_1139 VDD VSS sg13g2_decap_8
XFILLER_3_742 VDD VSS sg13g2_decap_8
XFILLER_111_106 VDD VSS sg13g2_decap_4
XFILLER_174_1169 VDD VSS sg13g2_decap_4
XFILLER_183_63 VDD VSS sg13g2_decap_8
X_13074_ _15037_/D _13067_/Y _13073_/Y _13127_/A VDD VSS sg13g2_a21oi_1
X_10286_ _14789_/D _10286_/A _10288_/B _10423_/C VDD VSS sg13g2_and3_1
XFILLER_2_252 VDD VSS sg13g2_decap_8
XFILLER_26_1404 VDD VSS sg13g2_decap_8
X_12025_ _12026_/B _12025_/A _14674_/Q VDD VSS sg13g2_nand2_1
XFILLER_116_90 VDD VSS sg13g2_decap_8
XFILLER_93_502 VDD VSS sg13g2_decap_8
XFILLER_18_7 VDD VSS sg13g2_decap_8
XFILLER_4_1211 VDD VSS sg13g2_decap_8
XFILLER_19_643 VDD VSS sg13g2_decap_8
XFILLER_65_248 VDD VSS sg13g2_fill_2
XFILLER_24_1183 VDD VSS sg13g2_decap_8
X_13976_ _13976_/Q clkload24/A _13976_/D _13976_/RESET_B VDD VSS sg13g2_dfrbpq_1
XFILLER_20_1036 VDD VSS sg13g2_decap_8
XFILLER_81_719 VDD VSS sg13g2_decap_8
XFILLER_185_1210 VDD VSS sg13g2_decap_8
XFILLER_4_1288 VDD VSS sg13g2_decap_8
X_12927_ _12944_/B _12943_/A _12988_/A _12943_/D VDD VSS sg13g2_or3_1
XFILLER_98_1284 VDD VSS sg13g2_decap_4
XFILLER_94_1115 VDD VSS sg13g2_decap_8
XFILLER_18_175 VDD VSS sg13g2_decap_8
XFILLER_33_112 VDD VSS sg13g2_decap_8
XFILLER_185_1276 VDD VSS sg13g2_fill_2
X_12858_ _12874_/A _12859_/A _13689_/Q VDD VSS sg13g2_and2_1
XFILLER_146_1249 VDD VSS sg13g2_fill_2
XFILLER_181_1129 VDD VSS sg13g2_decap_8
XFILLER_185_1298 VDD VSS sg13g2_decap_8
XFILLER_62_999 VDD VSS sg13g2_decap_8
X_11809_ _11809_/Y _12103_/A1 _14572_/Q VDD VSS sg13g2_nand2b_1
XFILLER_72_1424 VDD VSS sg13g2_decap_4
X_14658__1614 _14658_/RESET_B VDD VSS sg13g2_tiehi
XFILLER_33_189 VDD VSS sg13g2_fill_1
X_12789_ _12789_/X _12785_/X _12784_/X _12781_/X _12780_/X _12789_/S0 _12789_/S1 VDD
+ VSS sg13g2_mux4_1
XFILLER_109_1071 VDD VSS sg13g2_decap_8
XFILLER_72_1457 VDD VSS sg13g2_decap_8
XFILLER_14_392 VDD VSS sg13g2_decap_8
X_14528_ _14528_/Q clkload46/A _14528_/D _14528_/RESET_B VDD VSS sg13g2_dfrbpq_1
XFILLER_109_1093 VDD VSS sg13g2_decap_8
XFILLER_119_239 VDD VSS sg13g2_decap_8
X_14087__2185 _14087_/RESET_B VDD VSS sg13g2_tiehi
XFILLER_31_1121 VDD VSS sg13g2_decap_8
XFILLER_174_345 VDD VSS sg13g2_decap_8
X_14459_ _14459_/Q _14883_/CLK _14459_/D _14459_/RESET_B VDD VSS sg13g2_dfrbpq_1
XFILLER_179_1036 VDD VSS sg13g2_decap_8
XFILLER_128_762 VDD VSS sg13g2_decap_8
XFILLER_127_250 VDD VSS sg13g2_decap_4
XFILLER_31_1187 VDD VSS sg13g2_fill_2
XFILLER_115_423 VDD VSS sg13g2_decap_8
XFILLER_143_732 VDD VSS sg13g2_decap_8
XFILLER_116_979 VDD VSS sg13g2_decap_8
XFILLER_157_1345 VDD VSS sg13g2_decap_8
X_15026__2654 _15026_/RESET_B VDD VSS sg13g2_tiehi
XFILLER_142_242 VDD VSS sg13g2_decap_8
XFILLER_44_0 VDD VSS sg13g2_decap_8
XFILLER_130_404 VDD VSS sg13g2_fill_2
Xhold3117 input4/A mem_axi_rdata[0] VDD VSS sg13g2_dlygate4sd3_1
XFILLER_115_489 VDD VSS sg13g2_decap_8
X_08951_ _08951_/Y _12278_/A _08940_/S _08950_/Y VDD VSS sg13g2_a21oi_1
Xhold3128 input5/A mem_axi_rdata[10] VDD VSS sg13g2_dlygate4sd3_1
Xhold3139 hold3139/X input30/X VDD VSS sg13g2_dlygate4sd3_1
XFILLER_29_1061 VDD VSS sg13g2_decap_8
X_14843__2951 _14843_/RESET_B VDD VSS sg13g2_tiehi
X_07902_ _08074_/B _08063_/A _07903_/B _07884_/Y VDD VSS sg13g2_o21ai_1
XFILLER_111_640 VDD VSS sg13g2_decap_8
X_08882_ _08882_/X _08881_/X _08882_/A1 _08940_/S VDD VSS sg13g2_mux2_1
XFILLER_9_1155 VDD VSS sg13g2_decap_8
XFILLER_5_1008 VDD VSS sg13g2_decap_8
XFILLER_116_1064 VDD VSS sg13g2_decap_8
X_14750__3059 _14750_/RESET_B VDD VSS sg13g2_tiehi
X_07833_ _07981_/C _08692_/C _08692_/B VDD VSS sg13g2_nand2b_1
XFILLER_97_896 VDD VSS sg13g2_fill_2
XFILLER_57_738 VDD VSS sg13g2_decap_8
XFILLER_42_1250 VDD VSS sg13g2_decap_8
XFILLER_2_91 VDD VSS sg13g2_decap_8
X_07764_ _15216_/D _15098_/Q _15087_/Q _15074_/Q VDD VSS sg13g2_or3_1
XFILLER_77_1302 VDD VSS sg13g2_decap_8
X_14876__2885 _14876_/RESET_B VDD VSS sg13g2_tiehi
X_09503_ _14103_/D _10066_/A0 _14103_/Q _09505_/S VDD VSS sg13g2_mux2_1
XFILLER_129_1403 VDD VSS sg13g2_decap_4
X_07695_ _07696_/C _15079_/Q _15082_/Q _07694_/Y VDD VSS sg13g2_o21ai_1
XFILLER_164_1305 VDD VSS sg13g2_decap_8
XFILLER_129_1425 VDD VSS sg13g2_decap_8
XFILLER_25_646 VDD VSS sg13g2_decap_8
X_09434_ _14036_/D _09997_/A0 _14036_/Q _09440_/S VDD VSS sg13g2_mux2_1
X_14297__1975 _14297_/RESET_B VDD VSS sg13g2_tiehi
XFILLER_77_1379 VDD VSS sg13g2_decap_8
XFILLER_13_819 VDD VSS sg13g2_decap_8
XFILLER_164_1338 VDD VSS sg13g2_decap_8
XFILLER_164_1349 VDD VSS sg13g2_fill_2
XFILLER_80_785 VDD VSS sg13g2_decap_4
XFILLER_52_487 VDD VSS sg13g2_decap_8
XFILLER_12_329 VDD VSS sg13g2_decap_8
X_09365_ _13969_/D _09596_/A1 _13969_/Q _09365_/S VDD VSS sg13g2_mux2_1
XFILLER_162_1051 VDD VSS sg13g2_fill_1
XFILLER_138_504 VDD VSS sg13g2_decap_8
X_08316_ _08316_/Y _08275_/A _08303_/Y _08304_/Y VDD VSS sg13g2_o21ai_1
XFILLER_127_1182 VDD VSS sg13g2_decap_8
XFILLER_138_515 VDD VSS sg13g2_fill_2
XANTENNA_30 _16881_/A VDD VSS sg13g2_antennanp
XFILLER_123_1024 VDD VSS sg13g2_decap_8
XFILLER_177_161 VDD VSS sg13g2_decap_8
X_09296_ _13904_/D _13904_/Q _09927_/A1 _09298_/S VDD VSS sg13g2_mux2_1
XFILLER_14_1330 VDD VSS sg13g2_decap_8
XFILLER_165_334 VDD VSS sg13g2_decap_8
X_08247_ _08319_/C _08247_/A _08247_/B _08247_/C VDD VSS sg13g2_nor3_1
XFILLER_122_7 VDD VSS sg13g2_decap_8
XFILLER_165_345 VDD VSS sg13g2_fill_1
X_13752__2520 _13752_/RESET_B VDD VSS sg13g2_tiehi
XFILLER_140_1360 VDD VSS sg13g2_fill_1
XFILLER_119_773 VDD VSS sg13g2_decap_4
XFILLER_140_1371 VDD VSS sg13g2_fill_2
XFILLER_165_389 VDD VSS sg13g2_decap_4
XFILLER_180_315 VDD VSS sg13g2_decap_8
XFILLER_181_849 VDD VSS sg13g2_decap_8
XFILLER_21_56 VDD VSS sg13g2_decap_8
X_08178_ _08178_/Y _08060_/X _08029_/Y _08340_/A _08177_/X VDD VSS sg13g2_a22oi_1
XFILLER_107_946 VDD VSS sg13g2_decap_8
XFILLER_4_539 VDD VSS sg13g2_decap_8
XFILLER_101_1377 VDD VSS sg13g2_decap_8
X_10140_ _14717_/D _14717_/Q _10140_/A1 _10169_/S VDD VSS sg13g2_mux2_1
XFILLER_175_1478 VDD VSS sg13g2_fill_1
X_14132__2140 _14132_/RESET_B VDD VSS sg13g2_tiehi
X_13785__2487 _13785_/RESET_B VDD VSS sg13g2_tiehi
X_10071_ _14651_/D _10071_/A0 _14651_/Q _10096_/S VDD VSS sg13g2_mux2_1
XFILLER_82_1052 VDD VSS sg13g2_decap_8
XFILLER_0_778 VDD VSS sg13g2_decap_8
XFILLER_101_150 VDD VSS sg13g2_fill_2
X_14736__1536 _14736_/RESET_B VDD VSS sg13g2_tiehi
XFILLER_75_524 VDD VSS sg13g2_decap_4
XFILLER_48_749 VDD VSS sg13g2_decap_4
XFILLER_130_1039 VDD VSS sg13g2_decap_8
XFILLER_21_1312 VDD VSS sg13g2_decap_8
XFILLER_75_546 VDD VSS sg13g2_decap_4
X_13830_ _13830_/Q _14726_/CLK _13830_/D _13830_/RESET_B VDD VSS sg13g2_dfrbpq_1
XFILLER_60_1372 VDD VSS sg13g2_decap_8
XFILLER_75_568 VDD VSS sg13g2_decap_8
XFILLER_112_1451 VDD VSS sg13g2_decap_4
XFILLER_112_1462 VDD VSS sg13g2_fill_2
XFILLER_16_602 VDD VSS sg13g2_decap_8
XFILLER_1_1428 VDD VSS sg13g2_decap_8
XFILLER_44_911 VDD VSS sg13g2_fill_2
XFILLER_46_64 VDD VSS sg13g2_fill_2
X_13761_ _13761_/Q _14745_/CLK _13761_/D _13761_/RESET_B VDD VSS sg13g2_dfrbpq_1
Xclkbuf_5_26__f_clk_i clkbuf_leaf_59_clk_i/A clkbuf_4_13_0_clk_i/X VDD VSS sg13g2_buf_16
X_10973_ _10973_/Y _14940_/Q _11196_/B VDD VSS sg13g2_nand2_1
XFILLER_15_112 VDD VSS sg13g2_decap_8
XFILLER_21_1389 VDD VSS sg13g2_decap_8
XFILLER_95_1457 VDD VSS sg13g2_decap_8
XFILLER_56_1408 VDD VSS sg13g2_fill_2
X_12712_ _12712_/X _14581_/Q _14613_/Q _14645_/Q _14677_/Q _12715_/S0 _12715_/S1 VDD
+ VSS sg13g2_mux4_1
XFILLER_56_1419 VDD VSS sg13g2_decap_8
X_13692_ _13692_/Q _15182_/CLK _13692_/D _13692_/RESET_B VDD VSS sg13g2_dfrbpq_1
XFILLER_43_454 VDD VSS sg13g2_decap_8
XFILLER_16_679 VDD VSS sg13g2_decap_8
X_12643_ _12643_/X _14256_/Q _14288_/Q _14320_/Q _14352_/Q _12643_/S0 _12643_/S1 VDD
+ VSS sg13g2_mux4_1
XFILLER_15_189 VDD VSS sg13g2_decap_8
XFILLER_19_1252 VDD VSS sg13g2_decap_8
XFILLER_31_649 VDD VSS sg13g2_decap_8
XFILLER_54_1143 VDD VSS sg13g2_fill_2
XFILLER_15_1116 VDD VSS sg13g2_decap_8
XFILLER_169_673 VDD VSS sg13g2_decap_8
XFILLER_156_301 VDD VSS sg13g2_decap_8
XFILLER_168_161 VDD VSS sg13g2_decap_4
XFILLER_178_63 VDD VSS sg13g2_decap_8
XFILLER_180_1173 VDD VSS sg13g2_decap_8
X_12574_ _12574_/X _13963_/Q _13995_/Q _14027_/Q _14059_/Q _12600_/S0 _12600_/S1 VDD
+ VSS sg13g2_mux4_1
XFILLER_8_812 VDD VSS sg13g2_decap_8
XFILLER_106_1255 VDD VSS sg13g2_decap_8
XFILLER_7_14 VDD VSS sg13g2_decap_8
X_14313_ _14313_/Q clkload34/A _14313_/D _14313_/RESET_B VDD VSS sg13g2_dfrbpq_1
Xwire220 wire220/X wire220/A VDD VSS sg13g2_buf_2
XFILLER_106_1277 VDD VSS sg13g2_decap_8
XFILLER_12_896 VDD VSS sg13g2_decap_8
XFILLER_184_643 VDD VSS sg13g2_decap_8
Xwire231 wire231/X wire231/A VDD VSS sg13g2_buf_4
X_11525_ _11638_/A _11526_/A _12942_/B VDD VSS sg13g2_nor2_1
XFILLER_7_322 VDD VSS sg13g2_decap_8
XFILLER_32_1430 VDD VSS sg13g2_fill_1
XFILLER_144_507 VDD VSS sg13g2_decap_8
X_14342__1930 _14342_/RESET_B VDD VSS sg13g2_tiehi
XFILLER_89_1239 VDD VSS sg13g2_decap_8
X_14244_ _14244_/Q clkload33/A _14244_/D _14244_/RESET_B VDD VSS sg13g2_dfrbpq_1
Xwire275 wire275/X wire275/A VDD VSS sg13g2_buf_2
XFILLER_8_889 VDD VSS sg13g2_decap_8
XFILLER_183_175 VDD VSS sg13g2_decap_8
X_11456_ _11458_/B _11457_/A _11457_/B _11457_/C VDD VSS sg13g2_a21oi_1
XFILLER_109_272 VDD VSS sg13g2_decap_8
XFILLER_165_890 VDD VSS sg13g2_fill_1
XFILLER_7_399 VDD VSS sg13g2_decap_8
XFILLER_125_743 VDD VSS sg13g2_decap_8
X_10407_ _10407_/Y _14823_/Q _14824_/Q _14825_/Q _10413_/B VDD VSS sg13g2_nand4_1
X_14175_ _14175_/Q clkload21/A _14175_/D _14175_/RESET_B VDD VSS sg13g2_dfrbpq_1
XFILLER_139_1042 VDD VSS sg13g2_decap_8
X_11387_ _14960_/D _11384_/A _11248_/B _11386_/Y VDD VSS sg13g2_a21o_1
XFILLER_180_871 VDD VSS sg13g2_fill_2
XFILLER_112_404 VDD VSS sg13g2_fill_2
X_13126_ _13127_/B _13166_/A1 _13125_/X _13120_/X _13160_/B _13124_/Y VDD VSS sg13g2_a221oi_1
XFILLER_152_584 VDD VSS sg13g2_decap_8
X_10338_ _10345_/D _14803_/Q _14804_/Q _14805_/Q _14806_/Q VDD VSS sg13g2_and4_1
XFILLER_124_286 VDD VSS sg13g2_decap_4
XFILLER_26_1201 VDD VSS sg13g2_decap_8
XFILLER_140_746 VDD VSS sg13g2_decap_4
XFILLER_112_448 VDD VSS sg13g2_fill_2
X_13057_ _13058_/B _13057_/A _13057_/B _13057_/C VDD VSS sg13g2_and3_1
XFILLER_117_1351 VDD VSS sg13g2_fill_1
X_14375__1897 _14375_/RESET_B VDD VSS sg13g2_tiehi
X_10269_ _14784_/D _10269_/A _10299_/B _10423_/C VDD VSS sg13g2_and3_1
XFILLER_79_863 VDD VSS sg13g2_fill_2
XFILLER_61_1125 VDD VSS sg13g2_decap_8
XFILLER_121_971 VDD VSS sg13g2_decap_8
Xfanout1340 _11598_/C _11742_/C VDD VSS sg13g2_buf_1
XFILLER_87_93 VDD VSS sg13g2_decap_8
X_12008_ _12008_/Y _12009_/A _13670_/Q VDD VSS sg13g2_nor2_1
Xfanout1351 _11401_/C _11821_/S1 VDD VSS sg13g2_buf_1
Xfanout1362 _11262_/B _12319_/B1 VDD VSS sg13g2_buf_1
XFILLER_78_384 VDD VSS sg13g2_decap_8
XFILLER_26_1278 VDD VSS sg13g2_decap_8
Xfanout1373 _12284_/S1 _12288_/S1 VDD VSS sg13g2_buf_1
Xfanout1384 _11948_/S _11951_/A VDD VSS sg13g2_buf_1
XFILLER_94_855 VDD VSS sg13g2_fill_1
Xfanout1395 fanout1395/X fanout1410/X VDD VSS sg13g2_buf_1
XFILLER_47_760 VDD VSS sg13g2_decap_8
XFILLER_35_911 VDD VSS sg13g2_decap_4
XFILLER_59_1010 VDD VSS sg13g2_decap_8
XFILLER_19_473 VDD VSS sg13g2_decap_8
X_13830__2442 _13830_/RESET_B VDD VSS sg13g2_tiehi
X_13959_ _13959_/Q _14607_/CLK _13959_/D _13959_/RESET_B VDD VSS sg13g2_dfrbpq_1
XFILLER_81_538 VDD VSS sg13g2_decap_4
XFILLER_4_1085 VDD VSS sg13g2_decap_8
X_14590__1682 _14590_/RESET_B VDD VSS sg13g2_tiehi
XFILLER_46_281 VDD VSS sg13g2_decap_8
XFILLER_59_1054 VDD VSS sg13g2_decap_4
XFILLER_46_292 VDD VSS sg13g2_fill_1
XFILLER_50_903 VDD VSS sg13g2_fill_2
XFILLER_185_1073 VDD VSS sg13g2_decap_8
XFILLER_179_448 VDD VSS sg13g2_decap_8
XFILLER_21_126 VDD VSS sg13g2_decap_8
XFILLER_124_1322 VDD VSS sg13g2_decap_8
X_09150_ _09156_/B _14923_/Q _09150_/B _09150_/C _09157_/D VDD VSS sg13g2_nand4_1
XFILLER_148_824 VDD VSS sg13g2_decap_8
XFILLER_175_610 VDD VSS sg13g2_decap_4
XFILLER_33_1216 VDD VSS sg13g2_decap_8
X_14210__2062 _14210_/RESET_B VDD VSS sg13g2_tiehi
XFILLER_72_1276 VDD VSS sg13g2_decap_8
XFILLER_159_172 VDD VSS sg13g2_decap_8
X_08101_ _08101_/Y _12360_/A1 _07879_/A _07884_/A VDD VSS sg13g2_a21oi_1
X_09081_ _09087_/B _14913_/Q _13088_/A _09103_/C VDD VSS sg13g2_nand3_1
XFILLER_147_378 VDD VSS sg13g2_decap_4
XFILLER_163_827 VDD VSS sg13g2_decap_8
X_08032_ _08032_/Y _08201_/A _08104_/B _08032_/C _08032_/D VDD VSS sg13g2_nor4_1
XFILLER_159_1429 VDD VSS sg13g2_decap_8
XFILLER_174_175 VDD VSS sg13g2_decap_8
XFILLER_175_698 VDD VSS sg13g2_decap_8
Xmax_cap520 _09365_/S _09366_/S VDD VSS sg13g2_buf_8
XFILLER_162_348 VDD VSS sg13g2_decap_8
XFILLER_116_754 VDD VSS sg13g2_decap_4
XFILLER_115_231 VDD VSS sg13g2_decap_4
XFILLER_115_242 VDD VSS sg13g2_decap_8
XFILLER_143_551 VDD VSS sg13g2_decap_8
XFILLER_116_776 VDD VSS sg13g2_decap_8
XFILLER_104_927 VDD VSS sg13g2_decap_8
XFILLER_88_104 VDD VSS sg13g2_decap_8
XFILLER_104_949 VDD VSS sg13g2_fill_1
X_09983_ _14566_/D _10082_/A0 _14566_/Q _09990_/S VDD VSS sg13g2_mux2_1
XFILLER_131_735 VDD VSS sg13g2_decap_8
XFILLER_170_381 VDD VSS sg13g2_fill_2
XFILLER_130_223 VDD VSS sg13g2_decap_8
X_08934_ _08934_/X _08933_/X _12128_/A _08937_/S VDD VSS sg13g2_mux2_1
XFILLER_88_148 VDD VSS sg13g2_decap_8
XFILLER_83_1372 VDD VSS sg13g2_decap_8
XFILLER_131_1304 VDD VSS sg13g2_decap_8
XFILLER_57_502 VDD VSS sg13g2_decap_8
XFILLER_130_289 VDD VSS sg13g2_decap_8
XFILLER_131_1315 VDD VSS sg13g2_fill_2
X_08865_ _08865_/Y _10694_/S _14934_/Q VDD VSS sg13g2_nor2b_1
XFILLER_123_14 VDD VSS sg13g2_decap_8
XFILLER_96_170 VDD VSS sg13g2_decap_8
XFILLER_29_226 VDD VSS sg13g2_decap_4
XFILLER_170_1397 VDD VSS sg13g2_decap_8
XFILLER_57_546 VDD VSS sg13g2_decap_8
X_07816_ _07816_/X _15010_/Q _07818_/B VDD VSS sg13g2_and2_1
XFILLER_123_58 VDD VSS sg13g2_fill_1
XFILLER_45_708 VDD VSS sg13g2_fill_1
X_08796_ _13683_/D _08796_/A _08796_/B VDD VSS sg13g2_nor2_1
XFILLER_83_18 VDD VSS sg13g2_fill_2
X_07747_ _13320_/C _13499_/C _13303_/A VDD VSS sg13g2_nand2_1
XFILLER_129_1200 VDD VSS sg13g2_decap_4
X_14420__1852 _14420_/RESET_B VDD VSS sg13g2_tiehi
XFILLER_53_741 VDD VSS sg13g2_decap_4
XFILLER_37_292 VDD VSS sg13g2_decap_8
XFILLER_26_955 VDD VSS sg13g2_fill_1
XFILLER_38_1105 VDD VSS sg13g2_decap_8
XFILLER_0_1450 VDD VSS sg13g2_decap_8
XFILLER_26_977 VDD VSS sg13g2_decap_8
XFILLER_16_56 VDD VSS sg13g2_decap_8
X_07678_ _07679_/D _13293_/A _13438_/A _11243_/C VDD VSS sg13g2_nand3b_1
XFILLER_129_1244 VDD VSS sg13g2_decap_4
XFILLER_13_616 VDD VSS sg13g2_decap_8
XFILLER_164_1135 VDD VSS sg13g2_decap_8
XFILLER_77_1187 VDD VSS sg13g2_decap_8
X_09417_ _14019_/D _09582_/A1 _14019_/Q _09429_/S VDD VSS sg13g2_mux2_1
XFILLER_129_1277 VDD VSS sg13g2_decap_8
XFILLER_52_273 VDD VSS sg13g2_decap_8
XFILLER_129_1288 VDD VSS sg13g2_fill_1
XFILLER_41_958 VDD VSS sg13g2_decap_8
XFILLER_40_424 VDD VSS sg13g2_decap_8
XFILLER_12_126 VDD VSS sg13g2_decap_8
XFILLER_90_1332 VDD VSS sg13g2_decap_8
XFILLER_139_802 VDD VSS sg13g2_decap_4
XFILLER_9_609 VDD VSS sg13g2_decap_8
X_09348_ _13952_/D _10076_/A0 _13952_/Q _09363_/S VDD VSS sg13g2_mux2_1
XFILLER_16_1447 VDD VSS sg13g2_decap_8
XFILLER_8_119 VDD VSS sg13g2_decap_8
XFILLER_103_1406 VDD VSS sg13g2_decap_8
XFILLER_166_643 VDD VSS sg13g2_decap_8
X_09279_ _13887_/D _13887_/Q _10109_/A0 _09294_/S VDD VSS sg13g2_mux2_1
XFILLER_166_665 VDD VSS sg13g2_fill_1
XFILLER_32_77 VDD VSS sg13g2_decap_8
XFILLER_181_602 VDD VSS sg13g2_decap_8
X_11310_ _11310_/Y _11320_/S0 _14525_/Q _11894_/B VDD VSS sg13g2_a21oi_1
X_12290_ _12291_/B _12281_/X _12282_/X _12285_/X _12286_/X _11443_/A _11446_/A VDD
+ VSS sg13g2_mux4_1
XFILLER_5_826 VDD VSS sg13g2_decap_8
XFILLER_180_112 VDD VSS sg13g2_decap_8
XFILLER_107_743 VDD VSS sg13g2_decap_8
XFILLER_88_1261 VDD VSS sg13g2_decap_8
X_11241_ _11245_/A _11241_/A _11243_/C _11241_/C VDD VSS sg13g2_nand3_1
XFILLER_4_336 VDD VSS sg13g2_decap_8
XFILLER_10_1057 VDD VSS sg13g2_decap_8
XFILLER_88_1272 VDD VSS sg13g2_fill_2
XFILLER_175_1231 VDD VSS sg13g2_decap_8
XFILLER_181_679 VDD VSS sg13g2_decap_8
XFILLER_88_1283 VDD VSS sg13g2_fill_2
XFILLER_134_562 VDD VSS sg13g2_decap_8
XFILLER_164_21 VDD VSS sg13g2_decap_8
XFILLER_175_1253 VDD VSS sg13g2_decap_8
XFILLER_49_1256 VDD VSS sg13g2_decap_8
XFILLER_136_1215 VDD VSS sg13g2_fill_2
XFILLER_162_882 VDD VSS sg13g2_decap_8
XFILLER_180_189 VDD VSS sg13g2_decap_8
X_11172_ _11197_/A _11172_/A _11181_/A VDD VSS sg13g2_xnor2_1
XFILLER_136_1226 VDD VSS sg13g2_decap_8
XFILLER_136_1237 VDD VSS sg13g2_fill_1
XFILLER_62_1401 VDD VSS sg13g2_decap_8
X_10123_ _14701_/D _10156_/A1 _14701_/Q _10127_/S VDD VSS sg13g2_mux2_1
XFILLER_0_553 VDD VSS sg13g2_decap_8
XFILLER_103_971 VDD VSS sg13g2_decap_8
X_14931_ _14931_/Q clkload79/A _14931_/D _14931_/RESET_B VDD VSS sg13g2_dfrbpq_1
X_10054_ _14635_/D _10087_/A0 _14635_/Q _10060_/S VDD VSS sg13g2_mux2_1
XFILLER_23_1407 VDD VSS sg13g2_decap_8
X_14957__2723 _14957_/RESET_B VDD VSS sg13g2_tiehi
XFILLER_130_790 VDD VSS sg13g2_fill_2
XFILLER_180_42 VDD VSS sg13g2_decap_8
X_14862_ _14862_/Q clkload66/A _14862_/D _14862_/RESET_B VDD VSS sg13g2_dfrbpq_1
XFILLER_17_900 VDD VSS sg13g2_decap_8
XFILLER_60_1180 VDD VSS sg13g2_decap_8
XFILLER_5_1372 VDD VSS sg13g2_decap_8
X_13813_ _13813_/Q _14503_/CLK _13813_/D _13813_/RESET_B VDD VSS sg13g2_dfrbpq_1
XFILLER_1_1225 VDD VSS sg13g2_decap_8
X_14793_ _14793_/Q _14890_/CLK _14793_/D _14793_/RESET_B VDD VSS sg13g2_dfrbpq_1
XFILLER_90_335 VDD VSS sg13g2_fill_1
XFILLER_63_549 VDD VSS sg13g2_decap_8
XFILLER_17_955 VDD VSS sg13g2_decap_8
XFILLER_21_1186 VDD VSS sg13g2_decap_8
XFILLER_17_977 VDD VSS sg13g2_decap_8
X_13744_ _13744_/Q clkload14/A _13744_/D _13744_/RESET_B VDD VSS sg13g2_dfrbpq_1
XFILLER_95_1254 VDD VSS sg13g2_fill_1
X_10956_ _10956_/Y _10956_/A _10956_/B _11044_/C VDD VSS sg13g2_nand3_1
XFILLER_32_903 VDD VSS sg13g2_decap_8
XFILLER_91_1107 VDD VSS sg13g2_decap_8
XFILLER_44_774 VDD VSS sg13g2_decap_8
XFILLER_16_476 VDD VSS sg13g2_decap_8
X_13675_ _13675_/Q clkload65/A _13675_/D _13675_/RESET_B VDD VSS sg13g2_dfrbpq_1
XFILLER_71_593 VDD VSS sg13g2_decap_8
XFILLER_182_1268 VDD VSS sg13g2_decap_8
X_10887_ _14933_/D _10886_/X _10885_/Y _10875_/Y VDD VSS sg13g2_o21ai_1
X_12626_ _12626_/X _14127_/Q _14159_/Q _14191_/Q _14223_/Q _12633_/S0 _12633_/S1 VDD
+ VSS sg13g2_mux4_1
XFILLER_145_1090 VDD VSS sg13g2_decap_8
XFILLER_106_1063 VDD VSS sg13g2_fill_2
XFILLER_12_693 VDD VSS sg13g2_decap_8
X_12557_ _12557_/X _13834_/Q _13866_/Q _13898_/Q _13930_/Q _12668_/S0 _12668_/S1 VDD
+ VSS sg13g2_mux4_1
XFILLER_129_356 VDD VSS sg13g2_decap_4
XFILLER_106_1085 VDD VSS sg13g2_decap_8
XFILLER_157_676 VDD VSS sg13g2_decap_8
XFILLER_106_1096 VDD VSS sg13g2_fill_1
X_11508_ _11508_/X _14691_/Q _14723_/Q _13763_/Q _13795_/Q _12284_/S0 _12284_/S1 VDD
+ VSS sg13g2_mux4_1
XFILLER_156_175 VDD VSS sg13g2_decap_8
XFILLER_8_686 VDD VSS sg13g2_decap_8
XFILLER_89_1047 VDD VSS sg13g2_decap_8
X_12488_ _12488_/X _14693_/Q _14725_/Q _13765_/Q _13797_/Q _12654_/S0 _12654_/S1 VDD
+ VSS sg13g2_mux4_1
XFILLER_171_112 VDD VSS sg13g2_decap_8
XFILLER_172_646 VDD VSS sg13g2_decap_8
XFILLER_67_1301 VDD VSS sg13g2_decap_8
X_14227_ _14227_/Q _14739_/CLK _14227_/D _14227_/RESET_B VDD VSS sg13g2_dfrbpq_1
XFILLER_7_196 VDD VSS sg13g2_decap_8
XFILLER_144_359 VDD VSS sg13g2_decap_8
X_11439_ _11445_/A _12188_/C _11439_/B VDD VSS sg13g2_or2_1
XFILLER_153_860 VDD VSS sg13g2_decap_8
XFILLER_113_702 VDD VSS sg13g2_decap_4
XFILLER_154_1304 VDD VSS sg13g2_decap_8
XFILLER_99_936 VDD VSS sg13g2_decap_8
XFILLER_98_413 VDD VSS sg13g2_decap_8
X_13848__2424 _13848_/RESET_B VDD VSS sg13g2_tiehi
X_14158_ _14158_/Q _14222_/CLK _14158_/D _14158_/RESET_B VDD VSS sg13g2_dfrbpq_1
XFILLER_98_70 VDD VSS sg13g2_decap_8
XFILLER_152_370 VDD VSS sg13g2_decap_8
X_13109_ _13109_/Y _13106_/Y _13107_/Y _13108_/Y VDD VSS sg13g2_a21oi_1
X_14089_ _14089_/Q _14729_/CLK _14089_/D _14089_/RESET_B VDD VSS sg13g2_dfrbpq_1
XFILLER_67_811 VDD VSS sg13g2_fill_1
XFILLER_113_1012 VDD VSS sg13g2_decap_4
XFILLER_85_129 VDD VSS sg13g2_decap_8
XFILLER_117_1192 VDD VSS sg13g2_decap_8
Xfanout1170 _08598_/A3 _12009_/A VDD VSS sg13g2_buf_1
X_14228__2044 _14228_/RESET_B VDD VSS sg13g2_tiehi
Xfanout1181 _11914_/A _14977_/Q VDD VSS sg13g2_buf_1
X_08650_ _08650_/X _08650_/A _08650_/B VDD VSS sg13g2_xor2_1
XFILLER_6_1169 VDD VSS sg13g2_decap_8
XFILLER_113_1056 VDD VSS sg13g2_decap_8
Xfanout1192 _11798_/A _14974_/Q VDD VSS sg13g2_buf_1
XFILLER_94_663 VDD VSS sg13g2_decap_4
XFILLER_54_505 VDD VSS sg13g2_fill_1
XFILLER_113_1089 VDD VSS sg13g2_decap_8
XFILLER_81_302 VDD VSS sg13g2_decap_8
X_08581_ _15242_/D _08581_/A _08581_/B _08581_/C _08581_/D VDD VSS sg13g2_nand4_1
XFILLER_93_195 VDD VSS sg13g2_fill_1
XFILLER_82_858 VDD VSS sg13g2_fill_2
XFILLER_165_1411 VDD VSS sg13g2_decap_8
XFILLER_74_1305 VDD VSS sg13g2_decap_8
XFILLER_34_240 VDD VSS sg13g2_decap_4
XFILLER_74_1338 VDD VSS sg13g2_decap_8
XFILLER_74_1349 VDD VSS sg13g2_fill_2
XFILLER_179_245 VDD VSS sg13g2_decap_8
XFILLER_23_947 VDD VSS sg13g2_decap_8
XFILLER_22_424 VDD VSS sg13g2_decap_8
XFILLER_161_1319 VDD VSS sg13g2_decap_8
X_09202_ _13818_/D _13818_/Q _10169_/A1 _09202_/S VDD VSS sg13g2_mux2_1
XFILLER_148_610 VDD VSS sg13g2_decap_8
XFILLER_167_429 VDD VSS sg13g2_fill_2
XFILLER_124_1130 VDD VSS sg13g2_decap_8
XFILLER_148_621 VDD VSS sg13g2_fill_1
X_09133_ _09137_/B _13200_/A _09157_/C _14921_/Q VDD VSS sg13g2_a21oi_1
XFILLER_148_676 VDD VSS sg13g2_decap_8
X_09064_ _13771_/D _13771_/Q _10154_/A1 _09106_/S VDD VSS sg13g2_mux2_1
XFILLER_68_1109 VDD VSS sg13g2_decap_8
XFILLER_11_1344 VDD VSS sg13g2_decap_8
XFILLER_163_657 VDD VSS sg13g2_fill_1
X_08015_ _08015_/Y _08338_/B _08013_/X _08014_/Y VDD VSS sg13g2_o21ai_1
XFILLER_162_156 VDD VSS sg13g2_decap_8
XFILLER_144_871 VDD VSS sg13g2_decap_8
XFILLER_78_18 VDD VSS sg13g2_fill_2
Xmax_cap361 _09870_/S _09869_/S VDD VSS sg13g2_buf_8
XFILLER_103_201 VDD VSS sg13g2_fill_1
XFILLER_116_584 VDD VSS sg13g2_decap_8
X_14438__1834 _14438_/RESET_B VDD VSS sg13g2_tiehi
XFILLER_81_1309 VDD VSS sg13g2_fill_1
XFILLER_46_1429 VDD VSS sg13g2_decap_8
X_09966_ _14550_/D _14550_/Q _09966_/A1 _09969_/S VDD VSS sg13g2_mux2_1
XFILLER_77_619 VDD VSS sg13g2_decap_8
XFILLER_131_576 VDD VSS sg13g2_decap_8
X_08917_ _13711_/D _08932_/S _08915_/Y _08916_/Y VDD VSS sg13g2_a21oi_1
X_09897_ _14483_/D _10162_/A1 _14483_/Q _09901_/S VDD VSS sg13g2_mux2_1
XFILLER_134_79 VDD VSS sg13g2_fill_1
XFILLER_85_641 VDD VSS sg13g2_fill_2
XFILLER_18_708 VDD VSS sg13g2_fill_2
X_08848_ _08848_/Y _08848_/A _14929_/Q VDD VSS sg13g2_nor2b_1
XFILLER_72_302 VDD VSS sg13g2_decap_8
X_08779_ _08779_/Y _08788_/A1 _15115_/Q _15184_/Q _07719_/X VDD VSS sg13g2_a22oi_1
XFILLER_84_195 VDD VSS sg13g2_decap_4
XFILLER_27_77 VDD VSS sg13g2_decap_8
XFILLER_150_56 VDD VSS sg13g2_decap_8
X_10810_ _10810_/Y _10809_/Y _10807_/Y _10801_/Y VDD VSS sg13g2_a21oi_1
XFILLER_26_752 VDD VSS sg13g2_decap_8
XFILLER_14_903 VDD VSS sg13g2_decap_8
X_14082__2190 _14082_/RESET_B VDD VSS sg13g2_tiehi
X_11790_ _11790_/X _11783_/X _11784_/X _11787_/X _11788_/X _11964_/B _11999_/S1 VDD
+ VSS sg13g2_mux4_1
XFILLER_13_413 VDD VSS sg13g2_decap_8
XFILLER_92_1438 VDD VSS sg13g2_decap_8
X_10741_ _10741_/Y _14913_/Q _11048_/B VDD VSS sg13g2_nand2_1
XFILLER_43_21 VDD VSS sg13g2_decap_8
XFILLER_159_21 VDD VSS sg13g2_decap_8
XFILLER_9_406 VDD VSS sg13g2_decap_8
X_13460_ _15106_/D _13456_/X _13459_/Y _13458_/Y VDD VSS sg13g2_o21ai_1
X_13926__2346 _13926_/RESET_B VDD VSS sg13g2_tiehi
XFILLER_186_749 VDD VSS sg13g2_decap_8
X_14686__1586 _14686_/RESET_B VDD VSS sg13g2_tiehi
X_10672_ _10673_/A _07753_/B _10807_/B _13294_/B _14895_/Q VDD VSS sg13g2_a22oi_1
XFILLER_41_788 VDD VSS sg13g2_decap_8
XFILLER_40_265 VDD VSS sg13g2_decap_8
XFILLER_16_1244 VDD VSS sg13g2_decap_8
X_12411_ _12411_/X _14687_/Q _14719_/Q _13759_/Q _13791_/Q _12411_/S0 _12411_/S1 VDD
+ VSS sg13g2_mux4_1
XFILLER_43_98 VDD VSS sg13g2_decap_8
XFILLER_138_120 VDD VSS sg13g2_decap_8
XFILLER_185_259 VDD VSS sg13g2_decap_8
X_13391_ _13391_/Y _13414_/A _13494_/B _13391_/C VDD VSS sg13g2_nor3_1
XFILLER_138_153 VDD VSS sg13g2_decap_8
XFILLER_126_304 VDD VSS sg13g2_decap_8
XFILLER_142_1285 VDD VSS sg13g2_decap_8
X_15130_ _15130_/Q clkload88/A _15130_/D _15130_/RESET_B VDD VSS sg13g2_dfrbpq_1
XFILLER_177_1304 VDD VSS sg13g2_decap_8
X_12342_ _12342_/X _13947_/Q _13979_/Q _14011_/Q _14043_/Q wire940/X _12620_/S1 VDD
+ VSS sg13g2_mux4_1
XFILLER_153_101 VDD VSS sg13g2_decap_8
X_14830__2976 _14830_/RESET_B VDD VSS sg13g2_tiehi
XFILLER_153_112 VDD VSS sg13g2_fill_2
XFILLER_5_623 VDD VSS sg13g2_decap_8
XFILLER_111_0 VDD VSS sg13g2_decap_8
XFILLER_175_42 VDD VSS sg13g2_decap_8
X_15061_ _15061_/Q clkload90/A _15061_/D _15061_/RESET_B VDD VSS sg13g2_dfrbpq_1
X_12273_ _12273_/Y _12273_/A VDD VSS sg13g2_inv_1
XFILLER_4_133 VDD VSS sg13g2_decap_8
XFILLER_182_988 VDD VSS sg13g2_fill_2
XFILLER_141_307 VDD VSS sg13g2_fill_2
XFILLER_181_476 VDD VSS sg13g2_decap_8
X_14012_ _14012_/Q _14652_/CLK _14012_/D _14012_/RESET_B VDD VSS sg13g2_dfrbpq_1
X_11224_ wire275/A _11224_/A _11224_/B _11224_/C VDD VSS sg13g2_nor3_1
XFILLER_150_841 VDD VSS sg13g2_fill_2
XFILLER_1_840 VDD VSS sg13g2_decap_8
XFILLER_175_1094 VDD VSS sg13g2_decap_8
X_11155_ _14952_/D _11154_/Y _11153_/Y _11143_/Y VDD VSS sg13g2_o21ai_1
XFILLER_0_350 VDD VSS sg13g2_decap_8
XFILLER_110_727 VDD VSS sg13g2_decap_8
XFILLER_89_980 VDD VSS sg13g2_decap_8
XFILLER_67_107 VDD VSS sg13g2_decap_8
X_10106_ _14684_/D _14684_/Q _10130_/S _10105_/X VDD VSS sg13g2_a21o_1
XFILLER_89_991 VDD VSS sg13g2_fill_2
XFILLER_62_1242 VDD VSS sg13g2_decap_8
XFILLER_23_1204 VDD VSS sg13g2_decap_8
X_11086_ _11118_/C _11125_/A _11115_/A VDD VSS sg13g2_xnor2_1
XFILLER_114_1332 VDD VSS sg13g2_decap_8
X_14292__1980 _14292_/RESET_B VDD VSS sg13g2_tiehi
XFILLER_7_1456 VDD VSS sg13g2_decap_8
XFILLER_27_1384 VDD VSS sg13g2_decap_8
XFILLER_49_866 VDD VSS sg13g2_fill_2
XFILLER_48_343 VDD VSS sg13g2_decap_4
XFILLER_3_1309 VDD VSS sg13g2_decap_8
X_14914_ _14914_/Q clkload56/A _14914_/D _14914_/RESET_B VDD VSS sg13g2_dfrbpq_1
X_10037_ _10037_/Y _10070_/A _10037_/B _10070_/C VDD VSS sg13g2_nand3_1
XFILLER_76_685 VDD VSS sg13g2_fill_1
XFILLER_64_825 VDD VSS sg13g2_decap_8
XFILLER_149_1406 VDD VSS sg13g2_fill_2
XFILLER_97_1338 VDD VSS sg13g2_fill_1
X_14775__3031 _14775_/RESET_B VDD VSS sg13g2_tiehi
XFILLER_149_1417 VDD VSS sg13g2_fill_2
X_14845_ _14845_/Q clkload68/A _14845_/D _14845_/RESET_B VDD VSS sg13g2_dfrbpq_1
XFILLER_91_633 VDD VSS sg13g2_decap_8
XFILLER_90_110 VDD VSS sg13g2_decap_8
XFILLER_63_324 VDD VSS sg13g2_fill_1
XFILLER_149_1428 VDD VSS sg13g2_decap_8
XFILLER_1_1022 VDD VSS sg13g2_decap_8
XFILLER_63_335 VDD VSS sg13g2_decap_4
XFILLER_29_590 VDD VSS sg13g2_decap_8
XFILLER_95_1040 VDD VSS sg13g2_decap_8
XFILLER_17_763 VDD VSS sg13g2_decap_8
X_14776_ _14776_/Q _14864_/CLK _14776_/D _14776_/RESET_B VDD VSS sg13g2_dfrbpq_1
X_11988_ _11988_/Y _11986_/A _11988_/B _11989_/A VDD VSS sg13g2_nand3b_1
XFILLER_108_1103 VDD VSS sg13g2_decap_8
XFILLER_16_273 VDD VSS sg13g2_decap_8
XFILLER_1_1099 VDD VSS sg13g2_decap_8
X_13727_ _13727_/Q clkload21/A _13727_/D _13727_/RESET_B VDD VSS sg13g2_dfrbpq_1
XFILLER_56_1035 VDD VSS sg13g2_decap_4
XFILLER_147_1163 VDD VSS sg13g2_decap_8
X_10939_ _10939_/Y _10926_/C _10936_/B _11183_/B1 VDD VSS sg13g2_o21ai_1
XFILLER_149_418 VDD VSS sg13g2_fill_1
XFILLER_56_1068 VDD VSS sg13g2_decap_8
XFILLER_108_1147 VDD VSS sg13g2_decap_8
X_13658_ _13658_/Q _15212_/CLK _13658_/D _13658_/RESET_B VDD VSS sg13g2_dfrbpq_1
XFILLER_31_254 VDD VSS sg13g2_decap_8
XFILLER_143_1049 VDD VSS sg13g2_decap_8
X_14516__1756 _14516_/RESET_B VDD VSS sg13g2_tiehi
Xclkbuf_leaf_61_clk_i clkload86/A clkbuf_leaf_66_clk_i/A VDD VSS sg13g2_buf_8
XFILLER_32_788 VDD VSS sg13g2_decap_8
XFILLER_73_1382 VDD VSS sg13g2_decap_4
XFILLER_13_980 VDD VSS sg13g2_decap_8
XFILLER_160_1341 VDD VSS sg13g2_decap_8
X_12609_ _12609_/X _12607_/X _12608_/X _12664_/S VDD VSS sg13g2_mux2_1
XFILLER_176_259 VDD VSS sg13g2_decap_8
X_13589_ _13589_/Y _15003_/Q _13555_/B _13561_/S _15019_/Q _13541_/X VDD VSS sg13g2_a221oi_1
XFILLER_12_490 VDD VSS sg13g2_decap_8
XFILLER_160_1385 VDD VSS sg13g2_fill_2
XFILLER_9_973 VDD VSS sg13g2_decap_8
XFILLER_30_1219 VDD VSS sg13g2_fill_2
X_13780__2492 _13780_/RESET_B VDD VSS sg13g2_tiehi
XFILLER_117_326 VDD VSS sg13g2_fill_1
XFILLER_117_337 VDD VSS sg13g2_decap_8
XFILLER_8_483 VDD VSS sg13g2_decap_8
XFILLER_172_465 VDD VSS sg13g2_decap_8
Xclkbuf_leaf_76_clk_i _15212_/CLK clkload5/A VDD VSS sg13g2_buf_8
X_14731__1541 _14731_/RESET_B VDD VSS sg13g2_tiehi
XFILLER_119_1210 VDD VSS sg13g2_decap_8
XFILLER_119_1221 VDD VSS sg13g2_fill_1
Xfanout407 _09271_/S _09267_/S VDD VSS sg13g2_buf_1
X_09820_ _14408_/D _09919_/A1 _14408_/Q _09830_/S VDD VSS sg13g2_mux2_1
XFILLER_28_1137 VDD VSS sg13g2_decap_8
XFILLER_141_863 VDD VSS sg13g2_decap_4
Xfanout418 _10146_/A1 _09582_/A1 VDD VSS sg13g2_buf_1
XFILLER_98_243 VDD VSS sg13g2_decap_8
XFILLER_63_1028 VDD VSS sg13g2_decap_8
Xfanout429 _10143_/A1 wire432/X VDD VSS sg13g2_buf_1
XFILLER_86_405 VDD VSS sg13g2_decap_8
XFILLER_87_939 VDD VSS sg13g2_decap_8
XFILLER_115_1129 VDD VSS sg13g2_decap_8
XFILLER_119_1298 VDD VSS sg13g2_decap_8
XFILLER_140_373 VDD VSS sg13g2_decap_8
XFILLER_154_1178 VDD VSS sg13g2_decap_8
XFILLER_154_1189 VDD VSS sg13g2_fill_1
X_09751_ _14341_/D _14341_/Q _09916_/A1 _09764_/S VDD VSS sg13g2_mux2_1
XFILLER_39_310 VDD VSS sg13g2_fill_1
X_08702_ _15249_/D _08700_/Y _08701_/Y _08694_/Y VDD VSS sg13g2_o21ai_1
X_09682_ _14274_/D _09913_/A1 _14274_/Q _09704_/S VDD VSS sg13g2_mux2_1
XFILLER_39_365 VDD VSS sg13g2_fill_2
XFILLER_27_505 VDD VSS sg13g2_decap_8
XFILLER_104_49 VDD VSS sg13g2_decap_8
X_08633_ _15245_/D _08633_/A _08633_/B _08633_/C VDD VSS sg13g2_nand3_1
X_13690__2585 _13690_/RESET_B VDD VSS sg13g2_tiehi
Xclkbuf_leaf_14_clk_i clkload23/A clkbuf_5_6__f_clk_i/X VDD VSS sg13g2_buf_8
XFILLER_54_346 VDD VSS sg13g2_decap_8
X_08564_ _08581_/D _15013_/Q _08620_/A3 _08674_/B1 VDD VSS sg13g2_o21ai_1
XFILLER_82_688 VDD VSS sg13g2_fill_1
XFILLER_35_560 VDD VSS sg13g2_decap_8
XFILLER_81_176 VDD VSS sg13g2_fill_2
XFILLER_22_210 VDD VSS sg13g2_decap_8
XFILLER_126_1214 VDD VSS sg13g2_fill_2
X_08495_ _08495_/Y _08447_/B _08574_/C _08494_/Y VDD VSS sg13g2_a21oi_1
XFILLER_126_1225 VDD VSS sg13g2_fill_2
XFILLER_168_716 VDD VSS sg13g2_fill_2
X_14941__2755 _14941_/RESET_B VDD VSS sg13g2_tiehi
XFILLER_39_1277 VDD VSS sg13g2_decap_8
XFILLER_161_1116 VDD VSS sg13g2_decap_8
XFILLER_50_541 VDD VSS sg13g2_decap_8
XFILLER_165_1285 VDD VSS sg13g2_fill_1
XFILLER_39_1288 VDD VSS sg13g2_fill_2
XFILLER_11_917 VDD VSS sg13g2_decap_8
Xclkbuf_leaf_29_clk_i clkload28/A clkbuf_5_8__f_clk_i/X VDD VSS sg13g2_buf_8
XFILLER_74_1179 VDD VSS sg13g2_decap_4
XFILLER_126_1258 VDD VSS sg13g2_decap_8
XFILLER_52_1422 VDD VSS sg13g2_decap_8
XFILLER_10_427 VDD VSS sg13g2_decap_8
XFILLER_149_952 VDD VSS sg13g2_decap_4
XFILLER_13_35 VDD VSS sg13g2_decap_8
XFILLER_136_602 VDD VSS sg13g2_decap_8
XFILLER_13_1428 VDD VSS sg13g2_decap_8
XFILLER_52_1477 VDD VSS sg13g2_fill_2
XFILLER_136_613 VDD VSS sg13g2_fill_2
XFILLER_176_782 VDD VSS sg13g2_decap_4
X_09116_ _09117_/C _13190_/A _10760_/A _13142_/A _09136_/B VDD VSS sg13g2_nand4_1
XFILLER_129_46 VDD VSS sg13g2_fill_1
XFILLER_164_944 VDD VSS sg13g2_decap_8
XFILLER_100_1409 VDD VSS sg13g2_fill_2
XFILLER_135_112 VDD VSS sg13g2_decap_4
XFILLER_164_955 VDD VSS sg13g2_fill_2
XFILLER_89_28 VDD VSS sg13g2_decap_8
XFILLER_136_657 VDD VSS sg13g2_decap_8
XFILLER_163_443 VDD VSS sg13g2_decap_8
XFILLER_11_1141 VDD VSS sg13g2_decap_8
XFILLER_164_977 VDD VSS sg13g2_decap_8
X_09047_ _09047_/Y _15232_/Q _09053_/B VDD VSS sg13g2_nand2b_1
XFILLER_164_988 VDD VSS sg13g2_fill_2
XFILLER_144_690 VDD VSS sg13g2_fill_2
XFILLER_2_637 VDD VSS sg13g2_decap_8
XFILLER_116_392 VDD VSS sg13g2_decap_8
XFILLER_150_137 VDD VSS sg13g2_decap_8
XFILLER_172_1212 VDD VSS sg13g2_fill_2
XFILLER_150_148 VDD VSS sg13g2_fill_1
XFILLER_176_1392 VDD VSS sg13g2_decap_4
XFILLER_145_56 VDD VSS sg13g2_decap_8
XFILLER_1_147 VDD VSS sg13g2_decap_8
XFILLER_145_89 VDD VSS sg13g2_decap_8
XFILLER_133_1218 VDD VSS sg13g2_decap_8
XFILLER_172_1278 VDD VSS sg13g2_fill_2
Xfanout941 _12378_/S0 _12382_/S0 VDD VSS sg13g2_buf_1
Xfanout952 _12717_/S0 fanout953/X VDD VSS sg13g2_buf_1
X_09949_ _14533_/D _14533_/Q _09949_/A1 _09961_/S VDD VSS sg13g2_mux2_1
XFILLER_89_298 VDD VSS sg13g2_decap_8
XFILLER_38_21 VDD VSS sg13g2_decap_8
XFILLER_131_395 VDD VSS sg13g2_fill_2
Xfanout963 _12450_/S0 _12425_/S0 VDD VSS sg13g2_buf_1
Xfanout974 _12983_/A1 _11236_/A VDD VSS sg13g2_buf_1
Xfanout985 _12779_/A2 _13293_/C VDD VSS sg13g2_buf_1
X_12960_ _12960_/Y _12961_/A _12961_/C _12988_/C VDD VSS sg13g2_a21oi_1
Xfanout996 _13533_/B _13555_/C VDD VSS sg13g2_buf_1
XFILLER_57_140 VDD VSS sg13g2_decap_8
XFILLER_46_814 VDD VSS sg13g2_decap_4
XFILLER_86_994 VDD VSS sg13g2_decap_8
X_11911_ _11912_/B _12056_/A _12056_/B VDD VSS sg13g2_nand2_1
X_12891_ _12925_/A _14900_/Q _13687_/Q VDD VSS sg13g2_nand2_1
X_14630_ _14630_/Q clkload18/A _14630_/D _14630_/RESET_B VDD VSS sg13g2_dfrbpq_1
XFILLER_61_806 VDD VSS sg13g2_decap_4
X_11842_ _11867_/A _11843_/A _13675_/Q VDD VSS sg13g2_nand2_1
XFILLER_57_1300 VDD VSS sg13g2_decap_8
XFILLER_166_1038 VDD VSS sg13g2_decap_8
XFILLER_14_700 VDD VSS sg13g2_decap_8
XFILLER_54_42 VDD VSS sg13g2_decap_8
XFILLER_2_1386 VDD VSS sg13g2_decap_8
XFILLER_159_0 VDD VSS sg13g2_decap_8
X_14561_ _14561_/Q clkload38/A _14561_/D _14561_/RESET_B VDD VSS sg13g2_dfrbpq_1
XFILLER_60_338 VDD VSS sg13g2_decap_4
XFILLER_13_210 VDD VSS sg13g2_decap_8
X_11773_ _11776_/B _11773_/A _11773_/B _11773_/C _11773_/D VDD VSS sg13g2_nor4_1
XFILLER_92_1246 VDD VSS sg13g2_decap_8
XFILLER_54_97 VDD VSS sg13g2_decap_8
XFILLER_159_727 VDD VSS sg13g2_decap_8
XFILLER_18_1339 VDD VSS sg13g2_decap_8
X_13512_ _15135_/D _15135_/Q _08621_/A _13519_/B VDD VSS sg13g2_mux2_1
XFILLER_41_552 VDD VSS sg13g2_decap_8
XFILLER_14_777 VDD VSS sg13g2_decap_8
X_10724_ _14908_/D _10724_/A VDD VSS sg13g2_inv_1
X_14492_ _14492_/Q clkload64/A _14492_/D _14492_/RESET_B VDD VSS sg13g2_dfrbpq_1
XFILLER_9_203 VDD VSS sg13g2_decap_8
XFILLER_109_1478 VDD VSS sg13g2_fill_1
XFILLER_110_70 VDD VSS sg13g2_decap_8
XFILLER_13_287 VDD VSS sg13g2_decap_8
XFILLER_41_596 VDD VSS sg13g2_decap_8
XFILLER_16_1041 VDD VSS sg13g2_decap_8
XFILLER_174_708 VDD VSS sg13g2_fill_2
X_13443_ _15103_/D _15103_/Q _13353_/Y _13442_/Y VDD VSS sg13g2_a21o_1
X_10655_ _14890_/D _10663_/D _10655_/B _10655_/C VDD VSS sg13g2_nor3_1
XFILLER_6_910 VDD VSS sg13g2_decap_8
XFILLER_139_484 VDD VSS sg13g2_decap_8
X_13374_ _15077_/D _13361_/C _13444_/A _13372_/Y VDD VSS sg13g2_o21ai_1
Xclkload17 clkload17/Y clkload17/A VDD VSS sg13g2_inv_1
XFILLER_155_944 VDD VSS sg13g2_decap_8
XFILLER_177_1101 VDD VSS sg13g2_fill_2
XFILLER_182_730 VDD VSS sg13g2_decap_8
Xclkload28 clkload28/Y clkload28/A VDD VSS sg13g2_inv_2
X_10586_ _10597_/D _10649_/B _14872_/Q _14871_/Q _10586_/D VDD VSS sg13g2_and4_1
XFILLER_10_994 VDD VSS sg13g2_decap_8
XFILLER_155_955 VDD VSS sg13g2_fill_1
XFILLER_182_741 VDD VSS sg13g2_fill_2
XFILLER_126_134 VDD VSS sg13g2_decap_8
XFILLER_177_1123 VDD VSS sg13g2_fill_2
X_15113_ _15113_/Q _15113_/CLK _15113_/D _15113_/RESET_B VDD VSS sg13g2_dfrbpq_1
Xclkload39 clkload39/Y clkload39/A VDD VSS sg13g2_inv_1
XFILLER_5_420 VDD VSS sg13g2_decap_8
X_12325_ _12325_/Y _12306_/A _13850_/Q VDD VSS sg13g2_nand2b_1
XFILLER_103_1099 VDD VSS sg13g2_decap_8
XFILLER_126_167 VDD VSS sg13g2_decap_8
XFILLER_6_987 VDD VSS sg13g2_decap_8
XFILLER_182_796 VDD VSS sg13g2_decap_8
XFILLER_181_273 VDD VSS sg13g2_decap_8
X_15044_ _15044_/Q clkload65/A _15044_/D _15044_/RESET_B VDD VSS sg13g2_dfrbpq_1
XFILLER_154_498 VDD VSS sg13g2_decap_8
X_12256_ _12256_/Y _12259_/S0 _13912_/Q VDD VSS sg13g2_nand2b_1
XFILLER_142_649 VDD VSS sg13g2_decap_8
XFILLER_5_497 VDD VSS sg13g2_decap_8
XFILLER_170_969 VDD VSS sg13g2_decap_8
XFILLER_48_7 VDD VSS sg13g2_decap_8
X_11207_ _11207_/Y _11205_/A _11207_/A2 _11207_/B1 VDD VSS sg13g2_a21oi_1
XFILLER_123_863 VDD VSS sg13g2_decap_8
XFILLER_64_1337 VDD VSS sg13g2_decap_8
X_12187_ _12188_/B _12187_/A _12187_/B _12187_/C VDD VSS sg13g2_nand3_1
XFILLER_95_202 VDD VSS sg13g2_fill_1
XFILLER_122_384 VDD VSS sg13g2_fill_2
XFILLER_151_1329 VDD VSS sg13g2_fill_1
X_11138_ _11138_/Y _11163_/A _11138_/B _11138_/C VDD VSS sg13g2_nand3b_1
XFILLER_96_747 VDD VSS sg13g2_fill_2
XFILLER_68_449 VDD VSS sg13g2_decap_8
XFILLER_95_235 VDD VSS sg13g2_fill_2
XFILLER_84_909 VDD VSS sg13g2_decap_4
XFILLER_27_1181 VDD VSS sg13g2_decap_8
XFILLER_7_1253 VDD VSS sg13g2_decap_8
XFILLER_49_652 VDD VSS sg13g2_decap_8
X_11069_ _11069_/Y _11078_/B _11069_/B VDD VSS sg13g2_xnor2_1
XFILLER_3_1106 VDD VSS sg13g2_decap_8
XFILLER_97_1113 VDD VSS sg13g2_decap_8
XFILLER_92_920 VDD VSS sg13g2_fill_2
XFILLER_37_825 VDD VSS sg13g2_decap_8
XFILLER_23_1056 VDD VSS sg13g2_decap_8
XFILLER_114_1195 VDD VSS sg13g2_decap_8
XFILLER_91_430 VDD VSS sg13g2_fill_2
XFILLER_92_964 VDD VSS sg13g2_fill_2
XFILLER_91_441 VDD VSS sg13g2_decap_8
XFILLER_58_1108 VDD VSS sg13g2_fill_1
XFILLER_110_1059 VDD VSS sg13g2_decap_8
XFILLER_64_666 VDD VSS sg13g2_decap_8
XFILLER_149_1236 VDD VSS sg13g2_decap_8
X_13798__2474 _13798_/RESET_B VDD VSS sg13g2_tiehi
XFILLER_92_986 VDD VSS sg13g2_decap_8
XFILLER_36_368 VDD VSS sg13g2_decap_8
X_14828_ _14828_/Q _14890_/CLK _14828_/D _14828_/RESET_B VDD VSS sg13g2_dfrbpq_1
XFILLER_17_560 VDD VSS sg13g2_decap_8
XFILLER_184_1149 VDD VSS sg13g2_fill_1
XFILLER_63_187 VDD VSS sg13g2_decap_8
X_14759_ _14759_/Q _15200_/CLK _14759_/D _14759_/RESET_B VDD VSS sg13g2_dfrbpq_1
XFILLER_75_1455 VDD VSS sg13g2_decap_8
XFILLER_51_349 VDD VSS sg13g2_decap_4
XFILLER_32_541 VDD VSS sg13g2_decap_8
X_08280_ _08280_/X _08194_/B _08207_/X _08279_/X VDD VSS sg13g2_a21o_1
XFILLER_177_546 VDD VSS sg13g2_decap_8
XFILLER_60_894 VDD VSS sg13g2_decap_8
XFILLER_149_259 VDD VSS sg13g2_decap_8
X_14178__2094 _14178_/RESET_B VDD VSS sg13g2_tiehi
XFILLER_121_1111 VDD VSS sg13g2_fill_1
XFILLER_9_770 VDD VSS sg13g2_decap_8
XFILLER_74_0 VDD VSS sg13g2_decap_8
XFILLER_160_1182 VDD VSS sg13g2_decap_8
XFILLER_146_944 VDD VSS sg13g2_decap_8
XFILLER_30_1027 VDD VSS sg13g2_decap_8
XFILLER_145_432 VDD VSS sg13g2_decap_8
XFILLER_8_280 VDD VSS sg13g2_decap_8
XFILLER_172_240 VDD VSS sg13g2_decap_8
XFILLER_161_925 VDD VSS sg13g2_decap_8
XFILLER_69_1259 VDD VSS sg13g2_decap_4
XFILLER_132_104 VDD VSS sg13g2_decap_8
XFILLER_156_1218 VDD VSS sg13g2_decap_8
XFILLER_133_638 VDD VSS sg13g2_decap_8
XFILLER_156_1229 VDD VSS sg13g2_decap_4
XFILLER_133_649 VDD VSS sg13g2_fill_1
Xfanout204 _09828_/A0 _09098_/Y VDD VSS sg13g2_buf_1
XFILLER_82_1437 VDD VSS sg13g2_decap_8
XFILLER_5_91 VDD VSS sg13g2_decap_8
XFILLER_119_1062 VDD VSS sg13g2_decap_4
Xfanout215 _09759_/A1 wire216/X VDD VSS sg13g2_buf_1
Xfanout226 _09923_/A1 _09070_/Y VDD VSS sg13g2_buf_1
XFILLER_82_1459 VDD VSS sg13g2_decap_8
Xfanout237 fanout237/X _09058_/Y VDD VSS sg13g2_buf_1
X_09803_ _14392_/D _10167_/A1 _14392_/Q _09804_/S VDD VSS sg13g2_mux2_1
Xfanout248 _11980_/A _12126_/A VDD VSS sg13g2_buf_1
XFILLER_115_48 VDD VSS sg13g2_decap_8
XFILLER_140_181 VDD VSS sg13g2_decap_8
Xfanout259 _10051_/A0 _10151_/A1 VDD VSS sg13g2_buf_1
X_07995_ _08275_/B _15104_/Q _15091_/Q VDD VSS sg13g2_nor2_1
XFILLER_45_1270 VDD VSS sg13g2_fill_1
X_09734_ _14325_/D _09899_/A0 _14325_/Q _09738_/S VDD VSS sg13g2_mux2_1
X_14985__2695 _14985_/RESET_B VDD VSS sg13g2_tiehi
XFILLER_68_983 VDD VSS sg13g2_decap_8
XFILLER_55_600 VDD VSS sg13g2_fill_2
X_09665_ _14258_/D _09896_/A0 _14258_/Q _09665_/S VDD VSS sg13g2_mux2_1
XFILLER_67_493 VDD VSS sg13g2_decap_8
X_08616_ _08616_/Y _13533_/A _08616_/B VDD VSS sg13g2_nand2b_1
XFILLER_82_452 VDD VSS sg13g2_decap_8
XFILLER_76_1219 VDD VSS sg13g2_fill_1
X_14388__1884 _14388_/RESET_B VDD VSS sg13g2_tiehi
X_09596_ _14193_/D _14193_/Q _09596_/A1 _09596_/S VDD VSS sg13g2_mux2_1
XFILLER_167_1369 VDD VSS sg13g2_decap_8
XFILLER_36_891 VDD VSS sg13g2_decap_8
X_08547_ _08547_/Y _07956_/A _07812_/B _08497_/A VDD VSS sg13g2_a21oi_1
XFILLER_152_7 VDD VSS sg13g2_decap_8
XFILLER_23_552 VDD VSS sg13g2_decap_8
XFILLER_126_1033 VDD VSS sg13g2_fill_2
XFILLER_165_1082 VDD VSS sg13g2_decap_8
XFILLER_51_872 VDD VSS sg13g2_fill_2
XFILLER_11_714 VDD VSS sg13g2_decap_8
X_08478_ _08478_/Y _07805_/B _07949_/C _08447_/B VDD VSS sg13g2_o21ai_1
XFILLER_24_56 VDD VSS sg13g2_decap_8
XFILLER_50_382 VDD VSS sg13g2_decap_8
XFILLER_23_596 VDD VSS sg13g2_decap_8
XFILLER_10_224 VDD VSS sg13g2_decap_8
XFILLER_156_708 VDD VSS sg13g2_fill_1
X_14008__2264 _14008_/RESET_B VDD VSS sg13g2_tiehi
XFILLER_7_707 VDD VSS sg13g2_decap_8
XFILLER_137_911 VDD VSS sg13g2_decap_8
XFILLER_52_1263 VDD VSS sg13g2_decap_8
XFILLER_143_1380 VDD VSS sg13g2_fill_1
XFILLER_17_1383 VDD VSS sg13g2_decap_8
XFILLER_108_101 VDD VSS sg13g2_fill_1
XFILLER_13_1225 VDD VSS sg13g2_decap_8
X_10440_ _10442_/B _14836_/Q _14835_/Q _10443_/D VDD VSS sg13g2_nand3_1
XFILLER_6_217 VDD VSS sg13g2_decap_8
XFILLER_100_1206 VDD VSS sg13g2_fill_2
XFILLER_108_123 VDD VSS sg13g2_decap_8
XFILLER_178_1432 VDD VSS sg13g2_decap_8
XFILLER_87_1315 VDD VSS sg13g2_fill_1
XFILLER_164_763 VDD VSS sg13g2_decap_8
XFILLER_178_1443 VDD VSS sg13g2_fill_1
XFILLER_87_1326 VDD VSS sg13g2_decap_8
XFILLER_124_605 VDD VSS sg13g2_fill_2
XFILLER_152_914 VDD VSS sg13g2_decap_4
X_10371_ _10371_/Y _14815_/Q _10378_/D _10630_/C VDD VSS sg13g2_o21ai_1
XFILLER_40_77 VDD VSS sg13g2_fill_2
X_12110_ _12110_/Y _12090_/A _13876_/Q _11760_/C VDD VSS sg13g2_a21oi_1
XFILLER_3_924 VDD VSS sg13g2_decap_8
XFILLER_124_638 VDD VSS sg13g2_decap_8
X_13090_ _13092_/C _14911_/Q _13676_/Q _13077_/X VDD VSS sg13g2_a21oi_1
XFILLER_163_295 VDD VSS sg13g2_fill_1
XFILLER_156_99 VDD VSS sg13g2_fill_1
XFILLER_2_434 VDD VSS sg13g2_decap_8
XFILLER_151_468 VDD VSS sg13g2_decap_8
X_13876__2396 _13876_/RESET_B VDD VSS sg13g2_tiehi
X_12041_ _12041_/Y _12037_/Y _12038_/Y _12040_/Y _12039_/Y _12029_/B VDD VSS sg13g2_a221oi_1
XFILLER_104_340 VDD VSS sg13g2_fill_1
XFILLER_137_1140 VDD VSS sg13g2_decap_8
XFILLER_120_800 VDD VSS sg13g2_decap_8
XFILLER_172_1031 VDD VSS sg13g2_decap_8
XFILLER_105_885 VDD VSS sg13g2_decap_8
XFILLER_132_671 VDD VSS sg13g2_decap_8
XFILLER_78_725 VDD VSS sg13g2_decap_8
XFILLER_49_42 VDD VSS sg13g2_decap_8
XFILLER_172_21 VDD VSS sg13g2_decap_8
XFILLER_120_855 VDD VSS sg13g2_decap_4
XFILLER_172_1086 VDD VSS sg13g2_decap_8
Xfanout760 _12253_/B _12115_/A1 VDD VSS sg13g2_buf_1
Xfanout771 fanout771/X _07655_/Y VDD VSS sg13g2_buf_1
Xfanout782 _12184_/B _12105_/B1 VDD VSS sg13g2_buf_1
XFILLER_111_1302 VDD VSS sg13g2_decap_8
XFILLER_172_98 VDD VSS sg13g2_decap_8
X_13992_ _13992_/Q clkload23/A _13992_/D _13992_/RESET_B VDD VSS sg13g2_dfrbpq_1
XFILLER_92_205 VDD VSS sg13g2_decap_8
XFILLER_77_279 VDD VSS sg13g2_decap_8
Xfanout793 _13493_/A2 _07653_/Y VDD VSS sg13g2_buf_1
XFILLER_1_49 VDD VSS sg13g2_decap_8
XFILLER_98_1422 VDD VSS sg13g2_fill_2
XFILLER_24_1365 VDD VSS sg13g2_decap_8
XFILLER_150_1373 VDD VSS sg13g2_decap_8
XFILLER_105_92 VDD VSS sg13g2_decap_4
X_12943_ _12961_/A _12943_/A _12988_/A _12988_/B _12943_/D VDD VSS sg13g2_or4_1
XFILLER_92_249 VDD VSS sg13g2_fill_2
XFILLER_65_41 VDD VSS sg13g2_decap_8
XFILLER_45_132 VDD VSS sg13g2_decap_8
XFILLER_185_1425 VDD VSS sg13g2_decap_8
XFILLER_18_357 VDD VSS sg13g2_decap_8
XFILLER_98_1477 VDD VSS sg13g2_fill_2
XFILLER_73_452 VDD VSS sg13g2_decap_8
XFILLER_74_986 VDD VSS sg13g2_decap_8
X_12874_ _12878_/A _12874_/A _12876_/A _12877_/C VDD VSS sg13g2_or3_1
XFILLER_46_688 VDD VSS sg13g2_decap_8
XFILLER_46_699 VDD VSS sg13g2_fill_1
XFILLER_185_1469 VDD VSS sg13g2_fill_1
XFILLER_2_1183 VDD VSS sg13g2_decap_8
X_14613_ _14613_/Q clkload28/A _14613_/D _14613_/RESET_B VDD VSS sg13g2_dfrbpq_1
X_11825_ _11825_/Y _11826_/A1 _13900_/Q VDD VSS sg13g2_nand2b_1
XFILLER_92_1010 VDD VSS sg13g2_decap_4
XFILLER_57_1141 VDD VSS sg13g2_decap_8
XFILLER_109_1231 VDD VSS sg13g2_fill_2
XFILLER_109_1242 VDD VSS sg13g2_fill_2
X_14544_ _14544_/Q clkload10/A _14544_/D _14544_/RESET_B VDD VSS sg13g2_dfrbpq_1
XFILLER_18_1136 VDD VSS sg13g2_decap_8
X_11756_ _11756_/X _13834_/Q _13866_/Q _11969_/A VDD VSS sg13g2_mux2_1
XFILLER_14_574 VDD VSS sg13g2_decap_8
XFILLER_144_1155 VDD VSS sg13g2_fill_1
XFILLER_159_557 VDD VSS sg13g2_fill_1
X_10707_ _14904_/D _10999_/B1 _10923_/B _10706_/Y VDD VSS sg13g2_o21ai_1
XFILLER_186_354 VDD VSS sg13g2_decap_8
X_14475_ _14475_/Q _14733_/CLK _14475_/D _14475_/RESET_B VDD VSS sg13g2_dfrbpq_1
XFILLER_186_365 VDD VSS sg13g2_decap_8
X_11687_ _11687_/X _11687_/A _12253_/B VDD VSS sg13g2_and2_1
XFILLER_70_1341 VDD VSS sg13g2_decap_8
XFILLER_144_1199 VDD VSS sg13g2_decap_8
XFILLER_35_1472 VDD VSS sg13g2_fill_2
XFILLER_122_1431 VDD VSS sg13g2_decap_8
X_13426_ _15095_/D _13435_/B _13425_/Y _13423_/Y VDD VSS sg13g2_o21ai_1
XFILLER_127_410 VDD VSS sg13g2_decap_8
X_10638_ _10640_/A _14886_/Q _10633_/C _14887_/Q VDD VSS sg13g2_a21oi_1
XFILLER_31_1347 VDD VSS sg13g2_decap_8
XFILLER_155_752 VDD VSS sg13g2_decap_8
XFILLER_31_1358 VDD VSS sg13g2_fill_2
XFILLER_10_791 VDD VSS sg13g2_decap_8
X_13357_ _13357_/Y _13396_/A _13396_/B _13396_/C _13361_/C VDD VSS sg13g2_nor4_1
XFILLER_154_251 VDD VSS sg13g2_fill_2
XFILLER_182_560 VDD VSS sg13g2_decap_8
X_10569_ _14868_/D _10576_/C _10576_/D _10557_/B _07621_/Y _10577_/B VDD VSS sg13g2_a221oi_1
XFILLER_143_925 VDD VSS sg13g2_decap_8
X_12308_ _12308_/Y _12308_/A _12308_/B _12308_/C VDD VSS sg13g2_nand3_1
XFILLER_6_784 VDD VSS sg13g2_decap_8
X_13288_ _13289_/D _15204_/Q _13506_/A VDD VSS sg13g2_nand2b_1
XFILLER_142_457 VDD VSS sg13g2_fill_2
XFILLER_5_294 VDD VSS sg13g2_decap_8
X_15027_ _15027_/Q clkload79/A _15027_/D _15027_/RESET_B VDD VSS sg13g2_dfrbpq_1
XFILLER_68_1281 VDD VSS sg13g2_decap_8
XFILLER_29_1232 VDD VSS sg13g2_decap_8
XFILLER_114_159 VDD VSS sg13g2_fill_1
X_13706__2566 _13706_/RESET_B VDD VSS sg13g2_tiehi
X_12239_ _12239_/Y _12239_/A _12239_/B VDD VSS sg13g2_nand2_1
XFILLER_29_1243 VDD VSS sg13g2_decap_8
XFILLER_111_800 VDD VSS sg13g2_decap_4
XFILLER_170_799 VDD VSS sg13g2_decap_8
XFILLER_9_1337 VDD VSS sg13g2_decap_8
XFILLER_96_511 VDD VSS sg13g2_decap_8
XFILLER_68_202 VDD VSS sg13g2_decap_8
XFILLER_29_1276 VDD VSS sg13g2_decap_8
XFILLER_111_833 VDD VSS sg13g2_decap_8
XFILLER_110_321 VDD VSS sg13g2_decap_8
XFILLER_122_181 VDD VSS sg13g2_decap_4
XFILLER_96_544 VDD VSS sg13g2_decap_8
XFILLER_69_769 VDD VSS sg13g2_decap_8
XFILLER_116_1257 VDD VSS sg13g2_decap_8
XFILLER_81_1470 VDD VSS sg13g2_fill_2
XFILLER_7_1050 VDD VSS sg13g2_decap_8
X_07780_ _07797_/B _08318_/C _08318_/D VDD VSS sg13g2_or2_1
XFILLER_56_419 VDD VSS sg13g2_decap_8
XFILLER_65_920 VDD VSS sg13g2_decap_4
XFILLER_37_611 VDD VSS sg13g2_fill_2
Xinput4 input4/X input4/A VDD VSS sg13g2_buf_1
X_13921__2351 _13921_/RESET_B VDD VSS sg13g2_tiehi
X_14681__1591 _14681_/RESET_B VDD VSS sg13g2_tiehi
X_09450_ _14051_/D _09582_/A1 _14051_/Q _09462_/S VDD VSS sg13g2_mux2_1
XFILLER_36_143 VDD VSS sg13g2_decap_8
XFILLER_37_699 VDD VSS sg13g2_decap_8
XFILLER_149_1055 VDD VSS sg13g2_decap_4
X_08401_ wire681/A _15097_/Q _15092_/Q _07911_/A VDD VSS sg13g2_o21ai_1
XFILLER_24_327 VDD VSS sg13g2_decap_8
X_09381_ _13984_/D _10076_/A0 _13984_/Q _09396_/S VDD VSS sg13g2_mux2_1
XFILLER_149_1099 VDD VSS sg13g2_decap_8
XFILLER_80_978 VDD VSS sg13g2_decap_8
XFILLER_36_1203 VDD VSS sg13g2_decap_8
X_14265__2007 _14265_/RESET_B VDD VSS sg13g2_tiehi
X_08332_ _08335_/C _08340_/A _08157_/X _08331_/Y VDD VSS sg13g2_o21ai_1
XFILLER_51_179 VDD VSS sg13g2_decap_8
XFILLER_33_883 VDD VSS sg13g2_decap_8
XFILLER_177_343 VDD VSS sg13g2_decap_8
XFILLER_71_1149 VDD VSS sg13g2_fill_2
X_08263_ _08263_/Y _07929_/B _08263_/B VDD VSS sg13g2_nand2b_1
XFILLER_119_900 VDD VSS sg13g2_decap_4
XFILLER_123_1228 VDD VSS sg13g2_decap_8
XFILLER_119_911 VDD VSS sg13g2_decap_8
X_08194_ _08194_/Y _08081_/X _08194_/B VDD VSS sg13g2_nand2b_1
XFILLER_118_443 VDD VSS sg13g2_fill_2
XFILLER_146_752 VDD VSS sg13g2_decap_8
XFILLER_69_1012 VDD VSS sg13g2_decap_8
XFILLER_119_977 VDD VSS sg13g2_decap_8
XFILLER_146_763 VDD VSS sg13g2_fill_1
XFILLER_161_700 VDD VSS sg13g2_fill_2
XFILLER_106_616 VDD VSS sg13g2_decap_8
XFILLER_134_925 VDD VSS sg13g2_decap_8
XFILLER_10_14 VDD VSS sg13g2_decap_8
XFILLER_161_711 VDD VSS sg13g2_decap_8
XFILLER_156_1004 VDD VSS sg13g2_decap_8
XFILLER_160_210 VDD VSS sg13g2_decap_8
XFILLER_126_14 VDD VSS sg13g2_decap_8
XFILLER_47_1310 VDD VSS sg13g2_decap_8
XFILLER_47_1343 VDD VSS sg13g2_decap_8
XFILLER_87_500 VDD VSS sg13g2_decap_8
XFILLER_160_287 VDD VSS sg13g2_decap_8
XFILLER_82_1256 VDD VSS sg13g2_fill_2
XFILLER_134_1335 VDD VSS sg13g2_decap_8
XFILLER_99_393 VDD VSS sg13g2_decap_8
XFILLER_82_1278 VDD VSS sg13g2_fill_1
XFILLER_47_1398 VDD VSS sg13g2_fill_2
XFILLER_87_555 VDD VSS sg13g2_decap_8
XFILLER_47_408 VDD VSS sg13g2_fill_2
XFILLER_59_268 VDD VSS sg13g2_fill_2
XFILLER_19_56 VDD VSS sg13g2_decap_8
X_07978_ _07978_/Y _07905_/D _07960_/Y _07979_/A VDD VSS sg13g2_o21ai_1
XFILLER_28_600 VDD VSS sg13g2_decap_4
XFILLER_101_387 VDD VSS sg13g2_fill_1
X_09717_ _14308_/D _10147_/A1 _14308_/Q _09738_/S VDD VSS sg13g2_mux2_1
XFILLER_132_1070 VDD VSS sg13g2_decap_8
XFILLER_27_121 VDD VSS sg13g2_decap_8
X_14511__1761 _14511_/RESET_B VDD VSS sg13g2_tiehi
XFILLER_71_901 VDD VSS sg13g2_fill_1
X_09648_ _14241_/D _09912_/A1 _14241_/Q _09672_/S VDD VSS sg13g2_mux2_1
XFILLER_76_1027 VDD VSS sg13g2_decap_8
XFILLER_82_271 VDD VSS sg13g2_decap_8
XFILLER_76_1038 VDD VSS sg13g2_fill_2
XFILLER_55_496 VDD VSS sg13g2_decap_8
XFILLER_43_636 VDD VSS sg13g2_decap_8
X_09579_ _14176_/D _14176_/Q _10076_/A0 _09601_/S VDD VSS sg13g2_mux2_1
XFILLER_167_1188 VDD VSS sg13g2_decap_8
XFILLER_43_669 VDD VSS sg13g2_decap_8
XFILLER_145_1420 VDD VSS sg13g2_decap_8
XFILLER_54_1303 VDD VSS sg13g2_decap_8
XFILLER_169_822 VDD VSS sg13g2_decap_8
XFILLER_19_1434 VDD VSS sg13g2_decap_8
X_11610_ _11610_/Y _11621_/S0 _14406_/Q _11742_/C VDD VSS sg13g2_a21oi_1
XFILLER_42_157 VDD VSS sg13g2_decap_8
XFILLER_30_308 VDD VSS sg13g2_fill_1
X_12590_ _12590_/X _13740_/Q _14092_/Q _14444_/Q _14540_/Q _12591_/S0 _12591_/S1 VDD
+ VSS sg13g2_mux4_1
XFILLER_70_499 VDD VSS sg13g2_decap_8
XFILLER_11_511 VDD VSS sg13g2_decap_8
XFILLER_180_1366 VDD VSS sg13g2_decap_8
X_11541_ _11542_/A _13732_/Q _14084_/Q _14436_/Q _14532_/Q _12138_/S0 _12138_/S1 VDD
+ VSS sg13g2_mux4_1
XFILLER_129_719 VDD VSS sg13g2_decap_8
XFILLER_141_1328 VDD VSS sg13g2_fill_2
XFILLER_7_504 VDD VSS sg13g2_decap_8
XFILLER_167_21 VDD VSS sg13g2_decap_8
XFILLER_168_387 VDD VSS sg13g2_decap_8
XFILLER_17_1180 VDD VSS sg13g2_decap_8
X_14260_ _14260_/Q _14740_/CLK _14260_/D _14260_/RESET_B VDD VSS sg13g2_dfrbpq_1
XFILLER_51_65 VDD VSS sg13g2_fill_2
XFILLER_11_588 VDD VSS sg13g2_decap_8
XFILLER_13_1022 VDD VSS sg13g2_decap_8
X_11472_ _11472_/X _13825_/Q _13857_/Q _13889_/Q _13921_/Q _11493_/S0 _11493_/S1 VDD
+ VSS sg13g2_mux4_1
XFILLER_137_752 VDD VSS sg13g2_decap_4
XFILLER_183_357 VDD VSS sg13g2_decap_8
X_13211_ _15047_/D _13211_/A _13211_/B VDD VSS sg13g2_nor2_1
XFILLER_109_454 VDD VSS sg13g2_decap_4
XFILLER_125_903 VDD VSS sg13g2_fill_1
X_10423_ _14830_/D _10423_/A _10423_/B _10423_/C VDD VSS sg13g2_and3_1
X_14191_ _14191_/Q clkload12/A _14191_/D _14191_/RESET_B VDD VSS sg13g2_dfrbpq_1
XFILLER_87_1134 VDD VSS sg13g2_decap_8
XFILLER_139_1202 VDD VSS sg13g2_decap_8
XFILLER_167_98 VDD VSS sg13g2_decap_8
X_13963__2309 _13963_/RESET_B VDD VSS sg13g2_tiehi
XFILLER_100_1047 VDD VSS sg13g2_decap_8
XFILLER_136_284 VDD VSS sg13g2_decap_8
XFILLER_13_1099 VDD VSS sg13g2_decap_8
X_13142_ _13174_/A _13142_/A _13671_/Q VDD VSS sg13g2_nand2_1
X_10354_ _10360_/C _14811_/Q _10353_/B VDD VSS sg13g2_nor2b_1
XFILLER_3_721 VDD VSS sg13g2_decap_8
XFILLER_124_457 VDD VSS sg13g2_fill_2
XFILLER_151_243 VDD VSS sg13g2_decap_4
XFILLER_174_1148 VDD VSS sg13g2_decap_8
XFILLER_183_42 VDD VSS sg13g2_decap_8
XFILLER_4_0 VDD VSS sg13g2_decap_8
XFILLER_2_231 VDD VSS sg13g2_decap_8
XFILLER_139_1279 VDD VSS sg13g2_decap_8
X_13073_ _13073_/Y _13166_/A1 _13072_/X _13071_/Y VDD VSS sg13g2_a21oi_1
X_10285_ _10288_/B _14788_/Q _14789_/Q _10305_/A _10305_/B VDD VSS sg13g2_nand4_1
XFILLER_65_1454 VDD VSS sg13g2_decap_8
XFILLER_151_287 VDD VSS sg13g2_decap_4
XFILLER_78_511 VDD VSS sg13g2_fill_1
XFILLER_3_798 VDD VSS sg13g2_decap_8
Xfanout1500 _13440_/B _13427_/B VDD VSS sg13g2_buf_1
X_12024_ _12026_/A _12025_/A _14642_/Q VDD VSS sg13g2_nand2b_1
XFILLER_105_693 VDD VSS sg13g2_decap_8
XFILLER_152_1446 VDD VSS sg13g2_decap_4
XFILLER_61_1329 VDD VSS sg13g2_fill_2
XFILLER_120_663 VDD VSS sg13g2_fill_2
XFILLER_65_205 VDD VSS sg13g2_fill_2
XFILLER_78_599 VDD VSS sg13g2_fill_2
XFILLER_66_739 VDD VSS sg13g2_decap_8
Xfanout590 _10138_/A1 _10104_/A0 VDD VSS sg13g2_buf_1
XFILLER_76_84 VDD VSS sg13g2_decap_8
XFILLER_24_1162 VDD VSS sg13g2_decap_8
XFILLER_150_1181 VDD VSS sg13g2_decap_8
X_13975_ _13975_/Q _15017_/CLK _13975_/D _13975_/RESET_B VDD VSS sg13g2_dfrbpq_1
XFILLER_58_290 VDD VSS sg13g2_fill_2
XFILLER_98_1252 VDD VSS sg13g2_decap_4
XFILLER_59_1203 VDD VSS sg13g2_decap_8
XFILLER_4_1267 VDD VSS sg13g2_decap_8
XFILLER_62_901 VDD VSS sg13g2_decap_8
XFILLER_46_452 VDD VSS sg13g2_fill_2
XFILLER_18_154 VDD VSS sg13g2_decap_8
XFILLER_62_912 VDD VSS sg13g2_decap_8
XFILLER_47_986 VDD VSS sg13g2_decap_8
X_12926_ _12928_/B _14901_/Q _13686_/Q _12989_/B VDD VSS sg13g2_o21ai_1
XFILLER_132_90 VDD VSS sg13g2_decap_8
XFILLER_73_282 VDD VSS sg13g2_fill_1
XFILLER_181_1108 VDD VSS sg13g2_decap_8
XFILLER_34_658 VDD VSS sg13g2_fill_2
X_12857_ _12861_/A _12846_/Y _12848_/X _12847_/X VDD VSS sg13g2_a21oi_1
XFILLER_92_72 VDD VSS sg13g2_decap_4
XFILLER_62_978 VDD VSS sg13g2_decap_8
XFILLER_61_455 VDD VSS sg13g2_decap_8
XFILLER_72_1403 VDD VSS sg13g2_decap_8
X_11808_ _11808_/Y _11808_/A _11822_/B VDD VSS sg13g2_nand2_1
XFILLER_61_488 VDD VSS sg13g2_decap_8
X_12788_ _12788_/X _12787_/X _12786_/X _12783_/X _12782_/X _12789_/S0 _12789_/S1 VDD
+ VSS sg13g2_mux4_1
XFILLER_109_1050 VDD VSS sg13g2_decap_8
XFILLER_14_371 VDD VSS sg13g2_decap_8
XFILLER_61_499 VDD VSS sg13g2_fill_2
XFILLER_42_680 VDD VSS sg13g2_decap_8
X_15191__2874 _15191_/RESET_B VDD VSS sg13g2_tiehi
X_14527_ _14527_/Q clkload21/A _14527_/D _14527_/RESET_B VDD VSS sg13g2_dfrbpq_1
X_11739_ _11743_/A _11738_/X _11967_/B VDD VSS sg13g2_nand2b_1
XFILLER_119_218 VDD VSS sg13g2_decap_8
XFILLER_174_324 VDD VSS sg13g2_decap_8
XFILLER_179_1015 VDD VSS sg13g2_decap_8
X_14458_ _14458_/Q clkload26/A _14458_/D _14458_/RESET_B VDD VSS sg13g2_dfrbpq_1
XFILLER_162_508 VDD VSS sg13g2_decap_8
XFILLER_162_519 VDD VSS sg13g2_fill_1
X_13409_ _13409_/Y _13507_/B _15092_/Q VDD VSS sg13g2_nor2b_1
XFILLER_143_700 VDD VSS sg13g2_fill_2
X_14389_ _14389_/Q clkload32/A _14389_/D _14389_/RESET_B VDD VSS sg13g2_dfrbpq_1
XFILLER_31_1166 VDD VSS sg13g2_decap_8
XFILLER_115_402 VDD VSS sg13g2_decap_8
XFILLER_143_711 VDD VSS sg13g2_decap_8
X_14553__1719 _14553_/RESET_B VDD VSS sg13g2_tiehi
X_13939__2333 _13939_/RESET_B VDD VSS sg13g2_tiehi
XFILLER_6_581 VDD VSS sg13g2_decap_8
XFILLER_66_1207 VDD VSS sg13g2_fill_1
XFILLER_142_221 VDD VSS sg13g2_decap_8
X_14699__1573 _14699_/RESET_B VDD VSS sg13g2_tiehi
XFILLER_103_608 VDD VSS sg13g2_fill_2
XFILLER_115_468 VDD VSS sg13g2_decap_8
XFILLER_170_563 VDD VSS sg13g2_decap_8
X_08950_ _08950_/Y _08948_/Y _08949_/Y _08955_/S VDD VSS sg13g2_a21oi_1
XFILLER_88_308 VDD VSS sg13g2_fill_1
Xhold3118 hold3118/X input4/X VDD VSS sg13g2_dlygate4sd3_1
Xhold3129 hold3129/X input5/X VDD VSS sg13g2_dlygate4sd3_1
XFILLER_130_427 VDD VSS sg13g2_decap_8
X_07901_ _07904_/C _08073_/A _08073_/C _08073_/B VDD VSS sg13g2_a21oi_1
XFILLER_37_0 VDD VSS sg13g2_decap_8
XFILLER_142_298 VDD VSS sg13g2_fill_2
XFILLER_9_1134 VDD VSS sg13g2_decap_8
X_08881_ _08881_/X _15034_/Q _14938_/Q _10716_/A VDD VSS sg13g2_mux2_1
XFILLER_69_555 VDD VSS sg13g2_decap_8
XFILLER_97_875 VDD VSS sg13g2_decap_8
X_07832_ _07834_/B _08692_/C _08048_/B VDD VSS sg13g2_nor2b_1
XFILLER_57_717 VDD VSS sg13g2_fill_2
XFILLER_110_151 VDD VSS sg13g2_fill_1
XFILLER_99_1016 VDD VSS sg13g2_decap_8
XFILLER_84_514 VDD VSS sg13g2_decap_8
XFILLER_56_216 VDD VSS sg13g2_decap_8
XFILLER_116_1098 VDD VSS sg13g2_decap_4
XFILLER_96_396 VDD VSS sg13g2_decap_8
XFILLER_99_1049 VDD VSS sg13g2_decap_8
XFILLER_2_70 VDD VSS sg13g2_decap_8
X_07763_ _15204_/D _07744_/B _07738_/Y _07762_/Y VDD VSS sg13g2_o21ai_1
XFILLER_42_1284 VDD VSS sg13g2_decap_8
X_09502_ _14102_/D _09966_/A1 _14102_/Q _09505_/S VDD VSS sg13g2_mux2_1
XFILLER_112_38 VDD VSS sg13g2_decap_8
X_07694_ _07694_/Y _11241_/A _11241_/C _07674_/Y VDD VSS sg13g2_a21oi_1
XFILLER_65_783 VDD VSS sg13g2_decap_8
XFILLER_38_997 VDD VSS sg13g2_decap_4
XFILLER_112_49 VDD VSS sg13g2_fill_1
XFILLER_37_485 VDD VSS sg13g2_decap_8
XFILLER_25_625 VDD VSS sg13g2_decap_8
X_09433_ _14035_/D _10029_/A0 _14035_/Q _09439_/S VDD VSS sg13g2_mux2_1
XFILLER_12_308 VDD VSS sg13g2_decap_8
X_09364_ _13968_/D _10026_/A0 _13968_/Q _09365_/S VDD VSS sg13g2_mux2_1
XFILLER_24_168 VDD VSS sg13g2_decap_8
XFILLER_178_630 VDD VSS sg13g2_decap_8
XFILLER_127_1161 VDD VSS sg13g2_decap_8
X_08315_ _08315_/Y _08315_/A _08315_/B _08315_/C VDD VSS sg13g2_nor3_1
XFILLER_177_140 VDD VSS sg13g2_decap_8
XANTENNA_20 _12223_/A VDD VSS sg13g2_antennanp
X_09295_ _13903_/D _13903_/Q _10158_/A1 _09298_/S VDD VSS sg13g2_mux2_1
XANTENNA_31 _16883_/A VDD VSS sg13g2_antennanp
XFILLER_162_1085 VDD VSS sg13g2_decap_8
XFILLER_36_1088 VDD VSS sg13g2_decap_8
XFILLER_162_1096 VDD VSS sg13g2_fill_2
X_08246_ _08246_/Y _08246_/A1 _08243_/Y _08244_/Y _08245_/Y _08240_/Y VDD VSS sg13g2_a221oi_1
XFILLER_119_730 VDD VSS sg13g2_decap_8
XFILLER_166_858 VDD VSS sg13g2_decap_8
XFILLER_20_385 VDD VSS sg13g2_decap_8
XFILLER_101_1312 VDD VSS sg13g2_decap_8
XFILLER_119_752 VDD VSS sg13g2_fill_2
XFILLER_21_35 VDD VSS sg13g2_decap_8
XFILLER_181_828 VDD VSS sg13g2_decap_8
X_08177_ _08177_/X _08042_/X _08059_/X _08431_/D VDD VSS sg13g2_mux2_1
XFILLER_115_7 VDD VSS sg13g2_decap_8
XFILLER_14_1386 VDD VSS sg13g2_decap_8
XFILLER_4_518 VDD VSS sg13g2_decap_8
XFILLER_10_1239 VDD VSS sg13g2_decap_8
X_14529__1743 _14529_/RESET_B VDD VSS sg13g2_tiehi
XFILLER_133_232 VDD VSS sg13g2_fill_2
XFILLER_106_479 VDD VSS sg13g2_decap_8
XFILLER_134_788 VDD VSS sg13g2_decap_8
XFILLER_136_1419 VDD VSS sg13g2_decap_8
XFILLER_115_991 VDD VSS sg13g2_decap_8
XFILLER_0_735 VDD VSS sg13g2_fill_1
XFILLER_133_298 VDD VSS sg13g2_decap_8
XFILLER_121_449 VDD VSS sg13g2_fill_2
X_10070_ _10070_/Y _10070_/A _10070_/B _10070_/C VDD VSS sg13g2_nand3_1
XFILLER_0_757 VDD VSS sg13g2_decap_8
XFILLER_173_1192 VDD VSS sg13g2_decap_8
XFILLER_47_1195 VDD VSS sg13g2_fill_1
XFILLER_134_1154 VDD VSS sg13g2_decap_4
XFILLER_130_983 VDD VSS sg13g2_decap_8
XFILLER_48_728 VDD VSS sg13g2_decap_8
XFILLER_88_897 VDD VSS sg13g2_decap_8
XFILLER_43_1059 VDD VSS sg13g2_decap_4
XFILLER_102_685 VDD VSS sg13g2_decap_8
XFILLER_130_1018 VDD VSS sg13g2_decap_8
XFILLER_101_184 VDD VSS sg13g2_decap_8
XFILLER_47_249 VDD VSS sg13g2_decap_8
XFILLER_46_21 VDD VSS sg13g2_decap_4
XFILLER_29_953 VDD VSS sg13g2_decap_4
XFILLER_28_430 VDD VSS sg13g2_decap_8
XFILLER_29_964 VDD VSS sg13g2_decap_8
XFILLER_169_1239 VDD VSS sg13g2_decap_8
XFILLER_1_1407 VDD VSS sg13g2_decap_8
X_13760_ _13760_/Q _14720_/CLK _13760_/D _13760_/RESET_B VDD VSS sg13g2_dfrbpq_1
XFILLER_95_1414 VDD VSS sg13g2_fill_2
XFILLER_21_1368 VDD VSS sg13g2_decap_8
X_10972_ _14939_/D _10971_/Y _10970_/Y _10959_/Y VDD VSS sg13g2_o21ai_1
XFILLER_95_1436 VDD VSS sg13g2_decap_8
X_12711_ _12711_/X _13845_/Q _13877_/Q _13909_/Q _13941_/Q _12717_/S0 _12717_/S1 VDD
+ VSS sg13g2_mux4_1
XFILLER_16_658 VDD VSS sg13g2_decap_8
X_13691_ _13691_/Q clkload80/A _13691_/D _13691_/RESET_B VDD VSS sg13g2_dfrbpq_1
XFILLER_182_1428 VDD VSS sg13g2_fill_2
XFILLER_44_989 VDD VSS sg13g2_decap_8
XFILLER_15_168 VDD VSS sg13g2_decap_8
X_12642_ _12642_/X _14384_/Q _14416_/Q _14480_/Q _14512_/Q _12643_/S0 _12643_/S1 VDD
+ VSS sg13g2_mux4_1
XFILLER_19_1231 VDD VSS sg13g2_decap_8
XFILLER_43_499 VDD VSS sg13g2_decap_8
XFILLER_62_53 VDD VSS sg13g2_decap_8
XFILLER_141_0 VDD VSS sg13g2_fill_2
XFILLER_106_1212 VDD VSS sg13g2_fill_2
XFILLER_168_140 VDD VSS sg13g2_decap_8
XFILLER_178_42 VDD VSS sg13g2_decap_8
X_12573_ _12573_/X _14123_/Q _14155_/Q _14187_/Q _14219_/Q _12600_/S0 _12600_/S1 VDD
+ VSS sg13g2_mux4_1
XFILLER_129_527 VDD VSS sg13g2_decap_8
XFILLER_145_1294 VDD VSS sg13g2_decap_4
XFILLER_62_97 VDD VSS sg13g2_decap_8
XFILLER_12_875 VDD VSS sg13g2_decap_8
XFILLER_7_301 VDD VSS sg13g2_decap_8
XFILLER_50_1019 VDD VSS sg13g2_fill_1
XFILLER_184_633 VDD VSS sg13g2_decap_4
X_14312_ _14312_/Q clkload27/A _14312_/D _14312_/RESET_B VDD VSS sg13g2_dfrbpq_1
X_11524_ _11527_/A _11502_/A _13685_/Q _11505_/X VDD VSS sg13g2_a21oi_1
XFILLER_102_1109 VDD VSS sg13g2_fill_1
Xwire232 wire232/X wire232/A VDD VSS sg13g2_buf_2
XFILLER_11_385 VDD VSS sg13g2_decap_8
Xwire243 wire243/X wire243/A VDD VSS sg13g2_buf_2
XFILLER_89_1229 VDD VSS sg13g2_decap_4
XFILLER_8_868 VDD VSS sg13g2_decap_8
XFILLER_172_817 VDD VSS sg13g2_decap_8
XFILLER_183_154 VDD VSS sg13g2_decap_8
X_14243_ _14243_/Q clkload29/A _14243_/D _14243_/RESET_B VDD VSS sg13g2_dfrbpq_1
XFILLER_172_828 VDD VSS sg13g2_fill_2
X_11455_ _11457_/C _11430_/B _11430_/A _11427_/X VDD VSS sg13g2_a21o_1
XFILLER_32_1475 VDD VSS sg13g2_decap_4
XFILLER_109_251 VDD VSS sg13g2_decap_8
Xwire276 wire276/X wire276/A VDD VSS sg13g2_buf_2
XFILLER_7_378 VDD VSS sg13g2_decap_8
XFILLER_125_722 VDD VSS sg13g2_decap_8
XFILLER_171_327 VDD VSS sg13g2_decap_8
XFILLER_139_1010 VDD VSS sg13g2_fill_1
X_10406_ _14824_/D _10406_/A _10655_/B _10406_/C VDD VSS sg13g2_nor3_1
X_14174_ _14174_/Q clkload48/A _14174_/D _14174_/RESET_B VDD VSS sg13g2_dfrbpq_1
X_11386_ _11386_/Y _07684_/B _11385_/Y wire247/X _11381_/Y _11248_/B VDD VSS sg13g2_a221oi_1
XFILLER_178_1081 VDD VSS sg13g2_decap_8
XFILLER_113_917 VDD VSS sg13g2_decap_8
X_13125_ _13125_/X input16/X _13161_/A2 _13161_/B1 VDD VSS sg13g2_a21o_1
X_10337_ _14805_/D _10337_/A _10337_/B _10337_/C VDD VSS sg13g2_and3_1
XFILLER_124_265 VDD VSS sg13g2_decap_8
XFILLER_152_574 VDD VSS sg13g2_fill_1
XFILLER_139_1076 VDD VSS sg13g2_decap_8
XFILLER_98_639 VDD VSS sg13g2_decap_8
XFILLER_112_427 VDD VSS sg13g2_decap_8
XFILLER_79_820 VDD VSS sg13g2_fill_2
X_13056_ _15036_/D _13043_/Y _13055_/Y _13021_/A VDD VSS sg13g2_a21oi_1
XFILLER_3_595 VDD VSS sg13g2_decap_8
XFILLER_30_7 VDD VSS sg13g2_decap_8
XFILLER_105_490 VDD VSS sg13g2_fill_1
XFILLER_152_1221 VDD VSS sg13g2_fill_2
X_10268_ _10299_/B _14782_/Q _14783_/Q _14784_/Q _10268_/D VDD VSS sg13g2_nand4_1
XFILLER_140_769 VDD VSS sg13g2_decap_8
XFILLER_87_72 VDD VSS sg13g2_decap_8
XFILLER_121_961 VDD VSS sg13g2_decap_4
Xfanout1330 _12237_/C _12308_/C VDD VSS sg13g2_buf_1
X_12007_ _12053_/A _12009_/A _12082_/B VDD VSS sg13g2_nor2_1
XFILLER_152_1254 VDD VSS sg13g2_fill_1
Xfanout1341 _11963_/S1 _11742_/C VDD VSS sg13g2_buf_1
XFILLER_79_886 VDD VSS sg13g2_decap_8
XFILLER_78_363 VDD VSS sg13g2_decap_8
XFILLER_66_503 VDD VSS sg13g2_decap_8
XFILLER_26_1257 VDD VSS sg13g2_decap_8
Xfanout1352 _11419_/C _11821_/S1 VDD VSS sg13g2_buf_1
XFILLER_113_1227 VDD VSS sg13g2_decap_8
XFILLER_120_471 VDD VSS sg13g2_decap_8
X_10199_ _15181_/D hold3127/X _10199_/A1 _13477_/S VDD VSS sg13g2_mux2_1
Xfanout1363 _12319_/B1 fanout1364/X VDD VSS sg13g2_buf_1
XFILLER_152_1287 VDD VSS sg13g2_fill_2
Xfanout1374 _11713_/S1 _12288_/S1 VDD VSS sg13g2_buf_1
XFILLER_93_322 VDD VSS sg13g2_fill_2
Xfanout1385 _11951_/A _11997_/S0 VDD VSS sg13g2_buf_1
Xfanout1396 _11996_/S0 fanout1400/X VDD VSS sg13g2_buf_1
XFILLER_66_558 VDD VSS sg13g2_decap_4
XFILLER_94_878 VDD VSS sg13g2_decap_8
XFILLER_19_452 VDD VSS sg13g2_decap_8
XFILLER_93_366 VDD VSS sg13g2_decap_8
XFILLER_81_517 VDD VSS sg13g2_decap_8
XFILLER_4_1064 VDD VSS sg13g2_decap_8
X_13958_ _13958_/Q clkload18/A _13958_/D _13958_/RESET_B VDD VSS sg13g2_dfrbpq_1
XFILLER_98_1082 VDD VSS sg13g2_decap_8
XFILLER_59_1033 VDD VSS sg13g2_decap_8
XFILLER_34_411 VDD VSS sg13g2_decap_8
X_12909_ _12909_/Y _12925_/A _12925_/B _12909_/C VDD VSS sg13g2_nand3_1
X_14846__2945 _14846_/RESET_B VDD VSS sg13g2_tiehi
X_13889_ _13889_/Q clkload44/A _13889_/D _13889_/RESET_B VDD VSS sg13g2_dfrbpq_1
XFILLER_179_427 VDD VSS sg13g2_decap_8
XFILLER_185_1096 VDD VSS sg13g2_decap_8
XFILLER_50_937 VDD VSS sg13g2_decap_8
XFILLER_21_105 VDD VSS sg13g2_decap_8
X_14607__1665 _14607_/RESET_B VDD VSS sg13g2_tiehi
XFILLER_124_1301 VDD VSS sg13g2_decap_8
XFILLER_163_1350 VDD VSS sg13g2_decap_4
XFILLER_50_959 VDD VSS sg13g2_decap_8
XFILLER_148_803 VDD VSS sg13g2_fill_2
XFILLER_72_1255 VDD VSS sg13g2_decap_8
X_08100_ _08104_/C _08154_/A _08138_/B _08200_/C VDD VSS sg13g2_nor3_1
XFILLER_37_1397 VDD VSS sg13g2_decap_8
XFILLER_33_1239 VDD VSS sg13g2_decap_8
X_09080_ _09082_/B _13088_/A _09103_/C _14913_/Q VDD VSS sg13g2_a21o_1
X_14879__2879 _14879_/RESET_B VDD VSS sg13g2_tiehi
XFILLER_159_1408 VDD VSS sg13g2_decap_8
XFILLER_175_677 VDD VSS sg13g2_decap_8
X_08031_ _08032_/D _08154_/A _08236_/S _08031_/C VDD VSS sg13g2_nor3_1
XFILLER_174_154 VDD VSS sg13g2_decap_8
XFILLER_116_700 VDD VSS sg13g2_decap_8
XFILLER_122_1080 VDD VSS sg13g2_decap_4
XFILLER_162_327 VDD VSS sg13g2_decap_8
XFILLER_156_891 VDD VSS sg13g2_decap_8
XFILLER_115_210 VDD VSS sg13g2_decap_8
XFILLER_116_733 VDD VSS sg13g2_decap_8
XFILLER_155_390 VDD VSS sg13g2_decap_8
XFILLER_118_1105 VDD VSS sg13g2_fill_1
X_09982_ _14565_/D _10115_/A0 _14565_/Q _09994_/S VDD VSS sg13g2_mux2_1
XFILLER_170_393 VDD VSS sg13g2_fill_2
X_08933_ _08933_/X _15047_/Q _14951_/Q _08933_/S VDD VSS sg13g2_mux2_1
XFILLER_48_1471 VDD VSS sg13g2_decap_4
XFILLER_130_235 VDD VSS sg13g2_fill_1
XFILLER_69_352 VDD VSS sg13g2_fill_1
XFILLER_44_1346 VDD VSS sg13g2_fill_2
XFILLER_130_268 VDD VSS sg13g2_decap_8
XFILLER_112_983 VDD VSS sg13g2_fill_2
X_08864_ _13699_/D _16861_/A _08863_/X _08941_/S VDD VSS sg13g2_mux2_1
XFILLER_69_374 VDD VSS sg13g2_decap_4
XFILLER_111_471 VDD VSS sg13g2_fill_1
XFILLER_170_1376 VDD VSS sg13g2_decap_8
XFILLER_85_834 VDD VSS sg13g2_decap_8
XFILLER_57_525 VDD VSS sg13g2_fill_1
XFILLER_111_493 VDD VSS sg13g2_decap_8
X_07815_ _07815_/X _15010_/Q _07818_/B VDD VSS sg13g2_or2_1
XFILLER_84_333 VDD VSS sg13g2_decap_8
X_08795_ _08796_/B _13683_/Q _08801_/B VDD VSS sg13g2_nor2_1
XFILLER_42_1081 VDD VSS sg13g2_decap_4
XFILLER_84_377 VDD VSS sg13g2_decap_8
X_07746_ _07750_/B _13481_/A _15124_/Q _07746_/C VDD VSS sg13g2_nor3_1
XFILLER_26_923 VDD VSS sg13g2_decap_8
XFILLER_53_720 VDD VSS sg13g2_decap_8
XFILLER_37_271 VDD VSS sg13g2_decap_8
XFILLER_16_35 VDD VSS sg13g2_decap_8
X_07677_ _07677_/Y _13438_/A _07677_/B _07677_/C _07721_/A VDD VSS sg13g2_nand4_1
XFILLER_164_1114 VDD VSS sg13g2_decap_8
XFILLER_168_1283 VDD VSS sg13g2_decap_8
XFILLER_77_1166 VDD VSS sg13g2_decap_8
XFILLER_168_1294 VDD VSS sg13g2_fill_1
X_09416_ _14018_/D _10045_/A0 _14018_/Q _09429_/S VDD VSS sg13g2_mux2_1
XFILLER_52_252 VDD VSS sg13g2_decap_8
XFILLER_12_105 VDD VSS sg13g2_decap_8
XFILLER_90_1311 VDD VSS sg13g2_decap_8
XFILLER_80_583 VDD VSS sg13g2_decap_8
XFILLER_53_797 VDD VSS sg13g2_decap_8
XFILLER_80_594 VDD VSS sg13g2_fill_1
XFILLER_142_1401 VDD VSS sg13g2_fill_1
XFILLER_55_1453 VDD VSS sg13g2_fill_2
XFILLER_142_1412 VDD VSS sg13g2_fill_1
X_09347_ _13951_/D _09976_/A0 _13951_/Q _09362_/S VDD VSS sg13g2_mux2_1
XFILLER_16_1426 VDD VSS sg13g2_decap_8
XFILLER_139_825 VDD VSS sg13g2_decap_8
XFILLER_179_994 VDD VSS sg13g2_decap_8
XFILLER_142_1445 VDD VSS sg13g2_decap_8
XFILLER_165_110 VDD VSS sg13g2_decap_8
XFILLER_51_1339 VDD VSS sg13g2_decap_4
XFILLER_138_335 VDD VSS sg13g2_fill_2
X_09278_ _13886_/D _13886_/Q _10141_/A1 _09294_/S VDD VSS sg13g2_mux2_1
XFILLER_32_56 VDD VSS sg13g2_decap_8
X_13701__2571 _13701_/RESET_B VDD VSS sg13g2_tiehi
XFILLER_154_806 VDD VSS sg13g2_decap_8
XFILLER_165_143 VDD VSS sg13g2_decap_4
XFILLER_20_182 VDD VSS sg13g2_decap_8
XFILLER_148_56 VDD VSS sg13g2_decap_4
X_08229_ _08229_/Y _08229_/A _08248_/A _08229_/C VDD VSS sg13g2_nand3_1
XFILLER_5_805 VDD VSS sg13g2_decap_8
XFILLER_138_379 VDD VSS sg13g2_decap_8
XFILLER_165_165 VDD VSS sg13g2_decap_8
XFILLER_14_1183 VDD VSS sg13g2_decap_8
XFILLER_101_1142 VDD VSS sg13g2_fill_2
XFILLER_107_722 VDD VSS sg13g2_decap_8
XFILLER_119_582 VDD VSS sg13g2_fill_1
XFILLER_4_315 VDD VSS sg13g2_decap_8
XFILLER_119_593 VDD VSS sg13g2_fill_1
X_11240_ _11248_/A _12866_/A _15123_/Q _11239_/Y VDD VSS sg13g2_a21oi_1
XFILLER_10_1036 VDD VSS sg13g2_decap_8
XFILLER_134_530 VDD VSS sg13g2_decap_8
XFILLER_175_1210 VDD VSS sg13g2_decap_8
XFILLER_181_658 VDD VSS sg13g2_decap_8
XFILLER_49_1224 VDD VSS sg13g2_decap_8
XFILLER_162_861 VDD VSS sg13g2_decap_8
X_14045__2227 _14045_/RESET_B VDD VSS sg13g2_tiehi
XFILLER_180_168 VDD VSS sg13g2_decap_8
XFILLER_101_1197 VDD VSS sg13g2_decap_8
X_11171_ _11186_/A _11181_/A _11171_/B VDD VSS sg13g2_nand2_1
XFILLER_84_1137 VDD VSS sg13g2_decap_8
XFILLER_122_725 VDD VSS sg13g2_decap_8
XFILLER_84_1148 VDD VSS sg13g2_fill_2
XFILLER_171_1107 VDD VSS sg13g2_decap_8
XFILLER_106_287 VDD VSS sg13g2_fill_1
XFILLER_122_736 VDD VSS sg13g2_fill_2
XFILLER_161_393 VDD VSS sg13g2_decap_8
X_10122_ _14700_/D _10122_/A0 _14700_/Q _10130_/S VDD VSS sg13g2_mux2_1
XFILLER_0_532 VDD VSS sg13g2_decap_8
XFILLER_110_909 VDD VSS sg13g2_decap_8
XFILLER_164_88 VDD VSS sg13g2_decap_4
XFILLER_121_246 VDD VSS sg13g2_decap_8
XFILLER_62_1424 VDD VSS sg13g2_fill_1
X_14930_ _14930_/Q _15224_/CLK _14930_/D _14930_/RESET_B VDD VSS sg13g2_dfrbpq_1
X_10053_ _14634_/D _10086_/A0 _14634_/Q _10060_/S VDD VSS sg13g2_mux2_1
XFILLER_87_160 VDD VSS sg13g2_fill_2
XFILLER_48_514 VDD VSS sg13g2_fill_2
XFILLER_76_834 VDD VSS sg13g2_decap_4
XFILLER_180_21 VDD VSS sg13g2_decap_8
XFILLER_76_856 VDD VSS sg13g2_fill_1
XFILLER_75_322 VDD VSS sg13g2_decap_8
X_14260__2012 _14260_/RESET_B VDD VSS sg13g2_tiehi
XFILLER_87_193 VDD VSS sg13g2_decap_4
XFILLER_75_333 VDD VSS sg13g2_fill_1
X_14861_ _14861_/Q _14864_/CLK _14861_/D _14861_/RESET_B VDD VSS sg13g2_dfrbpq_1
XFILLER_75_355 VDD VSS sg13g2_decap_8
XFILLER_5_1351 VDD VSS sg13g2_decap_8
XFILLER_1_1204 VDD VSS sg13g2_decap_8
X_13812_ _13812_/Q _14740_/CLK _13812_/D _13812_/RESET_B VDD VSS sg13g2_dfrbpq_1
XFILLER_75_377 VDD VSS sg13g2_fill_2
XFILLER_169_1047 VDD VSS sg13g2_decap_4
XFILLER_180_98 VDD VSS sg13g2_decap_8
XFILLER_90_314 VDD VSS sg13g2_decap_8
XFILLER_63_528 VDD VSS sg13g2_decap_8
XFILLER_17_934 VDD VSS sg13g2_decap_8
XFILLER_21_1165 VDD VSS sg13g2_decap_8
X_14792_ _14792_/Q clkload62/A _14792_/D _14792_/RESET_B VDD VSS sg13g2_dfrbpq_1
XFILLER_99_1380 VDD VSS sg13g2_decap_8
XFILLER_113_81 VDD VSS sg13g2_decap_4
X_13743_ _13743_/Q _14607_/CLK _13743_/D _13743_/RESET_B VDD VSS sg13g2_dfrbpq_1
X_10955_ _10956_/B _10954_/C _10965_/C _10953_/Y VDD VSS sg13g2_a21o_1
XFILLER_16_455 VDD VSS sg13g2_decap_8
XFILLER_95_1266 VDD VSS sg13g2_decap_8
XFILLER_147_1345 VDD VSS sg13g2_fill_2
XFILLER_182_1247 VDD VSS sg13g2_decap_8
X_13674_ _13674_/Q clkload65/A _13674_/D _13674_/RESET_B VDD VSS sg13g2_dfrbpq_1
X_14998__2682 _14998_/RESET_B VDD VSS sg13g2_tiehi
X_10886_ _10886_/X _10897_/A _08723_/B _07705_/B VDD VSS sg13g2_a21o_1
XFILLER_43_296 VDD VSS sg13g2_decap_8
X_12625_ _15008_/D _12625_/A _12625_/B VDD VSS sg13g2_nor2_1
XFILLER_31_469 VDD VSS sg13g2_decap_8
XFILLER_106_1042 VDD VSS sg13g2_decap_8
XFILLER_129_324 VDD VSS sg13g2_decap_8
XFILLER_12_672 VDD VSS sg13g2_decap_8
X_12556_ _12569_/A _12779_/A1 _12779_/A2 _08383_/B VDD VSS sg13g2_a21oi_1
XFILLER_157_655 VDD VSS sg13g2_decap_8
XFILLER_184_441 VDD VSS sg13g2_fill_1
XFILLER_78_7 VDD VSS sg13g2_decap_8
XFILLER_11_182 VDD VSS sg13g2_decap_8
XFILLER_185_975 VDD VSS sg13g2_decap_8
X_11507_ _11507_/X _13827_/Q _13859_/Q _13891_/Q _13923_/Q _12284_/S0 _12284_/S1 VDD
+ VSS sg13g2_mux4_1
XFILLER_8_665 VDD VSS sg13g2_decap_8
XFILLER_89_1026 VDD VSS sg13g2_decap_8
XFILLER_185_997 VDD VSS sg13g2_decap_8
X_12487_ _12487_/X _13829_/Q _13861_/Q _13893_/Q _13925_/Q _12633_/S0 _12633_/S1 VDD
+ VSS sg13g2_mux4_1
XFILLER_176_1007 VDD VSS sg13g2_fill_1
XFILLER_138_891 VDD VSS sg13g2_decap_8
XFILLER_7_175 VDD VSS sg13g2_decap_8
X_14226_ _14226_/Q _14674_/CLK _14226_/D _14226_/RESET_B VDD VSS sg13g2_dfrbpq_1
X_11438_ _11439_/B _14240_/Q _14272_/Q _14304_/Q _14336_/Q _11489_/S0 _11489_/S1 VDD
+ VSS sg13g2_mux4_1
XFILLER_137_390 VDD VSS sg13g2_decap_8
XFILLER_160_809 VDD VSS sg13g2_decap_8
XFILLER_99_915 VDD VSS sg13g2_decap_8
XFILLER_171_168 VDD VSS sg13g2_fill_1
X_14157_ _14157_/Q _14669_/CLK _14157_/D _14157_/RESET_B VDD VSS sg13g2_dfrbpq_1
X_14470__1802 _14470_/RESET_B VDD VSS sg13g2_tiehi
X_11369_ _11369_/Y _11367_/Y _11366_/Y _11900_/B _11368_/X VDD VSS sg13g2_a22oi_1
XFILLER_4_882 VDD VSS sg13g2_decap_8
XFILLER_28_1319 VDD VSS sg13g2_decap_8
XFILLER_125_596 VDD VSS sg13g2_decap_8
XFILLER_140_533 VDD VSS sg13g2_decap_8
X_13108_ _13108_/Y _14786_/Q _13208_/A2 _13208_/B1 VDD VSS sg13g2_o21ai_1
X_14088_ _14088_/Q clkload23/A _14088_/D _14088_/RESET_B VDD VSS sg13g2_dfrbpq_1
XFILLER_3_392 VDD VSS sg13g2_decap_8
XFILLER_65_1070 VDD VSS sg13g2_decap_8
X_13039_ _13057_/C _14909_/Q _13678_/Q VDD VSS sg13g2_nand2_1
XFILLER_85_108 VDD VSS sg13g2_decap_8
XFILLER_65_1092 VDD VSS sg13g2_fill_2
XFILLER_79_683 VDD VSS sg13g2_fill_1
XFILLER_117_1182 VDD VSS sg13g2_fill_2
Xfanout1160 _07853_/B _12128_/A VDD VSS sg13g2_buf_1
XFILLER_6_1148 VDD VSS sg13g2_decap_8
XFILLER_26_1076 VDD VSS sg13g2_fill_1
Xfanout1171 _12009_/A _14980_/Q VDD VSS sg13g2_buf_1
XFILLER_66_333 VDD VSS sg13g2_decap_8
XFILLER_152_1095 VDD VSS sg13g2_fill_1
Xfanout1182 _08471_/B _08510_/A2 VDD VSS sg13g2_buf_1
XFILLER_94_653 VDD VSS sg13g2_decap_4
XFILLER_39_558 VDD VSS sg13g2_fill_2
X_13743__2529 _13743_/RESET_B VDD VSS sg13g2_tiehi
Xfanout1193 _07946_/B _08427_/A3 VDD VSS sg13g2_buf_1
X_13889__2383 _13889_/RESET_B VDD VSS sg13g2_tiehi
XFILLER_93_163 VDD VSS sg13g2_decap_4
X_08580_ _08581_/B _08641_/D _08578_/Y _08579_/Y VDD VSS sg13g2_o21ai_1
XFILLER_82_837 VDD VSS sg13g2_decap_8
XFILLER_26_219 VDD VSS sg13g2_decap_8
XFILLER_130_1371 VDD VSS sg13g2_decap_4
XFILLER_54_539 VDD VSS sg13g2_fill_1
XFILLER_35_720 VDD VSS sg13g2_decap_8
XFILLER_47_591 VDD VSS sg13g2_decap_8
XFILLER_35_731 VDD VSS sg13g2_fill_2
XFILLER_130_1393 VDD VSS sg13g2_fill_1
XFILLER_78_1464 VDD VSS sg13g2_decap_8
XFILLER_35_764 VDD VSS sg13g2_decap_4
XFILLER_23_904 VDD VSS sg13g2_fill_1
XFILLER_39_1437 VDD VSS sg13g2_decap_8
XFILLER_179_224 VDD VSS sg13g2_decap_8
XFILLER_23_926 VDD VSS sg13g2_decap_8
XFILLER_62_572 VDD VSS sg13g2_fill_1
XFILLER_39_1459 VDD VSS sg13g2_decap_8
XFILLER_165_1467 VDD VSS sg13g2_fill_2
XFILLER_50_723 VDD VSS sg13g2_fill_2
XFILLER_126_1429 VDD VSS sg13g2_decap_8
X_14123__2149 _14123_/RESET_B VDD VSS sg13g2_tiehi
X_09201_ _13817_/D _13817_/Q _10168_/A1 _09201_/S VDD VSS sg13g2_mux2_1
XFILLER_167_408 VDD VSS sg13g2_decap_8
XFILLER_50_767 VDD VSS sg13g2_fill_2
XFILLER_37_1150 VDD VSS sg13g2_fill_1
XFILLER_10_609 VDD VSS sg13g2_decap_8
XFILLER_37_1183 VDD VSS sg13g2_decap_8
X_09132_ _13781_/D _13781_/Q _10164_/A1 _09160_/S VDD VSS sg13g2_mux2_1
XFILLER_31_992 VDD VSS sg13g2_fill_2
XFILLER_147_132 VDD VSS sg13g2_decap_8
XFILLER_148_655 VDD VSS sg13g2_decap_8
XFILLER_124_1186 VDD VSS sg13g2_decap_8
X_09063_ _09063_/X _09137_/A _09060_/X _09062_/Y VDD VSS sg13g2_a21o_1
XFILLER_163_614 VDD VSS sg13g2_decap_8
XFILLER_175_474 VDD VSS sg13g2_decap_8
XFILLER_8_91 VDD VSS sg13g2_decap_8
XFILLER_11_1323 VDD VSS sg13g2_decap_8
XFILLER_163_636 VDD VSS sg13g2_decap_8
X_08014_ _08014_/Y _08011_/X _08338_/B VDD VSS sg13g2_nand2b_1
XFILLER_162_124 VDD VSS sg13g2_decap_4
XFILLER_85_1402 VDD VSS sg13g2_decap_8
XFILLER_85_1435 VDD VSS sg13g2_decap_8
XFILLER_2_819 VDD VSS sg13g2_decap_8
XFILLER_116_563 VDD VSS sg13g2_decap_8
XFILLER_46_1408 VDD VSS sg13g2_decap_8
XFILLER_1_329 VDD VSS sg13g2_decap_8
XFILLER_89_436 VDD VSS sg13g2_decap_8
XFILLER_134_14 VDD VSS sg13g2_fill_2
XFILLER_170_190 VDD VSS sg13g2_decap_4
X_09965_ _14549_/D _14549_/Q _09998_/A0 _09965_/S VDD VSS sg13g2_mux2_1
XFILLER_89_469 VDD VSS sg13g2_decap_8
XFILLER_103_257 VDD VSS sg13g2_fill_1
X_13676__2613 _13676_/RESET_B VDD VSS sg13g2_tiehi
XFILLER_44_1132 VDD VSS sg13g2_decap_8
X_08916_ _08916_/Y _13608_/A1 _08835_/B _16873_/A VDD VSS sg13g2_a21oi_1
XFILLER_170_1151 VDD VSS sg13g2_decap_8
XFILLER_98_992 VDD VSS sg13g2_decap_8
XFILLER_131_1113 VDD VSS sg13g2_fill_2
XFILLER_170_1162 VDD VSS sg13g2_fill_1
X_09896_ _14482_/D _09896_/A0 _14482_/Q _09896_/S VDD VSS sg13g2_mux2_1
XFILLER_94_18 VDD VSS sg13g2_fill_2
XFILLER_85_631 VDD VSS sg13g2_fill_2
XFILLER_58_845 VDD VSS sg13g2_decap_8
XFILLER_44_1187 VDD VSS sg13g2_decap_8
XFILLER_170_1195 VDD VSS sg13g2_fill_2
XFILLER_182_7 VDD VSS sg13g2_decap_8
X_08847_ _13694_/D _16856_/A _08846_/Y _08941_/S VDD VSS sg13g2_mux2_1
XFILLER_131_1179 VDD VSS sg13g2_decap_4
X_14333__1939 _14333_/RESET_B VDD VSS sg13g2_tiehi
X_13719__2553 _13719_/RESET_B VDD VSS sg13g2_tiehi
X_08778_ _08778_/Y _13678_/Q _08781_/B VDD VSS sg13g2_nor2_1
XFILLER_84_174 VDD VSS sg13g2_decap_8
XFILLER_150_35 VDD VSS sg13g2_decap_8
X_14479__1793 _14479_/RESET_B VDD VSS sg13g2_tiehi
XFILLER_27_56 VDD VSS sg13g2_decap_8
X_07729_ wire706/A _15105_/Q _07729_/B _13273_/B _07729_/D VDD VSS sg13g2_nor4_1
XFILLER_25_230 VDD VSS sg13g2_fill_2
XFILLER_92_1417 VDD VSS sg13g2_decap_8
X_10740_ _11033_/B _10740_/A1 _09079_/Y _08907_/Y VDD VSS sg13g2_o21ai_1
X_15193__2866 _15193_/RESET_B VDD VSS sg13g2_tiehi
XFILLER_14_959 VDD VSS sg13g2_decap_8
XFILLER_80_391 VDD VSS sg13g2_decap_8
X_10671_ _10671_/Y _13304_/B _13438_/A VDD VSS sg13g2_nand2b_1
XFILLER_40_244 VDD VSS sg13g2_decap_8
XFILLER_13_469 VDD VSS sg13g2_decap_8
XFILLER_16_1223 VDD VSS sg13g2_decap_8
XFILLER_43_77 VDD VSS sg13g2_decap_8
XFILLER_142_1231 VDD VSS sg13g2_decap_8
XFILLER_185_238 VDD VSS sg13g2_decap_8
X_12410_ _12410_/X _13823_/Q _13855_/Q _13887_/Q _13919_/Q _12585_/S0 _12591_/S1 VDD
+ VSS sg13g2_mux4_1
XFILLER_159_66 VDD VSS sg13g2_decap_4
XFILLER_55_1294 VDD VSS sg13g2_decap_8
XFILLER_22_981 VDD VSS sg13g2_decap_8
X_13390_ _15083_/D _15083_/Q _13407_/A _13389_/Y VDD VSS sg13g2_a21o_1
XFILLER_139_655 VDD VSS sg13g2_decap_4
XFILLER_90_1196 VDD VSS sg13g2_decap_8
XFILLER_127_817 VDD VSS sg13g2_decap_8
XFILLER_159_99 VDD VSS sg13g2_fill_2
XFILLER_182_901 VDD VSS sg13g2_fill_2
X_12341_ _14988_/D _12302_/Y _12340_/Y _12298_/Y VDD VSS sg13g2_a21oi_1
XFILLER_103_1248 VDD VSS sg13g2_fill_2
XFILLER_127_828 VDD VSS sg13g2_fill_2
XFILLER_5_602 VDD VSS sg13g2_decap_8
XFILLER_138_176 VDD VSS sg13g2_fill_1
XFILLER_166_485 VDD VSS sg13g2_decap_8
XFILLER_182_945 VDD VSS sg13g2_decap_8
XFILLER_175_21 VDD VSS sg13g2_decap_8
XFILLER_177_1327 VDD VSS sg13g2_decap_8
XFILLER_182_956 VDD VSS sg13g2_fill_2
X_15060_ _15060_/Q clkload91/A _15060_/D _15060_/RESET_B VDD VSS sg13g2_dfrbpq_1
XFILLER_4_112 VDD VSS sg13g2_decap_8
XFILLER_153_135 VDD VSS sg13g2_decap_4
X_12272_ _12273_/A _12272_/A _12231_/A VDD VSS sg13g2_nor2b_1
XFILLER_119_390 VDD VSS sg13g2_decap_8
XFILLER_154_669 VDD VSS sg13g2_decap_8
XFILLER_181_455 VDD VSS sg13g2_decap_8
X_14011_ _14011_/Q clkload60/A _14011_/D _14011_/RESET_B VDD VSS sg13g2_dfrbpq_1
XFILLER_104_0 VDD VSS sg13g2_decap_8
X_11223_ _11224_/C _11832_/C _11223_/B _11223_/C VDD VSS sg13g2_nor3_1
XFILLER_88_1081 VDD VSS sg13g2_decap_8
XFILLER_5_679 VDD VSS sg13g2_decap_8
XFILLER_135_883 VDD VSS sg13g2_fill_1
XFILLER_175_98 VDD VSS sg13g2_decap_8
XFILLER_4_189 VDD VSS sg13g2_decap_8
XFILLER_4_49 VDD VSS sg13g2_decap_8
X_11154_ _11154_/Y _11109_/B _11180_/C _11154_/B1 VDD VSS sg13g2_o21ai_1
XFILLER_108_92 VDD VSS sg13g2_decap_8
XFILLER_136_1046 VDD VSS sg13g2_decap_8
XFILLER_161_190 VDD VSS sg13g2_decap_8
XFILLER_110_706 VDD VSS sg13g2_decap_8
X_10105_ _10105_/X _10105_/A _10105_/B _10105_/C _10105_/D VDD VSS sg13g2_and4_1
X_11085_ _11085_/Y _11172_/A _11115_/A VDD VSS sg13g2_nor2_1
XFILLER_7_1435 VDD VSS sg13g2_decap_8
XFILLER_27_1363 VDD VSS sg13g2_decap_8
XFILLER_1_896 VDD VSS sg13g2_decap_8
XFILLER_49_845 VDD VSS sg13g2_decap_8
X_14913_ _14913_/Q clkload56/A _14913_/D _14913_/RESET_B VDD VSS sg13g2_dfrbpq_1
X_10036_ _14618_/D _10102_/A0 _14618_/Q _10036_/S VDD VSS sg13g2_mux2_1
XFILLER_48_333 VDD VSS sg13g2_decap_4
XFILLER_76_664 VDD VSS sg13g2_fill_2
XFILLER_64_804 VDD VSS sg13g2_decap_8
XFILLER_97_1317 VDD VSS sg13g2_decap_8
XFILLER_91_612 VDD VSS sg13g2_decap_8
XFILLER_84_40 VDD VSS sg13g2_decap_8
XFILLER_48_377 VDD VSS sg13g2_decap_8
XFILLER_1_1001 VDD VSS sg13g2_decap_8
X_14844_ _14844_/Q clkload68/A _14844_/D _14844_/RESET_B VDD VSS sg13g2_dfrbpq_1
XFILLER_76_697 VDD VSS sg13g2_decap_8
XFILLER_36_539 VDD VSS sg13g2_decap_8
X_14309__1963 _14309_/RESET_B VDD VSS sg13g2_tiehi
XFILLER_17_742 VDD VSS sg13g2_decap_8
Xclkbuf_5_10__f_clk_i clkbuf_leaf_37_clk_i/A clkbuf_4_5_0_clk_i/X VDD VSS sg13g2_buf_16
X_14775_ _14775_/Q _14864_/CLK _14775_/D _14775_/RESET_B VDD VSS sg13g2_dfrbpq_1
X_11987_ _11989_/B _11936_/A _13129_/B _11988_/B VDD VSS sg13g2_o21ai_1
XFILLER_90_155 VDD VSS sg13g2_decap_8
XFILLER_44_550 VDD VSS sg13g2_decap_8
XFILLER_16_252 VDD VSS sg13g2_decap_8
XFILLER_182_1011 VDD VSS sg13g2_fill_1
XFILLER_1_1078 VDD VSS sg13g2_decap_8
XFILLER_56_1014 VDD VSS sg13g2_decap_8
X_13726_ _13726_/Q clkload48/A _13726_/D _13726_/RESET_B VDD VSS sg13g2_dfrbpq_1
XFILLER_147_1153 VDD VSS sg13g2_decap_4
X_10938_ _10938_/Y _10937_/Y _11043_/A _10935_/Y _10934_/Y _13412_/C VDD VSS sg13g2_a221oi_1
XFILLER_31_211 VDD VSS sg13g2_decap_4
XFILLER_31_233 VDD VSS sg13g2_decap_8
XFILLER_143_1028 VDD VSS sg13g2_decap_8
XFILLER_177_728 VDD VSS sg13g2_decap_8
XFILLER_32_767 VDD VSS sg13g2_decap_8
X_13657_ _13657_/Q _15212_/CLK _13657_/D _13657_/RESET_B VDD VSS sg13g2_dfrbpq_1
X_10869_ _10869_/Y _10869_/A _10869_/B VDD VSS sg13g2_nor2_1
XFILLER_108_1159 VDD VSS sg13g2_decap_8
XFILLER_182_1088 VDD VSS sg13g2_fill_2
XFILLER_20_929 VDD VSS sg13g2_decap_4
XFILLER_73_1361 VDD VSS sg13g2_decap_8
XFILLER_160_1320 VDD VSS sg13g2_decap_8
XFILLER_176_238 VDD VSS sg13g2_decap_8
X_12608_ _12608_/X _12602_/X _12606_/X _12601_/X _12605_/X _12761_/S1 _12761_/S0 VDD
+ VSS sg13g2_mux4_1
X_13588_ _15161_/D _13593_/B _13586_/Y _13587_/Y VDD VSS sg13g2_a21oi_1
XFILLER_9_952 VDD VSS sg13g2_decap_8
XFILLER_129_154 VDD VSS sg13g2_fill_1
XFILLER_145_603 VDD VSS sg13g2_fill_2
XFILLER_117_305 VDD VSS sg13g2_decap_8
XFILLER_173_923 VDD VSS sg13g2_decap_8
X_12539_ _12539_/X _12537_/X _12538_/X _12636_/S VDD VSS sg13g2_mux2_1
XFILLER_8_462 VDD VSS sg13g2_decap_8
XFILLER_129_176 VDD VSS sg13g2_decap_8
XFILLER_157_485 VDD VSS sg13g2_decap_8
XFILLER_144_124 VDD VSS sg13g2_decap_8
XFILLER_144_135 VDD VSS sg13g2_fill_2
XFILLER_172_444 VDD VSS sg13g2_decap_8
XFILLER_126_850 VDD VSS sg13g2_decap_4
X_14209_ _14209_/Q clkload38/A _14209_/D _14209_/RESET_B VDD VSS sg13g2_dfrbpq_1
XFILLER_125_360 VDD VSS sg13g2_decap_8
XFILLER_153_680 VDD VSS sg13g2_decap_8
XFILLER_154_1102 VDD VSS sg13g2_decap_8
X_15189_ _15189_/Q clkload81/A _15189_/D _15189_/RESET_B VDD VSS sg13g2_dfrbpq_1
XFILLER_67_1154 VDD VSS sg13g2_decap_8
XFILLER_28_1116 VDD VSS sg13g2_decap_8
XFILLER_158_1282 VDD VSS sg13g2_decap_8
XFILLER_98_222 VDD VSS sg13g2_decap_8
XFILLER_63_1007 VDD VSS sg13g2_decap_8
Xfanout408 _09267_/S _09261_/S VDD VSS sg13g2_buf_1
XFILLER_67_1187 VDD VSS sg13g2_fill_2
Xfanout419 _09582_/A1 wire422/X VDD VSS sg13g2_buf_1
XFILLER_87_918 VDD VSS sg13g2_decap_8
XFILLER_140_352 VDD VSS sg13g2_decap_8
XFILLER_45_1430 VDD VSS sg13g2_decap_8
XFILLER_80_1332 VDD VSS sg13g2_fill_1
X_09750_ _14340_/D _14340_/Q _09882_/A0 _09771_/S VDD VSS sg13g2_mux2_1
XFILLER_132_1411 VDD VSS sg13g2_decap_8
XFILLER_132_1422 VDD VSS sg13g2_fill_1
X_08701_ _08701_/Y _07835_/Y _08699_/Y _08588_/B VDD VSS sg13g2_o21ai_1
X_09681_ _14273_/D _09912_/A1 _14273_/Q _09705_/S VDD VSS sg13g2_mux2_1
XFILLER_104_28 VDD VSS sg13g2_decap_8
XFILLER_80_1387 VDD VSS sg13g2_decap_8
XFILLER_67_664 VDD VSS sg13g2_fill_2
X_08632_ _08633_/A _08641_/A _08630_/Y _08631_/Y VDD VSS sg13g2_o21ai_1
XFILLER_81_111 VDD VSS sg13g2_decap_8
XFILLER_66_185 VDD VSS sg13g2_decap_4
XFILLER_54_325 VDD VSS sg13g2_decap_8
X_08563_ _08563_/Y _08560_/A _08407_/Y _08562_/Y VDD VSS sg13g2_a21oi_1
XFILLER_81_144 VDD VSS sg13g2_decap_4
XFILLER_42_509 VDD VSS sg13g2_decap_8
XFILLER_70_829 VDD VSS sg13g2_decap_8
XFILLER_39_1234 VDD VSS sg13g2_decap_4
X_08494_ _08494_/Y _08494_/A _08494_/B VDD VSS sg13g2_nor2_1
XFILLER_50_520 VDD VSS sg13g2_decap_8
XFILLER_35_594 VDD VSS sg13g2_decap_8
XFILLER_165_1264 VDD VSS sg13g2_decap_4
XFILLER_35_1109 VDD VSS sg13g2_fill_2
XFILLER_165_1297 VDD VSS sg13g2_fill_1
XFILLER_10_406 VDD VSS sg13g2_decap_8
XFILLER_149_931 VDD VSS sg13g2_decap_8
XFILLER_22_266 VDD VSS sg13g2_decap_4
XFILLER_13_14 VDD VSS sg13g2_decap_8
XFILLER_13_1407 VDD VSS sg13g2_decap_8
XFILLER_52_1456 VDD VSS sg13g2_decap_8
X_09115_ _09117_/B _10760_/A _09150_/B _13190_/A VDD VSS sg13g2_a21o_1
XFILLER_164_934 VDD VSS sg13g2_fill_1
XFILLER_176_794 VDD VSS sg13g2_decap_8
XFILLER_136_636 VDD VSS sg13g2_decap_8
XFILLER_163_422 VDD VSS sg13g2_decap_8
XFILLER_11_1120 VDD VSS sg13g2_decap_8
XFILLER_159_1024 VDD VSS sg13g2_fill_1
X_09046_ _13768_/D _13768_/Q _10051_/A0 _09106_/S VDD VSS sg13g2_mux2_1
XFILLER_117_850 VDD VSS sg13g2_decap_8
XFILLER_85_1210 VDD VSS sg13g2_decap_8
XFILLER_159_1057 VDD VSS sg13g2_decap_8
XFILLER_117_872 VDD VSS sg13g2_decap_8
XFILLER_135_179 VDD VSS sg13g2_fill_1
XFILLER_2_616 VDD VSS sg13g2_decap_8
XFILLER_116_371 VDD VSS sg13g2_decap_8
XFILLER_117_894 VDD VSS sg13g2_decap_8
XFILLER_132_820 VDD VSS sg13g2_decap_4
XFILLER_11_1197 VDD VSS sg13g2_decap_8
XFILLER_176_1371 VDD VSS sg13g2_decap_8
XFILLER_145_35 VDD VSS sg13g2_decap_8
XFILLER_176_1382 VDD VSS sg13g2_fill_2
XFILLER_8_7 VDD VSS sg13g2_decap_8
XFILLER_85_1265 VDD VSS sg13g2_decap_8
XFILLER_1_126 VDD VSS sg13g2_decap_8
XFILLER_145_68 VDD VSS sg13g2_decap_8
XFILLER_85_1298 VDD VSS sg13g2_decap_8
XFILLER_172_1257 VDD VSS sg13g2_decap_8
Xfanout920 _12606_/S0 _12564_/S0 VDD VSS sg13g2_buf_1
XFILLER_89_266 VDD VSS sg13g2_decap_8
XFILLER_172_1268 VDD VSS sg13g2_fill_1
Xfanout931 _12754_/S0 fanout932/X VDD VSS sg13g2_buf_1
Xfanout942 _12382_/S0 fanout948/X VDD VSS sg13g2_buf_1
X_09948_ _14532_/D _14532_/Q _10047_/A0 _09965_/S VDD VSS sg13g2_mux2_1
Xfanout953 fanout953/X fanout966/X VDD VSS sg13g2_buf_1
Xfanout964 _12424_/S0 _12425_/S0 VDD VSS sg13g2_buf_1
XFILLER_58_631 VDD VSS sg13g2_decap_8
X_14566__1706 _14566_/RESET_B VDD VSS sg13g2_tiehi
Xfanout975 _11236_/A _15209_/Q VDD VSS sg13g2_buf_1
Xfanout986 _07737_/B _12765_/A2 VDD VSS sg13g2_buf_1
Xfanout997 _13555_/C _13566_/C VDD VSS sg13g2_buf_1
X_09879_ _14465_/D _09912_/A1 _14465_/Q _09903_/S VDD VSS sg13g2_mux2_1
XFILLER_86_973 VDD VSS sg13g2_decap_8
X_14602__1670 _14602_/RESET_B VDD VSS sg13g2_tiehi
XFILLER_38_77 VDD VSS sg13g2_fill_2
XFILLER_161_56 VDD VSS sg13g2_fill_2
XFILLER_58_686 VDD VSS sg13g2_decap_8
X_11910_ _12056_/B _11910_/A _11910_/B _11910_/C VDD VSS sg13g2_nor3_1
XFILLER_79_1025 VDD VSS sg13g2_decap_8
XFILLER_18_539 VDD VSS sg13g2_decap_8
X_12890_ _12894_/A _12875_/Y _12861_/A _12889_/Y VDD VSS sg13g2_o21ai_1
XFILLER_79_1036 VDD VSS sg13g2_fill_1
XFILLER_73_645 VDD VSS sg13g2_fill_2
XFILLER_57_196 VDD VSS sg13g2_decap_8
XFILLER_45_336 VDD VSS sg13g2_decap_8
XFILLER_22_1282 VDD VSS sg13g2_decap_8
XFILLER_79_1069 VDD VSS sg13g2_fill_1
X_11841_ _11845_/C _11770_/A _13064_/B _13676_/Q _11798_/A _11779_/Y VDD VSS sg13g2_a221oi_1
XFILLER_73_667 VDD VSS sg13g2_fill_2
XFILLER_54_21 VDD VSS sg13g2_decap_8
XFILLER_2_1365 VDD VSS sg13g2_decap_8
XFILLER_73_678 VDD VSS sg13g2_fill_2
XFILLER_96_1361 VDD VSS sg13g2_decap_8
XFILLER_60_317 VDD VSS sg13g2_decap_8
XFILLER_57_1334 VDD VSS sg13g2_decap_4
X_14560_ _14560_/Q _14656_/CLK _14560_/D _14560_/RESET_B VDD VSS sg13g2_dfrbpq_1
X_11772_ _11772_/Y _11706_/A _13679_/Q _13678_/Q _11726_/A _11771_/Y VDD VSS sg13g2_a221oi_1
XFILLER_92_1225 VDD VSS sg13g2_decap_8
XFILLER_72_188 VDD VSS sg13g2_fill_1
XFILLER_14_756 VDD VSS sg13g2_decap_8
XFILLER_18_1318 VDD VSS sg13g2_decap_8
XFILLER_53_391 VDD VSS sg13g2_decap_8
XFILLER_41_531 VDD VSS sg13g2_decap_8
X_13511_ _15134_/D _15134_/Q _08621_/B _13519_/B VDD VSS sg13g2_mux2_1
X_10723_ _10724_/A _14908_/Q _11196_/B _11183_/B1 _11015_/C VDD VSS sg13g2_a22oi_1
X_14491_ _14491_/Q _14883_/CLK _14491_/D _14491_/RESET_B VDD VSS sg13g2_dfrbpq_1
XFILLER_13_266 VDD VSS sg13g2_decap_8
XFILLER_158_238 VDD VSS sg13g2_decap_4
XFILLER_139_430 VDD VSS sg13g2_fill_1
X_13442_ _13442_/Y _13442_/A _13444_/B _13444_/C VDD VSS sg13g2_nor3_1
X_10654_ _10663_/D _10654_/A _10654_/B VDD VSS sg13g2_nor2_1
XFILLER_70_42 VDD VSS sg13g2_decap_8
XFILLER_9_259 VDD VSS sg13g2_decap_8
XFILLER_139_452 VDD VSS sg13g2_decap_8
XFILLER_139_463 VDD VSS sg13g2_decap_8
XFILLER_107_1192 VDD VSS sg13g2_fill_1
XFILLER_155_923 VDD VSS sg13g2_decap_8
XFILLER_186_42 VDD VSS sg13g2_decap_8
X_13373_ _13444_/A _13396_/A _13396_/B _13438_/B VDD VSS sg13g2_nand3_1
XFILLER_10_973 VDD VSS sg13g2_decap_8
XFILLER_186_53 VDD VSS sg13g2_fill_2
X_10585_ _14872_/D _10591_/C _10591_/D _10581_/Y VDD VSS sg13g2_a21oi_1
XFILLER_103_1045 VDD VSS sg13g2_decap_8
XFILLER_16_1097 VDD VSS sg13g2_decap_8
Xclkload18 clkload18/Y clkload18/A VDD VSS sg13g2_inv_2
XFILLER_126_113 VDD VSS sg13g2_decap_8
Xclkload29 clkload29/Y clkload29/A VDD VSS sg13g2_inv_1
X_15112_ _15112_/Q _15113_/CLK _15112_/D _15112_/RESET_B VDD VSS sg13g2_dfrbpq_1
X_12324_ _12324_/X _12324_/A _12324_/B VDD VSS sg13g2_and2_1
XFILLER_103_1078 VDD VSS sg13g2_decap_8
XFILLER_6_966 VDD VSS sg13g2_decap_8
XFILLER_155_989 VDD VSS sg13g2_decap_8
XFILLER_181_252 VDD VSS sg13g2_decap_8
XFILLER_182_775 VDD VSS sg13g2_decap_8
XFILLER_138_1119 VDD VSS sg13g2_decap_8
X_15043_ _15043_/Q clkload83/A _15043_/D _15043_/RESET_B VDD VSS sg13g2_dfrbpq_1
X_12255_ _12255_/Y _12259_/S0 _13880_/Q _12259_/S1 VDD VSS sg13g2_a21oi_1
XFILLER_5_476 VDD VSS sg13g2_decap_8
XFILLER_170_948 VDD VSS sg13g2_fill_1
XFILLER_123_842 VDD VSS sg13g2_decap_8
X_11206_ _11206_/Y _11206_/A1 _11205_/X _11109_/B VDD VSS sg13g2_o21ai_1
XFILLER_64_1316 VDD VSS sg13g2_decap_8
X_12186_ _12187_/B _12186_/A _13942_/Q VDD VSS sg13g2_nand2_1
XFILLER_29_1458 VDD VSS sg13g2_decap_8
XFILLER_116_1417 VDD VSS sg13g2_decap_8
XFILLER_69_929 VDD VSS sg13g2_fill_2
XFILLER_122_363 VDD VSS sg13g2_decap_8
XFILLER_155_1477 VDD VSS sg13g2_fill_2
XFILLER_110_514 VDD VSS sg13g2_decap_8
XFILLER_123_897 VDD VSS sg13g2_decap_8
X_11137_ _11152_/B _11163_/A _11190_/C VDD VSS sg13g2_nor2_1
XFILLER_68_428 VDD VSS sg13g2_decap_8
XFILLER_1_693 VDD VSS sg13g2_decap_8
XFILLER_96_759 VDD VSS sg13g2_fill_2
XFILLER_7_1232 VDD VSS sg13g2_decap_8
XFILLER_27_1160 VDD VSS sg13g2_decap_8
XFILLER_49_631 VDD VSS sg13g2_decap_8
XFILLER_114_1130 VDD VSS sg13g2_decap_8
XFILLER_23_1013 VDD VSS sg13g2_decap_4
XFILLER_114_1141 VDD VSS sg13g2_fill_1
X_11068_ _11097_/C _11068_/A _11068_/B _11068_/C VDD VSS sg13g2_nand3_1
XFILLER_77_962 VDD VSS sg13g2_decap_8
XFILLER_95_269 VDD VSS sg13g2_decap_8
XFILLER_77_973 VDD VSS sg13g2_fill_1
XFILLER_62_1084 VDD VSS sg13g2_decap_8
XFILLER_37_804 VDD VSS sg13g2_decap_8
XFILLER_110_1005 VDD VSS sg13g2_decap_8
XFILLER_114_1174 VDD VSS sg13g2_decap_8
X_10019_ _14601_/D _10085_/A0 _14601_/Q _10031_/S VDD VSS sg13g2_mux2_1
XFILLER_95_94 VDD VSS sg13g2_decap_8
XFILLER_48_163 VDD VSS sg13g2_decap_8
XFILLER_36_303 VDD VSS sg13g2_decap_4
XFILLER_92_943 VDD VSS sg13g2_decap_8
XFILLER_149_1215 VDD VSS sg13g2_decap_8
XFILLER_36_347 VDD VSS sg13g2_decap_8
X_14827_ _14827_/Q _14890_/CLK _14827_/D _14827_/RESET_B VDD VSS sg13g2_dfrbpq_1
XFILLER_97_1169 VDD VSS sg13g2_fill_1
XFILLER_75_1423 VDD VSS sg13g2_fill_1
X_14758_ _14758_/Q _15182_/CLK _14758_/D _14758_/RESET_B VDD VSS sg13g2_dfrbpq_1
XFILLER_36_1418 VDD VSS sg13g2_decap_8
X_13709_ _13709_/Q clkload56/A _13709_/D _13709_/RESET_B VDD VSS sg13g2_dfrbpq_1
XFILLER_177_525 VDD VSS sg13g2_decap_8
X_14689_ _14689_/Q _14745_/CLK _14689_/D _14689_/RESET_B VDD VSS sg13g2_dfrbpq_1
XFILLER_60_873 VDD VSS sg13g2_decap_8
XFILLER_32_586 VDD VSS sg13g2_decap_4
X_14040__2232 _14040_/RESET_B VDD VSS sg13g2_tiehi
X_14911__2815 _14911_/RESET_B VDD VSS sg13g2_tiehi
XFILLER_146_901 VDD VSS sg13g2_fill_2
XFILLER_158_761 VDD VSS sg13g2_fill_2
X_13693__2579 _13693_/RESET_B VDD VSS sg13g2_tiehi
XFILLER_125_1281 VDD VSS sg13g2_decap_8
XFILLER_158_772 VDD VSS sg13g2_fill_2
X_15171__1522 _15171_/RESET_B VDD VSS sg13g2_tiehi
XFILLER_34_1164 VDD VSS sg13g2_decap_8
XFILLER_164_219 VDD VSS sg13g2_fill_2
XFILLER_34_1175 VDD VSS sg13g2_fill_2
XFILLER_145_411 VDD VSS sg13g2_decap_8
XFILLER_121_1156 VDD VSS sg13g2_decap_4
XFILLER_173_742 VDD VSS sg13g2_decap_8
XFILLER_69_1216 VDD VSS sg13g2_fill_2
X_14644__1628 _14644_/RESET_B VDD VSS sg13g2_tiehi
XFILLER_67_0 VDD VSS sg13g2_decap_8
XFILLER_161_904 VDD VSS sg13g2_decap_8
XFILLER_69_1238 VDD VSS sg13g2_decap_8
XFILLER_145_488 VDD VSS sg13g2_decap_8
X_14944__2749 _14944_/RESET_B VDD VSS sg13g2_tiehi
XFILLER_172_296 VDD VSS sg13g2_decap_8
X_14073__2199 _14073_/RESET_B VDD VSS sg13g2_tiehi
XFILLER_160_458 VDD VSS sg13g2_decap_8
XFILLER_5_70 VDD VSS sg13g2_decap_8
XFILLER_119_1041 VDD VSS sg13g2_decap_8
XFILLER_158_1090 VDD VSS sg13g2_decap_8
Xfanout205 _10024_/A0 _09727_/A0 VDD VSS sg13g2_buf_1
Xfanout227 _10154_/A1 _10087_/A0 VDD VSS sg13g2_buf_1
X_09802_ _14391_/D _09934_/A1 _14391_/Q _09804_/S VDD VSS sg13g2_mux2_1
XFILLER_8_1029 VDD VSS sg13g2_decap_8
XFILLER_101_514 VDD VSS sg13g2_fill_2
XFILLER_113_374 VDD VSS sg13g2_decap_8
XFILLER_115_27 VDD VSS sg13g2_decap_8
XFILLER_141_683 VDD VSS sg13g2_decap_8
Xfanout238 _10152_/A1 wire243/X VDD VSS sg13g2_buf_1
XFILLER_86_214 VDD VSS sg13g2_fill_2
XFILLER_113_385 VDD VSS sg13g2_fill_1
Xfanout249 _12126_/A _12195_/B1 VDD VSS sg13g2_buf_1
X_07994_ _07994_/X _15100_/Q _15089_/Q VDD VSS sg13g2_or2_1
XFILLER_80_1140 VDD VSS sg13g2_decap_8
XFILLER_86_236 VDD VSS sg13g2_fill_2
XFILLER_80_1151 VDD VSS sg13g2_fill_2
XFILLER_132_1230 VDD VSS sg13g2_decap_8
X_15012__2668 _15012_/RESET_B VDD VSS sg13g2_tiehi
X_09733_ _14324_/D _09799_/A0 _14324_/Q _09733_/S VDD VSS sg13g2_mux2_1
XFILLER_68_962 VDD VSS sg13g2_decap_8
XFILLER_86_269 VDD VSS sg13g2_decap_8
XFILLER_132_1252 VDD VSS sg13g2_decap_8
XFILLER_83_910 VDD VSS sg13g2_decap_4
XFILLER_67_472 VDD VSS sg13g2_decap_8
XFILLER_27_314 VDD VSS sg13g2_fill_2
X_09664_ _14257_/D _09928_/A1 _14257_/Q _09665_/S VDD VSS sg13g2_mux2_1
X_15122__2808 _15122_/RESET_B VDD VSS sg13g2_tiehi
X_08615_ _15244_/D _08615_/A _08615_/B _08615_/C VDD VSS sg13g2_nand3_1
X_09595_ _14192_/D _14192_/Q _10092_/A0 _09596_/S VDD VSS sg13g2_mux2_1
XFILLER_167_1348 VDD VSS sg13g2_fill_1
XFILLER_36_881 VDD VSS sg13g2_fill_1
X_08546_ _08546_/Y _07956_/A _07812_/B _08529_/Y VDD VSS sg13g2_o21ai_1
XFILLER_70_648 VDD VSS sg13g2_decap_8
XFILLER_42_339 VDD VSS sg13g2_decap_8
XFILLER_35_391 VDD VSS sg13g2_decap_8
XFILLER_23_531 VDD VSS sg13g2_decap_8
XFILLER_126_1012 VDD VSS sg13g2_decap_8
XFILLER_51_851 VDD VSS sg13g2_decap_8
XFILLER_24_35 VDD VSS sg13g2_decap_8
X_08477_ _08477_/Y _08443_/Y _07807_/C _08476_/Y VDD VSS sg13g2_a21oi_1
XFILLER_145_7 VDD VSS sg13g2_decap_8
XFILLER_10_203 VDD VSS sg13g2_decap_8
XFILLER_168_547 VDD VSS sg13g2_decap_4
XFILLER_126_1089 VDD VSS sg13g2_decap_8
XFILLER_149_761 VDD VSS sg13g2_fill_2
XFILLER_17_1362 VDD VSS sg13g2_decap_8
XFILLER_13_1204 VDD VSS sg13g2_decap_8
X_14283__1989 _14283_/RESET_B VDD VSS sg13g2_tiehi
XFILLER_183_539 VDD VSS sg13g2_decap_8
XFILLER_164_720 VDD VSS sg13g2_decap_4
XFILLER_178_1411 VDD VSS sg13g2_decap_8
XFILLER_137_967 VDD VSS sg13g2_decap_4
XFILLER_164_742 VDD VSS sg13g2_decap_8
XFILLER_104_1387 VDD VSS sg13g2_decap_8
X_10370_ _14814_/D _10370_/A _10655_/B _10370_/C VDD VSS sg13g2_nor3_1
XFILLER_40_56 VDD VSS sg13g2_decap_8
XFILLER_3_903 VDD VSS sg13g2_decap_8
X_09029_ _09031_/C _14905_/Q _12957_/A _10702_/A wire584/X VDD VSS sg13g2_and4_1
XFILLER_108_179 VDD VSS sg13g2_decap_8
XFILLER_151_414 VDD VSS sg13g2_decap_8
XFILLER_174_1319 VDD VSS sg13g2_fill_2
XFILLER_105_820 VDD VSS sg13g2_decap_8
XFILLER_2_413 VDD VSS sg13g2_decap_8
XFILLER_117_691 VDD VSS sg13g2_decap_8
XFILLER_151_447 VDD VSS sg13g2_decap_8
X_12040_ _12040_/Y _12040_/A1 _14226_/Q _12233_/B VDD VSS sg13g2_a21oi_1
XFILLER_123_149 VDD VSS sg13g2_fill_2
XFILLER_46_1013 VDD VSS sg13g2_fill_1
XFILLER_105_864 VDD VSS sg13g2_decap_8
XFILLER_78_704 VDD VSS sg13g2_decap_8
XFILLER_49_21 VDD VSS sg13g2_decap_8
XFILLER_46_1024 VDD VSS sg13g2_fill_2
XFILLER_132_661 VDD VSS sg13g2_decap_4
XFILLER_160_970 VDD VSS sg13g2_decap_8
XFILLER_137_1174 VDD VSS sg13g2_decap_8
XFILLER_46_1057 VDD VSS sg13g2_decap_8
XFILLER_132_694 VDD VSS sg13g2_fill_1
XFILLER_172_1065 VDD VSS sg13g2_decap_8
XFILLER_46_1068 VDD VSS sg13g2_fill_2
XFILLER_77_225 VDD VSS sg13g2_fill_2
Xfanout750 _11654_/S _11765_/A VDD VSS sg13g2_buf_1
XFILLER_49_98 VDD VSS sg13g2_decap_4
XFILLER_172_77 VDD VSS sg13g2_decap_8
Xclkbuf_leaf_60_clk_i _15224_/CLK clkbuf_leaf_78_clk_i/A VDD VSS sg13g2_buf_8
Xfanout761 _12115_/A1 fanout771/X VDD VSS sg13g2_buf_1
XFILLER_115_1450 VDD VSS sg13g2_fill_1
Xfanout772 _12239_/B _11542_/B VDD VSS sg13g2_buf_1
XFILLER_1_28 VDD VSS sg13g2_decap_8
X_13991_ _13991_/Q _14607_/CLK _13991_/D _13991_/RESET_B VDD VSS sg13g2_dfrbpq_1
Xfanout783 _12105_/B1 _07654_/Y VDD VSS sg13g2_buf_1
XFILLER_98_1401 VDD VSS sg13g2_decap_8
XFILLER_24_1344 VDD VSS sg13g2_decap_8
Xfanout794 _11172_/A _11185_/A VDD VSS sg13g2_buf_1
XFILLER_58_472 VDD VSS sg13g2_fill_2
X_12942_ _12988_/B _14903_/Q _12942_/B VDD VSS sg13g2_xnor2_1
XFILLER_4_1449 VDD VSS sg13g2_decap_8
XFILLER_45_111 VDD VSS sg13g2_decap_8
XFILLER_185_1404 VDD VSS sg13g2_decap_8
XFILLER_18_336 VDD VSS sg13g2_decap_8
XFILLER_111_1358 VDD VSS sg13g2_decap_4
XFILLER_171_0 VDD VSS sg13g2_decap_8
XFILLER_74_965 VDD VSS sg13g2_decap_8
XFILLER_59_1418 VDD VSS sg13g2_decap_8
XFILLER_46_667 VDD VSS sg13g2_decap_8
XFILLER_59_1429 VDD VSS sg13g2_fill_1
XFILLER_34_818 VDD VSS sg13g2_decap_4
X_12873_ _12877_/C _14899_/Q _13688_/Q VDD VSS sg13g2_xor2_1
XFILLER_65_97 VDD VSS sg13g2_fill_2
XFILLER_61_615 VDD VSS sg13g2_decap_4
XFILLER_2_1162 VDD VSS sg13g2_decap_8
Xclkbuf_leaf_75_clk_i clkload81/A clkbuf_leaf_88_clk_i/A VDD VSS sg13g2_buf_8
XFILLER_33_317 VDD VSS sg13g2_decap_8
X_14612_ _14612_/Q _14982_/CLK _14612_/D _14612_/RESET_B VDD VSS sg13g2_dfrbpq_1
XFILLER_92_1000 VDD VSS sg13g2_decap_4
X_11824_ _11824_/Y _11826_/A1 _13868_/Q _11805_/C VDD VSS sg13g2_a21oi_1
XFILLER_60_114 VDD VSS sg13g2_fill_1
XFILLER_109_1210 VDD VSS sg13g2_decap_8
XFILLER_92_1033 VDD VSS sg13g2_decap_8
XFILLER_18_1115 VDD VSS sg13g2_decap_8
XFILLER_14_553 VDD VSS sg13g2_decap_8
XFILLER_186_300 VDD VSS sg13g2_decap_8
X_14543_ _14543_/Q _14607_/CLK _14543_/D _14543_/RESET_B VDD VSS sg13g2_dfrbpq_1
XFILLER_81_41 VDD VSS sg13g2_decap_8
XFILLER_186_311 VDD VSS sg13g2_decap_8
X_11755_ _11755_/Y _11752_/Y _11754_/X _11625_/C VDD VSS sg13g2_o21ai_1
XFILLER_144_1134 VDD VSS sg13g2_decap_8
XFILLER_42_884 VDD VSS sg13g2_decap_8
X_10706_ _10706_/Y _12957_/A _10875_/B VDD VSS sg13g2_nand2_1
XFILLER_144_1178 VDD VSS sg13g2_decap_8
XFILLER_159_569 VDD VSS sg13g2_decap_8
X_14474_ _14474_/Q clkload17/A _14474_/D _14474_/RESET_B VDD VSS sg13g2_dfrbpq_1
X_11686_ _11687_/A _14248_/Q _14280_/Q _14312_/Q _14344_/Q _11759_/A _11970_/C VDD
+ VSS sg13g2_mux4_1
X_13425_ _13425_/Y _13469_/A _15130_/Q _13469_/C VDD VSS sg13g2_nand3_1
X_10637_ _14886_/D _10642_/C _10637_/B VDD VSS sg13g2_nor2_1
XFILLER_31_1326 VDD VSS sg13g2_decap_4
XFILLER_10_770 VDD VSS sg13g2_decap_8
XFILLER_122_1465 VDD VSS sg13g2_decap_8
XFILLER_60_7 VDD VSS sg13g2_decap_8
X_13356_ _13361_/C _13506_/A _13469_/A _13507_/B VDD VSS sg13g2_nand3_1
X_10568_ _10591_/C _10579_/B _10579_/C VDD VSS sg13g2_and2_1
Xmax_cap917 _12659_/S0 _12644_/S0 VDD VSS sg13g2_buf_8
XFILLER_6_763 VDD VSS sg13g2_decap_8
Xclkbuf_leaf_13_clk_i clkload22/A clkbuf_5_6__f_clk_i/X VDD VSS sg13g2_buf_8
XFILLER_115_628 VDD VSS sg13g2_decap_8
XFILLER_127_488 VDD VSS sg13g2_decap_8
X_12307_ _12308_/B _12307_/A _12307_/B _12307_/C VDD VSS sg13g2_nand3_1
XFILLER_114_116 VDD VSS sg13g2_decap_8
X_13287_ _13291_/B _13287_/A _13287_/B _13287_/C VDD VSS sg13g2_or3_1
X_10499_ _14853_/D _10499_/A _10499_/B _10499_/C VDD VSS sg13g2_and3_1
XFILLER_5_273 VDD VSS sg13g2_decap_8
X_15026_ _15026_/Q _15219_/CLK _15026_/D _15026_/RESET_B VDD VSS sg13g2_dfrbpq_1
X_12238_ _12239_/A _13976_/Q _14008_/Q _14040_/Q _14072_/Q _12238_/S0 _12245_/S1 VDD
+ VSS sg13g2_mux4_1
XFILLER_155_1241 VDD VSS sg13g2_decap_8
XFILLER_9_1316 VDD VSS sg13g2_decap_8
XFILLER_110_300 VDD VSS sg13g2_decap_8
X_12169_ _12170_/B _12169_/A _12169_/B _12169_/C VDD VSS sg13g2_nand3_1
XFILLER_2_980 VDD VSS sg13g2_decap_8
Xclkbuf_leaf_28_clk_i _14727_/CLK clkbuf_5_8__f_clk_i/X VDD VSS sg13g2_buf_8
XFILLER_68_247 VDD VSS sg13g2_decap_8
XFILLER_151_1149 VDD VSS sg13g2_decap_4
XFILLER_1_490 VDD VSS sg13g2_decap_8
XFILLER_68_269 VDD VSS sg13g2_decap_8
X_14058__2214 _14058_/RESET_B VDD VSS sg13g2_tiehi
Xinput5 input5/X input5/A VDD VSS sg13g2_buf_1
XFILLER_49_483 VDD VSS sg13g2_decap_8
XFILLER_110_399 VDD VSS sg13g2_decap_8
XFILLER_76_291 VDD VSS sg13g2_decap_8
XFILLER_36_122 VDD VSS sg13g2_decap_8
XFILLER_64_442 VDD VSS sg13g2_fill_2
XFILLER_25_807 VDD VSS sg13g2_decap_8
XFILLER_37_678 VDD VSS sg13g2_decap_8
X_15195__2858 _15195_/RESET_B VDD VSS sg13g2_tiehi
X_08400_ _08400_/Y _08659_/B _08668_/A VDD VSS sg13g2_nor2b_1
X_09380_ _13983_/D _09976_/A0 _13983_/Q _09395_/S VDD VSS sg13g2_mux2_1
XFILLER_80_946 VDD VSS sg13g2_decap_8
XFILLER_36_199 VDD VSS sg13g2_decap_8
XFILLER_75_1242 VDD VSS sg13g2_decap_8
XFILLER_127_1321 VDD VSS sg13g2_decap_8
X_08331_ _08331_/Y _08147_/Y _08241_/A _08027_/Y VDD VSS sg13g2_a21oi_1
XFILLER_162_1212 VDD VSS sg13g2_decap_8
XFILLER_51_158 VDD VSS sg13g2_decap_8
XFILLER_33_862 VDD VSS sg13g2_decap_8
XFILLER_127_1354 VDD VSS sg13g2_decap_8
XFILLER_177_322 VDD VSS sg13g2_decap_8
XFILLER_20_512 VDD VSS sg13g2_decap_8
XFILLER_162_1256 VDD VSS sg13g2_decap_8
XFILLER_178_867 VDD VSS sg13g2_fill_1
XFILLER_20_523 VDD VSS sg13g2_fill_1
X_08262_ _08262_/Y _08256_/Y _08257_/Y _08252_/Y _08381_/A _08261_/Y VDD VSS sg13g2_a221oi_1
XFILLER_71_1139 VDD VSS sg13g2_fill_2
XFILLER_36_1259 VDD VSS sg13g2_decap_8
XFILLER_60_692 VDD VSS sg13g2_decap_8
XFILLER_162_1289 VDD VSS sg13g2_decap_8
XFILLER_137_219 VDD VSS sg13g2_decap_8
XFILLER_119_934 VDD VSS sg13g2_decap_8
XFILLER_165_539 VDD VSS sg13g2_decap_4
XFILLER_177_399 VDD VSS sg13g2_decap_8
X_08193_ _08193_/Y _07890_/B _08191_/Y _08192_/Y VDD VSS sg13g2_a21oi_1
XFILLER_158_580 VDD VSS sg13g2_decap_8
XFILLER_119_945 VDD VSS sg13g2_fill_2
XFILLER_119_956 VDD VSS sg13g2_fill_2
X_15151__2748 _15151_/RESET_B VDD VSS sg13g2_tiehi
XFILLER_134_904 VDD VSS sg13g2_decap_8
XFILLER_12_1281 VDD VSS sg13g2_decap_8
XFILLER_145_285 VDD VSS sg13g2_decap_8
XFILLER_69_1068 VDD VSS sg13g2_fill_1
XFILLER_105_127 VDD VSS sg13g2_fill_2
XFILLER_133_436 VDD VSS sg13g2_decap_8
XFILLER_69_1079 VDD VSS sg13g2_decap_8
XFILLER_161_756 VDD VSS sg13g2_decap_8
XFILLER_86_1371 VDD VSS sg13g2_decap_4
XFILLER_156_1049 VDD VSS sg13g2_fill_2
XFILLER_47_1333 VDD VSS sg13g2_fill_1
XFILLER_160_266 VDD VSS sg13g2_decap_8
XFILLER_86_1393 VDD VSS sg13g2_decap_8
XFILLER_0_939 VDD VSS sg13g2_decap_8
XFILLER_134_1314 VDD VSS sg13g2_decap_8
XFILLER_82_1246 VDD VSS sg13g2_decap_4
XFILLER_59_203 VDD VSS sg13g2_decap_8
XFILLER_113_160 VDD VSS sg13g2_decap_8
XFILLER_113_171 VDD VSS sg13g2_fill_2
XFILLER_87_534 VDD VSS sg13g2_decap_8
XFILLER_19_35 VDD VSS sg13g2_decap_8
X_14888__2861 _14888_/RESET_B VDD VSS sg13g2_tiehi
XFILLER_75_718 VDD VSS sg13g2_decap_4
X_07977_ _07977_/Y _08577_/B _07866_/Y _07976_/X VDD VSS sg13g2_a21oi_1
X_09716_ _14307_/D _09881_/A0 _14307_/Q _09738_/S VDD VSS sg13g2_mux2_1
XFILLER_167_1101 VDD VSS sg13g2_decap_8
XFILLER_56_965 VDD VSS sg13g2_decap_8
XFILLER_167_1112 VDD VSS sg13g2_fill_2
XFILLER_167_1123 VDD VSS sg13g2_decap_8
X_09647_ _14240_/D _09911_/A1 _14240_/Q _09672_/S VDD VSS sg13g2_mux2_1
XFILLER_76_1006 VDD VSS sg13g2_decap_8
XFILLER_56_998 VDD VSS sg13g2_fill_2
XFILLER_167_1134 VDD VSS sg13g2_fill_1
XFILLER_55_475 VDD VSS sg13g2_decap_8
XFILLER_43_615 VDD VSS sg13g2_decap_8
XFILLER_83_795 VDD VSS sg13g2_decap_8
XFILLER_167_1167 VDD VSS sg13g2_decap_8
XFILLER_71_957 VDD VSS sg13g2_fill_1
XFILLER_43_648 VDD VSS sg13g2_decap_8
XFILLER_42_114 VDD VSS sg13g2_fill_1
XFILLER_128_1129 VDD VSS sg13g2_fill_1
X_09578_ _14175_/D _14175_/Q _10075_/A0 _09605_/S VDD VSS sg13g2_mux2_1
XFILLER_35_56 VDD VSS sg13g2_decap_8
XFILLER_27_199 VDD VSS sg13g2_decap_8
XFILLER_19_1413 VDD VSS sg13g2_decap_8
X_08529_ _08529_/Y _08566_/C _08495_/Y _08567_/C VDD VSS sg13g2_o21ai_1
XFILLER_51_670 VDD VSS sg13g2_decap_8
XFILLER_143_4 VDD VSS sg13g2_decap_8
XFILLER_180_1345 VDD VSS sg13g2_decap_8
X_13756__2516 _13756_/RESET_B VDD VSS sg13g2_tiehi
XFILLER_93_1397 VDD VSS sg13g2_decap_8
XFILLER_141_1307 VDD VSS sg13g2_decap_8
X_11540_ _11540_/Y _11536_/Y _11537_/Y _11539_/Y _11538_/Y _12239_/B VDD VSS sg13g2_a221oi_1
XFILLER_54_1359 VDD VSS sg13g2_decap_8
XFILLER_51_692 VDD VSS sg13g2_decap_8
XFILLER_23_383 VDD VSS sg13g2_decap_8
XFILLER_168_366 VDD VSS sg13g2_decap_8
XFILLER_169_889 VDD VSS sg13g2_decap_8
XFILLER_11_567 VDD VSS sg13g2_decap_8
XFILLER_128_219 VDD VSS sg13g2_fill_2
XFILLER_13_1001 VDD VSS sg13g2_decap_8
X_11471_ _11471_/X _13729_/Q _14081_/Q _14433_/Q _14529_/Q _11713_/S0 _11713_/S1 VDD
+ VSS sg13g2_mux4_1
XFILLER_137_720 VDD VSS sg13g2_fill_1
XFILLER_183_336 VDD VSS sg13g2_decap_8
XFILLER_51_88 VDD VSS sg13g2_decap_8
X_13210_ _13211_/B _13253_/B2 _13205_/X _13204_/Y _13303_/A _13209_/Y VDD VSS sg13g2_a221oi_1
X_10422_ _10423_/B _14828_/Q _14829_/Q _14830_/Q _10422_/D VDD VSS sg13g2_nand4_1
XFILLER_167_77 VDD VSS sg13g2_decap_8
XFILLER_178_1230 VDD VSS sg13g2_decap_8
X_14190_ _14190_/Q clkload52/A _14190_/D _14190_/RESET_B VDD VSS sg13g2_dfrbpq_1
XFILLER_13_1078 VDD VSS sg13g2_decap_8
XFILLER_178_1252 VDD VSS sg13g2_decap_8
XFILLER_100_1037 VDD VSS sg13g2_decap_4
XFILLER_164_572 VDD VSS sg13g2_decap_8
X_13971__2301 _13971_/RESET_B VDD VSS sg13g2_tiehi
X_14136__2136 _14136_/RESET_B VDD VSS sg13g2_tiehi
XFILLER_3_700 VDD VSS sg13g2_decap_8
X_13141_ _15042_/D _13155_/A _13141_/B VDD VSS sg13g2_nor2_1
X_10353_ _14810_/D _10353_/A _10353_/B _10365_/C VDD VSS sg13g2_and3_1
XFILLER_139_1225 VDD VSS sg13g2_fill_1
XFILLER_152_734 VDD VSS sg13g2_decap_8
XFILLER_178_1274 VDD VSS sg13g2_decap_8
XFILLER_178_1285 VDD VSS sg13g2_fill_1
XFILLER_152_756 VDD VSS sg13g2_decap_8
XFILLER_183_21 VDD VSS sg13g2_decap_8
XFILLER_87_1179 VDD VSS sg13g2_fill_2
XFILLER_2_210 VDD VSS sg13g2_decap_8
XFILLER_139_1258 VDD VSS sg13g2_decap_8
XFILLER_174_1138 VDD VSS sg13g2_decap_4
X_13072_ _13072_/X input11/X _13161_/A2 _13161_/B1 VDD VSS sg13g2_a21o_1
XFILLER_152_778 VDD VSS sg13g2_fill_2
X_10284_ _10284_/Y _14788_/Q _14789_/Q _10305_/A _10305_/B VDD VSS sg13g2_nand4_1
XFILLER_65_1433 VDD VSS sg13g2_fill_1
XFILLER_3_777 VDD VSS sg13g2_decap_8
XFILLER_105_672 VDD VSS sg13g2_fill_2
X_14748__1523 _14748_/RESET_B VDD VSS sg13g2_tiehi
X_12023_ _12027_/A _12022_/X _12233_/B VDD VSS sg13g2_nand2b_1
Xfanout1501 _13438_/A _13600_/C VDD VSS sg13g2_buf_1
XFILLER_152_1425 VDD VSS sg13g2_decap_8
XFILLER_61_1308 VDD VSS sg13g2_decap_8
XFILLER_2_287 VDD VSS sg13g2_decap_8
XFILLER_183_98 VDD VSS sg13g2_decap_8
XFILLER_26_1439 VDD VSS sg13g2_decap_8
XFILLER_120_642 VDD VSS sg13g2_decap_8
XFILLER_66_718 VDD VSS sg13g2_decap_8
XFILLER_24_1141 VDD VSS sg13g2_decap_8
XFILLER_120_686 VDD VSS sg13g2_decap_8
Xfanout580 _10870_/A _10691_/X VDD VSS sg13g2_buf_1
XFILLER_76_63 VDD VSS sg13g2_decap_8
Xfanout591 _09906_/A1 _10104_/A0 VDD VSS sg13g2_buf_1
XFILLER_93_537 VDD VSS sg13g2_decap_8
XFILLER_8_1393 VDD VSS sg13g2_decap_8
XFILLER_115_1280 VDD VSS sg13g2_fill_1
XFILLER_150_1160 VDD VSS sg13g2_decap_8
XFILLER_47_932 VDD VSS sg13g2_decap_8
X_13974_ _13974_/Q _14739_/CLK _13974_/D _13974_/RESET_B VDD VSS sg13g2_dfrbpq_1
XFILLER_98_1231 VDD VSS sg13g2_decap_8
XFILLER_4_1246 VDD VSS sg13g2_decap_8
XFILLER_47_943 VDD VSS sg13g2_fill_1
XFILLER_46_420 VDD VSS sg13g2_decap_8
XFILLER_47_954 VDD VSS sg13g2_decap_8
XFILLER_18_133 VDD VSS sg13g2_decap_8
X_12925_ _12989_/B _12925_/A _12925_/B _12925_/C VDD VSS sg13g2_nand3_1
XFILLER_185_1234 VDD VSS sg13g2_decap_4
XFILLER_74_784 VDD VSS sg13g2_decap_8
XFILLER_34_637 VDD VSS sg13g2_decap_8
XFILLER_179_609 VDD VSS sg13g2_decap_8
X_12856_ _15024_/D _12855_/Y _12850_/X _13211_/A VDD VSS sg13g2_a21oi_1
XFILLER_62_957 VDD VSS sg13g2_decap_8
XFILLER_61_434 VDD VSS sg13g2_decap_8
XFILLER_33_147 VDD VSS sg13g2_decap_8
XFILLER_178_119 VDD VSS sg13g2_decap_8
X_11807_ _11808_/A _13964_/Q _13996_/Q _14028_/Q _14060_/Q _11804_/A _11805_/C VDD
+ VSS sg13g2_mux4_1
XFILLER_14_350 VDD VSS sg13g2_decap_8
XFILLER_15_884 VDD VSS sg13g2_decap_8
X_12787_ _12787_/X _14714_/Q _14746_/Q _13786_/Q _13818_/Q _12787_/S0 _12787_/S1 VDD
+ VSS sg13g2_mux4_1
XFILLER_159_344 VDD VSS sg13g2_decap_8
X_14346__1926 _14346_/RESET_B VDD VSS sg13g2_tiehi
X_14526_ _14526_/Q clkload48/A _14526_/D _14526_/RESET_B VDD VSS sg13g2_dfrbpq_1
XFILLER_159_355 VDD VSS sg13g2_fill_2
X_11738_ _11738_/X _14570_/Q _14602_/Q _11738_/S VDD VSS sg13g2_mux2_1
XFILLER_30_843 VDD VSS sg13g2_decap_4
XFILLER_175_826 VDD VSS sg13g2_decap_8
XFILLER_41_191 VDD VSS sg13g2_decap_8
XFILLER_186_174 VDD VSS sg13g2_decap_8
XFILLER_186_185 VDD VSS sg13g2_decap_8
X_14457_ _14457_/Q clkload37/A _14457_/D _14457_/RESET_B VDD VSS sg13g2_dfrbpq_1
XFILLER_35_1281 VDD VSS sg13g2_decap_8
XFILLER_31_1112 VDD VSS sg13g2_fill_2
X_11669_ _11669_/Y _11665_/Y _11666_/Y _11668_/Y _11667_/Y _12101_/B VDD VSS sg13g2_a221oi_1
XFILLER_122_1251 VDD VSS sg13g2_fill_2
X_13408_ _15091_/D _13444_/A _13396_/D _13407_/Y VDD VSS sg13g2_o21ai_1
XFILLER_31_1145 VDD VSS sg13g2_decap_8
X_14388_ _14388_/Q clkload55/A _14388_/D _14388_/RESET_B VDD VSS sg13g2_dfrbpq_1
XFILLER_116_926 VDD VSS sg13g2_decap_8
XFILLER_122_1295 VDD VSS sg13g2_decap_8
XFILLER_155_572 VDD VSS sg13g2_decap_4
XFILLER_6_560 VDD VSS sg13g2_decap_8
XFILLER_142_200 VDD VSS sg13g2_decap_8
XFILLER_31_1189 VDD VSS sg13g2_fill_1
XFILLER_116_948 VDD VSS sg13g2_decap_4
X_13339_ _13341_/A _13654_/S _13502_/B _15175_/D _13351_/B VDD VSS sg13g2_or4_1
X_14561__1711 _14561_/RESET_B VDD VSS sg13g2_tiehi
XFILLER_127_296 VDD VSS sg13g2_decap_8
XFILLER_170_542 VDD VSS sg13g2_decap_8
XFILLER_118_1309 VDD VSS sg13g2_decap_8
XFILLER_157_1369 VDD VSS sg13g2_decap_8
XFILLER_124_970 VDD VSS sg13g2_decap_8
Xhold3119 _15169_/D _13486_/C VDD VSS sg13g2_dlygate4sd3_1
XFILLER_9_1113 VDD VSS sg13g2_decap_8
XFILLER_116_1000 VDD VSS sg13g2_decap_8
X_15009_ _15009_/Q _15017_/CLK _15009_/D _15009_/RESET_B VDD VSS sg13g2_dfrbpq_1
X_07900_ _07900_/Y _13601_/A _07900_/B VDD VSS sg13g2_nand2b_1
XFILLER_116_1011 VDD VSS sg13g2_fill_1
XFILLER_111_620 VDD VSS sg13g2_fill_2
X_08880_ _13703_/D _16865_/A _08879_/X _08938_/S VDD VSS sg13g2_mux2_1
XFILLER_69_534 VDD VSS sg13g2_decap_8
XFILLER_116_1033 VDD VSS sg13g2_decap_8
XFILLER_155_1093 VDD VSS sg13g2_decap_8
XFILLER_57_707 VDD VSS sg13g2_decap_4
X_07831_ _07979_/C _08048_/B _08692_/C VDD VSS sg13g2_nand2b_1
XFILLER_96_375 VDD VSS sg13g2_decap_8
XFILLER_69_589 VDD VSS sg13g2_decap_8
X_13834__2438 _13834_/RESET_B VDD VSS sg13g2_tiehi
XFILLER_81_1290 VDD VSS sg13g2_fill_2
X_14594__1678 _14594_/RESET_B VDD VSS sg13g2_tiehi
XFILLER_99_1039 VDD VSS sg13g2_decap_4
X_07762_ _07762_/Y _07989_/B _15204_/Q _07754_/Y VDD VSS sg13g2_a21oi_1
X_09501_ _14101_/D _09998_/A0 _14101_/Q _09501_/S VDD VSS sg13g2_mux2_1
XFILLER_65_751 VDD VSS sg13g2_decap_8
XFILLER_168_1432 VDD VSS sg13g2_decap_8
X_07693_ _07696_/B _15084_/Q _07701_/B VDD VSS sg13g2_nand2_1
XFILLER_25_604 VDD VSS sg13g2_decap_8
X_09432_ _14034_/D _09597_/A1 _14034_/Q _09432_/S VDD VSS sg13g2_mux2_1
XFILLER_52_434 VDD VSS sg13g2_decap_4
X_14214__2058 _14214_/RESET_B VDD VSS sg13g2_tiehi
XFILLER_80_765 VDD VSS sg13g2_decap_8
XFILLER_169_119 VDD VSS sg13g2_decap_8
XFILLER_40_607 VDD VSS sg13g2_decap_8
X_09363_ _13967_/D _09627_/A0 _13967_/Q _09363_/S VDD VSS sg13g2_mux2_1
XFILLER_36_1023 VDD VSS sg13g2_decap_8
XFILLER_162_1042 VDD VSS sg13g2_decap_8
X_08314_ _08350_/B _08315_/B _07776_/Y _08287_/Y _07779_/Y _07773_/Y VDD VSS sg13g2_a221oi_1
XFILLER_75_1094 VDD VSS sg13g2_decap_8
XFILLER_21_843 VDD VSS sg13g2_decap_8
X_09294_ _13902_/D _13902_/Q _10157_/A1 _09294_/S VDD VSS sg13g2_mux2_1
XANTENNA_10 _13711_/Q VDD VSS sg13g2_antennanp
XANTENNA_21 _09137_/A VDD VSS sg13g2_antennanp
XFILLER_162_1064 VDD VSS sg13g2_decap_8
XFILLER_127_1195 VDD VSS sg13g2_decap_8
XFILLER_166_837 VDD VSS sg13g2_decap_8
X_08245_ _08245_/Y _08070_/C _08021_/A _08027_/Y VDD VSS sg13g2_a21oi_1
XFILLER_20_364 VDD VSS sg13g2_decap_8
XFILLER_177_196 VDD VSS sg13g2_decap_8
XFILLER_21_14 VDD VSS sg13g2_decap_8
XFILLER_88_1400 VDD VSS sg13g2_decap_4
XFILLER_181_807 VDD VSS sg13g2_decap_8
XFILLER_14_1365 VDD VSS sg13g2_decap_8
X_08176_ _08187_/C _08188_/B _08142_/A _08175_/Y _07876_/A _08174_/Y VDD VSS sg13g2_a221oi_1
XFILLER_140_1373 VDD VSS sg13g2_fill_1
XFILLER_10_1218 VDD VSS sg13g2_decap_8
XFILLER_146_561 VDD VSS sg13g2_decap_4
XFILLER_134_712 VDD VSS sg13g2_fill_1
XFILLER_174_881 VDD VSS sg13g2_decap_8
XFILLER_174_892 VDD VSS sg13g2_fill_1
XFILLER_173_380 VDD VSS sg13g2_decap_8
XFILLER_49_1428 VDD VSS sg13g2_decap_8
XFILLER_108_7 VDD VSS sg13g2_decap_8
XFILLER_134_745 VDD VSS sg13g2_decap_8
XFILLER_137_69 VDD VSS sg13g2_fill_2
XFILLER_106_458 VDD VSS sg13g2_decap_8
XFILLER_134_767 VDD VSS sg13g2_decap_8
XFILLER_0_714 VDD VSS sg13g2_decap_8
XFILLER_86_1190 VDD VSS sg13g2_decap_8
XFILLER_47_1163 VDD VSS sg13g2_fill_2
XFILLER_102_631 VDD VSS sg13g2_decap_8
XFILLER_173_1171 VDD VSS sg13g2_decap_8
XFILLER_47_1174 VDD VSS sg13g2_decap_8
XFILLER_130_962 VDD VSS sg13g2_decap_8
XFILLER_88_876 VDD VSS sg13g2_decap_8
XFILLER_82_1087 VDD VSS sg13g2_decap_8
XFILLER_48_707 VDD VSS sg13g2_decap_8
XFILLER_101_163 VDD VSS sg13g2_decap_8
X_14424__1848 _14424_/RESET_B VDD VSS sg13g2_tiehi
XFILLER_60_1352 VDD VSS sg13g2_decap_8
XFILLER_47_228 VDD VSS sg13g2_decap_8
XFILLER_29_932 VDD VSS sg13g2_decap_8
XFILLER_134_1199 VDD VSS sg13g2_decap_8
XFILLER_169_1218 VDD VSS sg13g2_decap_8
XFILLER_21_1347 VDD VSS sg13g2_decap_8
XFILLER_62_209 VDD VSS sg13g2_fill_1
XFILLER_44_913 VDD VSS sg13g2_fill_1
XFILLER_29_987 VDD VSS sg13g2_decap_8
X_10971_ _10971_/Y _11082_/A1 _11015_/C _11183_/B1 VDD VSS sg13g2_o21ai_1
XFILLER_46_66 VDD VSS sg13g2_fill_1
XFILLER_16_637 VDD VSS sg13g2_decap_8
X_12710_ _12710_/X _14709_/Q _14741_/Q _13781_/Q _13813_/Q _12710_/S0 _12710_/S1 VDD
+ VSS sg13g2_mux4_1
XFILLER_182_1407 VDD VSS sg13g2_decap_8
XFILLER_46_99 VDD VSS sg13g2_decap_8
X_13690_ _13690_/Q _15182_/CLK _13690_/D _13690_/RESET_B VDD VSS sg13g2_dfrbpq_1
XFILLER_71_743 VDD VSS sg13g2_decap_8
XFILLER_15_147 VDD VSS sg13g2_decap_8
XFILLER_19_1210 VDD VSS sg13g2_decap_8
X_12641_ _12641_/X _14704_/Q _14736_/Q _13776_/Q _13808_/Q _12674_/S0 _12674_/S1 VDD
+ VSS sg13g2_mux4_1
XFILLER_62_21 VDD VSS sg13g2_decap_4
XFILLER_71_798 VDD VSS sg13g2_decap_8
XFILLER_70_275 VDD VSS sg13g2_decap_4
XFILLER_31_629 VDD VSS sg13g2_decap_8
XFILLER_180_1120 VDD VSS sg13g2_decap_8
XFILLER_58_1292 VDD VSS sg13g2_fill_2
XFILLER_145_1251 VDD VSS sg13g2_decap_8
XFILLER_169_653 VDD VSS sg13g2_decap_8
XFILLER_178_21 VDD VSS sg13g2_decap_8
XFILLER_180_1131 VDD VSS sg13g2_fill_1
XFILLER_93_1194 VDD VSS sg13g2_decap_4
XFILLER_54_1145 VDD VSS sg13g2_fill_1
X_12572_ _12572_/X _13739_/Q _14091_/Q _14443_/Q _14539_/Q _12600_/S0 _12600_/S1 VDD
+ VSS sg13g2_mux4_1
XFILLER_129_506 VDD VSS sg13g2_decap_8
XFILLER_12_854 VDD VSS sg13g2_decap_8
XFILLER_19_1287 VDD VSS sg13g2_decap_8
XFILLER_134_0 VDD VSS sg13g2_decap_8
X_14311_ _14311_/Q clkload13/A _14311_/D _14311_/RESET_B VDD VSS sg13g2_dfrbpq_1
XFILLER_54_1178 VDD VSS sg13g2_decap_4
X_11523_ _11566_/A _11526_/A _12227_/B VDD VSS sg13g2_nor2_1
XFILLER_32_1410 VDD VSS sg13g2_fill_1
XFILLER_11_364 VDD VSS sg13g2_decap_8
XFILLER_89_1208 VDD VSS sg13g2_decap_8
XFILLER_32_1421 VDD VSS sg13g2_decap_8
XFILLER_157_859 VDD VSS sg13g2_decap_8
XFILLER_178_98 VDD VSS sg13g2_decap_8
XFILLER_8_847 VDD VSS sg13g2_decap_8
XFILLER_156_347 VDD VSS sg13g2_decap_8
XFILLER_183_133 VDD VSS sg13g2_decap_8
Xwire244 wire244/X wire244/A VDD VSS sg13g2_buf_2
XFILLER_7_49 VDD VSS sg13g2_decap_8
XFILLER_109_230 VDD VSS sg13g2_decap_8
X_14242_ _14242_/Q clkload40/A _14242_/D _14242_/RESET_B VDD VSS sg13g2_dfrbpq_1
XFILLER_32_1454 VDD VSS sg13g2_decap_8
X_11454_ _11457_/B _11454_/A _13688_/Q VDD VSS sg13g2_nand2_1
XFILLER_7_357 VDD VSS sg13g2_decap_8
XFILLER_125_701 VDD VSS sg13g2_fill_2
XFILLER_165_870 VDD VSS sg13g2_decap_8
XFILLER_184_689 VDD VSS sg13g2_decap_8
Xwire288 wire288/X wire288/A VDD VSS sg13g2_buf_2
X_10405_ _10406_/A _14823_/Q _14824_/Q _10414_/B _10414_/C VDD VSS sg13g2_and4_1
XFILLER_137_594 VDD VSS sg13g2_decap_8
XFILLER_178_1060 VDD VSS sg13g2_decap_8
X_14173_ _14173_/Q clkload59/A _14173_/D _14173_/RESET_B VDD VSS sg13g2_dfrbpq_1
X_11385_ _11385_/Y _11385_/A _11385_/B VDD VSS sg13g2_xnor2_1
XFILLER_139_1022 VDD VSS sg13g2_decap_4
XFILLER_124_233 VDD VSS sg13g2_decap_4
X_13124_ _13124_/Y _13121_/Y _13122_/Y _13123_/Y VDD VSS sg13g2_a21oi_1
XFILLER_11_91 VDD VSS sg13g2_decap_8
X_10336_ _10337_/B _14803_/Q _14804_/Q _14805_/Q _10336_/D VDD VSS sg13g2_nand4_1
XFILLER_112_406 VDD VSS sg13g2_fill_1
XFILLER_3_574 VDD VSS sg13g2_decap_8
XFILLER_106_992 VDD VSS sg13g2_fill_2
XFILLER_127_91 VDD VSS sg13g2_decap_4
XFILLER_152_1200 VDD VSS sg13g2_decap_8
X_13055_ _13055_/Y _13253_/B2 _13050_/X _13054_/Y VDD VSS sg13g2_a21oi_1
X_10267_ _10269_/A _14783_/Q _10262_/Y _14784_/Q VDD VSS sg13g2_a21o_1
XFILLER_87_51 VDD VSS sg13g2_decap_8
XFILLER_65_1263 VDD VSS sg13g2_decap_8
XFILLER_78_331 VDD VSS sg13g2_decap_8
Xfanout1320 _12000_/A _11450_/A1 VDD VSS sg13g2_buf_1
XFILLER_26_1236 VDD VSS sg13g2_decap_8
X_12006_ _14979_/D _12006_/A _12006_/B VDD VSS sg13g2_nand2_1
XFILLER_65_1296 VDD VSS sg13g2_decap_4
XFILLER_113_1206 VDD VSS sg13g2_decap_8
Xfanout1331 _11898_/C _12308_/C VDD VSS sg13g2_buf_1
XFILLER_23_7 VDD VSS sg13g2_decap_8
Xfanout1342 _11742_/C fanout1350/X VDD VSS sg13g2_buf_1
X_10198_ _14756_/D _15199_/D _14756_/Q _13653_/S VDD VSS sg13g2_mux2_1
XFILLER_152_1266 VDD VSS sg13g2_decap_8
Xfanout1353 _11805_/C _11821_/S1 VDD VSS sg13g2_buf_1
XFILLER_94_824 VDD VSS sg13g2_decap_8
Xfanout1364 fanout1364/X _13658_/Q VDD VSS sg13g2_buf_1
Xfanout1375 _12286_/S1 _12288_/S1 VDD VSS sg13g2_buf_1
XFILLER_94_846 VDD VSS sg13g2_decap_8
Xfanout1386 _11997_/S0 fanout1395/X VDD VSS sg13g2_buf_1
XFILLER_8_1190 VDD VSS sg13g2_decap_8
XFILLER_19_431 VDD VSS sg13g2_decap_8
Xfanout1397 _12040_/A1 fanout1400/X VDD VSS sg13g2_buf_1
XFILLER_93_345 VDD VSS sg13g2_decap_8
XFILLER_4_1043 VDD VSS sg13g2_decap_8
X_13957_ _13957_/Q _14725_/CLK _13957_/D _13957_/RESET_B VDD VSS sg13g2_dfrbpq_1
XFILLER_185_1020 VDD VSS sg13g2_fill_2
XFILLER_47_795 VDD VSS sg13g2_fill_1
XFILLER_74_581 VDD VSS sg13g2_decap_8
XFILLER_62_721 VDD VSS sg13g2_decap_8
X_12908_ _12910_/A _12925_/A _12925_/B _12909_/C VDD VSS sg13g2_a21oi_1
XFILLER_62_732 VDD VSS sg13g2_fill_1
XFILLER_185_1053 VDD VSS sg13g2_fill_1
XFILLER_179_406 VDD VSS sg13g2_decap_8
X_13888_ _13888_/Q _14720_/CLK _13888_/D _13888_/RESET_B VDD VSS sg13g2_dfrbpq_1
XFILLER_62_754 VDD VSS sg13g2_decap_8
XFILLER_146_1015 VDD VSS sg13g2_decap_4
XFILLER_62_765 VDD VSS sg13g2_fill_2
XFILLER_35_979 VDD VSS sg13g2_decap_8
XFILLER_50_916 VDD VSS sg13g2_decap_8
X_12839_ _12840_/B _12836_/Y _12838_/Y _12828_/Y _13048_/B _12832_/Y VDD VSS sg13g2_a221oi_1
X_14872__2893 _14872_/RESET_B VDD VSS sg13g2_tiehi
XFILLER_37_1321 VDD VSS sg13g2_decap_8
XFILLER_76_1381 VDD VSS sg13g2_decap_8
XFILLER_37_1332 VDD VSS sg13g2_fill_1
XFILLER_163_1373 VDD VSS sg13g2_decap_8
XFILLER_37_1376 VDD VSS sg13g2_decap_8
XFILLER_159_152 VDD VSS sg13g2_fill_2
X_14509_ _14509_/Q _14726_/CLK _14509_/D _14509_/RESET_B VDD VSS sg13g2_dfrbpq_1
XFILLER_175_634 VDD VSS sg13g2_decap_8
XFILLER_148_859 VDD VSS sg13g2_decap_8
XFILLER_175_656 VDD VSS sg13g2_fill_1
XFILLER_174_133 VDD VSS sg13g2_decap_8
X_08030_ _08030_/Y _08070_/C _08234_/A VDD VSS sg13g2_nand2_1
XFILLER_30_695 VDD VSS sg13g2_decap_8
Xinput30 input30/X input30/A VDD VSS sg13g2_buf_1
XFILLER_156_870 VDD VSS sg13g2_decap_8
Xmax_cap522 _09363_/S _09372_/S VDD VSS sg13g2_buf_8
XFILLER_157_1122 VDD VSS sg13g2_fill_1
X_09981_ _14564_/D _10047_/A0 _14564_/Q _09998_/S VDD VSS sg13g2_mux2_1
XFILLER_103_417 VDD VSS sg13g2_fill_1
XFILLER_115_277 VDD VSS sg13g2_decap_4
XFILLER_143_586 VDD VSS sg13g2_decap_8
XFILLER_171_895 VDD VSS sg13g2_decap_8
XFILLER_157_1188 VDD VSS sg13g2_fill_2
XFILLER_103_439 VDD VSS sg13g2_decap_8
X_08932_ _13716_/D _16878_/A _08931_/X _08932_/S VDD VSS sg13g2_mux2_1
XFILLER_130_247 VDD VSS sg13g2_decap_8
XFILLER_170_1322 VDD VSS sg13g2_decap_8
XFILLER_44_1325 VDD VSS sg13g2_decap_8
XFILLER_112_962 VDD VSS sg13g2_fill_1
XFILLER_97_662 VDD VSS sg13g2_fill_2
X_08863_ _08863_/X _08862_/X _08863_/A1 _08940_/S VDD VSS sg13g2_mux2_1
XFILLER_85_813 VDD VSS sg13g2_decap_8
XFILLER_131_1328 VDD VSS sg13g2_decap_8
XFILLER_84_312 VDD VSS sg13g2_decap_4
X_07814_ _08567_/B _08522_/A _08548_/B VDD VSS sg13g2_nand2_1
XFILLER_123_49 VDD VSS sg13g2_decap_8
X_08794_ _08796_/A _13345_/B _14756_/Q _08727_/X _15199_/Q _13490_/B VDD VSS sg13g2_a221oi_1
XFILLER_42_1060 VDD VSS sg13g2_decap_8
X_15065__2974 _15065_/RESET_B VDD VSS sg13g2_tiehi
XFILLER_38_751 VDD VSS sg13g2_decap_8
X_07745_ _15208_/D _07741_/Y _07746_/C _07740_/Y VDD VSS sg13g2_o21ai_1
XFILLER_44_209 VDD VSS sg13g2_fill_2
XFILLER_38_784 VDD VSS sg13g2_decap_8
XFILLER_16_14 VDD VSS sg13g2_decap_8
X_07676_ _07721_/A _15079_/Q _15082_/Q _15080_/Q VDD VSS sg13g2_nor3_1
XFILLER_25_445 VDD VSS sg13g2_decap_8
XFILLER_52_231 VDD VSS sg13g2_decap_8
XFILLER_129_1235 VDD VSS sg13g2_decap_4
X_09415_ _14017_/D _09945_/A1 _14017_/Q _09429_/S VDD VSS sg13g2_mux2_1
XFILLER_80_562 VDD VSS sg13g2_decap_8
XFILLER_53_776 VDD VSS sg13g2_decap_8
XFILLER_41_916 VDD VSS sg13g2_decap_8
XFILLER_25_467 VDD VSS sg13g2_fill_2
XFILLER_129_1268 VDD VSS sg13g2_fill_1
XFILLER_16_1405 VDD VSS sg13g2_decap_8
XFILLER_179_973 VDD VSS sg13g2_decap_8
X_09346_ _13950_/D _10041_/A0 _13950_/Q _09362_/S VDD VSS sg13g2_mux2_1
XFILLER_181_1462 VDD VSS sg13g2_decap_8
XFILLER_142_1424 VDD VSS sg13g2_decap_8
XFILLER_181_1473 VDD VSS sg13g2_fill_2
XFILLER_138_314 VDD VSS sg13g2_decap_8
XFILLER_178_483 VDD VSS sg13g2_decap_8
XFILLER_32_35 VDD VSS sg13g2_decap_8
XFILLER_21_673 VDD VSS sg13g2_decap_8
X_09277_ _13885_/D _13885_/Q _09875_/A0 _09294_/S VDD VSS sg13g2_mux2_1
XFILLER_142_1468 VDD VSS sg13g2_fill_2
XFILLER_20_161 VDD VSS sg13g2_decap_8
XFILLER_21_684 VDD VSS sg13g2_fill_1
XFILLER_148_35 VDD VSS sg13g2_decap_8
XFILLER_21_695 VDD VSS sg13g2_decap_8
XFILLER_166_678 VDD VSS sg13g2_decap_4
X_08228_ _08229_/A _07909_/Y _07921_/Y _07889_/A VDD VSS sg13g2_o21ai_1
XFILLER_14_1162 VDD VSS sg13g2_decap_8
XFILLER_107_701 VDD VSS sg13g2_decap_4
XFILLER_119_561 VDD VSS sg13g2_fill_1
XFILLER_119_572 VDD VSS sg13g2_fill_1
XFILLER_10_1015 VDD VSS sg13g2_decap_8
XFILLER_181_637 VDD VSS sg13g2_decap_8
XFILLER_106_200 VDD VSS sg13g2_decap_4
XFILLER_140_1192 VDD VSS sg13g2_decap_8
XFILLER_101_1154 VDD VSS sg13g2_decap_4
XFILLER_146_380 VDD VSS sg13g2_fill_1
X_08159_ _08166_/B _08158_/X _08397_/A _08246_/A1 _08150_/X VDD VSS sg13g2_a22oi_1
XFILLER_146_391 VDD VSS sg13g2_decap_8
XFILLER_180_147 VDD VSS sg13g2_decap_8
XFILLER_101_1176 VDD VSS sg13g2_decap_8
XFILLER_106_244 VDD VSS sg13g2_fill_2
XFILLER_84_1116 VDD VSS sg13g2_decap_8
X_11170_ _11170_/Y _11170_/A _11170_/B VDD VSS sg13g2_nand2_1
XFILLER_88_1296 VDD VSS sg13g2_decap_8
XFILLER_122_704 VDD VSS sg13g2_decap_8
XFILLER_107_789 VDD VSS sg13g2_decap_8
XFILLER_136_1217 VDD VSS sg13g2_fill_1
XFILLER_161_372 VDD VSS sg13g2_decap_8
XFILLER_164_56 VDD VSS sg13g2_decap_8
X_10121_ _14699_/D _10154_/A1 _14699_/Q _10127_/S VDD VSS sg13g2_mux2_1
XFILLER_0_511 VDD VSS sg13g2_decap_8
XFILLER_175_1288 VDD VSS sg13g2_decap_8
XFILLER_79_139 VDD VSS sg13g2_decap_8
X_14657__1615 _14657_/RESET_B VDD VSS sg13g2_tiehi
X_10052_ _14633_/D _10085_/A0 _14633_/Q _10064_/S VDD VSS sg13g2_mux2_1
XFILLER_94_109 VDD VSS sg13g2_decap_8
XFILLER_88_673 VDD VSS sg13g2_decap_4
XFILLER_0_588 VDD VSS sg13g2_decap_8
XFILLER_130_792 VDD VSS sg13g2_fill_1
X_14860_ _14860_/Q clkload67/A _14860_/D _14860_/RESET_B VDD VSS sg13g2_dfrbpq_1
XFILLER_5_1330 VDD VSS sg13g2_decap_8
XFILLER_25_1280 VDD VSS sg13g2_decap_8
XFILLER_169_1015 VDD VSS sg13g2_fill_1
X_14086__2186 _14086_/RESET_B VDD VSS sg13g2_tiehi
XFILLER_91_805 VDD VSS sg13g2_fill_2
XFILLER_76_879 VDD VSS sg13g2_decap_8
X_13811_ _13811_/Q _14739_/CLK _13811_/D _13811_/RESET_B VDD VSS sg13g2_dfrbpq_1
XFILLER_57_98 VDD VSS sg13g2_decap_8
XFILLER_180_77 VDD VSS sg13g2_decap_8
XFILLER_21_1144 VDD VSS sg13g2_decap_8
X_14791_ _14791_/Q _14890_/CLK _14791_/D _14791_/RESET_B VDD VSS sg13g2_dfrbpq_1
XFILLER_44_710 VDD VSS sg13g2_fill_1
XFILLER_112_1283 VDD VSS sg13g2_fill_1
XFILLER_95_1223 VDD VSS sg13g2_decap_4
XFILLER_44_721 VDD VSS sg13g2_decap_8
X_13742_ _13742_/Q clkload52/A _13742_/D _13742_/RESET_B VDD VSS sg13g2_dfrbpq_1
XFILLER_56_592 VDD VSS sg13g2_decap_4
XFILLER_147_1313 VDD VSS sg13g2_decap_8
XFILLER_16_434 VDD VSS sg13g2_decap_8
XFILLER_186_1362 VDD VSS sg13g2_decap_8
X_10954_ _10967_/A _10954_/A _10954_/B _10954_/C _10954_/D VDD VSS sg13g2_nor4_1
XFILLER_73_42 VDD VSS sg13g2_fill_1
XFILLER_147_1324 VDD VSS sg13g2_decap_8
XFILLER_186_1373 VDD VSS sg13g2_decap_8
XFILLER_56_1218 VDD VSS sg13g2_decap_4
X_15025__2655 _15025_/RESET_B VDD VSS sg13g2_tiehi
X_13673_ _13673_/Q clkload82/A _13673_/D _13673_/RESET_B VDD VSS sg13g2_dfrbpq_1
X_10885_ _10885_/Y _10823_/B _10883_/X _10884_/Y VDD VSS sg13g2_a21oi_1
X_12624_ _12625_/B _13674_/Q _12624_/A2 _12623_/X _12386_/A _12749_/C1 VDD VSS sg13g2_a221oi_1
XFILLER_31_448 VDD VSS sg13g2_decap_8
XFILLER_185_910 VDD VSS sg13g2_fill_2
XFILLER_106_1021 VDD VSS sg13g2_decap_8
XFILLER_12_651 VDD VSS sg13g2_decap_8
XFILLER_157_634 VDD VSS sg13g2_decap_8
X_12555_ _15003_/D _12555_/A _12555_/B VDD VSS sg13g2_nor2_1
XFILLER_185_954 VDD VSS sg13g2_decap_8
XFILLER_11_161 VDD VSS sg13g2_decap_8
XFILLER_8_644 VDD VSS sg13g2_decap_8
XFILLER_145_818 VDD VSS sg13g2_decap_8
XFILLER_184_453 VDD VSS sg13g2_decap_8
X_11506_ _11506_/Y _11636_/A _11506_/B VDD VSS sg13g2_xnor2_1
XFILLER_32_1240 VDD VSS sg13g2_fill_1
XFILLER_184_464 VDD VSS sg13g2_decap_8
XFILLER_138_870 VDD VSS sg13g2_decap_8
X_12486_ _12499_/A _10213_/A _07737_/B _14999_/Q VDD VSS sg13g2_a21oi_1
XFILLER_32_1262 VDD VSS sg13g2_decap_4
XFILLER_144_317 VDD VSS sg13g2_decap_8
XFILLER_7_154 VDD VSS sg13g2_decap_8
X_14849__2939 _14849_/RESET_B VDD VSS sg13g2_tiehi
X_14225_ _14225_/Q _14513_/CLK _14225_/D _14225_/RESET_B VDD VSS sg13g2_dfrbpq_1
XFILLER_156_199 VDD VSS sg13g2_decap_8
X_11437_ _11445_/C _11436_/X _12188_/C VDD VSS sg13g2_nand2b_1
XFILLER_171_147 VDD VSS sg13g2_decap_8
XFILLER_67_1336 VDD VSS sg13g2_fill_2
X_14156_ _14156_/Q _14540_/CLK _14156_/D _14156_/RESET_B VDD VSS sg13g2_dfrbpq_1
XFILLER_67_1347 VDD VSS sg13g2_decap_8
XFILLER_4_861 VDD VSS sg13g2_decap_8
XFILLER_125_575 VDD VSS sg13g2_decap_8
X_11368_ _11368_/X _14238_/Q _14270_/Q _14302_/Q _14334_/Q _11410_/A1 _11419_/C VDD
+ VSS sg13g2_mux4_1
XFILLER_140_512 VDD VSS sg13g2_decap_8
X_13107_ _13107_/Y _14818_/Q _13068_/B _13180_/B1 _14882_/Q _13193_/B VDD VSS sg13g2_a221oi_1
X_14296__1976 _14296_/RESET_B VDD VSS sg13g2_tiehi
XFILLER_3_371 VDD VSS sg13g2_decap_8
XFILLER_154_1339 VDD VSS sg13g2_decap_4
X_10319_ _14799_/D _13328_/A _10319_/B _10319_/C VDD VSS sg13g2_nor3_1
X_14087_ _14087_/Q _14727_/CLK _14087_/D _14087_/RESET_B VDD VSS sg13g2_dfrbpq_1
X_11299_ _11299_/Y _11295_/Y _11296_/Y _11298_/Y _11297_/Y _11900_/B VDD VSS sg13g2_a221oi_1
XFILLER_67_802 VDD VSS sg13g2_decap_8
X_13038_ _13057_/B _14909_/Q _13678_/Q VDD VSS sg13g2_or2_1
XFILLER_152_1052 VDD VSS sg13g2_decap_8
X_14779__3027 _14779_/RESET_B VDD VSS sg13g2_tiehi
XFILLER_6_1127 VDD VSS sg13g2_decap_8
XFILLER_39_515 VDD VSS sg13g2_fill_1
XFILLER_121_781 VDD VSS sg13g2_decap_8
Xfanout1150 _08692_/B _12300_/A VDD VSS sg13g2_buf_1
XFILLER_66_312 VDD VSS sg13g2_decap_8
XFILLER_78_172 VDD VSS sg13g2_decap_8
Xfanout1161 _08627_/A2 _12128_/A VDD VSS sg13g2_buf_1
XFILLER_113_1036 VDD VSS sg13g2_decap_8
Xfanout1172 _08591_/A3 _07812_/B VDD VSS sg13g2_buf_1
XFILLER_26_1088 VDD VSS sg13g2_decap_4
Xfanout1183 _08470_/B _08510_/A2 VDD VSS sg13g2_buf_1
Xfanout1194 _08427_/A3 _11770_/A VDD VSS sg13g2_buf_1
XFILLER_96_1009 VDD VSS sg13g2_decap_8
XFILLER_94_676 VDD VSS sg13g2_decap_8
X_13751__2521 _13751_/RESET_B VDD VSS sg13g2_tiehi
X_14989_ _14989_/Q _15226_/CLK _14989_/D _14989_/RESET_B VDD VSS sg13g2_dfrbpq_1
XFILLER_81_315 VDD VSS sg13g2_decap_8
XFILLER_78_1443 VDD VSS sg13g2_decap_8
XFILLER_19_294 VDD VSS sg13g2_decap_8
XFILLER_179_203 VDD VSS sg13g2_decap_8
XFILLER_62_551 VDD VSS sg13g2_decap_8
XFILLER_35_787 VDD VSS sg13g2_decap_8
XFILLER_126_1408 VDD VSS sg13g2_decap_8
XFILLER_62_584 VDD VSS sg13g2_decap_4
X_09200_ _13816_/D _13816_/Q _10134_/A0 _09200_/S VDD VSS sg13g2_mux2_1
XFILLER_97_0 VDD VSS sg13g2_decap_8
XFILLER_50_746 VDD VSS sg13g2_decap_4
X_14131__2141 _14131_/RESET_B VDD VSS sg13g2_tiehi
XFILLER_37_1162 VDD VSS sg13g2_decap_8
X_13784__2488 _13784_/RESET_B VDD VSS sg13g2_tiehi
XFILLER_33_1004 VDD VSS sg13g2_decap_4
X_09131_ _09131_/X _09137_/A _10772_/A _09130_/Y VDD VSS sg13g2_a21o_1
XFILLER_176_954 VDD VSS sg13g2_decap_8
XFILLER_33_1048 VDD VSS sg13g2_decap_4
XFILLER_147_144 VDD VSS sg13g2_decap_8
XFILLER_175_453 VDD VSS sg13g2_decap_8
X_14735__1537 _14735_/RESET_B VDD VSS sg13g2_tiehi
X_09062_ _09062_/Y _13064_/A _09089_/C _09061_/Y VDD VSS sg13g2_a21oi_1
XFILLER_120_1018 VDD VSS sg13g2_fill_1
XFILLER_8_70 VDD VSS sg13g2_decap_8
XFILLER_11_1302 VDD VSS sg13g2_decap_8
XFILLER_120_1029 VDD VSS sg13g2_decap_4
XFILLER_135_306 VDD VSS sg13g2_fill_2
XFILLER_176_998 VDD VSS sg13g2_decap_8
XFILLER_147_188 VDD VSS sg13g2_decap_8
X_08013_ _08013_/X _07861_/B _07859_/B _07853_/B _07965_/B _08635_/S0 _08635_/S1 VDD
+ VSS sg13g2_mux4_1
XFILLER_147_199 VDD VSS sg13g2_fill_2
XFILLER_50_1384 VDD VSS sg13g2_fill_1
XFILLER_118_38 VDD VSS sg13g2_decap_8
XFILLER_102_1474 VDD VSS sg13g2_fill_1
XFILLER_11_1379 VDD VSS sg13g2_decap_8
Xmax_cap341 _09961_/S _09952_/S VDD VSS sg13g2_buf_8
XFILLER_1_308 VDD VSS sg13g2_decap_8
XFILLER_104_726 VDD VSS sg13g2_decap_8
XFILLER_143_372 VDD VSS sg13g2_decap_4
XFILLER_104_737 VDD VSS sg13g2_fill_1
XFILLER_171_692 VDD VSS sg13g2_decap_8
X_09964_ _14548_/D _14548_/Q _09997_/A0 _09964_/S VDD VSS sg13g2_mux2_1
XFILLER_44_1111 VDD VSS sg13g2_decap_8
XFILLER_98_960 VDD VSS sg13g2_fill_1
XFILLER_103_269 VDD VSS sg13g2_decap_8
X_08915_ _08915_/Y _11914_/A _08937_/S _08914_/Y VDD VSS sg13g2_a21oi_1
X_09895_ _14481_/D _09928_/A1 _14481_/Q _09896_/S VDD VSS sg13g2_mux2_1
XFILLER_58_824 VDD VSS sg13g2_decap_8
XFILLER_112_781 VDD VSS sg13g2_decap_8
XFILLER_44_1155 VDD VSS sg13g2_decap_4
XFILLER_57_312 VDD VSS sg13g2_decap_8
XFILLER_100_943 VDD VSS sg13g2_decap_8
XFILLER_135_1294 VDD VSS sg13g2_decap_8
XFILLER_170_1174 VDD VSS sg13g2_decap_8
X_08846_ _08846_/Y _08850_/S _08845_/Y _08843_/Y VDD VSS sg13g2_o21ai_1
XFILLER_40_1019 VDD VSS sg13g2_decap_8
XFILLER_57_345 VDD VSS sg13g2_decap_8
XFILLER_131_1147 VDD VSS sg13g2_decap_8
XFILLER_57_356 VDD VSS sg13g2_fill_1
XFILLER_85_676 VDD VSS sg13g2_decap_8
XFILLER_84_153 VDD VSS sg13g2_decap_8
XFILLER_57_367 VDD VSS sg13g2_decap_8
XFILLER_45_507 VDD VSS sg13g2_decap_8
XFILLER_57_378 VDD VSS sg13g2_fill_1
XFILLER_27_35 VDD VSS sg13g2_decap_8
XFILLER_150_14 VDD VSS sg13g2_decap_8
X_14341__1931 _14341_/RESET_B VDD VSS sg13g2_tiehi
X_08777_ _13677_/D _08728_/Y _08776_/Y _08775_/Y VDD VSS sg13g2_a21oi_1
XFILLER_22_1464 VDD VSS sg13g2_decap_8
XFILLER_175_7 VDD VSS sg13g2_decap_8
X_14953__2731 _14953_/RESET_B VDD VSS sg13g2_tiehi
X_07728_ _07728_/X _12851_/B _07728_/B _12895_/B VDD VSS sg13g2_or3_1
XFILLER_25_220 VDD VSS sg13g2_decap_4
XFILLER_129_1043 VDD VSS sg13g2_decap_8
XFILLER_168_1092 VDD VSS sg13g2_decap_8
XFILLER_81_882 VDD VSS sg13g2_decap_8
XFILLER_26_787 VDD VSS sg13g2_decap_8
XFILLER_14_938 VDD VSS sg13g2_decap_8
X_07659_ wire556/A _14763_/Q _07658_/X VDD VSS sg13g2_nor2b_1
XFILLER_0_1282 VDD VSS sg13g2_decap_8
XFILLER_80_381 VDD VSS sg13g2_decap_4
XFILLER_186_707 VDD VSS sg13g2_decap_8
XFILLER_41_746 VDD VSS sg13g2_decap_8
XFILLER_40_223 VDD VSS sg13g2_decap_8
XFILLER_25_297 VDD VSS sg13g2_decap_8
XFILLER_13_448 VDD VSS sg13g2_decap_8
XFILLER_16_1202 VDD VSS sg13g2_decap_8
X_10670_ _10670_/Y _13304_/B _13324_/A VDD VSS sg13g2_nor2_1
XFILLER_43_56 VDD VSS sg13g2_decap_8
XFILLER_185_217 VDD VSS sg13g2_decap_8
XFILLER_22_960 VDD VSS sg13g2_decap_8
X_14374__1898 _14374_/RESET_B VDD VSS sg13g2_tiehi
XFILLER_55_1273 VDD VSS sg13g2_fill_1
XFILLER_167_943 VDD VSS sg13g2_decap_8
X_09329_ _13936_/D _09927_/A1 _13936_/Q _09331_/S VDD VSS sg13g2_mux2_1
XFILLER_166_420 VDD VSS sg13g2_decap_8
XFILLER_178_280 VDD VSS sg13g2_decap_8
XFILLER_90_1175 VDD VSS sg13g2_decap_8
XFILLER_21_470 VDD VSS sg13g2_fill_2
XFILLER_51_1148 VDD VSS sg13g2_decap_8
XFILLER_51_1159 VDD VSS sg13g2_fill_1
XFILLER_167_987 VDD VSS sg13g2_decap_8
XFILLER_16_1279 VDD VSS sg13g2_decap_8
XFILLER_21_492 VDD VSS sg13g2_decap_8
X_12340_ _12340_/Y _12340_/A VDD VSS sg13g2_inv_1
XFILLER_154_615 VDD VSS sg13g2_decap_4
XFILLER_181_434 VDD VSS sg13g2_decap_8
X_12271_ _12297_/A _12271_/A _12278_/A VDD VSS sg13g2_nand2_1
XFILLER_5_658 VDD VSS sg13g2_decap_8
XFILLER_107_553 VDD VSS sg13g2_decap_8
X_14010_ _14010_/Q clkload53/A _14010_/D _14010_/RESET_B VDD VSS sg13g2_dfrbpq_1
XFILLER_141_309 VDD VSS sg13g2_fill_1
X_11222_ _11223_/C _11898_/C _11222_/B VDD VSS sg13g2_nor2_1
XFILLER_175_77 VDD VSS sg13g2_decap_8
XFILLER_49_1033 VDD VSS sg13g2_decap_8
XFILLER_175_1041 VDD VSS sg13g2_decap_8
XFILLER_4_168 VDD VSS sg13g2_decap_8
XFILLER_107_586 VDD VSS sg13g2_decap_8
XFILLER_135_895 VDD VSS sg13g2_decap_8
XFILLER_4_28 VDD VSS sg13g2_decap_8
XFILLER_134_394 VDD VSS sg13g2_decap_8
X_11153_ _11153_/Y _11152_/Y _11151_/A _11151_/Y _11150_/Y _11193_/A2 VDD VSS sg13g2_a221oi_1
XFILLER_150_876 VDD VSS sg13g2_decap_8
X_10104_ _14683_/D _10104_/A0 _14683_/Q _10130_/S VDD VSS sg13g2_mux2_1
XFILLER_95_407 VDD VSS sg13g2_decap_4
XFILLER_62_1222 VDD VSS sg13g2_decap_8
XFILLER_27_1342 VDD VSS sg13g2_decap_8
XFILLER_1_875 VDD VSS sg13g2_decap_8
X_11084_ _11084_/Y _11084_/A _11113_/B VDD VSS sg13g2_nand2_1
XFILLER_7_1414 VDD VSS sg13g2_decap_8
XFILLER_49_824 VDD VSS sg13g2_decap_8
XFILLER_0_385 VDD VSS sg13g2_decap_8
X_14912_ _14912_/Q clkload56/A _14912_/D _14912_/RESET_B VDD VSS sg13g2_dfrbpq_1
X_10035_ _14617_/D _10101_/A0 _14617_/Q _10035_/S VDD VSS sg13g2_mux2_1
XFILLER_62_1277 VDD VSS sg13g2_fill_1
XFILLER_49_868 VDD VSS sg13g2_fill_1
XFILLER_23_1239 VDD VSS sg13g2_decap_8
XFILLER_62_1299 VDD VSS sg13g2_fill_1
XFILLER_75_153 VDD VSS sg13g2_fill_2
X_14843_ _14843_/Q clkload68/A _14843_/D _14843_/RESET_B VDD VSS sg13g2_dfrbpq_1
XFILLER_36_518 VDD VSS sg13g2_decap_8
XFILLER_149_1408 VDD VSS sg13g2_fill_1
XFILLER_63_315 VDD VSS sg13g2_decap_8
XFILLER_17_721 VDD VSS sg13g2_decap_8
X_14774_ _14774_/Q clkload66/A _14774_/D _14774_/RESET_B VDD VSS sg13g2_dfrbpq_1
XFILLER_90_134 VDD VSS sg13g2_decap_8
XFILLER_16_231 VDD VSS sg13g2_decap_8
XFILLER_1_1057 VDD VSS sg13g2_decap_8
X_11986_ _11986_/Y _11986_/A _11986_/B VDD VSS sg13g2_nor2_1
XFILLER_147_1132 VDD VSS sg13g2_decap_8
X_13725_ _13725_/Q _14886_/CLK _13725_/D _13725_/RESET_B VDD VSS sg13g2_dfrbpq_1
X_10937_ _10937_/Y _10954_/B _10937_/B VDD VSS sg13g2_xnor2_1
XFILLER_71_370 VDD VSS sg13g2_decap_8
XFILLER_32_746 VDD VSS sg13g2_decap_8
XFILLER_182_1056 VDD VSS sg13g2_fill_1
XFILLER_108_1138 VDD VSS sg13g2_decap_4
XFILLER_182_1067 VDD VSS sg13g2_decap_8
X_13656_ _15122_/D _15192_/D _15122_/Q _13656_/S VDD VSS sg13g2_mux2_1
XFILLER_90_7 VDD VSS sg13g2_decap_8
X_10868_ _10869_/B _10890_/A _10890_/B _10868_/C VDD VSS sg13g2_nor3_1
XFILLER_176_217 VDD VSS sg13g2_decap_8
X_12607_ _12607_/X _12600_/X _12604_/X _12599_/X _12603_/X _12663_/S0 _12663_/S1 VDD
+ VSS sg13g2_mux4_1
XFILLER_9_931 VDD VSS sg13g2_decap_8
X_13587_ _13587_/Y _13587_/A _13593_/B VDD VSS sg13g2_nor2_1
XFILLER_31_289 VDD VSS sg13g2_decap_8
XFILLER_157_442 VDD VSS sg13g2_fill_2
X_10799_ _14926_/D _07705_/B _10798_/X _10796_/Y VDD VSS sg13g2_o21ai_1
XFILLER_34_1357 VDD VSS sg13g2_fill_1
XFILLER_173_902 VDD VSS sg13g2_decap_8
XFILLER_8_441 VDD VSS sg13g2_decap_8
X_12538_ _12538_/X _12536_/X _12535_/X _12532_/X _12531_/X _12761_/S0 _12664_/S VDD
+ VSS sg13g2_mux4_1
XFILLER_172_401 VDD VSS sg13g2_decap_8
XFILLER_121_1349 VDD VSS sg13g2_decap_8
XFILLER_144_103 VDD VSS sg13g2_decap_8
XFILLER_173_946 VDD VSS sg13g2_decap_8
XFILLER_184_272 VDD VSS sg13g2_decap_8
XFILLER_172_434 VDD VSS sg13g2_decap_4
XFILLER_32_1081 VDD VSS sg13g2_decap_8
X_12469_ _12469_/X _12467_/X _12468_/X _12553_/S VDD VSS sg13g2_mux2_1
XFILLER_144_147 VDD VSS sg13g2_decap_8
XFILLER_173_979 VDD VSS sg13g2_decap_8
X_13769__2503 _13769_/RESET_B VDD VSS sg13g2_tiehi
X_14208_ _14208_/Q clkload46/A _14208_/D _14208_/RESET_B VDD VSS sg13g2_dfrbpq_1
XFILLER_67_1122 VDD VSS sg13g2_fill_2
XFILLER_126_884 VDD VSS sg13g2_decap_8
X_15188_ _15188_/Q clkload82/A _15188_/D _15188_/RESET_B VDD VSS sg13g2_dfrbpq_1
XFILLER_99_724 VDD VSS sg13g2_fill_2
XFILLER_141_821 VDD VSS sg13g2_decap_8
XFILLER_99_735 VDD VSS sg13g2_decap_8
XFILLER_141_832 VDD VSS sg13g2_fill_2
XFILLER_154_1114 VDD VSS sg13g2_decap_8
XFILLER_119_1245 VDD VSS sg13g2_decap_8
XFILLER_154_1125 VDD VSS sg13g2_fill_1
X_14139_ _14139_/Q _14685_/CLK _14139_/D _14139_/RESET_B VDD VSS sg13g2_dfrbpq_1
Xfanout409 _09261_/S _09273_/S VDD VSS sg13g2_buf_1
XFILLER_140_331 VDD VSS sg13g2_decap_8
XFILLER_98_278 VDD VSS sg13g2_decap_4
XFILLER_100_206 VDD VSS sg13g2_decap_4
XFILLER_101_729 VDD VSS sg13g2_decap_8
XFILLER_171_1450 VDD VSS sg13g2_decap_8
XFILLER_80_1344 VDD VSS sg13g2_decap_8
XFILLER_39_301 VDD VSS sg13g2_decap_8
X_14149__2123 _14149_/RESET_B VDD VSS sg13g2_tiehi
X_08700_ _08700_/Y _08698_/X _08697_/Y _08695_/Y _08696_/Y _07974_/D VDD VSS sg13g2_a221oi_1
XFILLER_67_632 VDD VSS sg13g2_decap_4
X_09680_ _14272_/D _09911_/A1 _14272_/Q _09705_/S VDD VSS sg13g2_mux2_1
XFILLER_95_952 VDD VSS sg13g2_decap_4
XFILLER_132_1456 VDD VSS sg13g2_decap_8
XFILLER_12_0 VDD VSS sg13g2_decap_8
XFILLER_95_985 VDD VSS sg13g2_fill_2
X_08631_ _08631_/Y _08641_/A _08630_/Y _08395_/A VDD VSS sg13g2_a21oi_1
XFILLER_55_827 VDD VSS sg13g2_decap_4
XFILLER_54_304 VDD VSS sg13g2_decap_8
XFILLER_39_378 VDD VSS sg13g2_fill_2
XFILLER_82_624 VDD VSS sg13g2_decap_8
XFILLER_67_698 VDD VSS sg13g2_decap_8
XFILLER_94_495 VDD VSS sg13g2_decap_8
X_08562_ _08562_/Y _08030_/Y _08488_/B _08561_/Y VDD VSS sg13g2_o21ai_1
XFILLER_130_1191 VDD VSS sg13g2_decap_8
XFILLER_70_808 VDD VSS sg13g2_decap_8
XFILLER_82_679 VDD VSS sg13g2_decap_8
X_13679__2607 _13679_/RESET_B VDD VSS sg13g2_tiehi
XFILLER_78_1284 VDD VSS sg13g2_decap_8
XFILLER_120_39 VDD VSS sg13g2_decap_8
XFILLER_165_1243 VDD VSS sg13g2_decap_8
X_08493_ _08494_/B _15008_/Q _08471_/B _07805_/B _07949_/C VDD VSS sg13g2_a22oi_1
XFILLER_126_1216 VDD VSS sg13g2_fill_1
XFILLER_90_690 VDD VSS sg13g2_fill_2
XFILLER_62_381 VDD VSS sg13g2_fill_2
XFILLER_168_718 VDD VSS sg13g2_fill_1
XFILLER_126_1227 VDD VSS sg13g2_fill_1
XFILLER_22_245 VDD VSS sg13g2_decap_8
XFILLER_167_217 VDD VSS sg13g2_decap_4
XFILLER_50_598 VDD VSS sg13g2_fill_2
XFILLER_176_751 VDD VSS sg13g2_fill_2
XFILLER_164_902 VDD VSS sg13g2_decap_8
X_09114_ _10762_/B _09134_/S _15045_/Q _09113_/Y VDD VSS sg13g2_o21ai_1
XFILLER_148_497 VDD VSS sg13g2_fill_1
XFILLER_164_957 VDD VSS sg13g2_fill_1
XFILLER_175_294 VDD VSS sg13g2_decap_8
X_09045_ wire262/A _09024_/A _10716_/B _09044_/X VDD VSS sg13g2_o21ai_1
XFILLER_135_158 VDD VSS sg13g2_decap_8
XFILLER_159_1069 VDD VSS sg13g2_fill_1
X_14359__1913 _14359_/RESET_B VDD VSS sg13g2_tiehi
X_15178__2948 _15178_/RESET_B VDD VSS sg13g2_tiehi
XFILLER_116_350 VDD VSS sg13g2_decap_8
XFILLER_11_1176 VDD VSS sg13g2_decap_8
XFILLER_145_14 VDD VSS sg13g2_decap_8
XFILLER_1_105 VDD VSS sg13g2_decap_8
XFILLER_89_212 VDD VSS sg13g2_fill_2
XFILLER_137_1323 VDD VSS sg13g2_decap_8
XFILLER_172_1236 VDD VSS sg13g2_decap_8
XFILLER_89_245 VDD VSS sg13g2_decap_8
XFILLER_132_865 VDD VSS sg13g2_fill_2
Xfanout910 _12424_/S1 _12425_/S1 VDD VSS sg13g2_buf_1
Xfanout921 _12643_/S0 _12564_/S0 VDD VSS sg13g2_buf_1
Xfanout932 fanout932/X _15210_/Q VDD VSS sg13g2_buf_1
X_09947_ _14531_/D _14531_/Q _10079_/A0 _09965_/S VDD VSS sg13g2_mux2_1
Xfanout943 _12783_/S0 _12702_/S0 VDD VSS sg13g2_buf_1
XFILLER_58_610 VDD VSS sg13g2_decap_8
Xfanout954 _12759_/S0 _12757_/S0 VDD VSS sg13g2_buf_1
Xfanout965 _12425_/S0 fanout966/X VDD VSS sg13g2_buf_1
Xfanout976 _11243_/C _13289_/C VDD VSS sg13g2_buf_1
XFILLER_86_952 VDD VSS sg13g2_decap_8
Xfanout987 _12765_/A2 _13293_/C VDD VSS sg13g2_buf_1
X_09878_ _14464_/D _09911_/A1 _14464_/Q _09901_/S VDD VSS sg13g2_mux2_1
XFILLER_38_56 VDD VSS sg13g2_decap_8
XFILLER_161_35 VDD VSS sg13g2_decap_8
Xfanout998 _13566_/C _15202_/Q VDD VSS sg13g2_buf_1
XFILLER_58_665 VDD VSS sg13g2_decap_8
X_15160__2730 _15160_/RESET_B VDD VSS sg13g2_tiehi
XFILLER_73_602 VDD VSS sg13g2_decap_4
XFILLER_18_518 VDD VSS sg13g2_decap_8
X_08829_ _08830_/C _15055_/Q _13283_/A _11241_/C VDD VSS sg13g2_nor3_1
XFILLER_57_175 VDD VSS sg13g2_decap_8
XFILLER_100_795 VDD VSS sg13g2_decap_8
XFILLER_22_1261 VDD VSS sg13g2_decap_8
XFILLER_166_1007 VDD VSS sg13g2_decap_8
X_11840_ _11907_/B _11770_/A _13064_/B _13676_/Q _11798_/A VDD VSS sg13g2_a22oi_1
XFILLER_2_1344 VDD VSS sg13g2_decap_8
XFILLER_57_1313 VDD VSS sg13g2_decap_8
X_11771_ _11771_/Y _11771_/A _11771_/B _11773_/C VDD VSS sg13g2_nor3_1
XFILLER_109_1414 VDD VSS sg13g2_fill_1
XFILLER_54_893 VDD VSS sg13g2_fill_2
XFILLER_53_370 VDD VSS sg13g2_decap_8
XFILLER_14_735 VDD VSS sg13g2_decap_8
XFILLER_183_1354 VDD VSS sg13g2_decap_8
X_13847__2425 _13847_/RESET_B VDD VSS sg13g2_tiehi
X_13510_ _15133_/D _15133_/Q _13510_/A1 _13519_/B VDD VSS sg13g2_mux2_1
X_10722_ _10722_/Y _10725_/A _10720_/B _08885_/Y VDD VSS sg13g2_o21ai_1
XFILLER_109_1447 VDD VSS sg13g2_decap_8
X_14490_ _14490_/Q clkload57/A _14490_/D _14490_/RESET_B VDD VSS sg13g2_dfrbpq_1
XFILLER_13_245 VDD VSS sg13g2_decap_8
X_13441_ _15102_/D _13421_/Y _13438_/Y _13440_/Y VDD VSS sg13g2_o21ai_1
XFILLER_70_21 VDD VSS sg13g2_decap_8
X_10653_ _10654_/B _10653_/A _10653_/B _10653_/C _10653_/D VDD VSS sg13g2_nand4_1
XFILLER_9_238 VDD VSS sg13g2_decap_8
XFILLER_142_1051 VDD VSS sg13g2_decap_8
XFILLER_186_21 VDD VSS sg13g2_decap_8
XFILLER_167_773 VDD VSS sg13g2_decap_4
XFILLER_10_952 VDD VSS sg13g2_decap_8
XFILLER_16_1076 VDD VSS sg13g2_decap_8
X_13372_ _13372_/Y _13440_/A _13440_/B _15077_/Q VDD VSS sg13g2_nand3_1
X_10584_ _10606_/A _14872_/Q _14871_/Q _10584_/C VDD VSS sg13g2_nand3_1
XFILLER_154_412 VDD VSS sg13g2_decap_8
Xclkload19 clkload19/Y clkload19/A VDD VSS sg13g2_inv_1
XFILLER_177_1103 VDD VSS sg13g2_fill_1
X_14227__2045 _14227_/RESET_B VDD VSS sg13g2_tiehi
X_15111_ _15111_/Q _15113_/CLK _15111_/D _15111_/RESET_B VDD VSS sg13g2_dfrbpq_1
X_12323_ _12324_/A _14266_/Q _14298_/Q _14330_/Q _14362_/Q _12306_/A _12330_/S1 VDD
+ VSS sg13g2_mux4_1
XFILLER_155_968 VDD VSS sg13g2_decap_8
XFILLER_166_294 VDD VSS sg13g2_decap_4
XFILLER_86_1008 VDD VSS sg13g2_decap_8
XFILLER_6_945 VDD VSS sg13g2_decap_8
XFILLER_181_231 VDD VSS sg13g2_decap_8
XFILLER_182_754 VDD VSS sg13g2_decap_8
XFILLER_142_618 VDD VSS sg13g2_decap_8
XFILLER_154_478 VDD VSS sg13g2_fill_2
XFILLER_170_927 VDD VSS sg13g2_decap_8
XFILLER_177_1158 VDD VSS sg13g2_decap_8
X_15042_ _15042_/Q clkload65/A _15042_/D _15042_/RESET_B VDD VSS sg13g2_dfrbpq_1
XFILLER_79_30 VDD VSS sg13g2_fill_2
XFILLER_5_455 VDD VSS sg13g2_decap_8
XFILLER_170_938 VDD VSS sg13g2_fill_1
X_12254_ _12254_/Y _12245_/S0 _13848_/Q VDD VSS sg13g2_nand2b_1
XFILLER_68_1442 VDD VSS sg13g2_fill_2
XFILLER_108_895 VDD VSS sg13g2_decap_4
XFILLER_155_1412 VDD VSS sg13g2_decap_8
XFILLER_141_128 VDD VSS sg13g2_decap_4
X_11205_ _11205_/X _11205_/A _11205_/B VDD VSS sg13g2_xor2_1
XFILLER_29_1437 VDD VSS sg13g2_decap_8
X_12185_ _12187_/A _12186_/A _13910_/Q VDD VSS sg13g2_nand2b_1
XFILLER_96_705 VDD VSS sg13g2_decap_8
XFILLER_68_407 VDD VSS sg13g2_decap_8
XFILLER_110_504 VDD VSS sg13g2_fill_2
X_11136_ _11136_/Y _11146_/B _11136_/B VDD VSS sg13g2_xnor2_1
XFILLER_7_1211 VDD VSS sg13g2_decap_8
XFILLER_1_672 VDD VSS sg13g2_decap_8
XFILLER_96_749 VDD VSS sg13g2_fill_1
XFILLER_95_237 VDD VSS sg13g2_fill_1
X_15067__2966 _15067_/RESET_B VDD VSS sg13g2_tiehi
XFILLER_0_182 VDD VSS sg13g2_decap_8
XFILLER_153_1180 VDD VSS sg13g2_decap_8
X_11067_ _11067_/Y _11118_/A _11088_/A _11066_/Y VDD VSS sg13g2_a21oi_1
XFILLER_153_1191 VDD VSS sg13g2_fill_2
XFILLER_114_1153 VDD VSS sg13g2_decap_8
XFILLER_92_911 VDD VSS sg13g2_fill_1
X_10018_ _14600_/D _10051_/A0 _14600_/Q _10027_/S VDD VSS sg13g2_mux2_1
XFILLER_92_922 VDD VSS sg13g2_fill_1
XFILLER_7_1288 VDD VSS sg13g2_decap_8
XFILLER_64_635 VDD VSS sg13g2_decap_8
XFILLER_36_326 VDD VSS sg13g2_decap_8
XFILLER_97_1148 VDD VSS sg13g2_decap_8
XFILLER_40_1361 VDD VSS sg13g2_decap_8
X_14826_ _14826_/Q _14890_/CLK _14826_/D _14826_/RESET_B VDD VSS sg13g2_dfrbpq_1
X_15128__2796 _15128_/RESET_B VDD VSS sg13g2_tiehi
XFILLER_92_966 VDD VSS sg13g2_fill_1
XFILLER_52_808 VDD VSS sg13g2_decap_8
XFILLER_63_156 VDD VSS sg13g2_decap_8
X_14757_ _14757_/Q _15182_/CLK _14757_/D _14757_/RESET_B VDD VSS sg13g2_dfrbpq_1
XFILLER_75_1435 VDD VSS sg13g2_decap_8
XFILLER_45_882 VDD VSS sg13g2_decap_8
X_11969_ _11970_/B _11969_/A _13936_/Q VDD VSS sg13g2_nand2_1
XFILLER_44_370 VDD VSS sg13g2_decap_8
XFILLER_17_595 VDD VSS sg13g2_decap_8
XFILLER_177_504 VDD VSS sg13g2_decap_8
X_13708_ _13708_/Q clkload75/A _13708_/D _13708_/RESET_B VDD VSS sg13g2_dfrbpq_1
X_14437__1835 _14437_/RESET_B VDD VSS sg13g2_tiehi
XFILLER_60_852 VDD VSS sg13g2_decap_8
X_14688_ _14688_/Q _14720_/CLK _14688_/D _14688_/RESET_B VDD VSS sg13g2_dfrbpq_1
XFILLER_149_228 VDD VSS sg13g2_decap_8
X_13639_ _13747_/D _13639_/A VDD VSS sg13g2_buf_1
XFILLER_32_598 VDD VSS sg13g2_fill_1
XFILLER_20_749 VDD VSS sg13g2_decap_8
XFILLER_125_1260 VDD VSS sg13g2_decap_8
XFILLER_173_721 VDD VSS sg13g2_decap_8
XFILLER_185_581 VDD VSS sg13g2_decap_8
X_14652__1620 _14652_/RESET_B VDD VSS sg13g2_tiehi
XFILLER_121_1179 VDD VSS sg13g2_decap_8
XFILLER_12_1463 VDD VSS sg13g2_decap_8
XFILLER_145_467 VDD VSS sg13g2_decap_8
XFILLER_105_309 VDD VSS sg13g2_decap_8
XFILLER_172_275 VDD VSS sg13g2_decap_8
XFILLER_99_521 VDD VSS sg13g2_fill_1
XFILLER_114_832 VDD VSS sg13g2_decap_8
XFILLER_132_139 VDD VSS sg13g2_decap_8
X_14081__2191 _14081_/RESET_B VDD VSS sg13g2_tiehi
Xfanout206 _09727_/A0 fanout210/X VDD VSS sg13g2_buf_1
XFILLER_8_1008 VDD VSS sg13g2_decap_8
X_09801_ _14390_/D _09933_/A1 _14390_/Q _09804_/S VDD VSS sg13g2_mux2_1
XFILLER_87_716 VDD VSS sg13g2_fill_2
XFILLER_114_887 VDD VSS sg13g2_decap_8
Xfanout228 _10087_/A0 _09063_/X VDD VSS sg13g2_buf_1
XFILLER_87_738 VDD VSS sg13g2_fill_1
XFILLER_119_1086 VDD VSS sg13g2_decap_8
Xfanout239 _09920_/A1 wire243/X VDD VSS sg13g2_buf_1
X_07993_ _07993_/Y _15100_/Q _15089_/Q VDD VSS sg13g2_nor2_1
X_13925__2347 _13925_/RESET_B VDD VSS sg13g2_tiehi
X_14685__1587 _14685_/RESET_B VDD VSS sg13g2_tiehi
XFILLER_68_941 VDD VSS sg13g2_decap_8
XFILLER_45_1261 VDD VSS sg13g2_decap_8
X_09732_ _14323_/D _09831_/A0 _14323_/Q _09737_/S VDD VSS sg13g2_mux2_1
XFILLER_101_559 VDD VSS sg13g2_decap_8
XFILLER_171_1280 VDD VSS sg13g2_decap_8
X_15020__2660 _15020_/RESET_B VDD VSS sg13g2_tiehi
XFILLER_67_451 VDD VSS sg13g2_decap_8
XFILLER_80_1185 VDD VSS sg13g2_decap_8
XFILLER_39_153 VDD VSS sg13g2_decap_8
XFILLER_132_1275 VDD VSS sg13g2_fill_2
X_09663_ _14256_/D _10092_/A0 _14256_/Q _09665_/S VDD VSS sg13g2_mux2_1
XFILLER_28_838 VDD VSS sg13g2_decap_8
XFILLER_94_281 VDD VSS sg13g2_decap_8
XFILLER_83_955 VDD VSS sg13g2_fill_1
X_08614_ _08615_/B _08641_/B _08612_/X _08613_/Y VDD VSS sg13g2_o21ai_1
XFILLER_54_123 VDD VSS sg13g2_fill_2
XFILLER_131_38 VDD VSS sg13g2_decap_8
X_09594_ _14191_/D _14191_/Q _09627_/A0 _09603_/S VDD VSS sg13g2_mux2_1
XFILLER_55_668 VDD VSS sg13g2_decap_8
XFILLER_43_808 VDD VSS sg13g2_decap_8
X_08545_ _08545_/X _08545_/A _08545_/B _08545_/C _08545_/D VDD VSS sg13g2_and4_1
XFILLER_78_1070 VDD VSS sg13g2_fill_2
XFILLER_70_627 VDD VSS sg13g2_decap_8
XFILLER_39_1032 VDD VSS sg13g2_decap_4
XFILLER_35_370 VDD VSS sg13g2_decap_8
XFILLER_165_1040 VDD VSS sg13g2_decap_8
XFILLER_24_14 VDD VSS sg13g2_decap_8
X_08476_ _08476_/Y _08476_/A _08497_/A VDD VSS sg13g2_nand2_1
XFILLER_39_1098 VDD VSS sg13g2_decap_8
XFILLER_17_1341 VDD VSS sg13g2_decap_8
XFILLER_11_749 VDD VSS sg13g2_decap_8
XFILLER_138_7 VDD VSS sg13g2_decap_4
XFILLER_91_1292 VDD VSS sg13g2_fill_2
XFILLER_183_518 VDD VSS sg13g2_decap_8
XFILLER_10_259 VDD VSS sg13g2_decap_8
X_14291__1981 _14291_/RESET_B VDD VSS sg13g2_tiehi
XFILLER_104_1344 VDD VSS sg13g2_fill_1
XFILLER_149_795 VDD VSS sg13g2_decap_8
XFILLER_104_1366 VDD VSS sg13g2_decap_8
XFILLER_137_946 VDD VSS sg13g2_decap_8
XFILLER_148_283 VDD VSS sg13g2_fill_2
XFILLER_176_592 VDD VSS sg13g2_decap_8
XFILLER_52_1298 VDD VSS sg13g2_decap_4
XFILLER_40_35 VDD VSS sg13g2_decap_8
XFILLER_156_35 VDD VSS sg13g2_decap_8
XFILLER_124_607 VDD VSS sg13g2_fill_1
X_14774__3032 _14774_/RESET_B VDD VSS sg13g2_tiehi
XFILLER_163_264 VDD VSS sg13g2_decap_4
X_09028_ _09031_/B _14905_/Q _09024_/B VDD VSS sg13g2_nor2b_1
XFILLER_40_79 VDD VSS sg13g2_fill_1
XFILLER_145_990 VDD VSS sg13g2_fill_1
XFILLER_3_959 VDD VSS sg13g2_decap_8
XFILLER_176_1180 VDD VSS sg13g2_decap_8
XFILLER_132_651 VDD VSS sg13g2_decap_4
XFILLER_85_1085 VDD VSS sg13g2_decap_8
XFILLER_46_1036 VDD VSS sg13g2_decap_8
XFILLER_2_469 VDD VSS sg13g2_decap_8
XFILLER_137_1164 VDD VSS sg13g2_fill_1
XFILLER_77_204 VDD VSS sg13g2_decap_8
XFILLER_78_749 VDD VSS sg13g2_decap_8
XFILLER_133_1028 VDD VSS sg13g2_decap_8
Xclkbuf_leaf_9_clk_i clkload13/A clkbuf_leaf_9_clk_i/A VDD VSS sg13g2_buf_8
Xfanout740 _11664_/A _11458_/A VDD VSS sg13g2_buf_1
XFILLER_63_1350 VDD VSS sg13g2_decap_8
XFILLER_59_930 VDD VSS sg13g2_decap_4
XFILLER_49_77 VDD VSS sg13g2_decap_8
XFILLER_131_183 VDD VSS sg13g2_decap_8
XFILLER_172_56 VDD VSS sg13g2_decap_8
Xfanout751 _12192_/A _11765_/A VDD VSS sg13g2_buf_1
X_14515__1757 _14515_/RESET_B VDD VSS sg13g2_tiehi
Xfanout762 _11422_/B _11822_/B VDD VSS sg13g2_buf_1
XFILLER_24_1323 VDD VSS sg13g2_decap_8
X_13990_ _13990_/Q clkload18/A _13990_/D _13990_/RESET_B VDD VSS sg13g2_dfrbpq_1
Xfanout773 _12190_/B _11542_/B VDD VSS sg13g2_buf_1
XFILLER_93_708 VDD VSS sg13g2_fill_2
XFILLER_93_719 VDD VSS sg13g2_decap_8
XFILLER_59_974 VDD VSS sg13g2_decap_8
Xfanout784 _12304_/B _12328_/B1 VDD VSS sg13g2_buf_1
XFILLER_150_1353 VDD VSS sg13g2_decap_8
Xfanout795 _11185_/A _07652_/Y VDD VSS sg13g2_buf_1
XFILLER_4_1428 VDD VSS sg13g2_decap_8
XFILLER_46_602 VDD VSS sg13g2_decap_8
XFILLER_19_827 VDD VSS sg13g2_decap_4
X_12941_ _15029_/D _13266_/A _12941_/B VDD VSS sg13g2_nor2_1
XFILLER_98_1424 VDD VSS sg13g2_fill_1
XFILLER_65_21 VDD VSS sg13g2_decap_4
XFILLER_18_315 VDD VSS sg13g2_decap_8
XFILLER_86_793 VDD VSS sg13g2_decap_8
XFILLER_111_1337 VDD VSS sg13g2_decap_8
XFILLER_85_270 VDD VSS sg13g2_fill_1
X_12872_ _12872_/X _14899_/Q _13688_/Q VDD VSS sg13g2_and2_1
XFILLER_65_76 VDD VSS sg13g2_decap_8
XFILLER_2_1141 VDD VSS sg13g2_decap_8
XFILLER_164_0 VDD VSS sg13g2_decap_8
X_14611_ _14611_/Q clkload31/A _14611_/D _14611_/RESET_B VDD VSS sg13g2_dfrbpq_1
XFILLER_45_167 VDD VSS sg13g2_decap_8
X_11823_ _11823_/Y _11826_/A1 _13836_/Q VDD VSS sg13g2_nand2b_1
X_14730__1542 _14730_/RESET_B VDD VSS sg13g2_tiehi
XFILLER_121_60 VDD VSS sg13g2_decap_4
XFILLER_14_532 VDD VSS sg13g2_decap_8
XFILLER_26_392 VDD VSS sg13g2_decap_8
XFILLER_159_504 VDD VSS sg13g2_decap_4
X_14542_ _14542_/Q clkload52/A _14542_/D _14542_/RESET_B VDD VSS sg13g2_dfrbpq_1
XFILLER_109_1233 VDD VSS sg13g2_fill_1
XFILLER_121_93 VDD VSS sg13g2_fill_2
XFILLER_144_1113 VDD VSS sg13g2_decap_8
X_11754_ _11754_/X _11754_/A _11763_/B VDD VSS sg13g2_and2_1
XFILLER_109_1244 VDD VSS sg13g2_fill_1
XFILLER_57_1176 VDD VSS sg13g2_decap_8
X_10705_ _10936_/D _09021_/X _10788_/S _08869_/Y VDD VSS sg13g2_a21o_1
XFILLER_109_1277 VDD VSS sg13g2_decap_8
X_14473_ _14473_/Q clkload36/A _14473_/D _14473_/RESET_B VDD VSS sg13g2_dfrbpq_1
X_15228__3089 _15228_/RESET_B VDD VSS sg13g2_tiehi
XFILLER_109_1288 VDD VSS sg13g2_fill_2
X_11685_ _11685_/Y _11681_/Y _11682_/Y _11684_/Y _11683_/Y _12253_/B VDD VSS sg13g2_a221oi_1
XFILLER_81_97 VDD VSS sg13g2_decap_8
XFILLER_122_1411 VDD VSS sg13g2_decap_8
X_13424_ _13444_/C _13469_/A _15130_/Q VDD VSS sg13g2_nand2_1
XFILLER_35_1474 VDD VSS sg13g2_fill_1
XFILLER_31_1305 VDD VSS sg13g2_decap_8
XFILLER_128_924 VDD VSS sg13g2_decap_8
X_10636_ _10642_/C _10636_/A _10636_/B VDD VSS sg13g2_nor2_1
XFILLER_14_91 VDD VSS sg13g2_decap_8
XFILLER_167_581 VDD VSS sg13g2_decap_8
XFILLER_70_1376 VDD VSS sg13g2_decap_8
XFILLER_70_1387 VDD VSS sg13g2_fill_2
X_13355_ _13469_/C _13396_/A _13396_/B _13438_/B VDD VSS sg13g2_nor3_1
X_13663__2639 _13663_/RESET_B VDD VSS sg13g2_tiehi
XFILLER_127_445 VDD VSS sg13g2_decap_8
X_10567_ _10579_/C _10567_/A _10567_/B _10567_/C _10567_/D VDD VSS sg13g2_nor4_1
XFILLER_6_742 VDD VSS sg13g2_decap_8
XFILLER_115_607 VDD VSS sg13g2_decap_8
XFILLER_127_467 VDD VSS sg13g2_decap_8
XFILLER_154_253 VDD VSS sg13g2_fill_1
XFILLER_155_787 VDD VSS sg13g2_decap_8
X_12306_ _12307_/B _12306_/A _14234_/Q VDD VSS sg13g2_nand2_1
XFILLER_5_252 VDD VSS sg13g2_decap_8
XFILLER_170_724 VDD VSS sg13g2_decap_8
X_13286_ _13287_/B _13300_/C _07751_/Y _07710_/Y VDD VSS sg13g2_o21ai_1
XFILLER_53_7 VDD VSS sg13g2_decap_8
XFILLER_154_286 VDD VSS sg13g2_decap_8
XFILLER_182_595 VDD VSS sg13g2_decap_8
X_10498_ _10499_/B _14853_/Q _14852_/Q _10508_/A _10498_/D VDD VSS sg13g2_nand4_1
XFILLER_154_297 VDD VSS sg13g2_fill_2
X_15025_ _15025_/Q _15219_/CLK _15025_/D _15025_/RESET_B VDD VSS sg13g2_dfrbpq_1
XFILLER_68_1261 VDD VSS sg13g2_fill_2
XFILLER_155_1220 VDD VSS sg13g2_decap_4
X_12237_ _12237_/Y _12237_/A _12237_/B _12237_/C VDD VSS sg13g2_nand3_1
XFILLER_107_191 VDD VSS sg13g2_decap_8
XFILLER_170_768 VDD VSS sg13g2_decap_8
XFILLER_170_779 VDD VSS sg13g2_fill_2
X_14914__2809 _14914_/RESET_B VDD VSS sg13g2_tiehi
XFILLER_146_90 VDD VSS sg13g2_fill_2
XFILLER_151_971 VDD VSS sg13g2_decap_8
XFILLER_64_1147 VDD VSS sg13g2_decap_8
XFILLER_150_470 VDD VSS sg13g2_decap_4
XFILLER_151_993 VDD VSS sg13g2_fill_1
X_12168_ _12169_/B _12168_/A _14678_/Q VDD VSS sg13g2_nand2_1
XFILLER_123_695 VDD VSS sg13g2_decap_8
XFILLER_151_1128 VDD VSS sg13g2_decap_8
X_11119_ _11119_/Y _11119_/A _11119_/B VDD VSS sg13g2_nor2_1
XFILLER_111_868 VDD VSS sg13g2_decap_8
XFILLER_110_356 VDD VSS sg13g2_decap_8
X_12099_ _12099_/Y _12095_/Y _12096_/Y _12098_/Y _12097_/Y _12101_/B VDD VSS sg13g2_a221oi_1
XFILLER_96_579 VDD VSS sg13g2_decap_8
XFILLER_49_462 VDD VSS sg13g2_decap_8
XFILLER_110_378 VDD VSS sg13g2_decap_8
Xinput6 input6/X input6/A VDD VSS sg13g2_buf_1
XFILLER_83_229 VDD VSS sg13g2_decap_8
XFILLER_7_1085 VDD VSS sg13g2_decap_8
XFILLER_149_1002 VDD VSS sg13g2_decap_8
XFILLER_65_966 VDD VSS sg13g2_fill_1
XFILLER_37_657 VDD VSS sg13g2_decap_8
XFILLER_92_763 VDD VSS sg13g2_decap_8
XFILLER_64_454 VDD VSS sg13g2_decap_8
XFILLER_64_465 VDD VSS sg13g2_fill_1
XFILLER_40_1180 VDD VSS sg13g2_decap_4
XFILLER_18_871 VDD VSS sg13g2_decap_8
XFILLER_36_178 VDD VSS sg13g2_decap_8
X_14809_ _14809_/Q clkload62/A _14809_/D _14809_/RESET_B VDD VSS sg13g2_dfrbpq_1
XFILLER_75_1210 VDD VSS sg13g2_decap_4
XFILLER_149_1079 VDD VSS sg13g2_fill_1
XFILLER_51_137 VDD VSS sg13g2_decap_8
XFILLER_17_392 VDD VSS sg13g2_decap_8
X_08330_ _08330_/Y _08329_/B _08484_/C _08329_/Y VDD VSS sg13g2_o21ai_1
XFILLER_177_301 VDD VSS sg13g2_decap_8
XFILLER_178_835 VDD VSS sg13g2_decap_8
X_14099__2173 _14099_/RESET_B VDD VSS sg13g2_tiehi
XFILLER_36_1238 VDD VSS sg13g2_decap_8
X_08261_ _08261_/Y _08675_/A1 _08590_/B _08260_/Y VDD VSS sg13g2_o21ai_1
XFILLER_165_518 VDD VSS sg13g2_decap_8
XFILLER_177_378 VDD VSS sg13g2_decap_8
X_08192_ _08192_/Y _07890_/B _08191_/Y _08000_/X VDD VSS sg13g2_o21ai_1
XFILLER_146_721 VDD VSS sg13g2_decap_8
XFILLER_146_732 VDD VSS sg13g2_fill_2
XFILLER_118_445 VDD VSS sg13g2_fill_1
X_15038__2642 _15038_/RESET_B VDD VSS sg13g2_tiehi
XFILLER_118_467 VDD VSS sg13g2_decap_8
XFILLER_146_776 VDD VSS sg13g2_decap_8
XFILLER_173_562 VDD VSS sg13g2_decap_4
XFILLER_12_1260 VDD VSS sg13g2_decap_8
XFILLER_145_264 VDD VSS sg13g2_decap_8
XFILLER_69_1047 VDD VSS sg13g2_decap_8
XFILLER_105_106 VDD VSS sg13g2_decap_8
XFILLER_173_584 VDD VSS sg13g2_decap_8
XFILLER_10_49 VDD VSS sg13g2_decap_8
XFILLER_156_1039 VDD VSS sg13g2_decap_4
XFILLER_160_245 VDD VSS sg13g2_decap_8
XFILLER_126_49 VDD VSS sg13g2_decap_8
X_14762__3047 _14762_/RESET_B VDD VSS sg13g2_tiehi
XFILLER_0_918 VDD VSS sg13g2_decap_8
XFILLER_138_1473 VDD VSS sg13g2_fill_2
XFILLER_114_684 VDD VSS sg13g2_decap_8
XFILLER_142_993 VDD VSS sg13g2_decap_8
XFILLER_47_1378 VDD VSS sg13g2_decap_8
XFILLER_82_1269 VDD VSS sg13g2_fill_1
XFILLER_102_846 VDD VSS sg13g2_decap_8
XFILLER_59_237 VDD VSS sg13g2_fill_2
XFILLER_19_14 VDD VSS sg13g2_decap_8
X_07976_ _07976_/X _07976_/A _07976_/B _07976_/C VDD VSS sg13g2_or3_1
XFILLER_101_378 VDD VSS sg13g2_decap_8
X_09715_ _14306_/D _09913_/A1 _14306_/Q _09737_/S VDD VSS sg13g2_mux2_1
XFILLER_74_229 VDD VSS sg13g2_decap_8
XFILLER_56_944 VDD VSS sg13g2_decap_8
X_09646_ _14239_/D _10142_/A1 _14239_/Q _09673_/S VDD VSS sg13g2_mux2_1
XFILLER_83_752 VDD VSS sg13g2_decap_8
XFILLER_55_454 VDD VSS sg13g2_decap_8
XFILLER_27_156 VDD VSS sg13g2_decap_8
XFILLER_35_35 VDD VSS sg13g2_decap_8
XFILLER_128_1108 VDD VSS sg13g2_decap_8
XFILLER_15_329 VDD VSS sg13g2_decap_8
X_09577_ _14174_/D _14174_/Q _10074_/A0 _09605_/S VDD VSS sg13g2_mux2_1
XFILLER_58_1430 VDD VSS sg13g2_decap_4
XFILLER_110_1392 VDD VSS sg13g2_decap_4
X_08528_ _08567_/C _07815_/X _07822_/B _07816_/X VDD VSS sg13g2_a21oi_1
XFILLER_51_660 VDD VSS sg13g2_decap_4
XFILLER_93_1387 VDD VSS sg13g2_decap_4
XFILLER_19_1469 VDD VSS sg13g2_decap_4
XFILLER_168_345 VDD VSS sg13g2_decap_4
XFILLER_169_868 VDD VSS sg13g2_decap_8
X_08459_ _08459_/Y _08281_/Y _08270_/B _08035_/X VDD VSS sg13g2_a21oi_1
XFILLER_11_546 VDD VSS sg13g2_decap_8
XFILLER_156_518 VDD VSS sg13g2_decap_8
Xwire415 wire415/X wire416/X VDD VSS sg13g2_buf_2
XFILLER_183_315 VDD VSS sg13g2_decap_8
X_11470_ _11470_/X _14561_/Q _14593_/Q _14625_/Q _14657_/Q _11713_/S0 _11713_/S1 VDD
+ VSS sg13g2_mux4_1
XFILLER_177_890 VDD VSS sg13g2_fill_1
X_15092__2890 _15092_/RESET_B VDD VSS sg13g2_tiehi
XFILLER_7_539 VDD VSS sg13g2_decap_8
XFILLER_167_56 VDD VSS sg13g2_decap_8
X_10421_ _10423_/A _14830_/Q _10421_/B VDD VSS sg13g2_nand2b_1
XFILLER_13_1057 VDD VSS sg13g2_decap_8
XFILLER_87_1114 VDD VSS sg13g2_fill_2
XFILLER_164_551 VDD VSS sg13g2_decap_8
XFILLER_136_253 VDD VSS sg13g2_decap_8
XFILLER_104_1196 VDD VSS sg13g2_decap_8
XFILLER_109_478 VDD VSS sg13g2_decap_8
XFILLER_152_713 VDD VSS sg13g2_decap_8
X_13140_ _13141_/B _13166_/A1 _13136_/X _13139_/Y _13140_/B2 _13135_/Y VDD VSS sg13g2_a221oi_1
XFILLER_124_415 VDD VSS sg13g2_decap_8
XFILLER_125_938 VDD VSS sg13g2_decap_8
X_10352_ _10353_/B _14809_/Q _14810_/Q _10352_/C VDD VSS sg13g2_nand3_1
XFILLER_125_949 VDD VSS sg13g2_fill_1
XFILLER_136_275 VDD VSS sg13g2_fill_2
XFILLER_174_1117 VDD VSS sg13g2_decap_8
XFILLER_152_746 VDD VSS sg13g2_fill_1
X_13797__2475 _13797_/RESET_B VDD VSS sg13g2_tiehi
XFILLER_140_908 VDD VSS sg13g2_decap_8
X_13071_ _13071_/Y _13068_/Y _13069_/Y _13070_/Y VDD VSS sg13g2_a21oi_1
X_10283_ _10286_/A _14788_/Q _10311_/A _14789_/Q VDD VSS sg13g2_a21o_1
XFILLER_3_756 VDD VSS sg13g2_decap_8
X_12022_ _12022_/X _14578_/Q _14610_/Q _12025_/A VDD VSS sg13g2_mux2_1
XFILLER_183_77 VDD VSS sg13g2_decap_8
XFILLER_2_266 VDD VSS sg13g2_decap_8
XFILLER_132_470 VDD VSS sg13g2_fill_2
Xfanout1502 _07989_/B _13600_/C VDD VSS sg13g2_buf_1
XFILLER_78_524 VDD VSS sg13g2_decap_8
XFILLER_26_1418 VDD VSS sg13g2_decap_8
XFILLER_120_621 VDD VSS sg13g2_decap_8
XFILLER_78_535 VDD VSS sg13g2_fill_2
XFILLER_120_665 VDD VSS sg13g2_fill_1
XFILLER_76_42 VDD VSS sg13g2_decap_8
Xfanout570 _12693_/A2 _12777_/A2 VDD VSS sg13g2_buf_1
XFILLER_93_516 VDD VSS sg13g2_decap_8
XFILLER_8_1372 VDD VSS sg13g2_decap_8
X_14177__2095 _14177_/RESET_B VDD VSS sg13g2_tiehi
XFILLER_115_1270 VDD VSS sg13g2_decap_4
XFILLER_19_613 VDD VSS sg13g2_decap_8
Xfanout592 _09939_/A1 _10104_/A0 VDD VSS sg13g2_buf_1
X_13973_ _13973_/Q clkload29/A _13973_/D _13973_/RESET_B VDD VSS sg13g2_dfrbpq_1
XFILLER_98_1210 VDD VSS sg13g2_decap_8
XFILLER_4_1225 VDD VSS sg13g2_decap_8
XFILLER_18_112 VDD VSS sg13g2_decap_8
XFILLER_111_1134 VDD VSS sg13g2_decap_4
XFILLER_58_292 VDD VSS sg13g2_fill_1
XFILLER_19_657 VDD VSS sg13g2_decap_8
X_12924_ _12943_/D _12925_/A _12925_/B _12925_/C VDD VSS sg13g2_and3_1
XFILLER_74_752 VDD VSS sg13g2_decap_8
XFILLER_24_1197 VDD VSS sg13g2_decap_8
XFILLER_34_605 VDD VSS sg13g2_decap_8
XFILLER_73_251 VDD VSS sg13g2_decap_8
XFILLER_185_1246 VDD VSS sg13g2_decap_8
XFILLER_61_413 VDD VSS sg13g2_decap_8
XFILLER_146_1208 VDD VSS sg13g2_decap_8
XFILLER_18_189 VDD VSS sg13g2_decap_8
X_12855_ _12855_/Y _12845_/Y _13048_/B _12854_/Y VDD VSS sg13g2_a21oi_1
XFILLER_33_126 VDD VSS sg13g2_decap_8
X_11806_ _11806_/Y _11806_/A _11806_/B _11898_/C VDD VSS sg13g2_nand3_1
XFILLER_159_301 VDD VSS sg13g2_fill_2
XFILLER_15_863 VDD VSS sg13g2_decap_8
X_12786_ _12786_/X _13850_/Q _13882_/Q _13914_/Q _13946_/Q _12787_/S0 _12787_/S1 VDD
+ VSS sg13g2_mux4_1
XFILLER_92_96 VDD VSS sg13g2_decap_8
XFILLER_30_800 VDD VSS sg13g2_fill_2
X_14525_ _14525_/Q clkload59/A _14525_/D _14525_/RESET_B VDD VSS sg13g2_dfrbpq_1
XFILLER_186_120 VDD VSS sg13g2_decap_8
X_11737_ _11737_/Y _11734_/Y _11736_/X _11625_/C VDD VSS sg13g2_o21ai_1
XFILLER_175_805 VDD VSS sg13g2_decap_8
XFILLER_186_131 VDD VSS sg13g2_decap_8
XFILLER_41_170 VDD VSS sg13g2_decap_8
XFILLER_30_866 VDD VSS sg13g2_decap_8
X_14456_ _14456_/Q _14518_/CLK _14456_/D _14456_/RESET_B VDD VSS sg13g2_dfrbpq_1
XFILLER_35_1260 VDD VSS sg13g2_decap_8
XFILLER_175_849 VDD VSS sg13g2_fill_2
X_11668_ _11668_/Y _12100_/S0 _13928_/Q _12166_/B VDD VSS sg13g2_a21oi_1
XFILLER_128_732 VDD VSS sg13g2_decap_8
X_13407_ _13407_/Y _13407_/A _13440_/B _15091_/Q VDD VSS sg13g2_nand3_1
X_14984__2696 _14984_/RESET_B VDD VSS sg13g2_tiehi
XFILLER_70_1184 VDD VSS sg13g2_fill_2
XFILLER_31_1135 VDD VSS sg13g2_fill_1
XFILLER_174_359 VDD VSS sg13g2_decap_8
X_10619_ _14881_/D _10619_/A _10630_/C _10619_/C VDD VSS sg13g2_and3_1
XFILLER_122_1263 VDD VSS sg13g2_decap_4
X_14387_ _14387_/Q _14739_/CLK _14387_/D _14387_/RESET_B VDD VSS sg13g2_dfrbpq_1
XFILLER_116_905 VDD VSS sg13g2_decap_4
XFILLER_155_551 VDD VSS sg13g2_decap_8
X_11599_ _11599_/Y _11599_/A _11599_/B _11953_/C VDD VSS sg13g2_nand3_1
XFILLER_128_776 VDD VSS sg13g2_decap_8
XFILLER_143_702 VDD VSS sg13g2_fill_1
X_13338_ _13351_/B _13338_/A _13486_/B _13486_/C VDD VSS sg13g2_nand3_1
XFILLER_115_437 VDD VSS sg13g2_decap_8
XFILLER_143_757 VDD VSS sg13g2_decap_8
XFILLER_182_392 VDD VSS sg13g2_decap_8
X_14387__1885 _14387_/RESET_B VDD VSS sg13g2_tiehi
XFILLER_131_919 VDD VSS sg13g2_decap_8
XFILLER_157_1359 VDD VSS sg13g2_decap_4
X_13269_ _13269_/Y _13270_/A _13270_/B _13270_/C VDD VSS sg13g2_a21oi_1
XFILLER_142_256 VDD VSS sg13g2_fill_2
X_15008_ _15008_/Q _15237_/CLK _15008_/D _15008_/RESET_B VDD VSS sg13g2_dfrbpq_1
XFILLER_170_587 VDD VSS sg13g2_decap_8
XFILLER_97_833 VDD VSS sg13g2_decap_8
XFILLER_155_1072 VDD VSS sg13g2_decap_8
X_07830_ _07834_/A _08048_/B _08692_/C VDD VSS sg13g2_nor2b_1
XFILLER_111_654 VDD VSS sg13g2_decap_8
XFILLER_9_1169 VDD VSS sg13g2_decap_8
XFILLER_111_665 VDD VSS sg13g2_fill_2
XFILLER_96_354 VDD VSS sg13g2_decap_8
XFILLER_110_142 VDD VSS sg13g2_decap_8
XFILLER_38_900 VDD VSS sg13g2_decap_8
XFILLER_42_1231 VDD VSS sg13g2_decap_8
X_13842__2430 _13842_/RESET_B VDD VSS sg13g2_tiehi
X_14007__2265 _14007_/RESET_B VDD VSS sg13g2_tiehi
XFILLER_42_1242 VDD VSS sg13g2_fill_2
XFILLER_110_175 VDD VSS sg13g2_decap_8
X_07761_ _14766_/D _07989_/B _15204_/Q VDD VSS sg13g2_and2_1
XFILLER_38_933 VDD VSS sg13g2_fill_2
XFILLER_42_1264 VDD VSS sg13g2_decap_8
X_14858__2921 _14858_/RESET_B VDD VSS sg13g2_tiehi
XFILLER_42_1275 VDD VSS sg13g2_fill_2
X_09500_ _14100_/D _09997_/A0 _14100_/Q _09500_/S VDD VSS sg13g2_mux2_1
XFILLER_49_292 VDD VSS sg13g2_decap_8
XFILLER_37_432 VDD VSS sg13g2_decap_8
XFILLER_37_443 VDD VSS sg13g2_fill_1
X_07692_ _07701_/B _07690_/A _11241_/C _07679_/D VDD VSS sg13g2_a21oi_1
XFILLER_77_1316 VDD VSS sg13g2_decap_8
XFILLER_80_711 VDD VSS sg13g2_decap_8
XFILLER_77_1327 VDD VSS sg13g2_fill_2
XFILLER_53_925 VDD VSS sg13g2_fill_2
X_09431_ _14033_/D _09596_/A1 _14033_/Q _09432_/S VDD VSS sg13g2_mux2_1
XFILLER_64_273 VDD VSS sg13g2_decap_8
XFILLER_168_1477 VDD VSS sg13g2_fill_2
XFILLER_164_1319 VDD VSS sg13g2_fill_2
XFILLER_129_1439 VDD VSS sg13g2_decap_4
XFILLER_53_969 VDD VSS sg13g2_fill_1
X_14222__2050 _14222_/RESET_B VDD VSS sg13g2_tiehi
X_09362_ _13966_/D _10024_/A0 _13966_/Q _09362_/S VDD VSS sg13g2_mux2_1
XFILLER_36_1002 VDD VSS sg13g2_decap_8
X_13875__2397 _13875_/RESET_B VDD VSS sg13g2_tiehi
XFILLER_75_1073 VDD VSS sg13g2_decap_8
X_08313_ _15229_/D _08675_/A1 _08625_/B _08312_/Y VDD VSS sg13g2_o21ai_1
X_09293_ _13901_/D _13901_/Q _10156_/A1 _09298_/S VDD VSS sg13g2_mux2_1
XANTENNA_11 _13714_/Q VDD VSS sg13g2_antennanp
XANTENNA_22 _09137_/A VDD VSS sg13g2_antennanp
XFILLER_123_1016 VDD VSS sg13g2_fill_2
XFILLER_20_343 VDD VSS sg13g2_decap_8
X_08244_ _08244_/Y _08008_/B _08244_/B VDD VSS sg13g2_nand2b_1
XFILLER_123_1038 VDD VSS sg13g2_decap_8
XFILLER_165_315 VDD VSS sg13g2_fill_1
XFILLER_177_175 VDD VSS sg13g2_decap_8
XFILLER_123_1049 VDD VSS sg13g2_fill_1
XFILLER_53_1382 VDD VSS sg13g2_decap_4
XFILLER_14_1344 VDD VSS sg13g2_decap_8
XFILLER_118_231 VDD VSS sg13g2_fill_2
XFILLER_119_754 VDD VSS sg13g2_fill_1
X_08175_ _08175_/Y _08188_/B _08220_/B1 _08221_/A2 VDD VSS sg13g2_o21ai_1
XFILLER_107_916 VDD VSS sg13g2_fill_2
XFILLER_140_1385 VDD VSS sg13g2_decap_8
XFILLER_106_415 VDD VSS sg13g2_decap_8
XFILLER_134_724 VDD VSS sg13g2_decap_8
XFILLER_137_37 VDD VSS sg13g2_decap_4
XFILLER_175_1404 VDD VSS sg13g2_decap_4
XFILLER_180_329 VDD VSS sg13g2_decap_8
XFILLER_49_1418 VDD VSS sg13g2_decap_4
XFILLER_133_234 VDD VSS sg13g2_fill_1
XFILLER_161_543 VDD VSS sg13g2_fill_2
Xclkbuf_leaf_74_clk_i _15200_/CLK clkbuf_leaf_88_clk_i/A VDD VSS sg13g2_buf_8
Xoutput140 mem_axi_wvalid _07662_/Y VDD VSS sg13g2_buf_1
XFILLER_121_407 VDD VSS sg13g2_decap_8
XFILLER_121_418 VDD VSS sg13g2_fill_2
XFILLER_82_1022 VDD VSS sg13g2_decap_4
XFILLER_47_1142 VDD VSS sg13g2_decap_8
XFILLER_173_1150 VDD VSS sg13g2_decap_8
XFILLER_153_14 VDD VSS sg13g2_decap_8
XFILLER_114_481 VDD VSS sg13g2_decap_8
XFILLER_82_1066 VDD VSS sg13g2_decap_8
X_15227__3088 _15227_/RESET_B VDD VSS sg13g2_tiehi
XFILLER_29_900 VDD VSS sg13g2_decap_8
XFILLER_134_1178 VDD VSS sg13g2_decap_8
Xclkbuf_leaf_89_clk_i _15113_/CLK clkbuf_leaf_89_clk_i/A VDD VSS sg13g2_buf_8
XFILLER_25_1462 VDD VSS sg13g2_decap_8
X_07959_ _07959_/Y _07961_/B VDD VSS sg13g2_inv_1
XFILLER_25_1473 VDD VSS sg13g2_fill_2
X_14432__1840 _14432_/RESET_B VDD VSS sg13g2_tiehi
XFILLER_21_1326 VDD VSS sg13g2_decap_8
XFILLER_60_1386 VDD VSS sg13g2_decap_8
X_10970_ _10970_/Y _11027_/B1 _10964_/Y _10969_/Y VDD VSS sg13g2_a21oi_1
XFILLER_71_700 VDD VSS sg13g2_decap_8
XFILLER_28_465 VDD VSS sg13g2_decap_4
XFILLER_16_616 VDD VSS sg13g2_decap_8
XFILLER_71_711 VDD VSS sg13g2_fill_1
X_09629_ _14225_/D _09928_/A1 _14225_/Q _09630_/S VDD VSS sg13g2_mux2_1
XFILLER_71_722 VDD VSS sg13g2_decap_8
Xclkbuf_leaf_12_clk_i _14674_/CLK clkbuf_leaf_4_clk_i/A VDD VSS sg13g2_buf_8
XFILLER_15_126 VDD VSS sg13g2_decap_8
XFILLER_102_40 VDD VSS sg13g2_fill_2
X_12640_ _12640_/X _13840_/Q _13872_/Q _13904_/Q _13936_/Q _12668_/S0 _12668_/S1 VDD
+ VSS sg13g2_mux4_1
XFILLER_71_766 VDD VSS sg13g2_decap_4
XFILLER_71_777 VDD VSS sg13g2_decap_8
XFILLER_70_254 VDD VSS sg13g2_decap_8
XFILLER_58_1260 VDD VSS sg13g2_decap_8
XFILLER_43_468 VDD VSS sg13g2_decap_8
XFILLER_31_608 VDD VSS sg13g2_decap_8
X_13705__2567 _13705_/RESET_B VDD VSS sg13g2_tiehi
XFILLER_93_1173 VDD VSS sg13g2_decap_4
XFILLER_24_682 VDD VSS sg13g2_decap_4
XFILLER_12_833 VDD VSS sg13g2_decap_8
XFILLER_141_2 VDD VSS sg13g2_fill_1
X_12571_ _12571_/X _14571_/Q _14603_/Q _14635_/Q _14667_/Q _12600_/S0 _12600_/S1 VDD
+ VSS sg13g2_mux4_1
XFILLER_106_1214 VDD VSS sg13g2_fill_1
XFILLER_169_665 VDD VSS sg13g2_fill_2
XFILLER_19_1266 VDD VSS sg13g2_decap_8
XFILLER_141_1105 VDD VSS sg13g2_decap_8
X_14310_ _14310_/Q _14662_/CLK _14310_/D _14310_/RESET_B VDD VSS sg13g2_dfrbpq_1
XFILLER_11_343 VDD VSS sg13g2_decap_8
XFILLER_169_687 VDD VSS sg13g2_decap_8
X_11522_ _14965_/D _11502_/A _11723_/A2 _11521_/Y VDD VSS sg13g2_a21o_1
XFILLER_141_1138 VDD VSS sg13g2_decap_8
XFILLER_156_315 VDD VSS sg13g2_decap_8
XFILLER_157_838 VDD VSS sg13g2_decap_8
XFILLER_178_77 VDD VSS sg13g2_decap_8
XFILLER_180_1187 VDD VSS sg13g2_decap_8
Xclkbuf_leaf_27_clk_i _14741_/CLK clkbuf_5_8__f_clk_i/X VDD VSS sg13g2_buf_8
XFILLER_8_826 VDD VSS sg13g2_decap_8
XFILLER_156_326 VDD VSS sg13g2_decap_8
XFILLER_106_1269 VDD VSS sg13g2_decap_4
XFILLER_183_112 VDD VSS sg13g2_decap_8
XFILLER_7_28 VDD VSS sg13g2_decap_8
XFILLER_127_0 VDD VSS sg13g2_decap_8
X_14241_ _14241_/Q _14745_/CLK _14241_/D _14241_/RESET_B VDD VSS sg13g2_dfrbpq_1
Xwire245 wire245/X wire245/A VDD VSS sg13g2_buf_2
XFILLER_7_336 VDD VSS sg13g2_decap_8
XFILLER_184_668 VDD VSS sg13g2_decap_8
X_11453_ _11457_/A _11454_/A _13688_/Q VDD VSS sg13g2_or2_1
XFILLER_171_307 VDD VSS sg13g2_decap_8
XFILLER_137_573 VDD VSS sg13g2_decap_8
X_10404_ _10406_/C _14823_/Q _10413_/B _14824_/Q VDD VSS sg13g2_a21oi_1
XFILLER_183_189 VDD VSS sg13g2_decap_8
X_13920__2352 _13920_/RESET_B VDD VSS sg13g2_tiehi
X_14172_ _14172_/Q _14652_/CLK _14172_/D _14172_/RESET_B VDD VSS sg13g2_dfrbpq_1
X_14680__1592 _14680_/RESET_B VDD VSS sg13g2_tiehi
X_11384_ _11385_/B _11384_/A _13690_/Q VDD VSS sg13g2_xnor2_1
XFILLER_109_286 VDD VSS sg13g2_decap_8
XFILLER_124_212 VDD VSS sg13g2_decap_8
XFILLER_125_757 VDD VSS sg13g2_fill_2
XFILLER_180_852 VDD VSS sg13g2_fill_2
X_13123_ _13123_/Y _14787_/Q _13208_/A2 _13208_/B1 VDD VSS sg13g2_o21ai_1
XFILLER_11_70 VDD VSS sg13g2_decap_8
X_10335_ _10337_/A _14805_/Q _10335_/B VDD VSS sg13g2_nand2b_1
XFILLER_139_1056 VDD VSS sg13g2_decap_8
XFILLER_3_553 VDD VSS sg13g2_decap_8
XFILLER_127_70 VDD VSS sg13g2_decap_8
XFILLER_180_885 VDD VSS sg13g2_fill_1
XFILLER_140_727 VDD VSS sg13g2_decap_8
XFILLER_152_598 VDD VSS sg13g2_decap_8
X_13054_ _13054_/Y _13208_/A2 _13052_/Y _13053_/Y VDD VSS sg13g2_a21oi_1
X_14969__2711 _14969_/RESET_B VDD VSS sg13g2_tiehi
XFILLER_87_30 VDD VSS sg13g2_decap_8
XFILLER_65_1242 VDD VSS sg13g2_decap_8
X_10266_ _14783_/D _10278_/C _10347_/B _10266_/C VDD VSS sg13g2_nor3_1
XFILLER_97_129 VDD VSS sg13g2_decap_8
XFILLER_105_481 VDD VSS sg13g2_decap_8
XFILLER_117_1332 VDD VSS sg13g2_fill_1
X_14264__2008 _14264_/RESET_B VDD VSS sg13g2_tiehi
XFILLER_26_1215 VDD VSS sg13g2_decap_8
XFILLER_65_1275 VDD VSS sg13g2_fill_2
Xfanout1310 _12263_/C fanout1314/X VDD VSS sg13g2_buf_1
X_12005_ _12006_/B _11664_/A _11989_/Y _12004_/Y VDD VSS sg13g2_o21ai_1
Xfanout1321 _11957_/A _11450_/A1 VDD VSS sg13g2_buf_1
XFILLER_6_1309 VDD VSS sg13g2_decap_8
Xfanout1332 _12308_/C _13659_/Q VDD VSS sg13g2_buf_1
Xfanout1343 _11996_/S1 _12038_/B1 VDD VSS sg13g2_buf_1
X_10197_ _15199_/D hold3179/X _15199_/Q _13333_/S VDD VSS sg13g2_mux2_1
XFILLER_61_1139 VDD VSS sg13g2_decap_8
XFILLER_121_985 VDD VSS sg13g2_decap_4
Xfanout1354 _11821_/S1 fanout1364/X VDD VSS sg13g2_buf_1
XFILLER_93_302 VDD VSS sg13g2_fill_2
XFILLER_117_1398 VDD VSS sg13g2_decap_8
Xfanout1365 _11532_/C _12136_/S1 VDD VSS sg13g2_buf_1
Xfanout1376 _12288_/S1 fanout1381/X VDD VSS sg13g2_buf_1
XFILLER_66_538 VDD VSS sg13g2_fill_1
XFILLER_16_7 VDD VSS sg13g2_decap_8
Xfanout1387 _11850_/S0 fanout1395/X VDD VSS sg13g2_buf_1
XFILLER_66_549 VDD VSS sg13g2_fill_1
XFILLER_4_1022 VDD VSS sg13g2_decap_8
Xfanout1398 _11925_/S0 fanout1400/X VDD VSS sg13g2_buf_1
X_13956_ _13956_/Q _14503_/CLK _13956_/D _13956_/RESET_B VDD VSS sg13g2_dfrbpq_1
XFILLER_47_774 VDD VSS sg13g2_decap_8
XFILLER_98_1073 VDD VSS sg13g2_decap_4
XFILLER_59_1024 VDD VSS sg13g2_decap_4
XFILLER_19_487 VDD VSS sg13g2_decap_8
X_12907_ _12909_/C _12943_/A _12925_/C VDD VSS sg13g2_nand2b_1
XFILLER_4_1099 VDD VSS sg13g2_decap_8
X_13887_ _13887_/Q _14540_/CLK _13887_/D _13887_/RESET_B VDD VSS sg13g2_dfrbpq_1
XFILLER_35_958 VDD VSS sg13g2_decap_8
XFILLER_185_1065 VDD VSS sg13g2_decap_4
X_12838_ _12838_/Y _12838_/A _12878_/D VDD VSS sg13g2_nor2b_1
XFILLER_62_777 VDD VSS sg13g2_decap_8
XFILLER_185_1087 VDD VSS sg13g2_decap_4
XFILLER_62_788 VDD VSS sg13g2_fill_2
XFILLER_37_1344 VDD VSS sg13g2_decap_4
XFILLER_37_1355 VDD VSS sg13g2_decap_8
XFILLER_159_131 VDD VSS sg13g2_fill_2
XFILLER_15_693 VDD VSS sg13g2_decap_8
X_12769_ _12769_/X _14713_/Q _14745_/Q _13785_/Q _13817_/Q _12769_/S0 _12769_/S1 VDD
+ VSS sg13g2_mux4_1
XFILLER_124_1336 VDD VSS sg13g2_decap_8
X_14508_ _14508_/Q clkload50/A _14508_/D _14508_/RESET_B VDD VSS sg13g2_dfrbpq_1
XFILLER_174_112 VDD VSS sg13g2_decap_8
XFILLER_30_674 VDD VSS sg13g2_decap_8
Xinput20 input20/X input20/A VDD VSS sg13g2_buf_1
X_14439_ _14439_/Q _14727_/CLK _14439_/D _14439_/RESET_B VDD VSS sg13g2_dfrbpq_1
Xinput31 input31/X input31/A VDD VSS sg13g2_buf_1
Xmax_cap501 fanout500/A _09507_/Y VDD VSS sg13g2_buf_4
Xmax_cap512 _09399_/S _09394_/S VDD VSS sg13g2_buf_4
XFILLER_174_189 VDD VSS sg13g2_decap_8
XFILLER_157_1112 VDD VSS sg13g2_decap_4
X_14510__1762 _14510_/RESET_B VDD VSS sg13g2_tiehi
Xclkbuf_5_1__f_clk_i clkload0/A clkbuf_4_0_0_clk_i/X VDD VSS sg13g2_buf_16
X_09980_ _14563_/D _10079_/A0 _14563_/Q _09998_/S VDD VSS sg13g2_mux2_1
XFILLER_115_256 VDD VSS sg13g2_decap_8
XFILLER_143_565 VDD VSS sg13g2_decap_8
XFILLER_103_407 VDD VSS sg13g2_fill_2
XFILLER_118_1118 VDD VSS sg13g2_decap_8
XFILLER_131_716 VDD VSS sg13g2_decap_8
Xmax_cap578 _11793_/A1 wire579/X VDD VSS sg13g2_buf_4
XFILLER_42_0 VDD VSS sg13g2_decap_8
X_08931_ _08931_/X _08930_/X _12084_/A _08931_/S VDD VSS sg13g2_mux2_1
XFILLER_88_118 VDD VSS sg13g2_decap_8
XFILLER_135_1421 VDD VSS sg13g2_decap_8
XFILLER_170_1301 VDD VSS sg13g2_decap_8
XFILLER_170_395 VDD VSS sg13g2_fill_1
XFILLER_44_1304 VDD VSS sg13g2_decap_8
XFILLER_135_1432 VDD VSS sg13g2_fill_1
XFILLER_97_652 VDD VSS sg13g2_fill_1
XFILLER_69_343 VDD VSS sg13g2_decap_8
X_08862_ _08862_/X _15029_/Q _14933_/Q _10675_/A VDD VSS sg13g2_mux2_1
XFILLER_83_1386 VDD VSS sg13g2_decap_8
XFILLER_112_974 VDD VSS sg13g2_decap_4
XFILLER_170_1345 VDD VSS sg13g2_decap_8
XFILLER_83_1397 VDD VSS sg13g2_fill_1
XFILLER_44_1348 VDD VSS sg13g2_fill_1
XFILLER_57_516 VDD VSS sg13g2_decap_8
XFILLER_112_996 VDD VSS sg13g2_decap_8
X_07813_ _07954_/B _08522_/A _08548_/B VDD VSS sg13g2_and2_1
X_08793_ _13682_/D _08790_/Y _08791_/Y _08792_/Y VDD VSS sg13g2_a21oi_1
XFILLER_96_184 VDD VSS sg13g2_decap_8
XFILLER_38_730 VDD VSS sg13g2_decap_8
X_07744_ _07746_/C _07748_/B _07744_/B _07744_/C _07744_/D VDD VSS sg13g2_nand4_1
XFILLER_77_1102 VDD VSS sg13g2_fill_2
X_07675_ _07677_/C _15078_/Q _15081_/Q VDD VSS sg13g2_nor2_1
XFILLER_52_210 VDD VSS sg13g2_decap_8
XFILLER_129_1214 VDD VSS sg13g2_decap_8
XFILLER_80_541 VDD VSS sg13g2_decap_8
XFILLER_53_755 VDD VSS sg13g2_decap_8
X_09414_ _14016_/D _10076_/A0 _14016_/Q _09437_/S VDD VSS sg13g2_mux2_1
XFILLER_38_1119 VDD VSS sg13g2_decap_8
XFILLER_0_1464 VDD VSS sg13g2_decap_8
XFILLER_20_1392 VDD VSS sg13g2_decap_8
XFILLER_40_405 VDD VSS sg13g2_fill_1
XFILLER_25_479 VDD VSS sg13g2_decap_8
XFILLER_164_1149 VDD VSS sg13g2_decap_8
XFILLER_179_952 VDD VSS sg13g2_decap_8
XFILLER_55_1433 VDD VSS sg13g2_decap_8
X_09345_ _13949_/D _09842_/A1 _13949_/Q _09362_/S VDD VSS sg13g2_mux2_1
XFILLER_52_287 VDD VSS sg13g2_decap_8
XFILLER_40_438 VDD VSS sg13g2_decap_4
XFILLER_90_1346 VDD VSS sg13g2_decap_8
XFILLER_55_1466 VDD VSS sg13g2_decap_8
XFILLER_178_462 VDD VSS sg13g2_decap_8
XFILLER_55_1477 VDD VSS sg13g2_fill_2
XFILLER_32_14 VDD VSS sg13g2_decap_8
XFILLER_166_624 VDD VSS sg13g2_fill_1
XFILLER_20_140 VDD VSS sg13g2_decap_8
X_09276_ _13884_/D _13884_/Q _09907_/A1 _09294_/S VDD VSS sg13g2_mux2_1
XFILLER_148_14 VDD VSS sg13g2_decap_8
XFILLER_166_657 VDD VSS sg13g2_fill_2
X_08227_ _08227_/Y _14963_/Q _14995_/Q _08247_/C VDD VSS sg13g2_a21oi_1
XFILLER_120_7 VDD VSS sg13g2_decap_4
XFILLER_14_1141 VDD VSS sg13g2_decap_8
XFILLER_181_616 VDD VSS sg13g2_decap_8
XFILLER_147_871 VDD VSS sg13g2_fill_1
XFILLER_107_713 VDD VSS sg13g2_fill_1
X_08158_ _08158_/X _08005_/X _08019_/B _08018_/X _08031_/C _08070_/C _08236_/S VDD
+ VSS sg13g2_mux4_1
XFILLER_180_126 VDD VSS sg13g2_decap_8
XFILLER_107_757 VDD VSS sg13g2_decap_8
X_08089_ _08090_/C _07900_/B _07903_/B _07884_/A _13602_/A VDD VSS sg13g2_a22oi_1
XFILLER_161_351 VDD VSS sg13g2_decap_8
XFILLER_134_576 VDD VSS sg13g2_decap_8
XFILLER_164_35 VDD VSS sg13g2_decap_8
XFILLER_175_1267 VDD VSS sg13g2_decap_8
XFILLER_162_896 VDD VSS sg13g2_decap_4
X_10120_ _14698_/D _10153_/A1 _14698_/Q _10120_/S VDD VSS sg13g2_mux2_1
XFILLER_62_1415 VDD VSS sg13g2_decap_8
X_10051_ _14632_/D _10051_/A0 _14632_/Q _10060_/S VDD VSS sg13g2_mux2_1
XFILLER_88_652 VDD VSS sg13g2_decap_8
XFILLER_0_567 VDD VSS sg13g2_decap_8
XFILLER_62_1448 VDD VSS sg13g2_fill_2
XFILLER_48_505 VDD VSS sg13g2_decap_4
XFILLER_103_985 VDD VSS sg13g2_decap_8
XFILLER_88_685 VDD VSS sg13g2_decap_4
XFILLER_75_302 VDD VSS sg13g2_fill_2
XFILLER_29_730 VDD VSS sg13g2_decap_8
XFILLER_180_56 VDD VSS sg13g2_decap_8
XFILLER_21_1123 VDD VSS sg13g2_decap_8
X_13810_ _13810_/Q clkload15/A _13810_/D _13810_/RESET_B VDD VSS sg13g2_dfrbpq_1
X_14790_ _14790_/Q clkload62/A _14790_/D _14790_/RESET_B VDD VSS sg13g2_dfrbpq_1
XFILLER_91_828 VDD VSS sg13g2_decap_8
XFILLER_75_379 VDD VSS sg13g2_fill_1
XFILLER_60_1194 VDD VSS sg13g2_decap_8
XFILLER_5_1386 VDD VSS sg13g2_decap_8
XFILLER_28_251 VDD VSS sg13g2_fill_1
XFILLER_56_571 VDD VSS sg13g2_decap_8
XFILLER_16_413 VDD VSS sg13g2_decap_8
XFILLER_1_1239 VDD VSS sg13g2_decap_8
X_13741_ _13741_/Q clkload11/A _13741_/D _13741_/RESET_B VDD VSS sg13g2_dfrbpq_1
XFILLER_84_891 VDD VSS sg13g2_fill_2
XFILLER_147_1303 VDD VSS sg13g2_decap_4
X_10953_ _10953_/Y _10954_/C _10965_/C _11188_/C1 VDD VSS sg13g2_o21ai_1
X_13938__2334 _13938_/RESET_B VDD VSS sg13g2_tiehi
X_14698__1574 _14698_/RESET_B VDD VSS sg13g2_tiehi
X_13672_ _13672_/Q clkload83/A _13672_/D _13672_/RESET_B VDD VSS sg13g2_dfrbpq_1
XFILLER_43_254 VDD VSS sg13g2_decap_4
X_10884_ _10884_/Y _10823_/B _10878_/Y _07751_/B VDD VSS sg13g2_o21ai_1
XFILLER_44_788 VDD VSS sg13g2_fill_2
X_12623_ _12623_/X _12622_/X _12621_/X _12748_/S VDD VSS sg13g2_mux2_1
XFILLER_31_427 VDD VSS sg13g2_decap_8
XFILLER_58_1090 VDD VSS sg13g2_decap_8
XFILLER_12_630 VDD VSS sg13g2_decap_8
X_14842__2953 _14842_/RESET_B VDD VSS sg13g2_tiehi
XFILLER_157_613 VDD VSS sg13g2_decap_8
XFILLER_184_410 VDD VSS sg13g2_decap_8
X_12554_ _12555_/B _13679_/Q _12693_/A2 _12553_/X _12400_/A _12749_/C1 VDD VSS sg13g2_a221oi_1
XFILLER_40_972 VDD VSS sg13g2_decap_8
XFILLER_11_140 VDD VSS sg13g2_decap_8
XFILLER_184_421 VDD VSS sg13g2_fill_2
XFILLER_8_623 VDD VSS sg13g2_decap_8
XFILLER_156_134 VDD VSS sg13g2_decap_4
X_11505_ _11505_/X _11636_/A _11506_/B VDD VSS sg13g2_and2_1
X_12485_ _14998_/D _12485_/A _12485_/B VDD VSS sg13g2_nor2_1
XFILLER_7_133 VDD VSS sg13g2_decap_8
X_14224_ _14224_/Q clkload19/A _14224_/D _14224_/RESET_B VDD VSS sg13g2_dfrbpq_1
X_11436_ _11436_/X _14368_/Q _14400_/Q _14464_/Q _14496_/Q _11489_/S0 _11489_/S1 VDD
+ VSS sg13g2_mux4_1
XFILLER_125_510 VDD VSS sg13g2_fill_2
XFILLER_22_91 VDD VSS sg13g2_decap_8
XFILLER_171_126 VDD VSS sg13g2_decap_8
X_14875__2887 _14875_/RESET_B VDD VSS sg13g2_tiehi
XFILLER_67_1315 VDD VSS sg13g2_decap_4
X_14155_ _14155_/Q clkload11/A _14155_/D _14155_/RESET_B VDD VSS sg13g2_dfrbpq_1
XFILLER_4_840 VDD VSS sg13g2_decap_8
X_11367_ _11367_/Y _11362_/Y _11363_/Y _11900_/B VDD VSS sg13g2_a21oi_1
XFILLER_153_874 VDD VSS sg13g2_decap_8
XFILLER_180_660 VDD VSS sg13g2_decap_8
XFILLER_119_1427 VDD VSS sg13g2_decap_8
XFILLER_112_204 VDD VSS sg13g2_fill_2
XFILLER_154_1318 VDD VSS sg13g2_decap_8
XFILLER_180_682 VDD VSS sg13g2_decap_8
X_13106_ _13106_/Y _14850_/Q _13150_/B VDD VSS sg13g2_nand2_1
XFILLER_98_427 VDD VSS sg13g2_decap_4
XFILLER_3_350 VDD VSS sg13g2_decap_8
XFILLER_113_738 VDD VSS sg13g2_decap_8
X_10318_ _10319_/C _10342_/A _14799_/Q _10327_/B _10327_/C VDD VSS sg13g2_and4_1
XFILLER_98_84 VDD VSS sg13g2_decap_8
XFILLER_152_384 VDD VSS sg13g2_fill_2
X_14086_ _14086_/Q clkload18/A _14086_/D _14086_/RESET_B VDD VSS sg13g2_dfrbpq_1
XFILLER_106_790 VDD VSS sg13g2_decap_8
X_11298_ _11298_/Y _11212_/S _13917_/Q _11894_/B VDD VSS sg13g2_a21oi_1
X_13037_ _13037_/Y _14909_/Q _13678_/Q VDD VSS sg13g2_nor2_1
XFILLER_26_1023 VDD VSS sg13g2_fill_2
X_10249_ _10251_/A _14778_/Q _10255_/D _10350_/C VDD VSS sg13g2_o21ai_1
XFILLER_121_760 VDD VSS sg13g2_decap_8
XFILLER_6_1106 VDD VSS sg13g2_decap_8
Xfanout1140 _08009_/S fanout1144/X VDD VSS sg13g2_buf_1
XFILLER_78_162 VDD VSS sg13g2_decap_4
Xfanout1151 _12300_/A _14988_/Q VDD VSS sg13g2_buf_1
Xfanout1162 _12128_/A _14983_/Q VDD VSS sg13g2_buf_1
XFILLER_67_858 VDD VSS sg13g2_fill_1
Xfanout1173 _07812_/B _11983_/A VDD VSS sg13g2_buf_1
XFILLER_43_1370 VDD VSS sg13g2_decap_8
Xfanout1184 _08510_/A2 _11865_/A VDD VSS sg13g2_buf_1
Xfanout1195 _11770_/A _14973_/Q VDD VSS sg13g2_buf_1
X_14988_ _14988_/Q clkload70/A _14988_/D _14988_/RESET_B VDD VSS sg13g2_dfrbpq_1
XFILLER_94_699 VDD VSS sg13g2_decap_8
XFILLER_47_560 VDD VSS sg13g2_decap_8
XFILLER_19_273 VDD VSS sg13g2_decap_8
X_13939_ _13939_/Q clkload41/A _13939_/D _13939_/RESET_B VDD VSS sg13g2_dfrbpq_1
XFILLER_62_530 VDD VSS sg13g2_decap_8
XFILLER_165_1425 VDD VSS sg13g2_decap_8
X_14528__1744 _14528_/RESET_B VDD VSS sg13g2_tiehi
XFILLER_50_703 VDD VSS sg13g2_fill_1
XFILLER_90_883 VDD VSS sg13g2_decap_4
XFILLER_16_980 VDD VSS sg13g2_decap_8
XFILLER_35_799 VDD VSS sg13g2_decap_8
XFILLER_179_259 VDD VSS sg13g2_decap_8
XFILLER_34_298 VDD VSS sg13g2_decap_4
XFILLER_22_438 VDD VSS sg13g2_decap_8
XFILLER_15_490 VDD VSS sg13g2_decap_8
XFILLER_176_900 VDD VSS sg13g2_fill_1
XFILLER_50_769 VDD VSS sg13g2_fill_1
XFILLER_176_922 VDD VSS sg13g2_decap_4
X_09130_ _09130_/Y _13200_/A _09157_/C _09129_/Y VDD VSS sg13g2_a21oi_1
X_13792__2480 _13792_/RESET_B VDD VSS sg13g2_tiehi
XFILLER_72_1065 VDD VSS sg13g2_fill_1
XFILLER_124_1144 VDD VSS sg13g2_decap_8
XFILLER_148_635 VDD VSS sg13g2_decap_4
XFILLER_175_432 VDD VSS sg13g2_decap_8
X_15226__3087 _15226_/RESET_B VDD VSS sg13g2_tiehi
XFILLER_72_1087 VDD VSS sg13g2_decap_8
X_09061_ _09061_/Y _13064_/A _09089_/C _09090_/A VDD VSS sg13g2_o21ai_1
XFILLER_159_1207 VDD VSS sg13g2_decap_4
X_08012_ _08012_/Y _08054_/B _12152_/A VDD VSS sg13g2_nand2_1
XFILLER_50_1374 VDD VSS sg13g2_fill_2
XFILLER_116_510 VDD VSS sg13g2_fill_2
XFILLER_129_893 VDD VSS sg13g2_decap_8
XFILLER_11_1358 VDD VSS sg13g2_decap_8
XFILLER_116_543 VDD VSS sg13g2_fill_2
XFILLER_116_576 VDD VSS sg13g2_decap_4
XFILLER_144_885 VDD VSS sg13g2_decap_8
XFILLER_171_671 VDD VSS sg13g2_decap_8
XFILLER_89_416 VDD VSS sg13g2_decap_8
XFILLER_116_598 VDD VSS sg13g2_decap_8
X_09963_ _14547_/D _14547_/Q _10029_/A0 _09965_/S VDD VSS sg13g2_mux2_1
XFILLER_83_1150 VDD VSS sg13g2_decap_8
XFILLER_134_16 VDD VSS sg13g2_fill_1
X_08914_ _08914_/Y _08912_/Y _08913_/Y _08937_/S VDD VSS sg13g2_a21oi_1
XFILLER_134_27 VDD VSS sg13g2_decap_8
XFILLER_170_1120 VDD VSS sg13g2_decap_8
X_09894_ _14480_/D _09927_/A1 _14480_/Q _09896_/S VDD VSS sg13g2_mux2_1
XFILLER_83_1183 VDD VSS sg13g2_decap_8
XFILLER_131_1104 VDD VSS sg13g2_fill_2
XFILLER_100_922 VDD VSS sg13g2_decap_8
XFILLER_135_1273 VDD VSS sg13g2_decap_8
XFILLER_97_482 VDD VSS sg13g2_decap_8
XFILLER_131_1115 VDD VSS sg13g2_fill_1
X_08845_ _08845_/Y _15024_/Q _08848_/A _08844_/Y VDD VSS sg13g2_a21oi_1
XFILLER_131_1126 VDD VSS sg13g2_decap_8
XFILLER_97_493 VDD VSS sg13g2_fill_2
XFILLER_111_281 VDD VSS sg13g2_decap_4
XFILLER_170_1197 VDD VSS sg13g2_fill_1
XFILLER_85_655 VDD VSS sg13g2_decap_8
XFILLER_84_132 VDD VSS sg13g2_decap_8
XFILLER_27_14 VDD VSS sg13g2_decap_8
XFILLER_100_988 VDD VSS sg13g2_fill_2
X_08776_ _08776_/Y _08788_/A1 _15116_/Q _15185_/Q _07719_/X VDD VSS sg13g2_a22oi_1
XFILLER_22_1443 VDD VSS sg13g2_decap_8
XFILLER_26_700 VDD VSS sg13g2_decap_8
XFILLER_85_699 VDD VSS sg13g2_decap_4
XFILLER_72_316 VDD VSS sg13g2_decap_8
X_07727_ _07727_/Y _13206_/B _07727_/B _07727_/C VDD VSS sg13g2_nor3_1
XFILLER_129_1000 VDD VSS sg13g2_decap_4
XFILLER_168_1060 VDD VSS sg13g2_decap_8
XFILLER_168_7 VDD VSS sg13g2_decap_8
XFILLER_26_766 VDD VSS sg13g2_decap_8
XFILLER_129_1022 VDD VSS sg13g2_decap_8
XFILLER_14_917 VDD VSS sg13g2_decap_8
X_07658_ _07658_/X _14749_/Q _10210_/D VDD VSS sg13g2_and2_1
XFILLER_0_1261 VDD VSS sg13g2_decap_8
XFILLER_80_360 VDD VSS sg13g2_decap_8
XFILLER_40_202 VDD VSS sg13g2_decap_8
XFILLER_25_276 VDD VSS sg13g2_decap_8
XFILLER_13_427 VDD VSS sg13g2_decap_8
XFILLER_43_35 VDD VSS sg13g2_decap_8
XFILLER_90_1132 VDD VSS sg13g2_decap_8
XFILLER_55_1252 VDD VSS sg13g2_decap_8
XFILLER_142_1211 VDD VSS sg13g2_fill_2
XFILLER_159_35 VDD VSS sg13g2_decap_8
XFILLER_167_922 VDD VSS sg13g2_decap_8
XFILLER_107_1342 VDD VSS sg13g2_decap_8
XFILLER_179_782 VDD VSS sg13g2_decap_4
X_09328_ _13935_/D _10158_/A1 _13935_/Q _09331_/S VDD VSS sg13g2_mux2_1
XFILLER_90_1154 VDD VSS sg13g2_decap_8
X_14382__1890 _14382_/RESET_B VDD VSS sg13g2_tiehi
XFILLER_107_1364 VDD VSS sg13g2_decap_8
XFILLER_21_460 VDD VSS sg13g2_fill_2
XFILLER_16_1258 VDD VSS sg13g2_decap_8
XFILLER_103_1217 VDD VSS sg13g2_fill_1
XFILLER_138_134 VDD VSS sg13g2_decap_8
XFILLER_103_1228 VDD VSS sg13g2_decap_8
X_09259_ _13868_/D _13868_/Q _09923_/A1 _09261_/S VDD VSS sg13g2_mux2_1
XFILLER_138_167 VDD VSS sg13g2_decap_8
XFILLER_126_318 VDD VSS sg13g2_decap_8
XFILLER_142_1299 VDD VSS sg13g2_decap_8
XFILLER_181_413 VDD VSS sg13g2_decap_8
X_12270_ _14986_/D _12270_/A _12270_/B VDD VSS sg13g2_nor2_1
XFILLER_5_637 VDD VSS sg13g2_decap_8
XFILLER_107_532 VDD VSS sg13g2_decap_8
XFILLER_175_56 VDD VSS sg13g2_decap_8
X_11221_ _11222_/B _13723_/Q _14075_/Q _14427_/Q _14523_/Q _11212_/S _11366_/C VDD
+ VSS sg13g2_mux4_1
XFILLER_49_1012 VDD VSS sg13g2_decap_8
XFILLER_4_147 VDD VSS sg13g2_decap_8
X_14002__2270 _14002_/RESET_B VDD VSS sg13g2_tiehi
XFILLER_122_513 VDD VSS sg13g2_decap_8
XFILLER_134_373 VDD VSS sg13g2_decap_8
XFILLER_150_822 VDD VSS sg13g2_fill_1
XFILLER_162_682 VDD VSS sg13g2_decap_8
XFILLER_107_598 VDD VSS sg13g2_decap_8
X_11152_ _11152_/Y _11164_/B _11152_/B VDD VSS sg13g2_xnor2_1
XFILLER_49_1089 VDD VSS sg13g2_decap_8
XFILLER_122_546 VDD VSS sg13g2_decap_8
XFILLER_150_855 VDD VSS sg13g2_decap_8
XFILLER_27_1321 VDD VSS sg13g2_decap_8
XFILLER_1_854 VDD VSS sg13g2_decap_8
X_10103_ _10103_/Y _10105_/C _10105_/D _10105_/B VDD VSS sg13g2_nand3_1
X_14606__1666 _14606_/RESET_B VDD VSS sg13g2_tiehi
X_11083_ _14947_/D _11082_/Y _11081_/Y _11074_/Y VDD VSS sg13g2_o21ai_1
XFILLER_49_803 VDD VSS sg13g2_decap_8
XFILLER_0_364 VDD VSS sg13g2_decap_8
XFILLER_62_1256 VDD VSS sg13g2_decap_8
X_14911_ _14911_/Q clkload56/A _14911_/D _14911_/RESET_B VDD VSS sg13g2_dfrbpq_1
X_10034_ _14616_/D _10067_/A0 _14616_/Q _10035_/S VDD VSS sg13g2_mux2_1
XFILLER_48_313 VDD VSS sg13g2_fill_2
XFILLER_23_1218 VDD VSS sg13g2_decap_8
XFILLER_88_493 VDD VSS sg13g2_decap_8
XFILLER_76_633 VDD VSS sg13g2_decap_8
XFILLER_27_1398 VDD VSS sg13g2_decap_8
XFILLER_114_1368 VDD VSS sg13g2_decap_8
XFILLER_76_666 VDD VSS sg13g2_fill_1
X_14842_ _14842_/Q clkload68/A _14842_/D _14842_/RESET_B VDD VSS sg13g2_dfrbpq_1
XFILLER_64_839 VDD VSS sg13g2_decap_8
XFILLER_5_1183 VDD VSS sg13g2_decap_8
XFILLER_75_187 VDD VSS sg13g2_decap_8
XFILLER_112_1081 VDD VSS sg13g2_fill_1
XFILLER_16_210 VDD VSS sg13g2_decap_8
XFILLER_91_647 VDD VSS sg13g2_decap_8
XFILLER_90_124 VDD VSS sg13g2_decap_4
XFILLER_84_75 VDD VSS sg13g2_decap_8
XFILLER_1_1036 VDD VSS sg13g2_decap_8
X_14773_ _14773_/Q _15113_/CLK _14773_/D _14773_/RESET_B VDD VSS sg13g2_dfrbpq_1
X_11985_ _11988_/B _12055_/A _11917_/A _11986_/B VDD VSS sg13g2_o21ai_1
XFILLER_84_86 VDD VSS sg13g2_fill_2
XFILLER_91_669 VDD VSS sg13g2_decap_8
XFILLER_147_1111 VDD VSS sg13g2_decap_8
XFILLER_56_1005 VDD VSS sg13g2_decap_4
XFILLER_17_777 VDD VSS sg13g2_decap_8
X_13724_ _13724_/Q _14652_/CLK _13724_/D _13724_/RESET_B VDD VSS sg13g2_dfrbpq_1
X_10936_ _10965_/C wire276/X _10936_/B _10936_/C _10936_/D VDD VSS sg13g2_nand4_1
XFILLER_17_91 VDD VSS sg13g2_decap_8
XFILLER_186_1182 VDD VSS sg13g2_decap_8
XFILLER_186_1193 VDD VSS sg13g2_decap_8
XFILLER_32_725 VDD VSS sg13g2_decap_8
XFILLER_108_1117 VDD VSS sg13g2_decap_8
XFILLER_140_81 VDD VSS sg13g2_decap_8
XFILLER_16_287 VDD VSS sg13g2_decap_8
XFILLER_140_92 VDD VSS sg13g2_fill_2
XFILLER_147_1177 VDD VSS sg13g2_decap_8
XFILLER_177_708 VDD VSS sg13g2_fill_1
X_13655_ _15121_/D _15191_/D _15121_/Q _13656_/S VDD VSS sg13g2_mux2_1
X_10867_ _10867_/Y _10890_/A _10868_/C _10890_/B VDD VSS sg13g2_o21ai_1
XFILLER_147_1188 VDD VSS sg13g2_fill_2
XFILLER_73_1352 VDD VSS sg13g2_decap_4
XFILLER_9_910 VDD VSS sg13g2_decap_8
XFILLER_34_1314 VDD VSS sg13g2_fill_1
X_12606_ _12606_/X _14253_/Q _14285_/Q _14317_/Q _14349_/Q _12606_/S0 _12606_/S1 VDD
+ VSS sg13g2_mux4_1
XFILLER_31_268 VDD VSS sg13g2_decap_8
X_13586_ _13586_/Y _15002_/Q _13555_/B _13569_/S _15018_/Q _13537_/X VDD VSS sg13g2_a221oi_1
XFILLER_83_7 VDD VSS sg13g2_decap_8
XFILLER_34_1336 VDD VSS sg13g2_decap_8
XFILLER_157_421 VDD VSS sg13g2_decap_8
XFILLER_185_730 VDD VSS sg13g2_decap_8
X_10798_ _10798_/X _10807_/B _10798_/B VDD VSS sg13g2_xor2_1
XFILLER_13_994 VDD VSS sg13g2_decap_8
XFILLER_8_420 VDD VSS sg13g2_decap_8
XFILLER_160_1355 VDD VSS sg13g2_fill_2
XFILLER_185_752 VDD VSS sg13g2_decap_8
XFILLER_118_808 VDD VSS sg13g2_decap_8
X_12537_ _12537_/X _12534_/X _12533_/X _12530_/X _12529_/X wire853/X _12664_/S VDD
+ VSS sg13g2_mux4_1
XFILLER_118_819 VDD VSS sg13g2_fill_2
XFILLER_9_987 VDD VSS sg13g2_decap_8
XFILLER_172_424 VDD VSS sg13g2_fill_1
XFILLER_184_284 VDD VSS sg13g2_decap_8
X_12468_ _12468_/X _12466_/X _12465_/X _12462_/X _12461_/X _12775_/S1 _12720_/S VDD
+ VSS sg13g2_mux4_1
XFILLER_138_690 VDD VSS sg13g2_decap_8
XFILLER_8_497 VDD VSS sg13g2_decap_8
X_14207_ _14207_/Q clkload48/A _14207_/D _14207_/RESET_B VDD VSS sg13g2_dfrbpq_1
X_11419_ _11420_/B _11419_/A _11419_/B _11419_/C VDD VSS sg13g2_nand3_1
XFILLER_172_479 VDD VSS sg13g2_decap_8
X_15187_ _15187_/Q clkload82/A _15187_/D _15187_/RESET_B VDD VSS sg13g2_dfrbpq_1
X_12399_ _12400_/B _12397_/X _12398_/X _12790_/S VDD VSS sg13g2_mux2_1
XFILLER_113_524 VDD VSS sg13g2_decap_8
X_14138_ _14138_/Q clkload51/A _14138_/D _14138_/RESET_B VDD VSS sg13g2_dfrbpq_1
XFILLER_152_181 VDD VSS sg13g2_fill_1
XFILLER_180_490 VDD VSS sg13g2_decap_8
XFILLER_154_1137 VDD VSS sg13g2_decap_8
XFILLER_98_257 VDD VSS sg13g2_decap_8
X_14069_ _14069_/Q clkload29/A _14069_/D _14069_/RESET_B VDD VSS sg13g2_dfrbpq_1
XFILLER_86_419 VDD VSS sg13g2_fill_2
XFILLER_141_899 VDD VSS sg13g2_decap_4
XFILLER_140_387 VDD VSS sg13g2_decap_8
XFILLER_140_398 VDD VSS sg13g2_decap_8
XFILLER_95_931 VDD VSS sg13g2_fill_2
XFILLER_66_132 VDD VSS sg13g2_fill_1
X_13672__2621 _13672_/RESET_B VDD VSS sg13g2_tiehi
X_08630_ _08630_/Y _08649_/S _08629_/Y _08628_/Y VDD VSS sg13g2_o21ai_1
XFILLER_67_666 VDD VSS sg13g2_fill_1
X_13700__2572 _13700_/RESET_B VDD VSS sg13g2_tiehi
XFILLER_27_519 VDD VSS sg13g2_decap_8
XFILLER_94_474 VDD VSS sg13g2_decap_8
XFILLER_130_1170 VDD VSS sg13g2_decap_8
X_08561_ _08561_/Y _08659_/A _08659_/B _08561_/C VDD VSS sg13g2_nor3_1
XFILLER_78_1252 VDD VSS sg13g2_decap_4
XFILLER_169_1380 VDD VSS sg13g2_decap_8
XFILLER_165_1233 VDD VSS sg13g2_fill_1
X_08492_ _08574_/C _07950_/A _07949_/B _07807_/C _08476_/A VDD VSS sg13g2_a22oi_1
X_14044__2228 _14044_/RESET_B VDD VSS sg13g2_tiehi
XFILLER_35_574 VDD VSS sg13g2_fill_1
XFILLER_39_1258 VDD VSS sg13g2_fill_2
XFILLER_168_708 VDD VSS sg13g2_fill_2
XFILLER_22_224 VDD VSS sg13g2_decap_8
XFILLER_50_555 VDD VSS sg13g2_decap_8
XFILLER_91_1474 VDD VSS sg13g2_fill_1
XFILLER_176_730 VDD VSS sg13g2_decap_8
X_09113_ _09113_/Y _15242_/Q _09147_/B VDD VSS sg13g2_nand2b_1
XFILLER_13_49 VDD VSS sg13g2_decap_8
XFILLER_109_819 VDD VSS sg13g2_decap_8
XFILLER_149_988 VDD VSS sg13g2_decap_8
X_14956__2725 _14956_/RESET_B VDD VSS sg13g2_tiehi
XFILLER_175_273 VDD VSS sg13g2_decap_8
X_09044_ _09044_/X _09057_/A _09044_/B _09056_/C VDD VSS sg13g2_or3_1
XFILLER_159_1015 VDD VSS sg13g2_decap_8
XFILLER_117_830 VDD VSS sg13g2_fill_2
XFILLER_15_1291 VDD VSS sg13g2_decap_8
XFILLER_163_457 VDD VSS sg13g2_decap_8
XFILLER_11_1155 VDD VSS sg13g2_decap_8
XFILLER_102_1283 VDD VSS sg13g2_decap_8
XFILLER_104_513 VDD VSS sg13g2_decap_8
XFILLER_89_224 VDD VSS sg13g2_decap_8
XFILLER_46_1218 VDD VSS sg13g2_decap_8
Xfanout900 _12759_/S1 _12757_/S1 VDD VSS sg13g2_buf_1
XFILLER_137_1368 VDD VSS sg13g2_fill_2
X_14997__2683 _14997_/RESET_B VDD VSS sg13g2_tiehi
Xfanout911 _12425_/S1 fanout912/X VDD VSS sg13g2_buf_1
X_09946_ _14530_/D _14530_/Q _09946_/A1 _09965_/S VDD VSS sg13g2_mux2_1
Xfanout933 _12411_/S0 _12588_/S0 VDD VSS sg13g2_buf_1
Xfanout944 _12787_/S0 _12702_/S0 VDD VSS sg13g2_buf_1
XFILLER_98_780 VDD VSS sg13g2_decap_8
Xfanout955 _12689_/S0 _12757_/S0 VDD VSS sg13g2_buf_1
XFILLER_86_931 VDD VSS sg13g2_decap_8
Xfanout966 fanout966/X _12745_/S0 VDD VSS sg13g2_buf_1
XFILLER_38_35 VDD VSS sg13g2_decap_8
XFILLER_161_14 VDD VSS sg13g2_decap_8
Xfanout977 _13289_/C _15208_/Q VDD VSS sg13g2_buf_1
X_09877_ _14463_/D _10109_/A0 _14463_/Q _09904_/S VDD VSS sg13g2_mux2_1
XFILLER_58_644 VDD VSS sg13g2_decap_8
XFILLER_135_1092 VDD VSS sg13g2_decap_8
Xfanout988 _13300_/C _13293_/C VDD VSS sg13g2_buf_1
XFILLER_100_752 VDD VSS sg13g2_fill_2
Xfanout999 _12899_/C _12936_/B VDD VSS sg13g2_buf_1
XFILLER_38_79 VDD VSS sg13g2_fill_1
XFILLER_100_774 VDD VSS sg13g2_decap_8
XFILLER_161_58 VDD VSS sg13g2_fill_1
X_08828_ _08828_/Y _14766_/Q _13281_/B VDD VSS sg13g2_nor2_1
XFILLER_57_154 VDD VSS sg13g2_decap_8
XFILLER_161_69 VDD VSS sg13g2_decap_8
XFILLER_22_1240 VDD VSS sg13g2_decap_8
XFILLER_6_1470 VDD VSS sg13g2_decap_4
XFILLER_2_1323 VDD VSS sg13g2_decap_8
XFILLER_73_647 VDD VSS sg13g2_fill_1
X_08759_ _13671_/D _08765_/A1 _08757_/Y _08758_/Y VDD VSS sg13g2_a21oi_1
XFILLER_73_669 VDD VSS sg13g2_fill_1
XFILLER_72_157 VDD VSS sg13g2_fill_1
XFILLER_26_552 VDD VSS sg13g2_fill_2
X_11770_ _11910_/A _11770_/A _13064_/B VDD VSS sg13g2_xnor2_1
XFILLER_72_168 VDD VSS sg13g2_decap_4
XFILLER_54_872 VDD VSS sg13g2_decap_8
XFILLER_14_714 VDD VSS sg13g2_decap_8
XFILLER_183_1333 VDD VSS sg13g2_decap_8
XFILLER_54_56 VDD VSS sg13g2_decap_4
XFILLER_26_596 VDD VSS sg13g2_decap_8
XFILLER_109_1426 VDD VSS sg13g2_decap_8
X_10721_ _10965_/B _14939_/Q _08903_/S _10720_/Y VDD VSS sg13g2_a21oi_1
XFILLER_57_1358 VDD VSS sg13g2_fill_2
XFILLER_13_224 VDD VSS sg13g2_decap_8
XFILLER_57_1369 VDD VSS sg13g2_decap_8
XFILLER_144_1328 VDD VSS sg13g2_fill_1
XFILLER_186_516 VDD VSS sg13g2_decap_8
XFILLER_186_527 VDD VSS sg13g2_decap_8
XFILLER_41_566 VDD VSS sg13g2_fill_2
X_13440_ _13440_/Y _13440_/A _13440_/B _15102_/Q VDD VSS sg13g2_nand3_1
X_10652_ _10653_/D _10652_/A _10652_/B _10652_/C _10652_/D VDD VSS sg13g2_nor4_1
XFILLER_9_217 VDD VSS sg13g2_decap_8
XFILLER_110_84 VDD VSS sg13g2_decap_8
XFILLER_10_931 VDD VSS sg13g2_decap_8
XFILLER_16_1055 VDD VSS sg13g2_decap_8
XFILLER_107_1172 VDD VSS sg13g2_decap_8
X_13371_ _15076_/D _13361_/C _13442_/A _13369_/Y VDD VSS sg13g2_o21ai_1
XFILLER_182_700 VDD VSS sg13g2_decap_8
X_10583_ _10594_/D _14872_/Q _14871_/Q _10591_/C _10583_/D VDD VSS sg13g2_and4_1
XFILLER_70_77 VDD VSS sg13g2_decap_8
XFILLER_127_627 VDD VSS sg13g2_decap_8
XFILLER_166_273 VDD VSS sg13g2_decap_8
XFILLER_186_66 VDD VSS sg13g2_decap_4
X_15110_ _15110_/Q clkload85/A _15110_/D _15110_/RESET_B VDD VSS sg13g2_dfrbpq_1
X_12322_ _12322_/Y _12318_/Y _12319_/Y _12321_/Y _12320_/Y _12324_/B VDD VSS sg13g2_a221oi_1
XFILLER_6_924 VDD VSS sg13g2_decap_8
XFILLER_139_498 VDD VSS sg13g2_decap_8
XFILLER_181_210 VDD VSS sg13g2_decap_8
XFILLER_170_906 VDD VSS sg13g2_decap_8
XFILLER_177_1137 VDD VSS sg13g2_decap_8
X_13888__2384 _13888_/RESET_B VDD VSS sg13g2_tiehi
XFILLER_5_434 VDD VSS sg13g2_decap_8
XFILLER_126_148 VDD VSS sg13g2_decap_8
X_15041_ _15041_/Q clkload65/A _15041_/D _15041_/RESET_B VDD VSS sg13g2_dfrbpq_1
XFILLER_68_1421 VDD VSS sg13g2_decap_8
X_12253_ _12253_/X _12253_/A _12253_/B VDD VSS sg13g2_and2_1
XFILLER_123_811 VDD VSS sg13g2_decap_4
XFILLER_163_980 VDD VSS sg13g2_decap_8
XFILLER_181_287 VDD VSS sg13g2_decap_8
X_11204_ _11204_/Y _11203_/Y _11201_/A _11201_/Y _11202_/Y _11151_/A VDD VSS sg13g2_a221oi_1
XFILLER_29_1416 VDD VSS sg13g2_decap_8
X_12184_ _12188_/A _12183_/X _12184_/B VDD VSS sg13g2_nand2b_1
XFILLER_79_86 VDD VSS sg13g2_fill_2
XFILLER_123_877 VDD VSS sg13g2_decap_4
X_11135_ _11136_/B _11172_/A _11147_/A _11128_/Y VDD VSS sg13g2_o21ai_1
XFILLER_1_651 VDD VSS sg13g2_decap_8
XFILLER_62_1020 VDD VSS sg13g2_decap_4
XFILLER_150_685 VDD VSS sg13g2_decap_8
XFILLER_110_527 VDD VSS sg13g2_decap_8
XFILLER_0_161 VDD VSS sg13g2_decap_8
XFILLER_77_931 VDD VSS sg13g2_fill_1
XFILLER_62_1042 VDD VSS sg13g2_fill_2
X_11066_ _11066_/Y _11118_/A _11088_/A _11206_/A1 VDD VSS sg13g2_o21ai_1
XFILLER_95_52 VDD VSS sg13g2_fill_1
XFILLER_27_1195 VDD VSS sg13g2_decap_8
XFILLER_7_1267 VDD VSS sg13g2_decap_8
X_15225__3086 _15225_/RESET_B VDD VSS sg13g2_tiehi
X_10017_ _14599_/D _10117_/A0 _14599_/Q _10031_/S VDD VSS sg13g2_mux2_1
XFILLER_64_614 VDD VSS sg13g2_decap_8
XFILLER_49_688 VDD VSS sg13g2_fill_1
XFILLER_97_1127 VDD VSS sg13g2_decap_8
XFILLER_37_839 VDD VSS sg13g2_decap_8
XFILLER_76_496 VDD VSS sg13g2_decap_8
X_14825_ _14825_/Q clkload63/A _14825_/D _14825_/RESET_B VDD VSS sg13g2_dfrbpq_1
XFILLER_63_135 VDD VSS sg13g2_decap_8
XFILLER_91_455 VDD VSS sg13g2_decap_8
XFILLER_17_574 VDD VSS sg13g2_decap_8
X_14756_ _14756_/Q clkload81/A _14756_/D _14756_/RESET_B VDD VSS sg13g2_dfrbpq_1
X_11968_ _11970_/A _11969_/A _13904_/Q VDD VSS sg13g2_nand2b_1
XFILLER_91_499 VDD VSS sg13g2_fill_2
X_13707_ _13707_/Q _14947_/CLK _13707_/D _13707_/RESET_B VDD VSS sg13g2_dfrbpq_1
X_10919_ _10920_/B _10904_/B _10945_/B _10945_/A VDD VSS sg13g2_a21oi_1
XFILLER_75_1469 VDD VSS sg13g2_fill_2
XFILLER_149_207 VDD VSS sg13g2_decap_8
X_14687_ _14687_/Q clkload20/A _14687_/D _14687_/RESET_B VDD VSS sg13g2_dfrbpq_1
X_11899_ _11900_/A _13966_/Q _13998_/Q _14030_/Q _14062_/Q _11896_/A _11897_/C VDD
+ VSS sg13g2_mux4_1
XFILLER_20_728 VDD VSS sg13g2_decap_8
X_13638_ _13746_/D _13638_/A VDD VSS sg13g2_buf_1
XFILLER_34_1122 VDD VSS sg13g2_decap_8
XFILLER_158_741 VDD VSS sg13g2_fill_1
XFILLER_13_791 VDD VSS sg13g2_decap_8
XFILLER_121_1103 VDD VSS sg13g2_fill_2
XFILLER_185_560 VDD VSS sg13g2_decap_8
X_13569_ _13569_/X _14996_/Q _15012_/Q _13569_/S VDD VSS sg13g2_mux2_1
XFILLER_9_784 VDD VSS sg13g2_decap_8
XFILLER_146_958 VDD VSS sg13g2_decap_8
XFILLER_172_210 VDD VSS sg13g2_decap_8
XFILLER_12_1442 VDD VSS sg13g2_decap_8
XFILLER_145_446 VDD VSS sg13g2_decap_8
XFILLER_8_294 VDD VSS sg13g2_decap_8
X_13718__2554 _13718_/RESET_B VDD VSS sg13g2_tiehi
XFILLER_133_608 VDD VSS sg13g2_fill_2
XFILLER_172_254 VDD VSS sg13g2_decap_8
XFILLER_173_777 VDD VSS sg13g2_fill_1
X_14478__1794 _14478_/RESET_B VDD VSS sg13g2_tiehi
X_15239_ _15239_/Q _15249_/CLK _15239_/D _15239_/RESET_B VDD VSS sg13g2_dfrbpq_1
XFILLER_161_939 VDD VSS sg13g2_decap_8
XFILLER_160_416 VDD VSS sg13g2_decap_4
XFILLER_126_682 VDD VSS sg13g2_decap_4
XFILLER_132_118 VDD VSS sg13g2_decap_8
XFILLER_154_991 VDD VSS sg13g2_decap_4
XFILLER_141_630 VDD VSS sg13g2_decap_8
XFILLER_125_192 VDD VSS sg13g2_decap_8
XFILLER_141_641 VDD VSS sg13g2_fill_1
Xfanout207 _10090_/A0 fanout210/X VDD VSS sg13g2_buf_1
X_09800_ _14389_/D _09899_/A0 _14389_/Q _09800_/S VDD VSS sg13g2_mux2_1
XFILLER_141_663 VDD VSS sg13g2_decap_8
Xfanout218 _13166_/A1 _13253_/B2 VDD VSS sg13g2_buf_1
Xfanout229 _09724_/A0 _09922_/A1 VDD VSS sg13g2_buf_1
X_07992_ _15250_/D _13501_/A _07991_/A _07988_/Y VDD VSS sg13g2_a21oi_1
XFILLER_101_516 VDD VSS sg13g2_fill_1
XFILLER_86_216 VDD VSS sg13g2_fill_1
XFILLER_101_538 VDD VSS sg13g2_decap_8
X_09731_ _14322_/D _09896_/A0 _14322_/Q _09731_/S VDD VSS sg13g2_mux2_1
XFILLER_140_195 VDD VSS sg13g2_decap_8
Xclkbuf_4_14_0_clk_i clkbuf_4_14_0_clk_i/X clkbuf_0_clk_i/X VDD VSS sg13g2_buf_8
XFILLER_95_750 VDD VSS sg13g2_decap_8
XFILLER_95_761 VDD VSS sg13g2_fill_1
X_09662_ _14255_/D _09926_/A1 _14255_/Q _09665_/S VDD VSS sg13g2_mux2_1
XFILLER_68_997 VDD VSS sg13g2_decap_8
XFILLER_27_316 VDD VSS sg13g2_fill_1
X_08613_ _08613_/Y _08641_/B _08612_/X _08667_/A1 VDD VSS sg13g2_a21oi_1
XFILLER_39_187 VDD VSS sg13g2_decap_8
XFILLER_27_338 VDD VSS sg13g2_decap_4
X_09593_ _14190_/D _14190_/Q _09727_/A0 _09605_/S VDD VSS sg13g2_mux2_1
XFILLER_82_466 VDD VSS sg13g2_fill_2
XFILLER_39_1000 VDD VSS sg13g2_decap_8
X_08544_ _08545_/D _08544_/A _08544_/B _08617_/A VDD VSS sg13g2_nand3_1
XFILLER_82_477 VDD VSS sg13g2_decap_8
XFILLER_63_691 VDD VSS sg13g2_fill_1
XFILLER_126_1003 VDD VSS sg13g2_decap_4
X_08475_ _08475_/Y _08475_/A _08475_/B _08475_/C _08475_/D VDD VSS sg13g2_nor4_1
XFILLER_50_341 VDD VSS sg13g2_decap_4
XFILLER_23_566 VDD VSS sg13g2_decap_8
XFILLER_165_1096 VDD VSS sg13g2_decap_8
XFILLER_17_1320 VDD VSS sg13g2_decap_8
XFILLER_11_728 VDD VSS sg13g2_decap_8
X_15163__2724 _15163_/RESET_B VDD VSS sg13g2_tiehi
XFILLER_91_1271 VDD VSS sg13g2_decap_8
XFILLER_51_897 VDD VSS sg13g2_decap_8
XFILLER_126_1069 VDD VSS sg13g2_fill_1
XFILLER_50_396 VDD VSS sg13g2_fill_1
XFILLER_104_1312 VDD VSS sg13g2_decap_8
XFILLER_10_238 VDD VSS sg13g2_decap_8
XFILLER_149_763 VDD VSS sg13g2_fill_1
XFILLER_104_1323 VDD VSS sg13g2_fill_1
XFILLER_149_774 VDD VSS sg13g2_decap_8
XFILLER_164_700 VDD VSS sg13g2_fill_1
XFILLER_137_925 VDD VSS sg13g2_decap_8
XFILLER_176_571 VDD VSS sg13g2_decap_8
XFILLER_52_1277 VDD VSS sg13g2_fill_2
XFILLER_17_1397 VDD VSS sg13g2_decap_8
XFILLER_40_14 VDD VSS sg13g2_decap_8
XFILLER_13_1239 VDD VSS sg13g2_decap_8
XFILLER_136_424 VDD VSS sg13g2_decap_8
XFILLER_108_137 VDD VSS sg13g2_decap_8
XFILLER_156_14 VDD VSS sg13g2_decap_8
XFILLER_164_777 VDD VSS sg13g2_decap_8
X_09027_ _09027_/X _15032_/Q _15229_/Q _09078_/B VDD VSS sg13g2_mux2_1
XFILLER_136_479 VDD VSS sg13g2_decap_8
X_14308__1964 _14308_/RESET_B VDD VSS sg13g2_tiehi
XFILLER_123_107 VDD VSS sg13g2_decap_4
XFILLER_102_1091 VDD VSS sg13g2_decap_8
XFILLER_156_69 VDD VSS sg13g2_decap_8
XFILLER_85_1031 VDD VSS sg13g2_fill_2
XFILLER_3_938 VDD VSS sg13g2_decap_8
XFILLER_104_310 VDD VSS sg13g2_fill_2
XFILLER_132_630 VDD VSS sg13g2_decap_8
XFILLER_85_1053 VDD VSS sg13g2_fill_1
XFILLER_46_1004 VDD VSS sg13g2_decap_8
XFILLER_2_448 VDD VSS sg13g2_decap_8
XFILLER_104_376 VDD VSS sg13g2_decap_8
XFILLER_105_899 VDD VSS sg13g2_fill_2
XFILLER_132_685 VDD VSS sg13g2_decap_8
XFILLER_160_994 VDD VSS sg13g2_decap_4
XFILLER_49_56 VDD VSS sg13g2_decap_8
XFILLER_131_162 VDD VSS sg13g2_decap_8
XFILLER_172_35 VDD VSS sg13g2_decap_8
Xfanout730 _07753_/B _07702_/X VDD VSS sg13g2_buf_1
Xfanout741 _12301_/B1 _11458_/A VDD VSS sg13g2_buf_1
XFILLER_28_1471 VDD VSS sg13g2_decap_8
XFILLER_24_1302 VDD VSS sg13g2_decap_8
XFILLER_104_398 VDD VSS sg13g2_decap_8
XFILLER_131_195 VDD VSS sg13g2_decap_8
Xfanout752 _11765_/A _12217_/A VDD VSS sg13g2_buf_1
X_09929_ _14514_/D _14514_/Q _09929_/A1 _09929_/S VDD VSS sg13g2_mux2_1
Xfanout763 _11822_/B _12329_/C1 VDD VSS sg13g2_buf_1
Xfanout774 _11542_/B _12246_/B VDD VSS sg13g2_buf_1
XFILLER_4_1407 VDD VSS sg13g2_decap_8
XFILLER_19_806 VDD VSS sg13g2_decap_8
Xfanout785 _11894_/B _11872_/B1 VDD VSS sg13g2_buf_1
Xfanout796 _11151_/A _11188_/C1 VDD VSS sg13g2_buf_1
XFILLER_111_1316 VDD VSS sg13g2_decap_8
X_12940_ _12941_/B _07683_/A _12939_/Y _12928_/X _12878_/D _12932_/Y VDD VSS sg13g2_a221oi_1
XFILLER_86_772 VDD VSS sg13g2_decap_8
XFILLER_98_1436 VDD VSS sg13g2_decap_4
XFILLER_24_1379 VDD VSS sg13g2_decap_8
XFILLER_150_1387 VDD VSS sg13g2_fill_1
XFILLER_46_647 VDD VSS sg13g2_decap_4
XFILLER_2_1120 VDD VSS sg13g2_decap_8
XFILLER_73_433 VDD VSS sg13g2_decap_4
XFILLER_65_55 VDD VSS sg13g2_decap_8
X_12871_ _15025_/D _13281_/B _12871_/B VDD VSS sg13g2_nor2_1
XFILLER_45_146 VDD VSS sg13g2_decap_8
XFILLER_27_850 VDD VSS sg13g2_fill_2
XFILLER_185_1439 VDD VSS sg13g2_decap_8
XFILLER_73_466 VDD VSS sg13g2_decap_8
X_14610_ _14610_/Q _14610_/CLK _14610_/D _14610_/RESET_B VDD VSS sg13g2_dfrbpq_1
XFILLER_73_477 VDD VSS sg13g2_fill_1
X_11822_ _11822_/X _11822_/A _11822_/B VDD VSS sg13g2_and2_1
XFILLER_96_1160 VDD VSS sg13g2_decap_8
XFILLER_60_105 VDD VSS sg13g2_decap_8
XFILLER_27_883 VDD VSS sg13g2_decap_8
XFILLER_14_511 VDD VSS sg13g2_decap_8
Xclkbuf_5_29__f_clk_i clkbuf_leaf_89_clk_i/A clkbuf_4_14_0_clk_i/X VDD VSS sg13g2_buf_16
XFILLER_2_1197 VDD VSS sg13g2_decap_8
XFILLER_26_371 VDD VSS sg13g2_decap_8
XFILLER_96_1193 VDD VSS sg13g2_decap_4
XFILLER_54_691 VDD VSS sg13g2_decap_4
XFILLER_157_0 VDD VSS sg13g2_decap_8
X_14541_ _14541_/Q _14669_/CLK _14541_/D _14541_/RESET_B VDD VSS sg13g2_dfrbpq_1
X_11753_ _11754_/A _14250_/Q _14282_/Q _14314_/Q _14346_/Q _11753_/S0 _11742_/C VDD
+ VSS sg13g2_mux4_1
XFILLER_57_1155 VDD VSS sg13g2_decap_8
XFILLER_42_853 VDD VSS sg13g2_decap_8
XFILLER_159_516 VDD VSS sg13g2_decap_8
XFILLER_53_1008 VDD VSS sg13g2_decap_8
X_10704_ _10923_/B _09021_/X _10788_/S _08869_/Y VDD VSS sg13g2_a21oi_1
XFILLER_57_1199 VDD VSS sg13g2_decap_8
XFILLER_41_363 VDD VSS sg13g2_decap_8
XFILLER_35_1420 VDD VSS sg13g2_fill_2
XFILLER_105_1109 VDD VSS sg13g2_fill_2
XFILLER_14_588 VDD VSS sg13g2_decap_8
X_14472_ _14472_/Q _14740_/CLK _14472_/D _14472_/RESET_B VDD VSS sg13g2_dfrbpq_1
X_11684_ _11684_/Y _12114_/S0 _14504_/Q _11802_/B VDD VSS sg13g2_a21oi_1
XFILLER_81_76 VDD VSS sg13g2_decap_8
XFILLER_70_1311 VDD VSS sg13g2_fill_2
XFILLER_81_87 VDD VSS sg13g2_fill_2
XFILLER_14_70 VDD VSS sg13g2_decap_8
XFILLER_161_1461 VDD VSS sg13g2_decap_8
X_13423_ _13423_/Y _13440_/A _13440_/B _13423_/C VDD VSS sg13g2_nand3_1
X_10635_ _10636_/B _14886_/Q _14885_/Q _14884_/Q _14883_/Q VDD VSS sg13g2_nand4_1
XFILLER_139_251 VDD VSS sg13g2_fill_1
XFILLER_174_519 VDD VSS sg13g2_decap_8
XFILLER_70_1355 VDD VSS sg13g2_decap_8
XFILLER_122_1445 VDD VSS sg13g2_decap_4
XFILLER_139_262 VDD VSS sg13g2_fill_2
XFILLER_127_424 VDD VSS sg13g2_decap_8
XFILLER_155_733 VDD VSS sg13g2_decap_8
X_13354_ _13364_/B _13396_/A _13396_/B VDD VSS sg13g2_nor2_1
XFILLER_6_721 VDD VSS sg13g2_decap_8
X_10566_ _10567_/D _14868_/Q _14867_/Q _14866_/Q _10566_/D VDD VSS sg13g2_nand4_1
XFILLER_128_969 VDD VSS sg13g2_decap_8
XFILLER_155_766 VDD VSS sg13g2_decap_8
X_12305_ _12307_/A _12306_/A _14202_/Q VDD VSS sg13g2_nand2b_1
XFILLER_5_231 VDD VSS sg13g2_decap_8
XFILLER_170_703 VDD VSS sg13g2_decap_8
XFILLER_154_265 VDD VSS sg13g2_decap_8
XFILLER_182_574 VDD VSS sg13g2_decap_8
X_13285_ _13287_/C _13481_/A _07744_/D _13284_/Y VDD VSS sg13g2_a21oi_1
XFILLER_143_939 VDD VSS sg13g2_decap_8
X_10497_ _10499_/A _14853_/Q _10497_/B VDD VSS sg13g2_nand2b_1
XFILLER_68_1240 VDD VSS sg13g2_decap_8
XFILLER_108_682 VDD VSS sg13g2_decap_8
XFILLER_6_798 VDD VSS sg13g2_decap_8
XFILLER_170_747 VDD VSS sg13g2_decap_8
X_15024_ _15024_/Q _15219_/CLK _15024_/D _15024_/RESET_B VDD VSS sg13g2_dfrbpq_1
X_12236_ _12237_/B _12236_/A _12236_/B _12236_/C VDD VSS sg13g2_nand3_1
XFILLER_107_170 VDD VSS sg13g2_decap_8
XFILLER_68_1273 VDD VSS sg13g2_fill_2
XFILLER_46_7 VDD VSS sg13g2_decap_8
XFILLER_68_1295 VDD VSS sg13g2_decap_8
XFILLER_29_1257 VDD VSS sg13g2_decap_8
XFILLER_123_674 VDD VSS sg13g2_decap_8
X_12167_ _12169_/A _12168_/A _14646_/Q VDD VSS sg13g2_nand2b_1
X_14940__2757 _14940_/RESET_B VDD VSS sg13g2_tiehi
XFILLER_68_216 VDD VSS sg13g2_decap_8
XFILLER_111_847 VDD VSS sg13g2_decap_8
XFILLER_150_493 VDD VSS sg13g2_decap_8
X_11118_ _11119_/B _11118_/A _11118_/B _11118_/C _11118_/D VDD VSS sg13g2_nand4_1
XFILLER_110_335 VDD VSS sg13g2_decap_8
X_12098_ _12098_/Y _12098_/A1 _14676_/Q _12166_/B VDD VSS sg13g2_a21oi_1
XFILLER_96_558 VDD VSS sg13g2_decap_8
XFILLER_84_709 VDD VSS sg13g2_decap_8
XFILLER_77_750 VDD VSS sg13g2_decap_8
XFILLER_49_441 VDD VSS sg13g2_decap_8
XFILLER_7_1064 VDD VSS sg13g2_decap_8
X_11049_ _11064_/D _11185_/A _11068_/C VDD VSS sg13g2_xnor2_1
XFILLER_77_783 VDD VSS sg13g2_decap_8
Xinput7 input7/X input7/A VDD VSS sg13g2_buf_1
XFILLER_65_934 VDD VSS sg13g2_fill_2
XFILLER_92_720 VDD VSS sg13g2_fill_1
XFILLER_64_444 VDD VSS sg13g2_fill_1
XFILLER_52_606 VDD VSS sg13g2_fill_2
XFILLER_36_157 VDD VSS sg13g2_decap_8
X_14808_ _14808_/Q clkload67/A _14808_/D _14808_/RESET_B VDD VSS sg13g2_dfrbpq_1
XFILLER_51_116 VDD VSS sg13g2_decap_8
XFILLER_17_371 VDD VSS sg13g2_decap_8
XFILLER_45_680 VDD VSS sg13g2_decap_8
X_14739_ _14739_/Q _14739_/CLK _14739_/D _14739_/RESET_B VDD VSS sg13g2_dfrbpq_1
XFILLER_166_1383 VDD VSS sg13g2_fill_2
XFILLER_75_1266 VDD VSS sg13g2_decap_4
XFILLER_36_1217 VDD VSS sg13g2_decap_8
XFILLER_32_330 VDD VSS sg13g2_decap_8
X_08260_ _08260_/Y _08318_/B _08037_/C _08259_/Y VDD VSS sg13g2_a21oi_1
XFILLER_75_1288 VDD VSS sg13g2_fill_1
XFILLER_75_1299 VDD VSS sg13g2_decap_8
XFILLER_33_897 VDD VSS sg13g2_decap_8
XFILLER_32_374 VDD VSS sg13g2_fill_1
XFILLER_127_1389 VDD VSS sg13g2_decap_8
XFILLER_177_357 VDD VSS sg13g2_decap_8
X_08191_ _08191_/Y _07922_/Y _08248_/A _08190_/Y VDD VSS sg13g2_a21oi_1
XFILLER_119_925 VDD VSS sg13g2_decap_4
X_14565__1707 _14565_/RESET_B VDD VSS sg13g2_tiehi
XFILLER_72_0 VDD VSS sg13g2_decap_8
XFILLER_9_581 VDD VSS sg13g2_decap_8
X_14601__1671 _14601_/RESET_B VDD VSS sg13g2_tiehi
XFILLER_173_541 VDD VSS sg13g2_decap_8
XFILLER_69_1026 VDD VSS sg13g2_decap_8
XFILLER_118_479 VDD VSS sg13g2_decap_8
XFILLER_133_405 VDD VSS sg13g2_decap_4
XFILLER_173_574 VDD VSS sg13g2_fill_2
XFILLER_10_28 VDD VSS sg13g2_decap_8
XFILLER_161_725 VDD VSS sg13g2_decap_8
XFILLER_156_1018 VDD VSS sg13g2_decap_8
XFILLER_160_224 VDD VSS sg13g2_decap_8
XFILLER_126_28 VDD VSS sg13g2_decap_8
XFILLER_114_641 VDD VSS sg13g2_decap_8
XFILLER_173_1321 VDD VSS sg13g2_decap_8
XFILLER_138_1452 VDD VSS sg13g2_fill_2
XFILLER_142_972 VDD VSS sg13g2_decap_8
XFILLER_47_1357 VDD VSS sg13g2_decap_8
XFILLER_87_514 VDD VSS sg13g2_decap_8
XFILLER_102_825 VDD VSS sg13g2_decap_8
XFILLER_101_324 VDD VSS sg13g2_decap_8
XFILLER_134_1349 VDD VSS sg13g2_decap_8
XFILLER_173_1398 VDD VSS sg13g2_decap_8
X_07975_ _07979_/A _07976_/A _07976_/B _07976_/C VDD VSS sg13g2_nor3_1
XFILLER_102_869 VDD VSS sg13g2_decap_8
XFILLER_101_357 VDD VSS sg13g2_decap_8
XFILLER_56_901 VDD VSS sg13g2_decap_8
XFILLER_45_1081 VDD VSS sg13g2_decap_8
X_09714_ _14305_/D _09912_/A1 _14305_/Q _09738_/S VDD VSS sg13g2_mux2_1
XFILLER_74_208 VDD VSS sg13g2_decap_8
XFILLER_27_102 VDD VSS sg13g2_fill_2
XFILLER_132_1084 VDD VSS sg13g2_decap_8
XFILLER_55_433 VDD VSS sg13g2_decap_8
XFILLER_28_647 VDD VSS sg13g2_fill_1
X_09645_ _14238_/D _10141_/A1 _14238_/Q _09673_/S VDD VSS sg13g2_mux2_1
XFILLER_27_135 VDD VSS sg13g2_decap_8
XFILLER_82_230 VDD VSS sg13g2_decap_8
XFILLER_35_14 VDD VSS sg13g2_decap_8
XFILLER_15_308 VDD VSS sg13g2_decap_8
X_09576_ _14173_/D _14173_/Q _09941_/A1 _09605_/S VDD VSS sg13g2_mux2_1
XFILLER_110_1371 VDD VSS sg13g2_decap_8
XFILLER_42_105 VDD VSS sg13g2_decap_8
XFILLER_82_285 VDD VSS sg13g2_decap_8
X_08527_ _08566_/C _08527_/A _08527_/B VDD VSS sg13g2_nand2_1
XFILLER_150_7 VDD VSS sg13g2_decap_8
XFILLER_184_1461 VDD VSS sg13g2_decap_8
XFILLER_93_1366 VDD VSS sg13g2_decap_8
XFILLER_54_1317 VDD VSS sg13g2_decap_4
XFILLER_23_341 VDD VSS sg13g2_fill_1
XFILLER_169_836 VDD VSS sg13g2_decap_8
XFILLER_19_1448 VDD VSS sg13g2_decap_8
XFILLER_54_1339 VDD VSS sg13g2_fill_1
XFILLER_24_886 VDD VSS sg13g2_fill_1
X_08458_ _08458_/X _08362_/X _08457_/X _08597_/B VDD VSS sg13g2_mux2_1
XFILLER_145_1467 VDD VSS sg13g2_fill_2
XFILLER_11_525 VDD VSS sg13g2_decap_8
XFILLER_50_171 VDD VSS sg13g2_decap_4
Xwire416 wire416/X wire416/A VDD VSS sg13g2_buf_2
X_08389_ _08394_/B _08415_/A _08389_/B VDD VSS sg13g2_nor2_1
XFILLER_7_518 VDD VSS sg13g2_decap_8
XFILLER_109_413 VDD VSS sg13g2_decap_4
XFILLER_143_1180 VDD VSS sg13g2_decap_8
XFILLER_167_35 VDD VSS sg13g2_decap_8
XFILLER_52_1063 VDD VSS sg13g2_decap_8
XFILLER_17_1194 VDD VSS sg13g2_decap_8
X_10420_ _14829_/D _10420_/A _10421_/B _10423_/C VDD VSS sg13g2_and3_1
XFILLER_104_1153 VDD VSS sg13g2_decap_8
XFILLER_13_1036 VDD VSS sg13g2_decap_8
XFILLER_149_593 VDD VSS sg13g2_decap_8
X_15224__3085 _15224_/RESET_B VDD VSS sg13g2_tiehi
XFILLER_52_1085 VDD VSS sg13g2_decap_8
XFILLER_136_232 VDD VSS sg13g2_decap_8
X_10351_ _10353_/A _14809_/Q _10352_/C _14810_/Q VDD VSS sg13g2_a21o_1
XFILLER_139_1216 VDD VSS sg13g2_decap_8
XFILLER_136_298 VDD VSS sg13g2_decap_4
XFILLER_178_1298 VDD VSS sg13g2_fill_1
X_13070_ _13070_/Y _14783_/Q _13208_/A2 _13208_/B1 VDD VSS sg13g2_o21ai_1
XFILLER_3_735 VDD VSS sg13g2_decap_8
X_10282_ _14788_/D _10282_/A _10281_/Y VDD VSS sg13g2_nor2b_1
XFILLER_133_961 VDD VSS sg13g2_decap_8
XFILLER_183_56 VDD VSS sg13g2_decap_8
X_12021_ _12021_/Y _12021_/A _12101_/B VDD VSS sg13g2_nand2_1
XFILLER_2_245 VDD VSS sg13g2_decap_8
XFILLER_78_503 VDD VSS sg13g2_fill_1
XFILLER_120_600 VDD VSS sg13g2_decap_8
XFILLER_133_983 VDD VSS sg13g2_fill_1
XFILLER_133_994 VDD VSS sg13g2_decap_8
XFILLER_65_1468 VDD VSS sg13g2_decap_8
Xfanout1503 _13316_/B _13600_/C VDD VSS sg13g2_buf_1
XFILLER_76_21 VDD VSS sg13g2_decap_8
XFILLER_116_83 VDD VSS sg13g2_decap_8
Xfanout560 _13520_/A1 _13508_/X VDD VSS sg13g2_buf_1
XFILLER_8_1351 VDD VSS sg13g2_decap_8
XFILLER_59_761 VDD VSS sg13g2_decap_8
Xfanout571 _12777_/A2 _12624_/A2 VDD VSS sg13g2_buf_1
XFILLER_4_1204 VDD VSS sg13g2_decap_8
X_13972_ _13972_/Q clkload25/A _13972_/D _13972_/RESET_B VDD VSS sg13g2_dfrbpq_1
Xfanout593 _10104_/A0 _08969_/X VDD VSS sg13g2_buf_1
XFILLER_46_400 VDD VSS sg13g2_decap_4
XFILLER_86_580 VDD VSS sg13g2_fill_2
XFILLER_59_794 VDD VSS sg13g2_decap_8
XFILLER_19_636 VDD VSS sg13g2_decap_8
XFILLER_24_1176 VDD VSS sg13g2_decap_8
XFILLER_20_1029 VDD VSS sg13g2_decap_8
X_12923_ _12988_/A _14902_/Q _13685_/Q VDD VSS sg13g2_xnor2_1
XFILLER_150_1195 VDD VSS sg13g2_decap_8
XFILLER_185_1203 VDD VSS sg13g2_decap_8
XFILLER_73_230 VDD VSS sg13g2_decap_8
X_14643__1629 _14643_/RESET_B VDD VSS sg13g2_tiehi
XFILLER_18_168 VDD VSS sg13g2_decap_8
XFILLER_98_1288 VDD VSS sg13g2_fill_1
XFILLER_59_1239 VDD VSS sg13g2_decap_4
X_12854_ _12854_/Y _12851_/Y _12852_/Y _12853_/Y VDD VSS sg13g2_a21oi_1
XFILLER_98_1299 VDD VSS sg13g2_fill_2
XFILLER_92_42 VDD VSS sg13g2_decap_8
XFILLER_33_105 VDD VSS sg13g2_decap_8
XFILLER_92_53 VDD VSS sg13g2_fill_1
XFILLER_15_842 VDD VSS sg13g2_decap_8
X_11805_ _11806_/B _11805_/A _11805_/B _11805_/C VDD VSS sg13g2_nand3_1
X_12785_ _12785_/X _13754_/Q _14106_/Q _14458_/Q _14554_/Q _12787_/S0 _12787_/S1 VDD
+ VSS sg13g2_mux4_1
XFILLER_61_469 VDD VSS sg13g2_fill_2
XFILLER_72_1417 VDD VSS sg13g2_decap_8
XFILLER_109_1042 VDD VSS sg13g2_decap_4
XFILLER_72_1428 VDD VSS sg13g2_fill_2
X_14524_ _14524_/Q clkload56/A _14524_/D _14524_/RESET_B VDD VSS sg13g2_dfrbpq_1
X_11736_ _11736_/X _11736_/A _11763_/B VDD VSS sg13g2_and2_1
XFILLER_109_1064 VDD VSS sg13g2_decap_8
XFILLER_14_385 VDD VSS sg13g2_decap_8
XFILLER_42_694 VDD VSS sg13g2_decap_8
XFILLER_109_1086 VDD VSS sg13g2_decap_8
X_14455_ _14455_/Q clkload46/A _14455_/D _14455_/RESET_B VDD VSS sg13g2_dfrbpq_1
X_11667_ _11667_/Y _12100_/S0 _13896_/Q VDD VSS sg13g2_nand2b_1
X_15011__2669 _15011_/RESET_B VDD VSS sg13g2_tiehi
XFILLER_31_1114 VDD VSS sg13g2_fill_1
XFILLER_161_1291 VDD VSS sg13g2_decap_8
XFILLER_174_338 VDD VSS sg13g2_decap_8
XFILLER_179_1029 VDD VSS sg13g2_decap_8
X_13406_ _15090_/D _13442_/A _13396_/D _13405_/Y VDD VSS sg13g2_o21ai_1
XFILLER_155_530 VDD VSS sg13g2_decap_8
X_10618_ _10619_/A _10651_/D _14880_/Q _14879_/Q _10629_/C VDD VSS sg13g2_nand4_1
XFILLER_128_755 VDD VSS sg13g2_decap_8
X_14386_ _14386_/Q clkload15/A _14386_/D _14386_/RESET_B VDD VSS sg13g2_dfrbpq_1
X_11598_ _11599_/B _11598_/A _11598_/B _11598_/C VDD VSS sg13g2_nand3_1
XFILLER_122_1275 VDD VSS sg13g2_decap_4
XFILLER_127_243 VDD VSS sg13g2_decap_8
XFILLER_127_254 VDD VSS sg13g2_fill_1
XFILLER_183_883 VDD VSS sg13g2_decap_8
X_13337_ _13338_/A _13485_/B _15171_/D VDD VSS sg13g2_nor2b_1
X_10549_ _10567_/C _14865_/Q _14864_/Q _14863_/Q VDD VSS sg13g2_nand3_1
XFILLER_115_416 VDD VSS sg13g2_decap_8
XFILLER_143_725 VDD VSS sg13g2_decap_8
XFILLER_182_371 VDD VSS sg13g2_decap_8
XFILLER_6_595 VDD VSS sg13g2_decap_8
XFILLER_142_235 VDD VSS sg13g2_decap_8
X_13268_ _13270_/B _14924_/Q _13663_/Q _13259_/A VDD VSS sg13g2_o21ai_1
X_15007_ _15007_/Q clkload43/A _15007_/D _15007_/RESET_B VDD VSS sg13g2_dfrbpq_1
X_12219_ _12219_/X _12205_/X _12206_/X _12219_/S VDD VSS sg13g2_mux2_1
XFILLER_97_812 VDD VSS sg13g2_decap_8
XFILLER_155_1051 VDD VSS sg13g2_decap_8
X_13199_ _13199_/X _13200_/A _13667_/Q VDD VSS sg13g2_and2_1
XFILLER_29_1054 VDD VSS sg13g2_decap_8
XFILLER_111_633 VDD VSS sg13g2_decap_8
XFILLER_9_1148 VDD VSS sg13g2_decap_8
XFILLER_116_1057 VDD VSS sg13g2_decap_8
XFILLER_69_569 VDD VSS sg13g2_fill_2
XFILLER_42_1210 VDD VSS sg13g2_fill_1
XFILLER_97_889 VDD VSS sg13g2_decap_8
XFILLER_46_1390 VDD VSS sg13g2_decap_8
X_07760_ _15205_/D _07989_/B _07759_/Y _07754_/Y VDD VSS sg13g2_a21oi_1
XFILLER_133_1393 VDD VSS sg13g2_decap_8
XFILLER_38_956 VDD VSS sg13g2_decap_4
XFILLER_2_84 VDD VSS sg13g2_decap_8
X_15248__3109 _15248_/RESET_B VDD VSS sg13g2_tiehi
X_07691_ _07691_/Y _13281_/B _11241_/A _11241_/C VDD VSS sg13g2_o21ai_1
XFILLER_42_1298 VDD VSS sg13g2_fill_1
X_09430_ _14032_/D _10026_/A0 _14032_/Q _09432_/S VDD VSS sg13g2_mux2_1
XFILLER_64_252 VDD VSS sg13g2_decap_8
X_14619__1653 _14619_/RESET_B VDD VSS sg13g2_tiehi
XFILLER_92_583 VDD VSS sg13g2_fill_2
XFILLER_65_797 VDD VSS sg13g2_decap_8
XFILLER_129_1418 VDD VSS sg13g2_decap_8
XFILLER_37_499 VDD VSS sg13g2_decap_8
XFILLER_25_639 VDD VSS sg13g2_decap_8
XFILLER_24_116 VDD VSS sg13g2_decap_4
X_09361_ _13965_/D _09625_/A0 _13965_/Q _09365_/S VDD VSS sg13g2_mux2_1
XFILLER_75_1052 VDD VSS sg13g2_decap_8
X_08312_ _08312_/Y _08312_/A _08312_/B _08312_/C _08312_/D VDD VSS sg13g2_nor4_1
XFILLER_178_644 VDD VSS sg13g2_decap_8
X_09292_ _13900_/D _13900_/Q _09956_/A1 _09294_/S VDD VSS sg13g2_mux2_1
XANTENNA_12 _16879_/A VDD VSS sg13g2_antennanp
XFILLER_127_1175 VDD VSS sg13g2_decap_8
XFILLER_20_322 VDD VSS sg13g2_decap_8
XFILLER_36_1058 VDD VSS sg13g2_decap_4
XANTENNA_23 _11798_/A VDD VSS sg13g2_antennanp
XFILLER_177_154 VDD VSS sg13g2_decap_8
X_08243_ _08243_/Y _08241_/A _08015_/Y _08241_/Y VDD VSS sg13g2_o21ai_1
XFILLER_166_828 VDD VSS sg13g2_decap_4
Xclkbuf_leaf_8_clk_i _14607_/CLK clkbuf_leaf_9_clk_i/A VDD VSS sg13g2_buf_8
XFILLER_53_1361 VDD VSS sg13g2_decap_8
XFILLER_14_1323 VDD VSS sg13g2_decap_8
XFILLER_159_880 VDD VSS sg13g2_fill_1
XFILLER_165_327 VDD VSS sg13g2_decap_8
XFILLER_118_210 VDD VSS sg13g2_decap_8
X_08174_ _08174_/Y _08174_/A _08174_/B _08514_/A VDD VSS sg13g2_nor3_1
XFILLER_140_1353 VDD VSS sg13g2_decap_8
XFILLER_20_399 VDD VSS sg13g2_decap_4
XFILLER_119_766 VDD VSS sg13g2_decap_8
XFILLER_118_254 VDD VSS sg13g2_decap_4
XFILLER_134_703 VDD VSS sg13g2_fill_1
XFILLER_180_308 VDD VSS sg13g2_decap_8
XFILLER_21_49 VDD VSS sg13g2_decap_8
XFILLER_107_939 VDD VSS sg13g2_fill_2
XFILLER_161_522 VDD VSS sg13g2_decap_8
XFILLER_175_1449 VDD VSS sg13g2_fill_2
Xoutput130 mem_axi_wdata[4] _15136_/Q VDD VSS sg13g2_buf_1
Xoutput141 trap wire1272/X VDD VSS sg13g2_buf_1
XFILLER_82_1001 VDD VSS sg13g2_decap_8
XFILLER_88_801 VDD VSS sg13g2_decap_4
XFILLER_134_1113 VDD VSS sg13g2_decap_8
XFILLER_82_1045 VDD VSS sg13g2_decap_8
XFILLER_47_1165 VDD VSS sg13g2_fill_1
X_15095__2884 _15095_/RESET_B VDD VSS sg13g2_tiehi
XFILLER_101_132 VDD VSS sg13g2_decap_8
XFILLER_60_1310 VDD VSS sg13g2_decap_8
XFILLER_134_1168 VDD VSS sg13g2_fill_2
XFILLER_75_506 VDD VSS sg13g2_fill_1
XFILLER_25_1441 VDD VSS sg13g2_decap_8
XFILLER_130_997 VDD VSS sg13g2_decap_8
XFILLER_87_388 VDD VSS sg13g2_decap_8
XFILLER_75_528 VDD VSS sg13g2_fill_1
XFILLER_102_699 VDD VSS sg13g2_decap_8
XFILLER_21_1305 VDD VSS sg13g2_decap_8
X_07958_ _07961_/B _07958_/A _07958_/B VDD VSS sg13g2_and2_1
XFILLER_75_539 VDD VSS sg13g2_decap_8
XFILLER_28_400 VDD VSS sg13g2_fill_2
XFILLER_28_411 VDD VSS sg13g2_fill_1
XFILLER_60_1365 VDD VSS sg13g2_decap_8
XFILLER_101_198 VDD VSS sg13g2_decap_8
XFILLER_112_1444 VDD VSS sg13g2_decap_8
XFILLER_112_1455 VDD VSS sg13g2_fill_2
XFILLER_56_753 VDD VSS sg13g2_decap_8
X_07889_ _07890_/B _07889_/A _08229_/C VDD VSS sg13g2_nand2_1
XFILLER_44_904 VDD VSS sg13g2_decap_8
XFILLER_112_1477 VDD VSS sg13g2_fill_2
XFILLER_15_105 VDD VSS sg13g2_decap_8
X_09628_ _14224_/D _10092_/A0 _14224_/Q _09630_/S VDD VSS sg13g2_mux2_1
XFILLER_28_499 VDD VSS sg13g2_decap_8
XFILLER_3_1281 VDD VSS sg13g2_decap_8
XFILLER_43_447 VDD VSS sg13g2_decap_8
X_09559_ _14157_/D _09625_/A0 _14157_/Q _09563_/S VDD VSS sg13g2_mux2_1
XFILLER_145_1220 VDD VSS sg13g2_decap_8
XFILLER_24_661 VDD VSS sg13g2_decap_8
XFILLER_12_812 VDD VSS sg13g2_decap_8
XFILLER_19_1245 VDD VSS sg13g2_decap_8
X_12570_ _12583_/A _12751_/A1 _12737_/A2 _15005_/Q VDD VSS sg13g2_a21oi_1
XFILLER_54_1136 VDD VSS sg13g2_decap_8
XFILLER_24_694 VDD VSS sg13g2_decap_8
XFILLER_11_322 VDD VSS sg13g2_decap_8
XFILLER_15_1109 VDD VSS sg13g2_decap_8
XFILLER_8_805 VDD VSS sg13g2_decap_8
XFILLER_168_154 VDD VSS sg13g2_fill_2
XFILLER_178_56 VDD VSS sg13g2_decap_8
XFILLER_180_1166 VDD VSS sg13g2_decap_8
X_11521_ _11521_/Y _11520_/Y _11519_/Y _11506_/Y _11722_/B2 _11723_/A2 VDD VSS sg13g2_a221oi_1
XFILLER_168_165 VDD VSS sg13g2_fill_1
XFILLER_12_889 VDD VSS sg13g2_decap_8
XFILLER_180_1199 VDD VSS sg13g2_decap_8
XFILLER_7_315 VDD VSS sg13g2_decap_8
X_14240_ _14240_/Q clkload40/A _14240_/D _14240_/RESET_B VDD VSS sg13g2_dfrbpq_1
X_11452_ _11463_/A _11452_/A _13688_/Q VDD VSS sg13g2_nor2_1
Xwire246 wire246/X wire246/A VDD VSS sg13g2_buf_2
XFILLER_11_399 VDD VSS sg13g2_decap_8
X_14057__2215 _14057_/RESET_B VDD VSS sg13g2_tiehi
XFILLER_125_703 VDD VSS sg13g2_fill_1
XFILLER_183_168 VDD VSS sg13g2_decap_8
X_10403_ _14823_/D _14823_/Q _10400_/Y _10402_/Y VDD VSS sg13g2_a21oi_1
X_14171_ _14171_/Q _14685_/CLK _14171_/D _14171_/RESET_B VDD VSS sg13g2_dfrbpq_1
XFILLER_109_265 VDD VSS sg13g2_decap_8
X_11383_ _11383_/Y _11384_/A _13690_/Q VDD VSS sg13g2_nand2_1
XFILLER_125_736 VDD VSS sg13g2_decap_8
XFILLER_180_831 VDD VSS sg13g2_decap_8
XFILLER_164_382 VDD VSS sg13g2_decap_4
X_13122_ _13122_/Y _14883_/Q _07727_/C _13193_/B VDD VSS sg13g2_a21oi_1
X_10334_ _14804_/D _10334_/A _10335_/B _10337_/C VDD VSS sg13g2_and3_1
XFILLER_3_532 VDD VSS sg13g2_decap_8
XFILLER_178_1095 VDD VSS sg13g2_decap_8
XFILLER_180_864 VDD VSS sg13g2_decap_8
XFILLER_98_609 VDD VSS sg13g2_decap_4
XFILLER_2_0 VDD VSS sg13g2_decap_8
XFILLER_106_972 VDD VSS sg13g2_decap_8
X_13053_ _13053_/Y _14782_/Q _13208_/A2 _13208_/B1 VDD VSS sg13g2_o21ai_1
XFILLER_124_279 VDD VSS sg13g2_decap_8
X_10265_ _10278_/C _10265_/A _10265_/B _10265_/C _10265_/D VDD VSS sg13g2_nor4_1
XFILLER_106_994 VDD VSS sg13g2_fill_1
XFILLER_117_1311 VDD VSS sg13g2_decap_8
XFILLER_140_739 VDD VSS sg13g2_decap_8
XFILLER_156_1371 VDD VSS sg13g2_decap_8
X_14272__2000 _14272_/RESET_B VDD VSS sg13g2_tiehi
X_12004_ _12004_/Y _12002_/Y _12003_/Y _11980_/A VDD VSS sg13g2_a21oi_1
XFILLER_117_1344 VDD VSS sg13g2_decap_8
XFILLER_156_1393 VDD VSS sg13g2_decap_8
Xfanout1311 _11832_/C _12334_/C VDD VSS sg13g2_buf_1
XFILLER_79_856 VDD VSS sg13g2_decap_8
XFILLER_61_1118 VDD VSS sg13g2_decap_8
Xfanout1322 _11831_/B1 _11901_/B1 VDD VSS sg13g2_buf_1
X_10196_ _14755_/D _15198_/D _14755_/Q _13653_/S VDD VSS sg13g2_mux2_1
XFILLER_87_86 VDD VSS sg13g2_decap_8
Xfanout1333 _12188_/C _12219_/S VDD VSS sg13g2_buf_1
XFILLER_117_1377 VDD VSS sg13g2_decap_8
Xfanout1344 _11925_/S1 _12038_/B1 VDD VSS sg13g2_buf_1
Xfanout1355 _11897_/C _11328_/S1 VDD VSS sg13g2_buf_1
XFILLER_78_377 VDD VSS sg13g2_decap_8
Xfanout1366 _12140_/S1 _12136_/S1 VDD VSS sg13g2_buf_1
XFILLER_4_1001 VDD VSS sg13g2_decap_8
XFILLER_120_485 VDD VSS sg13g2_fill_2
Xfanout1377 _11489_/S1 _11444_/S1 VDD VSS sg13g2_buf_1
XFILLER_78_399 VDD VSS sg13g2_decap_8
XFILLER_59_580 VDD VSS sg13g2_fill_1
XFILLER_47_720 VDD VSS sg13g2_decap_8
Xfanout390 _09506_/S _09474_/X VDD VSS sg13g2_buf_1
Xfanout1388 _11621_/S0 _11597_/A VDD VSS sg13g2_buf_1
XFILLER_47_731 VDD VSS sg13g2_fill_1
XFILLER_143_81 VDD VSS sg13g2_decap_8
Xfanout1399 _12025_/A fanout1400/X VDD VSS sg13g2_buf_1
XFILLER_98_1030 VDD VSS sg13g2_decap_8
X_13955_ _13955_/Q clkload29/A _13955_/D _13955_/RESET_B VDD VSS sg13g2_dfrbpq_1
XFILLER_47_753 VDD VSS sg13g2_decap_8
XFILLER_81_509 VDD VSS sg13g2_decap_4
XFILLER_46_241 VDD VSS sg13g2_decap_8
XFILLER_35_904 VDD VSS sg13g2_decap_8
XFILLER_19_466 VDD VSS sg13g2_decap_8
XFILLER_59_1003 VDD VSS sg13g2_decap_8
XFILLER_35_915 VDD VSS sg13g2_fill_1
XFILLER_4_1078 VDD VSS sg13g2_decap_8
XFILLER_185_1022 VDD VSS sg13g2_fill_1
X_12906_ _12925_/C _14901_/Q _13686_/Q VDD VSS sg13g2_nand2_1
XFILLER_46_274 VDD VSS sg13g2_decap_8
X_13886_ _13886_/Q clkload50/A _13886_/D _13886_/RESET_B VDD VSS sg13g2_dfrbpq_1
XFILLER_98_1096 VDD VSS sg13g2_decap_8
XFILLER_59_1047 VDD VSS sg13g2_decap_8
XFILLER_34_425 VDD VSS sg13g2_fill_2
XFILLER_59_1058 VDD VSS sg13g2_fill_1
X_12837_ _12838_/A _14895_/Q _13692_/Q _12836_/C VDD VSS sg13g2_a21oi_1
XFILLER_159_110 VDD VSS sg13g2_decap_8
XFILLER_15_672 VDD VSS sg13g2_decap_8
XFILLER_21_119 VDD VSS sg13g2_decap_8
X_12768_ _12768_/X _13849_/Q _13881_/Q _13913_/Q _13945_/Q _12771_/S0 _12771_/S1 VDD
+ VSS sg13g2_mux4_1
XFILLER_124_1315 VDD VSS sg13g2_decap_8
XFILLER_42_480 VDD VSS sg13g2_decap_4
XFILLER_148_817 VDD VSS sg13g2_fill_2
XFILLER_14_182 VDD VSS sg13g2_decap_8
XFILLER_159_154 VDD VSS sg13g2_fill_1
XFILLER_175_603 VDD VSS sg13g2_decap_8
X_14507_ _14507_/Q _14733_/CLK _14507_/D _14507_/RESET_B VDD VSS sg13g2_dfrbpq_1
XFILLER_72_1269 VDD VSS sg13g2_decap_8
XFILLER_159_165 VDD VSS sg13g2_decap_8
X_11719_ _11719_/Y _12292_/A _11719_/B VDD VSS sg13g2_nor2_1
X_12699_ _12699_/X _14260_/Q _14292_/Q _14324_/Q _14356_/Q _12783_/S0 _12783_/S1 VDD
+ VSS sg13g2_mux4_1
X_14438_ _14438_/Q clkload18/A _14438_/D _14438_/RESET_B VDD VSS sg13g2_dfrbpq_1
Xinput10 input10/X input10/A VDD VSS sg13g2_buf_1
Xinput21 input21/X input21/A VDD VSS sg13g2_buf_1
XFILLER_122_1050 VDD VSS sg13g2_fill_1
XFILLER_128_541 VDD VSS sg13g2_decap_8
Xinput32 input32/X input32/A VDD VSS sg13g2_buf_1
XFILLER_174_168 VDD VSS sg13g2_decap_8
X_14369_ _14369_/Q clkload36/A _14369_/D _14369_/RESET_B VDD VSS sg13g2_dfrbpq_1
XFILLER_143_511 VDD VSS sg13g2_fill_1
XFILLER_7_882 VDD VSS sg13g2_decap_8
XFILLER_183_691 VDD VSS sg13g2_decap_4
XFILLER_115_224 VDD VSS sg13g2_decap_8
XFILLER_116_747 VDD VSS sg13g2_decap_8
XFILLER_143_533 VDD VSS sg13g2_decap_8
XFILLER_66_1007 VDD VSS sg13g2_fill_2
XFILLER_115_235 VDD VSS sg13g2_fill_2
XFILLER_143_544 VDD VSS sg13g2_decap_8
XFILLER_116_769 VDD VSS sg13g2_decap_8
XFILLER_6_392 VDD VSS sg13g2_decap_8
XFILLER_171_875 VDD VSS sg13g2_fill_1
XFILLER_131_728 VDD VSS sg13g2_decap_8
X_08930_ _08930_/X _15046_/Q _14950_/Q _10767_/A VDD VSS sg13g2_mux2_1
XFILLER_83_1343 VDD VSS sg13g2_decap_8
XFILLER_112_931 VDD VSS sg13g2_fill_1
XFILLER_83_1365 VDD VSS sg13g2_decap_8
XFILLER_35_0 VDD VSS sg13g2_decap_8
X_08861_ _13698_/D _16860_/A _08860_/X _08941_/S VDD VSS sg13g2_mux2_1
XFILLER_111_441 VDD VSS sg13g2_decap_8
X_13755__2517 _13755_/RESET_B VDD VSS sg13g2_tiehi
XFILLER_135_1477 VDD VSS sg13g2_fill_2
X_07812_ _08548_/B _07956_/A _07812_/B VDD VSS sg13g2_nand2_1
XFILLER_96_163 VDD VSS sg13g2_decap_8
X_08792_ _08792_/Y _13682_/Q _13482_/B VDD VSS sg13g2_nor2_1
XFILLER_29_219 VDD VSS sg13g2_decap_8
XFILLER_57_539 VDD VSS sg13g2_decap_8
X_07743_ _07744_/D _12348_/A _15217_/Q _15126_/Q VDD VSS sg13g2_nor3_1
XFILLER_133_1190 VDD VSS sg13g2_decap_8
X_15223__3084 _15223_/RESET_B VDD VSS sg13g2_tiehi
X_07674_ _07674_/Y _13438_/A _07677_/B VDD VSS sg13g2_nand2_1
XFILLER_52_200 VDD VSS sg13g2_decap_4
XFILLER_53_734 VDD VSS sg13g2_decap_8
XFILLER_37_285 VDD VSS sg13g2_decap_8
X_13970__2302 _13970_/RESET_B VDD VSS sg13g2_tiehi
X_14135__2137 _14135_/RESET_B VDD VSS sg13g2_tiehi
XFILLER_0_1443 VDD VSS sg13g2_decap_8
XFILLER_20_1371 VDD VSS sg13g2_decap_8
XFILLER_16_49 VDD VSS sg13g2_decap_8
X_09413_ _14015_/D _09976_/A0 _14015_/Q _09428_/S VDD VSS sg13g2_mux2_1
XFILLER_129_1248 VDD VSS sg13g2_fill_1
XFILLER_13_609 VDD VSS sg13g2_decap_8
XFILLER_164_1128 VDD VSS sg13g2_decap_8
XFILLER_55_1412 VDD VSS sg13g2_decap_8
XFILLER_179_931 VDD VSS sg13g2_decap_8
XFILLER_52_266 VDD VSS sg13g2_decap_8
XFILLER_40_417 VDD VSS sg13g2_decap_8
XFILLER_34_981 VDD VSS sg13g2_decap_8
XFILLER_12_119 VDD VSS sg13g2_decap_8
X_09344_ _13948_/D _10039_/A0 _13948_/Q _09362_/S VDD VSS sg13g2_mux2_1
XFILLER_34_992 VDD VSS sg13g2_fill_2
XFILLER_139_806 VDD VSS sg13g2_fill_1
XFILLER_178_441 VDD VSS sg13g2_decap_8
X_09275_ _13883_/D _13883_/Q _09939_/A1 _09294_/S VDD VSS sg13g2_mux2_1
XFILLER_166_636 VDD VSS sg13g2_decap_8
XFILLER_14_1120 VDD VSS sg13g2_decap_8
XFILLER_165_124 VDD VSS sg13g2_fill_1
X_08226_ _08247_/C _08203_/A _08203_/B _07909_/B _07910_/A _08188_/Y VDD VSS sg13g2_a221oi_1
XFILLER_53_1180 VDD VSS sg13g2_decap_8
XFILLER_147_850 VDD VSS sg13g2_decap_8
XFILLER_105_1270 VDD VSS sg13g2_decap_8
XFILLER_20_196 VDD VSS sg13g2_decap_8
XFILLER_101_1112 VDD VSS sg13g2_decap_4
XFILLER_5_819 VDD VSS sg13g2_decap_8
XFILLER_180_105 VDD VSS sg13g2_decap_8
X_08157_ _08157_/X _08005_/X _08018_/X _08236_/S VDD VSS sg13g2_mux2_1
XFILLER_147_894 VDD VSS sg13g2_decap_8
XFILLER_14_1197 VDD VSS sg13g2_decap_8
XFILLER_107_736 VDD VSS sg13g2_decap_8
XFILLER_88_1254 VDD VSS sg13g2_decap_8
XFILLER_4_329 VDD VSS sg13g2_decap_8
XFILLER_175_1224 VDD VSS sg13g2_decap_8
XFILLER_179_1393 VDD VSS sg13g2_decap_8
XFILLER_134_544 VDD VSS sg13g2_decap_8
X_08088_ _08088_/Y _07913_/A _08063_/B _08290_/S VDD VSS sg13g2_a21oi_1
XFILLER_49_1238 VDD VSS sg13g2_fill_1
XFILLER_134_555 VDD VSS sg13g2_decap_8
XFILLER_164_14 VDD VSS sg13g2_decap_8
XFILLER_162_875 VDD VSS sg13g2_decap_8
XFILLER_175_1246 VDD VSS sg13g2_decap_8
XFILLER_49_1249 VDD VSS sg13g2_decap_8
XFILLER_136_1208 VDD VSS sg13g2_decap_8
XFILLER_115_780 VDD VSS sg13g2_fill_1
X_10050_ _14631_/D _10117_/A0 _14631_/Q _10064_/S VDD VSS sg13g2_mux2_1
XFILLER_0_546 VDD VSS sg13g2_decap_8
XFILLER_103_964 VDD VSS sg13g2_decap_8
X_14345__1927 _14345_/RESET_B VDD VSS sg13g2_tiehi
XFILLER_180_35 VDD VSS sg13g2_decap_8
XFILLER_21_1102 VDD VSS sg13g2_decap_8
XFILLER_60_1151 VDD VSS sg13g2_decap_8
XFILLER_60_1173 VDD VSS sg13g2_decap_8
XFILLER_29_753 VDD VSS sg13g2_fill_2
XFILLER_75_369 VDD VSS sg13g2_decap_4
XFILLER_5_1365 VDD VSS sg13g2_decap_8
XFILLER_1_1218 VDD VSS sg13g2_decap_8
XFILLER_84_870 VDD VSS sg13g2_decap_8
XFILLER_44_701 VDD VSS sg13g2_decap_8
Xclkbuf_leaf_109_clk_i clkload51/A clkbuf_5_16__f_clk_i/X VDD VSS sg13g2_buf_8
X_13740_ _13740_/Q clkload17/A _13740_/D _13740_/RESET_B VDD VSS sg13g2_dfrbpq_1
XFILLER_90_328 VDD VSS sg13g2_decap_8
XFILLER_17_948 VDD VSS sg13g2_decap_8
XFILLER_21_1179 VDD VSS sg13g2_decap_8
X_10952_ _11015_/A _10954_/A _10954_/B _10954_/C _10954_/D VDD VSS sg13g2_nor4_1
XFILLER_99_1394 VDD VSS sg13g2_decap_8
XFILLER_95_1247 VDD VSS sg13g2_decap_8
X_14560__1712 _14560_/RESET_B VDD VSS sg13g2_tiehi
XFILLER_71_542 VDD VSS sg13g2_decap_4
XFILLER_16_469 VDD VSS sg13g2_decap_8
X_13671_ _13671_/Q clkload83/A _13671_/D _13671_/RESET_B VDD VSS sg13g2_dfrbpq_1
X_10883_ _10883_/X _10890_/C _10883_/B VDD VSS sg13g2_xor2_1
XFILLER_73_77 VDD VSS sg13g2_decap_4
XFILLER_25_970 VDD VSS sg13g2_fill_1
X_12622_ _12622_/X _12618_/X _12617_/X _12614_/X _12613_/X _12622_/S0 _12705_/S1 VDD
+ VSS sg13g2_mux4_1
XFILLER_145_1050 VDD VSS sg13g2_fill_1
XFILLER_19_1053 VDD VSS sg13g2_fill_1
XFILLER_169_463 VDD VSS sg13g2_decap_8
XFILLER_185_912 VDD VSS sg13g2_fill_1
XFILLER_40_951 VDD VSS sg13g2_decap_8
XFILLER_145_1083 VDD VSS sg13g2_decap_8
X_12553_ _12553_/X _12551_/X _12552_/X _12553_/S VDD VSS sg13g2_mux2_1
XFILLER_8_602 VDD VSS sg13g2_decap_8
XFILLER_185_934 VDD VSS sg13g2_fill_2
XFILLER_106_1056 VDD VSS sg13g2_decap_8
XFILLER_12_686 VDD VSS sg13g2_decap_8
XFILLER_129_349 VDD VSS sg13g2_decap_8
XFILLER_185_967 VDD VSS sg13g2_decap_4
X_11504_ _11506_/B _11777_/A _11777_/C VDD VSS sg13g2_nor2_1
XFILLER_7_112 VDD VSS sg13g2_decap_8
XFILLER_157_669 VDD VSS sg13g2_decap_8
X_13833__2439 _13833_/RESET_B VDD VSS sg13g2_tiehi
X_12484_ _12485_/B _12942_/B _12693_/A2 _12483_/X _12415_/A _12763_/C1 VDD VSS sg13g2_a221oi_1
XFILLER_11_196 VDD VSS sg13g2_decap_8
X_14593__1679 _14593_/RESET_B VDD VSS sg13g2_tiehi
XFILLER_32_1253 VDD VSS sg13g2_fill_1
XFILLER_156_168 VDD VSS sg13g2_decap_8
X_13979__2293 _13979_/RESET_B VDD VSS sg13g2_tiehi
XFILLER_8_679 VDD VSS sg13g2_decap_8
X_14223_ _14223_/Q clkload12/A _14223_/D _14223_/RESET_B VDD VSS sg13g2_dfrbpq_1
XFILLER_22_70 VDD VSS sg13g2_decap_8
XFILLER_171_105 VDD VSS sg13g2_decap_8
X_11435_ _11435_/X _13952_/Q _13984_/Q _14016_/Q _14048_/Q _11442_/S0 _11442_/S1 VDD
+ VSS sg13g2_mux4_1
XFILLER_172_639 VDD VSS sg13g2_decap_8
XFILLER_184_499 VDD VSS sg13g2_decap_8
X_15247__3108 _15247_/RESET_B VDD VSS sg13g2_tiehi
XFILLER_7_189 VDD VSS sg13g2_decap_8
XFILLER_138_92 VDD VSS sg13g2_decap_8
XFILLER_153_853 VDD VSS sg13g2_decap_8
X_14154_ _14154_/Q clkload26/A _14154_/D _14154_/RESET_B VDD VSS sg13g2_dfrbpq_1
X_11366_ _11366_/Y _11366_/A _11366_/B _11366_/C VDD VSS sg13g2_nand3_1
XFILLER_67_1338 VDD VSS sg13g2_fill_1
XFILLER_99_929 VDD VSS sg13g2_decap_8
XFILLER_158_1466 VDD VSS sg13g2_decap_4
XFILLER_98_63 VDD VSS sg13g2_fill_2
XFILLER_98_406 VDD VSS sg13g2_decap_8
X_13105_ _13105_/X input14/X _13161_/A2 _13161_/B1 VDD VSS sg13g2_a21o_1
X_10317_ _10319_/B _10342_/A _10342_/C _14799_/Q VDD VSS sg13g2_a21oi_1
X_14085_ _14085_/Q _14725_/CLK _14085_/D _14085_/RESET_B VDD VSS sg13g2_dfrbpq_1
X_11297_ _11297_/Y _11212_/S _13885_/Q VDD VSS sg13g2_nand2b_1
XFILLER_4_896 VDD VSS sg13g2_decap_8
X_14213__2059 _14213_/RESET_B VDD VSS sg13g2_tiehi
XFILLER_112_238 VDD VSS sg13g2_fill_2
X_13036_ _15035_/D _13027_/Y _13035_/Y _13021_/A VDD VSS sg13g2_a21oi_1
X_10248_ _14777_/D _10255_/D _10608_/B _10248_/C VDD VSS sg13g2_nor3_1
Xfanout1130 _13510_/A1 _13521_/A VDD VSS sg13g2_buf_1
XFILLER_113_1005 VDD VSS sg13g2_decap_8
Xfanout1141 _08046_/B fanout1144/X VDD VSS sg13g2_buf_1
XFILLER_113_1016 VDD VSS sg13g2_fill_1
Xfanout1152 _08673_/B _12278_/A VDD VSS sg13g2_buf_1
X_10179_ _10179_/Y _10182_/A _14747_/Q VDD VSS sg13g2_nand2_1
Xfanout1163 _07859_/B _12084_/A VDD VSS sg13g2_buf_1
Xfanout1174 _11983_/A _14979_/Q VDD VSS sg13g2_buf_1
XFILLER_78_196 VDD VSS sg13g2_decap_8
Xfanout1185 _11865_/A _14976_/Q VDD VSS sg13g2_buf_1
XFILLER_94_667 VDD VSS sg13g2_fill_1
XFILLER_130_1341 VDD VSS sg13g2_fill_2
Xfanout1196 _08383_/A _08457_/A3 VDD VSS sg13g2_buf_1
X_14987_ _14987_/Q clkload69/A _14987_/D _14987_/RESET_B VDD VSS sg13g2_dfrbpq_1
XFILLER_19_252 VDD VSS sg13g2_decap_8
XFILLER_130_1363 VDD VSS sg13g2_fill_2
XFILLER_75_881 VDD VSS sg13g2_decap_4
X_13938_ _13938_/Q clkload15/A _13938_/D _13938_/RESET_B VDD VSS sg13g2_dfrbpq_1
XFILLER_165_1404 VDD VSS sg13g2_decap_8
XFILLER_34_233 VDD VSS sg13g2_decap_8
XFILLER_90_862 VDD VSS sg13g2_decap_8
XFILLER_34_244 VDD VSS sg13g2_fill_1
X_13869_ _13869_/Q _14733_/CLK _13869_/D _13869_/RESET_B VDD VSS sg13g2_dfrbpq_1
XFILLER_34_255 VDD VSS sg13g2_decap_4
XFILLER_179_238 VDD VSS sg13g2_decap_8
Xclkbuf_leaf_73_clk_i clkload85/A clkbuf_leaf_89_clk_i/A VDD VSS sg13g2_buf_8
XFILLER_22_417 VDD VSS sg13g2_decap_8
XFILLER_148_603 VDD VSS sg13g2_decap_8
XFILLER_124_1123 VDD VSS sg13g2_decap_8
XFILLER_128_1292 VDD VSS sg13g2_fill_1
XFILLER_175_411 VDD VSS sg13g2_decap_8
XFILLER_37_1197 VDD VSS sg13g2_decap_8
X_09060_ _09060_/X _15037_/Q _15234_/Q _09072_/B VDD VSS sg13g2_mux2_1
XFILLER_72_1099 VDD VSS sg13g2_fill_1
XFILLER_148_669 VDD VSS sg13g2_decap_8
Xclkbuf_leaf_88_clk_i clkload83/A clkbuf_leaf_88_clk_i/A VDD VSS sg13g2_buf_8
XFILLER_15_1473 VDD VSS sg13g2_decap_4
X_14423__1849 _14423_/RESET_B VDD VSS sg13g2_tiehi
X_08011_ _08011_/X _07972_/B _08653_/B _08673_/B _08048_/B _08009_/S _07627_/A VDD
+ VSS sg13g2_mux4_1
XFILLER_129_872 VDD VSS sg13g2_decap_8
X_13809__2463 _13809_/RESET_B VDD VSS sg13g2_tiehi
XFILLER_50_1364 VDD VSS sg13g2_fill_1
XFILLER_11_1337 VDD VSS sg13g2_decap_8
XFILLER_156_680 VDD VSS sg13g2_fill_1
XFILLER_116_522 VDD VSS sg13g2_decap_8
XFILLER_128_382 VDD VSS sg13g2_decap_8
XFILLER_144_842 VDD VSS sg13g2_fill_2
XFILLER_162_149 VDD VSS sg13g2_decap_8
Xmax_cap343 _09958_/S _09964_/S VDD VSS sg13g2_buf_8
XFILLER_104_706 VDD VSS sg13g2_decap_4
XFILLER_85_1449 VDD VSS sg13g2_fill_1
Xclkbuf_leaf_11_clk_i clkload15/A clkbuf_leaf_4_clk_i/A VDD VSS sg13g2_buf_8
Xmax_cap387 _09493_/S _09497_/S VDD VSS sg13g2_buf_4
X_09962_ _14546_/D _14546_/Q _10161_/A1 _09970_/S VDD VSS sg13g2_mux2_1
XFILLER_170_1110 VDD VSS sg13g2_decap_4
X_08913_ _08913_/Y _10747_/A _14945_/Q VDD VSS sg13g2_nand2_1
XFILLER_131_569 VDD VSS sg13g2_decap_8
X_09893_ _14479_/D _10158_/A1 _14479_/Q _09903_/S VDD VSS sg13g2_mux2_1
XFILLER_44_1146 VDD VSS sg13g2_decap_4
XFILLER_69_163 VDD VSS sg13g2_decap_4
X_08844_ _08844_/Y _10669_/S _14928_/Q VDD VSS sg13g2_nor2b_1
Xclkbuf_leaf_26_clk_i _14503_/CLK clkload2/A VDD VSS sg13g2_buf_8
XFILLER_22_1422 VDD VSS sg13g2_decap_8
X_08775_ _08775_/Y _13064_/B _08775_/B VDD VSS sg13g2_nor2_1
X_07726_ _07735_/C _07726_/A _07726_/B _07726_/C _07726_/D VDD VSS sg13g2_nand4_1
XFILLER_84_188 VDD VSS sg13g2_decap_8
XFILLER_66_892 VDD VSS sg13g2_decap_8
XFILLER_84_199 VDD VSS sg13g2_fill_2
XFILLER_150_49 VDD VSS sg13g2_decap_8
XFILLER_53_520 VDD VSS sg13g2_decap_4
XFILLER_26_745 VDD VSS sg13g2_decap_8
XFILLER_0_1240 VDD VSS sg13g2_decap_8
X_07657_ _10210_/D _15165_/Q _15164_/Q _15167_/Q _15166_/Q VDD VSS sg13g2_nor4_1
XFILLER_13_406 VDD VSS sg13g2_decap_8
XFILLER_53_575 VDD VSS sg13g2_decap_4
XFILLER_43_14 VDD VSS sg13g2_decap_8
XFILLER_159_14 VDD VSS sg13g2_decap_8
X_15175__2968 _15175_/RESET_B VDD VSS sg13g2_tiehi
XFILLER_142_1201 VDD VSS sg13g2_fill_2
XFILLER_167_901 VDD VSS sg13g2_fill_2
XFILLER_179_761 VDD VSS sg13g2_decap_8
XFILLER_139_603 VDD VSS sg13g2_decap_4
XFILLER_146_1381 VDD VSS sg13g2_fill_2
X_09327_ _13934_/D _10157_/A1 _13934_/Q _09327_/S VDD VSS sg13g2_mux2_1
XFILLER_40_258 VDD VSS sg13g2_decap_8
XFILLER_16_1237 VDD VSS sg13g2_decap_8
XFILLER_138_113 VDD VSS sg13g2_decap_8
XFILLER_51_1128 VDD VSS sg13g2_fill_2
XFILLER_103_1207 VDD VSS sg13g2_fill_1
XFILLER_22_995 VDD VSS sg13g2_decap_8
X_09258_ _13867_/D _13867_/Q _10154_/A1 _09265_/S VDD VSS sg13g2_mux2_1
XFILLER_138_146 VDD VSS sg13g2_decap_8
X_08209_ _08209_/X _08209_/A _08234_/B VDD VSS sg13g2_and2_1
XFILLER_5_616 VDD VSS sg13g2_decap_8
XFILLER_166_499 VDD VSS sg13g2_decap_8
X_09189_ _13805_/D _13805_/Q _10156_/A1 _09193_/S VDD VSS sg13g2_mux2_1
XFILLER_147_691 VDD VSS sg13g2_fill_2
XFILLER_175_35 VDD VSS sg13g2_decap_8
X_11220_ _11223_/B _11872_/B1 _11217_/X _11219_/X VDD VSS sg13g2_a21oi_1
XFILLER_4_126 VDD VSS sg13g2_decap_8
XFILLER_88_1062 VDD VSS sg13g2_fill_1
XFILLER_181_469 VDD VSS sg13g2_decap_8
XFILLER_134_341 VDD VSS sg13g2_decap_8
XFILLER_150_801 VDD VSS sg13g2_decap_8
XFILLER_162_661 VDD VSS sg13g2_decap_8
XFILLER_88_1095 VDD VSS sg13g2_fill_2
XFILLER_108_51 VDD VSS sg13g2_fill_2
X_11151_ _11151_/Y _11151_/A _11151_/B VDD VSS sg13g2_nor2_1
X_14845__2947 _14845_/RESET_B VDD VSS sg13g2_tiehi
XFILLER_150_834 VDD VSS sg13g2_decap_8
XFILLER_122_536 VDD VSS sg13g2_decap_8
XFILLER_1_833 VDD VSS sg13g2_decap_8
XFILLER_27_1300 VDD VSS sg13g2_decap_8
X_10102_ _14682_/D _10102_/A0 _14682_/Q _10102_/S VDD VSS sg13g2_mux2_1
XFILLER_68_44 VDD VSS sg13g2_fill_2
X_11082_ _11082_/Y _11082_/A1 _10754_/X _11154_/B1 VDD VSS sg13g2_o21ai_1
XFILLER_0_343 VDD VSS sg13g2_decap_8
XFILLER_122_569 VDD VSS sg13g2_decap_8
XFILLER_89_973 VDD VSS sg13g2_decap_8
XFILLER_66_1393 VDD VSS sg13g2_decap_8
XFILLER_103_761 VDD VSS sg13g2_fill_2
Xhold3260 _10366_/A _14814_/Q VDD VSS sg13g2_dlygate4sd3_1
X_14910_ _14910_/Q _14947_/CLK _14910_/D _14910_/RESET_B VDD VSS sg13g2_dfrbpq_1
X_10033_ _14615_/D _10066_/A0 _14615_/Q _10035_/S VDD VSS sg13g2_mux2_1
XFILLER_88_472 VDD VSS sg13g2_decap_8
XFILLER_114_1325 VDD VSS sg13g2_decap_8
XFILLER_7_1449 VDD VSS sg13g2_decap_8
XFILLER_27_1377 VDD VSS sg13g2_decap_8
XFILLER_49_859 VDD VSS sg13g2_decap_8
XFILLER_48_347 VDD VSS sg13g2_fill_2
X_14841_ _14841_/Q clkload68/A _14841_/D _14841_/RESET_B VDD VSS sg13g2_dfrbpq_1
XFILLER_64_818 VDD VSS sg13g2_decap_8
XFILLER_75_155 VDD VSS sg13g2_fill_1
XFILLER_5_1162 VDD VSS sg13g2_decap_8
XFILLER_91_626 VDD VSS sg13g2_decap_8
XFILLER_90_103 VDD VSS sg13g2_decap_8
XFILLER_1_1015 VDD VSS sg13g2_decap_8
X_14772_ _14772_/Q _15113_/CLK _14772_/D _14772_/RESET_B VDD VSS sg13g2_dfrbpq_1
XFILLER_63_339 VDD VSS sg13g2_fill_2
XFILLER_29_583 VDD VSS sg13g2_decap_8
X_11984_ _11986_/B _11914_/A _13673_/Q _13129_/B _11936_/A VDD VSS sg13g2_a22oi_1
XFILLER_112_1093 VDD VSS sg13g2_decap_8
XFILLER_56_391 VDD VSS sg13g2_fill_2
XFILLER_17_756 VDD VSS sg13g2_decap_8
X_13723_ _13723_/Q clkload60/A _13723_/D _13723_/RESET_B VDD VSS sg13g2_dfrbpq_1
XFILLER_17_70 VDD VSS sg13g2_decap_8
X_10935_ _10935_/Y _11043_/A _10935_/B VDD VSS sg13g2_nor2_1
XFILLER_16_266 VDD VSS sg13g2_decap_8
XFILLER_182_1025 VDD VSS sg13g2_decap_4
XFILLER_56_1028 VDD VSS sg13g2_decap_8
XFILLER_72_895 VDD VSS sg13g2_decap_8
X_13654_ _15120_/D _15190_/D _12346_/A _13654_/S VDD VSS sg13g2_mux2_1
X_10866_ _10868_/C _14752_/Q _10870_/A _10857_/A VDD VSS sg13g2_a21oi_1
XFILLER_73_1331 VDD VSS sg13g2_decap_8
XFILLER_38_1451 VDD VSS sg13g2_decap_8
XFILLER_158_901 VDD VSS sg13g2_decap_8
XFILLER_31_247 VDD VSS sg13g2_decap_8
X_12605_ _12605_/X _14381_/Q _14413_/Q _14477_/Q _14509_/Q _12605_/S0 _12643_/S1 VDD
+ VSS sg13g2_mux4_1
XFILLER_13_973 VDD VSS sg13g2_decap_8
X_13585_ _15160_/D _13581_/B _13583_/Y _13584_/Y VDD VSS sg13g2_a21oi_1
XFILLER_73_1375 VDD VSS sg13g2_decap_8
XFILLER_160_1334 VDD VSS sg13g2_decap_8
X_10797_ _10798_/B _13279_/B _12346_/A _10797_/C VDD VSS sg13g2_nand3_1
XFILLER_73_1386 VDD VSS sg13g2_fill_2
XFILLER_158_967 VDD VSS sg13g2_decap_8
XFILLER_12_483 VDD VSS sg13g2_decap_8
XFILLER_157_444 VDD VSS sg13g2_fill_1
X_12536_ _12536_/X _14696_/Q _14728_/Q _13768_/Q _13800_/Q _12668_/S0 _12668_/S1 VDD
+ VSS sg13g2_mux4_1
XFILLER_40_792 VDD VSS sg13g2_fill_1
XFILLER_9_966 VDD VSS sg13g2_decap_8
XFILLER_76_7 VDD VSS sg13g2_decap_8
XFILLER_33_91 VDD VSS sg13g2_decap_8
XFILLER_185_786 VDD VSS sg13g2_fill_1
XFILLER_117_319 VDD VSS sg13g2_decap_8
XFILLER_173_937 VDD VSS sg13g2_decap_4
XFILLER_185_797 VDD VSS sg13g2_fill_2
XFILLER_8_476 VDD VSS sg13g2_decap_8
XFILLER_126_820 VDD VSS sg13g2_decap_4
XFILLER_157_499 VDD VSS sg13g2_decap_4
X_12467_ _12467_/X _12464_/X _12463_/X _12460_/X _12459_/X _12775_/S1 _12720_/S VDD
+ VSS sg13g2_mux4_1
X_15222__3083 _15222_/RESET_B VDD VSS sg13g2_tiehi
X_14206_ _14206_/Q clkload52/A _14206_/D _14206_/RESET_B VDD VSS sg13g2_dfrbpq_1
XFILLER_172_458 VDD VSS sg13g2_decap_8
X_11418_ _11419_/B _11418_/A _14207_/Q VDD VSS sg13g2_nand2_1
X_15186_ _15186_/Q clkload82/A _15186_/D _15186_/RESET_B VDD VSS sg13g2_dfrbpq_1
XFILLER_67_1124 VDD VSS sg13g2_fill_1
X_12398_ _12398_/X _12389_/X _12390_/X _12396_/X _12395_/X wire856/X _12355_/S VDD
+ VSS sg13g2_mux4_1
XFILLER_99_726 VDD VSS sg13g2_fill_1
XFILLER_125_374 VDD VSS sg13g2_decap_4
X_14137_ _14137_/Q clkload37/A _14137_/D _14137_/RESET_B VDD VSS sg13g2_dfrbpq_1
XFILLER_153_694 VDD VSS sg13g2_fill_2
X_11349_ _11349_/Y _11821_/S0 _13758_/Q VDD VSS sg13g2_nand2b_1
XFILLER_67_1168 VDD VSS sg13g2_decap_4
X_15097__2876 _15097_/RESET_B VDD VSS sg13g2_tiehi
XFILLER_158_1296 VDD VSS sg13g2_fill_2
XFILLER_98_236 VDD VSS sg13g2_decap_8
XFILLER_4_693 VDD VSS sg13g2_decap_8
XFILLER_113_569 VDD VSS sg13g2_decap_4
X_14068_ _14068_/Q _14982_/CLK _14068_/D _14068_/RESET_B VDD VSS sg13g2_dfrbpq_1
XFILLER_140_366 VDD VSS sg13g2_decap_8
XFILLER_79_450 VDD VSS sg13g2_decap_8
XFILLER_45_1444 VDD VSS sg13g2_decap_4
X_13019_ _13019_/Y _13017_/Y _13018_/Y _12933_/Y VDD VSS sg13g2_o21ai_1
XFILLER_45_1477 VDD VSS sg13g2_fill_2
XFILLER_82_604 VDD VSS sg13g2_fill_2
X_08560_ _08561_/C _08560_/A _08599_/B _08560_/C VDD VSS sg13g2_nor3_1
XFILLER_54_339 VDD VSS sg13g2_decap_8
XFILLER_35_531 VDD VSS sg13g2_decap_4
X_08491_ _08501_/D _08329_/B _08329_/A _08490_/Y VDD VSS sg13g2_o21ai_1
XFILLER_81_158 VDD VSS sg13g2_fill_1
XFILLER_35_553 VDD VSS sg13g2_decap_8
XFILLER_81_169 VDD VSS sg13g2_decap_8
X_14052__2220 _14052_/RESET_B VDD VSS sg13g2_tiehi
XFILLER_126_1207 VDD VSS sg13g2_decap_8
XFILLER_22_203 VDD VSS sg13g2_decap_8
XFILLER_62_383 VDD VSS sg13g2_fill_1
XFILLER_50_534 VDD VSS sg13g2_decap_8
XFILLER_161_1109 VDD VSS sg13g2_decap_8
XFILLER_52_1415 VDD VSS sg13g2_decap_8
XFILLER_149_945 VDD VSS sg13g2_decap_8
XFILLER_13_28 VDD VSS sg13g2_decap_8
XFILLER_149_956 VDD VSS sg13g2_fill_1
X_14656__1616 _14656_/RESET_B VDD VSS sg13g2_tiehi
X_09112_ _13778_/D _13778_/Q _10128_/A0 _09160_/S VDD VSS sg13g2_mux2_1
XFILLER_176_753 VDD VSS sg13g2_fill_1
Xclkbuf_4_10_0_clk_i clkbuf_4_10_0_clk_i/X clkbuf_0_clk_i/X VDD VSS sg13g2_buf_8
XFILLER_176_775 VDD VSS sg13g2_decap_8
XFILLER_30_280 VDD VSS sg13g2_decap_8
XFILLER_129_39 VDD VSS sg13g2_decap_8
XFILLER_175_252 VDD VSS sg13g2_decap_8
XFILLER_176_786 VDD VSS sg13g2_fill_2
X_09043_ _09056_/C _09043_/A _09043_/B VDD VSS sg13g2_nor2_1
XFILLER_15_1270 VDD VSS sg13g2_decap_8
XFILLER_135_116 VDD VSS sg13g2_fill_2
XFILLER_163_436 VDD VSS sg13g2_decap_8
X_14085__2187 _14085_/RESET_B VDD VSS sg13g2_tiehi
XFILLER_11_1134 VDD VSS sg13g2_decap_8
XFILLER_144_650 VDD VSS sg13g2_fill_1
XFILLER_85_1224 VDD VSS sg13g2_decap_4
XFILLER_144_661 VDD VSS sg13g2_decap_4
XFILLER_172_981 VDD VSS sg13g2_decap_8
XFILLER_144_683 VDD VSS sg13g2_decap_8
XFILLER_172_1205 VDD VSS sg13g2_decap_8
XFILLER_116_385 VDD VSS sg13g2_decap_8
XFILLER_143_182 VDD VSS sg13g2_decap_8
XFILLER_145_49 VDD VSS sg13g2_decap_8
XFILLER_85_1279 VDD VSS sg13g2_fill_2
XFILLER_176_1396 VDD VSS sg13g2_fill_2
X_15024__2656 _15024_/RESET_B VDD VSS sg13g2_tiehi
Xfanout901 _12689_/S1 _12757_/S1 VDD VSS sg13g2_buf_1
Xfanout912 fanout912/X _12745_/S1 VDD VSS sg13g2_buf_1
X_09945_ _14529_/D _14529_/Q _09945_/A1 _09965_/S VDD VSS sg13g2_mux2_1
Xfanout923 _12564_/S0 fanout932/X VDD VSS sg13g2_buf_1
Xfanout934 _12406_/S0 _12588_/S0 VDD VSS sg13g2_buf_1
XFILLER_86_910 VDD VSS sg13g2_decap_8
Xfanout945 _12702_/S0 fanout948/X VDD VSS sg13g2_buf_1
XFILLER_131_388 VDD VSS sg13g2_decap_8
XFILLER_38_14 VDD VSS sg13g2_decap_8
Xfanout956 _12730_/S0 _12757_/S0 VDD VSS sg13g2_buf_1
Xfanout967 _12756_/S0 _12745_/S0 VDD VSS sg13g2_buf_1
X_09876_ _14462_/D _09909_/A1 _14462_/Q _09904_/S VDD VSS sg13g2_mux2_1
XFILLER_100_731 VDD VSS sg13g2_decap_8
Xfanout978 _13160_/B _13303_/A VDD VSS sg13g2_buf_1
Xfanout989 _13293_/C _15206_/Q VDD VSS sg13g2_buf_1
XFILLER_57_133 VDD VSS sg13g2_decap_8
XFILLER_46_807 VDD VSS sg13g2_decap_8
X_08827_ _13692_/D _08825_/Y _08824_/Y _08826_/Y VDD VSS sg13g2_a21oi_1
XFILLER_180_7 VDD VSS sg13g2_decap_8
XFILLER_86_987 VDD VSS sg13g2_decap_8
XFILLER_46_818 VDD VSS sg13g2_fill_1
XFILLER_2_1302 VDD VSS sg13g2_decap_8
X_08758_ _08758_/Y _13671_/Q _08781_/B VDD VSS sg13g2_nor2_1
XFILLER_96_1331 VDD VSS sg13g2_fill_2
XFILLER_22_1296 VDD VSS sg13g2_decap_8
X_15246__3107 _15246_/RESET_B VDD VSS sg13g2_tiehi
X_07709_ _07754_/B _13283_/A _14895_/Q _07708_/Y VDD VSS sg13g2_a21oi_1
XFILLER_54_35 VDD VSS sg13g2_decap_8
XFILLER_2_1379 VDD VSS sg13g2_decap_8
X_08689_ _08690_/C _08692_/C _08692_/B _08001_/A VDD VSS sg13g2_a21oi_1
XFILLER_148_1454 VDD VSS sg13g2_fill_1
XFILLER_81_670 VDD VSS sg13g2_decap_8
XFILLER_13_203 VDD VSS sg13g2_decap_8
X_10720_ _10720_/Y _10725_/A _10720_/B VDD VSS sg13g2_nor2_1
XFILLER_92_1239 VDD VSS sg13g2_decap_8
XFILLER_183_1378 VDD VSS sg13g2_decap_4
X_14295__1977 _14295_/RESET_B VDD VSS sg13g2_tiehi
XFILLER_41_545 VDD VSS sg13g2_decap_8
XFILLER_16_1001 VDD VSS sg13g2_decap_4
XFILLER_110_63 VDD VSS sg13g2_decap_8
X_10651_ _10652_/D _14886_/Q _14885_/Q _14882_/Q _10651_/D VDD VSS sg13g2_nand4_1
XFILLER_10_910 VDD VSS sg13g2_decap_8
XFILLER_16_1034 VDD VSS sg13g2_decap_8
XFILLER_41_589 VDD VSS sg13g2_decap_8
XFILLER_55_1083 VDD VSS sg13g2_fill_2
XFILLER_181_1091 VDD VSS sg13g2_decap_8
X_13370_ _13442_/A _13396_/A _13396_/B _13438_/B VDD VSS sg13g2_nand3b_1
X_14778__3028 _14778_/RESET_B VDD VSS sg13g2_tiehi
X_10582_ _10591_/D _14872_/Q _14871_/Q _14870_/Q _10647_/C VDD VSS sg13g2_and4_1
XFILLER_70_56 VDD VSS sg13g2_fill_1
XFILLER_166_252 VDD VSS sg13g2_decap_8
XFILLER_6_903 VDD VSS sg13g2_decap_8
XFILLER_139_477 VDD VSS sg13g2_decap_8
XFILLER_155_937 VDD VSS sg13g2_decap_8
X_12321_ _12321_/Y _11277_/S _14522_/Q _12328_/B1 VDD VSS sg13g2_a21oi_1
XFILLER_10_987 VDD VSS sg13g2_decap_8
XFILLER_177_1116 VDD VSS sg13g2_decap_8
XFILLER_5_413 VDD VSS sg13g2_decap_8
XFILLER_126_127 VDD VSS sg13g2_decap_8
XFILLER_33_1392 VDD VSS sg13g2_decap_8
XFILLER_120_1351 VDD VSS sg13g2_decap_8
X_13750__2522 _13750_/RESET_B VDD VSS sg13g2_tiehi
X_15040_ _15040_/Q clkload65/A _15040_/D _15040_/RESET_B VDD VSS sg13g2_dfrbpq_1
XFILLER_119_190 VDD VSS sg13g2_decap_8
X_12252_ _12253_/A _14264_/Q _14296_/Q _14328_/Q _14360_/Q _12235_/A _11760_/C VDD
+ VSS sg13g2_mux4_1
XFILLER_108_875 VDD VSS sg13g2_fill_1
XFILLER_119_83 VDD VSS sg13g2_fill_1
XFILLER_120_1384 VDD VSS sg13g2_fill_1
XFILLER_181_266 VDD VSS sg13g2_decap_8
XFILLER_182_789 VDD VSS sg13g2_decap_8
XFILLER_68_1444 VDD VSS sg13g2_fill_1
XFILLER_102_0 VDD VSS sg13g2_decap_8
X_11203_ _11203_/Y _11203_/A1 _11199_/Y _11202_/Y VDD VSS sg13g2_a21oi_1
X_12183_ _12183_/X _13846_/Q _13878_/Q _12186_/A VDD VSS sg13g2_mux2_1
XFILLER_68_1477 VDD VSS sg13g2_fill_2
XFILLER_122_333 VDD VSS sg13g2_decap_4
XFILLER_123_856 VDD VSS sg13g2_decap_8
XFILLER_1_630 VDD VSS sg13g2_decap_8
X_11134_ _11146_/B _11172_/A _11163_/A VDD VSS sg13g2_xnor2_1
XFILLER_0_140 VDD VSS sg13g2_decap_8
XFILLER_122_377 VDD VSS sg13g2_decap_8
X_14130__2142 _14130_/RESET_B VDD VSS sg13g2_tiehi
XFILLER_89_781 VDD VSS sg13g2_fill_2
X_11065_ _11088_/A _11119_/A _11011_/Y _11063_/Y VDD VSS sg13g2_o21ai_1
XFILLER_89_792 VDD VSS sg13g2_decap_4
X_13783__2489 _13783_/RESET_B VDD VSS sg13g2_tiehi
XFILLER_88_280 VDD VSS sg13g2_decap_8
XFILLER_7_1246 VDD VSS sg13g2_decap_8
XFILLER_27_1174 VDD VSS sg13g2_decap_8
XFILLER_62_1065 VDD VSS sg13g2_fill_2
XFILLER_49_645 VDD VSS sg13g2_decap_8
X_14809__2997 _14809_/RESET_B VDD VSS sg13g2_tiehi
X_10016_ _14598_/D _10082_/A0 _14598_/Q _10027_/S VDD VSS sg13g2_mux2_1
XFILLER_62_1098 VDD VSS sg13g2_decap_8
XFILLER_37_818 VDD VSS sg13g2_decap_8
XFILLER_97_1106 VDD VSS sg13g2_decap_8
X_14734__1538 _14734_/RESET_B VDD VSS sg13g2_tiehi
XFILLER_91_401 VDD VSS sg13g2_decap_8
XFILLER_76_475 VDD VSS sg13g2_fill_2
XFILLER_110_1019 VDD VSS sg13g2_fill_2
XFILLER_114_1188 VDD VSS sg13g2_decap_8
XFILLER_149_1207 VDD VSS sg13g2_decap_4
X_14824_ _14824_/Q clkload63/A _14824_/D _14824_/RESET_B VDD VSS sg13g2_dfrbpq_1
XFILLER_92_957 VDD VSS sg13g2_decap_8
XFILLER_64_659 VDD VSS sg13g2_decap_8
XFILLER_40_1374 VDD VSS sg13g2_decap_4
XFILLER_149_1229 VDD VSS sg13g2_decap_8
XFILLER_92_979 VDD VSS sg13g2_decap_8
XFILLER_17_553 VDD VSS sg13g2_decap_8
X_14755_ _14755_/Q clkload81/A _14755_/D _14755_/RESET_B VDD VSS sg13g2_dfrbpq_1
X_11967_ _11971_/A _11966_/X _11967_/B VDD VSS sg13g2_nand2b_1
XFILLER_32_501 VDD VSS sg13g2_decap_8
X_13706_ _13706_/Q clkload74/A _13706_/D _13706_/RESET_B VDD VSS sg13g2_dfrbpq_1
XFILLER_162_1407 VDD VSS sg13g2_decap_8
X_10918_ _10945_/B _14756_/Q _10936_/D _10888_/Y VDD VSS sg13g2_a21oi_1
XFILLER_72_692 VDD VSS sg13g2_decap_8
X_14686_ _14686_/Q clkload50/A _14686_/D _14686_/RESET_B VDD VSS sg13g2_dfrbpq_1
X_11898_ _11898_/Y _11898_/A _11898_/B _11898_/C VDD VSS sg13g2_nand3_1
XFILLER_177_539 VDD VSS sg13g2_decap_8
X_13637_ _13745_/D _13637_/A VDD VSS sg13g2_buf_1
XFILLER_34_1101 VDD VSS sg13g2_decap_8
X_13675__2615 _13675_/RESET_B VDD VSS sg13g2_tiehi
X_10849_ _14930_/D _10849_/A _10849_/B VDD VSS sg13g2_nand2_1
XFILLER_60_887 VDD VSS sg13g2_decap_8
XFILLER_13_770 VDD VSS sg13g2_decap_8
XFILLER_158_731 VDD VSS sg13g2_decap_4
XFILLER_73_1172 VDD VSS sg13g2_decap_8
XFILLER_160_1142 VDD VSS sg13g2_decap_4
XFILLER_12_280 VDD VSS sg13g2_decap_8
X_13568_ _15154_/D _15154_/Q _13567_/Y _13570_/S VDD VSS sg13g2_mux2_1
XFILLER_9_763 VDD VSS sg13g2_decap_8
XFILLER_125_1295 VDD VSS sg13g2_fill_1
XFILLER_160_1175 VDD VSS sg13g2_decap_8
XFILLER_12_1421 VDD VSS sg13g2_decap_8
X_12519_ _12519_/X _14567_/Q _14599_/Q _14631_/Q _14663_/Q _12522_/S0 _12522_/S1 VDD
+ VSS sg13g2_mux4_1
XFILLER_145_425 VDD VSS sg13g2_decap_8
XFILLER_8_273 VDD VSS sg13g2_decap_8
XFILLER_51_1470 VDD VSS sg13g2_fill_2
X_13499_ _13499_/Y _13656_/S _13499_/B _13499_/C VDD VSS sg13g2_nand3_1
XFILLER_173_756 VDD VSS sg13g2_decap_4
XFILLER_172_233 VDD VSS sg13g2_decap_8
XFILLER_161_918 VDD VSS sg13g2_decap_8
X_14340__1932 _14340_/RESET_B VDD VSS sg13g2_tiehi
X_15238_ _15238_/Q _15249_/CLK _15238_/D _15238_/RESET_B VDD VSS sg13g2_dfrbpq_1
XFILLER_114_801 VDD VSS sg13g2_decap_8
XFILLER_154_970 VDD VSS sg13g2_decap_8
XFILLER_114_812 VDD VSS sg13g2_fill_1
XFILLER_119_1000 VDD VSS sg13g2_fill_1
XFILLER_99_512 VDD VSS sg13g2_decap_8
XFILLER_5_980 VDD VSS sg13g2_decap_8
XFILLER_126_694 VDD VSS sg13g2_decap_8
X_15169_ _15169_/Q clkload85/A _15169_/D _15169_/RESET_B VDD VSS sg13g2_dfrbpq_1
XFILLER_119_1022 VDD VSS sg13g2_decap_8
XFILLER_5_84 VDD VSS sg13g2_decap_8
XFILLER_4_490 VDD VSS sg13g2_decap_8
XFILLER_119_1055 VDD VSS sg13g2_decap_8
Xfanout208 _09925_/A1 fanout210/X VDD VSS sg13g2_buf_1
Xfanout219 _13253_/B2 _13048_/X VDD VSS sg13g2_buf_1
XFILLER_119_1066 VDD VSS sg13g2_fill_2
X_07991_ _15057_/D _07991_/A VDD VSS sg13g2_inv_1
XFILLER_80_1110 VDD VSS sg13g2_fill_1
XFILLER_86_206 VDD VSS sg13g2_decap_4
XFILLER_84_1290 VDD VSS sg13g2_decap_8
XFILLER_80_1121 VDD VSS sg13g2_fill_2
XFILLER_140_174 VDD VSS sg13g2_decap_8
XFILLER_141_697 VDD VSS sg13g2_fill_1
X_09730_ _14321_/D _09730_/A0 _14321_/Q _09731_/S VDD VSS sg13g2_mux2_1
XFILLER_39_111 VDD VSS sg13g2_fill_1
X_14373__1899 _14373_/RESET_B VDD VSS sg13g2_tiehi
XFILLER_67_431 VDD VSS sg13g2_decap_8
XFILLER_68_976 VDD VSS sg13g2_decap_8
X_09661_ _14254_/D _09727_/A0 _14254_/Q _09661_/S VDD VSS sg13g2_mux2_1
XFILLER_132_1266 VDD VSS sg13g2_decap_4
XFILLER_95_773 VDD VSS sg13g2_fill_2
XFILLER_132_1277 VDD VSS sg13g2_fill_1
XFILLER_67_486 VDD VSS sg13g2_decap_8
X_08612_ _08612_/X _08611_/Y _08610_/Y _08649_/S VDD VSS sg13g2_mux2_1
X_09592_ _14189_/D _14189_/Q _09625_/A0 _09596_/S VDD VSS sg13g2_mux2_1
XFILLER_54_125 VDD VSS sg13g2_fill_1
XFILLER_82_445 VDD VSS sg13g2_decap_8
XFILLER_54_147 VDD VSS sg13g2_decap_4
X_08543_ _08545_/C _08553_/A _08522_/C _08542_/Y VDD VSS sg13g2_a21oi_1
XFILLER_78_1050 VDD VSS sg13g2_fill_2
XFILLER_42_309 VDD VSS sg13g2_fill_2
XFILLER_36_873 VDD VSS sg13g2_fill_1
XFILLER_78_1072 VDD VSS sg13g2_fill_1
XFILLER_23_501 VDD VSS sg13g2_fill_2
X_08474_ _08475_/A _08138_/X _08400_/Y _08473_/Y VDD VSS sg13g2_a21o_1
XFILLER_39_1056 VDD VSS sg13g2_decap_8
XFILLER_23_545 VDD VSS sg13g2_decap_8
XFILLER_126_1026 VDD VSS sg13g2_decap_8
XFILLER_168_517 VDD VSS sg13g2_fill_2
XFILLER_51_865 VDD VSS sg13g2_decap_8
XFILLER_11_707 VDD VSS sg13g2_decap_8
XFILLER_24_49 VDD VSS sg13g2_decap_8
XFILLER_23_589 VDD VSS sg13g2_decap_8
XFILLER_56_1392 VDD VSS sg13g2_decap_4
XFILLER_10_217 VDD VSS sg13g2_decap_8
XFILLER_143_1351 VDD VSS sg13g2_decap_8
XFILLER_137_904 VDD VSS sg13g2_decap_8
XFILLER_143_1362 VDD VSS sg13g2_fill_2
XFILLER_176_550 VDD VSS sg13g2_decap_8
XFILLER_17_1376 VDD VSS sg13g2_decap_8
XFILLER_52_1256 VDD VSS sg13g2_decap_8
XFILLER_13_1218 VDD VSS sg13g2_decap_8
XFILLER_148_263 VDD VSS sg13g2_decap_8
XFILLER_108_116 VDD VSS sg13g2_decap_8
XFILLER_148_285 VDD VSS sg13g2_fill_1
XFILLER_163_211 VDD VSS sg13g2_fill_1
XFILLER_178_1425 VDD VSS sg13g2_decap_8
XFILLER_163_233 VDD VSS sg13g2_fill_2
XFILLER_164_756 VDD VSS sg13g2_decap_8
XFILLER_152_907 VDD VSS sg13g2_decap_8
X_09026_ _13765_/D _13765_/Q _10115_/A0 _09106_/S VDD VSS sg13g2_mux2_1
XFILLER_139_1409 VDD VSS sg13g2_fill_2
XFILLER_3_917 VDD VSS sg13g2_decap_8
XFILLER_85_1010 VDD VSS sg13g2_decap_8
XFILLER_105_834 VDD VSS sg13g2_decap_4
XFILLER_85_1043 VDD VSS sg13g2_fill_2
XFILLER_2_427 VDD VSS sg13g2_decap_8
XFILLER_132_620 VDD VSS sg13g2_decap_4
XFILLER_172_1002 VDD VSS sg13g2_decap_8
XFILLER_6_7 VDD VSS sg13g2_decap_8
XFILLER_104_333 VDD VSS sg13g2_decap_8
XFILLER_137_1133 VDD VSS sg13g2_decap_8
XFILLER_172_1024 VDD VSS sg13g2_decap_8
XFILLER_105_878 VDD VSS sg13g2_decap_8
XFILLER_78_718 VDD VSS sg13g2_decap_8
XFILLER_49_35 VDD VSS sg13g2_decap_8
XFILLER_131_141 VDD VSS sg13g2_fill_2
XFILLER_172_14 VDD VSS sg13g2_decap_8
XFILLER_160_984 VDD VSS sg13g2_decap_4
Xfanout720 _09204_/C _11045_/B1 VDD VSS sg13g2_buf_1
XFILLER_28_1450 VDD VSS sg13g2_decap_8
Xfanout731 _12124_/A2 _12156_/A VDD VSS sg13g2_buf_1
XFILLER_120_848 VDD VSS sg13g2_decap_8
XFILLER_172_1079 VDD VSS sg13g2_decap_8
Xfanout742 _11458_/A _07682_/Y VDD VSS sg13g2_buf_1
X_09928_ _14513_/D _14513_/Q _09928_/A1 _09929_/S VDD VSS sg13g2_mux2_1
XFILLER_120_859 VDD VSS sg13g2_fill_1
Xfanout753 _11378_/S _12217_/A VDD VSS sg13g2_buf_1
Xfanout764 _11900_/B _11875_/B VDD VSS sg13g2_buf_1
Xfanout775 _11515_/S0 _12246_/B VDD VSS sg13g2_buf_1
XFILLER_86_751 VDD VSS sg13g2_decap_8
Xfanout786 _11872_/B1 _12328_/B1 VDD VSS sg13g2_buf_1
Xfanout797 _11043_/A _11188_/C1 VDD VSS sg13g2_buf_1
X_09859_ _14446_/D _14446_/Q _10024_/A0 _09859_/S VDD VSS sg13g2_mux2_1
XFILLER_98_1415 VDD VSS sg13g2_decap_8
XFILLER_24_1358 VDD VSS sg13g2_decap_8
XFILLER_105_85 VDD VSS sg13g2_decap_8
XFILLER_73_412 VDD VSS sg13g2_decap_8
XFILLER_65_34 VDD VSS sg13g2_decap_8
XFILLER_150_1399 VDD VSS sg13g2_decap_4
X_12870_ _12871_/B _12869_/Y _13048_/B _13293_/B _12861_/X _12865_/Y VDD VSS sg13g2_a221oi_1
XFILLER_45_125 VDD VSS sg13g2_decap_8
XFILLER_185_1418 VDD VSS sg13g2_decap_8
XFILLER_74_979 VDD VSS sg13g2_decap_8
X_15221__3082 _15221_/RESET_B VDD VSS sg13g2_tiehi
XFILLER_22_1093 VDD VSS sg13g2_decap_8
X_11821_ _11822_/A _14252_/Q _14284_/Q _14316_/Q _14348_/Q _11821_/S0 _11821_/S1 VDD
+ VSS sg13g2_mux4_1
XFILLER_27_862 VDD VSS sg13g2_decap_8
X_13768__2504 _13768_/RESET_B VDD VSS sg13g2_tiehi
XFILLER_2_1176 VDD VSS sg13g2_decap_8
XFILLER_26_350 VDD VSS sg13g2_decap_8
XFILLER_54_670 VDD VSS sg13g2_decap_8
XFILLER_92_1014 VDD VSS sg13g2_fill_1
X_14540_ _14540_/Q _14540_/CLK _14540_/D _14540_/RESET_B VDD VSS sg13g2_dfrbpq_1
XFILLER_42_832 VDD VSS sg13g2_decap_8
X_11752_ _11752_/Y _11748_/Y _11749_/Y _11751_/Y _11750_/Y _11763_/B VDD VSS sg13g2_a221oi_1
XFILLER_109_1224 VDD VSS sg13g2_decap_8
X_15078__2930 _15078_/RESET_B VDD VSS sg13g2_tiehi
XFILLER_148_1295 VDD VSS sg13g2_decap_8
XFILLER_18_1129 VDD VSS sg13g2_decap_8
XFILLER_41_342 VDD VSS sg13g2_decap_8
XFILLER_14_567 VDD VSS sg13g2_decap_8
X_10703_ _14903_/D _10999_/B1 _10923_/A _10702_/Y VDD VSS sg13g2_o21ai_1
X_14471_ _14471_/Q _14503_/CLK _14471_/D _14471_/RESET_B VDD VSS sg13g2_dfrbpq_1
XFILLER_144_1148 VDD VSS sg13g2_decap_8
X_11683_ _11683_/Y _12114_/S0 _14472_/Q VDD VSS sg13g2_nand2b_1
XFILLER_42_898 VDD VSS sg13g2_decap_8
XFILLER_186_336 VDD VSS sg13g2_decap_8
XFILLER_186_347 VDD VSS sg13g2_decap_8
X_13422_ _15094_/D _13490_/D _13421_/Y _13419_/Y VDD VSS sg13g2_o21ai_1
XFILLER_70_1334 VDD VSS sg13g2_decap_8
XFILLER_41_397 VDD VSS sg13g2_decap_8
XFILLER_128_904 VDD VSS sg13g2_decap_4
X_10634_ _10637_/B _14886_/Q _10633_/C _10630_/C VDD VSS sg13g2_o21ai_1
XFILLER_35_1465 VDD VSS sg13g2_decap_8
XFILLER_167_561 VDD VSS sg13g2_decap_8
X_14148__2124 _14148_/RESET_B VDD VSS sg13g2_tiehi
XFILLER_127_403 VDD VSS sg13g2_decap_8
XFILLER_6_700 VDD VSS sg13g2_decap_8
X_13353_ _13353_/Y _13507_/A _13507_/B VDD VSS sg13g2_nor2_1
X_10565_ _10576_/D _10567_/C _10565_/B _10565_/C _10565_/D VDD VSS sg13g2_nor4_1
XFILLER_10_784 VDD VSS sg13g2_decap_8
XFILLER_155_745 VDD VSS sg13g2_fill_1
XFILLER_5_210 VDD VSS sg13g2_decap_8
XFILLER_154_233 VDD VSS sg13g2_fill_1
XFILLER_154_244 VDD VSS sg13g2_decap_8
XFILLER_182_553 VDD VSS sg13g2_decap_8
X_12304_ _12308_/A _12303_/X _12304_/B VDD VSS sg13g2_nand2b_1
XFILLER_143_918 VDD VSS sg13g2_decap_8
X_13284_ _13284_/Y _08831_/B _13284_/B _13300_/C VDD VSS sg13g2_nand3b_1
X_10496_ _14852_/D _10497_/B _10626_/B _10496_/C VDD VSS sg13g2_and3_1
XFILLER_6_777 VDD VSS sg13g2_decap_8
XFILLER_120_1181 VDD VSS sg13g2_decap_8
XFILLER_136_981 VDD VSS sg13g2_fill_1
X_15023_ _15023_/Q clkload91/A _15023_/D _15023_/RESET_B VDD VSS sg13g2_dfrbpq_1
XFILLER_30_70 VDD VSS sg13g2_fill_2
XFILLER_120_1192 VDD VSS sg13g2_fill_1
X_12235_ _12236_/B _12235_/A _14232_/Q VDD VSS sg13g2_nand2_1
XFILLER_159_1380 VDD VSS sg13g2_decap_8
XFILLER_5_287 VDD VSS sg13g2_decap_8
XFILLER_29_1225 VDD VSS sg13g2_decap_8
XFILLER_123_642 VDD VSS sg13g2_decap_8
XFILLER_64_1116 VDD VSS sg13g2_decap_4
X_12166_ _12170_/A _12165_/X _12166_/B VDD VSS sg13g2_nand2b_1
XFILLER_96_504 VDD VSS sg13g2_decap_8
XFILLER_39_7 VDD VSS sg13g2_decap_8
XFILLER_29_1269 VDD VSS sg13g2_decap_8
XFILLER_111_826 VDD VSS sg13g2_decap_8
XFILLER_151_1108 VDD VSS sg13g2_decap_8
XFILLER_110_314 VDD VSS sg13g2_decap_8
XFILLER_122_174 VDD VSS sg13g2_decap_8
X_11117_ _11117_/Y _11138_/B _11138_/C _11140_/B2 VDD VSS sg13g2_a21oi_1
XFILLER_96_537 VDD VSS sg13g2_decap_8
XFILLER_2_994 VDD VSS sg13g2_decap_8
XFILLER_122_185 VDD VSS sg13g2_fill_1
X_12097_ _12097_/Y _12100_/S0 _14644_/Q VDD VSS sg13g2_nand2b_1
XFILLER_49_420 VDD VSS sg13g2_decap_8
XFILLER_7_1043 VDD VSS sg13g2_decap_8
X_11048_ _11048_/Y _11048_/A _11048_/B VDD VSS sg13g2_nand2_1
XFILLER_37_604 VDD VSS sg13g2_decap_8
Xinput8 input8/X input8/A VDD VSS sg13g2_buf_1
XFILLER_65_924 VDD VSS sg13g2_fill_2
XFILLER_49_497 VDD VSS sg13g2_decap_8
XFILLER_36_136 VDD VSS sg13g2_decap_8
X_14807_ _14807_/Q clkload67/A _14807_/D _14807_/RESET_B VDD VSS sg13g2_dfrbpq_1
XFILLER_149_1048 VDD VSS sg13g2_decap_8
XFILLER_17_350 VDD VSS sg13g2_decap_8
XFILLER_149_1059 VDD VSS sg13g2_fill_2
X_12999_ _12999_/Y _12996_/Y _12998_/Y _12933_/Y VDD VSS sg13g2_o21ai_1
XFILLER_18_895 VDD VSS sg13g2_decap_8
X_14358__1914 _14358_/RESET_B VDD VSS sg13g2_tiehi
XFILLER_73_990 VDD VSS sg13g2_decap_8
X_14738_ _14738_/Q clkload15/A _14738_/D _14738_/RESET_B VDD VSS sg13g2_dfrbpq_1
XFILLER_166_1362 VDD VSS sg13g2_decap_8
XFILLER_75_1256 VDD VSS sg13g2_decap_4
XFILLER_33_876 VDD VSS sg13g2_decap_8
X_14669_ _14669_/Q _14669_/CLK _14669_/D _14669_/RESET_B VDD VSS sg13g2_dfrbpq_1
XFILLER_177_336 VDD VSS sg13g2_decap_8
X_08190_ _08190_/Y _08248_/A _08190_/B VDD VSS sg13g2_nor2_1
XFILLER_119_904 VDD VSS sg13g2_fill_2
XFILLER_125_1081 VDD VSS sg13g2_fill_1
XFILLER_9_560 VDD VSS sg13g2_decap_8
XFILLER_125_1092 VDD VSS sg13g2_decap_8
XFILLER_158_594 VDD VSS sg13g2_decap_8
XFILLER_173_520 VDD VSS sg13g2_decap_8
XFILLER_118_436 VDD VSS sg13g2_decap_8
XFILLER_173_531 VDD VSS sg13g2_fill_2
XFILLER_69_1005 VDD VSS sg13g2_decap_8
XFILLER_65_0 VDD VSS sg13g2_decap_8
XFILLER_106_609 VDD VSS sg13g2_decap_8
XFILLER_134_918 VDD VSS sg13g2_decap_8
XFILLER_160_203 VDD VSS sg13g2_decap_8
X_15245__3106 _15245_/RESET_B VDD VSS sg13g2_tiehi
XFILLER_86_1341 VDD VSS sg13g2_decap_8
XFILLER_12_1295 VDD VSS sg13g2_decap_8
XFILLER_138_1420 VDD VSS sg13g2_decap_4
XFILLER_145_299 VDD VSS sg13g2_decap_8
XFILLER_173_1300 VDD VSS sg13g2_decap_8
XFILLER_47_1303 VDD VSS sg13g2_decap_8
XFILLER_173_1355 VDD VSS sg13g2_fill_1
X_13846__2426 _13846_/RESET_B VDD VSS sg13g2_tiehi
XFILLER_141_461 VDD VSS sg13g2_fill_1
XFILLER_134_1328 VDD VSS sg13g2_decap_8
XFILLER_87_548 VDD VSS sg13g2_decap_8
XFILLER_59_239 VDD VSS sg13g2_fill_1
X_07974_ _07976_/B _08697_/B _08698_/A _07974_/C _07974_/D VDD VSS sg13g2_and4_1
X_09713_ _14304_/D _09911_/A1 _14304_/Q _09738_/S VDD VSS sg13g2_mux2_1
XFILLER_19_49 VDD VSS sg13g2_decap_8
XFILLER_28_604 VDD VSS sg13g2_fill_2
XFILLER_55_412 VDD VSS sg13g2_decap_8
X_09644_ _14237_/D _09908_/A1 _14237_/Q _09673_/S VDD VSS sg13g2_mux2_1
XFILLER_27_114 VDD VSS sg13g2_decap_8
XFILLER_67_294 VDD VSS sg13g2_decap_8
X_14226__2046 _14226_/RESET_B VDD VSS sg13g2_tiehi
XFILLER_3_1463 VDD VSS sg13g2_decap_8
X_09575_ _14172_/D _14172_/Q _10072_/A0 _09603_/S VDD VSS sg13g2_mux2_1
XFILLER_55_489 VDD VSS sg13g2_decap_8
XFILLER_43_629 VDD VSS sg13g2_decap_8
XFILLER_184_1440 VDD VSS sg13g2_decap_8
XFILLER_24_821 VDD VSS sg13g2_decap_8
X_08526_ _08535_/B _08526_/A _08526_/B _08526_/C VDD VSS sg13g2_and3_1
XFILLER_145_1413 VDD VSS sg13g2_decap_8
XFILLER_169_815 VDD VSS sg13g2_decap_8
XFILLER_19_1427 VDD VSS sg13g2_decap_8
XFILLER_11_504 VDD VSS sg13g2_decap_8
X_08457_ _08457_/X _07949_/C _07945_/B _07946_/B _08457_/A3 _08598_/S0 _08598_/S1
+ VDD VSS sg13g2_mux4_1
XFILLER_169_859 VDD VSS sg13g2_fill_1
XFILLER_50_150 VDD VSS sg13g2_decap_8
XFILLER_24_898 VDD VSS sg13g2_decap_8
XFILLER_180_1359 VDD VSS sg13g2_decap_8
XFILLER_51_14 VDD VSS sg13g2_decap_8
XFILLER_23_397 VDD VSS sg13g2_decap_8
XFILLER_167_14 VDD VSS sg13g2_decap_8
X_08388_ _08388_/Y _08374_/Y _08375_/Y _08387_/Y VDD VSS sg13g2_o21ai_1
XFILLER_52_1042 VDD VSS sg13g2_fill_2
XFILLER_17_1173 VDD VSS sg13g2_decap_8
XFILLER_104_1132 VDD VSS sg13g2_decap_8
XFILLER_13_1015 VDD VSS sg13g2_decap_8
XFILLER_149_572 VDD VSS sg13g2_decap_4
XFILLER_136_200 VDD VSS sg13g2_fill_1
Xwire439 wire439/X wire439/A VDD VSS sg13g2_buf_2
XFILLER_136_211 VDD VSS sg13g2_decap_8
XFILLER_137_745 VDD VSS sg13g2_decap_8
XFILLER_178_1211 VDD VSS sg13g2_fill_2
XFILLER_109_447 VDD VSS sg13g2_decap_8
XFILLER_137_756 VDD VSS sg13g2_fill_2
XFILLER_109_458 VDD VSS sg13g2_fill_2
X_10350_ _14809_/D _10350_/A _10350_/B _10350_/C VDD VSS sg13g2_and3_1
XFILLER_87_1127 VDD VSS sg13g2_decap_8
XFILLER_30_1351 VDD VSS sg13g2_decap_8
XFILLER_118_970 VDD VSS sg13g2_fill_1
XFILLER_178_1266 VDD VSS sg13g2_fill_2
XFILLER_164_586 VDD VSS sg13g2_decap_4
XFILLER_3_714 VDD VSS sg13g2_decap_8
XFILLER_30_1373 VDD VSS sg13g2_fill_1
XFILLER_118_992 VDD VSS sg13g2_decap_4
X_15099__2868 _15099_/RESET_B VDD VSS sg13g2_tiehi
X_09009_ _10697_/A _15029_/Q _15226_/Q _09009_/S VDD VSS sg13g2_mux2_1
X_10281_ _10281_/Y _14786_/Q _14787_/Q _14788_/Q _10281_/D VDD VSS sg13g2_nand4_1
XFILLER_65_1403 VDD VSS sg13g2_fill_1
XFILLER_105_631 VDD VSS sg13g2_fill_2
XFILLER_151_236 VDD VSS sg13g2_decap_8
XFILLER_183_35 VDD VSS sg13g2_decap_8
XFILLER_2_224 VDD VSS sg13g2_decap_8
XFILLER_151_247 VDD VSS sg13g2_fill_1
XFILLER_105_653 VDD VSS sg13g2_fill_2
X_12020_ _12021_/A _14706_/Q _14738_/Q _13778_/Q _13810_/Q _12232_/S _12236_/C VDD
+ VSS sg13g2_mux4_1
XFILLER_105_686 VDD VSS sg13g2_decap_8
XFILLER_160_781 VDD VSS sg13g2_decap_8
X_14436__1836 _14436_/RESET_B VDD VSS sg13g2_tiehi
Xfanout1504 _13469_/A _13600_/C VDD VSS sg13g2_buf_1
XFILLER_116_62 VDD VSS sg13g2_decap_8
XFILLER_152_1439 VDD VSS sg13g2_decap_8
XFILLER_8_1330 VDD VSS sg13g2_decap_8
XFILLER_120_656 VDD VSS sg13g2_decap_8
Xfanout550 _13656_/S _13502_/A VDD VSS sg13g2_buf_1
XFILLER_59_740 VDD VSS sg13g2_decap_8
X_14910__2817 _14910_/RESET_B VDD VSS sg13g2_tiehi
Xfanout561 _13562_/S fanout565/X VDD VSS sg13g2_buf_1
XFILLER_28_1291 VDD VSS sg13g2_decap_8
Xfanout572 _12624_/A2 _12442_/A2 VDD VSS sg13g2_buf_1
XFILLER_63_1182 VDD VSS sg13g2_decap_8
X_13971_ _13971_/Q clkload31/A _13971_/D _13971_/RESET_B VDD VSS sg13g2_dfrbpq_1
XFILLER_24_1155 VDD VSS sg13g2_decap_8
Xfanout594 _09126_/A1 _09166_/A1 VDD VSS sg13g2_buf_1
XFILLER_76_77 VDD VSS sg13g2_decap_8
XFILLER_150_1174 VDD VSS sg13g2_decap_8
X_12922_ _12945_/A _14902_/Q _13685_/Q VDD VSS sg13g2_nand2_1
XFILLER_98_1245 VDD VSS sg13g2_decap_8
XFILLER_47_968 VDD VSS sg13g2_fill_1
XFILLER_46_445 VDD VSS sg13g2_decap_8
XFILLER_98_1256 VDD VSS sg13g2_fill_1
XFILLER_47_979 VDD VSS sg13g2_decap_8
XFILLER_18_147 VDD VSS sg13g2_decap_8
X_14651__1621 _14651_/RESET_B VDD VSS sg13g2_tiehi
XFILLER_92_21 VDD VSS sg13g2_decap_8
X_12853_ _12853_/Y _14770_/Q _13275_/A2 _13140_/B2 VDD VSS sg13g2_o21ai_1
XFILLER_132_83 VDD VSS sg13g2_decap_8
XFILLER_74_798 VDD VSS sg13g2_decap_8
XFILLER_15_821 VDD VSS sg13g2_decap_8
XFILLER_27_681 VDD VSS sg13g2_decap_8
X_11804_ _11805_/B _11804_/A _14220_/Q VDD VSS sg13g2_nand2_1
XFILLER_92_65 VDD VSS sg13g2_decap_8
XFILLER_61_448 VDD VSS sg13g2_decap_8
X_12784_ _12784_/X _14586_/Q _14618_/Q _14650_/Q _14682_/Q _12787_/S0 _12787_/S1 VDD
+ VSS sg13g2_mux4_1
XFILLER_92_76 VDD VSS sg13g2_fill_2
XFILLER_159_303 VDD VSS sg13g2_fill_1
X_14080__2192 _14080_/RESET_B VDD VSS sg13g2_tiehi
XFILLER_109_1032 VDD VSS sg13g2_decap_4
X_14523_ _14523_/Q clkload58/A _14523_/D _14523_/RESET_B VDD VSS sg13g2_dfrbpq_1
XFILLER_148_1092 VDD VSS sg13g2_decap_8
X_11735_ _11736_/A _13962_/Q _13994_/Q _14026_/Q _14058_/Q _11741_/A _11963_/S1 VDD
+ VSS sg13g2_mux4_1
XFILLER_25_70 VDD VSS sg13g2_decap_8
XFILLER_14_364 VDD VSS sg13g2_decap_8
XFILLER_42_673 VDD VSS sg13g2_decap_8
XFILLER_70_993 VDD VSS sg13g2_fill_2
X_14454_ _14454_/Q clkload41/A _14454_/D _14454_/RESET_B VDD VSS sg13g2_dfrbpq_1
X_13924__2348 _13924_/RESET_B VDD VSS sg13g2_tiehi
X_11666_ _11666_/Y _12100_/S0 _13864_/Q _12236_/C VDD VSS sg13g2_a21oi_1
X_14684__1588 _14684_/RESET_B VDD VSS sg13g2_tiehi
XFILLER_168_892 VDD VSS sg13g2_fill_2
XFILLER_179_1008 VDD VSS sg13g2_decap_8
X_13405_ _13405_/Y _13440_/A _13440_/B _15090_/Q VDD VSS sg13g2_nand3_1
X_10617_ _10619_/C _10651_/D _10622_/C VDD VSS sg13g2_or2_1
XFILLER_167_380 VDD VSS sg13g2_decap_8
X_14385_ _14385_/Q _14513_/CLK _14385_/D _14385_/RESET_B VDD VSS sg13g2_dfrbpq_1
Xwire940 wire940/X wire940/A VDD VSS sg13g2_buf_8
XFILLER_35_1295 VDD VSS sg13g2_decap_4
X_11597_ _11598_/B _11597_/A _14214_/Q VDD VSS sg13g2_nand2_1
XFILLER_10_581 VDD VSS sg13g2_decap_8
XFILLER_31_1159 VDD VSS sg13g2_decap_8
X_13336_ _13485_/B hold3124/X _15172_/Q _13336_/S VDD VSS sg13g2_mux2_1
XFILLER_182_350 VDD VSS sg13g2_decap_8
X_10548_ _14864_/D _10556_/D _10577_/B _10548_/C VDD VSS sg13g2_nor3_1
XFILLER_6_574 VDD VSS sg13g2_decap_8
XFILLER_142_214 VDD VSS sg13g2_decap_8
XFILLER_157_1339 VDD VSS sg13g2_fill_2
X_13267_ _13270_/C _14925_/Q _13662_/Q VDD VSS sg13g2_xnor2_1
X_10479_ _10505_/B _10489_/C _14847_/Q VDD VSS sg13g2_and2_1
XFILLER_124_951 VDD VSS sg13g2_fill_1
XFILLER_170_556 VDD VSS sg13g2_decap_8
XFILLER_142_258 VDD VSS sg13g2_fill_1
X_15006_ _15006_/Q clkload71/A _15006_/D _15006_/RESET_B VDD VSS sg13g2_dfrbpq_1
XFILLER_29_1022 VDD VSS sg13g2_decap_4
X_12218_ _12223_/B _12217_/Y _12208_/Y _12217_/A _12216_/X _12221_/B1 VDD VSS sg13g2_a221oi_1
XFILLER_111_601 VDD VSS sg13g2_fill_1
XFILLER_124_984 VDD VSS sg13g2_decap_4
X_13198_ _15046_/D _13191_/Y _13197_/Y _13198_/B1 VDD VSS sg13g2_a21oi_1
XFILLER_9_1127 VDD VSS sg13g2_decap_8
X_12149_ _14983_/D _12149_/A _12149_/B VDD VSS sg13g2_nand2_1
XFILLER_69_548 VDD VSS sg13g2_decap_8
XFILLER_2_791 VDD VSS sg13g2_decap_8
XFILLER_97_868 VDD VSS sg13g2_decap_8
XFILLER_29_1099 VDD VSS sg13g2_fill_1
XFILLER_99_1009 VDD VSS sg13g2_decap_8
XFILLER_84_507 VDD VSS sg13g2_decap_8
XFILLER_81_1282 VDD VSS sg13g2_fill_2
XFILLER_56_209 VDD VSS sg13g2_decap_8
XFILLER_96_389 VDD VSS sg13g2_decap_8
XFILLER_133_1372 VDD VSS sg13g2_decap_8
XFILLER_2_63 VDD VSS sg13g2_decap_8
X_14290__1982 _14290_/RESET_B VDD VSS sg13g2_tiehi
XFILLER_65_732 VDD VSS sg13g2_decap_4
X_07690_ _07690_/X _07690_/A _11241_/C VDD VSS sg13g2_and2_1
XFILLER_64_231 VDD VSS sg13g2_decap_8
XFILLER_53_927 VDD VSS sg13g2_fill_1
XFILLER_37_478 VDD VSS sg13g2_decap_8
XFILLER_25_618 VDD VSS sg13g2_decap_8
X_14773__3033 _14773_/RESET_B VDD VSS sg13g2_tiehi
X_09360_ _13964_/D _09558_/A0 _13964_/Q _09362_/S VDD VSS sg13g2_mux2_1
XFILLER_75_1031 VDD VSS sg13g2_decap_8
XFILLER_80_779 VDD VSS sg13g2_fill_2
XFILLER_178_623 VDD VSS sg13g2_decap_8
X_08311_ _08312_/C _08616_/B _08381_/A VDD VSS sg13g2_nor2b_1
XFILLER_166_1181 VDD VSS sg13g2_decap_8
XFILLER_61_971 VDD VSS sg13g2_decap_8
X_09291_ _13899_/D _13899_/Q _10154_/A1 _09298_/S VDD VSS sg13g2_mux2_1
XFILLER_127_1154 VDD VSS sg13g2_decap_8
XFILLER_20_301 VDD VSS sg13g2_decap_8
XFILLER_36_1037 VDD VSS sg13g2_decap_4
XFILLER_177_133 VDD VSS sg13g2_decap_8
XANTENNA_13 _16881_/A VDD VSS sg13g2_antennanp
XFILLER_60_481 VDD VSS sg13g2_decap_8
XFILLER_32_172 VDD VSS sg13g2_decap_8
XFILLER_123_1018 VDD VSS sg13g2_fill_1
X_08242_ _08688_/B _08242_/A _08270_/B VDD VSS sg13g2_nand2_1
XFILLER_53_1340 VDD VSS sg13g2_decap_8
XANTENNA_24 wire1272/X VDD VSS sg13g2_antennanp
XFILLER_14_1302 VDD VSS sg13g2_decap_8
XFILLER_162_1078 VDD VSS sg13g2_decap_8
XFILLER_21_879 VDD VSS sg13g2_decap_4
XFILLER_119_723 VDD VSS sg13g2_decap_8
X_14514__1758 _14514_/RESET_B VDD VSS sg13g2_tiehi
XFILLER_20_378 VDD VSS sg13g2_decap_8
X_08173_ _08514_/A _08340_/B _08329_/B VDD VSS sg13g2_nand2_1
XFILLER_101_1305 VDD VSS sg13g2_decap_8
XFILLER_21_28 VDD VSS sg13g2_decap_8
XFILLER_118_233 VDD VSS sg13g2_fill_1
XFILLER_14_1379 VDD VSS sg13g2_decap_8
XFILLER_161_501 VDD VSS sg13g2_decap_8
XFILLER_133_203 VDD VSS sg13g2_fill_2
XFILLER_88_1469 VDD VSS sg13g2_decap_4
XFILLER_173_394 VDD VSS sg13g2_decap_8
X_15220__3081 _15220_/RESET_B VDD VSS sg13g2_tiehi
XFILLER_12_1092 VDD VSS sg13g2_decap_8
XFILLER_161_545 VDD VSS sg13g2_fill_1
Xoutput120 mem_axi_wdata[24] _15156_/Q VDD VSS sg13g2_buf_1
Xoutput131 mem_axi_wdata[5] _15137_/Q VDD VSS sg13g2_buf_1
XFILLER_161_567 VDD VSS sg13g2_decap_4
XFILLER_114_450 VDD VSS sg13g2_fill_2
XFILLER_115_984 VDD VSS sg13g2_decap_8
XFILLER_138_1261 VDD VSS sg13g2_fill_1
XFILLER_0_728 VDD VSS sg13g2_decap_8
XFILLER_101_111 VDD VSS sg13g2_decap_8
XFILLER_130_943 VDD VSS sg13g2_fill_2
XFILLER_153_27 VDD VSS sg13g2_decap_4
XFILLER_102_645 VDD VSS sg13g2_decap_4
XFILLER_141_280 VDD VSS sg13g2_fill_1
XFILLER_173_1185 VDD VSS sg13g2_decap_8
XFILLER_47_1188 VDD VSS sg13g2_decap_8
XFILLER_134_1147 VDD VSS sg13g2_decap_8
XFILLER_25_1420 VDD VSS sg13g2_decap_8
XFILLER_130_976 VDD VSS sg13g2_decap_8
XFILLER_134_1158 VDD VSS sg13g2_fill_2
X_07957_ _07958_/A _08567_/A _07956_/Y _07950_/Y _07829_/A _07954_/Y VDD VSS sg13g2_a221oi_1
XFILLER_112_1412 VDD VSS sg13g2_fill_2
XFILLER_101_177 VDD VSS sg13g2_decap_8
XFILLER_46_14 VDD VSS sg13g2_decap_8
XFILLER_29_946 VDD VSS sg13g2_decap_8
XFILLER_46_25 VDD VSS sg13g2_fill_2
XFILLER_29_957 VDD VSS sg13g2_fill_2
XFILLER_28_423 VDD VSS sg13g2_decap_8
X_07888_ _08229_/C _08203_/B _11461_/A VDD VSS sg13g2_nand2_1
XFILLER_95_1407 VDD VSS sg13g2_decap_8
X_09627_ _14223_/D _09627_/A0 _14223_/Q _09630_/S VDD VSS sg13g2_mux2_1
XFILLER_56_787 VDD VSS sg13g2_decap_4
XFILLER_55_264 VDD VSS sg13g2_fill_1
XFILLER_3_1260 VDD VSS sg13g2_decap_8
XFILLER_83_595 VDD VSS sg13g2_decap_8
XFILLER_55_286 VDD VSS sg13g2_fill_2
XFILLER_43_426 VDD VSS sg13g2_decap_8
XFILLER_37_990 VDD VSS sg13g2_decap_4
X_09558_ _14156_/D _09558_/A0 _14156_/Q _09572_/S VDD VSS sg13g2_mux2_1
XFILLER_71_757 VDD VSS sg13g2_decap_4
XFILLER_93_1131 VDD VSS sg13g2_decap_8
XFILLER_19_1224 VDD VSS sg13g2_decap_8
X_08509_ _08517_/B _08659_/A _08170_/X _08652_/B1 VDD VSS sg13g2_o21ai_1
X_09489_ _14089_/D _09953_/A1 _14089_/Q _09505_/S VDD VSS sg13g2_mux2_1
XFILLER_106_1205 VDD VSS sg13g2_decap_8
XFILLER_11_301 VDD VSS sg13g2_decap_8
XFILLER_23_161 VDD VSS sg13g2_decap_8
XFILLER_145_1265 VDD VSS sg13g2_decap_4
XFILLER_168_133 VDD VSS sg13g2_decap_8
XFILLER_178_35 VDD VSS sg13g2_decap_8
XFILLER_169_667 VDD VSS sg13g2_fill_1
X_11520_ _11520_/Y _14902_/Q _12294_/A2 _11722_/B2 VDD VSS sg13g2_a21oi_1
XFILLER_145_1287 VDD VSS sg13g2_decap_8
XFILLER_12_868 VDD VSS sg13g2_decap_8
XFILLER_184_615 VDD VSS sg13g2_decap_8
XFILLER_184_626 VDD VSS sg13g2_decap_8
XFILLER_184_637 VDD VSS sg13g2_fill_2
XFILLER_11_378 VDD VSS sg13g2_decap_8
XFILLER_137_520 VDD VSS sg13g2_fill_2
X_11451_ _11451_/Y _11450_/Y _11448_/X _11433_/Y VDD VSS sg13g2_o21ai_1
Xwire247 wire247/X wire247/A VDD VSS sg13g2_buf_2
XFILLER_183_147 VDD VSS sg13g2_decap_8
XFILLER_109_244 VDD VSS sg13g2_decap_8
X_10402_ _10402_/Y _14823_/Q _10401_/A _10611_/B VDD VSS sg13g2_o21ai_1
XFILLER_32_1468 VDD VSS sg13g2_decap_8
X_14170_ _14170_/Q clkload51/A _14170_/D _14170_/RESET_B VDD VSS sg13g2_dfrbpq_1
XFILLER_125_715 VDD VSS sg13g2_decap_8
X_11382_ _11385_/A _11339_/B _11335_/X _11336_/A VDD VSS sg13g2_a21oi_1
XFILLER_180_810 VDD VSS sg13g2_decap_8
X_13121_ _13121_/Y _14819_/Q _13206_/B _13150_/B _10508_/A VDD VSS sg13g2_a22oi_1
XFILLER_3_511 VDD VSS sg13g2_decap_8
XFILLER_30_1170 VDD VSS sg13g2_decap_8
XFILLER_178_1074 VDD VSS sg13g2_decap_8
X_10333_ _10335_/B _14803_/Q _14804_/Q _10414_/B _10345_/C VDD VSS sg13g2_nand4_1
XFILLER_65_1200 VDD VSS sg13g2_decap_8
XFILLER_106_951 VDD VSS sg13g2_decap_8
X_14669__1603 _14669_/RESET_B VDD VSS sg13g2_tiehi
XFILLER_124_258 VDD VSS sg13g2_decap_8
XFILLER_152_567 VDD VSS sg13g2_decap_8
X_13052_ _13052_/Y _14846_/Q _07727_/B _13180_/B1 _14878_/Q _13051_/X VDD VSS sg13g2_a221oi_1
XFILLER_79_802 VDD VSS sg13g2_decap_8
XFILLER_105_450 VDD VSS sg13g2_decap_8
XFILLER_180_898 VDD VSS sg13g2_decap_8
X_10264_ _10266_/C _14782_/Q _10268_/D _14783_/Q VDD VSS sg13g2_a21oi_1
XFILLER_121_910 VDD VSS sg13g2_fill_1
XFILLER_121_921 VDD VSS sg13g2_decap_4
XFILLER_3_588 VDD VSS sg13g2_decap_8
XFILLER_133_792 VDD VSS sg13g2_fill_2
XFILLER_152_1214 VDD VSS sg13g2_decap_8
X_12003_ _12003_/Y _13142_/A _12122_/A2 _12124_/A2 VDD VSS sg13g2_a21oi_1
XFILLER_156_1383 VDD VSS sg13g2_decap_4
Xfanout1312 _11884_/B1 _12334_/C VDD VSS sg13g2_buf_1
X_10195_ _15198_/D hold3164/X _15198_/Q _13479_/S VDD VSS sg13g2_mux2_1
XFILLER_87_65 VDD VSS sg13g2_decap_8
XFILLER_121_954 VDD VSS sg13g2_decap_8
XFILLER_132_291 VDD VSS sg13g2_decap_8
X_14098__2174 _14098_/RESET_B VDD VSS sg13g2_tiehi
Xfanout1323 _11224_/A _11901_/B1 VDD VSS sg13g2_buf_1
XFILLER_121_965 VDD VSS sg13g2_fill_2
Xfanout1334 _11494_/S0 _12219_/S VDD VSS sg13g2_buf_1
XFILLER_94_805 VDD VSS sg13g2_fill_1
XFILLER_79_879 VDD VSS sg13g2_decap_8
XFILLER_78_356 VDD VSS sg13g2_decap_8
Xfanout1345 _12026_/C _12038_/B1 VDD VSS sg13g2_buf_1
XFILLER_120_464 VDD VSS sg13g2_decap_8
Xfanout1356 _11366_/C _11328_/S1 VDD VSS sg13g2_buf_1
XFILLER_93_304 VDD VSS sg13g2_fill_1
Xfanout1367 _12138_/S1 _12136_/S1 VDD VSS sg13g2_buf_1
XFILLER_93_315 VDD VSS sg13g2_decap_8
Xfanout380 _09630_/S _09636_/S VDD VSS sg13g2_buf_1
Xfanout1378 _11493_/S1 _11444_/S1 VDD VSS sg13g2_buf_1
Xfanout391 _09501_/S _09505_/S VDD VSS sg13g2_buf_1
Xfanout1389 _11597_/A _11854_/S0 VDD VSS sg13g2_buf_1
XFILLER_59_592 VDD VSS sg13g2_decap_8
X_13954_ _13954_/Q clkload44/A _13954_/D _13954_/RESET_B VDD VSS sg13g2_dfrbpq_1
XFILLER_19_445 VDD VSS sg13g2_decap_8
XFILLER_93_359 VDD VSS sg13g2_decap_8
XFILLER_46_220 VDD VSS sg13g2_decap_8
XFILLER_4_1057 VDD VSS sg13g2_decap_8
X_12905_ _12943_/A _14901_/Q _13686_/Q VDD VSS sg13g2_nor2_1
X_15037__2643 _15037_/RESET_B VDD VSS sg13g2_tiehi
XFILLER_34_404 VDD VSS sg13g2_decap_8
X_13885_ _13885_/Q _14883_/CLK _13885_/D _13885_/RESET_B VDD VSS sg13g2_dfrbpq_1
XFILLER_74_595 VDD VSS sg13g2_decap_8
X_12836_ _12836_/Y _14895_/Q _12836_/B _12836_/C VDD VSS sg13g2_nand3_1
X_15244__3105 _15244_/RESET_B VDD VSS sg13g2_tiehi
XFILLER_15_651 VDD VSS sg13g2_decap_8
Xclkbuf_5_13__f_clk_i clkbuf_leaf_51_clk_i/A clkbuf_4_6_0_clk_i/X VDD VSS sg13g2_buf_16
XFILLER_72_1215 VDD VSS sg13g2_fill_1
XFILLER_163_1343 VDD VSS sg13g2_decap_8
X_12767_ _12767_/X _13753_/Q _14105_/Q _14457_/Q _14553_/Q _12771_/S0 _12771_/S1 VDD
+ VSS sg13g2_mux4_1
X_14761__3048 _14761_/RESET_B VDD VSS sg13g2_tiehi
XFILLER_76_1395 VDD VSS sg13g2_decap_8
XFILLER_14_161 VDD VSS sg13g2_decap_8
XFILLER_159_133 VDD VSS sg13g2_fill_1
XFILLER_163_1354 VDD VSS sg13g2_fill_2
X_14506_ _14506_/Q clkload17/A _14506_/D _14506_/RESET_B VDD VSS sg13g2_dfrbpq_1
XFILLER_72_1248 VDD VSS sg13g2_decap_8
XFILLER_30_632 VDD VSS sg13g2_decap_8
X_11718_ _11718_/X _11710_/X _11711_/X _11714_/X _11715_/X _11443_/A _11446_/A VDD
+ VSS sg13g2_mux4_1
XFILLER_147_306 VDD VSS sg13g2_decap_4
XFILLER_163_1387 VDD VSS sg13g2_decap_4
X_12698_ _12698_/X _14388_/Q _14420_/Q _14484_/Q _14516_/Q _12783_/S0 _12783_/S1 VDD
+ VSS sg13g2_mux4_1
XFILLER_175_648 VDD VSS sg13g2_decap_4
X_14437_ _14437_/Q _14725_/CLK _14437_/D _14437_/RESET_B VDD VSS sg13g2_dfrbpq_1
X_14887__2863 _14887_/RESET_B VDD VSS sg13g2_tiehi
XFILLER_128_520 VDD VSS sg13g2_decap_8
Xinput11 input11/X input11/A VDD VSS sg13g2_buf_1
X_11649_ _11649_/X _14375_/Q _14407_/Q _14471_/Q _14503_/Q _11531_/A _12136_/S1 VDD
+ VSS sg13g2_mux4_1
Xinput22 input22/X input22/A VDD VSS sg13g2_buf_1
XFILLER_35_1092 VDD VSS sg13g2_decap_8
XFILLER_156_851 VDD VSS sg13g2_fill_1
XFILLER_174_147 VDD VSS sg13g2_decap_8
Xinput33 input33/X input33/A VDD VSS sg13g2_buf_1
XFILLER_122_1073 VDD VSS sg13g2_decap_8
XFILLER_155_350 VDD VSS sg13g2_fill_1
X_14368_ _14368_/Q clkload40/A _14368_/D _14368_/RESET_B VDD VSS sg13g2_dfrbpq_1
XFILLER_7_861 VDD VSS sg13g2_decap_8
XFILLER_156_884 VDD VSS sg13g2_fill_2
XFILLER_183_670 VDD VSS sg13g2_decap_8
XFILLER_115_203 VDD VSS sg13g2_decap_8
XFILLER_116_726 VDD VSS sg13g2_decap_8
XFILLER_122_1095 VDD VSS sg13g2_decap_8
Xmax_cap514 _09396_/S _09405_/S VDD VSS sg13g2_buf_8
X_15062__1524 _15062_/RESET_B VDD VSS sg13g2_tiehi
XFILLER_155_383 VDD VSS sg13g2_decap_8
X_13319_ _15063_/D _13324_/A _13319_/B VDD VSS sg13g2_nor2_1
XFILLER_6_371 VDD VSS sg13g2_decap_8
XFILLER_157_1136 VDD VSS sg13g2_decap_8
X_14299_ _14299_/Q clkload58/A _14299_/D _14299_/RESET_B VDD VSS sg13g2_dfrbpq_1
XFILLER_83_1300 VDD VSS sg13g2_decap_8
XFILLER_124_781 VDD VSS sg13g2_decap_8
X_08860_ _08860_/X _08859_/X _11483_/A _08895_/S VDD VSS sg13g2_mux2_1
XFILLER_170_1336 VDD VSS sg13g2_decap_4
XFILLER_44_1339 VDD VSS sg13g2_decap_8
XFILLER_96_142 VDD VSS sg13g2_decap_4
X_07811_ _08522_/A _07956_/A _07812_/B VDD VSS sg13g2_or2_1
XFILLER_69_367 VDD VSS sg13g2_decap_8
XFILLER_28_0 VDD VSS sg13g2_decap_8
XFILLER_85_827 VDD VSS sg13g2_decap_8
XFILLER_69_378 VDD VSS sg13g2_fill_1
X_08791_ _08791_/Y _13499_/C _15176_/Q _15119_/Q _13279_/B _08825_/C1 VDD VSS sg13g2_a221oi_1
XFILLER_97_698 VDD VSS sg13g2_decap_8
XFILLER_84_326 VDD VSS sg13g2_decap_8
X_07742_ _07744_/C _13300_/C wire705/X VDD VSS sg13g2_and2_1
XFILLER_42_1074 VDD VSS sg13g2_decap_8
XFILLER_93_860 VDD VSS sg13g2_fill_1
XFILLER_38_765 VDD VSS sg13g2_fill_2
XFILLER_77_1104 VDD VSS sg13g2_fill_1
XFILLER_168_1232 VDD VSS sg13g2_decap_4
XFILLER_53_713 VDD VSS sg13g2_decap_8
X_07673_ _07677_/B _15055_/Q _13293_/D VDD VSS sg13g2_nor2b_1
XFILLER_37_264 VDD VSS sg13g2_decap_8
XFILLER_20_1350 VDD VSS sg13g2_decap_8
XFILLER_0_1422 VDD VSS sg13g2_decap_8
XFILLER_16_28 VDD VSS sg13g2_decap_8
XFILLER_80_521 VDD VSS sg13g2_fill_2
X_09412_ _14014_/D _10074_/A0 _14014_/Q _09428_/S VDD VSS sg13g2_mux2_1
XFILLER_164_1107 VDD VSS sg13g2_decap_8
XFILLER_179_910 VDD VSS sg13g2_decap_8
X_13796__2476 _13796_/RESET_B VDD VSS sg13g2_tiehi
XFILLER_52_245 VDD VSS sg13g2_decap_8
XFILLER_34_960 VDD VSS sg13g2_decap_8
XFILLER_80_576 VDD VSS sg13g2_decap_8
X_09343_ _13947_/D _10138_/A1 _13947_/Q _09362_/S VDD VSS sg13g2_mux2_1
XFILLER_94_1473 VDD VSS sg13g2_fill_2
XFILLER_178_420 VDD VSS sg13g2_decap_8
XFILLER_90_1326 VDD VSS sg13g2_fill_2
X_14747__1525 _14747_/RESET_B VDD VSS sg13g2_tiehi
XFILLER_139_818 VDD VSS sg13g2_decap_8
XFILLER_16_1419 VDD VSS sg13g2_decap_8
XFILLER_179_987 VDD VSS sg13g2_decap_8
X_09274_ _09274_/Y _09307_/B _09707_/B _09707_/C VDD VSS sg13g2_nor3_1
XFILLER_142_1438 VDD VSS sg13g2_decap_8
XFILLER_138_328 VDD VSS sg13g2_decap_8
XFILLER_178_497 VDD VSS sg13g2_decap_8
X_08225_ _08233_/B _08224_/X _08397_/A _08004_/Y _08214_/X VDD VSS sg13g2_a22oi_1
XFILLER_32_49 VDD VSS sg13g2_decap_8
XFILLER_18_1290 VDD VSS sg13g2_decap_8
XFILLER_119_531 VDD VSS sg13g2_decap_8
XFILLER_165_136 VDD VSS sg13g2_decap_8
XFILLER_20_175 VDD VSS sg13g2_decap_8
X_14176__2096 _14176_/RESET_B VDD VSS sg13g2_tiehi
XFILLER_140_1140 VDD VSS sg13g2_fill_2
XFILLER_148_49 VDD VSS sg13g2_decap_8
XFILLER_165_158 VDD VSS sg13g2_decap_8
X_08156_ _08166_/C _08188_/A _08142_/A _08155_/Y _07869_/X _08154_/Y VDD VSS sg13g2_a221oi_1
XFILLER_105_1293 VDD VSS sg13g2_decap_8
XFILLER_147_884 VDD VSS sg13g2_decap_4
XFILLER_14_1176 VDD VSS sg13g2_decap_8
XFILLER_88_1233 VDD VSS sg13g2_decap_4
XFILLER_4_308 VDD VSS sg13g2_decap_8
XFILLER_101_1135 VDD VSS sg13g2_decap_8
XFILLER_10_1029 VDD VSS sg13g2_decap_8
XFILLER_174_681 VDD VSS sg13g2_decap_8
XFILLER_175_1203 VDD VSS sg13g2_decap_8
XFILLER_134_523 VDD VSS sg13g2_decap_8
XFILLER_179_1372 VDD VSS sg13g2_decap_8
XFILLER_49_1217 VDD VSS sg13g2_decap_8
XFILLER_101_1168 VDD VSS sg13g2_decap_4
XFILLER_106_7 VDD VSS sg13g2_decap_8
X_08087_ _08087_/X _08085_/A _08079_/X _08086_/B _08081_/X _08270_/B _08452_/D VDD
+ VSS sg13g2_mux4_1
XFILLER_122_718 VDD VSS sg13g2_decap_8
XFILLER_161_386 VDD VSS sg13g2_decap_8
XFILLER_0_525 VDD VSS sg13g2_decap_8
XFILLER_88_632 VDD VSS sg13g2_decap_8
XFILLER_121_239 VDD VSS sg13g2_decap_8
XFILLER_76_827 VDD VSS sg13g2_decap_8
XFILLER_180_14 VDD VSS sg13g2_decap_8
X_08989_ _08989_/X _09006_/A _08985_/X _08988_/Y VDD VSS sg13g2_a21o_1
XFILLER_75_315 VDD VSS sg13g2_decap_8
XFILLER_76_849 VDD VSS sg13g2_decap_8
XFILLER_5_1344 VDD VSS sg13g2_decap_8
XFILLER_151_1280 VDD VSS sg13g2_decap_4
XFILLER_25_1294 VDD VSS sg13g2_decap_8
X_14983__2697 _14983_/RESET_B VDD VSS sg13g2_tiehi
XFILLER_90_307 VDD VSS sg13g2_decap_8
XFILLER_99_1373 VDD VSS sg13g2_decap_8
XFILLER_21_1158 VDD VSS sg13g2_decap_8
X_10951_ _10956_/A _11004_/A _10949_/Y _10950_/Y VDD VSS sg13g2_o21ai_1
XFILLER_44_735 VDD VSS sg13g2_fill_2
XFILLER_71_521 VDD VSS sg13g2_decap_8
XFILLER_16_448 VDD VSS sg13g2_decap_8
X_13670_ _13670_/Q clkload83/A _13670_/D _13670_/RESET_B VDD VSS sg13g2_dfrbpq_1
XFILLER_95_1259 VDD VSS sg13g2_decap_8
XFILLER_147_1338 VDD VSS sg13g2_decap_8
X_10882_ _10883_/B _14753_/Q _10871_/A _10869_/B VDD VSS sg13g2_a21oi_1
XFILLER_186_1398 VDD VSS sg13g2_decap_4
XFILLER_32_919 VDD VSS sg13g2_fill_2
XFILLER_19_1010 VDD VSS sg13g2_fill_2
X_14386__1886 _14386_/RESET_B VDD VSS sg13g2_tiehi
X_12621_ _12621_/X _12620_/X _12619_/X _12616_/X _12615_/X _12622_/S0 _12705_/S1 VDD
+ VSS sg13g2_mux4_1
XFILLER_169_420 VDD VSS sg13g2_fill_1
XFILLER_25_982 VDD VSS sg13g2_decap_8
XFILLER_43_289 VDD VSS sg13g2_decap_8
XFILLER_169_442 VDD VSS sg13g2_decap_8
XFILLER_40_930 VDD VSS sg13g2_decap_8
XFILLER_145_1062 VDD VSS sg13g2_decap_8
X_12552_ _12552_/X _12550_/X _12549_/X _12546_/X _12545_/X _12775_/S1 _12720_/S VDD
+ VSS sg13g2_mux4_1
XFILLER_106_1035 VDD VSS sg13g2_decap_8
XFILLER_129_317 VDD VSS sg13g2_decap_8
XFILLER_12_665 VDD VSS sg13g2_decap_8
XFILLER_132_0 VDD VSS sg13g2_decap_8
XFILLER_19_1098 VDD VSS sg13g2_decap_8
X_11503_ _11777_/C _11503_/A1 _13687_/Q _13686_/Q _11483_/A _11463_/Y VDD VSS sg13g2_a221oi_1
XFILLER_157_648 VDD VSS sg13g2_decap_8
XFILLER_184_434 VDD VSS sg13g2_decap_8
X_12483_ _12483_/X _12481_/X _12482_/X _12776_/S VDD VSS sg13g2_mux2_1
XFILLER_11_175 VDD VSS sg13g2_decap_8
X_13841__2431 _13841_/RESET_B VDD VSS sg13g2_tiehi
X_14006__2266 _14006_/RESET_B VDD VSS sg13g2_tiehi
XFILLER_8_658 VDD VSS sg13g2_decap_8
XFILLER_71_1292 VDD VSS sg13g2_decap_8
X_14222_ _14222_/Q _14222_/CLK _14222_/D _14222_/RESET_B VDD VSS sg13g2_dfrbpq_1
X_11434_ _11434_/X _14112_/Q _14144_/Q _14176_/Q _14208_/Q _11493_/S0 _11493_/S1 VDD
+ VSS sg13g2_mux4_1
XFILLER_138_884 VDD VSS sg13g2_decap_8
XFILLER_184_489 VDD VSS sg13g2_decap_4
XFILLER_123_1393 VDD VSS sg13g2_decap_4
XFILLER_153_810 VDD VSS sg13g2_decap_8
XFILLER_7_168 VDD VSS sg13g2_decap_8
XFILLER_165_692 VDD VSS sg13g2_decap_8
X_14153_ _14153_/Q clkload35/A _14153_/D _14153_/RESET_B VDD VSS sg13g2_dfrbpq_1
X_11365_ _11366_/B _11365_/A _14494_/Q VDD VSS sg13g2_nand2_1
XFILLER_99_908 VDD VSS sg13g2_decap_8
XFILLER_164_191 VDD VSS sg13g2_fill_1
XFILLER_98_42 VDD VSS sg13g2_decap_8
XFILLER_180_651 VDD VSS sg13g2_decap_4
X_13104_ _13104_/Y _13104_/A _13104_/B VDD VSS sg13g2_xnor2_1
X_10316_ _14798_/D _10342_/A _10342_/C _10315_/Y VDD VSS sg13g2_a21oi_1
XFILLER_4_875 VDD VSS sg13g2_decap_8
XFILLER_125_589 VDD VSS sg13g2_decap_8
X_14084_ _14084_/Q _14503_/CLK _14084_/D _14084_/RESET_B VDD VSS sg13g2_dfrbpq_1
X_11296_ _11296_/Y _11212_/S _13853_/Q _11300_/S1 VDD VSS sg13g2_a21oi_1
XFILLER_65_1030 VDD VSS sg13g2_decap_8
XFILLER_140_526 VDD VSS sg13g2_decap_8
X_14221__2051 _14221_/RESET_B VDD VSS sg13g2_tiehi
XFILLER_117_1120 VDD VSS sg13g2_decap_8
X_13035_ _13035_/Y _13034_/Y _07683_/A _13031_/Y VDD VSS sg13g2_a21oi_1
XFILLER_3_385 VDD VSS sg13g2_decap_8
XFILLER_117_1131 VDD VSS sg13g2_fill_2
XFILLER_140_559 VDD VSS sg13g2_decap_8
X_10247_ _10255_/D _14775_/Q _14776_/Q _14777_/Q _10247_/D VDD VSS sg13g2_and4_1
XFILLER_65_1063 VDD VSS sg13g2_decap_8
X_13874__2398 _13874_/RESET_B VDD VSS sg13g2_tiehi
Xfanout1120 _08599_/B _08621_/B VDD VSS sg13g2_buf_1
XFILLER_67_816 VDD VSS sg13g2_fill_1
XFILLER_154_81 VDD VSS sg13g2_decap_8
Xfanout1131 _08033_/A _08109_/A1 VDD VSS sg13g2_buf_1
XFILLER_79_676 VDD VSS sg13g2_decap_8
XFILLER_117_1175 VDD VSS sg13g2_decap_8
XFILLER_21_7 VDD VSS sg13g2_decap_8
Xfanout1142 _08686_/S0 _13518_/A1 VDD VSS sg13g2_buf_1
XFILLER_152_1066 VDD VSS sg13g2_decap_4
Xfanout1153 _12278_/A _14987_/Q VDD VSS sg13g2_buf_1
X_10178_ _10182_/A _10178_/A _10185_/B _10184_/C VDD VSS sg13g2_nand3_1
XFILLER_121_795 VDD VSS sg13g2_decap_8
XFILLER_152_1077 VDD VSS sg13g2_fill_1
XFILLER_66_326 VDD VSS sg13g2_decap_8
Xclkbuf_leaf_7_clk_i clkload12/A clkbuf_leaf_9_clk_i/A VDD VSS sg13g2_buf_8
Xfanout1164 _08620_/A2 _12084_/A VDD VSS sg13g2_buf_1
XFILLER_93_112 VDD VSS sg13g2_decap_8
XFILLER_78_186 VDD VSS sg13g2_decap_4
Xfanout1175 _07818_/B _11936_/A VDD VSS sg13g2_buf_1
XFILLER_94_646 VDD VSS sg13g2_decap_8
XFILLER_130_1320 VDD VSS sg13g2_decap_8
Xfanout1186 _07949_/C _08510_/A3 VDD VSS sg13g2_buf_1
XFILLER_94_657 VDD VSS sg13g2_fill_2
Xfanout1197 _08457_/A3 _14972_/Q VDD VSS sg13g2_buf_1
XFILLER_19_231 VDD VSS sg13g2_decap_8
X_14986_ _14986_/Q clkload69/A _14986_/D _14986_/RESET_B VDD VSS sg13g2_dfrbpq_1
XFILLER_93_167 VDD VSS sg13g2_fill_1
XFILLER_35_713 VDD VSS sg13g2_decap_8
XFILLER_130_1375 VDD VSS sg13g2_fill_1
X_13937_ _13937_/Q clkload8/A _13937_/D _13937_/RESET_B VDD VSS sg13g2_dfrbpq_1
XFILLER_81_329 VDD VSS sg13g2_decap_4
XFILLER_74_370 VDD VSS sg13g2_decap_8
XFILLER_78_1457 VDD VSS sg13g2_decap_8
XFILLER_74_381 VDD VSS sg13g2_fill_1
XFILLER_34_212 VDD VSS sg13g2_decap_8
XFILLER_170_91 VDD VSS sg13g2_decap_8
X_13868_ _13868_/Q _14540_/CLK _13868_/D _13868_/RESET_B VDD VSS sg13g2_dfrbpq_1
XFILLER_35_768 VDD VSS sg13g2_fill_1
XFILLER_179_217 VDD VSS sg13g2_decap_8
XFILLER_23_919 VDD VSS sg13g2_decap_8
XFILLER_62_565 VDD VSS sg13g2_fill_2
XFILLER_50_716 VDD VSS sg13g2_decap_8
X_12819_ _12819_/Y _14768_/Q _13275_/A2 _13140_/B2 VDD VSS sg13g2_o21ai_1
X_13799_ _13799_/Q _14741_/CLK _13799_/D _13799_/RESET_B VDD VSS sg13g2_dfrbpq_1
XFILLER_163_1140 VDD VSS sg13g2_decap_8
XFILLER_37_1143 VDD VSS sg13g2_decap_8
XFILLER_128_1271 VDD VSS sg13g2_decap_8
XFILLER_176_913 VDD VSS sg13g2_fill_1
XFILLER_128_1282 VDD VSS sg13g2_fill_2
XFILLER_163_1173 VDD VSS sg13g2_decap_4
XFILLER_37_1176 VDD VSS sg13g2_decap_8
XFILLER_147_103 VDD VSS sg13g2_fill_2
XFILLER_31_985 VDD VSS sg13g2_decap_8
XFILLER_30_462 VDD VSS sg13g2_fill_2
XFILLER_148_648 VDD VSS sg13g2_decap_8
XFILLER_50_1321 VDD VSS sg13g2_fill_1
XFILLER_15_1452 VDD VSS sg13g2_decap_8
XFILLER_147_158 VDD VSS sg13g2_fill_2
XFILLER_163_607 VDD VSS sg13g2_decap_8
XFILLER_175_467 VDD VSS sg13g2_decap_8
X_08010_ _08010_/Y _08054_/B _12229_/A VDD VSS sg13g2_nand2_1
XFILLER_102_1422 VDD VSS sg13g2_decap_8
X_14431__1841 _14431_/RESET_B VDD VSS sg13g2_tiehi
XFILLER_8_84 VDD VSS sg13g2_decap_8
XFILLER_11_1316 VDD VSS sg13g2_decap_8
XFILLER_128_361 VDD VSS sg13g2_decap_8
XFILLER_116_512 VDD VSS sg13g2_fill_1
XFILLER_156_692 VDD VSS sg13g2_decap_8
XFILLER_50_1398 VDD VSS sg13g2_decap_4
XFILLER_85_1428 VDD VSS sg13g2_decap_8
XFILLER_116_556 VDD VSS sg13g2_decap_8
Xmax_cap355 _09858_/S _09862_/S VDD VSS sg13g2_buf_4
X_09961_ _14545_/D _14545_/Q _10093_/A0 _09961_/S VDD VSS sg13g2_mux2_1
XFILLER_89_429 VDD VSS sg13g2_decap_8
XFILLER_170_183 VDD VSS sg13g2_decap_8
X_08912_ _08912_/Y _10793_/A _10793_/B _15041_/Q VDD VSS sg13g2_nand3_1
XFILLER_48_1261 VDD VSS sg13g2_decap_8
XFILLER_170_194 VDD VSS sg13g2_fill_1
XFILLER_112_740 VDD VSS sg13g2_decap_8
X_09892_ _14478_/D _09925_/A1 _14478_/Q wire288/X VDD VSS sg13g2_mux2_1
X_13704__2568 _13704_/RESET_B VDD VSS sg13g2_tiehi
XFILLER_44_1125 VDD VSS sg13g2_decap_8
XFILLER_100_902 VDD VSS sg13g2_decap_4
XFILLER_69_142 VDD VSS sg13g2_decap_8
XFILLER_170_1144 VDD VSS sg13g2_fill_2
XFILLER_98_985 VDD VSS sg13g2_decap_8
XFILLER_100_913 VDD VSS sg13g2_decap_4
X_08843_ _08843_/Y _08843_/A _08850_/S VDD VSS sg13g2_nand2_1
XFILLER_131_1106 VDD VSS sg13g2_fill_1
XFILLER_58_838 VDD VSS sg13g2_decap_8
XFILLER_112_795 VDD VSS sg13g2_decap_8
XFILLER_85_624 VDD VSS sg13g2_decap_8
XFILLER_57_326 VDD VSS sg13g2_fill_1
XFILLER_22_1401 VDD VSS sg13g2_decap_8
XFILLER_170_1188 VDD VSS sg13g2_decap_8
XFILLER_100_968 VDD VSS sg13g2_fill_1
X_08774_ _13676_/D _08728_/Y _08773_/Y _08772_/Y VDD VSS sg13g2_a21oi_1
XFILLER_73_808 VDD VSS sg13g2_fill_1
XFILLER_84_167 VDD VSS sg13g2_decap_8
XFILLER_66_871 VDD VSS sg13g2_decap_8
X_07725_ _07726_/D _15089_/Q _15086_/Q _15076_/Q _15074_/Q VDD VSS sg13g2_nor4_1
XFILLER_27_49 VDD VSS sg13g2_decap_8
XFILLER_150_28 VDD VSS sg13g2_decap_8
XFILLER_65_370 VDD VSS sg13g2_decap_8
X_07656_ _07656_/Y _12000_/A VDD VSS sg13g2_inv_1
XFILLER_81_896 VDD VSS sg13g2_fill_2
XFILLER_179_740 VDD VSS sg13g2_decap_8
XFILLER_53_598 VDD VSS sg13g2_decap_8
XFILLER_41_738 VDD VSS sg13g2_decap_4
XFILLER_0_1296 VDD VSS sg13g2_decap_8
XFILLER_107_1300 VDD VSS sg13g2_decap_8
XFILLER_129_1079 VDD VSS sg13g2_fill_2
X_14968__2712 _14968_/RESET_B VDD VSS sg13g2_tiehi
XFILLER_40_237 VDD VSS sg13g2_decap_8
X_14263__2009 _14263_/RESET_B VDD VSS sg13g2_tiehi
X_09326_ _13933_/D _10156_/A1 _13933_/Q _09331_/S VDD VSS sg13g2_mux2_1
XFILLER_16_1216 VDD VSS sg13g2_decap_8
XFILLER_181_1262 VDD VSS sg13g2_decap_8
XFILLER_142_1224 VDD VSS sg13g2_decap_8
XFILLER_181_1273 VDD VSS sg13g2_fill_1
XFILLER_22_974 VDD VSS sg13g2_decap_8
XFILLER_55_1287 VDD VSS sg13g2_decap_8
XFILLER_139_648 VDD VSS sg13g2_decap_8
XFILLER_167_957 VDD VSS sg13g2_decap_4
XFILLER_142_1257 VDD VSS sg13g2_decap_8
XFILLER_178_294 VDD VSS sg13g2_decap_8
X_09257_ _13866_/D _13866_/Q _10153_/A1 _09267_/S VDD VSS sg13g2_mux2_1
XFILLER_90_1189 VDD VSS sg13g2_decap_8
XFILLER_139_659 VDD VSS sg13g2_fill_2
X_08208_ _08209_/A _08452_/A _08207_/X _08223_/S VDD VSS sg13g2_mux2_1
XFILLER_166_478 VDD VSS sg13g2_decap_8
XFILLER_175_14 VDD VSS sg13g2_decap_8
XFILLER_182_938 VDD VSS sg13g2_decap_8
X_09188_ _13804_/D _13804_/Q _10122_/A0 _09202_/S VDD VSS sg13g2_mux2_1
XFILLER_4_105 VDD VSS sg13g2_decap_8
XFILLER_134_320 VDD VSS sg13g2_decap_8
XFILLER_153_139 VDD VSS sg13g2_fill_1
XFILLER_181_448 VDD VSS sg13g2_decap_8
X_08139_ _08182_/B _08843_/A _08142_/B VDD VSS sg13g2_nor2_1
XFILLER_88_1074 VDD VSS sg13g2_decap_8
XFILLER_108_30 VDD VSS sg13g2_decap_8
XFILLER_135_876 VDD VSS sg13g2_decap_8
X_11150_ _11150_/Y _11150_/A _11150_/B VDD VSS sg13g2_nand2_1
XFILLER_1_812 VDD VSS sg13g2_decap_8
X_15243__3104 _15243_/RESET_B VDD VSS sg13g2_tiehi
XFILLER_108_85 VDD VSS sg13g2_decap_8
XFILLER_161_183 VDD VSS sg13g2_decap_8
X_10101_ _14681_/D _10101_/A0 _14681_/Q _10101_/S VDD VSS sg13g2_mux2_1
XFILLER_136_1039 VDD VSS sg13g2_decap_8
XFILLER_0_322 VDD VSS sg13g2_decap_8
X_14871__2895 _14871_/RESET_B VDD VSS sg13g2_tiehi
X_11081_ _11081_/Y _11140_/B2 _11077_/Y _11080_/Y VDD VSS sg13g2_a21oi_1
XFILLER_66_1372 VDD VSS sg13g2_decap_8
Xhold3250 _10862_/A _14932_/Q VDD VSS sg13g2_dlygate4sd3_1
XFILLER_62_1236 VDD VSS sg13g2_fill_1
XFILLER_27_1356 VDD VSS sg13g2_decap_8
XFILLER_1_889 VDD VSS sg13g2_decap_8
Xhold3261 _13527_/A _15142_/Q VDD VSS sg13g2_dlygate4sd3_1
X_10032_ _14614_/D _10098_/A0 _14614_/Q _10035_/S VDD VSS sg13g2_mux2_1
XFILLER_7_1428 VDD VSS sg13g2_decap_8
XFILLER_49_838 VDD VSS sg13g2_decap_8
XFILLER_130_581 VDD VSS sg13g2_fill_2
XFILLER_48_326 VDD VSS sg13g2_decap_8
XFILLER_0_399 VDD VSS sg13g2_decap_8
XFILLER_48_337 VDD VSS sg13g2_fill_2
XFILLER_76_657 VDD VSS sg13g2_decap_8
XFILLER_75_123 VDD VSS sg13g2_decap_4
X_14840_ _14840_/Q clkload68/A _14840_/D _14840_/RESET_B VDD VSS sg13g2_dfrbpq_1
XFILLER_5_1141 VDD VSS sg13g2_decap_8
XFILLER_91_605 VDD VSS sg13g2_decap_8
XFILLER_29_562 VDD VSS sg13g2_decap_8
X_14771_ _14771_/Q _15113_/CLK _14771_/D _14771_/RESET_B VDD VSS sg13g2_dfrbpq_1
X_11983_ _12055_/C _11983_/A _13671_/Q VDD VSS sg13g2_xnor2_1
XFILLER_99_1170 VDD VSS sg13g2_decap_4
XFILLER_44_510 VDD VSS sg13g2_decap_8
XFILLER_17_735 VDD VSS sg13g2_decap_8
X_13859__2413 _13859_/RESET_B VDD VSS sg13g2_tiehi
X_13722_ _16884_/A clkload72/A _13722_/D _13722_/RESET_B VDD VSS sg13g2_dfrbpq_1
X_10934_ _10934_/Y _10946_/A _10934_/B _10948_/D VDD VSS sg13g2_nand3_1
XFILLER_90_148 VDD VSS sg13g2_decap_8
XFILLER_16_245 VDD VSS sg13g2_decap_8
XFILLER_182_1004 VDD VSS sg13g2_decap_8
XFILLER_72_863 VDD VSS sg13g2_fill_2
XFILLER_147_1146 VDD VSS sg13g2_decap_8
XFILLER_147_1157 VDD VSS sg13g2_fill_1
X_13653_ _15119_/D _15189_/D _15119_/Q _13653_/S VDD VSS sg13g2_mux2_1
XFILLER_31_204 VDD VSS sg13g2_decap_8
X_10865_ _10865_/Y _10865_/A _10865_/B VDD VSS sg13g2_nand2_1
XFILLER_31_215 VDD VSS sg13g2_fill_1
XFILLER_31_226 VDD VSS sg13g2_decap_8
X_12604_ _12604_/X _14701_/Q _14733_/Q _13773_/Q _13805_/Q _12604_/S0 _12604_/S1 VDD
+ VSS sg13g2_mux4_1
XFILLER_13_952 VDD VSS sg13g2_decap_8
XFILLER_34_1305 VDD VSS sg13g2_decap_4
XFILLER_125_1433 VDD VSS sg13g2_decap_4
XFILLER_160_1313 VDD VSS sg13g2_decap_8
X_13584_ _13584_/Y _13584_/A _13593_/B VDD VSS sg13g2_nor2_1
X_10796_ _10796_/Y _10796_/A _13294_/B VDD VSS sg13g2_nand2_1
X_14239__2033 _14239_/RESET_B VDD VSS sg13g2_tiehi
XFILLER_12_462 VDD VSS sg13g2_decap_8
XFILLER_125_1466 VDD VSS sg13g2_decap_4
X_12535_ _12535_/X _13832_/Q _13864_/Q _13896_/Q _13928_/Q _12755_/S0 _12758_/S1 VDD
+ VSS sg13g2_mux4_1
XFILLER_9_945 VDD VSS sg13g2_decap_8
XFILLER_33_70 VDD VSS sg13g2_decap_8
XFILLER_160_1357 VDD VSS sg13g2_fill_1
XFILLER_173_916 VDD VSS sg13g2_decap_8
XFILLER_8_455 VDD VSS sg13g2_decap_8
XFILLER_32_1051 VDD VSS sg13g2_fill_2
X_12466_ _12466_/X _13955_/Q _13987_/Q _14019_/Q _14051_/Q _12715_/S0 _12715_/S1 VDD
+ VSS sg13g2_mux4_1
XFILLER_144_117 VDD VSS sg13g2_decap_8
XFILLER_69_7 VDD VSS sg13g2_decap_4
X_14205_ _14205_/Q _14222_/CLK _14205_/D _14205_/RESET_B VDD VSS sg13g2_dfrbpq_1
XFILLER_126_843 VDD VSS sg13g2_decap_8
X_11417_ _11419_/A _11418_/A _14175_/Q VDD VSS sg13g2_nand2b_1
XFILLER_125_320 VDD VSS sg13g2_decap_8
XFILLER_126_854 VDD VSS sg13g2_fill_2
X_15185_ _15185_/Q _15212_/CLK _15185_/D _15185_/RESET_B VDD VSS sg13g2_dfrbpq_1
X_12397_ _12397_/X _12392_/X _12394_/X _12391_/X _12393_/X _12355_/S wire856/X VDD
+ VSS sg13g2_mux4_1
XFILLER_158_1242 VDD VSS sg13g2_decap_4
XFILLER_158_1253 VDD VSS sg13g2_fill_2
XFILLER_153_673 VDD VSS sg13g2_decap_8
X_14136_ _14136_/Q clkload24/A _14136_/D _14136_/RESET_B VDD VSS sg13g2_dfrbpq_1
XFILLER_67_1147 VDD VSS sg13g2_decap_8
XFILLER_126_898 VDD VSS sg13g2_decap_8
X_11348_ _11348_/Y _11821_/S0 _14718_/Q _11805_/C VDD VSS sg13g2_a21oi_1
XFILLER_119_1226 VDD VSS sg13g2_fill_1
XFILLER_158_1275 VDD VSS sg13g2_decap_8
XFILLER_98_215 VDD VSS sg13g2_decap_8
XFILLER_4_672 VDD VSS sg13g2_decap_8
XFILLER_28_1109 VDD VSS sg13g2_decap_8
XFILLER_99_749 VDD VSS sg13g2_fill_1
XFILLER_10_1393 VDD VSS sg13g2_decap_8
XFILLER_165_91 VDD VSS sg13g2_decap_8
XFILLER_119_1259 VDD VSS sg13g2_decap_4
XFILLER_171_1420 VDD VSS sg13g2_fill_1
X_14067_ _14067_/Q clkload31/A _14067_/D _14067_/RESET_B VDD VSS sg13g2_dfrbpq_1
XFILLER_45_1423 VDD VSS sg13g2_decap_8
XFILLER_3_182 VDD VSS sg13g2_decap_8
XFILLER_140_345 VDD VSS sg13g2_decap_8
X_11279_ _11279_/Y _11279_/A1 _14204_/Q _11872_/B1 VDD VSS sg13g2_a21oi_1
XFILLER_171_1442 VDD VSS sg13g2_fill_1
XFILLER_132_1404 VDD VSS sg13g2_decap_8
X_13018_ _13018_/Y input25/X _12795_/Y _12937_/Y VDD VSS sg13g2_o21ai_1
XFILLER_171_1464 VDD VSS sg13g2_decap_4
XFILLER_95_933 VDD VSS sg13g2_fill_1
XFILLER_80_1358 VDD VSS sg13g2_decap_4
XFILLER_80_1369 VDD VSS sg13g2_fill_2
XFILLER_79_495 VDD VSS sg13g2_decap_4
XFILLER_121_592 VDD VSS sg13g2_decap_8
XFILLER_67_657 VDD VSS sg13g2_decap_8
XFILLER_95_999 VDD VSS sg13g2_decap_8
XFILLER_66_167 VDD VSS sg13g2_fill_2
XFILLER_48_871 VDD VSS sg13g2_decap_4
XFILLER_81_104 VDD VSS sg13g2_decap_8
XFILLER_54_318 VDD VSS sg13g2_decap_8
XFILLER_66_189 VDD VSS sg13g2_fill_1
X_14969_ _14969_/Q clkload71/A _14969_/D _14969_/RESET_B VDD VSS sg13g2_dfrbpq_1
XFILLER_35_510 VDD VSS sg13g2_decap_8
XFILLER_78_1232 VDD VSS sg13g2_decap_8
X_14449__1823 _14449_/RESET_B VDD VSS sg13g2_tiehi
XFILLER_81_137 VDD VSS sg13g2_decap_8
X_08490_ _08490_/Y _08489_/Y _08488_/Y _08675_/A1 VDD VSS sg13g2_a21oi_1
XFILLER_39_1216 VDD VSS sg13g2_fill_2
XFILLER_39_1227 VDD VSS sg13g2_decap_8
XFILLER_78_1298 VDD VSS sg13g2_decap_8
XFILLER_74_1129 VDD VSS sg13g2_fill_2
XFILLER_50_513 VDD VSS sg13g2_decap_8
XFILLER_35_587 VDD VSS sg13g2_decap_8
XFILLER_165_1257 VDD VSS sg13g2_decap_8
XFILLER_165_1268 VDD VSS sg13g2_fill_2
XFILLER_62_395 VDD VSS sg13g2_decap_8
XFILLER_91_1443 VDD VSS sg13g2_decap_4
XFILLER_95_0 VDD VSS sg13g2_decap_8
XFILLER_149_924 VDD VSS sg13g2_decap_8
XFILLER_22_259 VDD VSS sg13g2_decap_8
X_09111_ _09111_/Y _09126_/A1 _10757_/B _09110_/X VDD VSS sg13g2_o21ai_1
XFILLER_52_1449 VDD VSS sg13g2_decap_8
XFILLER_149_968 VDD VSS sg13g2_fill_2
XFILLER_31_782 VDD VSS sg13g2_decap_8
XFILLER_175_231 VDD VSS sg13g2_decap_8
XFILLER_164_916 VDD VSS sg13g2_decap_4
XFILLER_164_927 VDD VSS sg13g2_decap_8
X_09042_ _09043_/B _14907_/Q _14906_/Q VDD VSS sg13g2_nand2_1
XFILLER_50_1140 VDD VSS sg13g2_decap_8
XFILLER_11_1113 VDD VSS sg13g2_decap_8
XFILLER_163_415 VDD VSS sg13g2_decap_8
XFILLER_102_1252 VDD VSS sg13g2_decap_4
XFILLER_117_843 VDD VSS sg13g2_decap_8
XFILLER_135_139 VDD VSS sg13g2_fill_1
XFILLER_159_1039 VDD VSS sg13g2_fill_1
XFILLER_85_1203 VDD VSS sg13g2_decap_8
XFILLER_116_331 VDD VSS sg13g2_decap_8
Xclkbuf_leaf_108_clk_i clkload50/A clkbuf_5_16__f_clk_i/X VDD VSS sg13g2_buf_8
XFILLER_172_960 VDD VSS sg13g2_decap_8
XFILLER_2_609 VDD VSS sg13g2_decap_8
XFILLER_117_887 VDD VSS sg13g2_decap_8
XFILLER_176_1353 VDD VSS sg13g2_decap_8
XFILLER_116_364 VDD VSS sg13g2_decap_8
XFILLER_145_28 VDD VSS sg13g2_decap_8
XFILLER_176_1364 VDD VSS sg13g2_decap_8
XFILLER_1_119 VDD VSS sg13g2_decap_8
X_13937__2335 _13937_/RESET_B VDD VSS sg13g2_tiehi
XFILLER_137_1337 VDD VSS sg13g2_decap_4
XFILLER_143_172 VDD VSS sg13g2_decap_4
X_14697__1575 _14697_/RESET_B VDD VSS sg13g2_tiehi
Xfanout902 _12730_/S1 _12757_/S1 VDD VSS sg13g2_buf_1
X_09944_ _14528_/D _14528_/Q _10043_/A0 _09965_/S VDD VSS sg13g2_mux2_1
Xfanout913 _12756_/S1 _12745_/S1 VDD VSS sg13g2_buf_1
XFILLER_89_259 VDD VSS sg13g2_decap_8
Xfanout924 _12654_/S0 _12674_/S0 VDD VSS sg13g2_buf_1
Xfanout935 _12585_/S0 _12588_/S0 VDD VSS sg13g2_buf_1
Xfanout946 _12366_/S0 _12368_/S0 VDD VSS sg13g2_buf_1
Xfanout957 _12757_/S0 fanout966/X VDD VSS sg13g2_buf_1
X_09875_ _14461_/D _09875_/A0 _14461_/Q _09904_/S VDD VSS sg13g2_mux2_1
XFILLER_58_624 VDD VSS sg13g2_decap_8
XFILLER_135_1072 VDD VSS sg13g2_decap_4
XFILLER_57_112 VDD VSS sg13g2_decap_8
Xfanout979 _13303_/A _15207_/Q VDD VSS sg13g2_buf_1
XFILLER_85_432 VDD VSS sg13g2_decap_8
X_08826_ _08826_/Y _12836_/B _13482_/B VDD VSS sg13g2_nor2_1
XFILLER_86_966 VDD VSS sg13g2_decap_8
XFILLER_100_754 VDD VSS sg13g2_fill_1
XFILLER_161_49 VDD VSS sg13g2_decap_8
XFILLER_58_679 VDD VSS sg13g2_decap_8
XFILLER_79_1018 VDD VSS sg13g2_decap_8
XFILLER_113_1370 VDD VSS sg13g2_fill_2
X_08757_ _08757_/Y _07720_/A _07720_/B _15191_/Q VDD VSS sg13g2_o21ai_1
XFILLER_96_1310 VDD VSS sg13g2_decap_8
XFILLER_73_638 VDD VSS sg13g2_decap_8
XFILLER_45_329 VDD VSS sg13g2_decap_8
XFILLER_173_7 VDD VSS sg13g2_decap_8
XFILLER_57_189 VDD VSS sg13g2_decap_8
XFILLER_22_1275 VDD VSS sg13g2_decap_8
XFILLER_66_690 VDD VSS sg13g2_decap_8
XFILLER_54_14 VDD VSS sg13g2_decap_8
X_07708_ _07708_/Y _07708_/A _07708_/B _07708_/C VDD VSS sg13g2_nor3_1
XFILLER_2_1358 VDD VSS sg13g2_decap_8
X_08688_ _08693_/A _08688_/A _08688_/B _08688_/C _08688_/D VDD VSS sg13g2_nand4_1
XFILLER_26_554 VDD VSS sg13g2_fill_1
XFILLER_57_1327 VDD VSS sg13g2_decap_8
XFILLER_92_1218 VDD VSS sg13g2_decap_8
XFILLER_57_1338 VDD VSS sg13g2_fill_1
X_07639_ _10237_/B _14774_/Q VDD VSS sg13g2_inv_1
XFILLER_53_384 VDD VSS sg13g2_decap_8
XFILLER_41_524 VDD VSS sg13g2_decap_8
XFILLER_14_749 VDD VSS sg13g2_decap_8
XFILLER_183_1368 VDD VSS sg13g2_decap_4
XFILLER_0_1093 VDD VSS sg13g2_decap_8
XFILLER_110_42 VDD VSS sg13g2_decap_8
X_10650_ _10652_/C _14890_/Q _14889_/Q _14888_/Q _14887_/Q VDD VSS sg13g2_nand4_1
XFILLER_13_259 VDD VSS sg13g2_decap_8
XFILLER_41_568 VDD VSS sg13g2_fill_1
XFILLER_107_1130 VDD VSS sg13g2_decap_4
XFILLER_179_581 VDD VSS sg13g2_decap_8
XFILLER_139_423 VDD VSS sg13g2_decap_8
XFILLER_167_732 VDD VSS sg13g2_decap_8
XFILLER_181_1070 VDD VSS sg13g2_decap_8
X_09309_ _13916_/D _10139_/A1 _13916_/Q _09327_/S VDD VSS sg13g2_mux2_1
XFILLER_70_35 VDD VSS sg13g2_decap_8
XFILLER_166_231 VDD VSS sg13g2_decap_8
X_10581_ _10581_/Y _14872_/Q _10580_/A _10365_/C VDD VSS sg13g2_o21ai_1
X_14786__3020 _14786_/RESET_B VDD VSS sg13g2_tiehi
XFILLER_142_1065 VDD VSS sg13g2_fill_2
XFILLER_155_916 VDD VSS sg13g2_decap_8
XFILLER_186_35 VDD VSS sg13g2_decap_8
X_12320_ _12320_/Y _12330_/S0 _14490_/Q VDD VSS sg13g2_nand2b_1
XFILLER_103_1038 VDD VSS sg13g2_decap_8
XFILLER_10_966 VDD VSS sg13g2_decap_8
XFILLER_33_1371 VDD VSS sg13g2_decap_8
XFILLER_120_1330 VDD VSS sg13g2_fill_1
XFILLER_33_1382 VDD VSS sg13g2_fill_2
X_12251_ _12251_/Y _12247_/Y _12248_/Y _12250_/Y _12249_/Y _12253_/B VDD VSS sg13g2_a221oi_1
XFILLER_6_959 VDD VSS sg13g2_decap_8
XFILLER_107_331 VDD VSS sg13g2_fill_1
XFILLER_181_245 VDD VSS sg13g2_decap_8
XFILLER_182_768 VDD VSS sg13g2_decap_8
XFILLER_135_651 VDD VSS sg13g2_decap_8
X_11202_ _11202_/Y _11202_/A _11205_/A VDD VSS sg13g2_xnor2_1
XFILLER_5_469 VDD VSS sg13g2_decap_8
X_12182_ _12182_/Y _12179_/Y _12181_/X _11559_/C VDD VSS sg13g2_o21ai_1
XFILLER_64_1309 VDD VSS sg13g2_decap_8
XFILLER_122_312 VDD VSS sg13g2_decap_8
XFILLER_155_1426 VDD VSS sg13g2_fill_1
X_14527__1745 _14527_/RESET_B VDD VSS sg13g2_tiehi
X_11133_ _11133_/Y _11133_/A _11156_/B VDD VSS sg13g2_nand2_1
Xclkbuf_leaf_72_clk_i _15182_/CLK clkbuf_leaf_89_clk_i/A VDD VSS sg13g2_buf_8
XFILLER_122_356 VDD VSS sg13g2_decap_8
XFILLER_96_719 VDD VSS sg13g2_fill_1
XFILLER_95_207 VDD VSS sg13g2_fill_1
XFILLER_114_1101 VDD VSS sg13g2_decap_4
XFILLER_118_1270 VDD VSS sg13g2_decap_4
XFILLER_153_1150 VDD VSS sg13g2_decap_8
X_11064_ _11119_/A _11064_/A _11064_/B _11064_/C _11064_/D VDD VSS sg13g2_nand4_1
XFILLER_7_1225 VDD VSS sg13g2_decap_8
XFILLER_27_1153 VDD VSS sg13g2_decap_8
XFILLER_118_1281 VDD VSS sg13g2_decap_8
XFILLER_1_686 VDD VSS sg13g2_decap_8
XFILLER_49_624 VDD VSS sg13g2_decap_8
XFILLER_23_1006 VDD VSS sg13g2_decap_8
X_13791__2481 _13791_/RESET_B VDD VSS sg13g2_tiehi
XFILLER_77_955 VDD VSS sg13g2_decap_8
XFILLER_23_1017 VDD VSS sg13g2_fill_2
X_10015_ _14597_/D _10115_/A0 _14597_/Q _10027_/S VDD VSS sg13g2_mux2_1
XFILLER_62_1077 VDD VSS sg13g2_decap_8
XFILLER_0_196 VDD VSS sg13g2_decap_8
XFILLER_114_1167 VDD VSS sg13g2_decap_8
XFILLER_95_87 VDD VSS sg13g2_decap_8
XFILLER_76_465 VDD VSS sg13g2_decap_4
XFILLER_64_605 VDD VSS sg13g2_decap_4
XFILLER_36_307 VDD VSS sg13g2_fill_1
X_14742__1530 _14742_/RESET_B VDD VSS sg13g2_tiehi
Xclkbuf_leaf_87_clk_i clkload82/A clkbuf_leaf_88_clk_i/A VDD VSS sg13g2_buf_8
XFILLER_92_936 VDD VSS sg13g2_decap_8
X_14823_ _14823_/Q _14890_/CLK _14823_/D _14823_/RESET_B VDD VSS sg13g2_dfrbpq_1
XFILLER_63_104 VDD VSS sg13g2_decap_4
XFILLER_28_70 VDD VSS sg13g2_decap_8
XFILLER_64_649 VDD VSS sg13g2_decap_8
XFILLER_63_126 VDD VSS sg13g2_decap_4
XFILLER_17_532 VDD VSS sg13g2_decap_8
XFILLER_29_392 VDD VSS sg13g2_decap_8
XFILLER_40_1397 VDD VSS sg13g2_decap_8
X_14754_ _14754_/Q clkload80/A _14754_/D _14754_/RESET_B VDD VSS sg13g2_dfrbpq_1
X_11966_ _11966_/X _13840_/Q _13872_/Q _11969_/A VDD VSS sg13g2_mux2_1
X_13705_ _16867_/A _15237_/CLK _13705_/D _13705_/RESET_B VDD VSS sg13g2_dfrbpq_1
X_10917_ _10948_/C _15119_/Q _10954_/A VDD VSS sg13g2_xor2_1
XFILLER_45_896 VDD VSS sg13g2_decap_8
X_14685_ _14685_/Q _14685_/CLK _14685_/D _14685_/RESET_B VDD VSS sg13g2_dfrbpq_1
Xclkbuf_leaf_10_clk_i _14610_/CLK clkbuf_leaf_4_clk_i/A VDD VSS sg13g2_buf_8
XFILLER_44_384 VDD VSS sg13g2_decap_4
X_11897_ _11898_/B _11897_/A _11897_/B _11897_/C VDD VSS sg13g2_nand3_1
XFILLER_71_170 VDD VSS sg13g2_fill_2
XFILLER_177_518 VDD VSS sg13g2_decap_8
X_13636_ _13744_/D _13636_/A VDD VSS sg13g2_buf_1
XFILLER_60_866 VDD VSS sg13g2_decap_8
X_10848_ _10849_/B _07751_/B _10851_/C _10847_/Y VDD VSS sg13g2_o21ai_1
XFILLER_73_1151 VDD VSS sg13g2_decap_8
XFILLER_32_579 VDD VSS sg13g2_decap_8
XFILLER_38_1293 VDD VSS sg13g2_fill_2
XFILLER_158_754 VDD VSS sg13g2_decap_8
X_13567_ _13567_/Y _08203_/B _13600_/B _13566_/Y VDD VSS sg13g2_a21oi_1
XFILLER_121_1105 VDD VSS sg13g2_fill_1
X_10779_ _10779_/Y _14921_/Q _11156_/B VDD VSS sg13g2_nand2_1
XFILLER_9_742 VDD VSS sg13g2_decap_8
XFILLER_34_1157 VDD VSS sg13g2_decap_8
XFILLER_125_1274 VDD VSS sg13g2_decap_8
XFILLER_12_1400 VDD VSS sg13g2_decap_8
XFILLER_145_404 VDD VSS sg13g2_decap_8
Xclkbuf_leaf_25_clk_i clkload33/A clkload2/A VDD VSS sg13g2_buf_8
X_12518_ _12518_/X _14247_/Q _14279_/Q _14311_/Q _14343_/Q _12522_/S0 _12522_/S1 VDD
+ VSS sg13g2_mux4_1
XFILLER_118_629 VDD VSS sg13g2_decap_8
XFILLER_8_252 VDD VSS sg13g2_decap_8
XFILLER_173_735 VDD VSS sg13g2_decap_8
X_13498_ _15127_/D _13498_/A VDD VSS sg13g2_inv_1
XFILLER_185_595 VDD VSS sg13g2_decap_8
XFILLER_69_1209 VDD VSS sg13g2_decap_8
X_15237_ _15237_/Q _15237_/CLK _15237_/D _15237_/RESET_B VDD VSS sg13g2_dfrbpq_1
X_12449_ _12449_/X _14114_/Q _14146_/Q _14178_/Q _14210_/Q _12450_/S0 _12450_/S1 VDD
+ VSS sg13g2_mux4_1
XFILLER_12_1477 VDD VSS sg13g2_fill_2
X_14952__2733 _14952_/RESET_B VDD VSS sg13g2_tiehi
XFILLER_172_289 VDD VSS sg13g2_decap_8
X_15168_ _16854_/A clkload88/A _15168_/D _15168_/RESET_B VDD VSS sg13g2_dfrbpq_1
XFILLER_125_161 VDD VSS sg13g2_fill_2
XFILLER_5_63 VDD VSS sg13g2_decap_8
XFILLER_114_846 VDD VSS sg13g2_decap_4
XFILLER_10_1190 VDD VSS sg13g2_decap_8
X_14119_ _14119_/Q clkload13/A _14119_/D _14119_/RESET_B VDD VSS sg13g2_dfrbpq_1
X_15099_ _15099_/Q clkload89/A _15099_/D _15099_/RESET_B VDD VSS sg13g2_dfrbpq_1
Xfanout209 _10157_/A1 fanout210/X VDD VSS sg13g2_buf_1
X_07990_ _07991_/A _08831_/B _13281_/B _11458_/A _11241_/A VDD VSS sg13g2_or4_1
XFILLER_140_142 VDD VSS sg13g2_fill_1
XFILLER_68_900 VDD VSS sg13g2_fill_1
XFILLER_101_507 VDD VSS sg13g2_decap_8
XFILLER_113_367 VDD VSS sg13g2_decap_8
XFILLER_141_676 VDD VSS sg13g2_fill_2
XFILLER_68_922 VDD VSS sg13g2_decap_8
XFILLER_86_229 VDD VSS sg13g2_decap_8
XFILLER_67_410 VDD VSS sg13g2_decap_8
XFILLER_136_1381 VDD VSS sg13g2_fill_1
XFILLER_132_1223 VDD VSS sg13g2_decap_8
XFILLER_68_955 VDD VSS sg13g2_decap_8
XFILLER_132_1245 VDD VSS sg13g2_decap_8
X_14381__1891 _14381_/RESET_B VDD VSS sg13g2_tiehi
X_09660_ _14253_/D _09924_/A1 _14253_/Q _09665_/S VDD VSS sg13g2_mux2_1
XFILLER_83_903 VDD VSS sg13g2_decap_8
XFILLER_10_0 VDD VSS sg13g2_decap_8
XFILLER_83_914 VDD VSS sg13g2_fill_1
XFILLER_80_1199 VDD VSS sg13g2_decap_8
XFILLER_67_465 VDD VSS sg13g2_decap_8
X_08611_ _08611_/Y _07864_/Y _07960_/Y _07964_/Y VDD VSS sg13g2_o21ai_1
XFILLER_27_307 VDD VSS sg13g2_decap_8
XFILLER_54_104 VDD VSS sg13g2_decap_4
X_09591_ _14188_/D _14188_/Q _09956_/A1 _09605_/S VDD VSS sg13g2_mux2_1
XFILLER_94_295 VDD VSS sg13g2_decap_8
X_08542_ _08542_/Y _07808_/Y _08654_/B _08541_/Y VDD VSS sg13g2_o21ai_1
XFILLER_82_468 VDD VSS sg13g2_fill_1
XFILLER_35_351 VDD VSS sg13g2_fill_1
X_14001__2271 _14001_/RESET_B VDD VSS sg13g2_tiehi
XFILLER_91_991 VDD VSS sg13g2_fill_2
X_08473_ _08473_/Y _08472_/X _08654_/B _08494_/A VDD VSS sg13g2_a21oi_1
XFILLER_78_1095 VDD VSS sg13g2_decap_8
XFILLER_35_384 VDD VSS sg13g2_decap_8
XFILLER_62_181 VDD VSS sg13g2_decap_8
XFILLER_51_844 VDD VSS sg13g2_decap_8
XFILLER_24_28 VDD VSS sg13g2_decap_8
X_15242__3103 _15242_/RESET_B VDD VSS sg13g2_tiehi
XFILLER_149_732 VDD VSS sg13g2_fill_2
X_14605__1667 _14605_/RESET_B VDD VSS sg13g2_tiehi
XFILLER_149_754 VDD VSS sg13g2_decap_8
XFILLER_17_1355 VDD VSS sg13g2_decap_8
XFILLER_148_231 VDD VSS sg13g2_decap_4
XFILLER_104_1336 VDD VSS sg13g2_decap_4
XFILLER_164_713 VDD VSS sg13g2_decap_8
XFILLER_143_1396 VDD VSS sg13g2_decap_8
XFILLER_178_1404 VDD VSS sg13g2_decap_8
XFILLER_164_735 VDD VSS sg13g2_decap_8
X_09025_ _09025_/X _09057_/A _09021_/X _09024_/X VDD VSS sg13g2_a21o_1
XFILLER_40_49 VDD VSS sg13g2_decap_8
XFILLER_156_49 VDD VSS sg13g2_fill_2
XFILLER_151_407 VDD VSS sg13g2_decap_8
XFILLER_105_813 VDD VSS sg13g2_decap_8
XFILLER_2_406 VDD VSS sg13g2_decap_8
XFILLER_104_301 VDD VSS sg13g2_decap_4
XFILLER_137_1101 VDD VSS sg13g2_fill_2
XFILLER_137_1112 VDD VSS sg13g2_decap_8
XFILLER_176_1161 VDD VSS sg13g2_fill_1
XFILLER_49_14 VDD VSS sg13g2_decap_8
XFILLER_131_120 VDD VSS sg13g2_decap_8
Xclkbuf_4_8_0_clk_i clkbuf_4_8_0_clk_i/X clkbuf_0_clk_i/X VDD VSS sg13g2_buf_8
XFILLER_176_1194 VDD VSS sg13g2_decap_8
XFILLER_132_665 VDD VSS sg13g2_fill_2
Xfanout710 _13275_/A2 _12918_/A2 VDD VSS sg13g2_buf_1
XFILLER_85_1099 VDD VSS sg13g2_decap_8
XFILLER_172_1058 VDD VSS sg13g2_decap_8
Xfanout721 _11045_/B1 _10999_/B1 VDD VSS sg13g2_buf_1
Xfanout732 _11868_/A _12156_/A VDD VSS sg13g2_buf_1
XFILLER_77_218 VDD VSS sg13g2_decap_8
XFILLER_150_1301 VDD VSS sg13g2_decap_4
X_09927_ _14512_/D _14512_/Q _09927_/A1 _09929_/S VDD VSS sg13g2_mux2_1
XFILLER_115_1421 VDD VSS sg13g2_decap_8
Xfanout743 _08719_/S _13333_/S VDD VSS sg13g2_buf_1
Xfanout754 _12217_/A _07656_/Y VDD VSS sg13g2_buf_1
XFILLER_63_1364 VDD VSS sg13g2_fill_2
Xfanout765 _11329_/B1 _11875_/B VDD VSS sg13g2_buf_1
XFILLER_105_42 VDD VSS sg13g2_decap_4
XFILLER_24_1337 VDD VSS sg13g2_decap_8
Xfanout787 _12328_/B1 _07654_/Y VDD VSS sg13g2_buf_1
X_09858_ _14445_/D _14445_/Q _10089_/A0 _09858_/S VDD VSS sg13g2_mux2_1
XFILLER_115_1476 VDD VSS sg13g2_fill_2
Xfanout798 _11188_/C1 _10869_/A VDD VSS sg13g2_buf_1
XFILLER_45_104 VDD VSS sg13g2_decap_8
XFILLER_18_329 VDD VSS sg13g2_decap_8
X_08809_ _08811_/A _13279_/B _14751_/Q _08727_/X _15194_/Q _08825_/C1 VDD VSS sg13g2_a221oi_1
X_09789_ _14378_/D _09921_/A1 _14378_/Q _09793_/S VDD VSS sg13g2_mux2_1
XFILLER_74_958 VDD VSS sg13g2_decap_8
XFILLER_22_1072 VDD VSS sg13g2_decap_8
X_11820_ _11820_/Y _11816_/Y _11817_/Y _11819_/Y _11818_/Y _11822_/B VDD VSS sg13g2_a221oi_1
XFILLER_2_1155 VDD VSS sg13g2_decap_8
XFILLER_61_619 VDD VSS sg13g2_fill_2
XFILLER_42_811 VDD VSS sg13g2_decap_8
XFILLER_148_1241 VDD VSS sg13g2_decap_8
XFILLER_92_1004 VDD VSS sg13g2_fill_2
XFILLER_82_980 VDD VSS sg13g2_decap_8
XFILLER_109_1203 VDD VSS sg13g2_decap_8
X_11751_ _11751_/Y _11753_/S0 _14506_/Q _11802_/B VDD VSS sg13g2_a21oi_1
XFILLER_92_1026 VDD VSS sg13g2_decap_8
XFILLER_18_1108 VDD VSS sg13g2_decap_8
XFILLER_14_546 VDD VSS sg13g2_decap_8
XFILLER_92_1048 VDD VSS sg13g2_fill_1
X_10702_ _10702_/Y _10702_/A _10903_/B VDD VSS sg13g2_nand2_1
XFILLER_144_1127 VDD VSS sg13g2_decap_8
X_14470_ _14470_/Q clkload20/A _14470_/D _14470_/RESET_B VDD VSS sg13g2_dfrbpq_1
X_11682_ _11682_/Y _12114_/S0 _14408_/Q _11970_/C VDD VSS sg13g2_a21oi_1
XFILLER_70_1302 VDD VSS sg13g2_decap_4
X_13421_ _13421_/Y _13448_/B _13421_/B _13459_/C VDD VSS sg13g2_nand3b_1
XFILLER_139_220 VDD VSS sg13g2_fill_2
XFILLER_161_1441 VDD VSS sg13g2_decap_4
X_10633_ _14885_/D _10633_/A _10633_/B _10633_/C VDD VSS sg13g2_nor3_1
XFILLER_122_1425 VDD VSS sg13g2_fill_1
X_15139__2772 _15139_/RESET_B VDD VSS sg13g2_tiehi
XFILLER_31_1319 VDD VSS sg13g2_decap_8
XFILLER_128_938 VDD VSS sg13g2_decap_4
X_13352_ _15071_/D _15071_/Q _13501_/A _13351_/Y VDD VSS sg13g2_a21o_1
XFILLER_10_763 VDD VSS sg13g2_decap_8
X_10564_ _10565_/D _14860_/Q _14859_/Q _14858_/Q _14857_/Q VDD VSS sg13g2_nand4_1
XFILLER_122_1458 VDD VSS sg13g2_decap_8
XFILLER_154_212 VDD VSS sg13g2_decap_8
XFILLER_182_532 VDD VSS sg13g2_decap_8
X_12303_ _12303_/X _14138_/Q _14170_/Q _12306_/A VDD VSS sg13g2_mux2_1
X_13283_ _13291_/A _13283_/A _13287_/A VDD VSS sg13g2_nand2_1
XFILLER_6_756 VDD VSS sg13g2_decap_8
X_10495_ _10497_/B _14852_/Q _10508_/A _14850_/Q _10495_/D VDD VSS sg13g2_nand4_1
XFILLER_120_1160 VDD VSS sg13g2_decap_8
XFILLER_136_971 VDD VSS sg13g2_fill_1
X_15022_ _15022_/Q clkload84/A _15022_/D _15022_/RESET_B VDD VSS sg13g2_dfrbpq_1
XFILLER_114_109 VDD VSS sg13g2_decap_8
X_12234_ _12236_/A _12232_/S _14200_/Q VDD VSS sg13g2_nand2b_1
XFILLER_5_266 VDD VSS sg13g2_decap_8
XFILLER_136_993 VDD VSS sg13g2_decap_8
XFILLER_170_738 VDD VSS sg13g2_decap_4
XFILLER_135_481 VDD VSS sg13g2_decap_8
XFILLER_135_492 VDD VSS sg13g2_fill_1
X_13678__2609 _13678_/RESET_B VDD VSS sg13g2_tiehi
XFILLER_68_1275 VDD VSS sg13g2_fill_1
XFILLER_155_1234 VDD VSS sg13g2_decap_8
X_14043__2229 _14043_/RESET_B VDD VSS sg13g2_tiehi
X_12165_ _12165_/X _14582_/Q _14614_/Q _12168_/A VDD VSS sg13g2_mux2_1
XFILLER_9_1309 VDD VSS sg13g2_decap_8
XFILLER_116_1207 VDD VSS sg13g2_decap_4
X_14189__2083 _14189_/RESET_B VDD VSS sg13g2_tiehi
XFILLER_122_153 VDD VSS sg13g2_decap_4
XFILLER_2_973 VDD VSS sg13g2_decap_8
X_11116_ _11190_/C _11138_/B _11138_/C VDD VSS sg13g2_nand2_1
X_12096_ _12096_/Y _12090_/A _14612_/Q _12091_/C VDD VSS sg13g2_a21oi_1
XFILLER_1_483 VDD VSS sg13g2_decap_8
XFILLER_7_1022 VDD VSS sg13g2_decap_8
XFILLER_42_1426 VDD VSS sg13g2_fill_2
X_11047_ _14944_/D _07616_/Y _10671_/Y _11046_/Y VDD VSS sg13g2_o21ai_1
XFILLER_49_476 VDD VSS sg13g2_decap_8
Xinput9 input9/X input9/A VDD VSS sg13g2_buf_1
XFILLER_76_262 VDD VSS sg13g2_fill_1
XFILLER_65_936 VDD VSS sg13g2_fill_1
XFILLER_162_92 VDD VSS sg13g2_decap_4
XFILLER_7_1099 VDD VSS sg13g2_decap_8
XFILLER_76_284 VDD VSS sg13g2_decap_8
XFILLER_149_1016 VDD VSS sg13g2_decap_4
X_14806_ _14806_/Q _14864_/CLK _14806_/D _14806_/RESET_B VDD VSS sg13g2_dfrbpq_1
X_12998_ _12998_/Y input24/X _12997_/Y _12937_/Y VDD VSS sg13g2_o21ai_1
XFILLER_166_1341 VDD VSS sg13g2_decap_8
X_14737_ _14737_/Q clkload7/A _14737_/D _14737_/RESET_B VDD VSS sg13g2_dfrbpq_1
XFILLER_33_833 VDD VSS sg13g2_fill_1
XFILLER_127_1314 VDD VSS sg13g2_decap_8
X_11949_ _11953_/A _11948_/X _11967_/B VDD VSS sg13g2_nand2b_1
XFILLER_162_1205 VDD VSS sg13g2_decap_8
XFILLER_33_855 VDD VSS sg13g2_decap_8
XFILLER_166_1385 VDD VSS sg13g2_fill_1
XFILLER_60_652 VDD VSS sg13g2_decap_8
XFILLER_127_1347 VDD VSS sg13g2_decap_8
XFILLER_177_315 VDD VSS sg13g2_decap_8
XFILLER_60_663 VDD VSS sg13g2_fill_1
XFILLER_178_849 VDD VSS sg13g2_decap_4
XFILLER_20_505 VDD VSS sg13g2_decap_8
X_14668_ _14668_/Q clkload26/A _14668_/D _14668_/RESET_B VDD VSS sg13g2_dfrbpq_1
X_14996__2684 _14996_/RESET_B VDD VSS sg13g2_tiehi
X_13619_ _13727_/D _13619_/A VDD VSS sg13g2_buf_1
XFILLER_125_1060 VDD VSS sg13g2_decap_8
X_14599_ _14599_/Q _14727_/CLK _14599_/D _14599_/RESET_B VDD VSS sg13g2_dfrbpq_1
XFILLER_145_201 VDD VSS sg13g2_decap_8
XFILLER_145_212 VDD VSS sg13g2_fill_2
XFILLER_146_746 VDD VSS sg13g2_fill_1
XFILLER_185_392 VDD VSS sg13g2_decap_8
X_14399__1873 _14399_/RESET_B VDD VSS sg13g2_tiehi
XFILLER_86_1320 VDD VSS sg13g2_decap_8
XFILLER_12_1274 VDD VSS sg13g2_decap_8
XFILLER_145_278 VDD VSS sg13g2_decap_8
XFILLER_58_0 VDD VSS sg13g2_decap_8
XFILLER_173_598 VDD VSS sg13g2_decap_8
XFILLER_114_610 VDD VSS sg13g2_fill_1
XFILLER_161_749 VDD VSS sg13g2_decap_8
XFILLER_138_1454 VDD VSS sg13g2_fill_1
XFILLER_160_259 VDD VSS sg13g2_decap_8
XFILLER_82_1239 VDD VSS sg13g2_decap_8
XFILLER_134_1307 VDD VSS sg13g2_decap_8
X_14019__2253 _14019_/RESET_B VDD VSS sg13g2_tiehi
XFILLER_114_698 VDD VSS sg13g2_decap_8
X_07973_ _07974_/C _08663_/A _08678_/A _07971_/Y VDD VSS sg13g2_o21ai_1
XFILLER_19_28 VDD VSS sg13g2_decap_8
X_09712_ _14303_/D _10142_/A1 _14303_/Q _09727_/S VDD VSS sg13g2_mux2_1
XFILLER_68_752 VDD VSS sg13g2_decap_8
XFILLER_67_240 VDD VSS sg13g2_decap_8
X_09643_ _14236_/D _10139_/A1 _14236_/Q _09673_/S VDD VSS sg13g2_mux2_1
XFILLER_56_958 VDD VSS sg13g2_decap_8
XFILLER_3_1442 VDD VSS sg13g2_decap_8
X_09574_ _14171_/D _14171_/Q _10138_/A1 _09605_/S VDD VSS sg13g2_mux2_1
XFILLER_55_468 VDD VSS sg13g2_decap_8
XFILLER_43_608 VDD VSS sg13g2_decap_8
X_13887__2385 _13887_/RESET_B VDD VSS sg13g2_tiehi
XFILLER_83_788 VDD VSS sg13g2_decap_8
XFILLER_71_928 VDD VSS sg13g2_decap_4
X_08525_ _08526_/A _08209_/X _08544_/B _08521_/X _08637_/B _08524_/Y VDD VSS sg13g2_a221oi_1
XFILLER_93_1324 VDD VSS sg13g2_decap_8
XFILLER_36_682 VDD VSS sg13g2_decap_8
XFILLER_35_49 VDD VSS sg13g2_decap_8
XFILLER_19_1406 VDD VSS sg13g2_decap_8
X_08456_ _08461_/C _08470_/A _08456_/B _15007_/Q VDD VSS sg13g2_nand3_1
XFILLER_145_1469 VDD VSS sg13g2_fill_1
XFILLER_51_685 VDD VSS sg13g2_decap_8
XFILLER_168_359 VDD VSS sg13g2_decap_8
XFILLER_17_1152 VDD VSS sg13g2_decap_8
X_08387_ _08387_/Y _08692_/A _08382_/X _08380_/Y _08637_/B _08386_/Y VDD VSS sg13g2_a221oi_1
XFILLER_149_551 VDD VSS sg13g2_decap_8
XFILLER_143_1160 VDD VSS sg13g2_decap_8
XFILLER_91_1092 VDD VSS sg13g2_decap_4
XFILLER_137_713 VDD VSS sg13g2_decap_8
XFILLER_143_1171 VDD VSS sg13g2_fill_2
XFILLER_183_329 VDD VSS sg13g2_decap_8
XFILLER_176_392 VDD VSS sg13g2_decap_8
XFILLER_164_565 VDD VSS sg13g2_decap_8
XFILLER_136_267 VDD VSS sg13g2_decap_4
XFILLER_152_727 VDD VSS sg13g2_decap_8
X_15127__2798 _15127_/RESET_B VDD VSS sg13g2_tiehi
X_09008_ _13762_/D _13762_/Q _10145_/A1 _09153_/S VDD VSS sg13g2_mux2_1
XFILLER_124_429 VDD VSS sg13g2_fill_1
X_10280_ _10282_/A _14788_/Q _10311_/A _10423_/C VDD VSS sg13g2_o21ai_1
XFILLER_2_203 VDD VSS sg13g2_decap_8
XFILLER_183_14 VDD VSS sg13g2_decap_8
XFILLER_65_1426 VDD VSS sg13g2_decap_8
XFILLER_65_1448 VDD VSS sg13g2_fill_2
XFILLER_116_41 VDD VSS sg13g2_decap_8
XFILLER_152_1418 VDD VSS sg13g2_decap_8
Xfanout1505 _13600_/C _13427_/B VDD VSS sg13g2_buf_1
XFILLER_104_175 VDD VSS sg13g2_fill_1
XFILLER_120_635 VDD VSS sg13g2_decap_8
Xfanout540 _08765_/A1 _08729_/Y VDD VSS sg13g2_buf_1
XFILLER_28_1270 VDD VSS sg13g2_decap_8
Xfanout551 _13654_/S _13502_/A VDD VSS sg13g2_buf_1
XFILLER_63_1161 VDD VSS sg13g2_decap_4
Xfanout562 _13570_/S fanout565/X VDD VSS sg13g2_buf_1
X_13970_ _13970_/Q _14674_/CLK _13970_/D _13970_/RESET_B VDD VSS sg13g2_dfrbpq_1
Xfanout573 _12442_/A2 _12358_/Y VDD VSS sg13g2_buf_1
XFILLER_76_56 VDD VSS sg13g2_decap_8
XFILLER_24_1134 VDD VSS sg13g2_decap_8
XFILLER_8_1386 VDD VSS sg13g2_decap_8
XFILLER_86_560 VDD VSS sg13g2_decap_8
XFILLER_150_1153 VDD VSS sg13g2_decap_8
Xfanout595 _09090_/A _09166_/A1 VDD VSS sg13g2_buf_1
XFILLER_47_925 VDD VSS sg13g2_decap_8
XFILLER_19_627 VDD VSS sg13g2_decap_4
XFILLER_46_413 VDD VSS sg13g2_decap_8
XFILLER_101_893 VDD VSS sg13g2_decap_8
X_12921_ _15028_/D _13266_/A _12921_/B VDD VSS sg13g2_nor2_1
XFILLER_98_1224 VDD VSS sg13g2_decap_8
XFILLER_86_582 VDD VSS sg13g2_fill_1
XFILLER_58_273 VDD VSS sg13g2_decap_8
XFILLER_4_1239 VDD VSS sg13g2_decap_8
XFILLER_18_126 VDD VSS sg13g2_decap_8
XFILLER_74_766 VDD VSS sg13g2_decap_4
XFILLER_185_1227 VDD VSS sg13g2_decap_8
X_12852_ _12852_/Y _14834_/Q _07728_/B _12895_/B _14866_/Q _13248_/B VDD VSS sg13g2_a221oi_1
XFILLER_34_619 VDD VSS sg13g2_decap_4
X_13717__2555 _13717_/RESET_B VDD VSS sg13g2_tiehi
X_14477__1795 _14477_/RESET_B VDD VSS sg13g2_tiehi
XFILLER_162_0 VDD VSS sg13g2_decap_8
XFILLER_61_427 VDD VSS sg13g2_decap_8
X_11803_ _11805_/A _11804_/A _14188_/Q VDD VSS sg13g2_nand2b_1
XFILLER_55_991 VDD VSS sg13g2_decap_8
X_12783_ _12783_/X _14266_/Q _14298_/Q _14330_/Q _14362_/Q _12783_/S0 _12783_/S1 VDD
+ VSS sg13g2_mux4_1
XFILLER_109_1011 VDD VSS sg13g2_decap_8
XFILLER_14_343 VDD VSS sg13g2_decap_8
X_14522_ _14522_/Q _14620_/CLK _14522_/D _14522_/RESET_B VDD VSS sg13g2_dfrbpq_1
X_11734_ _11734_/Y _11730_/Y _11731_/Y _11733_/Y _11732_/Y _11763_/B VDD VSS sg13g2_a221oi_1
XFILLER_15_877 VDD VSS sg13g2_decap_8
XFILLER_159_337 VDD VSS sg13g2_decap_8
XFILLER_15_899 VDD VSS sg13g2_decap_8
XFILLER_30_836 VDD VSS sg13g2_decap_8
X_14453_ _14453_/Q _14727_/CLK _14453_/D _14453_/RESET_B VDD VSS sg13g2_dfrbpq_1
X_11665_ _11665_/Y _12100_/S0 _13832_/Q VDD VSS sg13g2_nand2b_1
XFILLER_41_184 VDD VSS sg13g2_decap_8
XFILLER_30_847 VDD VSS sg13g2_fill_2
XFILLER_175_819 VDD VSS sg13g2_decap_8
XFILLER_186_156 VDD VSS sg13g2_decap_8
XFILLER_70_1132 VDD VSS sg13g2_decap_4
XFILLER_186_167 VDD VSS sg13g2_decap_8
XFILLER_168_871 VDD VSS sg13g2_decap_8
X_13932__2340 _13932_/RESET_B VDD VSS sg13g2_tiehi
X_13404_ _15089_/D _13435_/A _13396_/D _13403_/Y VDD VSS sg13g2_o21ai_1
X_14692__1580 _14692_/RESET_B VDD VSS sg13g2_tiehi
X_10616_ _14880_/D _07620_/Y _10611_/A _10615_/Y VDD VSS sg13g2_a21oi_1
XFILLER_35_1274 VDD VSS sg13g2_decap_8
X_14384_ _14384_/Q clkload10/A _14384_/D _14384_/RESET_B VDD VSS sg13g2_dfrbpq_1
XFILLER_122_1244 VDD VSS sg13g2_decap_8
XFILLER_183_830 VDD VSS sg13g2_fill_1
X_11596_ _11598_/A _11597_/A _14182_/Q VDD VSS sg13g2_nand2b_1
XFILLER_10_560 VDD VSS sg13g2_decap_8
X_13335_ _13486_/B hold3121/X _15170_/Q _13336_/S VDD VSS sg13g2_mux2_1
XFILLER_41_70 VDD VSS sg13g2_decap_8
X_10547_ _10556_/D _14864_/Q _14863_/Q _10566_/D _10547_/D VDD VSS sg13g2_and4_1
XFILLER_116_919 VDD VSS sg13g2_decap_8
XFILLER_122_1288 VDD VSS sg13g2_decap_8
XFILLER_155_565 VDD VSS sg13g2_decap_8
XFILLER_155_576 VDD VSS sg13g2_fill_1
Xmax_cap718 _08104_/B wire719/X VDD VSS sg13g2_buf_2
XFILLER_6_553 VDD VSS sg13g2_decap_8
X_13266_ _15051_/D _13266_/A _13266_/B VDD VSS sg13g2_nor2_1
XFILLER_51_7 VDD VSS sg13g2_decap_8
X_10478_ _14847_/D _10580_/B _10478_/B _10489_/D VDD VSS sg13g2_nor3_1
XFILLER_124_930 VDD VSS sg13g2_decap_8
XFILLER_29_1001 VDD VSS sg13g2_decap_8
X_15005_ _15005_/Q clkload43/A _15005_/D _15005_/RESET_B VDD VSS sg13g2_dfrbpq_1
X_12217_ _12217_/Y _12217_/A _12217_/B VDD VSS sg13g2_nor2_1
XFILLER_124_963 VDD VSS sg13g2_decap_8
XFILLER_155_1020 VDD VSS sg13g2_decap_8
X_13197_ _13197_/Y _13196_/Y _13297_/A0 _13192_/X _13253_/B2 VDD VSS sg13g2_a22oi_1
XFILLER_9_1106 VDD VSS sg13g2_decap_8
XFILLER_69_505 VDD VSS sg13g2_fill_2
XFILLER_151_782 VDD VSS sg13g2_decap_8
X_15241__3102 _15241_/RESET_B VDD VSS sg13g2_tiehi
X_12148_ _12149_/B _11664_/A _12132_/Y _12147_/Y VDD VSS sg13g2_o21ai_1
XFILLER_97_847 VDD VSS sg13g2_fill_2
XFILLER_2_770 VDD VSS sg13g2_decap_8
XFILLER_116_1026 VDD VSS sg13g2_decap_8
XFILLER_155_1086 VDD VSS sg13g2_decap_8
XFILLER_150_292 VDD VSS sg13g2_decap_8
XFILLER_173_91 VDD VSS sg13g2_decap_8
XFILLER_1_280 VDD VSS sg13g2_decap_8
XFILLER_42_1223 VDD VSS sg13g2_fill_2
X_12079_ _12079_/Y _13190_/A _12122_/A2 _12156_/A VDD VSS sg13g2_a21oi_1
XFILLER_96_368 VDD VSS sg13g2_decap_8
XFILLER_2_42 VDD VSS sg13g2_decap_8
XFILLER_133_1351 VDD VSS sg13g2_decap_8
XFILLER_38_914 VDD VSS sg13g2_decap_4
XFILLER_65_711 VDD VSS sg13g2_decap_8
XFILLER_77_582 VDD VSS sg13g2_decap_4
XFILLER_64_210 VDD VSS sg13g2_decap_8
XFILLER_168_1425 VDD VSS sg13g2_decap_8
XFILLER_92_552 VDD VSS sg13g2_decap_4
XFILLER_80_725 VDD VSS sg13g2_decap_4
XFILLER_18_671 VDD VSS sg13g2_fill_2
X_14307__1965 _14307_/RESET_B VDD VSS sg13g2_tiehi
XFILLER_80_736 VDD VSS sg13g2_fill_2
XFILLER_75_1010 VDD VSS sg13g2_decap_8
XFILLER_52_427 VDD VSS sg13g2_decap_8
XFILLER_46_991 VDD VSS sg13g2_fill_2
XFILLER_79_1190 VDD VSS sg13g2_fill_1
XFILLER_52_438 VDD VSS sg13g2_fill_1
XFILLER_80_758 VDD VSS sg13g2_decap_8
XFILLER_166_1160 VDD VSS sg13g2_decap_8
XFILLER_178_602 VDD VSS sg13g2_decap_8
X_08310_ _08616_/B _13529_/A _08126_/B _08688_/B VDD VSS sg13g2_o21ai_1
XFILLER_61_950 VDD VSS sg13g2_decap_8
XFILLER_162_1002 VDD VSS sg13g2_decap_8
X_09290_ _13898_/D _13898_/Q _10153_/A1 _09304_/S VDD VSS sg13g2_mux2_1
XFILLER_36_1016 VDD VSS sg13g2_decap_8
XFILLER_162_1035 VDD VSS sg13g2_decap_8
XFILLER_177_112 VDD VSS sg13g2_decap_8
XFILLER_75_1087 VDD VSS sg13g2_decap_8
XFILLER_60_460 VDD VSS sg13g2_decap_8
XFILLER_32_151 VDD VSS sg13g2_decap_8
XFILLER_61_994 VDD VSS sg13g2_decap_8
XFILLER_21_836 VDD VSS sg13g2_decap_8
X_08241_ _08241_/Y _08241_/A _08397_/B VDD VSS sg13g2_nand2_1
XANTENNA_14 _16883_/A VDD VSS sg13g2_antennanp
XFILLER_162_1057 VDD VSS sg13g2_decap_8
XANTENNA_25 output43/A VDD VSS sg13g2_antennanp
XFILLER_18_1472 VDD VSS sg13g2_decap_8
XFILLER_140_1311 VDD VSS sg13g2_decap_8
XFILLER_159_871 VDD VSS sg13g2_decap_8
XFILLER_20_357 VDD VSS sg13g2_decap_8
XFILLER_177_189 VDD VSS sg13g2_decap_8
X_14522__1750 _14522_/RESET_B VDD VSS sg13g2_tiehi
X_08172_ _08340_/B _08431_/A _08171_/X _08431_/D VDD VSS sg13g2_mux2_1
XFILLER_88_1404 VDD VSS sg13g2_fill_1
XFILLER_119_746 VDD VSS sg13g2_fill_2
XFILLER_14_1358 VDD VSS sg13g2_decap_8
XFILLER_158_392 VDD VSS sg13g2_fill_2
XFILLER_174_841 VDD VSS sg13g2_decap_8
XFILLER_174_852 VDD VSS sg13g2_fill_1
XFILLER_146_554 VDD VSS sg13g2_decap_8
XFILLER_146_565 VDD VSS sg13g2_fill_2
XFILLER_174_874 VDD VSS sg13g2_decap_8
XFILLER_140_1399 VDD VSS sg13g2_decap_8
XFILLER_173_373 VDD VSS sg13g2_decap_8
XFILLER_12_1071 VDD VSS sg13g2_decap_8
XFILLER_134_738 VDD VSS sg13g2_decap_8
Xoutput110 mem_axi_wdata[15] _15147_/Q VDD VSS sg13g2_buf_1
XFILLER_115_930 VDD VSS sg13g2_decap_8
Xoutput121 mem_axi_wdata[25] _15157_/Q VDD VSS sg13g2_buf_1
Xoutput132 mem_axi_wdata[6] _15138_/Q VDD VSS sg13g2_buf_1
XFILLER_0_707 VDD VSS sg13g2_decap_8
XFILLER_86_1183 VDD VSS sg13g2_decap_8
XFILLER_138_1273 VDD VSS sg13g2_fill_2
XFILLER_87_302 VDD VSS sg13g2_decap_8
XFILLER_47_1156 VDD VSS sg13g2_decap_8
XFILLER_173_1164 VDD VSS sg13g2_decap_8
XFILLER_114_495 VDD VSS sg13g2_fill_2
XFILLER_88_869 VDD VSS sg13g2_decap_8
X_07956_ _07956_/Y _07956_/A _07812_/B VDD VSS sg13g2_nor2b_1
XFILLER_101_156 VDD VSS sg13g2_decap_8
XFILLER_29_914 VDD VSS sg13g2_decap_4
XFILLER_68_560 VDD VSS sg13g2_decap_4
XFILLER_60_1345 VDD VSS sg13g2_decap_8
XFILLER_29_925 VDD VSS sg13g2_decap_8
XFILLER_28_402 VDD VSS sg13g2_fill_1
XFILLER_96_891 VDD VSS sg13g2_decap_8
XFILLER_68_593 VDD VSS sg13g2_decap_8
X_07887_ _07889_/A _08203_/A _14995_/Q VDD VSS sg13g2_nand2_1
X_09626_ _14222_/D _09727_/A0 _14222_/Q _09632_/S VDD VSS sg13g2_mux2_1
XFILLER_71_736 VDD VSS sg13g2_decap_8
X_09557_ _14155_/D _09724_/A0 _14155_/Q _09563_/S VDD VSS sg13g2_mux2_1
XFILLER_145_1200 VDD VSS sg13g2_fill_1
XFILLER_19_1203 VDD VSS sg13g2_decap_8
XFILLER_62_14 VDD VSS sg13g2_decap_8
XFILLER_24_641 VDD VSS sg13g2_decap_8
XFILLER_169_613 VDD VSS sg13g2_fill_2
X_08508_ _08517_/A _07818_/Y _08506_/Y _08507_/Y VDD VSS sg13g2_o21ai_1
XFILLER_62_25 VDD VSS sg13g2_fill_1
XFILLER_58_1274 VDD VSS sg13g2_decap_8
XFILLER_180_1113 VDD VSS sg13g2_decap_8
X_09488_ _14088_/D _10051_/A0 _14088_/Q _09497_/S VDD VSS sg13g2_mux2_1
XFILLER_58_1285 VDD VSS sg13g2_decap_8
XFILLER_145_1244 VDD VSS sg13g2_decap_8
XFILLER_168_112 VDD VSS sg13g2_decap_8
XFILLER_178_14 VDD VSS sg13g2_decap_8
XFILLER_70_279 VDD VSS sg13g2_fill_1
XFILLER_93_1187 VDD VSS sg13g2_decap_8
XFILLER_93_1198 VDD VSS sg13g2_fill_1
XFILLER_12_847 VDD VSS sg13g2_decap_8
XFILLER_157_808 VDD VSS sg13g2_fill_2
X_08439_ _08439_/Y _08574_/A _08438_/Y _08667_/A1 VDD VSS sg13g2_a21oi_1
XFILLER_141_1119 VDD VSS sg13g2_fill_2
XFILLER_168_156 VDD VSS sg13g2_fill_1
XFILLER_71_1441 VDD VSS sg13g2_fill_1
XFILLER_11_357 VDD VSS sg13g2_decap_8
X_11450_ _11450_/Y _11450_/A1 _11449_/X _11793_/A1 VDD VSS sg13g2_o21ai_1
XFILLER_71_1474 VDD VSS sg13g2_decap_4
XFILLER_177_690 VDD VSS sg13g2_decap_8
XFILLER_183_126 VDD VSS sg13g2_decap_8
XFILLER_109_223 VDD VSS sg13g2_decap_8
XFILLER_32_1447 VDD VSS sg13g2_decap_8
X_10401_ _14822_/D _10401_/A _10655_/B _10401_/C VDD VSS sg13g2_nor3_1
X_11381_ _11381_/Y _10681_/A _11433_/B _07684_/B VDD VSS sg13g2_a21oi_1
XFILLER_137_587 VDD VSS sg13g2_decap_8
XFILLER_178_1053 VDD VSS sg13g2_decap_8
X_13120_ _13120_/X _13120_/A _13170_/A VDD VSS sg13g2_xor2_1
XFILLER_139_1015 VDD VSS sg13g2_decap_8
X_10332_ _10334_/A _14803_/Q _10336_/D _14804_/Q VDD VSS sg13g2_a21o_1
XFILLER_106_930 VDD VSS sg13g2_decap_8
XFILLER_124_226 VDD VSS sg13g2_decap_8
XFILLER_139_1026 VDD VSS sg13g2_fill_1
XFILLER_11_84 VDD VSS sg13g2_decap_8
X_13051_ _13051_/X _14814_/Q _13068_/B VDD VSS sg13g2_and2_1
XFILLER_69_1381 VDD VSS sg13g2_decap_8
X_10263_ _14782_/D _14782_/Q _10268_/D _10261_/Y VDD VSS sg13g2_a21oi_1
XFILLER_69_1392 VDD VSS sg13g2_fill_1
XFILLER_152_579 VDD VSS sg13g2_fill_1
XFILLER_3_567 VDD VSS sg13g2_decap_8
XFILLER_106_985 VDD VSS sg13g2_decap_8
XFILLER_127_84 VDD VSS sg13g2_decap_8
X_12002_ _12002_/Y _11975_/A _11998_/X _12001_/Y VDD VSS sg13g2_o21ai_1
XFILLER_87_44 VDD VSS sg13g2_decap_8
XFILLER_65_1256 VDD VSS sg13g2_decap_8
Xfanout1302 _12836_/B _13692_/Q VDD VSS sg13g2_buf_1
XFILLER_78_324 VDD VSS sg13g2_decap_8
XFILLER_105_495 VDD VSS sg13g2_decap_8
X_10194_ _14754_/D _15197_/D _14754_/Q _13653_/S VDD VSS sg13g2_mux2_1
XFILLER_26_1229 VDD VSS sg13g2_decap_8
Xfanout1313 _12334_/C fanout1314/X VDD VSS sg13g2_buf_1
Xfanout1324 _11901_/B1 _11450_/A1 VDD VSS sg13g2_buf_1
XFILLER_65_1289 VDD VSS sg13g2_decap_8
Xfanout1335 _12219_/S _13659_/Q VDD VSS sg13g2_buf_1
XFILLER_152_1259 VDD VSS sg13g2_decap_8
Xfanout1346 _12038_/B1 fanout1350/X VDD VSS sg13g2_buf_1
XFILLER_94_817 VDD VSS sg13g2_decap_8
Xfanout1357 _11300_/S1 _11328_/S1 VDD VSS sg13g2_buf_1
Xfanout370 _09731_/S _09733_/S VDD VSS sg13g2_buf_1
XFILLER_94_839 VDD VSS sg13g2_decap_8
XFILLER_59_560 VDD VSS sg13g2_decap_4
Xfanout1368 _12136_/S1 fanout1381/X VDD VSS sg13g2_buf_1
XFILLER_59_571 VDD VSS sg13g2_decap_8
XFILLER_120_487 VDD VSS sg13g2_fill_1
Xfanout381 _09638_/S _09632_/S VDD VSS sg13g2_buf_1
Xfanout1379 _11442_/S1 _11444_/S1 VDD VSS sg13g2_buf_1
XFILLER_8_1183 VDD VSS sg13g2_decap_8
XFILLER_115_1070 VDD VSS sg13g2_decap_8
Xfanout392 _09505_/S _09474_/X VDD VSS sg13g2_buf_1
XFILLER_19_424 VDD VSS sg13g2_decap_8
X_13953_ _13953_/Q clkload38/A _13953_/D _13953_/RESET_B VDD VSS sg13g2_dfrbpq_1
X_14564__1708 _14564_/RESET_B VDD VSS sg13g2_tiehi
XFILLER_4_1036 VDD VSS sg13g2_decap_8
X_12904_ _15027_/D _13211_/A _12904_/B VDD VSS sg13g2_nor2_1
X_14600__1672 _14600_/RESET_B VDD VSS sg13g2_tiehi
X_13884_ _13884_/Q clkload64/A _13884_/D _13884_/RESET_B VDD VSS sg13g2_dfrbpq_1
XFILLER_74_574 VDD VSS sg13g2_decap_8
XFILLER_62_714 VDD VSS sg13g2_fill_2
XFILLER_47_788 VDD VSS sg13g2_decap_8
XFILLER_62_747 VDD VSS sg13g2_decap_8
XFILLER_36_70 VDD VSS sg13g2_decap_8
XFILLER_146_1008 VDD VSS sg13g2_decap_8
X_12835_ _12836_/C _12835_/A _13691_/Q VDD VSS sg13g2_xor2_1
XFILLER_146_1019 VDD VSS sg13g2_fill_1
XFILLER_15_630 VDD VSS sg13g2_decap_8
XFILLER_61_235 VDD VSS sg13g2_decap_4
XFILLER_36_81 VDD VSS sg13g2_fill_2
XFILLER_76_1352 VDD VSS sg13g2_decap_8
XFILLER_50_909 VDD VSS sg13g2_decap_8
XFILLER_37_1303 VDD VSS sg13g2_fill_2
XFILLER_37_1314 VDD VSS sg13g2_decap_8
XFILLER_14_140 VDD VSS sg13g2_decap_8
XFILLER_159_101 VDD VSS sg13g2_fill_1
XFILLER_76_1374 VDD VSS sg13g2_decap_8
X_12766_ _12766_/X _14585_/Q _14617_/Q _14649_/Q _14681_/Q _12771_/S0 _12771_/S1 VDD
+ VSS sg13g2_mux4_1
XFILLER_61_279 VDD VSS sg13g2_fill_1
XFILLER_99_7 VDD VSS sg13g2_decap_8
XFILLER_30_611 VDD VSS sg13g2_decap_8
XFILLER_163_1366 VDD VSS sg13g2_decap_8
X_14505_ _14505_/Q clkload30/A _14505_/D _14505_/RESET_B VDD VSS sg13g2_dfrbpq_1
XFILLER_37_1369 VDD VSS sg13g2_decap_8
XFILLER_159_145 VDD VSS sg13g2_decap_8
X_11717_ _11719_/B _12291_/A _11717_/B VDD VSS sg13g2_nor2_1
X_12697_ _12697_/X _13972_/Q _14004_/Q _14036_/Q _14068_/Q _12702_/S0 _12702_/S1 VDD
+ VSS sg13g2_mux4_1
X_14436_ _14436_/Q clkload32/A _14436_/D _14436_/RESET_B VDD VSS sg13g2_dfrbpq_1
X_11648_ _11648_/X _14247_/Q _14279_/Q _14311_/Q _14343_/Q _11528_/S _11532_/C VDD
+ VSS sg13g2_mux4_1
XFILLER_35_1071 VDD VSS sg13g2_decap_8
XFILLER_174_126 VDD VSS sg13g2_decap_8
XFILLER_30_688 VDD VSS sg13g2_decap_8
Xinput12 input12/X input12/A VDD VSS sg13g2_buf_1
Xinput23 input23/X input23/A VDD VSS sg13g2_buf_1
XFILLER_168_91 VDD VSS sg13g2_decap_8
Xinput34 input34/X input34/A VDD VSS sg13g2_buf_1
XFILLER_7_840 VDD VSS sg13g2_decap_8
X_14367_ _14367_/Q clkload49/A _14367_/D _14367_/RESET_B VDD VSS sg13g2_dfrbpq_1
X_11579_ _11579_/X _14373_/Q _14405_/Q _14469_/Q _14501_/Q _11996_/S0 _11996_/S1 VDD
+ VSS sg13g2_mux4_1
XFILLER_155_362 VDD VSS sg13g2_decap_8
XFILLER_6_350 VDD VSS sg13g2_decap_8
X_13318_ _13319_/B _15110_/Q _13306_/B _13309_/Y _15063_/Q VDD VSS sg13g2_a22oi_1
XFILLER_171_844 VDD VSS sg13g2_decap_4
X_14298_ _14298_/Q _14620_/CLK _14298_/D _14298_/RESET_B VDD VSS sg13g2_dfrbpq_1
XFILLER_143_579 VDD VSS sg13g2_decap_8
X_13249_ _13251_/B _14892_/Q _13249_/B VDD VSS sg13g2_nand2_1
XFILLER_69_302 VDD VSS sg13g2_decap_4
XFILLER_124_793 VDD VSS sg13g2_decap_8
XFILLER_170_1315 VDD VSS sg13g2_decap_8
XFILLER_44_1318 VDD VSS sg13g2_decap_8
XFILLER_111_421 VDD VSS sg13g2_fill_1
XFILLER_112_955 VDD VSS sg13g2_decap_8
XFILLER_123_292 VDD VSS sg13g2_decap_8
X_07810_ _08567_/A _15012_/Q _08541_/B VDD VSS sg13g2_xnor2_1
XFILLER_85_806 VDD VSS sg13g2_decap_8
XFILLER_170_1359 VDD VSS sg13g2_decap_8
X_08790_ _08790_/Y _13481_/A _13482_/A _13448_/B VDD VSS sg13g2_o21ai_1
XFILLER_84_305 VDD VSS sg13g2_decap_8
X_07741_ _07741_/Y _15124_/Q _13481_/A VDD VSS sg13g2_nand2b_1
XFILLER_42_1053 VDD VSS sg13g2_decap_8
XFILLER_96_198 VDD VSS sg13g2_decap_8
XFILLER_38_744 VDD VSS sg13g2_decap_8
XFILLER_168_1211 VDD VSS sg13g2_decap_8
X_07672_ _07672_/X _07665_/X _07670_/Y _07667_/Y VDD VSS sg13g2_a21o_1
XFILLER_93_872 VDD VSS sg13g2_decap_8
XFILLER_38_777 VDD VSS sg13g2_decap_8
XFILLER_0_1401 VDD VSS sg13g2_decap_8
XFILLER_93_883 VDD VSS sg13g2_fill_1
XFILLER_77_1116 VDD VSS sg13g2_decap_4
XFILLER_25_405 VDD VSS sg13g2_decap_4
X_09411_ _14013_/D _09842_/A1 _14013_/Q _09428_/S VDD VSS sg13g2_mux2_1
XFILLER_52_224 VDD VSS sg13g2_decap_8
XFILLER_25_438 VDD VSS sg13g2_decap_8
XFILLER_129_1228 VDD VSS sg13g2_decap_8
XFILLER_129_1239 VDD VSS sg13g2_fill_1
XFILLER_18_490 VDD VSS sg13g2_decap_8
XFILLER_53_769 VDD VSS sg13g2_decap_8
XFILLER_41_909 VDD VSS sg13g2_decap_8
XFILLER_168_1299 VDD VSS sg13g2_decap_8
XFILLER_94_1452 VDD VSS sg13g2_decap_8
XFILLER_80_555 VDD VSS sg13g2_decap_8
XFILLER_0_1478 VDD VSS sg13g2_fill_1
X_09342_ _09342_/Y _09342_/A _09441_/D VDD VSS sg13g2_nand2_1
XFILLER_80_599 VDD VSS sg13g2_decap_8
XFILLER_21_611 VDD VSS sg13g2_decap_8
XFILLER_55_1447 VDD VSS sg13g2_fill_1
XFILLER_179_966 VDD VSS sg13g2_decap_8
XFILLER_181_1455 VDD VSS sg13g2_decap_8
XFILLER_142_1417 VDD VSS sg13g2_decap_8
X_09273_ _13882_/D _13882_/Q _09739_/A0 _09273_/S VDD VSS sg13g2_mux2_1
XFILLER_138_307 VDD VSS sg13g2_decap_8
XFILLER_60_290 VDD VSS sg13g2_decap_4
XFILLER_178_476 VDD VSS sg13g2_decap_8
XFILLER_32_28 VDD VSS sg13g2_decap_8
XFILLER_21_666 VDD VSS sg13g2_decap_8
X_08224_ _08224_/X _08119_/X _08128_/X _08129_/X _08132_/X _08138_/B _08234_/B VDD
+ VSS sg13g2_mux4_1
XFILLER_20_154 VDD VSS sg13g2_decap_8
XFILLER_148_28 VDD VSS sg13g2_decap_8
XFILLER_14_1155 VDD VSS sg13g2_decap_8
X_08155_ _08155_/Y _08188_/A _08220_/B1 _08238_/B VDD VSS sg13g2_o21ai_1
XFILLER_10_1008 VDD VSS sg13g2_decap_8
XFILLER_134_502 VDD VSS sg13g2_decap_8
XFILLER_140_1185 VDD VSS sg13g2_decap_8
XFILLER_146_362 VDD VSS sg13g2_decap_8
XFILLER_106_204 VDD VSS sg13g2_fill_2
XFILLER_162_822 VDD VSS sg13g2_decap_8
X_08086_ _08270_/A _08452_/D _08086_/B VDD VSS sg13g2_nand2_1
XFILLER_161_321 VDD VSS sg13g2_decap_8
XFILLER_106_237 VDD VSS sg13g2_decap_8
XFILLER_88_1289 VDD VSS sg13g2_decap_8
XFILLER_161_365 VDD VSS sg13g2_decap_8
XFILLER_0_504 VDD VSS sg13g2_decap_8
XFILLER_164_49 VDD VSS sg13g2_decap_8
XFILLER_114_270 VDD VSS sg13g2_fill_2
XFILLER_142_590 VDD VSS sg13g2_decap_8
XFILLER_87_121 VDD VSS sg13g2_fill_2
XFILLER_57_14 VDD VSS sg13g2_decap_4
XFILLER_88_666 VDD VSS sg13g2_decap_8
X_15190__2878 _15190_/RESET_B VDD VSS sg13g2_tiehi
XFILLER_9_1470 VDD VSS sg13g2_decap_4
XFILLER_103_999 VDD VSS sg13g2_decap_8
X_08988_ _08988_/Y _09006_/A _08988_/B _08988_/C VDD VSS sg13g2_nor3_1
XFILLER_69_880 VDD VSS sg13g2_decap_8
XFILLER_5_1323 VDD VSS sg13g2_decap_8
XFILLER_112_1210 VDD VSS sg13g2_decap_4
XFILLER_25_1273 VDD VSS sg13g2_decap_8
XFILLER_116_1390 VDD VSS sg13g2_fill_2
X_07939_ _07939_/Y _08315_/B _07776_/Y _07773_/Y VDD VSS sg13g2_a21oi_1
XFILLER_112_1232 VDD VSS sg13g2_decap_8
XFILLER_112_1243 VDD VSS sg13g2_fill_1
XFILLER_99_1352 VDD VSS sg13g2_decap_8
XFILLER_112_1254 VDD VSS sg13g2_fill_2
XFILLER_21_1137 VDD VSS sg13g2_decap_8
XFILLER_56_552 VDD VSS sg13g2_decap_8
XFILLER_17_917 VDD VSS sg13g2_decap_8
X_10950_ _10950_/Y _10949_/Y _11004_/A _11188_/C1 VDD VSS sg13g2_a21oi_1
XFILLER_71_500 VDD VSS sg13g2_decap_8
XFILLER_186_1344 VDD VSS sg13g2_decap_8
XFILLER_56_585 VDD VSS sg13g2_decap_8
XFILLER_16_427 VDD VSS sg13g2_decap_8
XFILLER_186_1355 VDD VSS sg13g2_decap_8
XFILLER_56_596 VDD VSS sg13g2_fill_2
X_09609_ _14205_/D _09842_/A1 _14205_/Q _09638_/S VDD VSS sg13g2_mux2_1
X_10881_ _10890_/C _14754_/Q _10897_/A VDD VSS sg13g2_xor2_1
X_12620_ _12620_/X _14702_/Q _14734_/Q _13774_/Q _13806_/Q wire940/X _12620_/S1 VDD
+ VSS sg13g2_mux4_1
XFILLER_145_1041 VDD VSS sg13g2_decap_8
XFILLER_185_903 VDD VSS sg13g2_fill_2
X_12551_ _12551_/X _12548_/X _12547_/X _12544_/X _12543_/X _12775_/S1 _12720_/S VDD
+ VSS sg13g2_mux4_1
XFILLER_106_1014 VDD VSS sg13g2_decap_8
XFILLER_12_644 VDD VSS sg13g2_decap_8
X_15240__3101 _15240_/RESET_B VDD VSS sg13g2_tiehi
XFILLER_157_627 VDD VSS sg13g2_decap_8
X_11502_ _11636_/A _11502_/A _13685_/Q VDD VSS sg13g2_xor2_1
XFILLER_185_947 VDD VSS sg13g2_decap_8
XFILLER_40_986 VDD VSS sg13g2_decap_4
XFILLER_11_154 VDD VSS sg13g2_decap_8
X_12482_ _12482_/X _12480_/X _12479_/X _12476_/X _12475_/X _12732_/S0 _12762_/S VDD
+ VSS sg13g2_mux4_1
XFILLER_36_1380 VDD VSS sg13g2_fill_1
XFILLER_8_637 VDD VSS sg13g2_decap_8
XFILLER_184_446 VDD VSS sg13g2_decap_8
XFILLER_32_1233 VDD VSS sg13g2_fill_2
XFILLER_125_0 VDD VSS sg13g2_decap_8
X_14221_ _14221_/Q _14669_/CLK _14221_/D _14221_/RESET_B VDD VSS sg13g2_dfrbpq_1
X_11433_ _11433_/Y _14899_/Q _11433_/B VDD VSS sg13g2_nand2_1
XFILLER_138_863 VDD VSS sg13g2_decap_8
XFILLER_7_147 VDD VSS sg13g2_decap_8
XFILLER_158_1402 VDD VSS sg13g2_fill_2
XFILLER_165_671 VDD VSS sg13g2_decap_8
X_14857__2923 _14857_/RESET_B VDD VSS sg13g2_tiehi
XFILLER_32_1277 VDD VSS sg13g2_fill_1
X_14152_ _14152_/Q clkload22/A _14152_/D _14152_/RESET_B VDD VSS sg13g2_dfrbpq_1
XFILLER_138_72 VDD VSS sg13g2_decap_8
X_11364_ _11366_/A _11365_/A _14462_/Q VDD VSS sg13g2_nand2b_1
XFILLER_98_21 VDD VSS sg13g2_decap_8
XFILLER_152_321 VDD VSS sg13g2_decap_8
XFILLER_180_630 VDD VSS sg13g2_decap_8
XFILLER_67_1329 VDD VSS sg13g2_decap_8
XFILLER_125_568 VDD VSS sg13g2_decap_8
X_13103_ _13104_/B _14912_/Q _13675_/Q _13091_/Y VDD VSS sg13g2_a21oi_1
X_14618__1654 _14618_/RESET_B VDD VSS sg13g2_tiehi
X_10315_ _10315_/Y _10342_/A _10342_/C _10350_/C VDD VSS sg13g2_o21ai_1
XFILLER_4_854 VDD VSS sg13g2_decap_8
X_14083_ _14083_/Q _14723_/CLK _14083_/D _14083_/RESET_B VDD VSS sg13g2_dfrbpq_1
XFILLER_98_65 VDD VSS sg13g2_fill_1
XFILLER_140_505 VDD VSS sg13g2_decap_8
X_11295_ _11295_/Y _11212_/S _13821_/Q VDD VSS sg13g2_nand2b_1
XFILLER_153_899 VDD VSS sg13g2_decap_8
XFILLER_3_364 VDD VSS sg13g2_decap_8
XFILLER_180_696 VDD VSS sg13g2_decap_4
X_13034_ _13034_/Y _13032_/Y _13033_/Y _12933_/Y VDD VSS sg13g2_o21ai_1
X_10246_ _10248_/C _14776_/Q _10250_/D _14777_/Q VDD VSS sg13g2_a21oi_1
XFILLER_156_1170 VDD VSS sg13g2_decap_8
XFILLER_152_1023 VDD VSS sg13g2_decap_4
X_13882__2390 _13882_/RESET_B VDD VSS sg13g2_tiehi
Xfanout1110 _08340_/A _08270_/B VDD VSS sg13g2_buf_1
XFILLER_154_71 VDD VSS sg13g2_decap_4
Xfanout1121 _08621_/B _14991_/Q VDD VSS sg13g2_buf_1
XFILLER_152_1045 VDD VSS sg13g2_decap_8
Xfanout1132 _08402_/A _08109_/A1 VDD VSS sg13g2_buf_1
XFILLER_121_774 VDD VSS sg13g2_decap_8
X_10177_ _10184_/C _13316_/B _14766_/Q VDD VSS sg13g2_nand2_1
XFILLER_79_688 VDD VSS sg13g2_fill_2
Xfanout1143 _13518_/A1 fanout1144/X VDD VSS sg13g2_buf_1
XFILLER_66_305 VDD VSS sg13g2_decap_8
Xfanout1154 _08653_/B _12229_/A VDD VSS sg13g2_buf_1
XFILLER_113_1029 VDD VSS sg13g2_decap_8
Xfanout1165 _12084_/A _14982_/Q VDD VSS sg13g2_buf_1
Xfanout1176 _08119_/A2 _11936_/A VDD VSS sg13g2_buf_1
XFILLER_14_7 VDD VSS sg13g2_decap_8
XFILLER_19_210 VDD VSS sg13g2_decap_8
X_14985_ _14985_/Q clkload43/A _14985_/D _14985_/RESET_B VDD VSS sg13g2_dfrbpq_1
Xfanout1187 _08456_/B _08510_/A3 VDD VSS sg13g2_buf_1
XFILLER_82_809 VDD VSS sg13g2_decap_4
XFILLER_59_390 VDD VSS sg13g2_decap_8
Xfanout1198 _11726_/A _14972_/Q VDD VSS sg13g2_buf_1
XFILLER_93_146 VDD VSS sg13g2_fill_1
XFILLER_130_1343 VDD VSS sg13g2_fill_1
XFILLER_130_1365 VDD VSS sg13g2_fill_1
X_13936_ _13936_/Q clkload22/A _13936_/D _13936_/RESET_B VDD VSS sg13g2_dfrbpq_1
XFILLER_170_70 VDD VSS sg13g2_decap_8
XFILLER_78_1436 VDD VSS sg13g2_decap_8
XFILLER_19_287 VDD VSS sg13g2_decap_8
X_13867_ _13867_/Q clkload6/A _13867_/D _13867_/RESET_B VDD VSS sg13g2_dfrbpq_1
XFILLER_62_544 VDD VSS sg13g2_decap_8
X_12818_ _12818_/Y _14800_/Q _12851_/B _07728_/B _14832_/Q _13248_/B VDD VSS sg13g2_a221oi_1
XFILLER_62_577 VDD VSS sg13g2_decap_8
XFILLER_62_588 VDD VSS sg13g2_fill_1
XFILLER_37_1122 VDD VSS sg13g2_decap_8
XFILLER_16_994 VDD VSS sg13g2_decap_8
X_13798_ _13798_/Q _14726_/CLK _13798_/D _13798_/RESET_B VDD VSS sg13g2_dfrbpq_1
XFILLER_76_1182 VDD VSS sg13g2_decap_8
XFILLER_50_739 VDD VSS sg13g2_decap_8
XFILLER_72_1035 VDD VSS sg13g2_fill_2
XFILLER_63_90 VDD VSS sg13g2_decap_8
XFILLER_37_1155 VDD VSS sg13g2_decap_8
X_12749_ _12750_/B _13665_/Q _12777_/A2 _12748_/X _12400_/A _12749_/C1 VDD VSS sg13g2_a221oi_1
XFILLER_31_953 VDD VSS sg13g2_decap_4
XFILLER_33_1008 VDD VSS sg13g2_fill_2
XFILLER_176_947 VDD VSS sg13g2_decap_8
XFILLER_124_1158 VDD VSS sg13g2_fill_2
XFILLER_129_830 VDD VSS sg13g2_decap_4
XFILLER_15_1431 VDD VSS sg13g2_decap_8
XFILLER_30_474 VDD VSS sg13g2_decap_4
XFILLER_124_1169 VDD VSS sg13g2_fill_1
XFILLER_175_446 VDD VSS sg13g2_decap_8
XFILLER_102_1401 VDD VSS sg13g2_decap_8
XFILLER_8_63 VDD VSS sg13g2_decap_8
XFILLER_30_496 VDD VSS sg13g2_decap_8
XFILLER_128_340 VDD VSS sg13g2_decap_8
X_14419_ _14419_/Q _14739_/CLK _14419_/D _14419_/RESET_B VDD VSS sg13g2_dfrbpq_1
XFILLER_156_671 VDD VSS sg13g2_decap_8
XFILLER_144_822 VDD VSS sg13g2_decap_4
XFILLER_144_844 VDD VSS sg13g2_fill_1
XFILLER_183_490 VDD VSS sg13g2_decap_8
XFILLER_155_192 VDD VSS sg13g2_decap_8
XFILLER_143_343 VDD VSS sg13g2_fill_1
XFILLER_104_719 VDD VSS sg13g2_decap_8
XFILLER_143_365 VDD VSS sg13g2_decap_8
XFILLER_170_140 VDD VSS sg13g2_decap_8
X_09960_ _14544_/D _14544_/Q _10159_/A1 _09970_/S VDD VSS sg13g2_mux2_1
XFILLER_144_899 VDD VSS sg13g2_decap_8
XFILLER_170_151 VDD VSS sg13g2_fill_2
XFILLER_171_685 VDD VSS sg13g2_decap_8
Xmax_cap389 _09500_/S _09478_/S VDD VSS sg13g2_buf_4
XFILLER_40_0 VDD VSS sg13g2_decap_8
X_08911_ _13710_/D _08932_/S _08909_/Y _08910_/Y VDD VSS sg13g2_a21oi_1
XFILLER_98_942 VDD VSS sg13g2_fill_2
XFILLER_44_1104 VDD VSS sg13g2_decap_8
X_09891_ _14477_/D _09924_/A1 _14477_/Q _09896_/S VDD VSS sg13g2_mux2_1
XFILLER_98_953 VDD VSS sg13g2_fill_2
XFILLER_69_121 VDD VSS sg13g2_decap_8
X_13712__2560 _13712_/RESET_B VDD VSS sg13g2_tiehi
XFILLER_170_1134 VDD VSS sg13g2_decap_4
XFILLER_58_817 VDD VSS sg13g2_decap_8
X_08842_ _13693_/D _08841_/Y _16855_/A _08842_/S VDD VSS sg13g2_mux2_1
XFILLER_112_774 VDD VSS sg13g2_decap_8
XFILLER_44_1159 VDD VSS sg13g2_fill_1
XFILLER_100_936 VDD VSS sg13g2_decap_8
XFILLER_135_1287 VDD VSS sg13g2_decap_8
XFILLER_170_1167 VDD VSS sg13g2_decap_8
X_08773_ _08773_/Y _08788_/A1 _15117_/Q _15186_/Q _07719_/X VDD VSS sg13g2_a22oi_1
XFILLER_61_1473 VDD VSS sg13g2_fill_2
XFILLER_85_669 VDD VSS sg13g2_decap_8
XFILLER_84_146 VDD VSS sg13g2_decap_8
XFILLER_66_850 VDD VSS sg13g2_decap_8
XFILLER_27_28 VDD VSS sg13g2_decap_8
X_07724_ _07726_/C _15073_/Q _15072_/Q _15071_/Q _15083_/Q VDD VSS sg13g2_nor4_1
X_14056__2216 _14056_/RESET_B VDD VSS sg13g2_tiehi
XFILLER_22_1457 VDD VSS sg13g2_decap_8
XFILLER_26_714 VDD VSS sg13g2_decap_8
XFILLER_38_596 VDD VSS sg13g2_decap_8
XFILLER_25_213 VDD VSS sg13g2_decap_8
X_07655_ _07655_/Y _11953_/C VDD VSS sg13g2_inv_1
XFILLER_25_224 VDD VSS sg13g2_fill_2
XFILLER_81_853 VDD VSS sg13g2_decap_4
XFILLER_168_1074 VDD VSS sg13g2_fill_2
XFILLER_129_1036 VDD VSS sg13g2_decap_8
XFILLER_168_1085 VDD VSS sg13g2_decap_8
XFILLER_81_875 VDD VSS sg13g2_decap_8
XFILLER_0_1275 VDD VSS sg13g2_decap_8
XFILLER_80_374 VDD VSS sg13g2_decap_8
XFILLER_80_385 VDD VSS sg13g2_fill_2
XFILLER_40_216 VDD VSS sg13g2_decap_8
X_09325_ _13932_/D _09070_/Y _13932_/Q _09327_/S VDD VSS sg13g2_mux2_1
XFILLER_43_49 VDD VSS sg13g2_decap_8
XFILLER_22_953 VDD VSS sg13g2_decap_8
X_14271__2001 _14271_/RESET_B VDD VSS sg13g2_tiehi
XFILLER_55_1266 VDD VSS sg13g2_decap_8
XFILLER_159_49 VDD VSS sg13g2_decap_8
XFILLER_166_413 VDD VSS sg13g2_decap_8
XFILLER_167_936 VDD VSS sg13g2_decap_8
XFILLER_178_273 VDD VSS sg13g2_decap_8
XFILLER_90_1168 VDD VSS sg13g2_decap_8
X_09256_ _13865_/D _13865_/Q _09953_/A1 _09272_/S VDD VSS sg13g2_mux2_1
XFILLER_142_1269 VDD VSS sg13g2_fill_1
XFILLER_21_485 VDD VSS sg13g2_decap_8
X_08207_ _08207_/X _11461_/A _11454_/A _14961_/Q _08142_/C _08253_/S0 _08402_/A VDD
+ VSS sg13g2_mux4_1
XFILLER_154_608 VDD VSS sg13g2_decap_8
X_09187_ _13803_/D _13803_/Q _10154_/A1 _09193_/S VDD VSS sg13g2_mux2_1
XFILLER_135_822 VDD VSS sg13g2_decap_8
XFILLER_153_118 VDD VSS sg13g2_fill_2
XFILLER_175_991 VDD VSS sg13g2_fill_2
XFILLER_181_427 VDD VSS sg13g2_decap_8
X_08138_ _08138_/X _08138_/A _08138_/B _08138_/C VDD VSS sg13g2_and3_1
XFILLER_179_1170 VDD VSS sg13g2_fill_2
XFILLER_107_546 VDD VSS sg13g2_decap_8
XFILLER_49_1026 VDD VSS sg13g2_decap_8
XFILLER_175_1034 VDD VSS sg13g2_decap_8
XFILLER_135_888 VDD VSS sg13g2_decap_8
X_08069_ _08431_/A _08037_/B _08063_/Y _07884_/A VDD VSS sg13g2_a21oi_1
XFILLER_88_1097 VDD VSS sg13g2_fill_1
XFILLER_108_53 VDD VSS sg13g2_fill_1
XFILLER_161_162 VDD VSS sg13g2_decap_8
XFILLER_122_527 VDD VSS sg13g2_fill_1
XFILLER_134_387 VDD VSS sg13g2_decap_8
XFILLER_162_696 VDD VSS sg13g2_decap_8
X_10100_ _14680_/D _10100_/A0 _14680_/Q _10101_/S VDD VSS sg13g2_mux2_1
XFILLER_0_301 VDD VSS sg13g2_decap_8
XFILLER_89_931 VDD VSS sg13g2_fill_1
X_11080_ _11080_/Y _11140_/B2 _11079_/Y _11109_/B VDD VSS sg13g2_o21ai_1
XFILLER_89_953 VDD VSS sg13g2_fill_1
XFILLER_150_869 VDD VSS sg13g2_decap_8
XFILLER_62_1215 VDD VSS sg13g2_decap_8
XFILLER_27_1335 VDD VSS sg13g2_decap_8
XFILLER_118_1452 VDD VSS sg13g2_fill_1
XFILLER_1_868 VDD VSS sg13g2_decap_8
Xhold3240 _10774_/A _14920_/Q VDD VSS sg13g2_dlygate4sd3_1
XFILLER_7_1407 VDD VSS sg13g2_decap_8
Xhold3251 _13587_/A _15161_/Q VDD VSS sg13g2_dlygate4sd3_1
X_10031_ _14613_/D _10097_/A0 _14613_/Q _10031_/S VDD VSS sg13g2_mux2_1
X_14302__1970 _14302_/RESET_B VDD VSS sg13g2_tiehi
Xhold3262 _11084_/A _14948_/Q VDD VSS sg13g2_dlygate4sd3_1
XFILLER_49_817 VDD VSS sg13g2_decap_8
XFILLER_0_378 VDD VSS sg13g2_decap_8
XFILLER_130_593 VDD VSS sg13g2_decap_8
XFILLER_76_647 VDD VSS sg13g2_decap_4
XFILLER_5_1120 VDD VSS sg13g2_decap_8
XFILLER_25_1070 VDD VSS sg13g2_fill_1
XFILLER_75_146 VDD VSS sg13g2_decap_8
XFILLER_63_308 VDD VSS sg13g2_decap_8
XFILLER_17_714 VDD VSS sg13g2_decap_8
X_14770_ _14770_/Q clkload66/A _14770_/D _14770_/RESET_B VDD VSS sg13g2_dfrbpq_1
XFILLER_112_1062 VDD VSS sg13g2_fill_2
X_11982_ _11989_/A _11983_/A _13671_/Q VDD VSS sg13g2_xor2_1
XFILLER_95_1013 VDD VSS sg13g2_fill_2
XFILLER_5_1197 VDD VSS sg13g2_decap_8
XFILLER_72_831 VDD VSS sg13g2_fill_1
XFILLER_16_224 VDD VSS sg13g2_decap_8
X_13721_ _16883_/A clkload71/A _13721_/D _13721_/RESET_B VDD VSS sg13g2_dfrbpq_1
XFILLER_99_1193 VDD VSS sg13g2_decap_8
X_10933_ _10935_/B _10946_/A _10934_/B _10948_/D VDD VSS sg13g2_a21oi_1
XFILLER_56_393 VDD VSS sg13g2_fill_1
XFILLER_147_1125 VDD VSS sg13g2_decap_8
X_13652_ _15118_/D _15187_/D _15118_/Q _13652_/S VDD VSS sg13g2_mux2_1
X_10864_ _10890_/B _14753_/Q _10871_/A VDD VSS sg13g2_xnor2_1
XFILLER_71_363 VDD VSS sg13g2_decap_8
XFILLER_32_739 VDD VSS sg13g2_decap_8
XFILLER_13_931 VDD VSS sg13g2_decap_8
XFILLER_125_1412 VDD VSS sg13g2_decap_8
XFILLER_164_1461 VDD VSS sg13g2_decap_8
X_12603_ _12603_/X _13837_/Q _13869_/Q _13901_/Q _13933_/Q _12605_/S0 _12643_/S1 VDD
+ VSS sg13g2_mux4_1
XFILLER_185_700 VDD VSS sg13g2_decap_8
X_13583_ _13583_/Y _15001_/Q _13555_/B _13569_/S _15017_/Q _13533_/X VDD VSS sg13g2_a221oi_1
X_10795_ _14925_/D _11045_/B1 _11205_/A _10792_/Y VDD VSS sg13g2_o21ai_1
XFILLER_12_441 VDD VSS sg13g2_decap_8
XFILLER_9_924 VDD VSS sg13g2_decap_8
X_13754__2518 _13754_/RESET_B VDD VSS sg13g2_tiehi
X_12534_ _12534_/X _13736_/Q _14088_/Q _14440_/Q _14536_/Q _12755_/S0 _12758_/S1 VDD
+ VSS sg13g2_mux4_1
XFILLER_157_435 VDD VSS sg13g2_decap_8
XFILLER_8_434 VDD VSS sg13g2_decap_8
XFILLER_160_1369 VDD VSS sg13g2_decap_4
XFILLER_185_777 VDD VSS sg13g2_decap_4
XFILLER_184_254 VDD VSS sg13g2_decap_8
XFILLER_149_82 VDD VSS sg13g2_decap_8
XFILLER_184_265 VDD VSS sg13g2_decap_8
X_12465_ _12465_/X _14115_/Q _14147_/Q _14179_/Q _14211_/Q _12715_/S0 _12715_/S1 VDD
+ VSS sg13g2_mux4_1
XFILLER_185_799 VDD VSS sg13g2_fill_1
XFILLER_172_438 VDD VSS sg13g2_fill_2
X_14204_ _14204_/Q _14716_/CLK _14204_/D _14204_/RESET_B VDD VSS sg13g2_dfrbpq_1
XFILLER_137_170 VDD VSS sg13g2_fill_1
X_11416_ _11420_/A _11415_/X _12304_/B VDD VSS sg13g2_nand2b_1
XFILLER_158_1221 VDD VSS sg13g2_decap_8
X_15184_ _15184_/Q _15212_/CLK _15184_/D _15184_/RESET_B VDD VSS sg13g2_dfrbpq_1
X_12396_ _12396_/X _14238_/Q _14270_/Q _14302_/Q _14334_/Q _12406_/S0 _12406_/S1 VDD
+ VSS sg13g2_mux4_1
XFILLER_67_1115 VDD VSS sg13g2_decap_8
XFILLER_126_877 VDD VSS sg13g2_decap_8
XFILLER_153_652 VDD VSS sg13g2_decap_8
X_15107__2840 _15107_/RESET_B VDD VSS sg13g2_tiehi
XFILLER_99_706 VDD VSS sg13g2_decap_8
X_14134__2138 _14134_/RESET_B VDD VSS sg13g2_tiehi
X_14135_ _14135_/Q clkload47/A _14135_/D _14135_/RESET_B VDD VSS sg13g2_dfrbpq_1
X_11347_ _11347_/Y _11821_/S0 _14686_/Q VDD VSS sg13g2_nand2b_1
XFILLER_4_651 VDD VSS sg13g2_decap_8
XFILLER_141_814 VDD VSS sg13g2_decap_8
XFILLER_10_1372 VDD VSS sg13g2_decap_8
XFILLER_165_70 VDD VSS sg13g2_decap_8
XFILLER_113_538 VDD VSS sg13g2_fill_2
XFILLER_119_1238 VDD VSS sg13g2_decap_8
XFILLER_3_161 VDD VSS sg13g2_decap_8
XFILLER_158_1298 VDD VSS sg13g2_fill_1
XFILLER_152_195 VDD VSS sg13g2_fill_2
X_14066_ _14066_/Q _14674_/CLK _14066_/D _14066_/RESET_B VDD VSS sg13g2_dfrbpq_1
X_11278_ _11278_/Y _11279_/A1 _14172_/Q VDD VSS sg13g2_nand2b_1
XFILLER_84_1473 VDD VSS sg13g2_decap_4
X_13017_ _13017_/Y _12900_/A _12997_/A input8/X VDD VSS sg13g2_a21oi_1
X_10229_ _14771_/D _10237_/A _10237_/C _10228_/Y VDD VSS sg13g2_a21oi_1
XFILLER_95_912 VDD VSS sg13g2_decap_8
XFILLER_67_603 VDD VSS sg13g2_fill_2
XFILLER_80_1337 VDD VSS sg13g2_decap_8
XFILLER_121_560 VDD VSS sg13g2_decap_8
XFILLER_95_945 VDD VSS sg13g2_decap_8
XFILLER_95_956 VDD VSS sg13g2_fill_2
XFILLER_0_890 VDD VSS sg13g2_decap_8
XFILLER_132_1449 VDD VSS sg13g2_decap_8
XFILLER_95_978 VDD VSS sg13g2_decap_8
XFILLER_48_850 VDD VSS sg13g2_decap_8
XFILLER_181_91 VDD VSS sg13g2_decap_8
XFILLER_82_606 VDD VSS sg13g2_fill_1
XFILLER_82_617 VDD VSS sg13g2_decap_8
X_14968_ _14968_/Q clkload43/A _14968_/D _14968_/RESET_B VDD VSS sg13g2_dfrbpq_1
XFILLER_94_488 VDD VSS sg13g2_decap_8
XFILLER_66_179 VDD VSS sg13g2_fill_2
XFILLER_130_1184 VDD VSS sg13g2_decap_8
X_13919_ _13919_/Q _14540_/CLK _13919_/D _13919_/RESET_B VDD VSS sg13g2_dfrbpq_1
X_14899_ _14899_/Q clkload79/A _14899_/D _14899_/RESET_B VDD VSS sg13g2_dfrbpq_1
XFILLER_169_1394 VDD VSS sg13g2_fill_2
XFILLER_74_1119 VDD VSS sg13g2_fill_1
XFILLER_23_717 VDD VSS sg13g2_fill_2
XFILLER_90_683 VDD VSS sg13g2_decap_8
XFILLER_91_1422 VDD VSS sg13g2_decap_8
XFILLER_16_791 VDD VSS sg13g2_decap_8
XFILLER_22_238 VDD VSS sg13g2_decap_8
XFILLER_50_569 VDD VSS sg13g2_fill_1
X_09110_ _09110_/X _10760_/A _09150_/B _09109_/Y VDD VSS sg13g2_a21o_1
XFILLER_31_761 VDD VSS sg13g2_decap_8
XFILLER_175_210 VDD VSS sg13g2_decap_8
XFILLER_88_0 VDD VSS sg13g2_decap_8
XFILLER_176_744 VDD VSS sg13g2_decap_8
X_14344__1928 _14344_/RESET_B VDD VSS sg13g2_tiehi
XFILLER_148_457 VDD VSS sg13g2_fill_2
X_09041_ _09044_/B _14906_/Q _09031_/C _14907_/Q VDD VSS sg13g2_a21oi_1
XFILLER_164_939 VDD VSS sg13g2_fill_1
XFILLER_129_682 VDD VSS sg13g2_fill_2
XFILLER_175_287 VDD VSS sg13g2_decap_8
XFILLER_116_310 VDD VSS sg13g2_decap_8
XFILLER_129_693 VDD VSS sg13g2_fill_1
XFILLER_89_1351 VDD VSS sg13g2_decap_8
XFILLER_116_343 VDD VSS sg13g2_decap_8
XFILLER_11_1169 VDD VSS sg13g2_decap_8
XFILLER_102_1297 VDD VSS sg13g2_fill_1
XFILLER_144_674 VDD VSS sg13g2_decap_4
XFILLER_137_1316 VDD VSS sg13g2_decap_8
XFILLER_143_151 VDD VSS sg13g2_decap_8
XFILLER_89_205 VDD VSS sg13g2_decap_8
XFILLER_104_527 VDD VSS sg13g2_fill_2
XFILLER_89_238 VDD VSS sg13g2_decap_8
XFILLER_132_858 VDD VSS sg13g2_decap_8
XFILLER_172_1229 VDD VSS sg13g2_decap_8
X_09943_ _14527_/D _14527_/Q _09976_/A0 _09958_/S VDD VSS sg13g2_mux2_1
Xfanout903 _12757_/S1 fanout912/X VDD VSS sg13g2_buf_1
Xfanout914 _12745_/S1 _15211_/Q VDD VSS sg13g2_buf_1
Xfanout925 _12633_/S0 _12674_/S0 VDD VSS sg13g2_buf_1
XFILLER_58_603 VDD VSS sg13g2_decap_8
XFILLER_135_1051 VDD VSS sg13g2_decap_8
Xfanout947 _12368_/S0 fanout948/X VDD VSS sg13g2_buf_1
X_09874_ _14460_/D _09907_/A1 _14460_/Q _09904_/S VDD VSS sg13g2_mux2_1
XFILLER_112_571 VDD VSS sg13g2_fill_1
Xfanout958 _12769_/S0 _12773_/S0 VDD VSS sg13g2_buf_1
XFILLER_98_794 VDD VSS sg13g2_fill_2
X_14841__2955 _14841_/RESET_B VDD VSS sg13g2_tiehi
Xfanout969 _12745_/S0 _15210_/Q VDD VSS sg13g2_buf_1
XFILLER_86_945 VDD VSS sg13g2_decap_8
XFILLER_38_49 VDD VSS sg13g2_decap_8
XFILLER_161_28 VDD VSS sg13g2_decap_8
X_08825_ _08825_/Y _13279_/B _12346_/A _08727_/D _15177_/Q _08825_/C1 VDD VSS sg13g2_a221oi_1
XFILLER_58_658 VDD VSS sg13g2_decap_8
XFILLER_73_606 VDD VSS sg13g2_fill_1
XFILLER_26_1390 VDD VSS sg13g2_decap_8
XFILLER_61_1281 VDD VSS sg13g2_decap_8
XFILLER_100_788 VDD VSS sg13g2_decap_8
XFILLER_57_168 VDD VSS sg13g2_decap_8
XFILLER_22_1254 VDD VSS sg13g2_decap_8
X_08756_ _13670_/D _08765_/A1 _08754_/Y _08755_/Y VDD VSS sg13g2_a21oi_1
XFILLER_72_105 VDD VSS sg13g2_fill_2
X_13978__2294 _13978_/RESET_B VDD VSS sg13g2_tiehi
XFILLER_2_1337 VDD VSS sg13g2_decap_8
XFILLER_26_511 VDD VSS sg13g2_decap_8
XFILLER_96_1333 VDD VSS sg13g2_fill_1
X_07707_ _07708_/C _12997_/B _15201_/Q VDD VSS sg13g2_nor2_1
XFILLER_38_393 VDD VSS sg13g2_fill_2
XFILLER_166_7 VDD VSS sg13g2_decap_8
X_08687_ _08687_/X _08465_/X _08537_/X _08621_/C _08686_/X _08597_/B _08617_/A VDD
+ VSS sg13g2_mux4_1
X_14874__2889 _14874_/RESET_B VDD VSS sg13g2_tiehi
XFILLER_54_886 VDD VSS sg13g2_decap_8
XFILLER_53_363 VDD VSS sg13g2_decap_8
XFILLER_14_728 VDD VSS sg13g2_decap_8
XFILLER_183_1347 VDD VSS sg13g2_decap_8
X_07638_ _07638_/Y _14773_/Q VDD VSS sg13g2_inv_1
XFILLER_0_1072 VDD VSS sg13g2_decap_8
Xclkbuf_4_4_0_clk_i clkbuf_4_4_0_clk_i/X clkbuf_0_clk_i/X VDD VSS sg13g2_buf_8
XFILLER_110_21 VDD VSS sg13g2_decap_8
XFILLER_13_238 VDD VSS sg13g2_decap_8
XFILLER_142_1000 VDD VSS sg13g2_fill_1
XFILLER_179_560 VDD VSS sg13g2_decap_8
XFILLER_70_14 VDD VSS sg13g2_decap_8
XFILLER_166_210 VDD VSS sg13g2_decap_8
X_09308_ _13915_/D _09939_/A1 _13915_/Q _09327_/S VDD VSS sg13g2_mux2_1
X_10580_ _14871_/D _10580_/A _10580_/B _10580_/C VDD VSS sg13g2_nor3_1
XFILLER_55_1085 VDD VSS sg13g2_fill_1
XFILLER_110_98 VDD VSS sg13g2_decap_8
XFILLER_142_1044 VDD VSS sg13g2_decap_8
XFILLER_186_14 VDD VSS sg13g2_decap_8
XFILLER_103_1006 VDD VSS sg13g2_fill_2
XFILLER_103_1017 VDD VSS sg13g2_decap_8
XFILLER_10_945 VDD VSS sg13g2_decap_8
XFILLER_167_766 VDD VSS sg13g2_decap_8
XFILLER_16_1069 VDD VSS sg13g2_decap_8
XFILLER_167_777 VDD VSS sg13g2_fill_2
XFILLER_33_1350 VDD VSS sg13g2_decap_8
XFILLER_154_405 VDD VSS sg13g2_decap_8
XFILLER_182_714 VDD VSS sg13g2_fill_1
Xclkbuf_leaf_6_clk_i _14725_/CLK clkbuf_leaf_9_clk_i/A VDD VSS sg13g2_buf_8
X_09239_ _13850_/D _09739_/A0 _13850_/Q _09239_/S VDD VSS sg13g2_mux2_1
XFILLER_166_287 VDD VSS sg13g2_decap_8
XFILLER_6_938 VDD VSS sg13g2_decap_8
XFILLER_119_41 VDD VSS sg13g2_decap_8
XFILLER_181_224 VDD VSS sg13g2_decap_8
XFILLER_182_747 VDD VSS sg13g2_decap_8
X_12250_ _12250_/Y _12250_/A1 _14520_/Q _12166_/B VDD VSS sg13g2_a21oi_1
XFILLER_5_448 VDD VSS sg13g2_decap_8
XFILLER_108_866 VDD VSS sg13g2_fill_1
XFILLER_120_1375 VDD VSS sg13g2_decap_4
X_11201_ _11201_/Y _11201_/A _11201_/B VDD VSS sg13g2_nand2_1
XFILLER_68_1435 VDD VSS sg13g2_decap_8
XFILLER_108_888 VDD VSS sg13g2_decap_8
X_12181_ _12181_/X _12181_/A _12190_/B VDD VSS sg13g2_and2_1
XFILLER_155_1405 VDD VSS sg13g2_decap_8
XFILLER_134_162 VDD VSS sg13g2_decap_8
XFILLER_163_994 VDD VSS sg13g2_fill_1
XFILLER_135_696 VDD VSS sg13g2_fill_1
XFILLER_162_482 VDD VSS sg13g2_decap_8
XFILLER_155_1438 VDD VSS sg13g2_decap_4
X_11132_ _14950_/D _11131_/Y _11130_/Y _11113_/Y VDD VSS sg13g2_o21ai_1
XFILLER_155_1449 VDD VSS sg13g2_fill_1
XFILLER_7_1204 VDD VSS sg13g2_decap_8
XFILLER_27_1132 VDD VSS sg13g2_decap_8
XFILLER_1_665 VDD VSS sg13g2_decap_8
X_11063_ _11063_/Y _11060_/X _11035_/Y _11062_/Y VDD VSS sg13g2_a21oi_1
XFILLER_49_603 VDD VSS sg13g2_fill_1
XFILLER_0_175 VDD VSS sg13g2_decap_8
XFILLER_153_1173 VDD VSS sg13g2_decap_8
X_10014_ _14596_/D _10047_/A0 _14596_/Q _10031_/S VDD VSS sg13g2_mux2_1
XFILLER_48_124 VDD VSS sg13g2_fill_2
XFILLER_114_1146 VDD VSS sg13g2_decap_8
XFILLER_130_390 VDD VSS sg13g2_decap_8
X_14822_ _14822_/Q clkload63/A _14822_/D _14822_/RESET_B VDD VSS sg13g2_dfrbpq_1
XFILLER_64_628 VDD VSS sg13g2_decap_8
XFILLER_36_319 VDD VSS sg13g2_decap_8
XFILLER_40_1354 VDD VSS sg13g2_decap_8
XFILLER_17_511 VDD VSS sg13g2_decap_8
X_13808__2464 _13808_/RESET_B VDD VSS sg13g2_tiehi
XFILLER_29_371 VDD VSS sg13g2_decap_8
X_14753_ _14753_/Q clkload80/A _14753_/D _14753_/RESET_B VDD VSS sg13g2_dfrbpq_1
XFILLER_63_149 VDD VSS sg13g2_decap_8
X_11965_ _11965_/Y _11962_/Y _11964_/X _11999_/S1 VDD VSS sg13g2_o21ai_1
XFILLER_45_875 VDD VSS sg13g2_decap_8
X_13704_ _16866_/A _15237_/CLK _13704_/D _13704_/RESET_B VDD VSS sg13g2_dfrbpq_1
XFILLER_75_1428 VDD VSS sg13g2_decap_8
XFILLER_17_588 VDD VSS sg13g2_decap_8
X_10916_ _10920_/A _15119_/Q _10954_/A VDD VSS sg13g2_xnor2_1
X_14684_ _14684_/Q _14716_/CLK _14684_/D _14684_/RESET_B VDD VSS sg13g2_dfrbpq_1
XFILLER_71_160 VDD VSS sg13g2_decap_4
X_11896_ _11897_/B _11896_/A _14222_/Q VDD VSS sg13g2_nand2_1
XFILLER_60_845 VDD VSS sg13g2_decap_8
X_13635_ _13743_/D _13635_/A VDD VSS sg13g2_buf_1
XFILLER_73_1130 VDD VSS sg13g2_fill_1
X_10847_ _10847_/Y _10843_/Y _10846_/Y _13279_/D VDD VSS sg13g2_a21oi_1
XFILLER_9_721 VDD VSS sg13g2_decap_8
XFILLER_125_1253 VDD VSS sg13g2_decap_8
XFILLER_160_1133 VDD VSS sg13g2_fill_1
X_13566_ _13566_/Y _15011_/Q _13601_/B _13566_/C VDD VSS sg13g2_nor3_1
XFILLER_81_7 VDD VSS sg13g2_fill_2
X_10778_ _11180_/C _14952_/Q _08933_/S _10776_/X VDD VSS sg13g2_a21o_1
XFILLER_8_231 VDD VSS sg13g2_decap_8
X_12517_ _12517_/X _14375_/Q _14407_/Q _14471_/Q _14503_/Q _12710_/S0 _12710_/S1 VDD
+ VSS sg13g2_mux4_1
XFILLER_157_265 VDD VSS sg13g2_decap_4
XFILLER_185_574 VDD VSS sg13g2_decap_8
X_13497_ _13498_/A _13481_/A _13501_/A _15174_/D _13487_/Y VDD VSS sg13g2_a22oi_1
XFILLER_9_798 VDD VSS sg13g2_decap_8
XFILLER_172_224 VDD VSS sg13g2_decap_4
X_15236_ _15236_/Q clkload56/A _15236_/D _15236_/RESET_B VDD VSS sg13g2_dfrbpq_1
XFILLER_126_630 VDD VSS sg13g2_decap_8
XFILLER_12_1456 VDD VSS sg13g2_decap_8
X_12448_ _12448_/X _14690_/Q _14722_/Q _13762_/Q _13794_/Q _12452_/S0 _12452_/S1 VDD
+ VSS sg13g2_mux4_1
XFILLER_60_91 VDD VSS sg13g2_decap_8
XFILLER_126_663 VDD VSS sg13g2_fill_2
XFILLER_158_1040 VDD VSS sg13g2_fill_1
XFILLER_172_268 VDD VSS sg13g2_decap_8
XFILLER_176_91 VDD VSS sg13g2_decap_8
X_15167_ _15167_/Q clkload89/A _15167_/D _15167_/RESET_B VDD VSS sg13g2_dfrbpq_1
XFILLER_114_825 VDD VSS sg13g2_decap_8
X_12379_ _12379_/X _14109_/Q _14141_/Q _14173_/Q _14205_/Q _12618_/S0 _12618_/S1 VDD
+ VSS sg13g2_mux4_1
XFILLER_5_42 VDD VSS sg13g2_decap_8
XFILLER_158_1062 VDD VSS sg13g2_fill_1
XFILLER_113_313 VDD VSS sg13g2_decap_4
XFILLER_113_324 VDD VSS sg13g2_decap_4
X_14118_ _14118_/Q _14662_/CLK _14118_/D _14118_/RESET_B VDD VSS sg13g2_dfrbpq_1
XFILLER_99_558 VDD VSS sg13g2_fill_2
X_15098_ _15098_/Q clkload87/A _15098_/D _15098_/RESET_B VDD VSS sg13g2_dfrbpq_1
XFILLER_119_1079 VDD VSS sg13g2_decap_8
XFILLER_45_1232 VDD VSS sg13g2_decap_4
X_14049_ _14049_/Q clkload44/A _14049_/D _14049_/RESET_B VDD VSS sg13g2_dfrbpq_1
XFILLER_45_1254 VDD VSS sg13g2_decap_8
XFILLER_122_880 VDD VSS sg13g2_fill_1
XFILLER_79_271 VDD VSS sg13g2_decap_8
XFILLER_39_102 VDD VSS sg13g2_decap_8
XFILLER_171_1273 VDD VSS sg13g2_decap_8
X_08610_ _08610_/Y _08576_/Y _08608_/Y _08643_/A VDD VSS sg13g2_a21oi_1
X_09590_ _14187_/D _14187_/Q _09724_/A0 _09596_/S VDD VSS sg13g2_mux2_1
XFILLER_95_797 VDD VSS sg13g2_fill_1
XFILLER_94_274 VDD VSS sg13g2_decap_8
XFILLER_83_948 VDD VSS sg13g2_decap_8
XFILLER_55_639 VDD VSS sg13g2_fill_2
X_08541_ _08541_/Y _08653_/A _08541_/B _15012_/Q VDD VSS sg13g2_nand3_1
XFILLER_78_1030 VDD VSS sg13g2_fill_2
XFILLER_35_330 VDD VSS sg13g2_decap_8
XFILLER_39_1014 VDD VSS sg13g2_decap_8
X_08472_ _08472_/X _15008_/Q _08471_/B _08623_/A2 VDD VSS sg13g2_a21o_1
XFILLER_63_672 VDD VSS sg13g2_decap_8
XFILLER_39_1025 VDD VSS sg13g2_decap_8
XFILLER_35_363 VDD VSS sg13g2_decap_8
XFILLER_23_503 VDD VSS sg13g2_fill_1
XFILLER_165_1033 VDD VSS sg13g2_decap_8
XFILLER_62_160 VDD VSS sg13g2_decap_8
XFILLER_39_1036 VDD VSS sg13g2_fill_2
XFILLER_168_519 VDD VSS sg13g2_fill_1
XFILLER_149_711 VDD VSS sg13g2_decap_8
XFILLER_17_1334 VDD VSS sg13g2_decap_8
XFILLER_91_1263 VDD VSS sg13g2_fill_1
XFILLER_56_1383 VDD VSS sg13g2_decap_4
XFILLER_148_210 VDD VSS sg13g2_decap_8
XFILLER_91_1285 VDD VSS sg13g2_decap_8
XFILLER_149_788 VDD VSS sg13g2_decap_8
XFILLER_137_939 VDD VSS sg13g2_decap_8
XFILLER_176_585 VDD VSS sg13g2_decap_8
XFILLER_104_1359 VDD VSS sg13g2_decap_8
XFILLER_40_28 VDD VSS sg13g2_decap_8
X_09024_ _09024_/X _09024_/A _09024_/B _09024_/C VDD VSS sg13g2_and3_1
XFILLER_136_438 VDD VSS sg13g2_decap_4
XFILLER_163_235 VDD VSS sg13g2_fill_1
XFILLER_156_28 VDD VSS sg13g2_decap_8
XFILLER_163_257 VDD VSS sg13g2_decap_8
XFILLER_145_972 VDD VSS sg13g2_decap_8
XFILLER_145_983 VDD VSS sg13g2_fill_1
XFILLER_176_1140 VDD VSS sg13g2_decap_8
XFILLER_85_1045 VDD VSS sg13g2_fill_1
XFILLER_172_791 VDD VSS sg13g2_fill_1
XFILLER_104_324 VDD VSS sg13g2_decap_4
XFILLER_144_493 VDD VSS sg13g2_decap_8
XFILLER_132_644 VDD VSS sg13g2_decap_8
XFILLER_132_655 VDD VSS sg13g2_fill_2
Xfanout700 _12749_/C1 _12777_/C1 VDD VSS sg13g2_buf_1
XFILLER_131_143 VDD VSS sg13g2_fill_1
Xfanout711 _12918_/A2 _07728_/X VDD VSS sg13g2_buf_1
Xfanout722 _11168_/B1 _10999_/B1 VDD VSS sg13g2_buf_1
X_09926_ _14511_/D _14511_/Q _09926_/A1 _09936_/S VDD VSS sg13g2_mux2_1
XFILLER_154_1460 VDD VSS sg13g2_decap_4
Xfanout733 _12156_/A _12294_/B1 VDD VSS sg13g2_buf_1
XFILLER_63_1343 VDD VSS sg13g2_decap_8
XFILLER_131_176 VDD VSS sg13g2_decap_8
XFILLER_172_49 VDD VSS sg13g2_decap_8
Xfanout744 _13333_/S _13336_/S VDD VSS sg13g2_buf_1
XFILLER_59_934 VDD VSS sg13g2_fill_2
Xfanout755 _11615_/B _11763_/B VDD VSS sg13g2_buf_1
XFILLER_24_1316 VDD VSS sg13g2_decap_8
XFILLER_105_21 VDD VSS sg13g2_decap_8
Xfanout766 _11875_/B _12329_/C1 VDD VSS sg13g2_buf_1
XFILLER_112_390 VDD VSS sg13g2_decap_4
Xfanout777 _12246_/B _07655_/Y VDD VSS sg13g2_buf_1
X_09857_ _14444_/D _14444_/Q _10122_/A0 _09865_/S VDD VSS sg13g2_mux2_1
XFILLER_59_967 VDD VSS sg13g2_decap_8
Xfanout788 _11193_/A2 _11207_/A2 VDD VSS sg13g2_buf_1
Xfanout799 _10869_/A _07649_/Y VDD VSS sg13g2_buf_1
XFILLER_18_308 VDD VSS sg13g2_decap_8
XFILLER_65_14 VDD VSS sg13g2_decap_8
X_08808_ _13687_/D _08808_/A _08808_/B VDD VSS sg13g2_nor2_1
XFILLER_86_786 VDD VSS sg13g2_decap_8
X_09788_ _14377_/D _09920_/A1 _14377_/Q _09800_/S VDD VSS sg13g2_mux2_1
XFILLER_6_1281 VDD VSS sg13g2_decap_8
XFILLER_22_1051 VDD VSS sg13g2_decap_8
XFILLER_2_1134 VDD VSS sg13g2_decap_8
XFILLER_65_69 VDD VSS sg13g2_decap_8
X_08739_ _08739_/Y _07719_/A _11288_/A _15197_/Q VDD VSS sg13g2_o21ai_1
XFILLER_96_1174 VDD VSS sg13g2_decap_4
XFILLER_121_53 VDD VSS sg13g2_decap_8
X_11750_ _11750_/Y _11753_/S0 _14474_/Q VDD VSS sg13g2_nand2b_1
XFILLER_60_119 VDD VSS sg13g2_fill_2
XFILLER_121_64 VDD VSS sg13g2_fill_1
XFILLER_14_525 VDD VSS sg13g2_decap_8
XFILLER_183_1133 VDD VSS sg13g2_fill_2
XFILLER_26_385 VDD VSS sg13g2_decap_8
XFILLER_144_1106 VDD VSS sg13g2_decap_8
XFILLER_53_182 VDD VSS sg13g2_decap_8
XFILLER_121_86 VDD VSS sg13g2_decap_8
X_10701_ _10923_/A _09016_/B _10694_/S _08865_/Y VDD VSS sg13g2_a21oi_1
XFILLER_57_1169 VDD VSS sg13g2_decap_8
XFILLER_42_867 VDD VSS sg13g2_fill_2
X_11681_ _11681_/Y _12114_/S0 _14376_/Q VDD VSS sg13g2_nand2b_1
X_13420_ _13459_/C _15199_/Q _13448_/C VDD VSS sg13g2_and2_1
XFILLER_35_1434 VDD VSS sg13g2_decap_4
X_10632_ _10633_/C _14885_/Q _14884_/Q _14883_/Q _10632_/D VDD VSS sg13g2_and4_1
XFILLER_122_1404 VDD VSS sg13g2_decap_8
XFILLER_10_742 VDD VSS sg13g2_decap_8
XFILLER_14_84 VDD VSS sg13g2_decap_8
X_13351_ _13351_/Y _15183_/D _13351_/B _13351_/C _13351_/D VDD VSS sg13g2_nor4_1
X_10563_ _10565_/C _14866_/Q _10566_/D _14861_/Q VDD VSS sg13g2_nand3_1
XFILLER_70_1369 VDD VSS sg13g2_decap_8
XFILLER_182_511 VDD VSS sg13g2_decap_8
XFILLER_127_438 VDD VSS sg13g2_decap_8
X_13671__2623 _13671_/RESET_B VDD VSS sg13g2_tiehi
X_12302_ _12302_/Y _12299_/Y _12300_/Y _12301_/Y VDD VSS sg13g2_o21ai_1
XFILLER_6_735 VDD VSS sg13g2_decap_8
X_13282_ _13287_/A _13282_/A1 _10671_/Y _07744_/B _07744_/C _13281_/C VDD VSS sg13g2_a221oi_1
X_10494_ _10496_/C _10508_/A _10498_/D _14852_/Q VDD VSS sg13g2_a21o_1
XFILLER_5_245 VDD VSS sg13g2_decap_8
XFILLER_170_717 VDD VSS sg13g2_decap_8
X_15021_ _15021_/Q _15182_/CLK _15021_/D _15021_/RESET_B VDD VSS sg13g2_dfrbpq_1
XFILLER_154_279 VDD VSS sg13g2_decap_8
XFILLER_182_588 VDD VSS sg13g2_decap_8
X_12233_ _12237_/A _12232_/X _12233_/B VDD VSS sg13g2_nand2b_1
XFILLER_135_460 VDD VSS sg13g2_decap_8
XFILLER_68_1254 VDD VSS sg13g2_decap_8
XFILLER_30_72 VDD VSS sg13g2_fill_1
XFILLER_108_696 VDD VSS sg13g2_decap_8
XFILLER_155_1213 VDD VSS sg13g2_decap_8
XFILLER_107_184 VDD VSS sg13g2_decap_8
XFILLER_122_110 VDD VSS sg13g2_fill_2
X_12164_ _12164_/Y _12161_/Y _12163_/X _11559_/C VDD VSS sg13g2_o21ai_1
XFILLER_150_441 VDD VSS sg13g2_fill_1
XFILLER_151_964 VDD VSS sg13g2_decap_8
X_14051__2221 _14051_/RESET_B VDD VSS sg13g2_tiehi
XFILLER_2_952 VDD VSS sg13g2_decap_8
X_11115_ _11138_/C _11115_/A _11115_/B _11147_/A VDD VSS sg13g2_nor3_1
XFILLER_123_688 VDD VSS sg13g2_decap_8
XFILLER_150_463 VDD VSS sg13g2_decap_8
XFILLER_150_474 VDD VSS sg13g2_fill_1
XFILLER_1_462 VDD VSS sg13g2_decap_8
X_12095_ _12095_/Y _12090_/A _14580_/Q VDD VSS sg13g2_nand2b_1
XFILLER_7_1001 VDD VSS sg13g2_decap_8
XFILLER_110_349 VDD VSS sg13g2_decap_8
X_11046_ _11046_/Y _11046_/A _11046_/B VDD VSS sg13g2_nand2_1
XFILLER_103_390 VDD VSS sg13g2_fill_1
XFILLER_39_70 VDD VSS sg13g2_decap_4
X_14655__1617 _14655_/RESET_B VDD VSS sg13g2_tiehi
XFILLER_77_764 VDD VSS sg13g2_decap_4
XFILLER_49_455 VDD VSS sg13g2_decap_8
XFILLER_92_701 VDD VSS sg13g2_decap_8
XFILLER_7_1078 VDD VSS sg13g2_decap_8
X_14955__2727 _14955_/RESET_B VDD VSS sg13g2_tiehi
XFILLER_77_797 VDD VSS sg13g2_decap_8
XFILLER_18_820 VDD VSS sg13g2_decap_8
XFILLER_92_745 VDD VSS sg13g2_decap_4
X_14805_ _14805_/Q _14864_/CLK _14805_/D _14805_/RESET_B VDD VSS sg13g2_dfrbpq_1
XFILLER_91_233 VDD VSS sg13g2_fill_2
X_14084__2188 _14084_/RESET_B VDD VSS sg13g2_tiehi
XFILLER_40_1173 VDD VSS sg13g2_decap_8
XFILLER_18_864 VDD VSS sg13g2_decap_8
X_12997_ _12997_/Y _12997_/A _12997_/B VDD VSS sg13g2_nand2_1
XFILLER_40_1195 VDD VSS sg13g2_fill_1
Xclkbuf_leaf_107_clk_i clkload49/A clkbuf_5_16__f_clk_i/X VDD VSS sg13g2_buf_8
XFILLER_75_1203 VDD VSS sg13g2_decap_8
XFILLER_33_801 VDD VSS sg13g2_fill_1
XFILLER_75_1214 VDD VSS sg13g2_fill_1
X_14736_ _14736_/Q clkload14/A _14736_/D _14736_/RESET_B VDD VSS sg13g2_dfrbpq_1
XFILLER_79_1394 VDD VSS sg13g2_decap_8
X_11948_ _11948_/X _14576_/Q _14608_/Q _11948_/S VDD VSS sg13g2_mux2_1
XFILLER_17_385 VDD VSS sg13g2_decap_8
XFILLER_60_620 VDD VSS sg13g2_fill_1
XFILLER_45_694 VDD VSS sg13g2_decap_8
XFILLER_60_631 VDD VSS sg13g2_decap_8
X_14667_ _14667_/Q clkload9/A _14667_/D _14667_/RESET_B VDD VSS sg13g2_dfrbpq_1
XFILLER_32_344 VDD VSS sg13g2_fill_2
X_15023__2657 _15023_/RESET_B VDD VSS sg13g2_tiehi
X_11879_ _11879_/Y _11880_/A1 _14638_/Q VDD VSS sg13g2_nand2b_1
XFILLER_60_675 VDD VSS sg13g2_decap_8
X_13618_ _13726_/D _13618_/A VDD VSS sg13g2_buf_1
X_14598_ _14598_/Q _14726_/CLK _14598_/D _14598_/RESET_B VDD VSS sg13g2_dfrbpq_1
XFILLER_146_714 VDD VSS sg13g2_decap_8
X_13549_ _13549_/Y _15005_/Q _13558_/B _13566_/C VDD VSS sg13g2_nor3_1
XFILLER_185_371 VDD VSS sg13g2_decap_8
XFILLER_186_894 VDD VSS sg13g2_decap_4
XFILLER_9_595 VDD VSS sg13g2_decap_8
XFILLER_145_235 VDD VSS sg13g2_fill_1
XFILLER_127_950 VDD VSS sg13g2_decap_8
XFILLER_146_769 VDD VSS sg13g2_decap_8
XFILLER_173_555 VDD VSS sg13g2_decap_8
XFILLER_12_1253 VDD VSS sg13g2_decap_8
XFILLER_145_257 VDD VSS sg13g2_decap_8
XFILLER_173_566 VDD VSS sg13g2_fill_1
X_15219_ _15219_/Q _15219_/CLK _15219_/D _15219_/RESET_B VDD VSS sg13g2_dfrbpq_1
XFILLER_103_1392 VDD VSS sg13g2_decap_8
XFILLER_161_739 VDD VSS sg13g2_decap_4
XFILLER_160_238 VDD VSS sg13g2_decap_8
XFILLER_99_333 VDD VSS sg13g2_fill_1
XFILLER_173_1335 VDD VSS sg13g2_fill_2
Xclkbuf_5_4__f_clk_i clkbuf_5_4__f_clk_i/X clkbuf_4_2_0_clk_i/X VDD VSS sg13g2_buf_16
XFILLER_138_1466 VDD VSS sg13g2_decap_8
XFILLER_141_452 VDD VSS sg13g2_decap_8
XFILLER_114_677 VDD VSS sg13g2_decap_8
XFILLER_142_986 VDD VSS sg13g2_decap_8
XFILLER_87_528 VDD VSS sg13g2_fill_2
XFILLER_102_839 VDD VSS sg13g2_decap_8
X_14294__1978 _14294_/RESET_B VDD VSS sg13g2_tiehi
X_07972_ _08663_/A _15017_/Q _07972_/B VDD VSS sg13g2_nand2b_1
X_09711_ _14302_/D _09909_/A1 _14302_/Q _09727_/S VDD VSS sg13g2_mux2_1
XFILLER_95_550 VDD VSS sg13g2_decap_8
X_14777__3029 _14777_/RESET_B VDD VSS sg13g2_tiehi
XFILLER_56_915 VDD VSS sg13g2_fill_2
XFILLER_45_1095 VDD VSS sg13g2_decap_8
XFILLER_110_872 VDD VSS sg13g2_decap_8
XFILLER_110_883 VDD VSS sg13g2_fill_2
X_09642_ _14235_/D _09906_/A1 _14235_/Q _09673_/S VDD VSS sg13g2_mux2_1
XFILLER_95_572 VDD VSS sg13g2_decap_8
XFILLER_3_1421 VDD VSS sg13g2_decap_8
X_15063__1516 _15063_/RESET_B VDD VSS sg13g2_tiehi
XFILLER_132_1098 VDD VSS sg13g2_decap_8
XFILLER_55_447 VDD VSS sg13g2_decap_8
XFILLER_110_1341 VDD VSS sg13g2_decap_8
X_09573_ _09573_/X _10070_/A _10037_/B _09606_/C VDD VSS sg13g2_and3_1
XFILLER_27_149 VDD VSS sg13g2_decap_8
XFILLER_23_1393 VDD VSS sg13g2_decap_8
XFILLER_82_266 VDD VSS sg13g2_fill_1
XFILLER_35_28 VDD VSS sg13g2_decap_8
XFILLER_97_1472 VDD VSS sg13g2_fill_2
XFILLER_58_1423 VDD VSS sg13g2_decap_8
XFILLER_36_661 VDD VSS sg13g2_decap_8
X_08524_ _08524_/Y _08548_/B _08275_/B _08523_/Y VDD VSS sg13g2_o21ai_1
XFILLER_110_1385 VDD VSS sg13g2_decap_8
XFILLER_110_1396 VDD VSS sg13g2_fill_2
XFILLER_82_299 VDD VSS sg13g2_decap_8
XFILLER_58_1478 VDD VSS sg13g2_fill_1
X_08455_ _08461_/B _15007_/Q _08456_/B _08454_/X VDD VSS sg13g2_o21ai_1
XFILLER_51_653 VDD VSS sg13g2_decap_8
XFILLER_51_664 VDD VSS sg13g2_fill_2
Xclkbuf_leaf_71_clk_i clkload84/A clkbuf_leaf_89_clk_i/A VDD VSS sg13g2_buf_8
XFILLER_168_338 VDD VSS sg13g2_decap_8
XFILLER_17_1131 VDD VSS sg13g2_decap_8
X_08386_ _08386_/Y _08412_/B _08385_/Y _08381_/Y VDD VSS sg13g2_o21ai_1
XFILLER_11_539 VDD VSS sg13g2_decap_8
XFILLER_91_1071 VDD VSS sg13g2_decap_8
XFILLER_183_308 VDD VSS sg13g2_decap_8
XFILLER_52_1044 VDD VSS sg13g2_fill_1
XFILLER_129_7 VDD VSS sg13g2_decap_4
XFILLER_143_1194 VDD VSS sg13g2_decap_8
XFILLER_167_49 VDD VSS sg13g2_decap_8
XFILLER_176_371 VDD VSS sg13g2_decap_8
X_14808__2998 _14808_/RESET_B VDD VSS sg13g2_tiehi
XFILLER_104_1167 VDD VSS sg13g2_fill_2
XFILLER_52_1099 VDD VSS sg13g2_fill_2
XFILLER_178_1224 VDD VSS sg13g2_fill_1
XFILLER_136_246 VDD VSS sg13g2_decap_8
X_14733__1539 _14733_/RESET_B VDD VSS sg13g2_tiehi
Xclkbuf_leaf_86_clk_i clkload65/A clkbuf_leaf_94_clk_i/A VDD VSS sg13g2_buf_8
X_09007_ _09007_/X _09006_/A _09003_/X _09006_/Y VDD VSS sg13g2_a21o_1
XFILLER_178_1268 VDD VSS sg13g2_fill_1
XFILLER_133_931 VDD VSS sg13g2_fill_2
XFILLER_3_749 VDD VSS sg13g2_decap_8
XFILLER_2_259 VDD VSS sg13g2_decap_8
XFILLER_132_463 VDD VSS sg13g2_decap_8
XFILLER_78_517 VDD VSS sg13g2_decap_8
XFILLER_120_614 VDD VSS sg13g2_decap_8
Xfanout1506 _13427_/B fanout1507/X VDD VSS sg13g2_buf_1
Xfanout530 _09227_/S _09239_/S VDD VSS sg13g2_buf_1
Xfanout541 _08753_/A1 _08729_/Y VDD VSS sg13g2_buf_1
Xfanout552 _13502_/A _07989_/Y VDD VSS sg13g2_buf_1
X_09909_ _14494_/D _14494_/Q _09909_/A1 _09937_/S VDD VSS sg13g2_mux2_1
XFILLER_76_35 VDD VSS sg13g2_decap_8
Xfanout563 _13581_/B fanout565/X VDD VSS sg13g2_buf_1
XFILLER_150_1132 VDD VSS sg13g2_decap_8
Xfanout574 _12001_/A _12266_/B1 VDD VSS sg13g2_buf_1
XFILLER_93_509 VDD VSS sg13g2_decap_8
XFILLER_8_1365 VDD VSS sg13g2_decap_8
XFILLER_19_606 VDD VSS sg13g2_decap_8
XFILLER_59_775 VDD VSS sg13g2_fill_2
XFILLER_101_872 VDD VSS sg13g2_decap_8
XFILLER_115_1263 VDD VSS sg13g2_decap_8
Xfanout585 _10039_/A0 _10072_/A0 VDD VSS sg13g2_buf_1
XFILLER_98_1203 VDD VSS sg13g2_decap_8
XFILLER_58_252 VDD VSS sg13g2_decap_8
XFILLER_4_1218 VDD VSS sg13g2_decap_8
XFILLER_115_1274 VDD VSS sg13g2_fill_2
X_12920_ _12921_/B _07683_/A _12933_/A _12910_/Y _12878_/D _12919_/Y VDD VSS sg13g2_a221oi_1
Xfanout596 _09162_/A _09166_/A1 VDD VSS sg13g2_buf_1
XFILLER_18_105 VDD VSS sg13g2_decap_8
XFILLER_111_1127 VDD VSS sg13g2_decap_8
XFILLER_100_382 VDD VSS sg13g2_decap_8
XFILLER_111_1138 VDD VSS sg13g2_fill_2
Xclkbuf_leaf_24_clk_i clkload32/A clkload2/A VDD VSS sg13g2_buf_8
XFILLER_185_1217 VDD VSS sg13g2_fill_2
X_12851_ _12851_/Y _14802_/Q _12851_/B VDD VSS sg13g2_nand2_1
XFILLER_73_244 VDD VSS sg13g2_decap_8
XFILLER_61_406 VDD VSS sg13g2_decap_8
XFILLER_55_970 VDD VSS sg13g2_decap_8
X_11802_ _11806_/A _11801_/X _11802_/B VDD VSS sg13g2_nand2b_1
XFILLER_33_119 VDD VSS sg13g2_decap_8
X_12782_ _12782_/X _14394_/Q _14426_/Q _14490_/Q _14522_/Q _12783_/S0 _12783_/S1 VDD
+ VSS sg13g2_mux4_1
XFILLER_14_322 VDD VSS sg13g2_decap_8
XFILLER_54_491 VDD VSS sg13g2_decap_8
XFILLER_155_0 VDD VSS sg13g2_decap_8
XFILLER_15_856 VDD VSS sg13g2_decap_8
X_14521_ _14521_/Q clkload36/A _14521_/D _14521_/RESET_B VDD VSS sg13g2_dfrbpq_1
X_11733_ _11733_/Y _11759_/A _14218_/Q _11802_/B VDD VSS sg13g2_a21oi_1
Xclkbuf_leaf_39_clk_i clkload38/A clkbuf_leaf_39_clk_i/A VDD VSS sg13g2_buf_8
XFILLER_186_102 VDD VSS sg13g2_decap_8
XFILLER_186_113 VDD VSS sg13g2_decap_8
XFILLER_41_163 VDD VSS sg13g2_decap_8
X_14452_ _14452_/Q clkload25/A _14452_/D _14452_/RESET_B VDD VSS sg13g2_dfrbpq_1
XFILLER_14_399 VDD VSS sg13g2_decap_8
X_14069__2203 _14069_/RESET_B VDD VSS sg13g2_tiehi
X_11664_ _11664_/Y _11664_/A _11664_/B VDD VSS sg13g2_nor2_1
XFILLER_74_1291 VDD VSS sg13g2_decap_8
XFILLER_30_859 VDD VSS sg13g2_decap_8
XFILLER_35_1253 VDD VSS sg13g2_decap_8
X_13403_ _13403_/Y _13440_/A _13440_/B _15089_/Q VDD VSS sg13g2_nand3_1
X_10615_ _10615_/Y _10614_/A _10614_/B _10611_/B VDD VSS sg13g2_o21ai_1
XFILLER_126_1392 VDD VSS sg13g2_decap_8
XFILLER_128_725 VDD VSS sg13g2_decap_8
X_14383_ _14383_/Q _14610_/CLK _14383_/D _14383_/RESET_B VDD VSS sg13g2_dfrbpq_1
X_11595_ _11599_/A _11594_/X _11802_/B VDD VSS sg13g2_nand2b_1
XFILLER_70_1177 VDD VSS sg13g2_decap_8
XFILLER_31_1128 VDD VSS sg13g2_decap_8
XFILLER_155_544 VDD VSS sg13g2_decap_8
X_13334_ _13486_/C hold3118/X _15169_/Q _13336_/S VDD VSS sg13g2_mux2_1
XFILLER_128_769 VDD VSS sg13g2_decap_8
X_10546_ _10561_/A _14864_/Q _14863_/Q VDD VSS sg13g2_nand2_1
XFILLER_6_532 VDD VSS sg13g2_decap_8
X_14709__1563 _14709_/RESET_B VDD VSS sg13g2_tiehi
XFILLER_143_739 VDD VSS sg13g2_decap_8
X_13265_ _13266_/B _13048_/X _13264_/X _13259_/Y _13303_/A _13263_/Y VDD VSS sg13g2_a221oi_1
XFILLER_136_780 VDD VSS sg13g2_decap_8
XFILLER_170_525 VDD VSS sg13g2_decap_8
XFILLER_182_385 VDD VSS sg13g2_decap_8
X_10477_ _10489_/D _14847_/Q _10486_/D _10477_/C VDD VSS sg13g2_and3_1
X_15004_ _15004_/Q _15249_/CLK _15004_/D _15004_/RESET_B VDD VSS sg13g2_dfrbpq_1
XFILLER_108_493 VDD VSS sg13g2_decap_4
XFILLER_142_249 VDD VSS sg13g2_decap_8
X_12216_ _12216_/X _12211_/X _12212_/X _12246_/B VDD VSS sg13g2_mux2_1
XFILLER_123_430 VDD VSS sg13g2_fill_2
XFILLER_44_7 VDD VSS sg13g2_decap_8
X_13196_ _13196_/Y _13196_/A _13196_/B _13196_/C VDD VSS sg13g2_nand3_1
XFILLER_151_761 VDD VSS sg13g2_decap_8
XFILLER_97_826 VDD VSS sg13g2_decap_8
XFILLER_155_1065 VDD VSS sg13g2_decap_8
X_12147_ _12147_/Y _12145_/Y _12146_/Y _12126_/A VDD VSS sg13g2_a21oi_1
XFILLER_29_1068 VDD VSS sg13g2_decap_4
XFILLER_150_271 VDD VSS sg13g2_decap_8
XFILLER_173_70 VDD VSS sg13g2_decap_8
XFILLER_111_647 VDD VSS sg13g2_decap_8
XFILLER_96_347 VDD VSS sg13g2_decap_8
XFILLER_2_21 VDD VSS sg13g2_decap_8
XFILLER_110_135 VDD VSS sg13g2_decap_8
XFILLER_133_1330 VDD VSS sg13g2_fill_2
X_15162__2726 _15162_/RESET_B VDD VSS sg13g2_tiehi
XFILLER_133_1341 VDD VSS sg13g2_decap_4
X_12078_ _12078_/Y _12192_/A _12076_/X _12077_/Y VDD VSS sg13g2_o21ai_1
XFILLER_42_1257 VDD VSS sg13g2_decap_8
X_11029_ _11029_/Y _11029_/A _11029_/B _11044_/C VDD VSS sg13g2_nand3_1
XFILLER_37_425 VDD VSS sg13g2_decap_8
XFILLER_2_98 VDD VSS sg13g2_decap_8
XFILLER_77_1309 VDD VSS sg13g2_decap_8
XFILLER_64_266 VDD VSS sg13g2_decap_8
XFILLER_46_970 VDD VSS sg13g2_decap_8
XFILLER_17_182 VDD VSS sg13g2_decap_8
X_14719_ _14719_/Q clkload20/A _14719_/D _14719_/RESET_B VDD VSS sg13g2_dfrbpq_1
X_14919__2799 _14919_/RESET_B VDD VSS sg13g2_tiehi
XFILLER_75_1066 VDD VSS sg13g2_decap_8
X_08240_ _08240_/Y _08675_/A1 _08237_/Y _08239_/Y VDD VSS sg13g2_o21ai_1
XANTENNA_15 _16858_/A VDD VSS sg13g2_antennanp
XFILLER_18_1451 VDD VSS sg13g2_decap_8
XANTENNA_26 output41/A VDD VSS sg13g2_antennanp
XFILLER_127_1189 VDD VSS sg13g2_fill_1
XFILLER_20_336 VDD VSS sg13g2_decap_8
XFILLER_177_168 VDD VSS sg13g2_decap_8
XFILLER_105_1432 VDD VSS sg13g2_fill_2
X_08171_ _08171_/X _11384_/A _11335_/A _11452_/A _11428_/A _08253_/S0 _07913_/A VDD
+ VSS sg13g2_mux4_1
XFILLER_53_1375 VDD VSS sg13g2_decap_8
XFILLER_14_1337 VDD VSS sg13g2_decap_8
XFILLER_174_820 VDD VSS sg13g2_decap_8
XFILLER_53_1386 VDD VSS sg13g2_fill_2
XFILLER_70_0 VDD VSS sg13g2_decap_8
XFILLER_118_224 VDD VSS sg13g2_decap_8
XFILLER_9_392 VDD VSS sg13g2_decap_8
XFILLER_140_1378 VDD VSS sg13g2_decap_8
XFILLER_12_1050 VDD VSS sg13g2_decap_8
XFILLER_134_717 VDD VSS sg13g2_decap_8
XFILLER_173_352 VDD VSS sg13g2_decap_8
Xoutput100 mem_axi_awaddr[9] _16862_/X VDD VSS sg13g2_buf_1
XFILLER_161_536 VDD VSS sg13g2_decap_8
Xoutput111 mem_axi_wdata[16] _15148_/Q VDD VSS sg13g2_buf_1
Xoutput122 mem_axi_wdata[26] _15158_/Q VDD VSS sg13g2_buf_1
Xoutput133 mem_axi_wdata[7] _15139_/Q VDD VSS sg13g2_buf_1
X_13767__2505 _13767_/RESET_B VDD VSS sg13g2_tiehi
XFILLER_82_1015 VDD VSS sg13g2_decap_8
XFILLER_47_1135 VDD VSS sg13g2_decap_8
XFILLER_114_452 VDD VSS sg13g2_fill_1
XFILLER_82_1026 VDD VSS sg13g2_fill_2
XFILLER_102_603 VDD VSS sg13g2_decap_8
XFILLER_130_912 VDD VSS sg13g2_decap_8
XFILLER_114_474 VDD VSS sg13g2_decap_8
XFILLER_82_1059 VDD VSS sg13g2_decap_8
XFILLER_99_196 VDD VSS sg13g2_decap_8
XFILLER_141_293 VDD VSS sg13g2_decap_8
XFILLER_101_146 VDD VSS sg13g2_decap_4
X_07955_ _07958_/B _15012_/Q _08541_/B VDD VSS sg13g2_nand2b_1
XFILLER_60_1324 VDD VSS sg13g2_fill_2
XFILLER_96_870 VDD VSS sg13g2_decap_8
XFILLER_25_1455 VDD VSS sg13g2_decap_8
XFILLER_21_1319 VDD VSS sg13g2_decap_8
X_14147__2125 _14147_/RESET_B VDD VSS sg13g2_tiehi
XFILLER_56_723 VDD VSS sg13g2_fill_2
X_07886_ _07924_/C _08219_/A _13545_/A VDD VSS sg13g2_xor2_1
XFILLER_60_1379 VDD VSS sg13g2_decap_8
X_09625_ _14221_/D _09625_/A0 _14221_/Q _09630_/S VDD VSS sg13g2_mux2_1
XFILLER_16_609 VDD VSS sg13g2_decap_8
XFILLER_23_1190 VDD VSS sg13g2_decap_8
XFILLER_15_119 VDD VSS sg13g2_decap_8
X_09556_ _14154_/D _09622_/A0 _14154_/Q _09572_/S VDD VSS sg13g2_mux2_1
XFILLER_110_1182 VDD VSS sg13g2_fill_2
XFILLER_3_1295 VDD VSS sg13g2_decap_8
XFILLER_97_1291 VDD VSS sg13g2_fill_1
XFILLER_58_1253 VDD VSS sg13g2_decap_8
X_08507_ _08507_/Y _07818_/Y _08506_/Y _08667_/A1 VDD VSS sg13g2_a21oi_1
XFILLER_70_247 VDD VSS sg13g2_decap_8
XFILLER_52_951 VDD VSS sg13g2_decap_8
XFILLER_23_130 VDD VSS sg13g2_decap_8
X_09487_ _14087_/D _09951_/A1 _14087_/Q _09501_/S VDD VSS sg13g2_mux2_1
XFILLER_145_1234 VDD VSS sg13g2_fill_1
XFILLER_24_675 VDD VSS sg13g2_decap_8
XFILLER_12_826 VDD VSS sg13g2_decap_8
XFILLER_93_1177 VDD VSS sg13g2_fill_1
XFILLER_19_1259 VDD VSS sg13g2_decap_8
X_08438_ _08438_/Y _08436_/Y _08437_/Y _08552_/A1 _08435_/Y VDD VSS sg13g2_a22oi_1
XFILLER_11_336 VDD VSS sg13g2_decap_8
XFILLER_156_308 VDD VSS sg13g2_decap_8
XFILLER_8_819 VDD VSS sg13g2_decap_8
XFILLER_183_105 VDD VSS sg13g2_decap_8
Xwire216 wire216/X wire216/A VDD VSS sg13g2_buf_2
X_08369_ _08389_/B _08369_/A _08369_/B VDD VSS sg13g2_nand2_1
XFILLER_7_329 VDD VSS sg13g2_decap_8
XFILLER_165_831 VDD VSS sg13g2_decap_8
X_10400_ _10400_/Y wire220/X _10400_/B _10400_/C _10400_/D VDD VSS sg13g2_nor4_1
X_11380_ wire247/A _11360_/Y _11361_/Y _11379_/Y VDD VSS sg13g2_o21ai_1
XFILLER_137_566 VDD VSS sg13g2_decap_8
XFILLER_178_1032 VDD VSS sg13g2_decap_8
XFILLER_109_279 VDD VSS sg13g2_decap_8
XFILLER_124_205 VDD VSS sg13g2_decap_8
X_10331_ _14803_/D _10331_/A _10331_/B _10337_/C VDD VSS sg13g2_and3_1
XFILLER_11_63 VDD VSS sg13g2_decap_8
XFILLER_180_845 VDD VSS sg13g2_decap_8
XFILLER_139_1049 VDD VSS sg13g2_decap_8
X_13050_ _13050_/X _15062_/Q _15061_/Q _13050_/C VDD VSS sg13g2_or3_1
X_10262_ _10262_/Y _10265_/B _10262_/B VDD VSS sg13g2_nor2_1
XFILLER_3_546 VDD VSS sg13g2_decap_8
XFILLER_180_878 VDD VSS sg13g2_decap_8
XFILLER_127_63 VDD VSS sg13g2_decap_8
X_14357__1915 _14357_/RESET_B VDD VSS sg13g2_tiehi
XFILLER_121_901 VDD VSS sg13g2_fill_2
XFILLER_65_1235 VDD VSS sg13g2_decap_8
X_12001_ _12001_/Y _12001_/A _12001_/B VDD VSS sg13g2_nor2_1
XFILLER_105_474 VDD VSS sg13g2_decap_8
XFILLER_78_303 VDD VSS sg13g2_decap_4
XFILLER_26_1208 VDD VSS sg13g2_decap_8
XFILLER_117_1325 VDD VSS sg13g2_decap_8
XFILLER_120_400 VDD VSS sg13g2_decap_4
X_10193_ _15197_/D hold3155/X _15197_/Q _13479_/S VDD VSS sg13g2_mux2_1
XFILLER_133_794 VDD VSS sg13g2_fill_1
Xfanout1303 _12942_/B _13684_/Q VDD VSS sg13g2_buf_1
Xfanout1314 fanout1314/X _13661_/Q VDD VSS sg13g2_buf_1
Xfanout1325 _12046_/C _12265_/A2 VDD VSS sg13g2_buf_1
XFILLER_121_978 VDD VSS sg13g2_decap_8
Xfanout1336 _07654_/A _11850_/S1 VDD VSS sg13g2_buf_1
Xfanout1347 _11970_/C _11760_/C VDD VSS sg13g2_buf_1
Xfanout360 _09869_/S wire362/X VDD VSS sg13g2_buf_1
Xfanout1358 _11328_/S1 fanout1364/X VDD VSS sg13g2_buf_1
XFILLER_8_1162 VDD VSS sg13g2_decap_8
XFILLER_143_51 VDD VSS sg13g2_decap_4
Xfanout371 _09738_/S _09733_/S VDD VSS sg13g2_buf_1
Xfanout1369 _12245_/S1 _12259_/S1 VDD VSS sg13g2_buf_1
XFILLER_87_870 VDD VSS sg13g2_decap_8
Xfanout382 _09632_/S _09636_/S VDD VSS sg13g2_buf_1
XFILLER_87_881 VDD VSS sg13g2_fill_2
XFILLER_4_1015 VDD VSS sg13g2_decap_8
X_13952_ _13952_/Q _14720_/CLK _13952_/D _13952_/RESET_B VDD VSS sg13g2_dfrbpq_1
Xfanout393 _09331_/S _09333_/S VDD VSS sg13g2_buf_1
XFILLER_143_95 VDD VSS sg13g2_decap_8
X_14572__1700 _14572_/RESET_B VDD VSS sg13g2_tiehi
XFILLER_86_391 VDD VSS sg13g2_decap_4
X_12903_ _12904_/B _12983_/A1 _12902_/Y _12894_/X _12878_/D _12898_/Y VDD VSS sg13g2_a221oi_1
XFILLER_98_1044 VDD VSS sg13g2_fill_1
XFILLER_47_767 VDD VSS sg13g2_decap_8
X_13883_ _13883_/Q _14876_/CLK _13883_/D _13883_/RESET_B VDD VSS sg13g2_dfrbpq_1
XFILLER_74_564 VDD VSS sg13g2_fill_2
XFILLER_46_255 VDD VSS sg13g2_decap_4
XFILLER_98_1066 VDD VSS sg13g2_decap_8
XFILLER_59_1017 VDD VSS sg13g2_decap_8
XFILLER_41_1290 VDD VSS sg13g2_decap_8
XFILLER_59_1028 VDD VSS sg13g2_fill_1
XFILLER_28_970 VDD VSS sg13g2_fill_1
X_12834_ _12834_/Y _12835_/A _13691_/Q VDD VSS sg13g2_nor2_1
XFILLER_46_288 VDD VSS sg13g2_decap_4
XFILLER_185_1058 VDD VSS sg13g2_decap_8
XFILLER_27_491 VDD VSS sg13g2_decap_8
XFILLER_128_1443 VDD VSS sg13g2_fill_2
X_12765_ _12778_/A _12765_/A1 _12765_/A2 _15019_/Q VDD VSS sg13g2_a21oi_1
XFILLER_37_1337 VDD VSS sg13g2_decap_8
XFILLER_159_124 VDD VSS sg13g2_decap_8
XFILLER_15_686 VDD VSS sg13g2_decap_8
X_14504_ _14504_/Q _14740_/CLK _14504_/D _14504_/RESET_B VDD VSS sg13g2_dfrbpq_1
X_13845__2427 _13845_/RESET_B VDD VSS sg13g2_tiehi
X_11716_ _11717_/B _11708_/X _11709_/X _11712_/X _11713_/X _11443_/A _11446_/A VDD
+ VSS sg13g2_mux4_1
XFILLER_124_1329 VDD VSS sg13g2_decap_8
X_12696_ _12696_/X _14132_/Q _14164_/Q _14196_/Q _14228_/Q _12702_/S0 _12702_/S1 VDD
+ VSS sg13g2_mux4_1
XFILLER_14_196 VDD VSS sg13g2_decap_8
XFILLER_35_1050 VDD VSS sg13g2_decap_8
XFILLER_159_179 VDD VSS sg13g2_decap_8
XFILLER_174_105 VDD VSS sg13g2_decap_8
X_14435_ _14435_/Q _14723_/CLK _14435_/D _14435_/RESET_B VDD VSS sg13g2_dfrbpq_1
XFILLER_30_667 VDD VSS sg13g2_decap_8
X_11647_ _11647_/X _13735_/Q _14087_/Q _14439_/Q _14535_/Q _11528_/S _11532_/C VDD
+ VSS sg13g2_mux4_1
XFILLER_168_680 VDD VSS sg13g2_decap_8
XFILLER_122_1031 VDD VSS sg13g2_decap_8
Xinput13 input13/X input13/A VDD VSS sg13g2_buf_1
XFILLER_122_1042 VDD VSS sg13g2_fill_2
XFILLER_168_70 VDD VSS sg13g2_decap_8
Xinput24 input24/X input24/A VDD VSS sg13g2_buf_1
X_14366_ _14366_/Q clkload49/A _14366_/D _14366_/RESET_B VDD VSS sg13g2_dfrbpq_1
Xinput35 input35/X input35/A VDD VSS sg13g2_buf_1
XFILLER_128_555 VDD VSS sg13g2_fill_2
XFILLER_155_341 VDD VSS sg13g2_decap_8
X_11578_ _11578_/X _13957_/Q _13989_/Q _14021_/Q _14053_/Q _11996_/S0 _11996_/S1 VDD
+ VSS sg13g2_mux4_1
XFILLER_156_886 VDD VSS sg13g2_fill_1
XFILLER_128_588 VDD VSS sg13g2_decap_8
XFILLER_171_823 VDD VSS sg13g2_fill_2
X_13317_ _15062_/D _15078_/Q _07694_/Y _13316_/X VDD VSS sg13g2_a21o_1
XFILLER_128_599 VDD VSS sg13g2_decap_4
XFILLER_157_1105 VDD VSS sg13g2_decap_8
X_14225__2047 _14225_/RESET_B VDD VSS sg13g2_tiehi
X_10529_ _14858_/D _10529_/A _10529_/B _13499_/B VDD VSS sg13g2_and3_1
XFILLER_157_1116 VDD VSS sg13g2_fill_2
X_14297_ _14297_/Q clkload36/A _14297_/D _14297_/RESET_B VDD VSS sg13g2_dfrbpq_1
XFILLER_7_896 VDD VSS sg13g2_decap_8
XFILLER_100_1340 VDD VSS sg13g2_fill_2
XFILLER_109_791 VDD VSS sg13g2_fill_1
XFILLER_182_182 VDD VSS sg13g2_decap_8
XFILLER_87_1460 VDD VSS sg13g2_decap_8
XFILLER_115_249 VDD VSS sg13g2_decap_8
XFILLER_143_558 VDD VSS sg13g2_decap_8
Xclkbuf_5_22__f_clk_i clkbuf_leaf_94_clk_i/A clkbuf_4_11_0_clk_i/X VDD VSS sg13g2_buf_16
X_13248_ _13251_/A _14796_/Q _13248_/B VDD VSS sg13g2_nand2_1
XFILLER_48_1433 VDD VSS sg13g2_fill_1
XFILLER_100_1395 VDD VSS sg13g2_decap_4
XFILLER_170_377 VDD VSS sg13g2_decap_4
XFILLER_124_772 VDD VSS sg13g2_decap_4
XFILLER_135_1414 VDD VSS sg13g2_decap_8
XFILLER_184_91 VDD VSS sg13g2_decap_8
XFILLER_97_623 VDD VSS sg13g2_fill_2
X_13179_ _13179_/Y _14855_/Q _13218_/B VDD VSS sg13g2_nand2_1
XFILLER_135_1447 VDD VSS sg13g2_fill_2
XFILLER_97_645 VDD VSS sg13g2_decap_8
XFILLER_83_1379 VDD VSS sg13g2_fill_2
XFILLER_112_967 VDD VSS sg13g2_decap_8
XFILLER_111_455 VDD VSS sg13g2_fill_2
XFILLER_112_978 VDD VSS sg13g2_fill_1
XFILLER_57_509 VDD VSS sg13g2_decap_8
XFILLER_112_989 VDD VSS sg13g2_decap_8
XFILLER_96_177 VDD VSS sg13g2_decap_8
XFILLER_133_1160 VDD VSS sg13g2_decap_8
X_07740_ _07740_/Y _07740_/A _11243_/C VDD VSS sg13g2_nand2_1
XFILLER_38_723 VDD VSS sg13g2_decap_8
X_15170__2580 _15170_/RESET_B VDD VSS sg13g2_tiehi
X_07671_ _13281_/C _07665_/X _07670_/Y _07667_/Y VDD VSS sg13g2_a21oi_1
X_16869_ _16869_/X _16869_/A VDD VSS sg13g2_buf_1
X_09410_ _14012_/D _10039_/A0 _14012_/Q _09428_/S VDD VSS sg13g2_mux2_1
XFILLER_80_534 VDD VSS sg13g2_decap_8
XFILLER_37_299 VDD VSS sg13g2_decap_8
XFILLER_0_1457 VDD VSS sg13g2_decap_8
XFILLER_20_1385 VDD VSS sg13g2_decap_8
X_09341_ _09441_/D _10070_/A _09606_/C VDD VSS sg13g2_nor2b_1
XFILLER_55_1426 VDD VSS sg13g2_decap_8
XFILLER_179_945 VDD VSS sg13g2_decap_8
XFILLER_33_461 VDD VSS sg13g2_decap_4
XFILLER_90_1339 VDD VSS sg13g2_decap_8
X_09272_ _13881_/D _13881_/Q _09472_/A0 _09272_/S VDD VSS sg13g2_mux2_1
XFILLER_61_792 VDD VSS sg13g2_decap_8
XFILLER_55_1459 VDD VSS sg13g2_decap_8
XFILLER_178_455 VDD VSS sg13g2_decap_8
X_14435__1837 _14435_/RESET_B VDD VSS sg13g2_tiehi
XFILLER_166_617 VDD VSS sg13g2_decap_8
XFILLER_20_133 VDD VSS sg13g2_decap_8
X_08223_ _08223_/X _08119_/X _08128_/X _08223_/S VDD VSS sg13g2_mux2_1
XFILLER_14_1134 VDD VSS sg13g2_decap_8
XFILLER_53_1194 VDD VSS sg13g2_decap_8
XFILLER_181_609 VDD VSS sg13g2_decap_8
X_08154_ _08154_/Y _08154_/A _08174_/A _08659_/B _08484_/C VDD VSS sg13g2_nor4_1
XFILLER_146_341 VDD VSS sg13g2_decap_8
XFILLER_147_864 VDD VSS sg13g2_decap_8
XFILLER_162_801 VDD VSS sg13g2_decap_8
XFILLER_180_119 VDD VSS sg13g2_decap_8
XFILLER_161_300 VDD VSS sg13g2_decap_8
X_08085_ _08270_/C _08085_/A _08194_/B VDD VSS sg13g2_nand2_1
XFILLER_162_845 VDD VSS sg13g2_fill_2
XFILLER_88_1268 VDD VSS sg13g2_decap_4
XFILLER_162_856 VDD VSS sg13g2_fill_1
XFILLER_173_182 VDD VSS sg13g2_decap_8
X_14650__1622 _14650_/RESET_B VDD VSS sg13g2_tiehi
XFILLER_175_1238 VDD VSS sg13g2_decap_4
XFILLER_115_750 VDD VSS sg13g2_fill_2
XFILLER_134_569 VDD VSS sg13g2_decap_8
XFILLER_164_28 VDD VSS sg13g2_decap_8
XFILLER_103_901 VDD VSS sg13g2_fill_1
XFILLER_162_889 VDD VSS sg13g2_decap_8
XFILLER_87_100 VDD VSS sg13g2_decap_8
XFILLER_62_1408 VDD VSS sg13g2_fill_2
XFILLER_130_731 VDD VSS sg13g2_decap_8
XFILLER_88_645 VDD VSS sg13g2_decap_8
XFILLER_103_978 VDD VSS sg13g2_fill_2
XFILLER_48_509 VDD VSS sg13g2_fill_1
X_08987_ _08988_/C _12859_/A _10681_/A _10674_/A VDD VSS sg13g2_and3_1
XFILLER_88_689 VDD VSS sg13g2_fill_2
XFILLER_5_1302 VDD VSS sg13g2_decap_8
XFILLER_29_701 VDD VSS sg13g2_fill_1
X_13923__2349 _13923_/RESET_B VDD VSS sg13g2_tiehi
XFILLER_25_1252 VDD VSS sg13g2_decap_8
X_14683__1589 _14683_/RESET_B VDD VSS sg13g2_tiehi
X_07938_ _07938_/Y _07797_/D _07935_/Y _07937_/Y VDD VSS sg13g2_o21ai_1
XFILLER_29_723 VDD VSS sg13g2_decap_8
XFILLER_180_49 VDD VSS sg13g2_decap_8
XFILLER_99_1331 VDD VSS sg13g2_decap_8
XFILLER_21_1116 VDD VSS sg13g2_decap_8
XFILLER_60_1165 VDD VSS sg13g2_decap_4
XFILLER_56_531 VDD VSS sg13g2_decap_8
XFILLER_17_907 VDD VSS sg13g2_fill_1
XFILLER_186_1301 VDD VSS sg13g2_decap_8
XFILLER_60_1187 VDD VSS sg13g2_decap_8
XFILLER_5_1379 VDD VSS sg13g2_decap_8
X_07869_ _07869_/X _11428_/A _08201_/A VDD VSS sg13g2_or2_1
XFILLER_56_564 VDD VSS sg13g2_decap_8
XFILLER_16_406 VDD VSS sg13g2_decap_8
XFILLER_95_1217 VDD VSS sg13g2_fill_2
XFILLER_84_884 VDD VSS sg13g2_decap_8
X_09608_ _14204_/D _10072_/A0 _14204_/Q _09632_/S VDD VSS sg13g2_mux2_1
XFILLER_83_372 VDD VSS sg13g2_decap_4
XFILLER_147_1307 VDD VSS sg13g2_fill_2
X_10880_ _10880_/Y _10897_/A _14754_/Q VDD VSS sg13g2_nor2b_1
XFILLER_3_1092 VDD VSS sg13g2_decap_8
XFILLER_71_556 VDD VSS sg13g2_fill_2
XFILLER_58_1050 VDD VSS sg13g2_decap_8
X_09539_ _14138_/D _09638_/A0 _14138_/Q _09539_/S VDD VSS sg13g2_mux2_1
XFILLER_43_258 VDD VSS sg13g2_fill_1
XFILLER_19_1012 VDD VSS sg13g2_fill_1
XFILLER_24_472 VDD VSS sg13g2_decap_8
XFILLER_12_623 VDD VSS sg13g2_decap_8
X_12550_ _12550_/X _13961_/Q _13993_/Q _14025_/Q _14057_/Q _12550_/S0 _12550_/S1 VDD
+ VSS sg13g2_mux4_1
XFILLER_157_606 VDD VSS sg13g2_decap_8
XFILLER_11_133 VDD VSS sg13g2_decap_8
X_11501_ _14964_/D _11483_/A _11501_/A2 _11500_/Y VDD VSS sg13g2_a21o_1
XFILLER_40_965 VDD VSS sg13g2_decap_8
XFILLER_145_1097 VDD VSS sg13g2_decap_4
XFILLER_8_616 VDD VSS sg13g2_decap_8
X_12481_ _12481_/X _12478_/X _12477_/X _12474_/X _12473_/X _12732_/S0 _12762_/S VDD
+ VSS sg13g2_mux4_1
XFILLER_156_127 VDD VSS sg13g2_decap_8
XFILLER_71_1272 VDD VSS sg13g2_fill_1
XFILLER_156_138 VDD VSS sg13g2_fill_2
X_14220_ _14220_/Q _14540_/CLK _14220_/D _14220_/RESET_B VDD VSS sg13g2_dfrbpq_1
XFILLER_7_126 VDD VSS sg13g2_decap_8
X_11432_ _14961_/D _11428_/A _11501_/A2 _11431_/Y VDD VSS sg13g2_a21o_1
XFILLER_138_51 VDD VSS sg13g2_decap_8
XFILLER_22_84 VDD VSS sg13g2_decap_8
XFILLER_118_0 VDD VSS sg13g2_decap_8
XFILLER_171_119 VDD VSS sg13g2_decap_8
X_14151_ _14151_/Q _14727_/CLK _14151_/D _14151_/RESET_B VDD VSS sg13g2_dfrbpq_1
XFILLER_153_834 VDD VSS sg13g2_decap_4
X_11363_ _11363_/Y _11896_/A _14398_/Q _11897_/C VDD VSS sg13g2_a21oi_1
XFILLER_67_1308 VDD VSS sg13g2_decap_8
X_14883__2871 _14883_/RESET_B VDD VSS sg13g2_tiehi
XFILLER_67_1319 VDD VSS sg13g2_fill_2
XFILLER_4_833 VDD VSS sg13g2_decap_8
X_13102_ _13104_/A _14913_/Q _13674_/Q VDD VSS sg13g2_xor2_1
XFILLER_153_867 VDD VSS sg13g2_decap_8
X_14772__3034 _14772_/RESET_B VDD VSS sg13g2_tiehi
X_10314_ wire220/A _14796_/Q _14797_/Q _10342_/A _10327_/B VDD VSS sg13g2_nand4_1
XFILLER_152_355 VDD VSS sg13g2_fill_2
X_14082_ _14082_/Q _14656_/CLK _14082_/D _14082_/RESET_B VDD VSS sg13g2_dfrbpq_1
X_11294_ _14958_/D _11291_/A _11248_/B _11293_/Y VDD VSS sg13g2_a21o_1
XFILLER_3_343 VDD VSS sg13g2_decap_8
XFILLER_180_675 VDD VSS sg13g2_decap_8
XFILLER_98_77 VDD VSS sg13g2_decap_8
XFILLER_0_0 VDD VSS sg13g2_decap_8
XFILLER_152_377 VDD VSS sg13g2_decap_8
XFILLER_106_783 VDD VSS sg13g2_decap_8
X_13033_ _13033_/Y input27/X _12997_/Y _12937_/Y VDD VSS sg13g2_o21ai_1
X_10245_ _14776_/D _10245_/A _10608_/B _10245_/C VDD VSS sg13g2_nor3_1
XFILLER_79_623 VDD VSS sg13g2_decap_4
XFILLER_154_50 VDD VSS sg13g2_decap_8
Xfanout1100 _08668_/A _08659_/A VDD VSS sg13g2_buf_1
XFILLER_26_1016 VDD VSS sg13g2_decap_8
Xfanout1111 _08270_/B _08460_/A1 VDD VSS sg13g2_buf_1
XFILLER_78_133 VDD VSS sg13g2_decap_4
Xfanout1122 _08234_/A _13525_/A VDD VSS sg13g2_buf_1
X_10176_ _10176_/Y _14747_/Q _10174_/Y _10175_/Y VDD VSS sg13g2_a21oi_1
Xfanout1133 _07884_/A _08109_/A1 VDD VSS sg13g2_buf_1
XFILLER_78_155 VDD VSS sg13g2_decap_8
XFILLER_65_1098 VDD VSS sg13g2_decap_8
XFILLER_120_252 VDD VSS sg13g2_decap_8
Xfanout1144 fanout1144/X _14989_/Q VDD VSS sg13g2_buf_1
XFILLER_78_166 VDD VSS sg13g2_fill_2
Xfanout1155 _12229_/A _14986_/Q VDD VSS sg13g2_buf_1
XFILLER_43_1352 VDD VSS sg13g2_fill_2
XFILLER_117_1199 VDD VSS sg13g2_decap_8
Xfanout1166 _07861_/B _12061_/A VDD VSS sg13g2_buf_1
X_14513__1759 _14513_/RESET_B VDD VSS sg13g2_tiehi
X_14984_ _14984_/Q clkload69/A _14984_/D _14984_/RESET_B VDD VSS sg13g2_dfrbpq_1
Xfanout1177 _11936_/A _14978_/Q VDD VSS sg13g2_buf_1
Xfanout190 _09730_/A0 _10160_/A1 VDD VSS sg13g2_buf_1
Xfanout1188 _08510_/A3 _11843_/A VDD VSS sg13g2_buf_1
Xfanout1199 _11706_/A _08887_/A1 VDD VSS sg13g2_buf_1
XFILLER_43_1396 VDD VSS sg13g2_decap_4
X_13935_ _13935_/Q clkload13/A _13935_/D _13935_/RESET_B VDD VSS sg13g2_dfrbpq_1
Xwire1272 wire1272/X _14766_/Q VDD VSS sg13g2_buf_8
XFILLER_47_70 VDD VSS sg13g2_fill_1
XFILLER_47_553 VDD VSS sg13g2_decap_8
XFILLER_81_309 VDD VSS sg13g2_fill_2
XFILLER_47_92 VDD VSS sg13g2_decap_4
XFILLER_19_266 VDD VSS sg13g2_decap_8
XFILLER_130_1399 VDD VSS sg13g2_fill_2
XFILLER_90_832 VDD VSS sg13g2_decap_8
XFILLER_62_523 VDD VSS sg13g2_decap_8
X_13866_ _13866_/Q clkload27/A _13866_/D _13866_/RESET_B VDD VSS sg13g2_dfrbpq_1
XFILLER_165_1418 VDD VSS sg13g2_decap_8
X_12817_ _12817_/Y _14864_/Q _12895_/B VDD VSS sg13g2_nand2_1
XFILLER_90_876 VDD VSS sg13g2_decap_8
XFILLER_62_567 VDD VSS sg13g2_fill_1
XFILLER_16_973 VDD VSS sg13g2_decap_8
XFILLER_90_887 VDD VSS sg13g2_fill_2
X_13797_ _13797_/Q clkload8/A _13797_/D _13797_/RESET_B VDD VSS sg13g2_dfrbpq_1
XFILLER_43_781 VDD VSS sg13g2_decap_8
XFILLER_15_483 VDD VSS sg13g2_decap_8
X_12748_ _12748_/X _12746_/X _12747_/X _12748_/S VDD VSS sg13g2_mux2_1
XFILLER_31_943 VDD VSS sg13g2_decap_4
XFILLER_30_431 VDD VSS sg13g2_decap_4
XFILLER_148_617 VDD VSS sg13g2_decap_4
XFILLER_124_1137 VDD VSS sg13g2_decap_8
XFILLER_15_1410 VDD VSS sg13g2_decap_8
XFILLER_179_91 VDD VSS sg13g2_decap_8
X_15094__2886 _15094_/RESET_B VDD VSS sg13g2_tiehi
XFILLER_148_639 VDD VSS sg13g2_fill_1
XFILLER_175_425 VDD VSS sg13g2_decap_8
XFILLER_50_1301 VDD VSS sg13g2_decap_8
X_12679_ _12680_/B _13670_/Q _12707_/A2 _12678_/X _12707_/B2 _12707_/C1 VDD VSS sg13g2_a221oi_1
XFILLER_8_42 VDD VSS sg13g2_decap_8
XFILLER_129_853 VDD VSS sg13g2_fill_1
X_14418_ _14418_/Q clkload22/A _14418_/D _14418_/RESET_B VDD VSS sg13g2_dfrbpq_1
XFILLER_156_650 VDD VSS sg13g2_decap_8
XFILLER_129_886 VDD VSS sg13g2_decap_8
X_14349_ _14349_/Q clkload18/A _14349_/D _14349_/RESET_B VDD VSS sg13g2_dfrbpq_1
XFILLER_155_171 VDD VSS sg13g2_decap_8
XFILLER_116_536 VDD VSS sg13g2_decap_8
XFILLER_128_396 VDD VSS sg13g2_decap_8
XFILLER_7_693 VDD VSS sg13g2_decap_8
XFILLER_171_642 VDD VSS sg13g2_decap_8
XFILLER_144_878 VDD VSS sg13g2_decap_8
Xmax_cap357 _09859_/S _09865_/S VDD VSS sg13g2_buf_4
XFILLER_171_664 VDD VSS sg13g2_decap_8
XFILLER_100_1181 VDD VSS sg13g2_decap_8
X_08910_ _08910_/Y _13608_/A1 _08835_/B _16872_/A VDD VSS sg13g2_a21oi_1
XFILLER_69_100 VDD VSS sg13g2_decap_8
XFILLER_124_580 VDD VSS sg13g2_fill_2
XFILLER_139_1380 VDD VSS sg13g2_decap_8
X_09890_ _14476_/D _09923_/A1 _14476_/Q _09904_/S VDD VSS sg13g2_mux2_1
XFILLER_83_1143 VDD VSS sg13g2_decap_8
XFILLER_174_1271 VDD VSS sg13g2_decap_4
XFILLER_33_0 VDD VSS sg13g2_decap_8
XFILLER_174_1293 VDD VSS sg13g2_decap_8
XFILLER_83_1176 VDD VSS sg13g2_decap_8
XFILLER_48_1296 VDD VSS sg13g2_decap_8
X_08841_ _08841_/Y _08850_/S _08840_/Y _08836_/Y VDD VSS sg13g2_o21ai_1
XFILLER_135_1266 VDD VSS sg13g2_decap_8
XFILLER_131_1119 VDD VSS sg13g2_decap_8
XFILLER_111_274 VDD VSS sg13g2_decap_8
XFILLER_85_637 VDD VSS sg13g2_decap_4
X_08772_ _08772_/Y _13676_/Q _08775_/B VDD VSS sg13g2_nor2_1
XFILLER_85_648 VDD VSS sg13g2_decap_8
XFILLER_84_125 VDD VSS sg13g2_decap_8
XFILLER_22_1436 VDD VSS sg13g2_decap_8
X_07723_ _07726_/B _13427_/C _15095_/Q _15091_/Q _15090_/Q VDD VSS sg13g2_nor4_1
XFILLER_72_309 VDD VSS sg13g2_decap_8
XFILLER_93_681 VDD VSS sg13g2_decap_4
X_07654_ _07654_/Y _07654_/A VDD VSS sg13g2_inv_1
XFILLER_26_759 VDD VSS sg13g2_decap_8
XFILLER_92_191 VDD VSS sg13g2_decap_8
XFILLER_80_342 VDD VSS sg13g2_fill_2
XFILLER_0_1254 VDD VSS sg13g2_decap_8
XFILLER_20_1182 VDD VSS sg13g2_decap_8
XFILLER_80_353 VDD VSS sg13g2_decap_8
XFILLER_59_1370 VDD VSS sg13g2_fill_1
X_14668__1604 _14668_/RESET_B VDD VSS sg13g2_tiehi
XFILLER_25_269 VDD VSS sg13g2_decap_8
XFILLER_81_898 VDD VSS sg13g2_fill_1
XFILLER_43_28 VDD VSS sg13g2_decap_8
XFILLER_55_1223 VDD VSS sg13g2_decap_4
X_09324_ _13931_/D _10154_/A1 _13931_/Q _09331_/S VDD VSS sg13g2_mux2_1
XFILLER_90_1125 VDD VSS sg13g2_decap_8
XFILLER_55_1245 VDD VSS sg13g2_decap_8
XFILLER_22_932 VDD VSS sg13g2_decap_8
XFILLER_159_28 VDD VSS sg13g2_decap_8
XFILLER_167_915 VDD VSS sg13g2_decap_8
XFILLER_178_252 VDD VSS sg13g2_decap_8
XFILLER_179_775 VDD VSS sg13g2_decap_8
XFILLER_90_1147 VDD VSS sg13g2_decap_8
XFILLER_107_1335 VDD VSS sg13g2_decap_8
XFILLER_179_786 VDD VSS sg13g2_fill_2
XFILLER_21_442 VDD VSS sg13g2_decap_8
XFILLER_55_1278 VDD VSS sg13g2_decap_4
XFILLER_107_1357 VDD VSS sg13g2_decap_8
X_14097__2175 _14097_/RESET_B VDD VSS sg13g2_tiehi
X_09255_ _13864_/D _13864_/Q _10151_/A1 _09267_/S VDD VSS sg13g2_mux2_1
XFILLER_138_127 VDD VSS sg13g2_decap_8
X_08206_ _08211_/B _15104_/Q _15091_/Q _08247_/A VDD VSS sg13g2_o21ai_1
X_09186_ _13802_/D _13802_/Q _10153_/A1 _09196_/S VDD VSS sg13g2_mux2_1
XFILLER_181_406 VDD VSS sg13g2_decap_8
XFILLER_153_108 VDD VSS sg13g2_decap_4
XFILLER_88_1021 VDD VSS sg13g2_fill_2
XFILLER_105_1092 VDD VSS sg13g2_decap_8
X_08137_ _08138_/A _08142_/C _11335_/A _13602_/A _13601_/A _13517_/A _08300_/S1 VDD
+ VSS sg13g2_mux4_1
XFILLER_111_7 VDD VSS sg13g2_decap_8
XFILLER_175_49 VDD VSS sg13g2_decap_8
XFILLER_49_1005 VDD VSS sg13g2_decap_8
X_15036__2644 _15036_/RESET_B VDD VSS sg13g2_tiehi
XFILLER_134_355 VDD VSS sg13g2_decap_8
X_08068_ _08068_/Y _08029_/Y _08066_/Y _08256_/A _08244_/B _08067_/Y VDD VSS sg13g2_a221oi_1
XFILLER_122_506 VDD VSS sg13g2_decap_8
XFILLER_134_366 VDD VSS sg13g2_decap_8
XFILLER_150_815 VDD VSS sg13g2_decap_8
XFILLER_162_675 VDD VSS sg13g2_decap_8
Xclkbuf_4_0_0_clk_i clkbuf_4_0_0_clk_i/X clkbuf_0_clk_i/X VDD VSS sg13g2_buf_8
XFILLER_150_848 VDD VSS sg13g2_decap_8
XFILLER_1_847 VDD VSS sg13g2_decap_8
XFILLER_27_1314 VDD VSS sg13g2_decap_8
XFILLER_103_731 VDD VSS sg13g2_decap_8
XFILLER_118_1442 VDD VSS sg13g2_decap_4
Xhold3230 hold3230/X _15167_/Q VDD VSS sg13g2_dlygate4sd3_1
Xhold3241 _13590_/A _15162_/Q VDD VSS sg13g2_dlygate4sd3_1
X_10030_ _14612_/D _10096_/A0 _14612_/Q _10030_/S VDD VSS sg13g2_mux2_1
X_14760__3049 _14760_/RESET_B VDD VSS sg13g2_tiehi
XFILLER_0_357 VDD VSS sg13g2_decap_8
Xhold3252 _10796_/A _14926_/Q VDD VSS sg13g2_dlygate4sd3_1
XFILLER_89_987 VDD VSS sg13g2_decap_4
XFILLER_102_241 VDD VSS sg13g2_decap_8
Xhold3263 hold3263/X _14928_/Q VDD VSS sg13g2_dlygate4sd3_1
XFILLER_102_252 VDD VSS sg13g2_fill_1
XFILLER_89_998 VDD VSS sg13g2_fill_1
XFILLER_62_1249 VDD VSS sg13g2_decap_8
XFILLER_48_306 VDD VSS sg13g2_decap_8
XFILLER_153_1377 VDD VSS sg13g2_fill_2
XFILLER_88_486 VDD VSS sg13g2_decap_8
XFILLER_76_626 VDD VSS sg13g2_decap_8
XFILLER_114_1339 VDD VSS sg13g2_fill_2
XFILLER_153_1388 VDD VSS sg13g2_fill_2
XFILLER_99_1150 VDD VSS sg13g2_fill_2
X_11981_ _12012_/A _11983_/A _13671_/Q VDD VSS sg13g2_nand2_1
XFILLER_5_1176 VDD VSS sg13g2_decap_8
XFILLER_90_117 VDD VSS sg13g2_decap_8
XFILLER_16_203 VDD VSS sg13g2_decap_8
XFILLER_1_1029 VDD VSS sg13g2_decap_8
X_13720_ _16882_/A clkload72/A _13720_/D _13720_/RESET_B VDD VSS sg13g2_dfrbpq_1
X_10932_ _10948_/D _10946_/B _10932_/B VDD VSS sg13g2_nand2_1
XFILLER_90_128 VDD VSS sg13g2_fill_2
XFILLER_29_597 VDD VSS sg13g2_decap_8
XFILLER_147_1104 VDD VSS sg13g2_decap_8
XFILLER_71_320 VDD VSS sg13g2_decap_8
XFILLER_95_1047 VDD VSS sg13g2_decap_4
XFILLER_140_41 VDD VSS sg13g2_decap_8
XFILLER_186_1164 VDD VSS sg13g2_decap_8
XFILLER_72_865 VDD VSS sg13g2_fill_1
XFILLER_140_52 VDD VSS sg13g2_fill_1
XFILLER_186_1175 VDD VSS sg13g2_decap_8
XFILLER_56_1009 VDD VSS sg13g2_fill_1
XFILLER_17_84 VDD VSS sg13g2_decap_8
X_13651_ _15117_/D _15186_/D _15117_/Q _13651_/S VDD VSS sg13g2_mux2_1
X_10863_ _10863_/X _10871_/A _14753_/Q VDD VSS sg13g2_and2_1
XFILLER_32_718 VDD VSS sg13g2_decap_8
XFILLER_13_910 VDD VSS sg13g2_decap_8
XFILLER_140_74 VDD VSS sg13g2_decap_8
X_12602_ _12602_/X _13965_/Q _13997_/Q _14029_/Q _14061_/Q _12606_/S0 _12606_/S1 VDD
+ VSS sg13g2_mux4_1
XFILLER_12_420 VDD VSS sg13g2_decap_8
X_13582_ _15159_/D _13581_/B _13580_/Y _13581_/Y VDD VSS sg13g2_a21oi_1
XFILLER_73_1345 VDD VSS sg13g2_decap_8
XFILLER_38_1465 VDD VSS sg13g2_decap_8
X_10794_ _11205_/A _14956_/Q _10725_/A _10793_/X VDD VSS sg13g2_a21oi_1
XFILLER_9_903 VDD VSS sg13g2_decap_8
XFILLER_73_1356 VDD VSS sg13g2_fill_1
XFILLER_34_1329 VDD VSS sg13g2_decap_8
XFILLER_157_414 VDD VSS sg13g2_decap_8
X_12533_ _12533_/X _14568_/Q _14600_/Q _14632_/Q _14664_/Q _12755_/S0 _12758_/S1 VDD
+ VSS sg13g2_mux4_1
XFILLER_13_987 VDD VSS sg13g2_decap_8
XFILLER_8_413 VDD VSS sg13g2_decap_8
XFILLER_160_1348 VDD VSS sg13g2_decap_8
X_13762__2510 _13762_/RESET_B VDD VSS sg13g2_tiehi
XFILLER_12_497 VDD VSS sg13g2_decap_8
X_12464_ _12464_/X _13731_/Q _14083_/Q _14435_/Q _14531_/Q _12769_/S0 _12769_/S1 VDD
+ VSS sg13g2_mux4_1
XFILLER_32_1053 VDD VSS sg13g2_fill_1
XFILLER_172_417 VDD VSS sg13g2_decap_8
X_14203_ _14203_/Q _14685_/CLK _14203_/D _14203_/RESET_B VDD VSS sg13g2_dfrbpq_1
XFILLER_125_300 VDD VSS sg13g2_fill_2
XFILLER_138_683 VDD VSS sg13g2_decap_8
X_11415_ _11415_/X _14111_/Q _14143_/Q _11415_/S VDD VSS sg13g2_mux2_1
X_15183_ _15183_/Q _15200_/CLK _15183_/D _15183_/RESET_B VDD VSS sg13g2_dfrbpq_1
XFILLER_158_1211 VDD VSS sg13g2_decap_4
X_12395_ _12395_/X _14366_/Q _14398_/Q _14462_/Q _14494_/Q wire940/X _12620_/S1 VDD
+ VSS sg13g2_mux4_1
XFILLER_4_630 VDD VSS sg13g2_decap_8
X_14134_ _14134_/Q _14518_/CLK _14134_/D _14134_/RESET_B VDD VSS sg13g2_dfrbpq_1
XFILLER_10_1351 VDD VSS sg13g2_decap_8
X_11346_ _11346_/Y _11342_/Y _11343_/Y _11345_/Y _11344_/Y _11822_/B VDD VSS sg13g2_a221oi_1
XFILLER_119_1217 VDD VSS sg13g2_decap_4
X_14142__2130 _14142_/RESET_B VDD VSS sg13g2_tiehi
XFILLER_3_140 VDD VSS sg13g2_decap_8
XFILLER_180_483 VDD VSS sg13g2_decap_8
X_13795__2477 _13795_/RESET_B VDD VSS sg13g2_tiehi
X_14065_ _14065_/Q clkload6/A _14065_/D _14065_/RESET_B VDD VSS sg13g2_dfrbpq_1
X_11277_ _11277_/X _14108_/Q _14140_/Q _11277_/S VDD VSS sg13g2_mux2_1
X_13016_ _13016_/Y _13013_/Y _13014_/Y _13015_/Y VDD VSS sg13g2_a21oi_1
X_10228_ _10228_/Y _10237_/A _10237_/C _10441_/C VDD VSS sg13g2_o21ai_1
X_14746__1526 _14746_/RESET_B VDD VSS sg13g2_tiehi
XFILLER_79_464 VDD VSS sg13g2_decap_4
XFILLER_94_401 VDD VSS sg13g2_decap_8
XFILLER_132_1428 VDD VSS sg13g2_fill_2
X_10159_ _14736_/D _14736_/Q _10159_/A1 _10160_/S VDD VSS sg13g2_mux2_1
XFILLER_66_125 VDD VSS sg13g2_decap_8
XFILLER_181_70 VDD VSS sg13g2_decap_8
X_14175__2097 _14175_/RESET_B VDD VSS sg13g2_tiehi
XFILLER_130_1141 VDD VSS sg13g2_decap_8
X_14967_ _14967_/Q clkload43/A _14967_/D _14967_/RESET_B VDD VSS sg13g2_dfrbpq_1
XFILLER_130_1163 VDD VSS sg13g2_decap_8
XFILLER_47_361 VDD VSS sg13g2_decap_8
XFILLER_75_681 VDD VSS sg13g2_decap_8
XFILLER_75_692 VDD VSS sg13g2_fill_1
X_13918_ _13918_/Q _14734_/CLK _13918_/D _13918_/RESET_B VDD VSS sg13g2_dfrbpq_1
X_14898_ _14898_/Q clkload79/A _14898_/D _14898_/RESET_B VDD VSS sg13g2_dfrbpq_1
XFILLER_78_1256 VDD VSS sg13g2_fill_1
XFILLER_74_180 VDD VSS sg13g2_decap_8
XFILLER_62_320 VDD VSS sg13g2_decap_8
XFILLER_39_1218 VDD VSS sg13g2_fill_1
XFILLER_165_1226 VDD VSS sg13g2_decap_8
XFILLER_35_567 VDD VSS sg13g2_decap_8
X_13849_ _13849_/Q _14745_/CLK _13849_/D _13849_/RESET_B VDD VSS sg13g2_dfrbpq_1
XFILLER_91_1401 VDD VSS sg13g2_decap_8
XFILLER_90_673 VDD VSS sg13g2_fill_1
XFILLER_63_898 VDD VSS sg13g2_fill_2
XFILLER_16_770 VDD VSS sg13g2_decap_8
XFILLER_62_375 VDD VSS sg13g2_fill_1
XFILLER_22_217 VDD VSS sg13g2_decap_8
XFILLER_149_904 VDD VSS sg13g2_decap_4
XFILLER_50_548 VDD VSS sg13g2_decap_8
XFILLER_15_280 VDD VSS sg13g2_decap_8
XFILLER_176_723 VDD VSS sg13g2_decap_8
XFILLER_52_1429 VDD VSS sg13g2_decap_4
X_14352__1920 _14352_/RESET_B VDD VSS sg13g2_tiehi
X_09040_ _10716_/B _09053_/B _15034_/Q _09039_/Y VDD VSS sg13g2_o21ai_1
XFILLER_136_609 VDD VSS sg13g2_decap_4
XFILLER_30_294 VDD VSS sg13g2_decap_8
XFILLER_175_266 VDD VSS sg13g2_decap_8
XFILLER_159_1008 VDD VSS sg13g2_decap_8
XFILLER_117_823 VDD VSS sg13g2_fill_2
XFILLER_141_1281 VDD VSS sg13g2_fill_1
XFILLER_15_1284 VDD VSS sg13g2_decap_8
XFILLER_8_980 VDD VSS sg13g2_decap_8
X_14982__2698 _14982_/RESET_B VDD VSS sg13g2_tiehi
X_15186__2900 _15186_/RESET_B VDD VSS sg13g2_tiehi
XFILLER_50_1186 VDD VSS sg13g2_fill_2
XFILLER_11_1148 VDD VSS sg13g2_decap_8
XFILLER_176_1333 VDD VSS sg13g2_decap_8
XFILLER_7_490 VDD VSS sg13g2_decap_8
XFILLER_143_130 VDD VSS sg13g2_decap_8
XFILLER_104_506 VDD VSS sg13g2_decap_8
XFILLER_172_995 VDD VSS sg13g2_decap_8
X_09942_ _14526_/D _14526_/Q _10041_/A0 _09958_/S VDD VSS sg13g2_mux2_1
XFILLER_116_399 VDD VSS sg13g2_decap_8
X_14385__1887 _14385_/RESET_B VDD VSS sg13g2_tiehi
Xmax_cap198 _10413_/B _10401_/A VDD VSS sg13g2_buf_2
Xfanout904 _12769_/S1 _12773_/S1 VDD VSS sg13g2_buf_1
Xfanout915 _12600_/S0 _12604_/S0 VDD VSS sg13g2_buf_1
XFILLER_98_751 VDD VSS sg13g2_fill_2
XFILLER_135_1030 VDD VSS sg13g2_decap_8
Xfanout926 _12675_/S0 _12674_/S0 VDD VSS sg13g2_buf_1
Xfanout937 _12588_/S0 fanout948/X VDD VSS sg13g2_buf_1
X_09873_ _14459_/D _09906_/A1 _14459_/Q _09904_/S VDD VSS sg13g2_mux2_1
XFILLER_98_773 VDD VSS sg13g2_decap_8
Xfanout948 fanout948/X _15210_/Q VDD VSS sg13g2_buf_1
XFILLER_86_924 VDD VSS sg13g2_decap_8
XFILLER_85_401 VDD VSS sg13g2_decap_8
Xfanout959 _12550_/S0 _12773_/S0 VDD VSS sg13g2_buf_1
XFILLER_97_272 VDD VSS sg13g2_decap_8
XFILLER_38_28 VDD VSS sg13g2_decap_8
X_08824_ _08824_/Y _13482_/A _15190_/Q VDD VSS sg13g2_nand2_1
XFILLER_100_745 VDD VSS sg13g2_decap_8
XFILLER_61_1260 VDD VSS sg13g2_decap_8
XFILLER_57_147 VDD VSS sg13g2_decap_8
XFILLER_100_767 VDD VSS sg13g2_decap_8
XFILLER_22_1233 VDD VSS sg13g2_decap_8
XFILLER_6_1463 VDD VSS sg13g2_decap_8
X_08755_ _08755_/Y _13670_/Q _08781_/B VDD VSS sg13g2_nor2_1
XFILLER_6_1474 VDD VSS sg13g2_fill_1
X_13840__2432 _13840_/RESET_B VDD VSS sg13g2_tiehi
X_14005__2267 _14005_/RESET_B VDD VSS sg13g2_tiehi
XFILLER_2_1316 VDD VSS sg13g2_decap_8
XFILLER_66_670 VDD VSS sg13g2_fill_2
X_07706_ _07708_/B _13602_/A _15201_/Q _13601_/A VDD VSS sg13g2_a21oi_1
X_08686_ _08686_/X _08692_/B _12278_/A _14986_/Q _07972_/B _08686_/S0 _13510_/A1 VDD
+ VSS sg13g2_mux4_1
XFILLER_57_1307 VDD VSS sg13g2_fill_1
XFILLER_26_545 VDD VSS sg13g2_decap_8
XFILLER_54_865 VDD VSS sg13g2_decap_8
XFILLER_53_342 VDD VSS sg13g2_decap_8
XFILLER_14_707 VDD VSS sg13g2_decap_8
XFILLER_54_49 VDD VSS sg13g2_decap_8
X_07637_ _10237_/A _14771_/Q VDD VSS sg13g2_inv_1
XFILLER_0_1051 VDD VSS sg13g2_decap_8
XFILLER_109_1419 VDD VSS sg13g2_decap_8
XFILLER_81_684 VDD VSS sg13g2_fill_2
XFILLER_13_217 VDD VSS sg13g2_decap_8
XFILLER_159_7 VDD VSS sg13g2_decap_8
XFILLER_186_509 VDD VSS sg13g2_decap_8
XFILLER_107_1110 VDD VSS sg13g2_fill_1
X_14220__2052 _14220_/RESET_B VDD VSS sg13g2_tiehi
XFILLER_41_559 VDD VSS sg13g2_decap_8
XFILLER_146_1181 VDD VSS sg13g2_decap_4
X_09307_ _09339_/S _09938_/D _09307_/B VDD VSS sg13g2_or2_1
XFILLER_110_77 VDD VSS sg13g2_decap_8
X_13873__2399 _13873_/RESET_B VDD VSS sg13g2_tiehi
XFILLER_10_924 VDD VSS sg13g2_decap_8
XFILLER_107_1165 VDD VSS sg13g2_decap_8
XFILLER_16_1048 VDD VSS sg13g2_decap_8
XFILLER_142_1067 VDD VSS sg13g2_fill_1
X_09238_ _13849_/D _09472_/A0 _13849_/Q _09238_/S VDD VSS sg13g2_mux2_1
XFILLER_107_1198 VDD VSS sg13g2_decap_8
XFILLER_148_970 VDD VSS sg13g2_decap_4
XFILLER_166_266 VDD VSS sg13g2_decap_8
XFILLER_6_917 VDD VSS sg13g2_decap_8
XFILLER_186_59 VDD VSS sg13g2_decap_8
XFILLER_181_203 VDD VSS sg13g2_decap_8
XFILLER_182_737 VDD VSS sg13g2_decap_4
X_09169_ _09938_/D _09441_/A _09240_/A _09441_/C VDD VSS sg13g2_nand3_1
XFILLER_5_427 VDD VSS sg13g2_decap_8
XFILLER_107_322 VDD VSS sg13g2_decap_8
XFILLER_120_1365 VDD VSS sg13g2_decap_4
X_11200_ _11201_/B _10785_/Y _11185_/B _11171_/B VDD VSS sg13g2_o21ai_1
XFILLER_123_804 VDD VSS sg13g2_decap_8
XFILLER_163_973 VDD VSS sg13g2_decap_8
X_12180_ _12181_/A _14262_/Q _14294_/Q _14326_/Q _14358_/Q _12245_/S0 _12245_/S1 VDD
+ VSS sg13g2_mux4_1
XFILLER_107_366 VDD VSS sg13g2_fill_2
XFILLER_122_303 VDD VSS sg13g2_decap_4
X_11131_ _11131_/Y _11109_/B _10769_/X _11154_/B1 VDD VSS sg13g2_o21ai_1
XFILLER_27_1111 VDD VSS sg13g2_decap_8
XFILLER_1_644 VDD VSS sg13g2_decap_8
XFILLER_89_751 VDD VSS sg13g2_decap_4
XFILLER_62_1013 VDD VSS sg13g2_decap_8
XFILLER_150_678 VDD VSS sg13g2_decap_8
X_11062_ _11062_/Y _11185_/A _11078_/A _11061_/Y VDD VSS sg13g2_a21oi_1
XFILLER_0_154 VDD VSS sg13g2_decap_8
XFILLER_135_74 VDD VSS sg13g2_fill_1
X_10013_ _14595_/D _10079_/A0 _14595_/Q _10031_/S VDD VSS sg13g2_mux2_1
XFILLER_103_594 VDD VSS sg13g2_decap_8
XFILLER_88_294 VDD VSS sg13g2_decap_8
XFILLER_27_1188 VDD VSS sg13g2_decap_8
XFILLER_49_659 VDD VSS sg13g2_fill_2
X_14821_ _14821_/Q clkload63/A _14821_/D _14821_/RESET_B VDD VSS sg13g2_dfrbpq_1
XFILLER_185_0 VDD VSS sg13g2_decap_8
XFILLER_76_489 VDD VSS sg13g2_decap_8
X_14430__1842 _14430_/RESET_B VDD VSS sg13g2_tiehi
XFILLER_85_990 VDD VSS sg13g2_decap_4
XFILLER_151_62 VDD VSS sg13g2_decap_4
X_14752_ _14752_/Q clkload80/A _14752_/D _14752_/RESET_B VDD VSS sg13g2_dfrbpq_1
X_11964_ _11964_/X _11964_/A _11964_/B VDD VSS sg13g2_and2_1
XFILLER_91_448 VDD VSS sg13g2_decap_8
XFILLER_151_95 VDD VSS sg13g2_decap_8
X_13703_ _16865_/A clkload74/A _13703_/D _13703_/RESET_B VDD VSS sg13g2_dfrbpq_1
XFILLER_17_567 VDD VSS sg13g2_decap_8
X_10915_ _10946_/A _10936_/C _15119_/Q VDD VSS sg13g2_nand2_1
XFILLER_72_662 VDD VSS sg13g2_decap_8
X_14683_ _14683_/Q clkload60/A _14683_/D _14683_/RESET_B VDD VSS sg13g2_dfrbpq_1
XFILLER_60_813 VDD VSS sg13g2_decap_4
X_11895_ _11897_/A _11880_/A1 _14190_/Q VDD VSS sg13g2_nand2b_1
XFILLER_32_515 VDD VSS sg13g2_decap_4
X_13634_ _13742_/D _13634_/A VDD VSS sg13g2_buf_1
X_10846_ _10846_/Y _10845_/Y _10897_/D _13307_/B VDD VSS sg13g2_a21oi_1
XFILLER_32_548 VDD VSS sg13g2_fill_2
XFILLER_9_700 VDD VSS sg13g2_decap_8
XFILLER_34_1115 VDD VSS sg13g2_decap_8
X_13565_ _15153_/D _15153_/Q _13564_/Y _13570_/S VDD VSS sg13g2_mux2_1
X_13703__2569 _13703_/RESET_B VDD VSS sg13g2_tiehi
XFILLER_38_1295 VDD VSS sg13g2_fill_1
XFILLER_13_784 VDD VSS sg13g2_decap_8
X_10777_ _11164_/B _14952_/Q _08933_/S _10776_/X VDD VSS sg13g2_a21oi_1
XFILLER_8_210 VDD VSS sg13g2_decap_8
XFILLER_185_553 VDD VSS sg13g2_decap_8
X_12516_ _12516_/X _14695_/Q _14727_/Q _13767_/Q _13799_/Q _12522_/S0 _12522_/S1 VDD
+ VSS sg13g2_mux4_1
XFILLER_12_294 VDD VSS sg13g2_decap_8
XFILLER_146_929 VDD VSS sg13g2_fill_1
X_13496_ _15126_/D _13494_/Y _13495_/Y _13493_/Y VDD VSS sg13g2_o21ai_1
XFILLER_9_777 VDD VSS sg13g2_decap_8
XFILLER_74_7 VDD VSS sg13g2_decap_4
XFILLER_172_203 VDD VSS sg13g2_decap_8
X_15235_ _15235_/Q _15237_/CLK _15235_/D _15235_/RESET_B VDD VSS sg13g2_dfrbpq_1
XFILLER_60_70 VDD VSS sg13g2_decap_8
XFILLER_12_1435 VDD VSS sg13g2_decap_8
XFILLER_145_439 VDD VSS sg13g2_decap_8
X_12447_ _12447_/X _13826_/Q _13858_/Q _13890_/Q _13922_/Q _12450_/S0 _12450_/S1 VDD
+ VSS sg13g2_mux4_1
XFILLER_8_287 VDD VSS sg13g2_decap_8
XFILLER_172_247 VDD VSS sg13g2_decap_8
XFILLER_176_70 VDD VSS sg13g2_decap_8
X_15166_ _15166_/Q clkload89/A _15166_/D _15166_/RESET_B VDD VSS sg13g2_dfrbpq_1
XFILLER_5_21 VDD VSS sg13g2_decap_8
X_12378_ _12378_/X _14685_/Q _14717_/Q _13757_/Q _13789_/Q _12378_/S0 _12378_/S1 VDD
+ VSS sg13g2_mux4_1
XFILLER_126_675 VDD VSS sg13g2_decap_8
XFILLER_154_984 VDD VSS sg13g2_decap_8
XFILLER_158_1052 VDD VSS sg13g2_fill_1
XFILLER_125_163 VDD VSS sg13g2_fill_1
X_14117_ _14117_/Q clkload8/A _14117_/D _14117_/RESET_B VDD VSS sg13g2_dfrbpq_1
XFILLER_5_994 VDD VSS sg13g2_decap_8
X_11329_ _11329_/Y _11327_/Y _11326_/Y _11329_/B1 _11328_/X VDD VSS sg13g2_a22oi_1
XFILLER_114_859 VDD VSS sg13g2_fill_2
XFILLER_125_185 VDD VSS sg13g2_decap_8
XFILLER_180_280 VDD VSS sg13g2_decap_8
X_15097_ _15097_/Q clkload86/A _15097_/D _15097_/RESET_B VDD VSS sg13g2_dfrbpq_1
XFILLER_141_656 VDD VSS sg13g2_decap_8
XFILLER_5_98 VDD VSS sg13g2_decap_8
XFILLER_45_1211 VDD VSS sg13g2_decap_8
XFILLER_141_678 VDD VSS sg13g2_fill_1
X_14048_ _14048_/Q _14720_/CLK _14048_/D _14048_/RESET_B VDD VSS sg13g2_dfrbpq_1
X_14967__2713 _14967_/RESET_B VDD VSS sg13g2_tiehi
XFILLER_136_1372 VDD VSS sg13g2_decap_8
XFILLER_171_1252 VDD VSS sg13g2_decap_8
XFILLER_140_188 VDD VSS sg13g2_decap_8
XFILLER_95_743 VDD VSS sg13g2_decap_8
XFILLER_67_445 VDD VSS sg13g2_fill_1
XFILLER_48_681 VDD VSS sg13g2_decap_8
X_08540_ _08545_/B _08621_/A _08538_/X _08539_/Y VDD VSS sg13g2_o21ai_1
XFILLER_48_692 VDD VSS sg13g2_fill_2
XFILLER_36_832 VDD VSS sg13g2_decap_4
XFILLER_82_459 VDD VSS sg13g2_decap_8
XFILLER_47_191 VDD VSS sg13g2_decap_8
XFILLER_63_662 VDD VSS sg13g2_decap_4
X_08471_ _08494_/A _15008_/Q _08471_/B VDD VSS sg13g2_nor2_1
XFILLER_36_898 VDD VSS sg13g2_decap_8
XFILLER_126_1007 VDD VSS sg13g2_fill_1
XFILLER_1_1393 VDD VSS sg13g2_decap_8
X_14844__2949 _14844_/RESET_B VDD VSS sg13g2_tiehi
XFILLER_50_334 VDD VSS sg13g2_decap_8
XFILLER_23_559 VDD VSS sg13g2_decap_8
XFILLER_165_1089 VDD VSS sg13g2_decap_8
XFILLER_17_1313 VDD VSS sg13g2_decap_8
XFILLER_50_345 VDD VSS sg13g2_fill_2
XFILLER_108_1441 VDD VSS sg13g2_fill_1
XFILLER_108_1452 VDD VSS sg13g2_decap_8
XFILLER_149_734 VDD VSS sg13g2_fill_1
XFILLER_104_1305 VDD VSS sg13g2_decap_8
XFILLER_50_389 VDD VSS sg13g2_decap_8
XFILLER_137_918 VDD VSS sg13g2_decap_8
XFILLER_176_564 VDD VSS sg13g2_decap_8
XFILLER_104_1349 VDD VSS sg13g2_fill_2
X_09023_ _09024_/C _10702_/A wire584/X _12957_/A VDD VSS sg13g2_a21o_1
XFILLER_15_1081 VDD VSS sg13g2_decap_8
XFILLER_178_1439 VDD VSS sg13g2_decap_4
XFILLER_102_1051 VDD VSS sg13g2_decap_8
X_13858__2414 _13858_/RESET_B VDD VSS sg13g2_tiehi
XFILLER_89_1182 VDD VSS sg13g2_decap_8
XFILLER_102_1084 VDD VSS sg13g2_decap_8
XFILLER_132_601 VDD VSS sg13g2_decap_8
XFILLER_85_1024 VDD VSS sg13g2_decap_8
XFILLER_116_163 VDD VSS sg13g2_fill_1
XFILLER_144_472 VDD VSS sg13g2_decap_8
X_14928__2781 _14928_/RESET_B VDD VSS sg13g2_tiehi
XFILLER_172_1016 VDD VSS sg13g2_decap_4
XFILLER_171_291 VDD VSS sg13g2_decap_8
XFILLER_63_1300 VDD VSS sg13g2_decap_4
XFILLER_120_807 VDD VSS sg13g2_decap_8
Xfanout701 _12443_/A2 _12777_/C1 VDD VSS sg13g2_buf_1
Xfanout712 _13193_/B _13082_/B VDD VSS sg13g2_buf_1
X_09925_ _14510_/D _14510_/Q _09925_/A1 _09925_/S VDD VSS sg13g2_mux2_1
XFILLER_49_49 VDD VSS sg13g2_decap_8
XFILLER_131_155 VDD VSS sg13g2_decap_8
XFILLER_132_678 VDD VSS sg13g2_decap_8
XFILLER_172_28 VDD VSS sg13g2_decap_8
Xfanout723 _11207_/B1 _10999_/B1 VDD VSS sg13g2_buf_1
XFILLER_160_998 VDD VSS sg13g2_fill_1
Xfanout734 _12225_/B2 _11722_/B2 VDD VSS sg13g2_buf_1
XFILLER_28_1464 VDD VSS sg13g2_decap_8
Xfanout745 _13477_/S _13479_/S VDD VSS sg13g2_buf_1
XFILLER_86_721 VDD VSS sg13g2_decap_8
Xfanout756 _11763_/B _11964_/B VDD VSS sg13g2_buf_1
X_14238__2034 _14238_/RESET_B VDD VSS sg13g2_tiehi
Xfanout767 _12329_/C1 fanout771/X VDD VSS sg13g2_buf_1
X_09856_ _14443_/D _14443_/Q _10087_/A0 _09858_/S VDD VSS sg13g2_mux2_1
Xfanout778 _11802_/B _12105_/B1 VDD VSS sg13g2_buf_1
XFILLER_100_542 VDD VSS sg13g2_decap_8
Xfanout789 _11207_/A2 _13412_/C VDD VSS sg13g2_buf_1
XFILLER_86_765 VDD VSS sg13g2_decap_8
XFILLER_111_1309 VDD VSS sg13g2_decap_8
XFILLER_115_1478 VDD VSS sg13g2_fill_1
X_08807_ _08808_/B _13687_/Q _08822_/B VDD VSS sg13g2_nor2_1
XFILLER_98_1429 VDD VSS sg13g2_decap_8
XFILLER_74_927 VDD VSS sg13g2_fill_2
XFILLER_6_1260 VDD VSS sg13g2_decap_8
XFILLER_22_1030 VDD VSS sg13g2_decap_8
X_09787_ _14376_/D _09919_/A1 _14376_/Q _09797_/S VDD VSS sg13g2_mux2_1
XFILLER_73_426 VDD VSS sg13g2_decap_8
XFILLER_65_48 VDD VSS sg13g2_decap_8
XFILLER_2_1113 VDD VSS sg13g2_decap_8
XFILLER_85_297 VDD VSS sg13g2_decap_8
XFILLER_73_437 VDD VSS sg13g2_fill_2
X_08738_ _13664_/D _08765_/A1 _08736_/Y _08737_/Y VDD VSS sg13g2_a21oi_1
XFILLER_45_139 VDD VSS sg13g2_decap_8
XFILLER_27_843 VDD VSS sg13g2_decap_8
XFILLER_73_459 VDD VSS sg13g2_decap_8
XFILLER_38_191 VDD VSS sg13g2_decap_4
XFILLER_121_21 VDD VSS sg13g2_fill_1
XFILLER_121_32 VDD VSS sg13g2_decap_8
XFILLER_57_1104 VDD VSS sg13g2_decap_4
XFILLER_27_876 VDD VSS sg13g2_decap_8
XFILLER_14_504 VDD VSS sg13g2_decap_8
X_08669_ _08669_/Y _08048_/A _12278_/A _08669_/B1 VDD VSS sg13g2_a21oi_1
XFILLER_26_364 VDD VSS sg13g2_decap_8
XFILLER_54_684 VDD VSS sg13g2_decap_8
XFILLER_57_1148 VDD VSS sg13g2_decap_8
XFILLER_54_695 VDD VSS sg13g2_fill_1
X_10700_ _14902_/D _07705_/B _10897_/A _10699_/Y VDD VSS sg13g2_o21ai_1
XFILLER_42_846 VDD VSS sg13g2_decap_8
X_11680_ _11680_/Y _11975_/A _11679_/X _12048_/A1 VDD VSS sg13g2_a21oi_1
XFILLER_41_356 VDD VSS sg13g2_decap_8
XFILLER_35_1413 VDD VSS sg13g2_decap_8
X_10631_ _10633_/B _14885_/Q _10630_/B VDD VSS sg13g2_nor2b_1
XFILLER_167_531 VDD VSS sg13g2_decap_8
XFILLER_14_63 VDD VSS sg13g2_decap_8
XFILLER_10_721 VDD VSS sg13g2_decap_8
XFILLER_70_1348 VDD VSS sg13g2_decap_8
X_13350_ _13351_/D _15181_/D _15182_/D VDD VSS sg13g2_or2_1
X_10562_ _10565_/B _14868_/Q _14867_/Q _14856_/Q _14855_/Q VDD VSS sg13g2_nand4_1
XFILLER_122_1438 VDD VSS sg13g2_decap_8
XFILLER_167_575 VDD VSS sg13g2_fill_2
XFILLER_127_417 VDD VSS sg13g2_decap_8
XFILLER_155_726 VDD VSS sg13g2_decap_8
XFILLER_6_714 VDD VSS sg13g2_decap_8
X_12301_ _12301_/Y _12299_/Y _12300_/Y _12301_/B1 VDD VSS sg13g2_a21oi_1
X_13281_ _15053_/D _13281_/A _13281_/B _13281_/C VDD VSS sg13g2_nor3_1
XFILLER_10_798 VDD VSS sg13g2_decap_8
XFILLER_155_759 VDD VSS sg13g2_decap_8
X_10493_ _14851_/D _10493_/A _10492_/Y VDD VSS sg13g2_nor2b_1
XFILLER_5_224 VDD VSS sg13g2_decap_8
XFILLER_108_642 VDD VSS sg13g2_decap_8
X_15020_ _15020_/Q _15249_/CLK _15020_/D _15020_/RESET_B VDD VSS sg13g2_dfrbpq_1
XFILLER_136_962 VDD VSS sg13g2_decap_8
XFILLER_154_258 VDD VSS sg13g2_decap_8
XFILLER_182_567 VDD VSS sg13g2_decap_8
X_12232_ _12232_/X _14136_/Q _14168_/Q _12232_/S VDD VSS sg13g2_mux2_1
XFILLER_100_0 VDD VSS sg13g2_decap_8
X_14448__1824 _14448_/RESET_B VDD VSS sg13g2_tiehi
XFILLER_107_163 VDD VSS sg13g2_decap_8
XFILLER_163_792 VDD VSS sg13g2_decap_8
X_12163_ _12163_/X _12163_/A _12190_/B VDD VSS sg13g2_and2_1
XFILLER_2_931 VDD VSS sg13g2_decap_8
XFILLER_159_1394 VDD VSS sg13g2_decap_8
XFILLER_68_1288 VDD VSS sg13g2_decap_8
XFILLER_155_1258 VDD VSS sg13g2_fill_1
XFILLER_1_441 VDD VSS sg13g2_decap_8
X_11114_ _11114_/X _11097_/Y _10764_/X _10769_/X VDD VSS sg13g2_a21o_1
XFILLER_96_518 VDD VSS sg13g2_fill_1
XFILLER_68_209 VDD VSS sg13g2_decap_8
X_12094_ _12094_/Y _12094_/A _12094_/B VDD VSS sg13g2_nand2_1
XFILLER_81_1433 VDD VSS sg13g2_decap_8
XFILLER_150_486 VDD VSS sg13g2_decap_8
XFILLER_110_328 VDD VSS sg13g2_decap_8
X_11045_ _11046_/B _11052_/B _11207_/A2 _11045_/B1 VDD VSS sg13g2_a21oi_1
XFILLER_77_743 VDD VSS sg13g2_decap_8
XFILLER_49_434 VDD VSS sg13g2_decap_8
XFILLER_42_1428 VDD VSS sg13g2_fill_1
XFILLER_7_1057 VDD VSS sg13g2_decap_8
XFILLER_77_776 VDD VSS sg13g2_decap_8
XFILLER_40_1152 VDD VSS sg13g2_decap_8
X_14804_ _14804_/Q _14864_/CLK _14804_/D _14804_/RESET_B VDD VSS sg13g2_dfrbpq_1
X_12996_ _12996_/Y _12900_/A _12997_/A input7/X VDD VSS sg13g2_a21oi_1
X_14092__2180 _14092_/RESET_B VDD VSS sg13g2_tiehi
XFILLER_166_1321 VDD VSS sg13g2_fill_1
XFILLER_55_70 VDD VSS sg13g2_fill_1
XFILLER_17_364 VDD VSS sg13g2_decap_8
X_14735_ _14735_/Q clkload13/A _14735_/D _14735_/RESET_B VDD VSS sg13g2_dfrbpq_1
X_11947_ _11947_/Y _11944_/Y _11946_/X _11999_/S1 VDD VSS sg13g2_o21ai_1
XFILLER_72_470 VDD VSS sg13g2_fill_1
XFILLER_55_92 VDD VSS sg13g2_decap_8
XFILLER_44_161 VDD VSS sg13g2_decap_8
XFILLER_32_323 VDD VSS sg13g2_decap_8
XFILLER_166_1376 VDD VSS sg13g2_decap_8
X_13936__2336 _13936_/RESET_B VDD VSS sg13g2_tiehi
X_14666_ _14666_/Q clkload16/A _14666_/D _14666_/RESET_B VDD VSS sg13g2_dfrbpq_1
XFILLER_127_1338 VDD VSS sg13g2_fill_1
X_14696__1576 _14696_/RESET_B VDD VSS sg13g2_tiehi
X_11878_ _11878_/Y _11880_/A1 _14606_/Q _11897_/C VDD VSS sg13g2_a21oi_1
X_13617_ _13725_/D _13617_/A VDD VSS sg13g2_buf_1
X_10829_ _10831_/C _10818_/A _10818_/B _10823_/C VDD VSS sg13g2_o21ai_1
X_14597_ _14597_/Q _14725_/CLK _14597_/D _14597_/RESET_B VDD VSS sg13g2_dfrbpq_1
XFILLER_125_1040 VDD VSS sg13g2_fill_1
XFILLER_186_840 VDD VSS sg13g2_decap_8
XFILLER_13_581 VDD VSS sg13g2_decap_8
XFILLER_186_851 VDD VSS sg13g2_decap_8
XFILLER_119_918 VDD VSS sg13g2_decap_8
X_13548_ _15147_/D _13547_/B _13546_/Y _13547_/Y VDD VSS sg13g2_a21oi_1
XFILLER_119_929 VDD VSS sg13g2_fill_1
XFILLER_185_350 VDD VSS sg13g2_decap_8
XFILLER_9_574 VDD VSS sg13g2_decap_8
XFILLER_12_1232 VDD VSS sg13g2_decap_8
XFILLER_146_759 VDD VSS sg13g2_decap_4
X_13479_ _15180_/D hold3144/X _15180_/Q _13479_/S VDD VSS sg13g2_mux2_1
XFILLER_51_1281 VDD VSS sg13g2_fill_2
XFILLER_127_940 VDD VSS sg13g2_decap_4
XFILLER_69_1019 VDD VSS sg13g2_decap_8
X_15218_ _15218_/Q _15224_/CLK _15218_/D _15218_/RESET_B VDD VSS sg13g2_dfrbpq_1
XFILLER_161_718 VDD VSS sg13g2_decap_8
XFILLER_114_601 VDD VSS sg13g2_decap_8
XFILLER_142_910 VDD VSS sg13g2_decap_8
XFILLER_160_217 VDD VSS sg13g2_decap_8
XFILLER_99_312 VDD VSS sg13g2_decap_8
XFILLER_154_792 VDD VSS sg13g2_decap_8
XFILLER_86_1355 VDD VSS sg13g2_fill_2
XFILLER_114_634 VDD VSS sg13g2_decap_8
XFILLER_142_943 VDD VSS sg13g2_decap_4
XFILLER_173_1314 VDD VSS sg13g2_decap_8
X_15149_ _15149_/Q clkload78/A _15149_/D _15149_/RESET_B VDD VSS sg13g2_dfrbpq_1
XFILLER_138_1445 VDD VSS sg13g2_decap_8
XFILLER_5_791 VDD VSS sg13g2_decap_8
XFILLER_141_431 VDD VSS sg13g2_decap_8
XFILLER_114_656 VDD VSS sg13g2_fill_1
XFILLER_142_965 VDD VSS sg13g2_decap_8
XFILLER_87_507 VDD VSS sg13g2_decap_8
X_07971_ _07971_/Y _15018_/Q _08653_/B VDD VSS sg13g2_nand2b_1
XFILLER_101_317 VDD VSS sg13g2_decap_8
XFILLER_45_1041 VDD VSS sg13g2_decap_8
X_09710_ _14301_/D _09908_/A1 _14301_/Q _09727_/S VDD VSS sg13g2_mux2_1
XFILLER_136_1180 VDD VSS sg13g2_decap_8
XFILLER_110_851 VDD VSS sg13g2_decap_8
XFILLER_171_1093 VDD VSS sg13g2_decap_8
X_09641_ _09661_/S _15064_/Q _09740_/B _09707_/B _09641_/D VDD VSS sg13g2_or4_1
X_14785__3021 _14785_/RESET_B VDD VSS sg13g2_tiehi
XFILLER_3_1400 VDD VSS sg13g2_decap_8
XFILLER_132_1077 VDD VSS sg13g2_decap_8
Xclkbuf_leaf_5_clk_i clkload8/A clkbuf_leaf_5_clk_i/A VDD VSS sg13g2_buf_8
XFILLER_55_426 VDD VSS sg13g2_decap_8
XFILLER_82_223 VDD VSS sg13g2_decap_8
XFILLER_27_128 VDD VSS sg13g2_decap_8
XFILLER_23_1372 VDD VSS sg13g2_decap_8
X_09572_ _14170_/D _09638_/A0 _14170_/Q _09572_/S VDD VSS sg13g2_mux2_1
XFILLER_97_1440 VDD VSS sg13g2_decap_8
XFILLER_58_1402 VDD VSS sg13g2_decap_8
X_08523_ _08523_/Y _07956_/A _08591_/A3 _08674_/B1 VDD VSS sg13g2_o21ai_1
XFILLER_82_278 VDD VSS sg13g2_decap_8
XFILLER_184_1454 VDD VSS sg13g2_decap_8
XFILLER_145_1427 VDD VSS sg13g2_fill_2
XFILLER_1_1190 VDD VSS sg13g2_decap_8
X_08454_ _08454_/X _15103_/Q _15090_/Q _08454_/C VDD VSS sg13g2_or3_1
XFILLER_23_334 VDD VSS sg13g2_decap_8
XFILLER_169_829 VDD VSS sg13g2_decap_8
X_14526__1746 _14526_/RESET_B VDD VSS sg13g2_tiehi
XFILLER_24_879 VDD VSS sg13g2_fill_2
XFILLER_17_1110 VDD VSS sg13g2_decap_8
XFILLER_11_518 VDD VSS sg13g2_decap_8
X_08385_ _08385_/Y _15103_/Q _15090_/Q _08385_/C VDD VSS sg13g2_nor3_1
XFILLER_52_1012 VDD VSS sg13g2_decap_8
XFILLER_50_164 VDD VSS sg13g2_decap_8
XFILLER_149_531 VDD VSS sg13g2_decap_8
XFILLER_177_851 VDD VSS sg13g2_decap_8
XFILLER_104_1113 VDD VSS sg13g2_fill_1
XFILLER_109_406 VDD VSS sg13g2_decap_8
XFILLER_167_28 VDD VSS sg13g2_decap_8
XFILLER_176_350 VDD VSS sg13g2_decap_8
XFILLER_52_1056 VDD VSS sg13g2_decap_8
XFILLER_17_1187 VDD VSS sg13g2_decap_8
X_13790__2482 _13790_/RESET_B VDD VSS sg13g2_tiehi
XFILLER_109_417 VDD VSS sg13g2_fill_2
XFILLER_13_1029 VDD VSS sg13g2_decap_8
XFILLER_149_586 VDD VSS sg13g2_decap_8
XFILLER_104_1146 VDD VSS sg13g2_decap_8
X_14816__2990 _14816_/RESET_B VDD VSS sg13g2_tiehi
XFILLER_136_225 VDD VSS sg13g2_decap_8
X_14741__1531 _14741_/RESET_B VDD VSS sg13g2_tiehi
X_09006_ _09006_/Y _09006_/A _09006_/B _09022_/D VDD VSS sg13g2_nor3_1
XFILLER_139_1209 VDD VSS sg13g2_decap_8
XFILLER_117_450 VDD VSS sg13g2_fill_1
X_15135__2780 _15135_/RESET_B VDD VSS sg13g2_tiehi
XFILLER_133_910 VDD VSS sg13g2_decap_8
XFILLER_145_781 VDD VSS sg13g2_decap_4
XFILLER_3_728 VDD VSS sg13g2_decap_8
XFILLER_133_954 VDD VSS sg13g2_decap_8
XFILLER_4_7 VDD VSS sg13g2_decap_8
XFILLER_2_238 VDD VSS sg13g2_decap_8
XFILLER_183_49 VDD VSS sg13g2_decap_8
XFILLER_65_1439 VDD VSS sg13g2_fill_1
XFILLER_133_987 VDD VSS sg13g2_decap_8
Xfanout1507 fanout1507/X input38/X VDD VSS sg13g2_buf_1
XFILLER_160_795 VDD VSS sg13g2_decap_8
Xfanout531 _09976_/A0 _10075_/A0 VDD VSS sg13g2_buf_1
XFILLER_99_890 VDD VSS sg13g2_decap_4
XFILLER_76_14 VDD VSS sg13g2_decap_8
XFILLER_116_76 VDD VSS sg13g2_decap_8
Xfanout542 _08667_/A1 _08395_/A VDD VSS sg13g2_buf_1
XFILLER_150_1111 VDD VSS sg13g2_decap_8
X_09908_ _14493_/D _14493_/Q _09908_/A1 _09937_/S VDD VSS sg13g2_mux2_1
XFILLER_8_1344 VDD VSS sg13g2_decap_8
X_13674__2617 _13674_/RESET_B VDD VSS sg13g2_tiehi
Xfanout553 _13501_/A _13647_/S VDD VSS sg13g2_buf_1
XFILLER_115_1242 VDD VSS sg13g2_decap_8
Xfanout564 _13593_/B fanout565/X VDD VSS sg13g2_buf_1
XFILLER_59_754 VDD VSS sg13g2_decap_8
XFILLER_58_231 VDD VSS sg13g2_decap_8
Xfanout575 _12292_/A _12266_/B1 VDD VSS sg13g2_buf_1
Xfanout586 _10072_/A0 _10105_/A VDD VSS sg13g2_buf_1
Xfanout597 _09166_/A1 _08999_/B1 VDD VSS sg13g2_buf_1
X_09839_ wire363/A _09905_/A _09872_/B _09938_/C _09839_/D VDD VSS sg13g2_nor4_1
XFILLER_59_787 VDD VSS sg13g2_decap_8
XFILLER_24_1169 VDD VSS sg13g2_decap_8
XFILLER_100_361 VDD VSS sg13g2_decap_8
XFILLER_150_1188 VDD VSS sg13g2_fill_2
XFILLER_73_223 VDD VSS sg13g2_decap_8
XFILLER_132_42 VDD VSS sg13g2_decap_8
X_12850_ _12850_/X _12846_/Y _12848_/X _12849_/Y VDD VSS sg13g2_a21o_1
XFILLER_62_919 VDD VSS sg13g2_decap_4
XFILLER_15_802 VDD VSS sg13g2_fill_2
X_11801_ _11801_/X _14124_/Q _14156_/Q _11804_/A VDD VSS sg13g2_mux2_1
XFILLER_92_35 VDD VSS sg13g2_decap_8
XFILLER_73_278 VDD VSS sg13g2_decap_4
XFILLER_132_97 VDD VSS sg13g2_decap_8
X_12781_ _12781_/X _13978_/Q _14010_/Q _14042_/Q _14074_/Q _12783_/S0 _12783_/S1 VDD
+ VSS sg13g2_mux4_1
XFILLER_14_301 VDD VSS sg13g2_decap_8
XFILLER_148_1040 VDD VSS sg13g2_decap_8
XFILLER_15_835 VDD VSS sg13g2_decap_8
XFILLER_27_695 VDD VSS sg13g2_decap_8
XFILLER_148_1051 VDD VSS sg13g2_fill_1
X_14520_ _14520_/Q clkload25/A _14520_/D _14520_/RESET_B VDD VSS sg13g2_dfrbpq_1
XFILLER_54_481 VDD VSS sg13g2_decap_4
XFILLER_26_172 VDD VSS sg13g2_decap_8
X_11732_ _11732_/Y _11759_/A _14186_/Q VDD VSS sg13g2_nand2b_1
XFILLER_26_183 VDD VSS sg13g2_fill_1
XFILLER_41_142 VDD VSS sg13g2_decap_8
XFILLER_109_1057 VDD VSS sg13g2_decap_8
XFILLER_148_0 VDD VSS sg13g2_decap_8
X_14451_ _14451_/Q clkload32/A _14451_/D _14451_/RESET_B VDD VSS sg13g2_dfrbpq_1
XFILLER_14_378 VDD VSS sg13g2_decap_8
X_11663_ _11663_/Y _11663_/A _11663_/B _11773_/B VDD VSS sg13g2_nand3_1
XFILLER_42_687 VDD VSS sg13g2_decap_8
XFILLER_35_1232 VDD VSS sg13g2_fill_2
X_13402_ _15088_/D _13396_/D _13433_/A _13400_/Y VDD VSS sg13g2_o21ai_1
X_10614_ _10622_/C _10614_/A _10614_/B VDD VSS sg13g2_nor2_1
X_14382_ _14382_/Q _14734_/CLK _14382_/D _14382_/RESET_B VDD VSS sg13g2_dfrbpq_1
XFILLER_167_361 VDD VSS sg13g2_decap_8
X_11594_ _11594_/X _14118_/Q _14150_/Q _11597_/A VDD VSS sg13g2_mux2_1
X_14380__1892 _14380_/RESET_B VDD VSS sg13g2_tiehi
XFILLER_155_523 VDD VSS sg13g2_decap_8
X_13333_ _15171_/D hold3131/X _15171_/Q _13333_/S VDD VSS sg13g2_mux2_1
XFILLER_6_511 VDD VSS sg13g2_decap_8
XFILLER_167_394 VDD VSS sg13g2_decap_8
X_10545_ _10548_/C _14864_/Q _10544_/B VDD VSS sg13g2_nor2b_1
XFILLER_122_1279 VDD VSS sg13g2_fill_1
XFILLER_10_595 VDD VSS sg13g2_decap_8
XFILLER_183_876 VDD VSS sg13g2_decap_8
XFILLER_115_409 VDD VSS sg13g2_decap_8
XFILLER_143_718 VDD VSS sg13g2_decap_8
XFILLER_182_364 VDD VSS sg13g2_decap_8
X_13264_ _13264_/X input27/X _13272_/A2 _13264_/B1 VDD VSS sg13g2_a21o_1
X_10476_ _10478_/B _10486_/D _10492_/C _14847_/Q VDD VSS sg13g2_a21oi_1
XFILLER_68_1030 VDD VSS sg13g2_decap_8
X_15003_ _15003_/Q _15019_/CLK _15003_/D _15003_/RESET_B VDD VSS sg13g2_dfrbpq_1
XFILLER_6_588 VDD VSS sg13g2_decap_8
XFILLER_142_228 VDD VSS sg13g2_decap_8
X_12215_ _12215_/X _13975_/Q _14007_/Q _14039_/Q _14071_/Q _12215_/S0 _12215_/S1 VDD
+ VSS sg13g2_mux4_1
X_13195_ _13196_/C _14824_/Q _13206_/B _07727_/C _14888_/Q VDD VSS sg13g2_a22oi_1
X_14000__2272 _14000_/RESET_B VDD VSS sg13g2_tiehi
XFILLER_97_805 VDD VSS sg13g2_decap_8
XFILLER_155_1044 VDD VSS sg13g2_decap_8
X_12146_ _12146_/Y _13200_/A _12294_/A2 _12156_/A VDD VSS sg13g2_a21oi_1
XFILLER_111_626 VDD VSS sg13g2_decap_8
XFILLER_96_315 VDD VSS sg13g2_fill_1
XFILLER_37_7 VDD VSS sg13g2_decap_8
XFILLER_97_849 VDD VSS sg13g2_fill_1
XFILLER_81_1230 VDD VSS sg13g2_fill_1
XFILLER_123_497 VDD VSS sg13g2_decap_8
XFILLER_172_1380 VDD VSS sg13g2_decap_4
X_12077_ _12077_/Y _12292_/A _12077_/B VDD VSS sg13g2_nor2_1
XFILLER_46_1383 VDD VSS sg13g2_decap_8
X_14604__1668 _14604_/RESET_B VDD VSS sg13g2_tiehi
X_15049__2620 _15049_/RESET_B VDD VSS sg13g2_tiehi
XFILLER_42_1225 VDD VSS sg13g2_fill_1
X_11028_ _11029_/B _11052_/A _11052_/D _11027_/Y VDD VSS sg13g2_o21ai_1
XFILLER_133_1386 VDD VSS sg13g2_decap_8
XFILLER_2_77 VDD VSS sg13g2_decap_8
XFILLER_64_245 VDD VSS sg13g2_decap_8
XFILLER_53_908 VDD VSS sg13g2_decap_8
XFILLER_80_705 VDD VSS sg13g2_fill_1
X_12979_ _12979_/Y _12976_/Y _12977_/Y _12978_/Y VDD VSS sg13g2_a21oi_1
XFILLER_80_738 VDD VSS sg13g2_fill_1
XFILLER_79_1181 VDD VSS sg13g2_decap_8
XFILLER_46_993 VDD VSS sg13g2_fill_1
XFILLER_17_161 VDD VSS sg13g2_decap_8
X_14718_ _14718_/Q clkload50/A _14718_/D _14718_/RESET_B VDD VSS sg13g2_dfrbpq_1
XFILLER_75_1045 VDD VSS sg13g2_decap_8
XFILLER_178_637 VDD VSS sg13g2_decap_8
XFILLER_166_1195 VDD VSS sg13g2_fill_2
XFILLER_18_1430 VDD VSS sg13g2_decap_8
XFILLER_127_1168 VDD VSS sg13g2_decap_8
XFILLER_159_840 VDD VSS sg13g2_decap_8
XFILLER_20_315 VDD VSS sg13g2_decap_8
X_14649_ _14649_/Q clkload37/A _14649_/D _14649_/RESET_B VDD VSS sg13g2_dfrbpq_1
XANTENNA_16 _16861_/A VDD VSS sg13g2_antennanp
XFILLER_177_147 VDD VSS sg13g2_decap_8
XFILLER_60_495 VDD VSS sg13g2_decap_8
XANTENNA_27 output68/A VDD VSS sg13g2_antennanp
XFILLER_53_1354 VDD VSS sg13g2_decap_8
X_08170_ _08170_/X _08044_/X _08052_/Y _08167_/B _08397_/B _08560_/A _08338_/B VDD
+ VSS sg13g2_mux4_1
XFILLER_14_1316 VDD VSS sg13g2_decap_8
XFILLER_118_203 VDD VSS sg13g2_decap_8
XFILLER_119_737 VDD VSS sg13g2_decap_4
XFILLER_158_394 VDD VSS sg13g2_fill_1
XFILLER_9_371 VDD VSS sg13g2_decap_8
XFILLER_119_759 VDD VSS sg13g2_decap_8
XFILLER_101_1319 VDD VSS sg13g2_decap_4
XFILLER_173_331 VDD VSS sg13g2_decap_8
XFILLER_118_258 VDD VSS sg13g2_fill_2
XFILLER_63_0 VDD VSS sg13g2_decap_8
XFILLER_161_515 VDD VSS sg13g2_decap_8
XFILLER_127_770 VDD VSS sg13g2_decap_8
Xoutput101 mem_axi_awvalid _07766_/Y VDD VSS sg13g2_buf_1
XFILLER_127_792 VDD VSS sg13g2_fill_1
Xoutput112 mem_axi_wdata[17] _15149_/Q VDD VSS sg13g2_buf_1
Xoutput123 mem_axi_wdata[27] _15159_/Q VDD VSS sg13g2_buf_1
XFILLER_86_1152 VDD VSS sg13g2_decap_8
XFILLER_114_420 VDD VSS sg13g2_fill_1
Xoutput134 mem_axi_wdata[8] _15140_/Q VDD VSS sg13g2_buf_1
XFILLER_99_131 VDD VSS sg13g2_decap_8
XFILLER_88_805 VDD VSS sg13g2_fill_1
XFILLER_115_998 VDD VSS sg13g2_decap_8
XFILLER_138_1275 VDD VSS sg13g2_fill_1
XFILLER_82_1038 VDD VSS sg13g2_decap_8
XFILLER_101_125 VDD VSS sg13g2_decap_8
X_07954_ _07954_/Y _08553_/A _07954_/B _07954_/C VDD VSS sg13g2_nor3_1
XFILLER_64_1472 VDD VSS sg13g2_decap_8
XFILLER_60_1303 VDD VSS sg13g2_decap_8
XFILLER_25_1434 VDD VSS sg13g2_decap_8
XFILLER_110_670 VDD VSS sg13g2_fill_2
X_07885_ _07926_/A _13545_/A _08219_/A VDD VSS sg13g2_nor2b_1
XFILLER_112_1437 VDD VSS sg13g2_decap_8
XFILLER_110_692 VDD VSS sg13g2_decap_8
X_09624_ _14220_/D _09956_/A1 _14220_/Q _09638_/S VDD VSS sg13g2_mux2_1
XFILLER_83_532 VDD VSS sg13g2_decap_4
XFILLER_28_437 VDD VSS sg13g2_fill_1
XFILLER_71_716 VDD VSS sg13g2_fill_2
X_09555_ _14153_/D _10085_/A0 _14153_/Q _09571_/S VDD VSS sg13g2_mux2_1
XFILLER_3_1274 VDD VSS sg13g2_decap_8
XFILLER_97_1270 VDD VSS sg13g2_fill_1
XFILLER_36_470 VDD VSS sg13g2_fill_2
X_08506_ _08506_/Y _08502_/Y _08503_/Y _08505_/Y VDD VSS sg13g2_o21ai_1
XFILLER_145_1213 VDD VSS sg13g2_decap_8
XFILLER_169_615 VDD VSS sg13g2_fill_1
X_09486_ _14086_/D _10082_/A0 _14086_/Q _09493_/S VDD VSS sg13g2_mux2_1
XFILLER_93_1145 VDD VSS sg13g2_fill_1
XFILLER_184_1273 VDD VSS sg13g2_fill_1
XFILLER_12_805 VDD VSS sg13g2_decap_8
XFILLER_19_1238 VDD VSS sg13g2_decap_8
XFILLER_54_1129 VDD VSS sg13g2_decap_8
X_08437_ _08437_/Y _15005_/Q _07946_/B _08552_/A1 VDD VSS sg13g2_a21oi_1
X_14188__2084 _14188_/RESET_B VDD VSS sg13g2_tiehi
XFILLER_106_1219 VDD VSS sg13g2_decap_4
XFILLER_11_315 VDD VSS sg13g2_decap_8
XFILLER_51_484 VDD VSS sg13g2_fill_1
XFILLER_23_175 VDD VSS sg13g2_decap_4
XFILLER_168_147 VDD VSS sg13g2_decap_8
XFILLER_178_49 VDD VSS sg13g2_decap_8
XFILLER_180_1159 VDD VSS sg13g2_decap_8
XFILLER_71_1432 VDD VSS sg13g2_decap_8
X_08368_ _08369_/A _07797_/C _08350_/B _07935_/Y VDD VSS sg13g2_o21ai_1
XFILLER_7_308 VDD VSS sg13g2_decap_8
XFILLER_178_1000 VDD VSS sg13g2_decap_8
XFILLER_178_1011 VDD VSS sg13g2_fill_2
X_08299_ _08312_/D _08318_/C _08297_/Y _08298_/Y VDD VSS sg13g2_a21oi_1
XFILLER_109_258 VDD VSS sg13g2_decap_8
X_10330_ _10331_/B _14798_/Q _14803_/Q _10342_/C _10345_/C VDD VSS sg13g2_nand4_1
XFILLER_125_729 VDD VSS sg13g2_decap_8
XFILLER_118_770 VDD VSS sg13g2_decap_8
XFILLER_11_42 VDD VSS sg13g2_decap_8
XFILLER_164_375 VDD VSS sg13g2_decap_8
XFILLER_180_824 VDD VSS sg13g2_decap_8
XFILLER_178_1088 VDD VSS sg13g2_decap_8
XFILLER_3_525 VDD VSS sg13g2_decap_8
XFILLER_30_1184 VDD VSS sg13g2_decap_8
XFILLER_127_42 VDD VSS sg13g2_decap_8
X_10261_ _10261_/Y _14782_/Q _10268_/D _10423_/C VDD VSS sg13g2_o21ai_1
Xclkbuf_leaf_106_clk_i clkload48/A clkbuf_5_16__f_clk_i/X VDD VSS sg13g2_buf_8
XFILLER_65_1214 VDD VSS sg13g2_fill_1
XFILLER_106_965 VDD VSS sg13g2_decap_8
X_12000_ _12001_/B _12000_/A _12000_/B VDD VSS sg13g2_nor2_1
XFILLER_117_1304 VDD VSS sg13g2_decap_8
XFILLER_79_816 VDD VSS sg13g2_decap_4
XFILLER_156_1364 VDD VSS sg13g2_decap_8
X_10192_ _14753_/D _15196_/D _14753_/Q _13501_/A VDD VSS sg13g2_mux2_1
XFILLER_117_1337 VDD VSS sg13g2_decap_8
XFILLER_79_849 VDD VSS sg13g2_decap_8
Xfanout1304 _13064_/B _13677_/Q VDD VSS sg13g2_buf_1
XFILLER_152_1228 VDD VSS sg13g2_fill_1
Xfanout1315 _11559_/C _12191_/B1 VDD VSS sg13g2_buf_1
Xfanout1326 _12291_/A _12265_/A2 VDD VSS sg13g2_buf_1
XFILLER_87_79 VDD VSS sg13g2_decap_8
X_14995__2685 _14995_/RESET_B VDD VSS sg13g2_tiehi
Xfanout1337 _11997_/S1 _11850_/S1 VDD VSS sg13g2_buf_1
XFILLER_8_1141 VDD VSS sg13g2_decap_8
Xfanout350 _09936_/S _09921_/S VDD VSS sg13g2_buf_1
Xfanout1348 _12236_/C _11760_/C VDD VSS sg13g2_buf_1
Xfanout1359 _12307_/C _12091_/C VDD VSS sg13g2_buf_1
XFILLER_47_702 VDD VSS sg13g2_decap_4
XFILLER_120_478 VDD VSS sg13g2_decap_8
Xfanout372 _09737_/S _09733_/S VDD VSS sg13g2_buf_1
X_13951_ _13951_/Q clkload21/A _13951_/D _13951_/RESET_B VDD VSS sg13g2_dfrbpq_1
Xfanout383 _09633_/S _09637_/S VDD VSS sg13g2_buf_1
XFILLER_143_74 VDD VSS sg13g2_decap_8
Xfanout394 _09338_/S _09333_/S VDD VSS sg13g2_buf_1
XFILLER_86_370 VDD VSS sg13g2_decap_8
XFILLER_98_1023 VDD VSS sg13g2_decap_8
XFILLER_74_521 VDD VSS sg13g2_decap_8
XFILLER_115_1094 VDD VSS sg13g2_decap_8
X_12902_ _12902_/Y _12902_/A _12902_/B _12902_/C VDD VSS sg13g2_nand3_1
XFILLER_19_459 VDD VSS sg13g2_decap_8
X_13882_ _13882_/Q clkload51/A _13882_/D _13882_/RESET_B VDD VSS sg13g2_dfrbpq_1
XFILLER_46_234 VDD VSS sg13g2_decap_8
XFILLER_185_1004 VDD VSS sg13g2_fill_2
X_14398__1874 _14398_/RESET_B VDD VSS sg13g2_tiehi
X_12833_ _12833_/Y _12835_/A _13691_/Q VDD VSS sg13g2_nand2_1
XFILLER_34_418 VDD VSS sg13g2_decap_8
XFILLER_98_1089 VDD VSS sg13g2_decap_8
XFILLER_76_1321 VDD VSS sg13g2_fill_2
XFILLER_27_470 VDD VSS sg13g2_decap_8
XFILLER_37_1305 VDD VSS sg13g2_fill_1
XFILLER_36_94 VDD VSS sg13g2_fill_2
X_12764_ _15018_/D _12764_/A _12764_/B VDD VSS sg13g2_nor2_1
XFILLER_128_1433 VDD VSS sg13g2_fill_1
XFILLER_15_665 VDD VSS sg13g2_decap_8
X_14503_ _14503_/Q _14503_/CLK _14503_/D _14503_/RESET_B VDD VSS sg13g2_dfrbpq_1
X_11715_ _11715_/X _14249_/Q _14281_/Q _14313_/Q _14345_/Q _12284_/S0 _12284_/S1 VDD
+ VSS sg13g2_mux4_1
XFILLER_124_1308 VDD VSS sg13g2_decap_8
XFILLER_43_996 VDD VSS sg13g2_fill_2
XFILLER_42_473 VDD VSS sg13g2_decap_8
XFILLER_128_1477 VDD VSS sg13g2_fill_2
XFILLER_14_175 VDD VSS sg13g2_decap_8
X_12695_ _12708_/A _12956_/B _12765_/A2 _15014_/Q VDD VSS sg13g2_a21oi_1
X_14018__2254 _14018_/RESET_B VDD VSS sg13g2_tiehi
XFILLER_175_618 VDD VSS sg13g2_decap_8
X_14434_ _14434_/Q _14656_/CLK _14434_/D _14434_/RESET_B VDD VSS sg13g2_dfrbpq_1
X_11646_ _11646_/X _14567_/Q _14599_/Q _14631_/Q _14663_/Q _11528_/S _11532_/C VDD
+ VSS sg13g2_mux4_1
XFILLER_52_71 VDD VSS sg13g2_fill_1
XFILLER_156_810 VDD VSS sg13g2_decap_8
XFILLER_161_1081 VDD VSS sg13g2_fill_2
Xinput14 input14/X input14/A VDD VSS sg13g2_buf_1
XFILLER_11_882 VDD VSS sg13g2_decap_8
XFILLER_128_534 VDD VSS sg13g2_decap_8
XFILLER_161_1092 VDD VSS sg13g2_fill_2
X_14365_ _14365_/Q _14886_/CLK _14365_/D _14365_/RESET_B VDD VSS sg13g2_dfrbpq_1
Xinput25 input25/X input25/A VDD VSS sg13g2_buf_1
Xinput36 input36/X input36/A VDD VSS sg13g2_buf_1
X_11577_ _11577_/X _14117_/Q _14149_/Q _14181_/Q _14213_/Q _11996_/S0 _11996_/S1 VDD
+ VSS sg13g2_mux4_1
XFILLER_116_707 VDD VSS sg13g2_decap_8
XFILLER_10_392 VDD VSS sg13g2_decap_8
X_13316_ _13316_/X _15062_/Q _13316_/B _13316_/C VDD VSS sg13g2_and3_1
Xmax_cap506 _09462_/S _09471_/S VDD VSS sg13g2_buf_8
XFILLER_143_504 VDD VSS sg13g2_decap_8
X_10528_ _10529_/B _10558_/B _10558_/C _10531_/D VDD VSS sg13g2_nand3_1
XFILLER_7_875 VDD VSS sg13g2_decap_8
XFILLER_156_898 VDD VSS sg13g2_decap_8
XFILLER_183_684 VDD VSS sg13g2_decap_8
X_14296_ _14296_/Q _14664_/CLK _14296_/D _14296_/RESET_B VDD VSS sg13g2_dfrbpq_1
XFILLER_115_217 VDD VSS sg13g2_decap_8
XFILLER_182_161 VDD VSS sg13g2_decap_8
XFILLER_183_695 VDD VSS sg13g2_fill_2
XFILLER_13_1393 VDD VSS sg13g2_decap_8
XFILLER_155_397 VDD VSS sg13g2_decap_8
XFILLER_6_385 VDD VSS sg13g2_decap_8
X_13247_ _13247_/Y _13247_/A _13247_/B _13247_/C _13271_/C VDD VSS sg13g2_nand4_1
X_13886__2386 _13886_/RESET_B VDD VSS sg13g2_tiehi
XFILLER_124_740 VDD VSS sg13g2_fill_2
XFILLER_170_345 VDD VSS sg13g2_fill_1
XFILLER_171_868 VDD VSS sg13g2_fill_2
X_10459_ _10459_/Y _10538_/A _10459_/B _10459_/C _10512_/A VDD VSS sg13g2_nor4_1
XFILLER_83_1314 VDD VSS sg13g2_fill_1
XFILLER_184_70 VDD VSS sg13g2_decap_8
XFILLER_112_902 VDD VSS sg13g2_fill_2
XFILLER_97_602 VDD VSS sg13g2_decap_8
X_13178_ _13178_/X input20/X _13272_/A2 _13264_/B1 VDD VSS sg13g2_a21o_1
XFILLER_83_1358 VDD VSS sg13g2_decap_8
XFILLER_111_412 VDD VSS sg13g2_decap_8
XFILLER_111_434 VDD VSS sg13g2_decap_8
X_12129_ _12198_/C _12061_/A _13190_/B _13668_/Q _12084_/A VDD VSS sg13g2_a22oi_1
Xclkbuf_leaf_70_clk_i clkload80/A clkbuf_leaf_78_clk_i/A VDD VSS sg13g2_buf_8
XFILLER_96_156 VDD VSS sg13g2_decap_8
XFILLER_46_1180 VDD VSS sg13g2_decap_8
XFILLER_111_467 VDD VSS sg13g2_decap_4
XFILLER_38_702 VDD VSS sg13g2_decap_8
XFILLER_133_1183 VDD VSS sg13g2_decap_8
X_15091__2894 _15091_/RESET_B VDD VSS sg13g2_tiehi
X_07670_ _07670_/Y _13283_/A _13613_/B _13613_/C VDD VSS sg13g2_nand3_1
XFILLER_93_852 VDD VSS sg13g2_fill_2
X_16868_ _16868_/X _16868_/A VDD VSS sg13g2_buf_1
XFILLER_92_340 VDD VSS sg13g2_decap_8
Xclkbuf_leaf_85_clk_i clkload64/A clkbuf_leaf_94_clk_i/A VDD VSS sg13g2_buf_8
XFILLER_92_373 VDD VSS sg13g2_decap_4
XFILLER_53_727 VDD VSS sg13g2_decap_8
XFILLER_52_204 VDD VSS sg13g2_fill_2
XFILLER_37_278 VDD VSS sg13g2_decap_8
XFILLER_20_1364 VDD VSS sg13g2_decap_8
XFILLER_0_1436 VDD VSS sg13g2_decap_8
X_09340_ _09606_/C _10105_/C _09905_/A VDD VSS sg13g2_nor2b_1
XFILLER_55_1405 VDD VSS sg13g2_decap_8
XFILLER_179_924 VDD VSS sg13g2_decap_8
XFILLER_181_1413 VDD VSS sg13g2_decap_4
XFILLER_52_259 VDD VSS sg13g2_decap_8
XFILLER_34_974 VDD VSS sg13g2_decap_8
XFILLER_90_1318 VDD VSS sg13g2_decap_4
XFILLER_61_771 VDD VSS sg13g2_decap_8
XFILLER_178_434 VDD VSS sg13g2_decap_8
X_09271_ _13880_/D _13880_/Q _10067_/A0 _09271_/S VDD VSS sg13g2_mux2_1
X_15238__3099 _15238_/RESET_B VDD VSS sg13g2_tiehi
XFILLER_20_112 VDD VSS sg13g2_decap_8
XFILLER_33_495 VDD VSS sg13g2_fill_1
X_08222_ _08233_/C _08142_/A _08247_/B _08217_/X _08110_/D _08221_/Y VDD VSS sg13g2_a221oi_1
XFILLER_166_629 VDD VSS sg13g2_decap_8
XFILLER_14_1113 VDD VSS sg13g2_decap_8
XFILLER_159_670 VDD VSS sg13g2_decap_8
XFILLER_165_117 VDD VSS sg13g2_decap_8
XFILLER_53_1173 VDD VSS sg13g2_decap_8
XFILLER_146_320 VDD VSS sg13g2_decap_8
XFILLER_147_843 VDD VSS sg13g2_decap_8
X_08153_ _08484_/C _08234_/A _08151_/X _08152_/Y VDD VSS sg13g2_o21ai_1
XFILLER_105_1263 VDD VSS sg13g2_decap_8
XFILLER_20_189 VDD VSS sg13g2_decap_8
XFILLER_101_1105 VDD VSS sg13g2_decap_8
XFILLER_101_1116 VDD VSS sg13g2_fill_2
Xclkbuf_leaf_23_clk_i clkload31/A clkload2/A VDD VSS sg13g2_buf_8
XFILLER_107_729 VDD VSS sg13g2_decap_8
X_08084_ _08085_/A _08591_/A3 _08541_/B _07861_/B _08620_/A2 _08598_/S0 _08598_/S1
+ VDD VSS sg13g2_mux4_1
XFILLER_88_1247 VDD VSS sg13g2_decap_8
XFILLER_173_161 VDD VSS sg13g2_decap_8
XFILLER_175_1217 VDD VSS sg13g2_decap_8
XFILLER_134_537 VDD VSS sg13g2_decap_8
XFILLER_179_1386 VDD VSS sg13g2_decap_8
XFILLER_162_868 VDD VSS sg13g2_decap_8
X_13716__2556 _13716_/RESET_B VDD VSS sg13g2_tiehi
X_14476__1796 _14476_/RESET_B VDD VSS sg13g2_tiehi
XFILLER_130_710 VDD VSS sg13g2_decap_8
XFILLER_0_539 VDD VSS sg13g2_decap_8
Xclkbuf_leaf_38_clk_i clkload37/A clkbuf_leaf_39_clk_i/A VDD VSS sg13g2_buf_8
X_08986_ _08988_/B _10681_/A _10674_/A _12859_/A VDD VSS sg13g2_a21oi_1
XFILLER_25_1231 VDD VSS sg13g2_decap_8
XFILLER_69_871 VDD VSS sg13g2_decap_4
XFILLER_180_28 VDD VSS sg13g2_decap_8
X_07937_ _07937_/Y _08414_/C _07936_/Y _07793_/Y VDD VSS sg13g2_a21oi_1
XFILLER_75_329 VDD VSS sg13g2_decap_4
XFILLER_60_1144 VDD VSS sg13g2_decap_8
X_13931__2341 _13931_/RESET_B VDD VSS sg13g2_tiehi
XFILLER_112_1223 VDD VSS sg13g2_fill_1
X_14691__1581 _14691_/RESET_B VDD VSS sg13g2_tiehi
XFILLER_84_830 VDD VSS sg13g2_decap_4
XFILLER_5_1358 VDD VSS sg13g2_decap_8
XFILLER_28_223 VDD VSS sg13g2_fill_1
X_07868_ _08183_/B _07912_/B _13533_/A VDD VSS sg13g2_nor2_1
XFILLER_83_351 VDD VSS sg13g2_decap_8
XFILLER_99_1387 VDD VSS sg13g2_decap_8
X_09607_ _14203_/D _10138_/A1 _14203_/Q _09638_/S VDD VSS sg13g2_mux2_1
XFILLER_3_1071 VDD VSS sg13g2_decap_8
X_07799_ _07799_/X _15006_/Q _07945_/B VDD VSS sg13g2_and2_1
XFILLER_71_535 VDD VSS sg13g2_decap_8
XFILLER_37_790 VDD VSS sg13g2_decap_8
X_09538_ _14137_/D _10101_/A0 _14137_/Q _09538_/S VDD VSS sg13g2_mux2_1
XFILLER_145_1010 VDD VSS sg13g2_decap_8
XFILLER_19_1024 VDD VSS sg13g2_fill_1
XFILLER_12_602 VDD VSS sg13g2_decap_8
XFILLER_52_771 VDD VSS sg13g2_decap_8
XFILLER_25_996 VDD VSS sg13g2_decap_8
XFILLER_19_1046 VDD VSS sg13g2_decap_8
X_09469_ _14070_/D _09966_/A1 _14070_/Q _09472_/S VDD VSS sg13g2_mux2_1
XFILLER_52_782 VDD VSS sg13g2_fill_1
XFILLER_185_905 VDD VSS sg13g2_fill_1
XFILLER_11_112 VDD VSS sg13g2_decap_8
XFILLER_169_456 VDD VSS sg13g2_decap_8
XFILLER_40_944 VDD VSS sg13g2_decap_8
X_11500_ _11500_/Y _11499_/Y _11498_/Y _11485_/Y _11721_/B1 _11501_/A2 VDD VSS sg13g2_a221oi_1
XFILLER_145_1076 VDD VSS sg13g2_decap_8
XFILLER_185_927 VDD VSS sg13g2_decap_8
X_12480_ _12480_/X _14692_/Q _14724_/Q _13764_/Q _13796_/Q _12759_/S0 _12759_/S1 VDD
+ VSS sg13g2_mux4_1
XFILLER_106_1049 VDD VSS sg13g2_decap_8
XFILLER_12_679 VDD VSS sg13g2_decap_8
XFILLER_7_105 VDD VSS sg13g2_decap_8
XFILLER_123_1341 VDD VSS sg13g2_decap_8
X_11431_ _11431_/Y _07684_/B _11430_/Y wire231/X _11426_/Y _11248_/B VDD VSS sg13g2_a221oi_1
XFILLER_123_1352 VDD VSS sg13g2_fill_2
XFILLER_11_189 VDD VSS sg13g2_decap_8
XFILLER_22_63 VDD VSS sg13g2_decap_8
X_14150_ _14150_/Q _14662_/CLK _14150_/D _14150_/RESET_B VDD VSS sg13g2_dfrbpq_1
XFILLER_138_898 VDD VSS sg13g2_decap_4
X_11362_ _11362_/Y _11896_/A _14366_/Q VDD VSS sg13g2_nand2b_1
XFILLER_153_824 VDD VSS sg13g2_decap_4
XFILLER_4_812 VDD VSS sg13g2_decap_8
X_13101_ _13116_/A _14913_/Q _13674_/Q VDD VSS sg13g2_nand2_1
XFILLER_138_85 VDD VSS sg13g2_decap_8
X_10313_ _10313_/X _14796_/Q _14797_/Q _10342_/A _10327_/B VDD VSS sg13g2_and4_1
X_14081_ _14081_/Q clkload38/A _14081_/D _14081_/RESET_B VDD VSS sg13g2_dfrbpq_1
XFILLER_3_322 VDD VSS sg13g2_decap_8
XFILLER_106_740 VDD VSS sg13g2_decap_8
XFILLER_158_1459 VDD VSS sg13g2_decap_8
X_11293_ _11293_/Y _11340_/A1 _11292_/Y _11287_/Y _11289_/Y _11248_/B VDD VSS sg13g2_a221oi_1
XFILLER_98_56 VDD VSS sg13g2_decap_8
X_14306__1966 _14306_/RESET_B VDD VSS sg13g2_tiehi
XFILLER_69_1180 VDD VSS sg13g2_decap_8
X_13032_ _13032_/Y _12900_/A _12997_/A input9/X VDD VSS sg13g2_a21oi_1
X_10244_ _10245_/A _14775_/Q _14776_/Q _10247_/D VDD VSS sg13g2_and3_1
XFILLER_4_889 VDD VSS sg13g2_decap_8
XFILLER_65_1044 VDD VSS sg13g2_fill_2
XFILLER_105_272 VDD VSS sg13g2_decap_8
XFILLER_133_581 VDD VSS sg13g2_fill_2
XFILLER_161_890 VDD VSS sg13g2_decap_4
XFILLER_78_112 VDD VSS sg13g2_decap_8
Xfanout1101 _08659_/A _08035_/A VDD VSS sg13g2_buf_1
XFILLER_3_399 VDD VSS sg13g2_decap_8
XFILLER_121_743 VDD VSS sg13g2_decap_4
Xfanout1112 _08621_/A _08460_/A1 VDD VSS sg13g2_buf_1
XFILLER_65_1077 VDD VSS sg13g2_decap_8
XFILLER_120_231 VDD VSS sg13g2_decap_8
X_10175_ _10175_/Y _13293_/A _13613_/B _13613_/C VDD VSS sg13g2_nor3_1
Xfanout1123 _08103_/B _13525_/A VDD VSS sg13g2_buf_1
Xfanout1134 _08109_/A1 _08300_/S1 VDD VSS sg13g2_buf_1
XFILLER_154_95 VDD VSS sg13g2_decap_8
Xfanout1145 _08023_/A _08253_/S0 VDD VSS sg13g2_buf_1
XFILLER_43_1331 VDD VSS sg13g2_decap_8
Xfanout1156 _12203_/A _14985_/Q VDD VSS sg13g2_buf_1
Xfanout1167 _08620_/A3 _12061_/A VDD VSS sg13g2_buf_1
X_14983_ _14983_/Q clkload69/A _14983_/D _14983_/RESET_B VDD VSS sg13g2_dfrbpq_1
Xfanout180 _10162_/A1 _09930_/A1 VDD VSS sg13g2_buf_1
Xfanout1178 _07821_/B _08510_/A1 VDD VSS sg13g2_buf_1
X_14521__1751 _14521_/RESET_B VDD VSS sg13g2_tiehi
Xfanout191 _10160_/A1 wire192/X VDD VSS sg13g2_buf_1
Xfanout1189 _11843_/A _14975_/Q VDD VSS sg13g2_buf_1
XFILLER_130_1334 VDD VSS sg13g2_decap_8
X_13934_ _13934_/Q clkload60/A _13934_/D _13934_/RESET_B VDD VSS sg13g2_dfrbpq_1
XFILLER_130_1356 VDD VSS sg13g2_decap_8
XFILLER_19_245 VDD VSS sg13g2_decap_8
XFILLER_74_340 VDD VSS sg13g2_decap_8
XFILLER_35_727 VDD VSS sg13g2_decap_4
X_13865_ _13865_/Q clkload34/A _13865_/D _13865_/RESET_B VDD VSS sg13g2_dfrbpq_1
XFILLER_47_598 VDD VSS sg13g2_decap_8
XFILLER_74_395 VDD VSS sg13g2_fill_2
XFILLER_34_226 VDD VSS sg13g2_decap_8
XFILLER_16_952 VDD VSS sg13g2_decap_8
X_12816_ _12816_/Y _12914_/A _12814_/Y _12815_/Y VDD VSS sg13g2_o21ai_1
XFILLER_34_259 VDD VSS sg13g2_fill_2
XFILLER_163_1110 VDD VSS sg13g2_fill_1
X_13796_ _13796_/Q _14744_/CLK _13796_/D _13796_/RESET_B VDD VSS sg13g2_dfrbpq_1
XFILLER_43_760 VDD VSS sg13g2_decap_8
XFILLER_72_1004 VDD VSS sg13g2_decap_4
XFILLER_15_462 VDD VSS sg13g2_decap_8
X_12747_ _12747_/X _12741_/X _12745_/X _12740_/X _12744_/X _12747_/S0 _12747_/S1 VDD
+ VSS sg13g2_mux4_1
XFILLER_30_410 VDD VSS sg13g2_decap_8
XFILLER_163_1154 VDD VSS sg13g2_decap_8
XFILLER_72_1037 VDD VSS sg13g2_fill_1
XFILLER_124_1116 VDD VSS sg13g2_decap_8
XFILLER_179_70 VDD VSS sg13g2_decap_8
XFILLER_175_404 VDD VSS sg13g2_decap_8
XFILLER_8_21 VDD VSS sg13g2_decap_8
X_12678_ _12678_/X _12676_/X _12677_/X _12678_/S VDD VSS sg13g2_mux2_1
XFILLER_54_1460 VDD VSS sg13g2_decap_8
XFILLER_147_139 VDD VSS sg13g2_fill_1
X_14417_ _14417_/Q _14513_/CLK _14417_/D _14417_/RESET_B VDD VSS sg13g2_dfrbpq_1
X_11629_ _11629_/Y _14905_/Q _12122_/A2 _11625_/Y _11628_/Y VDD VSS sg13g2_a22oi_1
XFILLER_50_1335 VDD VSS sg13g2_fill_2
XFILLER_129_865 VDD VSS sg13g2_decap_8
XFILLER_15_1466 VDD VSS sg13g2_decap_8
XFILLER_15_1477 VDD VSS sg13g2_fill_2
XFILLER_102_1436 VDD VSS sg13g2_decap_8
XFILLER_8_98 VDD VSS sg13g2_decap_8
XFILLER_128_375 VDD VSS sg13g2_decap_8
X_14348_ _14348_/Q clkload50/A _14348_/D _14348_/RESET_B VDD VSS sg13g2_dfrbpq_1
XFILLER_144_835 VDD VSS sg13g2_decap_8
XFILLER_7_672 VDD VSS sg13g2_decap_8
XFILLER_85_1409 VDD VSS sg13g2_fill_2
XFILLER_13_1190 VDD VSS sg13g2_decap_8
X_14279_ _14279_/Q _14741_/CLK _14279_/D _14279_/RESET_B VDD VSS sg13g2_dfrbpq_1
XFILLER_6_182 VDD VSS sg13g2_decap_8
XFILLER_83_1100 VDD VSS sg13g2_fill_2
Xmax_cap369 fanout367/A _09772_/S VDD VSS sg13g2_buf_2
XFILLER_98_922 VDD VSS sg13g2_fill_2
XFILLER_83_1122 VDD VSS sg13g2_decap_8
XFILLER_170_1103 VDD VSS sg13g2_decap_8
XFILLER_98_944 VDD VSS sg13g2_fill_1
XFILLER_48_1275 VDD VSS sg13g2_fill_2
XFILLER_170_1114 VDD VSS sg13g2_fill_1
X_08840_ _08840_/Y _15023_/Q _08848_/A _10805_/B VDD VSS sg13g2_a21oi_1
XFILLER_112_754 VDD VSS sg13g2_decap_4
XFILLER_44_1139 VDD VSS sg13g2_decap_8
XFILLER_97_465 VDD VSS sg13g2_decap_4
XFILLER_69_156 VDD VSS sg13g2_decap_8
XFILLER_98_999 VDD VSS sg13g2_decap_8
XFILLER_69_167 VDD VSS sg13g2_fill_1
XFILLER_26_0 VDD VSS sg13g2_decap_8
XFILLER_170_1158 VDD VSS sg13g2_decap_4
X_08771_ _13675_/D _08728_/Y _08770_/Y _08769_/Y VDD VSS sg13g2_a21oi_1
XFILLER_69_178 VDD VSS sg13g2_decap_8
XFILLER_61_1453 VDD VSS sg13g2_fill_2
XFILLER_22_1415 VDD VSS sg13g2_decap_8
XFILLER_78_690 VDD VSS sg13g2_decap_8
X_07722_ _07726_/A _15109_/Q _15104_/Q _15103_/Q _15100_/Q VDD VSS sg13g2_nor4_1
XFILLER_168_1010 VDD VSS sg13g2_fill_2
XFILLER_81_811 VDD VSS sg13g2_decap_8
X_07653_ _07653_/Y _10647_/D VDD VSS sg13g2_inv_1
XFILLER_168_1043 VDD VSS sg13g2_decap_4
XFILLER_81_833 VDD VSS sg13g2_fill_1
XFILLER_65_384 VDD VSS sg13g2_fill_1
XFILLER_53_524 VDD VSS sg13g2_fill_1
XFILLER_26_738 VDD VSS sg13g2_decap_8
XFILLER_0_1233 VDD VSS sg13g2_decap_8
XFILLER_20_1161 VDD VSS sg13g2_decap_8
XFILLER_53_546 VDD VSS sg13g2_fill_2
XFILLER_168_1076 VDD VSS sg13g2_fill_1
XFILLER_59_1360 VDD VSS sg13g2_fill_2
XFILLER_55_1202 VDD VSS sg13g2_decap_8
XFILLER_53_579 VDD VSS sg13g2_fill_2
XFILLER_59_1382 VDD VSS sg13g2_decap_8
XFILLER_22_900 VDD VSS sg13g2_decap_4
XFILLER_146_1341 VDD VSS sg13g2_decap_8
XFILLER_185_1390 VDD VSS sg13g2_decap_8
X_09323_ _13930_/D _10153_/A1 _13930_/Q _09333_/S VDD VSS sg13g2_mux2_1
XFILLER_181_1232 VDD VSS sg13g2_decap_8
XFILLER_178_231 VDD VSS sg13g2_decap_8
XFILLER_179_754 VDD VSS sg13g2_decap_8
XFILLER_80_398 VDD VSS sg13g2_decap_8
XFILLER_181_1243 VDD VSS sg13g2_fill_1
XFILLER_139_607 VDD VSS sg13g2_fill_2
X_09254_ _13863_/D _13863_/Q _09918_/A1 _09272_/S VDD VSS sg13g2_mux2_1
XFILLER_138_106 VDD VSS sg13g2_decap_8
XFILLER_142_1238 VDD VSS sg13g2_decap_8
XFILLER_22_988 VDD VSS sg13g2_decap_8
X_08205_ _08211_/C _11461_/A _14995_/Q _08204_/Y VDD VSS sg13g2_o21ai_1
XFILLER_166_448 VDD VSS sg13g2_fill_2
X_09185_ _13801_/D _13801_/Q _10152_/A1 _09201_/S VDD VSS sg13g2_mux2_1
XFILLER_135_802 VDD VSS sg13g2_fill_1
XFILLER_147_662 VDD VSS sg13g2_decap_8
XFILLER_5_609 VDD VSS sg13g2_decap_8
X_14563__1709 _14563_/RESET_B VDD VSS sg13g2_tiehi
X_08136_ _08145_/B _08402_/C _08133_/X _08135_/Y VDD VSS sg13g2_o21ai_1
XFILLER_175_993 VDD VSS sg13g2_fill_1
X_13949__2323 _13949_/RESET_B VDD VSS sg13g2_tiehi
XFILLER_175_28 VDD VSS sg13g2_decap_8
XFILLER_4_119 VDD VSS sg13g2_decap_8
XFILLER_119_397 VDD VSS sg13g2_decap_4
XFILLER_175_1003 VDD VSS sg13g2_fill_1
XFILLER_88_1055 VDD VSS sg13g2_decap_8
XFILLER_134_334 VDD VSS sg13g2_decap_8
XFILLER_146_194 VDD VSS sg13g2_decap_8
XFILLER_179_1183 VDD VSS sg13g2_decap_8
X_08067_ _08067_/Y _08402_/C _08064_/X _08397_/A VDD VSS sg13g2_o21ai_1
XFILLER_104_7 VDD VSS sg13g2_decap_8
XFILLER_162_654 VDD VSS sg13g2_decap_8
XFILLER_88_1088 VDD VSS sg13g2_decap_8
XFILLER_108_44 VDD VSS sg13g2_decap_8
XFILLER_150_827 VDD VSS sg13g2_decap_8
X_14853__2931 _14853_/RESET_B VDD VSS sg13g2_tiehi
XFILLER_1_826 VDD VSS sg13g2_decap_8
XFILLER_108_99 VDD VSS sg13g2_fill_2
XFILLER_161_197 VDD VSS sg13g2_decap_8
Xhold3220 _10800_/A _14927_/Q VDD VSS sg13g2_dlygate4sd3_1
Xhold3231 _13547_/A _15147_/Q VDD VSS sg13g2_dlygate4sd3_1
XFILLER_88_432 VDD VSS sg13g2_decap_8
XFILLER_0_336 VDD VSS sg13g2_decap_8
Xhold3242 hold3242/X _15166_/Q VDD VSS sg13g2_dlygate4sd3_1
XFILLER_89_966 VDD VSS sg13g2_decap_8
XFILLER_66_1386 VDD VSS sg13g2_decap_8
XFILLER_103_754 VDD VSS sg13g2_decap_8
Xhold3253 _10959_/A _14939_/Q VDD VSS sg13g2_dlygate4sd3_1
XFILLER_118_1476 VDD VSS sg13g2_fill_2
Xhold3264 hold3264/X _15164_/Q VDD VSS sg13g2_dlygate4sd3_1
XFILLER_103_776 VDD VSS sg13g2_decap_8
XFILLER_114_1318 VDD VSS sg13g2_fill_2
XFILLER_124_21 VDD VSS sg13g2_fill_1
X_08969_ _08969_/X _08969_/A _09141_/A _10697_/B VDD VSS sg13g2_and3_1
X_14886__2865 _14886_/RESET_B VDD VSS sg13g2_tiehi
X_11980_ _12006_/A _11980_/A _11983_/A VDD VSS sg13g2_nand2_1
XFILLER_5_1155 VDD VSS sg13g2_decap_8
XFILLER_112_1042 VDD VSS sg13g2_decap_8
XFILLER_91_619 VDD VSS sg13g2_decap_8
XFILLER_84_47 VDD VSS sg13g2_decap_8
XFILLER_186_1110 VDD VSS sg13g2_decap_8
XFILLER_1_1008 VDD VSS sg13g2_decap_8
XFILLER_186_1121 VDD VSS sg13g2_decap_8
XFILLER_84_671 VDD VSS sg13g2_decap_8
XFILLER_72_811 VDD VSS sg13g2_fill_1
XFILLER_29_576 VDD VSS sg13g2_decap_8
X_10931_ _10932_/B _14757_/Q _10954_/B VDD VSS sg13g2_nand2b_1
XFILLER_112_1086 VDD VSS sg13g2_decap_8
XFILLER_17_749 VDD VSS sg13g2_decap_8
XFILLER_56_384 VDD VSS sg13g2_decap_8
XFILLER_17_63 VDD VSS sg13g2_decap_8
XFILLER_44_557 VDD VSS sg13g2_fill_2
XFILLER_16_259 VDD VSS sg13g2_decap_8
XFILLER_182_1018 VDD VSS sg13g2_decap_8
X_13650_ _15116_/D _15185_/D _15116_/Q _13652_/S VDD VSS sg13g2_mux2_1
X_10862_ _10862_/Y _10862_/A _10875_/B VDD VSS sg13g2_nand2_1
XFILLER_72_888 VDD VSS sg13g2_decap_8
XFILLER_182_1029 VDD VSS sg13g2_fill_1
XFILLER_73_1302 VDD VSS sg13g2_decap_8
X_12601_ _12601_/X _14125_/Q _14157_/Q _14189_/Q _14221_/Q _12606_/S0 _12606_/S1 VDD
+ VSS sg13g2_mux4_1
XFILLER_38_1444 VDD VSS sg13g2_decap_8
XFILLER_25_782 VDD VSS sg13g2_decap_8
X_13581_ _13581_/Y _13581_/A _13581_/B VDD VSS sg13g2_nor2_1
XFILLER_169_231 VDD VSS sg13g2_decap_4
X_10793_ _10793_/X _10793_/A _10793_/B _10793_/C VDD VSS sg13g2_and3_1
XFILLER_13_966 VDD VSS sg13g2_decap_8
X_12532_ _12532_/X _14248_/Q _14280_/Q _14312_/Q _14344_/Q _12668_/S0 _12668_/S1 VDD
+ VSS sg13g2_mux4_1
XFILLER_73_1368 VDD VSS sg13g2_decap_8
XFILLER_160_1327 VDD VSS sg13g2_decap_8
XFILLER_184_201 VDD VSS sg13g2_decap_8
XFILLER_184_212 VDD VSS sg13g2_decap_8
XFILLER_12_476 VDD VSS sg13g2_decap_8
XFILLER_130_0 VDD VSS sg13g2_decap_8
XFILLER_184_223 VDD VSS sg13g2_fill_2
XFILLER_9_959 VDD VSS sg13g2_decap_8
XFILLER_33_84 VDD VSS sg13g2_decap_8
X_12463_ _12463_/X _14563_/Q _14595_/Q _14627_/Q _14659_/Q _12769_/S0 _12769_/S1 VDD
+ VSS sg13g2_mux4_1
XFILLER_166_971 VDD VSS sg13g2_fill_1
XFILLER_8_469 VDD VSS sg13g2_decap_8
XFILLER_126_813 VDD VSS sg13g2_decap_8
X_14202_ _14202_/Q clkload51/A _14202_/D _14202_/RESET_B VDD VSS sg13g2_dfrbpq_1
X_11414_ _11424_/C _11411_/Y _11413_/X _11831_/B1 VDD VSS sg13g2_o21ai_1
XFILLER_123_1182 VDD VSS sg13g2_decap_8
X_15182_ _15182_/Q _15182_/CLK _15182_/D _15182_/RESET_B VDD VSS sg13g2_dfrbpq_1
XFILLER_126_824 VDD VSS sg13g2_fill_2
XFILLER_153_610 VDD VSS sg13g2_decap_8
XFILLER_165_470 VDD VSS sg13g2_decap_8
XFILLER_166_993 VDD VSS sg13g2_fill_2
X_12394_ _12394_/X _13950_/Q _13982_/Q _14014_/Q _14046_/Q _12406_/S0 _12406_/S1 VDD
+ VSS sg13g2_mux4_1
X_14539__1733 _14539_/RESET_B VDD VSS sg13g2_tiehi
XFILLER_153_632 VDD VSS sg13g2_fill_1
XFILLER_10_1330 VDD VSS sg13g2_decap_8
X_14133_ _14133_/Q clkload28/A _14133_/D _14133_/RESET_B VDD VSS sg13g2_dfrbpq_1
X_11345_ _11345_/Y _11821_/S0 _13918_/Q _12304_/B VDD VSS sg13g2_a21oi_1
XFILLER_125_367 VDD VSS sg13g2_decap_8
XFILLER_181_985 VDD VSS sg13g2_fill_1
XFILLER_153_687 VDD VSS sg13g2_decap_8
XFILLER_180_462 VDD VSS sg13g2_decap_8
X_14064_ _14064_/Q _14733_/CLK _14064_/D _14064_/RESET_B VDD VSS sg13g2_dfrbpq_1
XFILLER_158_1289 VDD VSS sg13g2_decap_8
X_11276_ _11276_/Y _11275_/X _12094_/B _11274_/Y VDD VSS sg13g2_a21oi_1
XFILLER_98_229 VDD VSS sg13g2_decap_8
XFILLER_4_686 VDD VSS sg13g2_decap_8
XFILLER_134_890 VDD VSS sg13g2_decap_8
XFILLER_84_1453 VDD VSS sg13g2_fill_1
X_13015_ _13015_/Y _14780_/Q _13236_/A2 _13220_/B1 VDD VSS sg13g2_o21ai_1
X_10227_ _14770_/D _10234_/D _13324_/A _10227_/C VDD VSS sg13g2_nor3_1
XFILLER_79_443 VDD VSS sg13g2_decap_8
XFILLER_3_196 VDD VSS sg13g2_decap_8
XFILLER_140_359 VDD VSS sg13g2_decap_8
XFILLER_45_1437 VDD VSS sg13g2_decap_8
XFILLER_45_1448 VDD VSS sg13g2_fill_2
X_15237__3098 _15237_/RESET_B VDD VSS sg13g2_tiehi
XFILLER_132_1418 VDD VSS sg13g2_decap_4
X_10158_ _14735_/D _14735_/Q _10158_/A1 _10160_/S VDD VSS sg13g2_mux2_1
XFILLER_58_92 VDD VSS sg13g2_decap_8
XFILLER_130_1120 VDD VSS sg13g2_decap_8
XFILLER_43_1172 VDD VSS sg13g2_decap_8
X_14966_ _14966_/Q clkload43/A _14966_/D _14966_/RESET_B VDD VSS sg13g2_dfrbpq_1
X_10089_ _14669_/D _10089_/A0 _14669_/Q _10093_/S VDD VSS sg13g2_mux2_1
XFILLER_130_1153 VDD VSS sg13g2_fill_2
XFILLER_63_811 VDD VSS sg13g2_decap_4
XFILLER_48_885 VDD VSS sg13g2_decap_4
XFILLER_81_118 VDD VSS sg13g2_fill_2
X_13917_ _13917_/Q _14883_/CLK _13917_/D _13917_/RESET_B VDD VSS sg13g2_dfrbpq_1
XFILLER_63_833 VDD VSS sg13g2_decap_8
XFILLER_62_310 VDD VSS sg13g2_decap_4
XFILLER_35_524 VDD VSS sg13g2_decap_8
X_14897_ _14897_/Q clkload79/A _14897_/D _14897_/RESET_B VDD VSS sg13g2_dfrbpq_1
XFILLER_78_1246 VDD VSS sg13g2_fill_1
XFILLER_63_844 VDD VSS sg13g2_fill_1
XFILLER_35_546 VDD VSS sg13g2_decap_8
XFILLER_90_652 VDD VSS sg13g2_decap_8
X_13848_ _13848_/Q clkload24/A _13848_/D _13848_/RESET_B VDD VSS sg13g2_dfrbpq_1
XFILLER_74_91 VDD VSS sg13g2_fill_1
XFILLER_50_527 VDD VSS sg13g2_decap_8
XFILLER_90_696 VDD VSS sg13g2_decap_8
X_13779_ _13779_/Q _14739_/CLK _13779_/D _13779_/RESET_B VDD VSS sg13g2_dfrbpq_1
XFILLER_176_702 VDD VSS sg13g2_decap_8
XFILLER_149_938 VDD VSS sg13g2_decap_8
XFILLER_31_796 VDD VSS sg13g2_decap_8
XFILLER_30_273 VDD VSS sg13g2_decap_8
XFILLER_148_459 VDD VSS sg13g2_fill_1
XFILLER_175_245 VDD VSS sg13g2_decap_8
XFILLER_15_1263 VDD VSS sg13g2_decap_8
XFILLER_50_1154 VDD VSS sg13g2_fill_1
XFILLER_129_684 VDD VSS sg13g2_fill_1
XFILLER_163_429 VDD VSS sg13g2_decap_8
XFILLER_11_1127 VDD VSS sg13g2_decap_8
XFILLER_141_1293 VDD VSS sg13g2_decap_8
XFILLER_176_1312 VDD VSS sg13g2_decap_8
X_14990__2690 _14990_/RESET_B VDD VSS sg13g2_tiehi
XFILLER_172_941 VDD VSS sg13g2_fill_1
XFILLER_117_857 VDD VSS sg13g2_fill_1
XFILLER_85_1217 VDD VSS sg13g2_decap_8
XFILLER_117_879 VDD VSS sg13g2_decap_4
XFILLER_144_665 VDD VSS sg13g2_fill_1
XFILLER_172_974 VDD VSS sg13g2_decap_8
XFILLER_85_1228 VDD VSS sg13g2_fill_2
XFILLER_171_462 VDD VSS sg13g2_decap_4
XFILLER_116_378 VDD VSS sg13g2_decap_8
XFILLER_176_1378 VDD VSS sg13g2_decap_4
X_09941_ _14525_/D _14525_/Q _09941_/A1 _09958_/S VDD VSS sg13g2_mux2_1
XFILLER_98_730 VDD VSS sg13g2_decap_8
Xfanout905 _12550_/S1 _12773_/S1 VDD VSS sg13g2_buf_1
Xfanout916 _12644_/S0 _12604_/S0 VDD VSS sg13g2_buf_1
Xfanout927 _12674_/S0 fanout932/X VDD VSS sg13g2_buf_1
X_09872_ wire288/A _09938_/A _09872_/B _10137_/A _10037_/B VDD VSS sg13g2_nand4_1
XFILLER_140_860 VDD VSS sg13g2_fill_2
Xfanout938 _12618_/S0 _12382_/S0 VDD VSS sg13g2_buf_1
XFILLER_112_562 VDD VSS sg13g2_fill_2
Xfanout949 _12522_/S0 fanout953/X VDD VSS sg13g2_buf_1
X_08823_ _13691_/D _08821_/Y _08820_/Y _08822_/Y VDD VSS sg13g2_a21oi_1
XFILLER_58_638 VDD VSS sg13g2_fill_2
XFILLER_57_126 VDD VSS sg13g2_decap_8
XFILLER_85_446 VDD VSS sg13g2_decap_8
XFILLER_6_1442 VDD VSS sg13g2_decap_8
XFILLER_22_1212 VDD VSS sg13g2_decap_8
X_08754_ _08754_/Y _07720_/A _07720_/B _15192_/Q VDD VSS sg13g2_o21ai_1
XFILLER_61_1294 VDD VSS sg13g2_decap_8
XFILLER_72_107 VDD VSS sg13g2_fill_1
X_07705_ _15201_/D _07705_/A _07705_/B _07705_/C VDD VSS sg13g2_nand3_1
XFILLER_54_811 VDD VSS sg13g2_decap_8
XFILLER_96_1324 VDD VSS sg13g2_decap_8
X_08685_ _15248_/D _08395_/A _08684_/X _08676_/Y VDD VSS sg13g2_o21ai_1
XFILLER_22_1289 VDD VSS sg13g2_decap_8
XFILLER_54_28 VDD VSS sg13g2_decap_8
XFILLER_53_321 VDD VSS sg13g2_decap_8
XFILLER_0_1030 VDD VSS sg13g2_decap_8
X_07636_ _07636_/Y _15009_/Q VDD VSS sg13g2_inv_1
XFILLER_96_1368 VDD VSS sg13g2_fill_2
XFILLER_148_1447 VDD VSS sg13g2_decap_8
XFILLER_81_663 VDD VSS sg13g2_decap_8
X_14617__1655 _14617_/RESET_B VDD VSS sg13g2_tiehi
XFILLER_80_151 VDD VSS sg13g2_decap_8
XFILLER_53_398 VDD VSS sg13g2_decap_4
XFILLER_41_538 VDD VSS sg13g2_decap_8
XFILLER_55_1032 VDD VSS sg13g2_fill_2
XFILLER_110_56 VDD VSS sg13g2_decap_8
XFILLER_16_1005 VDD VSS sg13g2_fill_2
X_09306_ _13914_/D _13914_/Q _09739_/A0 _09306_/S VDD VSS sg13g2_mux2_1
XFILLER_10_903 VDD VSS sg13g2_decap_8
XFILLER_179_595 VDD VSS sg13g2_decap_8
X_13881__2391 _13881_/RESET_B VDD VSS sg13g2_tiehi
XFILLER_55_1076 VDD VSS sg13g2_decap_8
XFILLER_167_746 VDD VSS sg13g2_decap_8
XFILLER_181_1084 VDD VSS sg13g2_decap_8
XFILLER_70_49 VDD VSS sg13g2_decap_8
X_09237_ _13848_/D _10134_/A0 _13848_/Q _09237_/S VDD VSS sg13g2_mux2_1
XFILLER_166_245 VDD VSS sg13g2_decap_8
XFILLER_33_1341 VDD VSS sg13g2_fill_1
XFILLER_120_1300 VDD VSS sg13g2_fill_1
XFILLER_186_49 VDD VSS sg13g2_decap_4
XFILLER_5_406 VDD VSS sg13g2_decap_8
XFILLER_177_1109 VDD VSS sg13g2_decap_8
X_09168_ _10070_/B _09441_/A _10004_/B _09441_/C VDD VSS sg13g2_and3_1
XFILLER_108_835 VDD VSS sg13g2_fill_2
XFILLER_120_1344 VDD VSS sg13g2_decap_8
XFILLER_147_481 VDD VSS sg13g2_decap_8
XFILLER_119_183 VDD VSS sg13g2_decap_8
XFILLER_147_492 VDD VSS sg13g2_fill_1
XFILLER_163_952 VDD VSS sg13g2_decap_8
X_08119_ _08119_/X _08470_/B _07820_/B _08119_/A2 _08591_/A3 _08686_/S0 _08278_/S1
+ VDD VSS sg13g2_mux4_1
XFILLER_79_14 VDD VSS sg13g2_decap_4
XFILLER_119_76 VDD VSS sg13g2_decap_8
XFILLER_181_259 VDD VSS sg13g2_decap_8
X_09099_ _13776_/D _13776_/Q _10159_/A1 _09106_/S VDD VSS sg13g2_mux2_1
X_11130_ _11130_/Y _11129_/Y _11127_/Y _11114_/X _11117_/Y _11193_/A2 VDD VSS sg13g2_a221oi_1
XFILLER_123_849 VDD VSS sg13g2_decap_8
XFILLER_122_326 VDD VSS sg13g2_decap_8
XFILLER_1_623 VDD VSS sg13g2_decap_8
XFILLER_122_337 VDD VSS sg13g2_fill_2
XFILLER_89_730 VDD VSS sg13g2_decap_8
XFILLER_135_42 VDD VSS sg13g2_fill_1
X_11061_ _11061_/Y _11068_/C _11202_/A _14760_/Q _11033_/B VDD VSS sg13g2_a22oi_1
XFILLER_0_133 VDD VSS sg13g2_decap_8
XFILLER_131_860 VDD VSS sg13g2_decap_8
XFILLER_135_64 VDD VSS sg13g2_decap_4
XFILLER_89_774 VDD VSS sg13g2_decap_8
X_10012_ _14594_/D _10045_/A0 _14594_/Q _10031_/S VDD VSS sg13g2_mux2_1
XFILLER_153_1164 VDD VSS sg13g2_fill_2
XFILLER_88_273 VDD VSS sg13g2_decap_8
XFILLER_7_1239 VDD VSS sg13g2_decap_8
XFILLER_27_1167 VDD VSS sg13g2_decap_8
XFILLER_118_1295 VDD VSS sg13g2_decap_8
XFILLER_62_1058 VDD VSS sg13g2_decap_8
XFILLER_49_638 VDD VSS sg13g2_decap_8
XFILLER_114_1137 VDD VSS sg13g2_decap_4
XFILLER_77_969 VDD VSS sg13g2_decap_4
XFILLER_40_1312 VDD VSS sg13g2_fill_1
X_14820_ _14820_/Q clkload63/A _14820_/D _14820_/RESET_B VDD VSS sg13g2_dfrbpq_1
XFILLER_131_1440 VDD VSS sg13g2_fill_1
XFILLER_40_1323 VDD VSS sg13g2_decap_4
XFILLER_57_671 VDD VSS sg13g2_decap_8
XFILLER_28_84 VDD VSS sg13g2_fill_1
XFILLER_178_0 VDD VSS sg13g2_decap_8
X_14751_ _14751_/Q clkload84/A _14751_/D _14751_/RESET_B VDD VSS sg13g2_dfrbpq_1
X_11963_ _11964_/A _14256_/Q _14288_/Q _14320_/Q _14352_/Q _11963_/S0 _11963_/S1 VDD
+ VSS sg13g2_mux4_1
XFILLER_40_1378 VDD VSS sg13g2_fill_2
XFILLER_17_546 VDD VSS sg13g2_decap_8
XFILLER_72_641 VDD VSS sg13g2_decap_8
X_13702_ _16864_/A clkload74/A _13702_/D _13702_/RESET_B VDD VSS sg13g2_dfrbpq_1
X_10914_ _10914_/Y _10914_/A _11196_/B VDD VSS sg13g2_nand2_1
XFILLER_75_1419 VDD VSS sg13g2_decap_4
X_14682_ _14682_/Q clkload53/A _14682_/D _14682_/RESET_B VDD VSS sg13g2_dfrbpq_1
X_11894_ _11898_/A _11893_/X _11894_/B VDD VSS sg13g2_nand2b_1
XFILLER_72_685 VDD VSS sg13g2_decap_8
XFILLER_38_1230 VDD VSS sg13g2_decap_8
X_13633_ _13741_/D _13633_/A VDD VSS sg13g2_buf_1
X_10845_ _10845_/Y _10876_/D _10876_/A _10843_/C VDD VSS sg13g2_a21oi_1
XFILLER_158_724 VDD VSS sg13g2_decap_8
XFILLER_73_1165 VDD VSS sg13g2_decap_8
XFILLER_13_763 VDD VSS sg13g2_decap_8
X_13564_ _13564_/Y _07910_/A _13564_/A2 _13563_/Y VDD VSS sg13g2_a21oi_1
X_10776_ _10776_/X _10776_/A _10793_/B _10793_/A VDD VSS sg13g2_and3_1
XFILLER_158_735 VDD VSS sg13g2_fill_2
XFILLER_164_1293 VDD VSS sg13g2_decap_8
X_13711__2561 _13711_/RESET_B VDD VSS sg13g2_tiehi
XFILLER_185_532 VDD VSS sg13g2_decap_8
XFILLER_81_9 VDD VSS sg13g2_fill_1
XFILLER_40_571 VDD VSS sg13g2_fill_2
XFILLER_160_1146 VDD VSS sg13g2_fill_2
XFILLER_12_273 VDD VSS sg13g2_decap_8
X_12515_ _12515_/X _13831_/Q _13863_/Q _13895_/Q _13927_/Q _12522_/S0 _12522_/S1 VDD
+ VSS sg13g2_mux4_1
X_13495_ _13495_/Y _15129_/Q _15071_/Q _08822_/B VDD VSS sg13g2_o21ai_1
XFILLER_9_756 VDD VSS sg13g2_decap_8
XFILLER_40_593 VDD VSS sg13g2_decap_8
XFILLER_125_1288 VDD VSS sg13g2_decap_8
XFILLER_12_1414 VDD VSS sg13g2_decap_8
XFILLER_139_982 VDD VSS sg13g2_decap_8
XFILLER_145_418 VDD VSS sg13g2_decap_8
XFILLER_51_1463 VDD VSS sg13g2_decap_8
X_15234_ _15234_/Q clkload76/A _15234_/D _15234_/RESET_B VDD VSS sg13g2_dfrbpq_1
X_12446_ _12446_/X _13730_/Q _14082_/Q _14434_/Q _14530_/Q _12450_/S0 _12450_/S1 VDD
+ VSS sg13g2_mux4_1
XFILLER_8_266 VDD VSS sg13g2_decap_8
XFILLER_173_749 VDD VSS sg13g2_decap_8
XFILLER_67_7 VDD VSS sg13g2_fill_2
X_14055__2217 _14055_/RESET_B VDD VSS sg13g2_tiehi
XFILLER_154_963 VDD VSS sg13g2_decap_8
X_15165_ _15165_/Q clkload89/A _15165_/D _15165_/RESET_B VDD VSS sg13g2_dfrbpq_1
X_12377_ _12377_/X _13821_/Q _13853_/Q _13885_/Q _13917_/Q _12378_/S0 _12378_/S1 VDD
+ VSS sg13g2_mux4_1
XFILLER_99_505 VDD VSS sg13g2_decap_8
XFILLER_153_462 VDD VSS sg13g2_decap_8
XFILLER_5_973 VDD VSS sg13g2_decap_8
XFILLER_113_304 VDD VSS sg13g2_fill_1
X_14116_ _14116_/Q _14503_/CLK _14116_/D _14116_/RESET_B VDD VSS sg13g2_dfrbpq_1
X_11328_ _11328_/X _13949_/Q _13981_/Q _14013_/Q _14045_/Q _11328_/S0 _11328_/S1 VDD
+ VSS sg13g2_mux4_1
XFILLER_181_793 VDD VSS sg13g2_decap_8
X_15096_ _15096_/Q clkload86/A _15096_/D _15096_/RESET_B VDD VSS sg13g2_dfrbpq_1
XFILLER_5_77 VDD VSS sg13g2_decap_8
XFILLER_4_483 VDD VSS sg13g2_decap_8
XFILLER_119_1048 VDD VSS sg13g2_decap_8
XFILLER_158_1097 VDD VSS sg13g2_decap_8
XFILLER_136_1340 VDD VSS sg13g2_fill_2
X_14047_ _14047_/Q clkload21/A _14047_/D _14047_/RESET_B VDD VSS sg13g2_dfrbpq_1
X_11259_ _11259_/Y _11275_/S0 _13820_/Q VDD VSS sg13g2_nand2b_1
XFILLER_80_1103 VDD VSS sg13g2_decap_8
XFILLER_69_80 VDD VSS sg13g2_fill_2
XFILLER_84_1283 VDD VSS sg13g2_decap_8
XFILLER_80_1147 VDD VSS sg13g2_decap_4
X_14270__2002 _14270_/RESET_B VDD VSS sg13g2_tiehi
XFILLER_67_424 VDD VSS sg13g2_decap_8
XFILLER_94_232 VDD VSS sg13g2_decap_8
XFILLER_68_969 VDD VSS sg13g2_decap_8
XFILLER_95_766 VDD VSS sg13g2_decap_8
XFILLER_132_1259 VDD VSS sg13g2_decap_8
XFILLER_67_479 VDD VSS sg13g2_decap_8
XFILLER_36_811 VDD VSS sg13g2_decap_8
X_14949_ _14949_/Q clkload57/A _14949_/D _14949_/RESET_B VDD VSS sg13g2_dfrbpq_1
X_08470_ _08475_/B _08470_/A _08470_/B _15008_/Q VDD VSS sg13g2_and3_1
XFILLER_1_1372 VDD VSS sg13g2_decap_8
XFILLER_56_1330 VDD VSS sg13g2_fill_2
XFILLER_35_398 VDD VSS sg13g2_decap_8
XFILLER_23_538 VDD VSS sg13g2_decap_8
XFILLER_126_1019 VDD VSS sg13g2_decap_8
XFILLER_62_195 VDD VSS sg13g2_decap_8
XFILLER_51_858 VDD VSS sg13g2_decap_8
XFILLER_108_1431 VDD VSS sg13g2_decap_4
XFILLER_93_0 VDD VSS sg13g2_decap_8
X_14870__2897 _14870_/RESET_B VDD VSS sg13g2_tiehi
X_14301__1971 _14301_/RESET_B VDD VSS sg13g2_tiehi
XFILLER_176_543 VDD VSS sg13g2_decap_8
XFILLER_17_1369 VDD VSS sg13g2_decap_8
XFILLER_148_256 VDD VSS sg13g2_decap_8
X_09022_ _09024_/B _12957_/A _10702_/A _14902_/Q _09022_/D VDD VSS sg13g2_nand4_1
XFILLER_15_1060 VDD VSS sg13g2_decap_8
XFILLER_178_1418 VDD VSS sg13g2_decap_8
XFILLER_164_749 VDD VSS sg13g2_decap_8
XFILLER_117_632 VDD VSS sg13g2_decap_4
XFILLER_89_1161 VDD VSS sg13g2_decap_8
XFILLER_105_827 VDD VSS sg13g2_decap_8
XFILLER_145_996 VDD VSS sg13g2_decap_8
XFILLER_160_922 VDD VSS sg13g2_decap_8
XFILLER_172_782 VDD VSS sg13g2_decap_8
XFILLER_105_838 VDD VSS sg13g2_fill_2
XFILLER_116_175 VDD VSS sg13g2_decap_8
XFILLER_117_698 VDD VSS sg13g2_decap_8
XFILLER_132_624 VDD VSS sg13g2_fill_2
XFILLER_137_1126 VDD VSS sg13g2_decap_8
XFILLER_160_944 VDD VSS sg13g2_decap_8
XFILLER_171_270 VDD VSS sg13g2_decap_8
XFILLER_28_1410 VDD VSS sg13g2_fill_1
XFILLER_49_28 VDD VSS sg13g2_decap_8
XFILLER_131_134 VDD VSS sg13g2_decap_8
XFILLER_160_977 VDD VSS sg13g2_decap_8
Xfanout702 _13282_/A1 _12777_/C1 VDD VSS sg13g2_buf_1
X_09924_ _14509_/D _14509_/Q _09924_/A1 _09929_/S VDD VSS sg13g2_mux2_1
XFILLER_160_988 VDD VSS sg13g2_fill_1
Xfanout713 _13274_/C1 _13082_/B VDD VSS sg13g2_buf_1
XFILLER_28_1443 VDD VSS sg13g2_decap_8
Xfanout724 _10999_/B1 _07703_/Y VDD VSS sg13g2_buf_1
XFILLER_86_700 VDD VSS sg13g2_decap_8
Xfanout735 _11722_/B2 _11721_/B1 VDD VSS sg13g2_buf_1
XFILLER_113_882 VDD VSS sg13g2_decap_8
Xfanout746 _13479_/S _13336_/S VDD VSS sg13g2_buf_1
XFILLER_100_510 VDD VSS sg13g2_decap_8
Xfanout757 _11964_/B fanout771/X VDD VSS sg13g2_buf_1
X_09855_ _14442_/D _14442_/Q _10086_/A0 _09858_/S VDD VSS sg13g2_mux2_1
Xfanout768 _12317_/B _12094_/B VDD VSS sg13g2_buf_1
XFILLER_86_744 VDD VSS sg13g2_decap_8
Xfanout779 _11967_/B _12105_/B1 VDD VSS sg13g2_buf_1
X_13753__2519 _13753_/RESET_B VDD VSS sg13g2_tiehi
XFILLER_98_1408 VDD VSS sg13g2_decap_8
X_08806_ _08808_/A _10823_/B _14752_/Q _08727_/X _15195_/Q _08825_/C1 VDD VSS sg13g2_a221oi_1
X_13899__2373 _13899_/RESET_B VDD VSS sg13g2_tiehi
XFILLER_105_78 VDD VSS sg13g2_decap_8
X_09786_ _14375_/D _09885_/A0 _14375_/Q _09800_/S VDD VSS sg13g2_mux2_1
XFILLER_73_405 VDD VSS sg13g2_decap_8
XFILLER_61_1091 VDD VSS sg13g2_decap_8
XFILLER_45_118 VDD VSS sg13g2_decap_8
XFILLER_67_991 VDD VSS sg13g2_fill_2
XFILLER_39_682 VDD VSS sg13g2_fill_2
XFILLER_27_822 VDD VSS sg13g2_decap_8
XFILLER_171_7 VDD VSS sg13g2_decap_8
X_08737_ _08737_/Y _13664_/Q _08801_/B VDD VSS sg13g2_nor2_1
XFILLER_96_1121 VDD VSS sg13g2_decap_8
XFILLER_38_170 VDD VSS sg13g2_decap_8
XFILLER_113_1192 VDD VSS sg13g2_decap_8
XFILLER_96_1132 VDD VSS sg13g2_fill_1
XFILLER_22_1086 VDD VSS sg13g2_decap_8
XFILLER_2_1169 VDD VSS sg13g2_decap_8
XFILLER_26_343 VDD VSS sg13g2_decap_8
X_08668_ _08668_/X _08668_/A _08668_/B VDD VSS sg13g2_or2_1
XFILLER_54_663 VDD VSS sg13g2_decap_8
XFILLER_42_825 VDD VSS sg13g2_decap_8
XFILLER_148_1255 VDD VSS sg13g2_decap_4
X_14133__2139 _14133_/RESET_B VDD VSS sg13g2_tiehi
XFILLER_82_994 VDD VSS sg13g2_decap_8
XFILLER_109_1217 VDD VSS sg13g2_decap_8
X_07619_ _09011_/C _14900_/Q VDD VSS sg13g2_inv_1
XFILLER_81_493 VDD VSS sg13g2_decap_8
X_08599_ _08600_/D _08599_/A _08599_/B _08599_/C VDD VSS sg13g2_nor3_1
XFILLER_121_99 VDD VSS sg13g2_decap_8
XFILLER_148_1288 VDD VSS sg13g2_decap_8
XFILLER_81_48 VDD VSS sg13g2_decap_8
XFILLER_42_869 VDD VSS sg13g2_fill_1
XFILLER_186_318 VDD VSS sg13g2_decap_8
X_10630_ _14884_/D _10630_/A _10630_/B _10630_/C VDD VSS sg13g2_and3_1
XFILLER_186_329 VDD VSS sg13g2_decap_8
XFILLER_14_42 VDD VSS sg13g2_decap_8
XFILLER_10_700 VDD VSS sg13g2_decap_8
XFILLER_70_1327 VDD VSS sg13g2_decap_8
XFILLER_179_392 VDD VSS sg13g2_decap_8
X_15236__3097 _15236_/RESET_B VDD VSS sg13g2_tiehi
XFILLER_22_582 VDD VSS sg13g2_decap_8
XFILLER_128_908 VDD VSS sg13g2_fill_1
X_10561_ _10653_/A _10561_/A _10561_/B _10561_/C _10561_/D VDD VSS sg13g2_nor4_1
X_12300_ _12300_/Y _12300_/A _13662_/Q VDD VSS sg13g2_xnor2_1
XFILLER_10_777 VDD VSS sg13g2_decap_8
X_13280_ _13281_/A _08831_/B _07752_/Y _13279_/Y VDD VSS sg13g2_a21oi_1
X_10492_ _10492_/Y _10508_/A _14850_/Q _10492_/C _10508_/C VDD VSS sg13g2_nand4_1
XFILLER_5_203 VDD VSS sg13g2_decap_8
XFILLER_154_226 VDD VSS sg13g2_decap_8
XFILLER_182_546 VDD VSS sg13g2_decap_8
X_12231_ _12231_/X _12231_/A _12231_/B VDD VSS sg13g2_xor2_1
XFILLER_107_142 VDD VSS sg13g2_decap_8
XFILLER_120_1174 VDD VSS sg13g2_decap_8
XFILLER_151_900 VDD VSS sg13g2_decap_8
XFILLER_151_911 VDD VSS sg13g2_decap_8
XFILLER_163_771 VDD VSS sg13g2_decap_8
XFILLER_30_63 VDD VSS sg13g2_decap_8
XFILLER_159_1373 VDD VSS sg13g2_decap_8
X_12162_ _12163_/A _13974_/Q _14006_/Q _14038_/Q _14070_/Q _12171_/S0 _12187_/C VDD
+ VSS sg13g2_mux4_1
XFILLER_2_910 VDD VSS sg13g2_decap_8
XFILLER_68_1267 VDD VSS sg13g2_fill_1
XFILLER_29_1218 VDD VSS sg13g2_decap_8
XFILLER_123_635 VDD VSS sg13g2_decap_8
XFILLER_150_432 VDD VSS sg13g2_decap_8
XFILLER_155_1248 VDD VSS sg13g2_decap_8
XFILLER_1_420 VDD VSS sg13g2_decap_8
X_11113_ _11113_/Y _14950_/Q _11113_/B VDD VSS sg13g2_nand2_1
XFILLER_81_1401 VDD VSS sg13g2_fill_2
XFILLER_111_819 VDD VSS sg13g2_decap_8
X_12093_ _12094_/A _13972_/Q _14004_/Q _14036_/Q _14068_/Q _12090_/A _12091_/C VDD
+ VSS sg13g2_mux4_1
XFILLER_110_307 VDD VSS sg13g2_decap_8
XFILLER_122_167 VDD VSS sg13g2_decap_8
XFILLER_2_987 VDD VSS sg13g2_decap_8
X_11044_ _11046_/A _11044_/A _11044_/B _11044_/C VDD VSS sg13g2_nand3_1
XFILLER_89_582 VDD VSS sg13g2_decap_8
XFILLER_77_722 VDD VSS sg13g2_decap_8
XFILLER_1_497 VDD VSS sg13g2_decap_8
XFILLER_7_1036 VDD VSS sg13g2_decap_8
X_14343__1929 _14343_/RESET_B VDD VSS sg13g2_tiehi
X_13729__2543 _13729_/RESET_B VDD VSS sg13g2_tiehi
X_14489__1783 _14489_/RESET_B VDD VSS sg13g2_tiehi
X_14803_ _14803_/Q _14864_/CLK _14803_/D _14803_/RESET_B VDD VSS sg13g2_dfrbpq_1
XFILLER_79_1330 VDD VSS sg13g2_decap_8
XFILLER_76_298 VDD VSS sg13g2_fill_1
XFILLER_36_129 VDD VSS sg13g2_decap_8
X_12995_ _13005_/A _13010_/A _13308_/A _12995_/C VDD VSS sg13g2_nand3_1
XFILLER_91_235 VDD VSS sg13g2_fill_1
XFILLER_29_181 VDD VSS sg13g2_decap_4
XFILLER_17_343 VDD VSS sg13g2_decap_8
X_14734_ _14734_/Q _14734_/CLK _14734_/D _14734_/RESET_B VDD VSS sg13g2_dfrbpq_1
X_11946_ _11946_/X _11946_/A _11964_/B VDD VSS sg13g2_and2_1
XFILLER_73_983 VDD VSS sg13g2_decap_8
XFILLER_166_1355 VDD VSS sg13g2_fill_1
XFILLER_75_1249 VDD VSS sg13g2_decap_8
XFILLER_127_1328 VDD VSS sg13g2_fill_1
X_14665_ _14665_/Q clkload35/A _14665_/D _14665_/RESET_B VDD VSS sg13g2_dfrbpq_1
XFILLER_162_1219 VDD VSS sg13g2_fill_2
X_14109__2163 _14109_/RESET_B VDD VSS sg13g2_tiehi
X_11877_ _11877_/Y _11896_/A _14574_/Q VDD VSS sg13g2_nand2b_1
XFILLER_33_869 VDD VSS sg13g2_decap_8
XFILLER_32_346 VDD VSS sg13g2_fill_1
XFILLER_177_329 VDD VSS sg13g2_decap_8
X_13616_ _13724_/D _13616_/A VDD VSS sg13g2_buf_1
Xclkbuf_5_16__f_clk_i clkbuf_5_16__f_clk_i/X clkbuf_4_8_0_clk_i/X VDD VSS sg13g2_buf_16
XFILLER_20_519 VDD VSS sg13g2_decap_4
X_10828_ _10831_/B _10851_/D _12347_/B VDD VSS sg13g2_nand2_1
XFILLER_13_560 VDD VSS sg13g2_decap_8
X_14596_ _14596_/Q clkload33/A _14596_/D _14596_/RESET_B VDD VSS sg13g2_dfrbpq_1
XFILLER_60_699 VDD VSS sg13g2_decap_8
X_13547_ _13547_/Y _13547_/A _13547_/B VDD VSS sg13g2_nor2_1
XFILLER_125_1074 VDD VSS sg13g2_decap_8
X_10759_ _10759_/X _14948_/Q _10757_/A _10757_/Y VDD VSS sg13g2_a21o_1
XFILLER_9_553 VDD VSS sg13g2_decap_8
XFILLER_158_587 VDD VSS sg13g2_decap_8
XFILLER_173_513 VDD VSS sg13g2_decap_8
XFILLER_12_1211 VDD VSS sg13g2_decap_8
XFILLER_51_1260 VDD VSS sg13g2_decap_8
XFILLER_16_1391 VDD VSS sg13g2_decap_8
X_13478_ _15113_/D _15179_/D _15113_/Q _13480_/S VDD VSS sg13g2_mux2_1
X_15217_ _15217_/Q _15219_/CLK _15217_/D _15217_/RESET_B VDD VSS sg13g2_dfrbpq_1
X_13977__2295 _13977_/RESET_B VDD VSS sg13g2_tiehi
X_12429_ _12429_/Y _13688_/Q _12442_/A2 _12428_/X _12386_/A _12443_/A2 VDD VSS sg13g2_a221oi_1
XFILLER_177_1440 VDD VSS sg13g2_decap_8
XFILLER_154_771 VDD VSS sg13g2_decap_8
XFILLER_86_1334 VDD VSS sg13g2_decap_8
XFILLER_127_996 VDD VSS sg13g2_decap_8
XFILLER_12_1288 VDD VSS sg13g2_decap_8
XFILLER_138_1424 VDD VSS sg13g2_fill_1
XFILLER_5_770 VDD VSS sg13g2_decap_8
X_15148_ _15148_/Q clkload78/A _15148_/D _15148_/RESET_B VDD VSS sg13g2_dfrbpq_1
XFILLER_113_123 VDD VSS sg13g2_decap_4
XFILLER_4_280 VDD VSS sg13g2_decap_8
X_07970_ _07976_/A _08697_/B _07834_/A _07981_/C VDD VSS sg13g2_o21ai_1
X_15079_ _15079_/Q clkload89/A _15079_/D _15079_/RESET_B VDD VSS sg13g2_dfrbpq_1
XFILLER_45_1020 VDD VSS sg13g2_decap_8
XFILLER_113_167 VDD VSS sg13g2_decap_4
XFILLER_110_830 VDD VSS sg13g2_decap_4
XFILLER_122_690 VDD VSS sg13g2_decap_4
XFILLER_68_766 VDD VSS sg13g2_decap_4
X_09640_ _09740_/B _09938_/C _09938_/B _09938_/A VDD VSS sg13g2_nand3b_1
XFILLER_67_254 VDD VSS sg13g2_decap_4
XFILLER_83_714 VDD VSS sg13g2_decap_8
XFILLER_55_405 VDD VSS sg13g2_decap_8
X_14319__1953 _14319_/RESET_B VDD VSS sg13g2_tiehi
XFILLER_27_107 VDD VSS sg13g2_decap_8
XFILLER_23_1351 VDD VSS sg13g2_decap_8
XFILLER_67_287 VDD VSS sg13g2_decap_8
X_09571_ _14169_/D _09637_/A0 _14169_/Q _09571_/S VDD VSS sg13g2_mux2_1
XFILLER_167_1108 VDD VSS sg13g2_decap_4
XFILLER_3_1456 VDD VSS sg13g2_decap_8
X_08522_ _08526_/B _08522_/A _08548_/B _08522_/C VDD VSS sg13g2_nand3_1
XFILLER_184_1411 VDD VSS sg13g2_fill_1
XFILLER_184_1422 VDD VSS sg13g2_decap_8
XFILLER_97_1474 VDD VSS sg13g2_fill_1
XFILLER_64_983 VDD VSS sg13g2_fill_1
XFILLER_24_814 VDD VSS sg13g2_decap_8
XFILLER_36_696 VDD VSS sg13g2_decap_8
XFILLER_145_1406 VDD VSS sg13g2_decap_8
X_08453_ _08454_/C _07805_/B _08456_/B _08001_/A VDD VSS sg13g2_a21oi_1
XFILLER_35_184 VDD VSS sg13g2_decap_4
XFILLER_50_143 VDD VSS sg13g2_decap_8
XFILLER_149_510 VDD VSS sg13g2_decap_8
X_08384_ _08385_/C _08457_/A3 _08383_/B _08001_/A VDD VSS sg13g2_a21oi_1
XFILLER_51_677 VDD VSS sg13g2_decap_4
XFILLER_177_830 VDD VSS sg13g2_decap_8
XFILLER_56_1171 VDD VSS sg13g2_decap_8
XFILLER_51_699 VDD VSS sg13g2_decap_8
XFILLER_52_1035 VDD VSS sg13g2_decap_8
XFILLER_149_565 VDD VSS sg13g2_decap_8
XFILLER_17_1166 VDD VSS sg13g2_decap_8
XFILLER_104_1125 VDD VSS sg13g2_decap_8
XFILLER_13_1008 VDD VSS sg13g2_decap_8
XFILLER_177_896 VDD VSS sg13g2_decap_8
XFILLER_137_738 VDD VSS sg13g2_decap_8
XFILLER_178_1237 VDD VSS sg13g2_fill_2
X_09005_ _09022_/D _09011_/B _09011_/C _09011_/D VDD VSS sg13g2_nor3_1
XFILLER_118_952 VDD VSS sg13g2_decap_8
XFILLER_164_579 VDD VSS sg13g2_decap_8
XFILLER_178_1259 VDD VSS sg13g2_decap_8
X_13807__2465 _13807_/RESET_B VDD VSS sg13g2_tiehi
XFILLER_3_707 VDD VSS sg13g2_decap_8
XFILLER_118_985 VDD VSS sg13g2_decap_8
XFILLER_145_760 VDD VSS sg13g2_decap_8
XFILLER_151_207 VDD VSS sg13g2_fill_2
XFILLER_118_996 VDD VSS sg13g2_fill_1
XFILLER_133_933 VDD VSS sg13g2_fill_1
XFILLER_2_217 VDD VSS sg13g2_decap_8
XFILLER_183_28 VDD VSS sg13g2_decap_8
XFILLER_104_112 VDD VSS sg13g2_decap_8
XFILLER_105_646 VDD VSS sg13g2_decap_8
XFILLER_105_679 VDD VSS sg13g2_decap_8
XFILLER_160_774 VDD VSS sg13g2_decap_8
Xfanout510 _09395_/S _09407_/S VDD VSS sg13g2_buf_1
Xfanout521 _09372_/S _09371_/S VDD VSS sg13g2_buf_1
XFILLER_8_1323 VDD VSS sg13g2_decap_8
Xfanout532 _10075_/A0 _08989_/X VDD VSS sg13g2_buf_1
X_09907_ _14492_/D _14492_/Q _09907_/A1 _09937_/S VDD VSS sg13g2_mux2_1
XFILLER_120_649 VDD VSS sg13g2_decap_8
Xfanout543 _08395_/A _08001_/Y VDD VSS sg13g2_buf_1
XFILLER_59_733 VDD VSS sg13g2_decap_8
XFILLER_24_1104 VDD VSS sg13g2_decap_8
Xfanout554 _13647_/S _07989_/Y VDD VSS sg13g2_buf_1
XFILLER_28_1284 VDD VSS sg13g2_decap_8
XFILLER_24_1115 VDD VSS sg13g2_fill_2
Xfanout565 fanout565/X _13508_/X VDD VSS sg13g2_buf_1
Xfanout576 _12266_/B1 _12223_/A VDD VSS sg13g2_buf_1
XFILLER_86_552 VDD VSS sg13g2_decap_4
Xfanout587 _09907_/A1 _10139_/A1 VDD VSS sg13g2_buf_1
X_09838_ _14426_/D _10169_/A1 _14426_/Q _09838_/S VDD VSS sg13g2_mux2_1
XFILLER_63_1197 VDD VSS sg13g2_decap_8
XFILLER_24_1148 VDD VSS sg13g2_decap_8
Xfanout598 _09024_/A _08999_/B1 VDD VSS sg13g2_buf_1
XFILLER_150_1167 VDD VSS sg13g2_decap_8
XFILLER_47_939 VDD VSS sg13g2_decap_4
XFILLER_132_21 VDD VSS sg13g2_decap_8
XFILLER_73_202 VDD VSS sg13g2_decap_8
XFILLER_46_427 VDD VSS sg13g2_decap_8
XFILLER_98_1238 VDD VSS sg13g2_decap_8
XFILLER_46_438 VDD VSS sg13g2_decap_8
X_09769_ _14359_/D _14359_/Q _09934_/A1 _09769_/S VDD VSS sg13g2_mux2_1
XFILLER_92_14 VDD VSS sg13g2_decap_8
XFILLER_132_76 VDD VSS sg13g2_decap_8
X_11800_ _11800_/Y _12056_/A _11800_/B VDD VSS sg13g2_xnor2_1
XFILLER_15_814 VDD VSS sg13g2_decap_8
X_12780_ _12780_/X _14138_/Q _14170_/Q _14202_/Q _14234_/Q _12783_/S0 _12783_/S1 VDD
+ VSS sg13g2_mux4_1
X_14951__2735 _14951_/RESET_B VDD VSS sg13g2_tiehi
XFILLER_26_151 VDD VSS sg13g2_decap_8
XFILLER_92_58 VDD VSS sg13g2_decap_8
XFILLER_54_471 VDD VSS sg13g2_decap_4
XFILLER_42_622 VDD VSS sg13g2_decap_8
X_11731_ _11731_/Y _11759_/A _14154_/Q _11970_/C VDD VSS sg13g2_a21oi_1
XFILLER_109_1025 VDD VSS sg13g2_decap_8
XFILLER_41_121 VDD VSS sg13g2_decap_8
XFILLER_109_1036 VDD VSS sg13g2_fill_1
XFILLER_25_63 VDD VSS sg13g2_decap_8
XFILLER_14_357 VDD VSS sg13g2_decap_8
XFILLER_42_666 VDD VSS sg13g2_decap_8
X_14450_ _14450_/Q _14610_/CLK _14450_/D _14450_/RESET_B VDD VSS sg13g2_dfrbpq_1
XFILLER_70_986 VDD VSS sg13g2_decap_8
XFILLER_35_1211 VDD VSS sg13g2_decap_8
X_11662_ _11664_/B _11663_/A _11663_/B _11773_/B VDD VSS sg13g2_a21oi_1
XFILLER_161_1230 VDD VSS sg13g2_fill_1
X_13401_ _13433_/A _13414_/A _13401_/B _13401_/C VDD VSS sg13g2_nand3b_1
X_10613_ _10625_/D _10613_/A _10614_/B VDD VSS sg13g2_nor2_1
XFILLER_41_198 VDD VSS sg13g2_decap_8
XFILLER_128_705 VDD VSS sg13g2_fill_2
XFILLER_167_340 VDD VSS sg13g2_decap_8
X_14381_ _14381_/Q _14733_/CLK _14381_/D _14381_/RESET_B VDD VSS sg13g2_dfrbpq_1
X_11593_ _11593_/Y _11636_/C _11593_/B VDD VSS sg13g2_xnor2_1
XFILLER_128_716 VDD VSS sg13g2_fill_2
XFILLER_155_502 VDD VSS sg13g2_decap_8
XFILLER_168_885 VDD VSS sg13g2_decap_8
XFILLER_167_373 VDD VSS sg13g2_decap_8
XFILLER_35_1288 VDD VSS sg13g2_fill_2
X_13332_ _15175_/D hold3114/X _15175_/Q _13477_/S VDD VSS sg13g2_mux2_1
X_10544_ _14863_/D _10544_/A _10544_/B _10544_/C VDD VSS sg13g2_and3_1
XFILLER_35_1299 VDD VSS sg13g2_fill_1
XFILLER_183_844 VDD VSS sg13g2_decap_4
XFILLER_109_930 VDD VSS sg13g2_decap_4
XFILLER_10_574 VDD VSS sg13g2_decap_8
XFILLER_109_941 VDD VSS sg13g2_decap_8
XFILLER_182_343 VDD VSS sg13g2_decap_8
XFILLER_108_440 VDD VSS sg13g2_decap_8
X_13263_ _13263_/Y _13260_/Y _13261_/Y _13262_/Y VDD VSS sg13g2_a21oi_1
X_10475_ _14846_/D _10486_/D _10492_/C _10474_/Y VDD VSS sg13g2_a21oi_1
XFILLER_124_900 VDD VSS sg13g2_decap_8
XFILLER_6_567 VDD VSS sg13g2_decap_8
XFILLER_124_911 VDD VSS sg13g2_fill_1
XFILLER_142_207 VDD VSS sg13g2_decap_8
XFILLER_157_84 VDD VSS sg13g2_decap_8
X_15002_ _15002_/Q _15019_/CLK _15002_/D _15002_/RESET_B VDD VSS sg13g2_dfrbpq_1
X_12214_ _12214_/Y _12213_/X _12219_/S VDD VSS sg13g2_nand2b_1
XFILLER_170_549 VDD VSS sg13g2_decap_8
X_13194_ _13196_/B _14856_/Q _13218_/B VDD VSS sg13g2_nand2_1
XFILLER_124_944 VDD VSS sg13g2_decap_8
XFILLER_68_1064 VDD VSS sg13g2_decap_4
XFILLER_29_1015 VDD VSS sg13g2_decap_8
XFILLER_123_432 VDD VSS sg13g2_fill_1
XFILLER_29_1026 VDD VSS sg13g2_fill_1
XFILLER_124_977 VDD VSS sg13g2_decap_8
XFILLER_155_1034 VDD VSS sg13g2_decap_4
X_12145_ _12145_/Y _11654_/S _12141_/X _12144_/Y VDD VSS sg13g2_o21ai_1
XFILLER_123_454 VDD VSS sg13g2_decap_4
XFILLER_124_988 VDD VSS sg13g2_fill_2
XFILLER_116_1007 VDD VSS sg13g2_decap_4
XFILLER_2_784 VDD VSS sg13g2_decap_8
X_12076_ _12076_/X _12073_/X _12072_/X _12069_/X _12068_/X _12188_/C _11559_/C VDD
+ VSS sg13g2_mux4_1
XFILLER_46_1362 VDD VSS sg13g2_decap_8
XFILLER_42_1204 VDD VSS sg13g2_fill_1
XFILLER_133_1332 VDD VSS sg13g2_fill_1
XFILLER_1_294 VDD VSS sg13g2_decap_8
X_14612__1660 _14612_/RESET_B VDD VSS sg13g2_tiehi
XFILLER_77_541 VDD VSS sg13g2_decap_8
X_11027_ _11027_/Y _11052_/D _11052_/A _11027_/B1 VDD VSS sg13g2_a21oi_1
XFILLER_2_56 VDD VSS sg13g2_decap_8
XFILLER_133_1365 VDD VSS sg13g2_decap_8
X_16884_ _16884_/X _16884_/A VDD VSS sg13g2_buf_1
XFILLER_81_1297 VDD VSS sg13g2_decap_4
XFILLER_65_725 VDD VSS sg13g2_decap_8
XFILLER_65_736 VDD VSS sg13g2_fill_1
XFILLER_64_224 VDD VSS sg13g2_decap_8
XFILLER_168_1439 VDD VSS sg13g2_decap_8
XFILLER_17_140 VDD VSS sg13g2_decap_8
X_12978_ _12978_/Y _14778_/Q _13236_/A2 _13236_/B1 VDD VSS sg13g2_o21ai_1
XFILLER_45_460 VDD VSS sg13g2_fill_2
XFILLER_75_1024 VDD VSS sg13g2_decap_8
X_14717_ _14717_/Q clkload58/A _14717_/D _14717_/RESET_B VDD VSS sg13g2_dfrbpq_1
X_11929_ _11929_/Y _12001_/A _11929_/B VDD VSS sg13g2_nor2_1
XFILLER_45_493 VDD VSS sg13g2_decap_8
XFILLER_32_121 VDD VSS sg13g2_decap_8
XFILLER_166_1174 VDD VSS sg13g2_decap_8
XFILLER_178_616 VDD VSS sg13g2_decap_8
XFILLER_61_964 VDD VSS sg13g2_decap_8
XFILLER_127_1136 VDD VSS sg13g2_fill_1
XFILLER_162_1016 VDD VSS sg13g2_decap_8
XFILLER_21_806 VDD VSS sg13g2_decap_8
XFILLER_127_1147 VDD VSS sg13g2_decap_8
XFILLER_53_1300 VDD VSS sg13g2_decap_8
X_14648_ _14648_/Q _14982_/CLK _14648_/D _14648_/RESET_B VDD VSS sg13g2_dfrbpq_1
XFILLER_162_1049 VDD VSS sg13g2_fill_2
XFILLER_177_126 VDD VSS sg13g2_decap_8
XFILLER_60_474 VDD VSS sg13g2_decap_8
XFILLER_32_165 VDD VSS sg13g2_decap_8
XANTENNA_17 wire439/X VDD VSS sg13g2_antennanp
XFILLER_92_1382 VDD VSS sg13g2_decap_8
XFILLER_53_1333 VDD VSS sg13g2_decap_8
XANTENNA_28 fanout1507/X VDD VSS sg13g2_antennanp
XFILLER_105_1434 VDD VSS sg13g2_fill_1
XFILLER_158_351 VDD VSS sg13g2_decap_8
XFILLER_186_660 VDD VSS sg13g2_decap_8
X_14579_ _14579_/Q clkload31/A _14579_/D _14579_/RESET_B VDD VSS sg13g2_dfrbpq_1
XFILLER_140_1325 VDD VSS sg13g2_fill_1
XFILLER_186_671 VDD VSS sg13g2_decap_8
XFILLER_9_350 VDD VSS sg13g2_decap_8
XFILLER_88_1418 VDD VSS sg13g2_decap_8
XFILLER_134_708 VDD VSS sg13g2_decap_4
XFILLER_174_888 VDD VSS sg13g2_decap_4
XFILLER_173_387 VDD VSS sg13g2_decap_8
Xoutput102 mem_axi_bready _07661_/Y VDD VSS sg13g2_buf_1
XFILLER_86_1131 VDD VSS sg13g2_decap_8
XFILLER_12_1085 VDD VSS sg13g2_decap_8
Xoutput113 mem_axi_wdata[18] _15150_/Q VDD VSS sg13g2_buf_1
XFILLER_56_0 VDD VSS sg13g2_decap_8
Xoutput124 mem_axi_wdata[28] _15160_/Q VDD VSS sg13g2_buf_1
XFILLER_115_944 VDD VSS sg13g2_fill_2
XFILLER_47_1104 VDD VSS sg13g2_decap_4
Xoutput135 mem_axi_wdata[9] _15141_/Q VDD VSS sg13g2_buf_1
XFILLER_114_443 VDD VSS sg13g2_decap_8
XFILLER_138_1254 VDD VSS sg13g2_decap_8
XFILLER_86_1197 VDD VSS sg13g2_decap_8
XFILLER_130_936 VDD VSS sg13g2_decap_8
XFILLER_101_104 VDD VSS sg13g2_decap_8
XFILLER_141_273 VDD VSS sg13g2_decap_8
XFILLER_173_1178 VDD VSS sg13g2_decap_8
XFILLER_102_638 VDD VSS sg13g2_decap_8
XFILLER_25_1413 VDD VSS sg13g2_decap_8
XFILLER_102_649 VDD VSS sg13g2_fill_1
X_07953_ _07954_/C _07818_/Y _07952_/Y _07951_/Y VDD VSS sg13g2_a21oi_1
XFILLER_130_969 VDD VSS sg13g2_decap_8
XFILLER_151_1432 VDD VSS sg13g2_decap_8
XFILLER_151_1443 VDD VSS sg13g2_fill_2
XFILLER_60_1326 VDD VSS sg13g2_fill_1
XFILLER_112_1405 VDD VSS sg13g2_fill_2
X_15235__3096 _15235_/RESET_B VDD VSS sg13g2_tiehi
X_07884_ _07884_/Y _07884_/A _08063_/B VDD VSS sg13g2_xnor2_1
XFILLER_110_660 VDD VSS sg13g2_decap_4
XFILLER_29_939 VDD VSS sg13g2_decap_8
X_15138__2774 _15138_/RESET_B VDD VSS sg13g2_tiehi
XFILLER_60_1359 VDD VSS sg13g2_fill_2
XFILLER_56_725 VDD VSS sg13g2_fill_1
XFILLER_28_416 VDD VSS sg13g2_decap_8
X_09623_ _14219_/D _09724_/A0 _14219_/Q _09630_/S VDD VSS sg13g2_mux2_1
XFILLER_95_393 VDD VSS sg13g2_decap_8
XFILLER_3_1253 VDD VSS sg13g2_decap_8
XFILLER_110_1140 VDD VSS sg13g2_decap_4
X_09554_ _14152_/D _09620_/A0 _14152_/Q _09563_/S VDD VSS sg13g2_mux2_1
XFILLER_83_588 VDD VSS sg13g2_decap_8
XFILLER_37_994 VDD VSS sg13g2_fill_1
XFILLER_97_1282 VDD VSS sg13g2_decap_8
X_08505_ _08505_/Y _07822_/A _08495_/Y _08504_/Y VDD VSS sg13g2_o21ai_1
XFILLER_93_1124 VDD VSS sg13g2_decap_8
XFILLER_58_1244 VDD VSS sg13g2_decap_4
XFILLER_52_931 VDD VSS sg13g2_fill_1
XFILLER_36_482 VDD VSS sg13g2_decap_8
XFILLER_149_1372 VDD VSS sg13g2_decap_8
XFILLER_19_1217 VDD VSS sg13g2_decap_8
X_09485_ _14085_/D _09949_/A1 _14085_/Q _09497_/S VDD VSS sg13g2_mux2_1
XFILLER_102_79 VDD VSS sg13g2_fill_2
XFILLER_24_655 VDD VSS sg13g2_fill_2
XFILLER_180_1127 VDD VSS sg13g2_decap_4
X_14050__2222 _14050_/RESET_B VDD VSS sg13g2_tiehi
X_08436_ _08436_/Y _08421_/Y _08436_/B VDD VSS sg13g2_nand2b_1
XFILLER_58_1299 VDD VSS sg13g2_decap_4
XFILLER_23_154 VDD VSS sg13g2_decap_8
XFILLER_145_1258 VDD VSS sg13g2_decap_8
XFILLER_168_126 VDD VSS sg13g2_decap_8
XFILLER_178_28 VDD VSS sg13g2_decap_8
XFILLER_145_1269 VDD VSS sg13g2_fill_2
XFILLER_184_608 VDD VSS sg13g2_decap_8
X_08367_ _08367_/Y _08411_/A _08411_/C _08366_/X VDD VSS sg13g2_o21ai_1
XFILLER_134_7 VDD VSS sg13g2_decap_8
XFILLER_32_1406 VDD VSS sg13g2_decap_4
XFILLER_32_1428 VDD VSS sg13g2_fill_2
XFILLER_20_861 VDD VSS sg13g2_decap_8
X_14654__1618 _14654_/RESET_B VDD VSS sg13g2_tiehi
X_08298_ _08298_/Y _08318_/C _08297_/Y _08000_/X VDD VSS sg13g2_o21ai_1
XFILLER_109_237 VDD VSS sg13g2_decap_8
XFILLER_30_1130 VDD VSS sg13g2_decap_4
XFILLER_11_21 VDD VSS sg13g2_decap_8
XFILLER_165_877 VDD VSS sg13g2_fill_2
XFILLER_180_803 VDD VSS sg13g2_decap_8
XFILLER_178_1067 VDD VSS sg13g2_decap_8
XFILLER_3_504 VDD VSS sg13g2_decap_8
XFILLER_30_1163 VDD VSS sg13g2_decap_8
XFILLER_127_21 VDD VSS sg13g2_decap_8
X_14083__2189 _14083_/RESET_B VDD VSS sg13g2_tiehi
X_10260_ _14781_/D _10265_/A _10265_/D _10259_/Y VDD VSS sg13g2_a21oi_1
XFILLER_106_944 VDD VSS sg13g2_decap_8
XFILLER_105_443 VDD VSS sg13g2_decap_8
XFILLER_11_98 VDD VSS sg13g2_decap_8
XFILLER_87_14 VDD VSS sg13g2_fill_2
X_10191_ _15196_/D hold3157/X _15196_/Q _13479_/S VDD VSS sg13g2_mux2_1
XFILLER_121_925 VDD VSS sg13g2_fill_2
XFILLER_133_785 VDD VSS sg13g2_decap_8
XFILLER_152_1207 VDD VSS sg13g2_decap_8
XFILLER_160_571 VDD VSS sg13g2_decap_8
XFILLER_156_1387 VDD VSS sg13g2_fill_1
Xfanout1305 _13129_/B _13672_/Q VDD VSS sg13g2_buf_1
XFILLER_87_58 VDD VSS sg13g2_decap_8
XFILLER_120_424 VDD VSS sg13g2_fill_2
XFILLER_132_284 VDD VSS sg13g2_decap_8
Xfanout1316 _12191_/B1 _12221_/B1 VDD VSS sg13g2_buf_1
X_15022__2658 _15022_/RESET_B VDD VSS sg13g2_tiehi
XFILLER_8_1120 VDD VSS sg13g2_decap_8
Xfanout1327 _12265_/A2 _11450_/A1 VDD VSS sg13g2_buf_1
Xfanout340 _09952_/S _09970_/S VDD VSS sg13g2_buf_1
Xfanout1338 _11952_/C _11850_/S1 VDD VSS sg13g2_buf_1
Xfanout351 _09935_/S _09921_/S VDD VSS sg13g2_buf_1
Xfanout1349 _11760_/C fanout1350/X VDD VSS sg13g2_buf_1
XFILLER_28_1081 VDD VSS sg13g2_decap_8
X_13950_ _13950_/Q clkload48/A _13950_/D _13950_/RESET_B VDD VSS sg13g2_dfrbpq_1
Xfanout373 _09733_/S _09727_/S VDD VSS sg13g2_buf_1
Xfanout384 _09637_/S _09636_/S VDD VSS sg13g2_buf_1
XFILLER_59_585 VDD VSS sg13g2_decap_8
Xfanout395 _09337_/S _09333_/S VDD VSS sg13g2_buf_1
XFILLER_98_1013 VDD VSS sg13g2_decap_4
XFILLER_8_1197 VDD VSS sg13g2_decap_8
XFILLER_115_1084 VDD VSS sg13g2_decap_4
X_12901_ _12902_/A input32/X _12841_/B _12803_/X input9/X VDD VSS sg13g2_a22oi_1
XFILLER_46_213 VDD VSS sg13g2_decap_8
XFILLER_19_438 VDD VSS sg13g2_decap_8
X_13881_ _13881_/Q _14745_/CLK _13881_/D _13881_/RESET_B VDD VSS sg13g2_dfrbpq_1
XFILLER_185_1027 VDD VSS sg13g2_fill_2
X_12832_ _12832_/Y _12829_/Y _12830_/Y _12831_/Y VDD VSS sg13g2_a21oi_1
XFILLER_74_588 VDD VSS sg13g2_decap_8
XFILLER_62_728 VDD VSS sg13g2_decap_4
XFILLER_160_0 VDD VSS sg13g2_decap_8
XFILLER_15_644 VDD VSS sg13g2_decap_8
X_12763_ _12764_/B _13664_/Q _12791_/A2 _12762_/X _12763_/B2 _12763_/C1 VDD VSS sg13g2_a221oi_1
XFILLER_163_1314 VDD VSS sg13g2_fill_2
XFILLER_37_1328 VDD VSS sg13g2_decap_4
XFILLER_128_1445 VDD VSS sg13g2_fill_1
X_14502_ _14502_/Q clkload20/A _14502_/D _14502_/RESET_B VDD VSS sg13g2_dfrbpq_1
XFILLER_14_154 VDD VSS sg13g2_decap_8
X_11714_ _11714_/X _14377_/Q _14409_/Q _14473_/Q _14505_/Q _12284_/S0 _12284_/S1 VDD
+ VSS sg13g2_mux4_1
XFILLER_76_1388 VDD VSS sg13g2_decap_8
X_12694_ _15013_/D _12694_/A _12694_/B VDD VSS sg13g2_nor2_1
XFILLER_70_783 VDD VSS sg13g2_fill_2
XFILLER_30_625 VDD VSS sg13g2_decap_8
X_14293__1979 _14293_/RESET_B VDD VSS sg13g2_tiehi
X_14433_ _14433_/Q clkload38/A _14433_/D _14433_/RESET_B VDD VSS sg13g2_dfrbpq_1
X_11645_ _11645_/X _13831_/Q _13863_/Q _13895_/Q _13927_/Q _11528_/S _11532_/C VDD
+ VSS sg13g2_mux4_1
XFILLER_11_861 VDD VSS sg13g2_decap_8
XFILLER_128_513 VDD VSS sg13g2_decap_8
XFILLER_35_1085 VDD VSS sg13g2_decap_8
XFILLER_156_844 VDD VSS sg13g2_decap_8
X_14364_ _14364_/Q _14716_/CLK _14364_/D _14364_/RESET_B VDD VSS sg13g2_dfrbpq_1
Xinput15 input15/X input15/A VDD VSS sg13g2_buf_1
Xinput26 input26/X input26/A VDD VSS sg13g2_buf_1
X_11576_ _11576_/X _14693_/Q _14725_/Q _13765_/Q _13797_/Q _11996_/S0 _11996_/S1 VDD
+ VSS sg13g2_mux4_1
XFILLER_10_371 VDD VSS sg13g2_decap_8
XFILLER_155_332 VDD VSS sg13g2_decap_4
Xinput37 input37/X input37/A VDD VSS sg13g2_buf_1
XFILLER_122_1066 VDD VSS sg13g2_decap_8
XFILLER_7_854 VDD VSS sg13g2_decap_8
XFILLER_156_877 VDD VSS sg13g2_decap_8
XFILLER_183_663 VDD VSS sg13g2_decap_8
X_13315_ _15061_/D _15079_/Q _07694_/Y _13314_/X VDD VSS sg13g2_a21o_1
XFILLER_116_719 VDD VSS sg13g2_decap_8
XFILLER_122_1088 VDD VSS sg13g2_decap_8
XFILLER_182_140 VDD VSS sg13g2_decap_8
Xclkbuf_leaf_4_clk_i clkload14/A clkbuf_leaf_4_clk_i/A VDD VSS sg13g2_buf_8
X_10527_ _10529_/A _10558_/C _10531_/D _10558_/B VDD VSS sg13g2_a21o_1
XFILLER_13_1372 VDD VSS sg13g2_decap_8
X_14295_ _14295_/Q clkload42/A _14295_/D _14295_/RESET_B VDD VSS sg13g2_dfrbpq_1
XFILLER_155_376 VDD VSS sg13g2_decap_8
XFILLER_171_825 VDD VSS sg13g2_fill_1
XFILLER_6_364 VDD VSS sg13g2_decap_8
XFILLER_109_782 VDD VSS sg13g2_decap_8
XFILLER_87_1440 VDD VSS sg13g2_fill_2
XFILLER_108_270 VDD VSS sg13g2_decap_8
X_13246_ _13247_/C _14922_/Q _13665_/Q _13246_/C VDD VSS sg13g2_nand3_1
X_10458_ _10512_/A _14842_/Q _14841_/Q _14840_/Q _14839_/Q VDD VSS sg13g2_nand4_1
XFILLER_108_281 VDD VSS sg13g2_fill_2
XFILLER_174_1421 VDD VSS sg13g2_decap_8
X_13177_ _13177_/X _13225_/A _13188_/A VDD VSS sg13g2_xor2_1
X_10389_ _14820_/D _10378_/D _10387_/X _10388_/Y VDD VSS sg13g2_a21oi_1
XFILLER_123_273 VDD VSS sg13g2_fill_2
XFILLER_135_1449 VDD VSS sg13g2_fill_1
XFILLER_170_1329 VDD VSS sg13g2_decap_8
X_12128_ _12198_/B _12128_/A _13667_/Q VDD VSS sg13g2_xnor2_1
XFILLER_2_581 VDD VSS sg13g2_decap_8
XFILLER_96_135 VDD VSS sg13g2_decap_8
X_12059_ _12062_/B _12054_/Y _11986_/Y _11913_/A _12056_/C _12058_/Y VDD VSS sg13g2_a221oi_1
XFILLER_77_91 VDD VSS sg13g2_decap_8
X_15073__2950 _15073_/RESET_B VDD VSS sg13g2_tiehi
XFILLER_77_382 VDD VSS sg13g2_fill_1
XFILLER_42_1067 VDD VSS sg13g2_decap_8
X_14807__2999 _14807_/RESET_B VDD VSS sg13g2_tiehi
X_16867_ _16867_/X _16867_/A VDD VSS sg13g2_buf_1
XFILLER_38_758 VDD VSS sg13g2_decap_8
XFILLER_168_1225 VDD VSS sg13g2_decap_8
XFILLER_53_706 VDD VSS sg13g2_decap_8
XFILLER_20_1343 VDD VSS sg13g2_decap_8
Xclkbuf_5_31__f_clk_i clkbuf_leaf_68_clk_i/A clkbuf_4_15_0_clk_i/X VDD VSS sg13g2_buf_16
XFILLER_0_1415 VDD VSS sg13g2_decap_8
XFILLER_179_903 VDD VSS sg13g2_decap_8
XFILLER_52_238 VDD VSS sg13g2_decap_8
XFILLER_34_953 VDD VSS sg13g2_decap_8
XFILLER_94_1466 VDD VSS sg13g2_decap_8
XFILLER_80_569 VDD VSS sg13g2_decap_8
XFILLER_178_413 VDD VSS sg13g2_decap_8
X_09270_ _13879_/D _13879_/Q _10166_/A1 _09271_/S VDD VSS sg13g2_mux2_1
XFILLER_181_1469 VDD VSS sg13g2_decap_4
X_08221_ _08221_/Y _08220_/X _08221_/A2 _08319_/A VDD VSS sg13g2_a21oi_1
XFILLER_147_822 VDD VSS sg13g2_decap_8
XFILLER_18_1283 VDD VSS sg13g2_decap_8
XFILLER_105_1242 VDD VSS sg13g2_decap_8
XFILLER_119_524 VDD VSS sg13g2_decap_8
XFILLER_165_129 VDD VSS sg13g2_decap_8
X_08152_ _08152_/Y _08402_/A _08402_/B _08103_/B VDD VSS sg13g2_o21ai_1
XFILLER_20_168 VDD VSS sg13g2_decap_8
XFILLER_119_557 VDD VSS sg13g2_decap_4
XFILLER_105_1286 VDD VSS sg13g2_decap_8
XFILLER_147_877 VDD VSS sg13g2_decap_8
XFILLER_14_1169 VDD VSS sg13g2_decap_8
XFILLER_179_1343 VDD VSS sg13g2_decap_8
XFILLER_88_1226 VDD VSS sg13g2_decap_8
XFILLER_101_1128 VDD VSS sg13g2_decap_8
XFILLER_173_140 VDD VSS sg13g2_decap_8
X_08083_ _08086_/B _08456_/B _08470_/B _07820_/B _08119_/A2 _08046_/B _08278_/S1 VDD
+ VSS sg13g2_mux4_1
XFILLER_88_1237 VDD VSS sg13g2_fill_2
XFILLER_147_888 VDD VSS sg13g2_fill_1
XFILLER_174_674 VDD VSS sg13g2_decap_8
XFILLER_134_516 VDD VSS sg13g2_decap_8
XFILLER_140_1199 VDD VSS sg13g2_decap_8
XFILLER_146_376 VDD VSS sg13g2_decap_4
XFILLER_179_1365 VDD VSS sg13g2_decap_8
XFILLER_162_836 VDD VSS sg13g2_decap_4
XFILLER_146_398 VDD VSS sg13g2_decap_8
XFILLER_115_752 VDD VSS sg13g2_fill_1
XFILLER_130_700 VDD VSS sg13g2_fill_2
XFILLER_161_379 VDD VSS sg13g2_decap_8
XFILLER_0_518 VDD VSS sg13g2_decap_8
XFILLER_88_625 VDD VSS sg13g2_decap_8
XFILLER_138_1084 VDD VSS sg13g2_fill_1
X_08985_ _08985_/X _15025_/Q _15222_/Q _09009_/S VDD VSS sg13g2_mux2_1
XFILLER_25_1210 VDD VSS sg13g2_decap_8
XFILLER_69_850 VDD VSS sg13g2_decap_8
XFILLER_60_1101 VDD VSS sg13g2_fill_1
XFILLER_60_1112 VDD VSS sg13g2_fill_2
X_14068__2204 _14068_/RESET_B VDD VSS sg13g2_tiehi
XFILLER_75_308 VDD VSS sg13g2_decap_8
X_07936_ _07936_/Y _15003_/Q _07790_/A VDD VSS sg13g2_nor2b_1
XFILLER_68_360 VDD VSS sg13g2_fill_1
XFILLER_69_894 VDD VSS sg13g2_decap_4
XFILLER_5_1337 VDD VSS sg13g2_decap_8
XFILLER_151_1273 VDD VSS sg13g2_decap_8
XFILLER_151_1284 VDD VSS sg13g2_fill_1
XFILLER_96_691 VDD VSS sg13g2_decap_8
XFILLER_25_1287 VDD VSS sg13g2_decap_8
X_07867_ _07905_/D _07969_/A _08678_/A _08650_/A _07867_/D VDD VSS sg13g2_or4_1
XFILLER_83_330 VDD VSS sg13g2_decap_8
X_09606_ _09606_/Y _10070_/A _10070_/B _09606_/C VDD VSS sg13g2_nand3_1
XFILLER_3_1050 VDD VSS sg13g2_decap_8
XFILLER_44_728 VDD VSS sg13g2_decap_8
XFILLER_71_514 VDD VSS sg13g2_decap_8
X_14708__1564 _14708_/RESET_B VDD VSS sg13g2_tiehi
X_07798_ _07798_/X _15006_/Q _07945_/B VDD VSS sg13g2_or2_1
XFILLER_25_920 VDD VSS sg13g2_decap_8
X_09537_ _14136_/D _09770_/A1 _14136_/Q _09537_/S VDD VSS sg13g2_mux2_1
XFILLER_25_975 VDD VSS sg13g2_decap_8
X_09468_ _14069_/D _09998_/A0 _14069_/Q _09472_/S VDD VSS sg13g2_mux2_1
XFILLER_40_923 VDD VSS sg13g2_decap_8
XFILLER_52_794 VDD VSS sg13g2_decap_8
XFILLER_51_260 VDD VSS sg13g2_decap_8
XFILLER_145_1055 VDD VSS sg13g2_decap_8
XFILLER_106_1028 VDD VSS sg13g2_decap_8
X_08419_ _08419_/Y _08419_/A VDD VSS sg13g2_inv_1
XFILLER_12_658 VDD VSS sg13g2_decap_8
XFILLER_71_1241 VDD VSS sg13g2_decap_8
X_09399_ _14002_/D _09597_/A1 _14002_/Q _09399_/S VDD VSS sg13g2_mux2_1
XFILLER_184_427 VDD VSS sg13g2_decap_8
XFILLER_11_168 VDD VSS sg13g2_decap_8
XFILLER_138_833 VDD VSS sg13g2_decap_8
X_11430_ _11430_/Y _11430_/A _11430_/B VDD VSS sg13g2_xnor2_1
XFILLER_71_1285 VDD VSS sg13g2_decap_8
XFILLER_177_490 VDD VSS sg13g2_decap_8
XFILLER_22_42 VDD VSS sg13g2_decap_8
XFILLER_138_877 VDD VSS sg13g2_decap_8
XFILLER_153_803 VDD VSS sg13g2_decap_8
X_11361_ _11361_/Y _11832_/C _11361_/B VDD VSS sg13g2_nand2b_1
XFILLER_123_1397 VDD VSS sg13g2_fill_1
XFILLER_165_685 VDD VSS sg13g2_decap_8
X_13100_ _15039_/D _13093_/Y _13099_/Y _13155_/A VDD VSS sg13g2_a21oi_1
X_10312_ _14797_/D _10577_/B _10312_/B _10342_/C VDD VSS sg13g2_nor3_1
XFILLER_3_301 VDD VSS sg13g2_decap_8
XFILLER_98_35 VDD VSS sg13g2_decap_8
XFILLER_180_644 VDD VSS sg13g2_decap_8
X_14080_ _14080_/Q _14656_/CLK _14080_/D _14080_/RESET_B VDD VSS sg13g2_dfrbpq_1
X_11292_ _11292_/Y _11292_/A _11292_/B VDD VSS sg13g2_xnor2_1
XFILLER_118_590 VDD VSS sg13g2_fill_2
XFILLER_180_655 VDD VSS sg13g2_fill_1
XFILLER_4_868 VDD VSS sg13g2_decap_8
X_13031_ _13031_/Y _13028_/Y _13029_/Y _13030_/Y VDD VSS sg13g2_a21oi_1
X_10243_ _10245_/C _14775_/Q _10247_/D _14776_/Q VDD VSS sg13g2_a21oi_1
XFILLER_105_240 VDD VSS sg13g2_decap_8
XFILLER_140_519 VDD VSS sg13g2_decap_8
XFILLER_65_1023 VDD VSS sg13g2_decap_8
XFILLER_117_1113 VDD VSS sg13g2_decap_8
XFILLER_3_378 VDD VSS sg13g2_decap_8
XFILLER_121_722 VDD VSS sg13g2_decap_8
XFILLER_65_1056 VDD VSS sg13g2_decap_8
Xfanout1102 _08201_/A _08035_/A VDD VSS sg13g2_buf_1
X_10174_ _10174_/Y _15055_/Q _15054_/Q _13613_/C VDD VSS sg13g2_nor3_1
Xfanout1113 _13529_/A _08460_/A1 VDD VSS sg13g2_buf_1
Xfanout1124 _13525_/A _14991_/Q VDD VSS sg13g2_buf_1
XFILLER_79_669 VDD VSS sg13g2_decap_8
XFILLER_67_809 VDD VSS sg13g2_fill_2
XFILLER_117_1168 VDD VSS sg13g2_decap_8
Xfanout1135 _08300_/S1 _13521_/A VDD VSS sg13g2_buf_1
XFILLER_152_1059 VDD VSS sg13g2_decap_8
XFILLER_82_1381 VDD VSS sg13g2_decap_8
XFILLER_121_788 VDD VSS sg13g2_decap_8
Xfanout1146 _08253_/S0 _07900_/B VDD VSS sg13g2_buf_1
X_14982_ _14982_/Q _14982_/CLK _14982_/D _14982_/RESET_B VDD VSS sg13g2_dfrbpq_1
Xfanout1157 _07972_/B _14985_/Q VDD VSS sg13g2_buf_1
XFILLER_93_105 VDD VSS sg13g2_decap_8
XFILLER_78_179 VDD VSS sg13g2_decap_8
XFILLER_66_319 VDD VSS sg13g2_decap_8
Xfanout170 _10164_/A1 _09899_/A0 VDD VSS sg13g2_buf_1
Xfanout1168 _12061_/A _14981_/Q VDD VSS sg13g2_buf_1
XFILLER_130_1313 VDD VSS sg13g2_decap_8
Xfanout181 _09930_/A1 _09118_/Y VDD VSS sg13g2_buf_1
Xfanout1179 _07820_/B _08510_/A1 VDD VSS sg13g2_buf_1
XFILLER_19_224 VDD VSS sg13g2_decap_8
X_13933_ _13933_/Q _14733_/CLK _13933_/D _13933_/RESET_B VDD VSS sg13g2_dfrbpq_1
XFILLER_75_842 VDD VSS sg13g2_decap_8
XFILLER_35_706 VDD VSS sg13g2_decap_8
XFILLER_74_363 VDD VSS sg13g2_decap_8
X_13864_ _13864_/Q _14664_/CLK _13864_/D _13864_/RESET_B VDD VSS sg13g2_dfrbpq_1
XFILLER_34_205 VDD VSS sg13g2_decap_8
XFILLER_170_84 VDD VSS sg13g2_decap_8
XFILLER_16_931 VDD VSS sg13g2_decap_8
X_12815_ _12815_/Y input15/X _12841_/B _12803_/X input35/X _12813_/X VDD VSS sg13g2_a221oi_1
XFILLER_62_558 VDD VSS sg13g2_decap_8
X_13795_ _13795_/Q clkload30/A _13795_/D _13795_/RESET_B VDD VSS sg13g2_dfrbpq_1
XFILLER_50_709 VDD VSS sg13g2_decap_8
XFILLER_15_441 VDD VSS sg13g2_decap_8
X_13766__2506 _13766_/RESET_B VDD VSS sg13g2_tiehi
XFILLER_128_1242 VDD VSS sg13g2_fill_2
XFILLER_163_1122 VDD VSS sg13g2_decap_4
XFILLER_163_1133 VDD VSS sg13g2_decap_8
X_12746_ _12746_/X _12739_/X _12743_/X _12738_/X _12742_/X _12747_/S0 _12747_/S1 VDD
+ VSS sg13g2_mux4_1
XFILLER_37_1136 VDD VSS sg13g2_decap_8
XFILLER_76_1196 VDD VSS sg13g2_decap_8
X_13802__2470 _13802_/RESET_B VDD VSS sg13g2_tiehi
XFILLER_97_7 VDD VSS sg13g2_decap_8
XFILLER_163_1166 VDD VSS sg13g2_decap_8
XFILLER_37_1169 VDD VSS sg13g2_decap_8
XFILLER_128_1297 VDD VSS sg13g2_decap_8
XFILLER_129_800 VDD VSS sg13g2_fill_1
XFILLER_42_293 VDD VSS sg13g2_decap_4
X_12677_ _12677_/X _12675_/X _12674_/X _12668_/X _12669_/X wire853/X _12636_/S VDD
+ VSS sg13g2_mux4_1
XFILLER_30_455 VDD VSS sg13g2_decap_8
X_14416_ _14416_/Q clkload19/A _14416_/D _14416_/RESET_B VDD VSS sg13g2_dfrbpq_1
XFILLER_15_1445 VDD VSS sg13g2_decap_8
X_11628_ _11628_/Y _11626_/Y _11627_/Y _12001_/A VDD VSS sg13g2_a21oi_1
X_15234__3095 _15234_/RESET_B VDD VSS sg13g2_tiehi
XFILLER_102_1415 VDD VSS sg13g2_decap_8
XFILLER_156_641 VDD VSS sg13g2_decap_4
XFILLER_8_77 VDD VSS sg13g2_decap_8
XFILLER_11_1309 VDD VSS sg13g2_decap_8
XFILLER_128_354 VDD VSS sg13g2_decap_8
X_14146__2126 _14146_/RESET_B VDD VSS sg13g2_tiehi
X_14347_ _14347_/Q clkload11/A _14347_/D _14347_/RESET_B VDD VSS sg13g2_dfrbpq_1
XFILLER_7_651 VDD VSS sg13g2_decap_8
X_11559_ _11559_/Y _11557_/Y _11559_/B _11559_/C VDD VSS sg13g2_nand3b_1
XFILLER_156_685 VDD VSS sg13g2_decap_8
XFILLER_6_161 VDD VSS sg13g2_decap_8
XFILLER_116_549 VDD VSS sg13g2_decap_8
X_14278_ _14278_/Q _14662_/CLK _14278_/D _14278_/RESET_B VDD VSS sg13g2_dfrbpq_1
XFILLER_48_1232 VDD VSS sg13g2_fill_1
X_13229_ _13232_/A _13188_/A _13225_/X _13228_/Y VDD VSS sg13g2_a21oi_1
XFILLER_171_699 VDD VSS sg13g2_decap_8
XFILLER_48_1254 VDD VSS sg13g2_decap_8
XFILLER_124_582 VDD VSS sg13g2_fill_1
XFILLER_112_733 VDD VSS sg13g2_decap_8
XFILLER_44_1118 VDD VSS sg13g2_decap_8
XFILLER_69_135 VDD VSS sg13g2_decap_8
XFILLER_98_978 VDD VSS sg13g2_decap_8
XFILLER_100_906 VDD VSS sg13g2_fill_2
XFILLER_85_617 VDD VSS sg13g2_decap_8
XFILLER_61_1432 VDD VSS sg13g2_decap_8
XFILLER_112_788 VDD VSS sg13g2_decap_8
X_08770_ _08770_/Y _08788_/A1 _15118_/Q _15187_/Q _07719_/X VDD VSS sg13g2_a22oi_1
XFILLER_61_1443 VDD VSS sg13g2_fill_2
XFILLER_57_319 VDD VSS sg13g2_decap_8
XFILLER_19_0 VDD VSS sg13g2_decap_8
X_07721_ _07735_/B _07721_/A _07721_/B wire719/A VDD VSS sg13g2_nand3_1
XFILLER_38_533 VDD VSS sg13g2_fill_1
XFILLER_66_864 VDD VSS sg13g2_decap_8
XFILLER_65_363 VDD VSS sg13g2_decap_8
XFILLER_53_503 VDD VSS sg13g2_fill_1
X_07652_ _07652_/Y _11171_/B VDD VSS sg13g2_inv_1
XFILLER_0_1212 VDD VSS sg13g2_decap_8
XFILLER_20_1140 VDD VSS sg13g2_decap_8
XFILLER_80_300 VDD VSS sg13g2_fill_2
XFILLER_93_694 VDD VSS sg13g2_decap_8
XFILLER_80_333 VDD VSS sg13g2_decap_4
XFILLER_94_1241 VDD VSS sg13g2_decap_4
XFILLER_146_1320 VDD VSS sg13g2_decap_8
XFILLER_168_1099 VDD VSS sg13g2_decap_8
Xclkbuf_leaf_105_clk_i clkload52/A clkload3/A VDD VSS sg13g2_buf_8
XFILLER_81_889 VDD VSS sg13g2_decap_8
XFILLER_179_733 VDD VSS sg13g2_decap_8
XFILLER_181_1211 VDD VSS sg13g2_decap_8
X_09322_ _13929_/D _09621_/A0 _13929_/Q _09338_/S VDD VSS sg13g2_mux2_1
XFILLER_0_1289 VDD VSS sg13g2_decap_8
XFILLER_178_210 VDD VSS sg13g2_decap_8
X_14356__1916 _14356_/RESET_B VDD VSS sg13g2_tiehi
XFILLER_16_1209 VDD VSS sg13g2_decap_8
XFILLER_181_1255 VDD VSS sg13g2_decap_8
XFILLER_142_1217 VDD VSS sg13g2_decap_8
X_09253_ _13862_/D _13862_/Q _10149_/A1 _09265_/S VDD VSS sg13g2_mux2_1
XFILLER_22_967 VDD VSS sg13g2_decap_8
XFILLER_178_287 VDD VSS sg13g2_decap_8
XFILLER_21_466 VDD VSS sg13g2_decap_4
XFILLER_18_1080 VDD VSS sg13g2_decap_8
X_08204_ _08204_/Y _08220_/B1 _08247_/A _08221_/A2 VDD VSS sg13g2_o21ai_1
X_09184_ _13800_/D _13800_/Q _09919_/A1 _09193_/S VDD VSS sg13g2_mux2_1
XFILLER_147_641 VDD VSS sg13g2_decap_8
XFILLER_21_499 VDD VSS sg13g2_decap_8
X_08135_ _08135_/Y _08142_/B _08131_/Y _08134_/Y VDD VSS sg13g2_a21oi_1
XFILLER_88_1023 VDD VSS sg13g2_fill_1
XFILLER_146_162 VDD VSS sg13g2_fill_1
XFILLER_174_471 VDD VSS sg13g2_decap_8
X_14571__1701 _14571_/RESET_B VDD VSS sg13g2_tiehi
XFILLER_134_313 VDD VSS sg13g2_decap_8
X_08066_ _08066_/Y _08066_/A VDD VSS sg13g2_inv_1
XFILLER_135_858 VDD VSS sg13g2_fill_1
XFILLER_88_1067 VDD VSS sg13g2_decap_8
XFILLER_175_1048 VDD VSS sg13g2_fill_1
XFILLER_118_1400 VDD VSS sg13g2_decap_8
XFILLER_1_805 VDD VSS sg13g2_decap_8
XFILLER_66_1332 VDD VSS sg13g2_decap_8
XFILLER_161_176 VDD VSS sg13g2_decap_8
XFILLER_115_571 VDD VSS sg13g2_decap_8
XFILLER_143_880 VDD VSS sg13g2_decap_8
Xhold3210 _13630_/A _13738_/Q VDD VSS sg13g2_dlygate4sd3_1
XFILLER_88_411 VDD VSS sg13g2_decap_8
XFILLER_0_315 VDD VSS sg13g2_decap_8
Xhold3221 _10987_/A _14941_/Q VDD VSS sg13g2_dlygate4sd3_1
XFILLER_102_210 VDD VSS sg13g2_decap_8
XFILLER_153_1324 VDD VSS sg13g2_decap_4
Xhold3232 _13535_/A _15144_/Q VDD VSS sg13g2_dlygate4sd3_1
Xhold3243 _13539_/A _15145_/Q VDD VSS sg13g2_dlygate4sd3_1
XFILLER_62_1229 VDD VSS sg13g2_decap_8
XFILLER_27_1349 VDD VSS sg13g2_decap_8
Xhold3254 _13578_/A _15158_/Q VDD VSS sg13g2_dlygate4sd3_1
X_13844__2428 _13844_/RESET_B VDD VSS sg13g2_tiehi
XFILLER_103_788 VDD VSS sg13g2_fill_2
XFILLER_48_319 VDD VSS sg13g2_decap_8
X_08968_ _08969_/A _15021_/Q _15218_/Q _09009_/S VDD VSS sg13g2_mux2_1
XFILLER_9_1281 VDD VSS sg13g2_decap_8
XFILLER_75_116 VDD VSS sg13g2_decap_8
XFILLER_75_127 VDD VSS sg13g2_fill_2
XFILLER_57_831 VDD VSS sg13g2_decap_8
XFILLER_112_1010 VDD VSS sg13g2_decap_8
XFILLER_5_1134 VDD VSS sg13g2_decap_8
X_07919_ _07919_/Y _08160_/B _08160_/C _07871_/X VDD VSS sg13g2_o21ai_1
X_08899_ _08899_/Y _08897_/Y _08898_/Y _08931_/S VDD VSS sg13g2_a21oi_1
XFILLER_29_555 VDD VSS sg13g2_decap_8
XFILLER_72_801 VDD VSS sg13g2_fill_1
XFILLER_99_1163 VDD VSS sg13g2_decap_8
XFILLER_17_728 VDD VSS sg13g2_decap_8
X_10930_ _10946_/B _10936_/B _14757_/Q VDD VSS sg13g2_nand2_1
XFILLER_44_503 VDD VSS sg13g2_decap_8
XFILLER_17_42 VDD VSS sg13g2_decap_8
XFILLER_16_238 VDD VSS sg13g2_decap_8
X_14224__2048 _14224_/RESET_B VDD VSS sg13g2_tiehi
XFILLER_83_182 VDD VSS sg13g2_fill_1
X_10861_ _14931_/D _10860_/Y _10859_/Y _10850_/Y VDD VSS sg13g2_o21ai_1
XFILLER_147_1139 VDD VSS sg13g2_decap_8
X_12600_ _12600_/X _13741_/Q _14093_/Q _14445_/Q _14541_/Q _12600_/S0 _12600_/S1 VDD
+ VSS sg13g2_mux4_1
XFILLER_25_761 VDD VSS sg13g2_decap_8
X_13580_ _13580_/Y _15000_/Q _13555_/B _13569_/S _15016_/Q _13529_/X VDD VSS sg13g2_a221oi_1
X_10792_ _10792_/Y _14925_/Q _11113_/B VDD VSS sg13g2_nand2_1
XFILLER_13_945 VDD VSS sg13g2_decap_8
XFILLER_125_1426 VDD VSS sg13g2_decap_8
XFILLER_160_1306 VDD VSS sg13g2_decap_8
XFILLER_164_1475 VDD VSS sg13g2_decap_4
X_12531_ _12531_/X _14376_/Q _14408_/Q _14472_/Q _14504_/Q _12668_/S0 _12668_/S1 VDD
+ VSS sg13g2_mux4_1
XFILLER_24_293 VDD VSS sg13g2_decap_8
XFILLER_125_1437 VDD VSS sg13g2_fill_2
XFILLER_12_455 VDD VSS sg13g2_decap_8
XFILLER_40_764 VDD VSS sg13g2_fill_1
XFILLER_125_1459 VDD VSS sg13g2_decap_8
XFILLER_9_938 VDD VSS sg13g2_decap_8
XFILLER_33_63 VDD VSS sg13g2_decap_8
XFILLER_185_747 VDD VSS sg13g2_fill_1
X_15250_ _15250_/Q clkload91/A _15250_/D _15250_/RESET_B VDD VSS sg13g2_dfrbpq_1
XFILLER_32_1011 VDD VSS sg13g2_decap_4
X_12462_ _12462_/X _14243_/Q _14275_/Q _14307_/Q _14339_/Q _12715_/S0 _12715_/S1 VDD
+ VSS sg13g2_mux4_1
XFILLER_149_63 VDD VSS sg13g2_decap_4
XFILLER_173_909 VDD VSS sg13g2_decap_8
XFILLER_8_448 VDD VSS sg13g2_decap_8
XFILLER_123_0 VDD VSS sg13g2_decap_8
X_14201_ _14201_/Q clkload38/A _14201_/D _14201_/RESET_B VDD VSS sg13g2_dfrbpq_1
XFILLER_32_1044 VDD VSS sg13g2_decap_8
XFILLER_138_663 VDD VSS sg13g2_fill_2
XFILLER_172_408 VDD VSS sg13g2_fill_1
X_11413_ _11413_/X _11413_/A _11422_/B VDD VSS sg13g2_and2_1
XFILLER_149_96 VDD VSS sg13g2_decap_8
XFILLER_184_279 VDD VSS sg13g2_fill_1
X_15181_ _15181_/Q _15182_/CLK _15181_/D _15181_/RESET_B VDD VSS sg13g2_dfrbpq_1
X_12393_ _12393_/X _14110_/Q _14142_/Q _14174_/Q _14206_/Q _12406_/S0 _12406_/S1 VDD
+ VSS sg13g2_mux4_1
XFILLER_126_836 VDD VSS sg13g2_decap_8
XFILLER_32_1088 VDD VSS sg13g2_fill_1
XFILLER_181_942 VDD VSS sg13g2_decap_8
X_14132_ _14132_/Q clkload55/A _14132_/D _14132_/RESET_B VDD VSS sg13g2_dfrbpq_1
X_11344_ _11344_/Y _11821_/S0 _13886_/Q VDD VSS sg13g2_nand2b_1
XFILLER_158_1235 VDD VSS sg13g2_decap_8
Xclkbuf_leaf_84_clk_i _14716_/CLK clkbuf_leaf_94_clk_i/A VDD VSS sg13g2_buf_8
XFILLER_180_441 VDD VSS sg13g2_decap_8
XFILLER_153_666 VDD VSS sg13g2_decap_8
XFILLER_158_1268 VDD VSS sg13g2_decap_8
XFILLER_4_665 VDD VSS sg13g2_decap_8
XFILLER_141_828 VDD VSS sg13g2_decap_4
X_14063_ _14063_/Q _14607_/CLK _14063_/D _14063_/RESET_B VDD VSS sg13g2_dfrbpq_1
XFILLER_84_1432 VDD VSS sg13g2_decap_8
XFILLER_10_1386 VDD VSS sg13g2_decap_8
X_11275_ _11275_/X _14236_/Q _14268_/Q _14300_/Q _14332_/Q _11275_/S0 _11262_/B VDD
+ VSS sg13g2_mux4_1
XFILLER_165_84 VDD VSS sg13g2_decap_8
XFILLER_3_175 VDD VSS sg13g2_decap_8
XFILLER_140_338 VDD VSS sg13g2_decap_8
X_13014_ _13014_/Y _14812_/Q _13250_/A2 _07727_/B _14844_/Q _13082_/B VDD VSS sg13g2_a221oi_1
XFILLER_45_1416 VDD VSS sg13g2_decap_8
X_10226_ _10237_/C _14767_/Q _14768_/Q _14769_/Q _14770_/Q VDD VSS sg13g2_nand4_1
XFILLER_171_1457 VDD VSS sg13g2_decap_8
XFILLER_95_926 VDD VSS sg13g2_fill_1
XFILLER_39_308 VDD VSS sg13g2_fill_2
XFILLER_171_1468 VDD VSS sg13g2_fill_2
X_14434__1838 _14434_/RESET_B VDD VSS sg13g2_tiehi
Xclkbuf_leaf_99_clk_i _14886_/CLK clkbuf_leaf_99_clk_i/A VDD VSS sg13g2_buf_8
X_10157_ _14734_/D _14734_/Q _10157_/A1 _10169_/S VDD VSS sg13g2_mux2_1
XFILLER_121_574 VDD VSS sg13g2_decap_8
XFILLER_121_585 VDD VSS sg13g2_decap_8
XFILLER_79_499 VDD VSS sg13g2_fill_1
XFILLER_12_7 VDD VSS sg13g2_decap_8
X_14965_ _14965_/Q clkload43/A _14965_/D _14965_/RESET_B VDD VSS sg13g2_dfrbpq_1
X_10088_ _14668_/D _10122_/A0 _14668_/Q _10096_/S VDD VSS sg13g2_mux2_1
XFILLER_48_864 VDD VSS sg13g2_decap_8
X_13916_ _13916_/Q clkload64/A _13916_/D _13916_/RESET_B VDD VSS sg13g2_dfrbpq_1
X_14896_ _14896_/Q clkload80/A _14896_/D _14896_/RESET_B VDD VSS sg13g2_dfrbpq_1
Xclkbuf_leaf_22_clk_i _14739_/CLK clkbuf_leaf_48_clk_i/A VDD VSS sg13g2_buf_8
XFILLER_90_620 VDD VSS sg13g2_fill_1
XFILLER_130_1198 VDD VSS sg13g2_decap_4
XFILLER_39_1209 VDD VSS sg13g2_decap_8
X_13847_ _13847_/Q _15017_/CLK _13847_/D _13847_/RESET_B VDD VSS sg13g2_dfrbpq_1
XFILLER_50_506 VDD VSS sg13g2_decap_8
XFILLER_62_388 VDD VSS sg13g2_decap_8
X_13778_ _13778_/Q clkload15/A _13778_/D _13778_/RESET_B VDD VSS sg13g2_dfrbpq_1
XFILLER_91_1436 VDD VSS sg13g2_decap_8
XFILLER_128_1061 VDD VSS sg13g2_decap_8
XFILLER_31_742 VDD VSS sg13g2_fill_1
X_12729_ _12729_/X _13750_/Q _14102_/Q _14454_/Q _14550_/Q _12730_/S0 _12730_/S1 VDD
+ VSS sg13g2_mux4_1
Xclkbuf_leaf_37_clk_i clkload35/A clkbuf_leaf_37_clk_i/A VDD VSS sg13g2_buf_8
XFILLER_148_427 VDD VSS sg13g2_fill_2
XFILLER_31_775 VDD VSS sg13g2_decap_8
XFILLER_30_252 VDD VSS sg13g2_decap_8
XFILLER_175_224 VDD VSS sg13g2_decap_8
XFILLER_15_1242 VDD VSS sg13g2_decap_8
XFILLER_164_909 VDD VSS sg13g2_decap_8
XFILLER_129_652 VDD VSS sg13g2_fill_2
XFILLER_106_1381 VDD VSS sg13g2_decap_8
XFILLER_117_803 VDD VSS sg13g2_fill_2
XFILLER_163_408 VDD VSS sg13g2_decap_8
XFILLER_11_1106 VDD VSS sg13g2_decap_8
XFILLER_117_825 VDD VSS sg13g2_fill_1
XFILLER_117_836 VDD VSS sg13g2_decap_8
XFILLER_176_1302 VDD VSS sg13g2_fill_2
XFILLER_116_324 VDD VSS sg13g2_decap_8
XFILLER_89_1365 VDD VSS sg13g2_fill_1
XFILLER_172_953 VDD VSS sg13g2_decap_8
XFILLER_116_357 VDD VSS sg13g2_decap_8
X_09940_ _14524_/D _14524_/Q _10072_/A0 _09958_/S VDD VSS sg13g2_mux2_1
XFILLER_143_165 VDD VSS sg13g2_decap_8
XFILLER_143_176 VDD VSS sg13g2_fill_2
XFILLER_48_1040 VDD VSS sg13g2_fill_1
XFILLER_48_1051 VDD VSS sg13g2_decap_8
XFILLER_131_349 VDD VSS sg13g2_fill_2
Xfanout906 _12771_/S1 _12773_/S1 VDD VSS sg13g2_buf_1
X_09871_ _14458_/D _14458_/Q _10102_/A0 _09871_/S VDD VSS sg13g2_mux2_1
XFILLER_98_753 VDD VSS sg13g2_fill_1
Xfanout928 _12668_/S0 _12754_/S0 VDD VSS sg13g2_buf_1
XFILLER_112_552 VDD VSS sg13g2_fill_2
Xfanout939 wire940/A _12382_/S0 VDD VSS sg13g2_buf_1
XFILLER_100_703 VDD VSS sg13g2_fill_2
XFILLER_97_252 VDD VSS sg13g2_decap_8
X_08822_ _08822_/Y _13691_/Q _08822_/B VDD VSS sg13g2_nor2_1
XFILLER_58_617 VDD VSS sg13g2_decap_8
XFILLER_135_1065 VDD VSS sg13g2_decap_8
XFILLER_57_105 VDD VSS sg13g2_decap_8
XFILLER_135_1076 VDD VSS sg13g2_fill_2
XFILLER_140_894 VDD VSS sg13g2_decap_8
XFILLER_6_1421 VDD VSS sg13g2_decap_8
XFILLER_86_959 VDD VSS sg13g2_decap_8
XFILLER_61_1240 VDD VSS sg13g2_decap_8
XFILLER_39_842 VDD VSS sg13g2_decap_8
X_08753_ _13669_/D _08753_/A1 _08751_/Y _08752_/Y VDD VSS sg13g2_a21oi_1
XFILLER_113_1363 VDD VSS sg13g2_decap_8
XFILLER_96_1303 VDD VSS sg13g2_decap_8
X_07704_ _07705_/A _15080_/Q _07694_/Y _15201_/Q _07697_/A VDD VSS sg13g2_a22oi_1
XFILLER_94_981 VDD VSS sg13g2_fill_2
XFILLER_66_672 VDD VSS sg13g2_fill_1
XFILLER_22_1268 VDD VSS sg13g2_decap_8
X_14856__2925 _14856_/RESET_B VDD VSS sg13g2_tiehi
X_08684_ _08684_/X _08684_/A _08684_/B VDD VSS sg13g2_xor2_1
XFILLER_66_683 VDD VSS sg13g2_decap_8
XFILLER_93_480 VDD VSS sg13g2_decap_8
XFILLER_53_311 VDD VSS sg13g2_decap_4
XFILLER_26_525 VDD VSS sg13g2_fill_2
XFILLER_81_642 VDD VSS sg13g2_decap_8
XFILLER_183_1317 VDD VSS sg13g2_decap_8
X_07635_ _07910_/A _14994_/Q VDD VSS sg13g2_inv_1
XFILLER_80_130 VDD VSS sg13g2_decap_8
XFILLER_148_1459 VDD VSS sg13g2_decap_8
X_14771__3035 _14771_/RESET_B VDD VSS sg13g2_tiehi
XFILLER_53_377 VDD VSS sg13g2_decap_8
XFILLER_41_517 VDD VSS sg13g2_decap_8
XFILLER_0_1086 VDD VSS sg13g2_decap_8
XFILLER_110_35 VDD VSS sg13g2_decap_8
XFILLER_146_1161 VDD VSS sg13g2_fill_1
X_09305_ _13913_/D _13913_/Q _09472_/A0 _09305_/S VDD VSS sg13g2_mux2_1
XFILLER_107_1123 VDD VSS sg13g2_decap_8
XFILLER_179_574 VDD VSS sg13g2_decap_8
X_14889__2859 _14889_/RESET_B VDD VSS sg13g2_tiehi
XFILLER_139_416 VDD VSS sg13g2_decap_8
XFILLER_167_725 VDD VSS sg13g2_decap_8
XFILLER_70_28 VDD VSS sg13g2_decap_8
XFILLER_22_764 VDD VSS sg13g2_decap_4
XFILLER_166_224 VDD VSS sg13g2_decap_8
XFILLER_21_252 VDD VSS sg13g2_decap_8
X_09236_ _13847_/D _10166_/A1 _13847_/Q _09237_/S VDD VSS sg13g2_mux2_1
XFILLER_142_1058 VDD VSS sg13g2_fill_2
XFILLER_155_909 VDD VSS sg13g2_decap_8
XFILLER_186_28 VDD VSS sg13g2_decap_8
XFILLER_10_959 VDD VSS sg13g2_decap_8
XFILLER_119_11 VDD VSS sg13g2_fill_2
XFILLER_154_419 VDD VSS sg13g2_decap_4
XFILLER_33_1364 VDD VSS sg13g2_decap_8
XFILLER_120_1323 VDD VSS sg13g2_decap_8
X_09167_ _13786_/D _13786_/Q _10102_/A0 _09167_/S VDD VSS sg13g2_mux2_1
XFILLER_181_238 VDD VSS sg13g2_decap_8
X_08118_ _08145_/A _07904_/B _08116_/Y _08117_/Y VDD VSS sg13g2_o21ai_1
XFILLER_135_644 VDD VSS sg13g2_decap_8
X_09098_ _09098_/Y _09126_/A1 _10747_/B _09097_/X VDD VSS sg13g2_o21ai_1
XFILLER_119_88 VDD VSS sg13g2_decap_8
XFILLER_107_368 VDD VSS sg13g2_fill_1
XFILLER_155_1419 VDD VSS sg13g2_decap_8
XFILLER_1_602 VDD VSS sg13g2_decap_8
X_08049_ _08397_/B _08049_/A _08048_/B VDD VSS sg13g2_nor2b_1
XFILLER_150_636 VDD VSS sg13g2_fill_1
XFILLER_162_496 VDD VSS sg13g2_fill_2
XFILLER_0_112 VDD VSS sg13g2_decap_8
XFILLER_153_1110 VDD VSS sg13g2_fill_1
X_11060_ _11060_/X _11064_/C _11064_/D VDD VSS sg13g2_and2_1
XFILLER_103_530 VDD VSS sg13g2_fill_2
XFILLER_122_349 VDD VSS sg13g2_decap_8
XFILLER_103_541 VDD VSS sg13g2_decap_8
XFILLER_118_1263 VDD VSS sg13g2_decap_8
XFILLER_153_1143 VDD VSS sg13g2_decap_8
X_10011_ _14593_/D _10077_/A0 _14593_/Q _10031_/S VDD VSS sg13g2_mux2_1
XFILLER_95_14 VDD VSS sg13g2_decap_8
XFILLER_88_252 VDD VSS sg13g2_decap_8
XFILLER_7_1218 VDD VSS sg13g2_decap_8
XFILLER_27_1146 VDD VSS sg13g2_decap_8
XFILLER_103_563 VDD VSS sg13g2_fill_2
XFILLER_114_1105 VDD VSS sg13g2_fill_1
XFILLER_1_679 VDD VSS sg13g2_decap_8
XFILLER_49_617 VDD VSS sg13g2_decap_8
X_15075__2942 _15075_/RESET_B VDD VSS sg13g2_tiehi
XFILLER_0_189 VDD VSS sg13g2_decap_8
XFILLER_153_1187 VDD VSS sg13g2_decap_4
XFILLER_76_458 VDD VSS sg13g2_decap_8
XFILLER_64_609 VDD VSS sg13g2_fill_1
X_15233__3094 _15233_/RESET_B VDD VSS sg13g2_tiehi
XFILLER_76_469 VDD VSS sg13g2_fill_2
XFILLER_151_31 VDD VSS sg13g2_fill_2
XFILLER_92_929 VDD VSS sg13g2_decap_8
XFILLER_29_352 VDD VSS sg13g2_decap_8
XFILLER_28_63 VDD VSS sg13g2_decap_8
XFILLER_131_1463 VDD VSS sg13g2_decap_8
XFILLER_63_108 VDD VSS sg13g2_fill_1
X_14750_ _14750_/Q clkload91/A _14750_/D _14750_/RESET_B VDD VSS sg13g2_dfrbpq_1
XFILLER_63_119 VDD VSS sg13g2_decap_8
X_11962_ _11962_/Y _11958_/Y _11959_/Y _11961_/Y _11960_/Y _11964_/B VDD VSS sg13g2_a221oi_1
XFILLER_40_1368 VDD VSS sg13g2_fill_1
XFILLER_17_525 VDD VSS sg13g2_decap_8
XFILLER_29_385 VDD VSS sg13g2_decap_8
XFILLER_28_96 VDD VSS sg13g2_decap_8
X_13701_ _13701_/Q clkload74/A _13701_/D _13701_/RESET_B VDD VSS sg13g2_dfrbpq_1
XFILLER_44_322 VDD VSS sg13g2_decap_8
X_10913_ _14935_/D _10912_/Y _10911_/Y _10903_/Y VDD VSS sg13g2_o21ai_1
XFILLER_56_193 VDD VSS sg13g2_decap_4
X_14681_ _14681_/Q clkload38/A _14681_/D _14681_/RESET_B VDD VSS sg13g2_dfrbpq_1
X_11893_ _11893_/X _14126_/Q _14158_/Q _11896_/A VDD VSS sg13g2_mux2_1
XFILLER_45_889 VDD VSS sg13g2_decap_8
X_13632_ _13740_/D _13632_/A VDD VSS sg13g2_buf_1
XFILLER_44_377 VDD VSS sg13g2_decap_8
X_10844_ _10897_/D _10844_/A _10844_/B _10851_/D _10851_/C VDD VSS sg13g2_nand4_1
XFILLER_44_388 VDD VSS sg13g2_fill_2
XFILLER_60_859 VDD VSS sg13g2_decap_8
XFILLER_13_742 VDD VSS sg13g2_decap_8
XFILLER_158_703 VDD VSS sg13g2_decap_4
XFILLER_164_1261 VDD VSS sg13g2_decap_8
XFILLER_164_1272 VDD VSS sg13g2_fill_2
X_13563_ _13563_/Y _15010_/Q _13601_/B _13566_/C VDD VSS sg13g2_nor3_1
XFILLER_160_1114 VDD VSS sg13g2_fill_2
XFILLER_185_511 VDD VSS sg13g2_decap_8
X_10775_ _14920_/D _11168_/B1 _11163_/A _10774_/Y VDD VSS sg13g2_o21ai_1
XFILLER_40_550 VDD VSS sg13g2_decap_8
XFILLER_12_252 VDD VSS sg13g2_decap_8
XFILLER_158_747 VDD VSS sg13g2_decap_8
X_12514_ _12527_/A _12765_/A1 _07737_/B _08351_/B VDD VSS sg13g2_a21oi_1
XFILLER_9_735 VDD VSS sg13g2_decap_8
XFILLER_125_1267 VDD VSS sg13g2_decap_8
X_13494_ _13494_/Y _15071_/Q _13494_/B VDD VSS sg13g2_nor2_1
XFILLER_8_245 VDD VSS sg13g2_decap_8
X_15233_ _15233_/Q _15249_/CLK _15233_/D _15233_/RESET_B VDD VSS sg13g2_dfrbpq_1
XFILLER_173_728 VDD VSS sg13g2_decap_8
XFILLER_185_588 VDD VSS sg13g2_decap_8
X_12445_ _12445_/X _14562_/Q _14594_/Q _14626_/Q _14658_/Q _12450_/S0 _12450_/S1 VDD
+ VSS sg13g2_mux4_1
XFILLER_126_611 VDD VSS sg13g2_fill_2
XFILLER_138_482 VDD VSS sg13g2_decap_8
XFILLER_126_644 VDD VSS sg13g2_decap_8
X_15164_ _15164_/Q clkload89/A _15164_/D _15164_/RESET_B VDD VSS sg13g2_dfrbpq_1
X_12376_ _12376_/X _13725_/Q _14077_/Q _14429_/Q _14525_/Q _12618_/S0 _12618_/S1 VDD
+ VSS sg13g2_mux4_1
XFILLER_125_132 VDD VSS sg13g2_decap_8
XFILLER_5_952 VDD VSS sg13g2_decap_8
XFILLER_181_772 VDD VSS sg13g2_decap_8
X_14115_ _14115_/Q clkload29/A _14115_/D _14115_/RESET_B VDD VSS sg13g2_dfrbpq_1
X_11327_ _11327_/Y _11322_/Y _11323_/Y _11329_/B1 VDD VSS sg13g2_a21oi_1
XFILLER_114_839 VDD VSS sg13g2_decap_8
X_15095_ _15095_/Q clkload87/A _15095_/D _15095_/RESET_B VDD VSS sg13g2_dfrbpq_1
XFILLER_5_56 VDD VSS sg13g2_decap_8
XFILLER_4_462 VDD VSS sg13g2_decap_8
XFILLER_10_1183 VDD VSS sg13g2_decap_8
XFILLER_141_647 VDD VSS sg13g2_fill_2
X_14046_ _14046_/Q clkload48/A _14046_/D _14046_/RESET_B VDD VSS sg13g2_dfrbpq_1
X_14667__1605 _14667_/RESET_B VDD VSS sg13g2_tiehi
XFILLER_84_1262 VDD VSS sg13g2_decap_8
X_11258_ _11258_/Y _11256_/Y _11255_/Y _12324_/B _11257_/X VDD VSS sg13g2_a22oi_1
XFILLER_68_915 VDD VSS sg13g2_decap_8
XFILLER_79_252 VDD VSS sg13g2_decap_8
X_10209_ _14762_/D _10209_/A _10209_/B _10209_/C VDD VSS sg13g2_nor3_1
XFILLER_67_403 VDD VSS sg13g2_decap_8
XFILLER_45_1268 VDD VSS sg13g2_fill_2
X_11189_ _11189_/Y _11190_/C _11190_/A _11199_/B VDD VSS sg13g2_o21ai_1
XFILLER_79_285 VDD VSS sg13g2_decap_4
XFILLER_68_948 VDD VSS sg13g2_decap_8
XFILLER_171_1287 VDD VSS sg13g2_decap_4
X_14096__2176 _14096_/RESET_B VDD VSS sg13g2_tiehi
XFILLER_121_393 VDD VSS sg13g2_decap_8
XFILLER_171_1298 VDD VSS sg13g2_fill_2
XFILLER_67_458 VDD VSS sg13g2_decap_8
XFILLER_54_108 VDD VSS sg13g2_fill_1
X_14948_ _14948_/Q clkload57/A _14948_/D _14948_/RESET_B VDD VSS sg13g2_dfrbpq_1
XFILLER_94_288 VDD VSS sg13g2_decap_8
XFILLER_78_1011 VDD VSS sg13g2_decap_8
X_15035__2645 _15035_/RESET_B VDD VSS sg13g2_tiehi
XFILLER_35_344 VDD VSS sg13g2_decap_8
XFILLER_1_1351 VDD VSS sg13g2_decap_8
X_14879_ _14879_/Q clkload61/A _14879_/D _14879_/RESET_B VDD VSS sg13g2_dfrbpq_1
XFILLER_91_984 VDD VSS sg13g2_decap_8
XFILLER_63_686 VDD VSS sg13g2_fill_1
XFILLER_35_377 VDD VSS sg13g2_decap_8
XFILLER_165_1047 VDD VSS sg13g2_fill_1
XFILLER_62_174 VDD VSS sg13g2_decap_8
XFILLER_91_1222 VDD VSS sg13g2_decap_8
XFILLER_91_1233 VDD VSS sg13g2_fill_2
XFILLER_149_703 VDD VSS sg13g2_decap_4
XFILLER_149_725 VDD VSS sg13g2_decap_8
XFILLER_176_522 VDD VSS sg13g2_decap_8
XFILLER_17_1348 VDD VSS sg13g2_decap_8
XFILLER_52_1228 VDD VSS sg13g2_fill_1
XFILLER_148_224 VDD VSS sg13g2_decap_8
XFILLER_86_0 VDD VSS sg13g2_decap_8
XFILLER_149_769 VDD VSS sg13g2_fill_1
XFILLER_104_1329 VDD VSS sg13g2_decap_8
XFILLER_143_1378 VDD VSS sg13g2_fill_2
XFILLER_143_1389 VDD VSS sg13g2_decap_8
XFILLER_164_706 VDD VSS sg13g2_decap_8
X_09021_ _09021_/X _15031_/Q _15228_/Q _09053_/B VDD VSS sg13g2_mux2_1
XFILLER_164_728 VDD VSS sg13g2_decap_8
XFILLER_176_599 VDD VSS sg13g2_decap_8
XFILLER_129_482 VDD VSS sg13g2_fill_2
XFILLER_89_1140 VDD VSS sg13g2_decap_8
XFILLER_116_132 VDD VSS sg13g2_decap_8
XFILLER_105_806 VDD VSS sg13g2_decap_8
XFILLER_104_305 VDD VSS sg13g2_fill_1
XFILLER_176_1154 VDD VSS sg13g2_decap_8
XFILLER_131_113 VDD VSS sg13g2_decap_8
XFILLER_176_1187 VDD VSS sg13g2_decap_8
X_09923_ _14508_/D _14508_/Q _09923_/A1 _09937_/S VDD VSS sg13g2_mux2_1
XFILLER_67_1471 VDD VSS sg13g2_fill_1
XFILLER_28_1422 VDD VSS sg13g2_decap_8
Xfanout703 _12777_/C1 _07737_/Y VDD VSS sg13g2_buf_1
Xfanout714 _13082_/B _13138_/B1 VDD VSS sg13g2_buf_1
X_14789__3017 _14789_/RESET_B VDD VSS sg13g2_tiehi
Xfanout725 _07705_/B _07703_/Y VDD VSS sg13g2_buf_1
XFILLER_115_1414 VDD VSS sg13g2_decap_8
Xfanout736 _11721_/B1 _12294_/B1 VDD VSS sg13g2_buf_1
XFILLER_150_1305 VDD VSS sg13g2_fill_2
Xfanout747 _13336_/S _10187_/S VDD VSS sg13g2_buf_1
X_09854_ _14441_/D _14441_/Q _09953_/A1 _09870_/S VDD VSS sg13g2_mux2_1
XFILLER_63_1357 VDD VSS sg13g2_decap_8
Xfanout758 _12029_/B _12115_/A1 VDD VSS sg13g2_buf_1
Xfanout769 _12324_/B _12094_/B VDD VSS sg13g2_buf_1
XFILLER_105_35 VDD VSS sg13g2_decap_8
XFILLER_85_222 VDD VSS sg13g2_decap_8
XFILLER_105_46 VDD VSS sg13g2_fill_1
X_08805_ _13686_/D _08805_/A _08805_/B VDD VSS sg13g2_nor2_1
X_13761__2511 _13761_/RESET_B VDD VSS sg13g2_tiehi
X_09785_ _14374_/D _09917_/A1 _14374_/Q _09797_/S VDD VSS sg13g2_mux2_1
XFILLER_74_929 VDD VSS sg13g2_fill_1
XFILLER_100_588 VDD VSS sg13g2_fill_2
X_08736_ _08736_/Y _07719_/A _11288_/A _15198_/Q VDD VSS sg13g2_o21ai_1
XFILLER_113_1171 VDD VSS sg13g2_decap_8
XFILLER_6_1295 VDD VSS sg13g2_decap_8
XFILLER_22_1065 VDD VSS sg13g2_decap_8
XFILLER_2_1148 VDD VSS sg13g2_decap_8
XFILLER_26_322 VDD VSS sg13g2_decap_8
XFILLER_54_642 VDD VSS sg13g2_decap_8
X_08667_ _15247_/D _08667_/A1 _08666_/X _08661_/X VDD VSS sg13g2_o21ai_1
XFILLER_148_1234 VDD VSS sg13g2_decap_8
XFILLER_164_7 VDD VSS sg13g2_decap_8
XFILLER_82_973 VDD VSS sg13g2_decap_8
XFILLER_42_804 VDD VSS sg13g2_decap_8
X_15106__2842 _15106_/RESET_B VDD VSS sg13g2_tiehi
XFILLER_96_1188 VDD VSS sg13g2_fill_1
XFILLER_92_1019 VDD VSS sg13g2_decap_8
X_07618_ _09011_/B _14901_/Q VDD VSS sg13g2_inv_1
XFILLER_14_539 VDD VSS sg13g2_decap_8
X_14141__2131 _14141_/RESET_B VDD VSS sg13g2_tiehi
X_08598_ _08599_/C _07853_/B _08620_/A2 _08620_/A3 _08598_/A3 _08598_/S0 _08598_/S1
+ VDD VSS sg13g2_mux4_1
XFILLER_26_399 VDD VSS sg13g2_decap_4
X_13794__2478 _13794_/RESET_B VDD VSS sg13g2_tiehi
XFILLER_53_196 VDD VSS sg13g2_decap_8
XFILLER_14_21 VDD VSS sg13g2_decap_8
XFILLER_70_1306 VDD VSS sg13g2_fill_1
XFILLER_139_202 VDD VSS sg13g2_decap_8
XFILLER_179_371 VDD VSS sg13g2_decap_8
XFILLER_161_1434 VDD VSS sg13g2_decap_8
XFILLER_161_1445 VDD VSS sg13g2_fill_1
XFILLER_22_561 VDD VSS sg13g2_decap_8
X_14745__1527 _14745_/RESET_B VDD VSS sg13g2_tiehi
XFILLER_122_1418 VDD VSS sg13g2_decap_8
X_10560_ _10561_/D _14868_/Q _14867_/Q _14866_/Q _14865_/Q VDD VSS sg13g2_nand4_1
XFILLER_50_892 VDD VSS sg13g2_decap_8
XFILLER_155_706 VDD VSS sg13g2_fill_2
XFILLER_10_756 VDD VSS sg13g2_decap_8
XFILLER_14_98 VDD VSS sg13g2_decap_8
XFILLER_167_588 VDD VSS sg13g2_fill_1
X_09219_ _13830_/D _10149_/A1 _13830_/Q _09231_/S VDD VSS sg13g2_mux2_1
XFILLER_154_205 VDD VSS sg13g2_decap_8
XFILLER_136_920 VDD VSS sg13g2_decap_8
XFILLER_182_525 VDD VSS sg13g2_decap_8
X_10491_ _10493_/A _10508_/A _10498_/D _10626_/B VDD VSS sg13g2_o21ai_1
XFILLER_154_238 VDD VSS sg13g2_fill_2
X_14174__2098 _14174_/RESET_B VDD VSS sg13g2_tiehi
XFILLER_6_749 VDD VSS sg13g2_decap_8
X_12230_ _12231_/B _12272_/A _12204_/A _12274_/A VDD VSS sg13g2_o21ai_1
XFILLER_120_1153 VDD VSS sg13g2_decap_8
XFILLER_159_1330 VDD VSS sg13g2_decap_8
XFILLER_30_42 VDD VSS sg13g2_decap_8
XFILLER_5_259 VDD VSS sg13g2_decap_8
XFILLER_136_986 VDD VSS sg13g2_decap_8
XFILLER_159_1352 VDD VSS sg13g2_fill_2
XFILLER_11_1470 VDD VSS sg13g2_decap_4
XFILLER_135_474 VDD VSS sg13g2_decap_8
XFILLER_146_42 VDD VSS sg13g2_decap_8
X_12161_ _12161_/Y _12157_/Y _12158_/Y _12160_/Y _12159_/Y _12190_/B VDD VSS sg13g2_a221oi_1
XFILLER_146_53 VDD VSS sg13g2_fill_2
XFILLER_150_411 VDD VSS sg13g2_decap_8
XFILLER_162_271 VDD VSS sg13g2_fill_1
XFILLER_162_282 VDD VSS sg13g2_decap_8
XFILLER_107_198 VDD VSS sg13g2_decap_8
X_11112_ _14949_/D _11111_/Y _11110_/Y _11102_/Y VDD VSS sg13g2_o21ai_1
XFILLER_122_146 VDD VSS sg13g2_decap_8
XFILLER_151_978 VDD VSS sg13g2_fill_2
X_12092_ _12092_/Y _12092_/A _12092_/B _12308_/C VDD VSS sg13g2_nand3_1
XFILLER_2_966 VDD VSS sg13g2_decap_8
XFILLER_151_989 VDD VSS sg13g2_decap_4
XFILLER_1_476 VDD VSS sg13g2_decap_8
X_11043_ _11044_/B _11043_/A _11043_/B _11078_/D VDD VSS sg13g2_nand3_1
XFILLER_7_1015 VDD VSS sg13g2_decap_8
XFILLER_104_894 VDD VSS sg13g2_decap_8
XFILLER_118_1071 VDD VSS sg13g2_fill_2
X_14351__1921 _14351_/RESET_B VDD VSS sg13g2_tiehi
XFILLER_49_469 VDD VSS sg13g2_decap_8
XFILLER_162_85 VDD VSS sg13g2_decap_8
X_14802_ _14802_/Q clkload66/A _14802_/D _14802_/RESET_B VDD VSS sg13g2_dfrbpq_1
XFILLER_131_1260 VDD VSS sg13g2_decap_8
XFILLER_162_96 VDD VSS sg13g2_fill_1
XFILLER_29_160 VDD VSS sg13g2_fill_2
XFILLER_149_1009 VDD VSS sg13g2_fill_1
X_12994_ _13010_/A _12994_/A _13058_/D VDD VSS sg13g2_nand2_1
XFILLER_17_322 VDD VSS sg13g2_decap_8
XFILLER_73_940 VDD VSS sg13g2_decap_8
X_14733_ _14733_/Q _14733_/CLK _14733_/D _14733_/RESET_B VDD VSS sg13g2_dfrbpq_1
X_14981__2699 _14981_/RESET_B VDD VSS sg13g2_tiehi
XFILLER_73_951 VDD VSS sg13g2_fill_1
X_11945_ _11946_/A _13968_/Q _14000_/Q _14032_/Q _14064_/Q _11948_/S _11952_/C VDD
+ VSS sg13g2_mux4_1
XFILLER_18_878 VDD VSS sg13g2_decap_8
XFILLER_166_1334 VDD VSS sg13g2_decap_8
X_14664_ _14664_/Q _14664_/CLK _14664_/D _14664_/RESET_B VDD VSS sg13g2_dfrbpq_1
XFILLER_72_483 VDD VSS sg13g2_decap_8
XFILLER_17_399 VDD VSS sg13g2_decap_8
X_11876_ _11876_/Y _11873_/Y _11875_/X _11901_/B1 VDD VSS sg13g2_o21ai_1
XFILLER_60_645 VDD VSS sg13g2_decap_8
XFILLER_177_308 VDD VSS sg13g2_decap_8
X_13615_ _13723_/D _13615_/A VDD VSS sg13g2_buf_1
X_14384__1888 _14384_/RESET_B VDD VSS sg13g2_tiehi
X_10827_ _10831_/A _12347_/B _10827_/B VDD VSS sg13g2_nand2b_1
X_14595_ _14595_/Q _14729_/CLK _14595_/D _14595_/RESET_B VDD VSS sg13g2_dfrbpq_1
XFILLER_125_1053 VDD VSS sg13g2_decap_8
X_13546_ _13546_/Y _14996_/Q _13555_/C _08383_/B _13546_/B2 VDD VSS sg13g2_a22oi_1
XFILLER_9_532 VDD VSS sg13g2_decap_8
X_10758_ _11115_/A _14948_/Q _10757_/A _10757_/Y VDD VSS sg13g2_a21oi_1
X_14840__2957 _14840_/RESET_B VDD VSS sg13g2_tiehi
XFILLER_71_82 VDD VSS sg13g2_decap_4
XFILLER_146_728 VDD VSS sg13g2_decap_4
XFILLER_16_1370 VDD VSS sg13g2_decap_8
XFILLER_185_385 VDD VSS sg13g2_decap_8
X_13477_ _15179_/D hold3129/X _15179_/Q _13477_/S VDD VSS sg13g2_mux2_1
X_10689_ _10689_/Y _14899_/Q _10875_/B VDD VSS sg13g2_nand2_1
XFILLER_51_1283 VDD VSS sg13g2_fill_1
X_14004__2268 _14004_/RESET_B VDD VSS sg13g2_tiehi
X_15216_ _15216_/Q _15216_/CLK _15216_/D _15216_/RESET_B VDD VSS sg13g2_dfrbpq_1
XFILLER_126_430 VDD VSS sg13g2_fill_1
X_12428_ _12428_/X _12426_/X _12427_/X _12776_/S VDD VSS sg13g2_mux2_1
XFILLER_86_1313 VDD VSS sg13g2_decap_8
XFILLER_12_1267 VDD VSS sg13g2_decap_8
XFILLER_126_463 VDD VSS sg13g2_decap_8
X_15147_ _15147_/Q clkload78/A _15147_/D _15147_/RESET_B VDD VSS sg13g2_dfrbpq_1
X_12359_ _12359_/Y _15119_/Q _12348_/A _12442_/A2 _15123_/Q _13282_/A1 VDD VSS sg13g2_a221oi_1
XFILLER_126_496 VDD VSS sg13g2_decap_8
XFILLER_153_282 VDD VSS sg13g2_fill_2
X_15078_ _15078_/Q clkload87/A _15078_/D _15078_/RESET_B VDD VSS sg13g2_dfrbpq_1
XFILLER_99_369 VDD VSS sg13g2_fill_2
X_14029_ _14029_/Q clkload18/A _14029_/D _14029_/RESET_B VDD VSS sg13g2_dfrbpq_1
XFILLER_84_1092 VDD VSS sg13g2_fill_2
XFILLER_171_1062 VDD VSS sg13g2_decap_8
XFILLER_67_233 VDD VSS sg13g2_decap_8
XFILLER_121_190 VDD VSS sg13g2_fill_1
XFILLER_95_564 VDD VSS sg13g2_decap_4
XFILLER_23_1330 VDD VSS sg13g2_decap_8
XFILLER_95_586 VDD VSS sg13g2_decap_8
X_09570_ _14168_/D _09770_/A1 _14168_/Q _09570_/S VDD VSS sg13g2_mux2_1
XFILLER_95_597 VDD VSS sg13g2_decap_8
XFILLER_3_1435 VDD VSS sg13g2_decap_8
XFILLER_83_759 VDD VSS sg13g2_fill_2
XFILLER_48_491 VDD VSS sg13g2_decap_8
X_08521_ _08521_/X _08279_/A _08362_/X _08457_/X _08597_/C _08597_/B _08617_/A VDD
+ VSS sg13g2_mux4_1
XFILLER_35_141 VDD VSS sg13g2_decap_8
XFILLER_36_675 VDD VSS sg13g2_decap_8
XFILLER_91_781 VDD VSS sg13g2_fill_2
X_08452_ _08461_/A _08452_/A _08544_/B _08452_/C _08452_/D VDD VSS sg13g2_nand4_1
XFILLER_145_1429 VDD VSS sg13g2_fill_1
XFILLER_50_122 VDD VSS sg13g2_decap_8
XFILLER_168_308 VDD VSS sg13g2_fill_2
XFILLER_56_1150 VDD VSS sg13g2_decap_8
X_08383_ _08412_/B _08383_/A _08383_/B VDD VSS sg13g2_nor2_1
XFILLER_32_881 VDD VSS sg13g2_decap_8
XFILLER_149_544 VDD VSS sg13g2_decap_8
XFILLER_17_1145 VDD VSS sg13g2_decap_8
XFILLER_56_1194 VDD VSS sg13g2_decap_4
XFILLER_143_1153 VDD VSS sg13g2_decap_8
XFILLER_91_1085 VDD VSS sg13g2_decap_8
XFILLER_137_706 VDD VSS sg13g2_decap_8
XFILLER_177_886 VDD VSS sg13g2_decap_4
XFILLER_176_385 VDD VSS sg13g2_decap_8
XFILLER_30_1323 VDD VSS sg13g2_fill_1
X_15232__3093 _15232_/RESET_B VDD VSS sg13g2_tiehi
X_09004_ _09006_/B _14900_/Q _08993_/X _14901_/Q VDD VSS sg13g2_a21oi_1
XFILLER_164_558 VDD VSS sg13g2_decap_8
XFILLER_129_290 VDD VSS sg13g2_decap_4
XFILLER_118_975 VDD VSS sg13g2_decap_4
XFILLER_117_496 VDD VSS sg13g2_decap_8
XFILLER_132_422 VDD VSS sg13g2_fill_2
XFILLER_160_742 VDD VSS sg13g2_decap_8
XFILLER_144_293 VDD VSS sg13g2_decap_4
XFILLER_78_509 VDD VSS sg13g2_fill_2
XFILLER_116_34 VDD VSS sg13g2_decap_8
Xfanout500 _09538_/S fanout500/A VDD VSS sg13g2_buf_1
XFILLER_8_1302 VDD VSS sg13g2_decap_8
Xfanout511 _09394_/S _09407_/S VDD VSS sg13g2_buf_1
XFILLER_120_628 VDD VSS sg13g2_decap_8
X_14159__2113 _14159_/RESET_B VDD VSS sg13g2_tiehi
X_09906_ _14491_/D _14491_/Q _09906_/A1 _09937_/S VDD VSS sg13g2_mux2_1
XFILLER_59_712 VDD VSS sg13g2_decap_8
Xfanout533 _10142_/A1 _10109_/A0 VDD VSS sg13g2_buf_1
XFILLER_28_1263 VDD VSS sg13g2_decap_8
XFILLER_63_1154 VDD VSS sg13g2_decap_8
Xfanout544 _08039_/A _08001_/Y VDD VSS sg13g2_buf_1
XFILLER_58_211 VDD VSS sg13g2_decap_8
Xfanout555 _11241_/A _07672_/X VDD VSS sg13g2_buf_1
XFILLER_101_842 VDD VSS sg13g2_decap_8
XFILLER_76_49 VDD VSS sg13g2_decap_8
XFILLER_24_1127 VDD VSS sg13g2_decap_8
XFILLER_112_190 VDD VSS sg13g2_decap_8
Xfanout577 _12223_/A _11235_/X VDD VSS sg13g2_buf_1
X_09837_ _14425_/D _09936_/A1 _14425_/Q _09837_/S VDD VSS sg13g2_mux2_1
XFILLER_150_1146 VDD VSS sg13g2_decap_8
Xfanout588 _10139_/A1 _10105_/A VDD VSS sg13g2_buf_1
XFILLER_8_1379 VDD VSS sg13g2_decap_8
XFILLER_101_886 VDD VSS sg13g2_decap_8
Xfanout599 _08999_/B1 _08967_/Y VDD VSS sg13g2_buf_1
XFILLER_98_1217 VDD VSS sg13g2_decap_8
XFILLER_58_266 VDD VSS sg13g2_decap_8
XFILLER_18_119 VDD VSS sg13g2_decap_8
X_09768_ _14358_/D _14358_/Q _09933_/A1 _09769_/S VDD VSS sg13g2_mux2_1
XFILLER_74_759 VDD VSS sg13g2_fill_2
XFILLER_6_1092 VDD VSS sg13g2_decap_8
XFILLER_27_642 VDD VSS sg13g2_decap_4
X_08719_ _15192_/D input19/X _15192_/Q _08719_/S VDD VSS sg13g2_mux2_1
XFILLER_73_258 VDD VSS sg13g2_fill_2
X_09699_ _14291_/D _09831_/A0 _14291_/Q _09704_/S VDD VSS sg13g2_mux2_1
XFILLER_54_450 VDD VSS sg13g2_decap_8
XFILLER_55_984 VDD VSS sg13g2_decap_8
XFILLER_42_601 VDD VSS sg13g2_decap_8
X_11730_ _11730_/Y _11759_/A _14122_/Q VDD VSS sg13g2_nand2b_1
XFILLER_109_1004 VDD VSS sg13g2_decap_8
XFILLER_25_42 VDD VSS sg13g2_decap_8
XFILLER_14_336 VDD VSS sg13g2_decap_8
X_11661_ _11773_/B _11661_/A _13680_/Q VDD VSS sg13g2_xnor2_1
XFILLER_30_829 VDD VSS sg13g2_decap_8
XFILLER_168_842 VDD VSS sg13g2_decap_8
XFILLER_186_138 VDD VSS sg13g2_decap_8
X_13400_ _13400_/Y _13437_/A _13469_/A _15088_/Q VDD VSS sg13g2_nand3_1
XFILLER_41_177 VDD VSS sg13g2_decap_8
XFILLER_35_1234 VDD VSS sg13g2_fill_1
XFILLER_186_149 VDD VSS sg13g2_decap_8
X_10612_ _10614_/B _14880_/Q _14879_/Q VDD VSS sg13g2_nand2_1
XFILLER_23_881 VDD VSS sg13g2_decap_8
X_14380_ _14380_/Q clkload50/A _14380_/D _14380_/RESET_B VDD VSS sg13g2_dfrbpq_1
X_14966__2714 _14966_/RESET_B VDD VSS sg13g2_tiehi
XFILLER_122_1204 VDD VSS sg13g2_decap_4
XFILLER_168_864 VDD VSS sg13g2_decap_8
X_11592_ _11593_/B _11570_/A _13683_/Q _11571_/Y VDD VSS sg13g2_a21oi_1
XFILLER_70_1136 VDD VSS sg13g2_fill_1
XFILLER_70_1147 VDD VSS sg13g2_fill_2
XFILLER_35_1267 VDD VSS sg13g2_decap_8
XFILLER_122_1237 VDD VSS sg13g2_decap_8
X_13331_ _15173_/D _13502_/B VDD VSS sg13g2_inv_1
XFILLER_10_553 VDD VSS sg13g2_decap_8
XFILLER_128_739 VDD VSS sg13g2_decap_4
XFILLER_183_823 VDD VSS sg13g2_decap_8
X_10543_ _10544_/B _14863_/Q _10566_/D _10543_/C _10543_/D VDD VSS sg13g2_nand4_1
XFILLER_182_322 VDD VSS sg13g2_decap_8
XFILLER_41_63 VDD VSS sg13g2_decap_8
XFILLER_155_558 VDD VSS sg13g2_decap_8
X_13262_ _13262_/Y _14797_/Q _13275_/A2 _13275_/B1 VDD VSS sg13g2_o21ai_1
XFILLER_6_546 VDD VSS sg13g2_decap_8
X_14369__1903 _14369_/RESET_B VDD VSS sg13g2_tiehi
X_10474_ _10474_/Y _10486_/D _10492_/C _10630_/C VDD VSS sg13g2_o21ai_1
XFILLER_109_986 VDD VSS sg13g2_decap_8
X_15001_ _15001_/Q clkload77/A _15001_/D _15001_/RESET_B VDD VSS sg13g2_dfrbpq_1
X_12213_ _12213_/X _14135_/Q _14167_/Q _14199_/Q _14231_/Q _12213_/S0 _12215_/S1 VDD
+ VSS sg13g2_mux4_1
XFILLER_109_997 VDD VSS sg13g2_decap_8
XFILLER_124_923 VDD VSS sg13g2_decap_8
XFILLER_136_794 VDD VSS sg13g2_fill_2
XFILLER_182_399 VDD VSS sg13g2_decap_8
X_13193_ _13196_/A _14792_/Q _13193_/B VDD VSS sg13g2_nand2_1
XFILLER_159_1171 VDD VSS sg13g2_decap_8
XFILLER_124_956 VDD VSS sg13g2_decap_8
XFILLER_155_1013 VDD VSS sg13g2_decap_8
XFILLER_151_742 VDD VSS sg13g2_decap_4
XFILLER_159_1193 VDD VSS sg13g2_fill_2
X_12144_ _12144_/Y _12292_/A _12144_/B VDD VSS sg13g2_nor2_1
XFILLER_151_775 VDD VSS sg13g2_decap_8
XFILLER_2_763 VDD VSS sg13g2_decap_8
XFILLER_46_1341 VDD VSS sg13g2_decap_8
XFILLER_110_105 VDD VSS sg13g2_fill_2
XFILLER_155_1079 VDD VSS sg13g2_decap_8
XFILLER_133_1311 VDD VSS sg13g2_decap_8
XFILLER_150_285 VDD VSS sg13g2_decap_8
X_12075_ _12077_/B _12291_/A _12075_/B VDD VSS sg13g2_nor2_1
XFILLER_81_1243 VDD VSS sg13g2_decap_4
XFILLER_173_84 VDD VSS sg13g2_decap_8
XFILLER_1_273 VDD VSS sg13g2_decap_8
XFILLER_89_380 VDD VSS sg13g2_decap_8
XFILLER_77_520 VDD VSS sg13g2_decap_8
XFILLER_49_211 VDD VSS sg13g2_fill_1
XFILLER_2_35 VDD VSS sg13g2_decap_8
XFILLER_110_149 VDD VSS sg13g2_fill_2
X_11026_ _11029_/A _11022_/Y _11064_/B _11025_/Y VDD VSS sg13g2_o21ai_1
XFILLER_38_907 VDD VSS sg13g2_decap_8
XFILLER_42_1238 VDD VSS sg13g2_decap_4
XFILLER_38_918 VDD VSS sg13g2_fill_1
X_16883_ _16883_/X _16883_/A VDD VSS sg13g2_buf_1
XFILLER_65_704 VDD VSS sg13g2_decap_8
XFILLER_77_575 VDD VSS sg13g2_decap_8
XFILLER_64_203 VDD VSS sg13g2_decap_8
XFILLER_92_523 VDD VSS sg13g2_fill_1
XFILLER_168_1418 VDD VSS sg13g2_decap_8
XFILLER_49_299 VDD VSS sg13g2_decap_8
XFILLER_37_439 VDD VSS sg13g2_decap_4
XFILLER_92_545 VDD VSS sg13g2_decap_8
XFILLER_66_93 VDD VSS sg13g2_decap_4
XFILLER_18_653 VDD VSS sg13g2_decap_4
X_12977_ _12977_/Y _14810_/Q _13274_/A2 _13249_/B _14874_/Q _13082_/B VDD VSS sg13g2_a221oi_1
XFILLER_80_718 VDD VSS sg13g2_decap_8
XFILLER_80_729 VDD VSS sg13g2_fill_2
XFILLER_46_984 VDD VSS sg13g2_decap_8
X_13857__2415 _13857_/RESET_B VDD VSS sg13g2_tiehi
X_14716_ _14716_/Q _14716_/CLK _14716_/D _14716_/RESET_B VDD VSS sg13g2_dfrbpq_1
X_11928_ _11928_/X _11920_/X _11921_/X _11923_/X _11922_/X _12029_/B _12048_/A1 VDD
+ VSS sg13g2_mux4_1
XFILLER_166_1153 VDD VSS sg13g2_decap_8
XFILLER_61_943 VDD VSS sg13g2_decap_8
XFILLER_17_196 VDD VSS sg13g2_decap_8
XFILLER_72_291 VDD VSS sg13g2_decap_8
XFILLER_36_1009 VDD VSS sg13g2_decap_8
XFILLER_177_105 VDD VSS sg13g2_decap_8
X_14647_ _14647_/Q clkload47/A _14647_/D _14647_/RESET_B VDD VSS sg13g2_dfrbpq_1
XFILLER_60_453 VDD VSS sg13g2_decap_8
XFILLER_32_144 VDD VSS sg13g2_decap_8
XFILLER_162_1028 VDD VSS sg13g2_decap_8
XFILLER_166_1197 VDD VSS sg13g2_fill_1
X_11859_ _11859_/Y _11765_/A _11857_/X _11858_/Y VDD VSS sg13g2_o21ai_1
XFILLER_57_1470 VDD VSS sg13g2_fill_2
XFILLER_21_829 VDD VSS sg13g2_decap_8
XFILLER_105_1402 VDD VSS sg13g2_fill_2
XANTENNA_18 wire439/X VDD VSS sg13g2_antennanp
XANTENNA_29 fanout1507/X VDD VSS sg13g2_antennanp
XFILLER_18_1465 VDD VSS sg13g2_decap_8
X_14578_ _14578_/Q _14610_/CLK _14578_/D _14578_/RESET_B VDD VSS sg13g2_dfrbpq_1
XFILLER_140_1304 VDD VSS sg13g2_decap_8
XFILLER_144_1473 VDD VSS sg13g2_fill_2
XFILLER_146_503 VDD VSS sg13g2_fill_2
X_14237__2035 _14237_/RESET_B VDD VSS sg13g2_tiehi
X_13529_ _13529_/X _13529_/A _13533_/B VDD VSS sg13g2_and2_1
XFILLER_158_385 VDD VSS sg13g2_decap_8
XFILLER_174_834 VDD VSS sg13g2_decap_8
XFILLER_185_182 VDD VSS sg13g2_decap_8
XFILLER_174_867 VDD VSS sg13g2_decap_8
XFILLER_51_1080 VDD VSS sg13g2_decap_8
XFILLER_103_1170 VDD VSS sg13g2_decap_8
XFILLER_115_901 VDD VSS sg13g2_fill_2
XFILLER_12_1064 VDD VSS sg13g2_decap_8
XFILLER_173_366 VDD VSS sg13g2_decap_8
Xoutput103 mem_axi_rready _07658_/X VDD VSS sg13g2_buf_1
Xoutput114 mem_axi_wdata[19] _15151_/Q VDD VSS sg13g2_buf_1
XFILLER_99_100 VDD VSS sg13g2_fill_2
XFILLER_126_271 VDD VSS sg13g2_decap_4
XFILLER_142_720 VDD VSS sg13g2_decap_8
XFILLER_154_580 VDD VSS sg13g2_fill_1
Xoutput125 mem_axi_wdata[29] _15161_/Q VDD VSS sg13g2_buf_1
Xoutput136 mem_axi_wstrb[0] _15164_/Q VDD VSS sg13g2_buf_1
XFILLER_138_1233 VDD VSS sg13g2_decap_4
XFILLER_86_1176 VDD VSS sg13g2_decap_8
XFILLER_49_0 VDD VSS sg13g2_decap_8
XFILLER_47_1149 VDD VSS sg13g2_decap_8
XFILLER_142_775 VDD VSS sg13g2_decap_4
XFILLER_173_1157 VDD VSS sg13g2_decap_8
X_15077__2934 _15077_/RESET_B VDD VSS sg13g2_tiehi
XFILLER_114_488 VDD VSS sg13g2_decap_8
X_07952_ _07952_/Y _15009_/Q _07821_/B VDD VSS sg13g2_nor2b_1
XFILLER_151_1411 VDD VSS sg13g2_decap_8
XFILLER_96_840 VDD VSS sg13g2_fill_2
XFILLER_29_907 VDD VSS sg13g2_decap_8
XFILLER_68_553 VDD VSS sg13g2_decap_8
X_07883_ _08073_/C _07884_/A _08063_/B VDD VSS sg13g2_nand2_1
XFILLER_68_564 VDD VSS sg13g2_fill_2
XFILLER_60_1338 VDD VSS sg13g2_decap_8
XFILLER_29_918 VDD VSS sg13g2_fill_2
XFILLER_96_884 VDD VSS sg13g2_decap_8
XFILLER_25_1469 VDD VSS sg13g2_decap_4
XFILLER_151_1477 VDD VSS sg13g2_fill_2
X_09622_ _14218_/D _09622_/A0 _14218_/Q _09638_/S VDD VSS sg13g2_mux2_1
XFILLER_95_372 VDD VSS sg13g2_decap_8
XFILLER_3_1232 VDD VSS sg13g2_decap_8
X_13670__2625 _13670_/RESET_B VDD VSS sg13g2_tiehi
X_09553_ _14151_/D _09619_/A0 _14151_/Q _09567_/S VDD VSS sg13g2_mux2_1
XFILLER_71_707 VDD VSS sg13g2_decap_4
XFILLER_55_269 VDD VSS sg13g2_decap_4
XFILLER_71_729 VDD VSS sg13g2_decap_8
XFILLER_58_1212 VDD VSS sg13g2_decap_8
X_08504_ _08504_/Y _15009_/Q _07821_/B _08497_/A VDD VSS sg13g2_a21oi_1
XFILLER_70_217 VDD VSS sg13g2_fill_2
XFILLER_24_612 VDD VSS sg13g2_decap_8
XFILLER_149_1351 VDD VSS sg13g2_decap_8
XFILLER_110_1196 VDD VSS sg13g2_decap_8
X_14447__1825 _14447_/RESET_B VDD VSS sg13g2_tiehi
X_09484_ _14084_/D _10047_/A0 _14084_/Q _09501_/S VDD VSS sg13g2_mux2_1
XFILLER_24_634 VDD VSS sg13g2_decap_8
XFILLER_169_606 VDD VSS sg13g2_decap_8
XFILLER_58_1267 VDD VSS sg13g2_decap_8
XFILLER_180_1106 VDD VSS sg13g2_decap_8
XFILLER_52_965 VDD VSS sg13g2_decap_4
XFILLER_168_105 VDD VSS sg13g2_decap_8
X_08435_ _08435_/Y _08435_/A _08442_/B VDD VSS sg13g2_nand2_1
XFILLER_52_998 VDD VSS sg13g2_decap_8
X_08366_ _08366_/X _08414_/D _08414_/A _08414_/B _08366_/D VDD VSS sg13g2_or4_1
XFILLER_20_840 VDD VSS sg13g2_decap_8
XFILLER_165_812 VDD VSS sg13g2_fill_2
XFILLER_177_683 VDD VSS sg13g2_decap_8
XFILLER_183_119 VDD VSS sg13g2_decap_8
XFILLER_71_1478 VDD VSS sg13g2_fill_1
XFILLER_109_216 VDD VSS sg13g2_decap_8
X_14662__1610 _14662_/RESET_B VDD VSS sg13g2_tiehi
X_08297_ _08297_/Y _08248_/A _08294_/Y _08296_/Y _08295_/Y VDD VSS sg13g2_a22oi_1
XFILLER_127_7 VDD VSS sg13g2_decap_8
XFILLER_165_845 VDD VSS sg13g2_decap_4
XFILLER_176_182 VDD VSS sg13g2_decap_8
X_14954__2729 _14954_/RESET_B VDD VSS sg13g2_tiehi
XFILLER_178_1046 VDD VSS sg13g2_decap_8
XFILLER_139_1008 VDD VSS sg13g2_fill_2
XFILLER_106_923 VDD VSS sg13g2_decap_8
XFILLER_124_219 VDD VSS sg13g2_decap_8
X_14091__2181 _14091_/RESET_B VDD VSS sg13g2_tiehi
XFILLER_105_422 VDD VSS sg13g2_decap_8
XFILLER_11_77 VDD VSS sg13g2_decap_8
XFILLER_69_1374 VDD VSS sg13g2_decap_8
XFILLER_133_742 VDD VSS sg13g2_decap_8
XFILLER_156_1333 VDD VSS sg13g2_decap_8
X_10190_ _14752_/D _15195_/D _14752_/Q _13647_/S VDD VSS sg13g2_mux2_1
XFILLER_127_77 VDD VSS sg13g2_decap_8
XFILLER_160_550 VDD VSS sg13g2_decap_8
XFILLER_87_37 VDD VSS sg13g2_decap_8
XFILLER_65_1249 VDD VSS sg13g2_decap_8
XFILLER_105_488 VDD VSS sg13g2_fill_2
X_13935__2337 _13935_/RESET_B VDD VSS sg13g2_tiehi
XFILLER_78_317 VDD VSS sg13g2_decap_8
X_14695__1577 _14695_/RESET_B VDD VSS sg13g2_tiehi
Xfanout1306 _13190_/B _13669_/Q VDD VSS sg13g2_buf_1
Xfanout1317 _11446_/A _12221_/B1 VDD VSS sg13g2_buf_1
X_15030__2650 _15030_/RESET_B VDD VSS sg13g2_tiehi
Xfanout330 _10167_/S _10163_/S VDD VSS sg13g2_buf_1
Xfanout1328 _11450_/A1 _13660_/Q VDD VSS sg13g2_buf_1
XFILLER_28_1060 VDD VSS sg13g2_decap_8
Xfanout1339 _11850_/S1 fanout1350/X VDD VSS sg13g2_buf_1
Xfanout352 _09921_/S _09925_/S VDD VSS sg13g2_buf_1
XFILLER_87_851 VDD VSS sg13g2_fill_2
XFILLER_59_553 VDD VSS sg13g2_fill_2
Xfanout374 _09727_/S _09739_/S VDD VSS sg13g2_buf_1
XFILLER_8_1176 VDD VSS sg13g2_decap_8
XFILLER_59_564 VDD VSS sg13g2_fill_2
XFILLER_115_1063 VDD VSS sg13g2_decap_8
XFILLER_19_406 VDD VSS sg13g2_fill_1
Xfanout385 _09636_/S _09606_/Y VDD VSS sg13g2_buf_1
XFILLER_74_501 VDD VSS sg13g2_decap_8
XFILLER_19_417 VDD VSS sg13g2_decap_8
X_12900_ _12902_/B _12900_/A _12900_/B _12900_/C input18/X VDD VSS sg13g2_nand4_1
Xfanout396 _09333_/S _09327_/S VDD VSS sg13g2_buf_1
XFILLER_4_1029 VDD VSS sg13g2_decap_8
X_13880_ _13880_/Q clkload25/A _13880_/D _13880_/RESET_B VDD VSS sg13g2_dfrbpq_1
XFILLER_185_1006 VDD VSS sg13g2_fill_1
X_12831_ _12831_/Y _14769_/Q _13275_/A2 _13140_/B2 VDD VSS sg13g2_o21ai_1
XFILLER_167_1440 VDD VSS sg13g2_fill_2
XFILLER_76_1323 VDD VSS sg13g2_fill_1
XFILLER_36_63 VDD VSS sg13g2_decap_8
XFILLER_15_623 VDD VSS sg13g2_decap_8
X_12762_ _12762_/X _12760_/X _12761_/X _12762_/S VDD VSS sg13g2_mux2_1
XFILLER_76_1345 VDD VSS sg13g2_decap_8
XFILLER_61_239 VDD VSS sg13g2_fill_2
XFILLER_36_96 VDD VSS sg13g2_fill_1
X_14501_ _14501_/Q clkload14/A _14501_/D _14501_/RESET_B VDD VSS sg13g2_dfrbpq_1
XFILLER_76_1367 VDD VSS sg13g2_decap_8
XFILLER_14_133 VDD VSS sg13g2_decap_8
XFILLER_153_0 VDD VSS sg13g2_decap_8
X_11713_ _11713_/X _13961_/Q _13993_/Q _14025_/Q _14057_/Q _11713_/S0 _11713_/S1 VDD
+ VSS sg13g2_mux4_1
XFILLER_70_762 VDD VSS sg13g2_decap_8
X_12693_ _12694_/B _13190_/B _12693_/A2 _12692_/X _12415_/A _12791_/C1 VDD VSS sg13g2_a221oi_1
XFILLER_30_604 VDD VSS sg13g2_decap_8
XFILLER_159_138 VDD VSS sg13g2_decap_8
X_14432_ _14432_/Q _14656_/CLK _14432_/D _14432_/RESET_B VDD VSS sg13g2_dfrbpq_1
X_11644_ _11644_/X _14695_/Q _14727_/Q _13767_/Q _13799_/Q _11528_/S _11532_/C VDD
+ VSS sg13g2_mux4_1
XFILLER_11_840 VDD VSS sg13g2_decap_8
XFILLER_126_1181 VDD VSS sg13g2_decap_8
XFILLER_174_119 VDD VSS sg13g2_decap_8
XFILLER_35_1064 VDD VSS sg13g2_decap_8
XFILLER_161_1072 VDD VSS sg13g2_fill_2
X_14363_ _14363_/Q clkload58/A _14363_/D _14363_/RESET_B VDD VSS sg13g2_dfrbpq_1
XFILLER_10_350 VDD VSS sg13g2_decap_8
XFILLER_155_311 VDD VSS sg13g2_decap_8
XFILLER_156_834 VDD VSS sg13g2_decap_4
XFILLER_161_1083 VDD VSS sg13g2_fill_1
XFILLER_168_694 VDD VSS sg13g2_decap_8
Xinput16 input16/X input16/A VDD VSS sg13g2_buf_1
X_11575_ _11575_/X _13829_/Q _13861_/Q _13893_/Q _13925_/Q _11925_/S0 _11925_/S1 VDD
+ VSS sg13g2_mux4_1
Xinput27 input27/X input27/A VDD VSS sg13g2_buf_1
XFILLER_7_833 VDD VSS sg13g2_decap_8
XFILLER_167_182 VDD VSS sg13g2_decap_8
XFILLER_168_84 VDD VSS sg13g2_decap_8
XFILLER_183_642 VDD VSS sg13g2_decap_8
X_13314_ _13314_/X _15061_/Q _13316_/B _13316_/C VDD VSS sg13g2_and3_1
X_14784__3022 _14784_/RESET_B VDD VSS sg13g2_tiehi
Xinput38 input38/X rst_ni VDD VSS sg13g2_buf_1
X_10526_ _14857_/D _10558_/C _10531_/D _10525_/Y VDD VSS sg13g2_a21oi_1
XFILLER_109_750 VDD VSS sg13g2_fill_1
XFILLER_13_1351 VDD VSS sg13g2_decap_8
XFILLER_155_355 VDD VSS sg13g2_decap_8
X_14294_ _14294_/Q _14518_/CLK _14294_/D _14294_/RESET_B VDD VSS sg13g2_dfrbpq_1
XFILLER_6_343 VDD VSS sg13g2_decap_8
XFILLER_171_815 VDD VSS sg13g2_fill_2
Xmax_cap508 _09472_/S _09467_/S VDD VSS sg13g2_buf_8
XFILLER_171_837 VDD VSS sg13g2_decap_8
X_13245_ _13245_/X _13245_/A _13665_/Q _13246_/C VDD VSS sg13g2_and3_1
XFILLER_136_580 VDD VSS sg13g2_fill_1
XFILLER_174_1400 VDD VSS sg13g2_decap_8
X_10457_ _10460_/C _14841_/Q _10462_/D _14842_/Q VDD VSS sg13g2_a21oi_1
XFILLER_182_196 VDD VSS sg13g2_decap_8
XFILLER_87_1474 VDD VSS sg13g2_decap_4
X_13176_ _13188_/A _13176_/A _13176_/B _13176_/C VDD VSS sg13g2_nand3_1
XFILLER_83_1327 VDD VSS sg13g2_fill_2
XFILLER_42_7 VDD VSS sg13g2_decap_8
XFILLER_123_241 VDD VSS sg13g2_fill_1
X_10388_ _10388_/Y _14820_/Q _10386_/C _10630_/C VDD VSS sg13g2_o21ai_1
XFILLER_69_306 VDD VSS sg13g2_fill_2
XFILLER_135_1428 VDD VSS sg13g2_decap_4
XFILLER_170_1308 VDD VSS sg13g2_decap_8
XFILLER_2_560 VDD VSS sg13g2_decap_8
X_12127_ _12155_/A _12128_/A _13667_/Q VDD VSS sg13g2_nand2_1
XFILLER_112_948 VDD VSS sg13g2_decap_8
XFILLER_123_285 VDD VSS sg13g2_decap_8
X_14525__1747 _14525_/RESET_B VDD VSS sg13g2_tiehi
X_12058_ _12058_/Y _12012_/A _12008_/Y _12010_/B VDD VSS sg13g2_o21ai_1
XFILLER_81_1073 VDD VSS sg13g2_fill_2
XFILLER_77_70 VDD VSS sg13g2_decap_8
XFILLER_93_810 VDD VSS sg13g2_fill_2
XFILLER_77_361 VDD VSS sg13g2_decap_8
XFILLER_42_1046 VDD VSS sg13g2_decap_8
X_11009_ _11010_/C _11009_/A _11009_/B _11009_/C _11009_/D VDD VSS sg13g2_nand4_1
XFILLER_38_737 VDD VSS sg13g2_decap_8
XFILLER_93_832 VDD VSS sg13g2_decap_4
X_16866_ _16866_/X _16866_/A VDD VSS sg13g2_buf_1
XFILLER_168_1204 VDD VSS sg13g2_decap_8
X_14815__2991 _14815_/RESET_B VDD VSS sg13g2_tiehi
XFILLER_92_331 VDD VSS sg13g2_decap_4
XFILLER_93_865 VDD VSS sg13g2_fill_2
XFILLER_20_1322 VDD VSS sg13g2_decap_8
XFILLER_77_1109 VDD VSS sg13g2_decap_8
XFILLER_19_962 VDD VSS sg13g2_decap_8
X_15231__3092 _15231_/RESET_B VDD VSS sg13g2_tiehi
XFILLER_111_1461 VDD VSS sg13g2_decap_8
X_14740__1532 _14740_/RESET_B VDD VSS sg13g2_tiehi
XFILLER_25_409 VDD VSS sg13g2_fill_1
XFILLER_34_910 VDD VSS sg13g2_decap_8
XFILLER_52_217 VDD VSS sg13g2_decap_8
XFILLER_46_770 VDD VSS sg13g2_decap_8
XFILLER_18_483 VDD VSS sg13g2_decap_8
XFILLER_94_1445 VDD VSS sg13g2_decap_8
XFILLER_93_91 VDD VSS sg13g2_decap_8
XFILLER_80_548 VDD VSS sg13g2_decap_8
XFILLER_20_1399 VDD VSS sg13g2_decap_8
XFILLER_21_604 VDD VSS sg13g2_decap_8
XFILLER_179_959 VDD VSS sg13g2_decap_8
X_08220_ _08220_/X _08235_/A0 _13545_/A _08220_/B1 VDD VSS sg13g2_a21o_1
XFILLER_60_283 VDD VSS sg13g2_decap_8
XFILLER_159_650 VDD VSS sg13g2_decap_8
XFILLER_178_469 VDD VSS sg13g2_decap_8
XFILLER_60_294 VDD VSS sg13g2_fill_2
XFILLER_18_1262 VDD VSS sg13g2_decap_8
XFILLER_105_1221 VDD VSS sg13g2_decap_8
XFILLER_144_1270 VDD VSS sg13g2_decap_8
XFILLER_159_661 VDD VSS sg13g2_decap_4
XFILLER_140_1112 VDD VSS sg13g2_decap_8
XFILLER_20_147 VDD VSS sg13g2_decap_8
X_08151_ _08151_/X _11428_/A _07879_/A _11384_/A _08063_/B _08033_/A _07900_/B VDD
+ VSS sg13g2_mux4_1
XFILLER_179_1311 VDD VSS sg13g2_fill_1
XFILLER_186_480 VDD VSS sg13g2_decap_8
XFILLER_14_1148 VDD VSS sg13g2_decap_8
XFILLER_174_631 VDD VSS sg13g2_decap_8
XFILLER_186_491 VDD VSS sg13g2_decap_8
XFILLER_146_355 VDD VSS sg13g2_decap_8
X_08082_ _08082_/X _08081_/X _08079_/X _08194_/B VDD VSS sg13g2_mux2_1
XFILLER_140_1178 VDD VSS sg13g2_decap_8
XFILLER_162_815 VDD VSS sg13g2_decap_8
XFILLER_31_1462 VDD VSS sg13g2_decap_8
XFILLER_161_314 VDD VSS sg13g2_decap_8
XFILLER_173_196 VDD VSS sg13g2_decap_8
XFILLER_161_358 VDD VSS sg13g2_decap_8
XFILLER_177_1090 VDD VSS sg13g2_decap_8
XFILLER_114_252 VDD VSS sg13g2_decap_8
XFILLER_138_1052 VDD VSS sg13g2_decap_4
XFILLER_142_583 VDD VSS sg13g2_decap_8
XFILLER_87_114 VDD VSS sg13g2_decap_8
X_08984_ _13758_/D _13758_/Q _10141_/A1 _09127_/S VDD VSS sg13g2_mux2_1
XFILLER_130_745 VDD VSS sg13g2_decap_4
XFILLER_88_659 VDD VSS sg13g2_decap_8
XFILLER_130_756 VDD VSS sg13g2_fill_2
XFILLER_64_1260 VDD VSS sg13g2_decap_4
XFILLER_57_18 VDD VSS sg13g2_fill_1
XFILLER_9_1463 VDD VSS sg13g2_decap_8
XFILLER_116_1350 VDD VSS sg13g2_decap_8
X_07935_ _07935_/Y _08414_/D _07934_/Y _07933_/Y VDD VSS sg13g2_a21oi_1
XFILLER_9_1474 VDD VSS sg13g2_fill_1
XFILLER_112_1203 VDD VSS sg13g2_decap_8
XFILLER_151_1252 VDD VSS sg13g2_decap_4
XFILLER_60_1135 VDD VSS sg13g2_fill_1
XFILLER_5_1316 VDD VSS sg13g2_decap_8
XFILLER_116_1372 VDD VSS sg13g2_decap_8
XFILLER_56_501 VDD VSS sg13g2_fill_2
XFILLER_25_1266 VDD VSS sg13g2_decap_8
XFILLER_29_737 VDD VSS sg13g2_fill_2
X_07866_ _07866_/Y _07969_/A _08678_/A _08650_/A _07867_/D VDD VSS sg13g2_nor4_1
XFILLER_99_1345 VDD VSS sg13g2_decap_8
XFILLER_56_545 VDD VSS sg13g2_decap_8
X_09605_ _14202_/D _14202_/Q _09739_/A0 _09605_/S VDD VSS sg13g2_mux2_1
XFILLER_186_1326 VDD VSS sg13g2_decap_8
XFILLER_186_1337 VDD VSS sg13g2_decap_8
XFILLER_56_578 VDD VSS sg13g2_decap_8
X_07797_ _07797_/X _07797_/A _07797_/B _07797_/C _07797_/D VDD VSS sg13g2_or4_1
XFILLER_43_206 VDD VSS sg13g2_fill_2
X_09536_ _14135_/D _10099_/A0 _14135_/Q _09538_/S VDD VSS sg13g2_mux2_1
XFILLER_24_442 VDD VSS sg13g2_fill_2
XFILLER_58_1064 VDD VSS sg13g2_fill_1
XFILLER_40_902 VDD VSS sg13g2_decap_8
XFILLER_149_1192 VDD VSS sg13g2_decap_4
X_09467_ _14068_/D _10096_/A0 _14068_/Q _09467_/S VDD VSS sg13g2_mux2_1
XFILLER_145_1034 VDD VSS sg13g2_fill_2
XFILLER_58_1097 VDD VSS sg13g2_decap_8
XFILLER_12_637 VDD VSS sg13g2_decap_8
X_08418_ _08419_/A _08418_/A _08418_/B VDD VSS sg13g2_and2_1
X_09398_ _14001_/D _09596_/A1 _14001_/Q _09399_/S VDD VSS sg13g2_mux2_1
XFILLER_11_147 VDD VSS sg13g2_decap_8
XFILLER_184_417 VDD VSS sg13g2_decap_4
XFILLER_40_979 VDD VSS sg13g2_decap_8
XFILLER_162_1381 VDD VSS sg13g2_decap_8
XFILLER_137_300 VDD VSS sg13g2_decap_8
X_14603__1669 _14603_/RESET_B VDD VSS sg13g2_tiehi
X_15161__2728 _15161_/RESET_B VDD VSS sg13g2_tiehi
X_08349_ _08353_/A _08414_/A _08366_/D _08348_/Y VDD VSS sg13g2_o21ai_1
XFILLER_22_21 VDD VSS sg13g2_decap_8
XFILLER_138_856 VDD VSS sg13g2_decap_8
XFILLER_149_193 VDD VSS sg13g2_decap_8
XFILLER_165_653 VDD VSS sg13g2_decap_8
X_11360_ _11360_/Y _11357_/Y _11359_/Y _11831_/B1 VDD VSS sg13g2_a21oi_1
XFILLER_165_664 VDD VSS sg13g2_decap_8
XFILLER_138_65 VDD VSS sg13g2_decap_8
XFILLER_22_98 VDD VSS sg13g2_decap_8
XFILLER_152_314 VDD VSS sg13g2_decap_8
XFILLER_180_623 VDD VSS sg13g2_decap_8
X_10311_ _10342_/C _10311_/A _10311_/B _10311_/C _10327_/C VDD VSS sg13g2_and4_1
XFILLER_98_14 VDD VSS sg13g2_decap_8
XFILLER_125_539 VDD VSS sg13g2_fill_1
X_11291_ _11292_/B _11291_/A _12836_/B VDD VSS sg13g2_xnor2_1
XFILLER_4_847 VDD VSS sg13g2_decap_8
XFILLER_180_667 VDD VSS sg13g2_decap_4
X_13030_ _13030_/Y _14781_/Q _13220_/A2 _13220_/B1 VDD VSS sg13g2_o21ai_1
XFILLER_65_1002 VDD VSS sg13g2_fill_2
X_10242_ _14775_/D _14775_/Q _10247_/D _10241_/Y VDD VSS sg13g2_a21oi_1
XFILLER_3_357 VDD VSS sg13g2_decap_8
XFILLER_121_701 VDD VSS sg13g2_decap_8
XFILLER_180_689 VDD VSS sg13g2_decap_8
XFILLER_121_712 VDD VSS sg13g2_fill_2
XFILLER_106_797 VDD VSS sg13g2_decap_8
XFILLER_156_1163 VDD VSS sg13g2_decap_8
XFILLER_120_200 VDD VSS sg13g2_decap_8
XFILLER_133_583 VDD VSS sg13g2_fill_1
XFILLER_133_594 VDD VSS sg13g2_decap_8
XFILLER_152_1016 VDD VSS sg13g2_decap_8
X_14898__2841 _14898_/RESET_B VDD VSS sg13g2_tiehi
Xfanout1103 _08174_/A _08035_/A VDD VSS sg13g2_buf_1
X_10173_ _10173_/Y _10185_/B _13508_/C _10178_/A VDD VSS sg13g2_nand3_1
XFILLER_152_1027 VDD VSS sg13g2_fill_2
XFILLER_154_64 VDD VSS sg13g2_decap_8
XFILLER_160_391 VDD VSS sg13g2_decap_4
Xfanout1114 _08460_/A1 _14992_/Q VDD VSS sg13g2_buf_1
XFILLER_82_1360 VDD VSS sg13g2_decap_8
XFILLER_121_767 VDD VSS sg13g2_decap_8
XFILLER_154_75 VDD VSS sg13g2_fill_2
Xfanout1125 _08635_/S1 _08598_/S1 VDD VSS sg13g2_buf_1
Xfanout1136 _13521_/A _14990_/Q VDD VSS sg13g2_buf_1
Xfanout1147 _07900_/B _14989_/Q VDD VSS sg13g2_buf_1
XFILLER_120_266 VDD VSS sg13g2_fill_2
X_14981_ _14981_/Q _14982_/CLK _14981_/D _14981_/RESET_B VDD VSS sg13g2_dfrbpq_1
Xfanout160 _10066_/A0 fanout162/X VDD VSS sg13g2_buf_1
Xfanout1158 _07965_/B _12152_/A VDD VSS sg13g2_buf_1
Xfanout171 _09899_/A0 _09131_/X VDD VSS sg13g2_buf_1
XFILLER_87_670 VDD VSS sg13g2_decap_8
XFILLER_19_203 VDD VSS sg13g2_decap_8
Xfanout1169 _08541_/B _08598_/A3 VDD VSS sg13g2_buf_1
XFILLER_75_821 VDD VSS sg13g2_decap_8
Xfanout182 _09896_/A0 _09597_/A1 VDD VSS sg13g2_buf_1
XFILLER_59_383 VDD VSS sg13g2_decap_8
X_13932_ _13932_/Q _14540_/CLK _13932_/D _13932_/RESET_B VDD VSS sg13g2_dfrbpq_1
Xfanout193 _10091_/A0 _09627_/A0 VDD VSS sg13g2_buf_1
XFILLER_93_139 VDD VSS sg13g2_decap_8
XFILLER_43_1377 VDD VSS sg13g2_decap_8
XFILLER_86_191 VDD VSS sg13g2_decap_8
XFILLER_47_567 VDD VSS sg13g2_fill_2
XFILLER_170_63 VDD VSS sg13g2_decap_8
X_13863_ _13863_/Q _14741_/CLK _13863_/D _13863_/RESET_B VDD VSS sg13g2_dfrbpq_1
XFILLER_78_1429 VDD VSS sg13g2_decap_8
X_12814_ _12814_/Y _12900_/B input12/X _12814_/C VDD VSS sg13g2_nand3_1
XFILLER_90_846 VDD VSS sg13g2_fill_2
XFILLER_74_397 VDD VSS sg13g2_fill_1
XFILLER_62_537 VDD VSS sg13g2_decap_8
XFILLER_15_420 VDD VSS sg13g2_decap_8
X_13794_ _13794_/Q clkload40/A _13794_/D _13794_/RESET_B VDD VSS sg13g2_dfrbpq_1
XFILLER_76_1131 VDD VSS sg13g2_fill_2
XFILLER_128_1221 VDD VSS sg13g2_decap_8
XFILLER_163_1101 VDD VSS sg13g2_decap_8
XFILLER_76_1153 VDD VSS sg13g2_fill_2
XFILLER_37_1115 VDD VSS sg13g2_decap_8
XFILLER_16_987 VDD VSS sg13g2_decap_8
X_12745_ _12745_/X _14263_/Q _14295_/Q _14327_/Q _14359_/Q _12745_/S0 _12745_/S1 VDD
+ VSS sg13g2_mux4_1
XFILLER_42_250 VDD VSS sg13g2_fill_2
XFILLER_42_272 VDD VSS sg13g2_decap_8
XFILLER_15_497 VDD VSS sg13g2_decap_8
XFILLER_54_1440 VDD VSS sg13g2_decap_4
X_12676_ _12676_/X _12673_/X _12672_/X _12671_/X _12670_/X wire853/A _12636_/S VDD
+ VSS sg13g2_mux4_1
XFILLER_31_957 VDD VSS sg13g2_fill_1
XFILLER_169_970 VDD VSS sg13g2_decap_8
XFILLER_169_981 VDD VSS sg13g2_fill_1
XFILLER_129_823 VDD VSS sg13g2_decap_8
XFILLER_15_1424 VDD VSS sg13g2_decap_8
X_14415_ _14415_/Q _14610_/CLK _14415_/D _14415_/RESET_B VDD VSS sg13g2_dfrbpq_1
XFILLER_175_439 VDD VSS sg13g2_decap_8
X_11627_ _11627_/Y _11622_/X _12000_/A _11625_/C VDD VSS sg13g2_a21oi_1
XFILLER_8_56 VDD VSS sg13g2_decap_8
XFILLER_128_333 VDD VSS sg13g2_decap_8
XFILLER_7_630 VDD VSS sg13g2_decap_8
X_14346_ _14346_/Q clkload17/A _14346_/D _14346_/RESET_B VDD VSS sg13g2_dfrbpq_1
XFILLER_156_664 VDD VSS sg13g2_decap_8
X_11558_ _11559_/B _11547_/Y _11549_/X _12046_/C VDD VSS sg13g2_o21ai_1
XFILLER_171_601 VDD VSS sg13g2_decap_8
XFILLER_144_826 VDD VSS sg13g2_fill_2
XFILLER_6_140 VDD VSS sg13g2_decap_8
XFILLER_183_483 VDD VSS sg13g2_decap_8
X_10509_ _10521_/D _10512_/A _10509_/B _10509_/C _10509_/D VDD VSS sg13g2_nor4_1
XFILLER_109_580 VDD VSS sg13g2_decap_8
XFILLER_155_185 VDD VSS sg13g2_decap_8
X_14277_ _14277_/Q clkload8/A _14277_/D _14277_/RESET_B VDD VSS sg13g2_dfrbpq_1
XFILLER_143_336 VDD VSS sg13g2_decap_8
X_11489_ _11489_/X _14370_/Q _14402_/Q _14466_/Q _14498_/Q _11489_/S0 _11489_/S1 VDD
+ VSS sg13g2_mux4_1
XFILLER_171_656 VDD VSS sg13g2_decap_4
XFILLER_170_133 VDD VSS sg13g2_decap_8
XFILLER_48_1211 VDD VSS sg13g2_decap_8
X_13228_ _13228_/Y _13228_/A _13228_/B _13228_/C VDD VSS sg13g2_nand3_1
XFILLER_171_678 VDD VSS sg13g2_decap_8
XFILLER_112_701 VDD VSS sg13g2_decap_8
XFILLER_100_1195 VDD VSS sg13g2_decap_8
XFILLER_97_401 VDD VSS sg13g2_decap_8
XFILLER_98_935 VDD VSS sg13g2_decap_8
XFILLER_135_1214 VDD VSS sg13g2_fill_1
XFILLER_69_114 VDD VSS sg13g2_decap_8
XFILLER_139_1394 VDD VSS sg13g2_decap_4
X_13159_ _13159_/Y _13174_/A _13158_/B _13170_/D VDD VSS sg13g2_a21oi_1
XFILLER_83_1157 VDD VSS sg13g2_fill_1
XFILLER_48_1277 VDD VSS sg13g2_fill_1
XFILLER_135_1247 VDD VSS sg13g2_fill_2
XFILLER_170_1127 VDD VSS sg13g2_decap_8
XFILLER_170_1138 VDD VSS sg13g2_fill_1
XFILLER_61_1411 VDD VSS sg13g2_decap_8
XFILLER_112_767 VDD VSS sg13g2_decap_8
X_14187__2085 _14187_/RESET_B VDD VSS sg13g2_tiehi
XFILLER_100_929 VDD VSS sg13g2_decap_8
XFILLER_97_489 VDD VSS sg13g2_decap_4
XFILLER_38_512 VDD VSS sg13g2_decap_4
X_07720_ _15217_/D _07720_/A _07720_/B _13345_/B VDD VSS sg13g2_or3_1
XFILLER_61_1466 VDD VSS sg13g2_decap_8
XFILLER_84_139 VDD VSS sg13g2_decap_8
XFILLER_66_843 VDD VSS sg13g2_decap_8
XFILLER_26_707 VDD VSS sg13g2_decap_8
XFILLER_168_1012 VDD VSS sg13g2_fill_1
X_07651_ _11023_/A _15118_/Q VDD VSS sg13g2_inv_1
XFILLER_65_353 VDD VSS sg13g2_fill_2
XFILLER_25_206 VDD VSS sg13g2_decap_8
XFILLER_4_1393 VDD VSS sg13g2_decap_8
XFILLER_19_792 VDD VSS sg13g2_decap_8
XFILLER_168_1067 VDD VSS sg13g2_decap_8
XFILLER_81_857 VDD VSS sg13g2_fill_1
XFILLER_129_1029 VDD VSS sg13g2_decap_8
XFILLER_179_701 VDD VSS sg13g2_fill_1
XFILLER_18_280 VDD VSS sg13g2_decap_8
XFILLER_0_1268 VDD VSS sg13g2_decap_8
XFILLER_20_1196 VDD VSS sg13g2_decap_8
X_09321_ _13928_/D wire262/X _13928_/Q _09333_/S VDD VSS sg13g2_mux2_1
XFILLER_80_367 VDD VSS sg13g2_decap_8
XFILLER_40_209 VDD VSS sg13g2_decap_8
XFILLER_33_250 VDD VSS sg13g2_decap_8
X_09252_ _13861_/D _13861_/Q _09883_/A0 _09265_/S VDD VSS sg13g2_mux2_1
XFILLER_90_1139 VDD VSS sg13g2_decap_4
XFILLER_55_1259 VDD VSS sg13g2_decap_8
XFILLER_22_946 VDD VSS sg13g2_decap_8
XFILLER_33_294 VDD VSS sg13g2_fill_2
XFILLER_166_406 VDD VSS sg13g2_decap_8
XFILLER_167_929 VDD VSS sg13g2_decap_8
XFILLER_178_266 VDD VSS sg13g2_decap_8
XFILLER_107_1349 VDD VSS sg13g2_decap_4
XFILLER_21_456 VDD VSS sg13g2_decap_4
X_08203_ _08247_/A _08203_/A _08203_/B VDD VSS sg13g2_nor2_1
X_14994__2686 _14994_/RESET_B VDD VSS sg13g2_tiehi
X_09183_ _13799_/D _13799_/Q _09885_/A0 _09201_/S VDD VSS sg13g2_mux2_1
X_08134_ _08134_/Y _08030_/Y _08132_/X _08397_/A VDD VSS sg13g2_o21ai_1
XFILLER_135_815 VDD VSS sg13g2_decap_8
XFILLER_174_450 VDD VSS sg13g2_decap_8
XFILLER_179_1152 VDD VSS sg13g2_decap_8
XFILLER_107_539 VDD VSS sg13g2_decap_8
X_14397__1875 _14397_/RESET_B VDD VSS sg13g2_tiehi
X_08065_ _08066_/A _11503_/A1 _11502_/A _11452_/A _11483_/A _08033_/A _12360_/A1 VDD
+ VSS sg13g2_mux4_1
XFILLER_161_111 VDD VSS sg13g2_fill_2
XFILLER_49_1019 VDD VSS sg13g2_decap_8
XFILLER_66_1311 VDD VSS sg13g2_decap_8
Xmax_cap861 _12732_/S0 _12690_/S1 VDD VSS sg13g2_buf_8
XFILLER_115_550 VDD VSS sg13g2_decap_8
XFILLER_161_155 VDD VSS sg13g2_decap_8
XFILLER_162_689 VDD VSS sg13g2_decap_8
XFILLER_89_913 VDD VSS sg13g2_decap_4
Xhold3200 _13637_/A _13745_/Q VDD VSS sg13g2_dlygate4sd3_1
Xhold3211 _13634_/A _13742_/Q VDD VSS sg13g2_dlygate4sd3_1
Xhold3222 _13643_/A _13751_/Q VDD VSS sg13g2_dlygate4sd3_1
Xhold3233 hold3233/X _15165_/Q VDD VSS sg13g2_dlygate4sd3_1
XFILLER_27_1328 VDD VSS sg13g2_decap_8
XFILLER_103_745 VDD VSS sg13g2_decap_4
Xhold3244 _13519_/A _15140_/Q VDD VSS sg13g2_dlygate4sd3_1
Xhold3255 _10182_/B _14748_/Q VDD VSS sg13g2_dlygate4sd3_1
XFILLER_118_1478 VDD VSS sg13g2_fill_1
X_14017__2255 _14017_/RESET_B VDD VSS sg13g2_tiehi
X_13852__2420 _13852_/RESET_B VDD VSS sg13g2_tiehi
X_08967_ _08967_/Y _09141_/A _09016_/C VDD VSS sg13g2_nand2_1
XFILLER_9_1260 VDD VSS sg13g2_decap_8
XFILLER_57_810 VDD VSS sg13g2_decap_8
XFILLER_5_1113 VDD VSS sg13g2_decap_8
Xpicorv32_macro mem_axi_araddr[0] VDD VSS sg13g2_tielo
XFILLER_69_681 VDD VSS sg13g2_decap_8
XFILLER_25_1052 VDD VSS sg13g2_decap_8
X_07918_ _07918_/Y _07893_/Y _07916_/Y _07917_/B VDD VSS sg13g2_a21oi_1
XFILLER_75_139 VDD VSS sg13g2_decap_8
X_08898_ _08898_/Y _08903_/S _14942_/Q VDD VSS sg13g2_nand2_1
XFILLER_84_640 VDD VSS sg13g2_fill_2
XFILLER_17_21 VDD VSS sg13g2_decap_8
X_07849_ _07849_/X _15016_/Q _07965_/B VDD VSS sg13g2_and2_1
XFILLER_95_1006 VDD VSS sg13g2_decap_8
XFILLER_83_150 VDD VSS sg13g2_fill_1
XFILLER_57_898 VDD VSS sg13g2_decap_8
Xclkbuf_leaf_3_clk_i clkload10/A clkload0/A VDD VSS sg13g2_buf_8
XFILLER_99_1186 VDD VSS sg13g2_decap_8
XFILLER_16_217 VDD VSS sg13g2_decap_8
XFILLER_147_1118 VDD VSS sg13g2_decap_8
X_14232__2040 _14232_/RESET_B VDD VSS sg13g2_tiehi
X_10860_ _10860_/Y _07751_/B _10691_/X _07753_/B VDD VSS sg13g2_o21ai_1
XFILLER_71_334 VDD VSS sg13g2_fill_1
XFILLER_25_740 VDD VSS sg13g2_decap_8
X_13885__2387 _13885_/RESET_B VDD VSS sg13g2_tiehi
XFILLER_71_356 VDD VSS sg13g2_decap_8
XFILLER_17_98 VDD VSS sg13g2_decap_8
X_09519_ _14118_/D _09618_/A0 _14118_/Q _09530_/S VDD VSS sg13g2_mux2_1
XFILLER_140_88 VDD VSS sg13g2_decap_4
X_10791_ _14924_/D _11168_/B1 _11199_/B _10790_/Y VDD VSS sg13g2_o21ai_1
XFILLER_13_924 VDD VSS sg13g2_decap_8
X_12530_ _12530_/X _13960_/Q _13992_/Q _14024_/Q _14056_/Q _12668_/S0 _12668_/S1 VDD
+ VSS sg13g2_mux4_1
XFILLER_52_592 VDD VSS sg13g2_decap_8
XFILLER_12_434 VDD VSS sg13g2_decap_8
XFILLER_9_917 VDD VSS sg13g2_decap_8
XFILLER_33_42 VDD VSS sg13g2_decap_8
XFILLER_157_428 VDD VSS sg13g2_decap_8
XFILLER_185_737 VDD VSS sg13g2_fill_1
XFILLER_149_42 VDD VSS sg13g2_decap_8
X_12461_ _12461_/X _14371_/Q _14403_/Q _14467_/Q _14499_/Q _12715_/S0 _12715_/S1 VDD
+ VSS sg13g2_mux4_1
XFILLER_138_620 VDD VSS sg13g2_decap_8
XFILLER_185_759 VDD VSS sg13g2_fill_1
XFILLER_8_427 VDD VSS sg13g2_decap_8
XFILLER_138_631 VDD VSS sg13g2_fill_1
XFILLER_184_236 VDD VSS sg13g2_decap_4
XFILLER_123_1151 VDD VSS sg13g2_fill_2
XFILLER_184_247 VDD VSS sg13g2_decap_8
X_14200_ _14200_/Q _14664_/CLK _14200_/D _14200_/RESET_B VDD VSS sg13g2_dfrbpq_1
X_11412_ _11413_/A _14239_/Q _14271_/Q _14303_/Q _14335_/Q _11412_/S0 _11401_/C VDD
+ VSS sg13g2_mux4_1
X_15180_ _15180_/Q clkload84/A _15180_/D _15180_/RESET_B VDD VSS sg13g2_dfrbpq_1
X_12392_ _12392_/X _13726_/Q _14078_/Q _14430_/Q _14526_/Q _12411_/S0 _12411_/S1 VDD
+ VSS sg13g2_mux4_1
XFILLER_137_152 VDD VSS sg13g2_decap_8
XFILLER_181_921 VDD VSS sg13g2_decap_8
XFILLER_116_0 VDD VSS sg13g2_decap_8
XFILLER_138_697 VDD VSS sg13g2_decap_8
X_14131_ _14131_/Q clkload33/A _14131_/D _14131_/RESET_B VDD VSS sg13g2_dfrbpq_1
X_11343_ _11343_/Y _11821_/S0 _13854_/Q _11805_/C VDD VSS sg13g2_a21oi_1
XFILLER_180_420 VDD VSS sg13g2_decap_8
XFILLER_67_1108 VDD VSS sg13g2_decap_8
XFILLER_153_645 VDD VSS sg13g2_decap_8
X_15230__3091 _15230_/RESET_B VDD VSS sg13g2_tiehi
XFILLER_4_644 VDD VSS sg13g2_decap_8
XFILLER_141_807 VDD VSS sg13g2_decap_8
XFILLER_84_1411 VDD VSS sg13g2_decap_4
XFILLER_10_1365 VDD VSS sg13g2_decap_8
X_14062_ _14062_/Q _14222_/CLK _14062_/D _14062_/RESET_B VDD VSS sg13g2_dfrbpq_1
XFILLER_165_63 VDD VSS sg13g2_decap_8
X_11274_ _11274_/Y _11270_/Y _11271_/Y _11273_/Y _11272_/Y _12324_/B VDD VSS sg13g2_a221oi_1
XFILLER_3_154 VDD VSS sg13g2_decap_8
XFILLER_180_497 VDD VSS sg13g2_decap_8
X_13013_ _13013_/Y _14876_/Q _13028_/B VDD VSS sg13g2_nand2_1
X_10225_ _10234_/D _14767_/Q _14768_/Q _14769_/Q _14770_/Q VDD VSS sg13g2_and4_1
XFILLER_84_1466 VDD VSS sg13g2_decap_8
XFILLER_79_423 VDD VSS sg13g2_decap_4
XFILLER_84_1477 VDD VSS sg13g2_fill_2
XFILLER_133_391 VDD VSS sg13g2_decap_8
XFILLER_95_905 VDD VSS sg13g2_decap_8
XFILLER_121_553 VDD VSS sg13g2_decap_8
X_10156_ _14733_/D _14733_/Q _10156_/A1 _10160_/S VDD VSS sg13g2_mux2_1
XFILLER_95_938 VDD VSS sg13g2_decap_8
XFILLER_43_1130 VDD VSS sg13g2_decap_8
X_14442__1830 _14442_/RESET_B VDD VSS sg13g2_tiehi
XFILLER_94_415 VDD VSS sg13g2_decap_8
XFILLER_0_883 VDD VSS sg13g2_decap_8
XFILLER_43_1141 VDD VSS sg13g2_fill_1
X_14964_ _14964_/Q _15237_/CLK _14964_/D _14964_/RESET_B VDD VSS sg13g2_dfrbpq_1
X_10087_ _14667_/D _10087_/A0 _14667_/Q _10093_/S VDD VSS sg13g2_mux2_1
XFILLER_181_84 VDD VSS sg13g2_decap_8
X_13915_ _13915_/Q _14876_/CLK _13915_/D _13915_/RESET_B VDD VSS sg13g2_dfrbpq_1
XFILLER_130_1177 VDD VSS sg13g2_decap_8
X_14895_ _14895_/Q clkload91/A _14895_/D _14895_/RESET_B VDD VSS sg13g2_dfrbpq_1
XFILLER_47_375 VDD VSS sg13g2_decap_8
XFILLER_169_1387 VDD VSS sg13g2_decap_8
X_13846_ _13846_/Q clkload39/A _13846_/D _13846_/RESET_B VDD VSS sg13g2_dfrbpq_1
XFILLER_74_194 VDD VSS sg13g2_decap_8
XFILLER_62_334 VDD VSS sg13g2_fill_2
X_13715__2557 _13715_/RESET_B VDD VSS sg13g2_tiehi
X_14475__1797 _14475_/RESET_B VDD VSS sg13g2_tiehi
X_13777_ _13777_/Q clkload7/A _13777_/D _13777_/RESET_B VDD VSS sg13g2_dfrbpq_1
XFILLER_91_1415 VDD VSS sg13g2_decap_8
XFILLER_16_784 VDD VSS sg13g2_decap_8
X_10989_ _10989_/Y _10995_/B _15116_/Q VDD VSS sg13g2_nand2b_1
XFILLER_31_721 VDD VSS sg13g2_decap_8
XFILLER_15_294 VDD VSS sg13g2_decap_8
X_12728_ _12728_/X _14582_/Q _14614_/Q _14646_/Q _14678_/Q _12742_/S0 _12756_/S1 VDD
+ VSS sg13g2_mux4_1
XFILLER_30_220 VDD VSS sg13g2_decap_8
XFILLER_31_754 VDD VSS sg13g2_decap_8
XFILLER_30_231 VDD VSS sg13g2_fill_1
XFILLER_175_203 VDD VSS sg13g2_decap_8
XFILLER_176_737 VDD VSS sg13g2_decap_8
XFILLER_15_1221 VDD VSS sg13g2_decap_8
X_12659_ _12659_/X _14705_/Q _14737_/Q _13777_/Q _13809_/Q _12659_/S0 _12659_/S1 VDD
+ VSS sg13g2_mux4_1
XFILLER_157_973 VDD VSS sg13g2_decap_4
X_13930__2342 _13930_/RESET_B VDD VSS sg13g2_tiehi
XFILLER_129_675 VDD VSS sg13g2_decap_8
X_14690__1582 _14690_/RESET_B VDD VSS sg13g2_tiehi
XFILLER_116_303 VDD VSS sg13g2_decap_8
XFILLER_89_1344 VDD VSS sg13g2_decap_8
XFILLER_15_1298 VDD VSS sg13g2_decap_8
XFILLER_144_623 VDD VSS sg13g2_fill_2
XFILLER_172_932 VDD VSS sg13g2_decap_8
XFILLER_8_994 VDD VSS sg13g2_decap_8
XFILLER_156_494 VDD VSS sg13g2_decap_8
X_14329_ _14329_/Q clkload36/A _14329_/D _14329_/RESET_B VDD VSS sg13g2_dfrbpq_1
XFILLER_183_280 VDD VSS sg13g2_decap_8
XFILLER_137_1309 VDD VSS sg13g2_decap_8
XFILLER_143_144 VDD VSS sg13g2_decap_8
X_14979__2701 _14979_/RESET_B VDD VSS sg13g2_tiehi
XFILLER_125_870 VDD VSS sg13g2_decap_8
XFILLER_171_486 VDD VSS sg13g2_decap_4
XFILLER_87_1090 VDD VSS sg13g2_decap_8
XFILLER_135_1011 VDD VSS sg13g2_decap_4
Xfanout907 _12773_/S1 fanout912/X VDD VSS sg13g2_buf_1
X_09870_ _14457_/D _14457_/Q _10101_/A0 _09870_/S VDD VSS sg13g2_mux2_1
Xfanout918 _12661_/S0 _12604_/S0 VDD VSS sg13g2_buf_1
XFILLER_112_531 VDD VSS sg13g2_decap_8
XFILLER_97_231 VDD VSS sg13g2_decap_8
XFILLER_31_0 VDD VSS sg13g2_decap_8
Xclkbuf_5_7__f_clk_i clkbuf_5_7__f_clk_i/X clkbuf_4_3_0_clk_i/X VDD VSS sg13g2_buf_16
Xfanout929 _12758_/S0 _12754_/S0 VDD VSS sg13g2_buf_1
XFILLER_135_1044 VDD VSS sg13g2_decap_8
X_08821_ _08821_/Y _13279_/B _15121_/Q _08727_/D _15178_/Q _08825_/C1 VDD VSS sg13g2_a221oi_1
XFILLER_48_1096 VDD VSS sg13g2_decap_8
XFILLER_98_787 VDD VSS sg13g2_decap_8
XFILLER_6_1400 VDD VSS sg13g2_decap_8
XFILLER_86_938 VDD VSS sg13g2_decap_8
XFILLER_85_415 VDD VSS sg13g2_decap_8
XFILLER_135_1099 VDD VSS sg13g2_decap_8
X_08752_ _08752_/Y _13669_/Q _08781_/B VDD VSS sg13g2_nor2_1
XFILLER_26_1383 VDD VSS sg13g2_decap_8
XFILLER_152_1391 VDD VSS sg13g2_fill_1
XFILLER_61_1274 VDD VSS sg13g2_decap_8
XFILLER_22_1247 VDD VSS sg13g2_decap_8
X_07703_ _07703_/Y _10647_/A _10441_/C VDD VSS sg13g2_nand2_1
X_08683_ _08684_/B _08649_/S _08697_/A _08682_/Y VDD VSS sg13g2_o21ai_1
XFILLER_26_504 VDD VSS sg13g2_decap_8
XFILLER_81_621 VDD VSS sg13g2_decap_8
X_07634_ _07909_/B _11452_/A VDD VSS sg13g2_inv_1
XFILLER_65_194 VDD VSS sg13g2_decap_8
XFILLER_4_1190 VDD VSS sg13g2_decap_8
X_14882__2873 _14882_/RESET_B VDD VSS sg13g2_tiehi
XFILLER_54_879 VDD VSS sg13g2_decap_8
XFILLER_53_356 VDD VSS sg13g2_decap_8
XFILLER_0_1065 VDD VSS sg13g2_decap_8
X_14305__1967 _14305_/RESET_B VDD VSS sg13g2_tiehi
XFILLER_94_1050 VDD VSS sg13g2_decap_8
XFILLER_110_14 VDD VSS sg13g2_decap_8
XFILLER_94_1061 VDD VSS sg13g2_fill_1
XFILLER_81_698 VDD VSS sg13g2_decap_8
X_09304_ _13912_/D _13912_/Q _10100_/A0 _09304_/S VDD VSS sg13g2_mux2_1
XFILLER_80_186 VDD VSS sg13g2_decap_8
XFILLER_22_721 VDD VSS sg13g2_decap_4
XFILLER_179_553 VDD VSS sg13g2_decap_8
XFILLER_34_592 VDD VSS sg13g2_decap_8
XFILLER_167_715 VDD VSS sg13g2_fill_1
XFILLER_181_1064 VDD VSS sg13g2_fill_2
XFILLER_21_231 VDD VSS sg13g2_decap_8
XFILLER_166_203 VDD VSS sg13g2_decap_8
XFILLER_142_1037 VDD VSS sg13g2_decap_8
X_09235_ _13846_/D _10165_/A1 _13846_/Q _09237_/S VDD VSS sg13g2_mux2_1
XFILLER_10_938 VDD VSS sg13g2_decap_8
XFILLER_107_1179 VDD VSS sg13g2_decap_8
XFILLER_182_707 VDD VSS sg13g2_decap_8
XFILLER_21_297 VDD VSS sg13g2_decap_8
X_09166_ _09166_/Y _09166_/A1 _09165_/Y _09162_/Y VDD VSS sg13g2_a21oi_1
XFILLER_148_984 VDD VSS sg13g2_fill_2
XFILLER_119_34 VDD VSS sg13g2_decap_8
X_14520__1752 _14520_/RESET_B VDD VSS sg13g2_tiehi
XFILLER_181_217 VDD VSS sg13g2_decap_8
X_08117_ _08117_/Y _07904_/B _08116_/Y _08039_/A VDD VSS sg13g2_a21oi_1
XFILLER_108_859 VDD VSS sg13g2_decap_8
XFILLER_174_280 VDD VSS sg13g2_decap_8
X_09097_ _09097_/X _09137_/A _09097_/B _09136_/B VDD VSS sg13g2_or3_1
XFILLER_120_1379 VDD VSS sg13g2_fill_1
XFILLER_68_1428 VDD VSS sg13g2_decap_8
XFILLER_163_987 VDD VSS sg13g2_decap_8
X_08048_ _08048_/Y _08048_/A _08048_/B VDD VSS sg13g2_nand2_1
XFILLER_116_870 VDD VSS sg13g2_fill_2
XFILLER_162_475 VDD VSS sg13g2_decap_8
XFILLER_118_1220 VDD VSS sg13g2_decap_8
XFILLER_66_1152 VDD VSS sg13g2_decap_8
XFILLER_27_1125 VDD VSS sg13g2_decap_8
XFILLER_1_658 VDD VSS sg13g2_decap_8
XFILLER_88_231 VDD VSS sg13g2_decap_8
X_10010_ _14592_/D _10043_/A0 _14592_/Q _10031_/S VDD VSS sg13g2_mux2_1
XFILLER_66_1196 VDD VSS sg13g2_decap_8
XFILLER_62_1038 VDD VSS sg13g2_decap_4
XFILLER_0_168 VDD VSS sg13g2_decap_8
XFILLER_130_361 VDD VSS sg13g2_fill_1
X_09999_ _14582_/D _10098_/A0 _14582_/Q _10002_/S VDD VSS sg13g2_mux2_1
XFILLER_95_48 VDD VSS sg13g2_decap_4
X_15093__2888 _15093_/RESET_B VDD VSS sg13g2_tiehi
XFILLER_130_383 VDD VSS sg13g2_decap_8
XFILLER_28_42 VDD VSS sg13g2_decap_8
XFILLER_151_21 VDD VSS sg13g2_decap_4
XFILLER_17_504 VDD VSS sg13g2_decap_8
X_11961_ _11961_/Y _11963_/S0 _14512_/Q _11967_/B VDD VSS sg13g2_a21oi_1
XFILLER_29_364 VDD VSS sg13g2_decap_8
XFILLER_56_150 VDD VSS sg13g2_decap_8
X_13700_ _16862_/A clkload74/A _13700_/D _13700_/RESET_B VDD VSS sg13g2_dfrbpq_1
X_10912_ _10912_/Y _10926_/C _10936_/D _11056_/B1 VDD VSS sg13g2_o21ai_1
X_14680_ _14680_/Q _14982_/CLK _14680_/D _14680_/RESET_B VDD VSS sg13g2_dfrbpq_1
X_11892_ _11892_/Y _11889_/Y _11891_/X _11901_/B1 VDD VSS sg13g2_o21ai_1
XFILLER_45_868 VDD VSS sg13g2_decap_8
X_13631_ _13739_/D _13631_/A VDD VSS sg13g2_buf_1
XFILLER_71_153 VDD VSS sg13g2_decap_8
XFILLER_38_1210 VDD VSS sg13g2_decap_4
X_10843_ _10843_/Y _10841_/Y _10843_/B _10843_/C VDD VSS sg13g2_nand3b_1
XFILLER_71_164 VDD VSS sg13g2_fill_2
XFILLER_13_721 VDD VSS sg13g2_decap_8
XFILLER_164_1240 VDD VSS sg13g2_decap_8
XFILLER_73_1123 VDD VSS sg13g2_decap_8
XFILLER_53_890 VDD VSS sg13g2_decap_8
XFILLER_125_1213 VDD VSS sg13g2_decap_4
X_13562_ _15152_/D _15152_/Q _13561_/X _13562_/S VDD VSS sg13g2_mux2_1
X_10774_ _10774_/Y _10774_/A _11156_/B VDD VSS sg13g2_nand2_1
XFILLER_44_96 VDD VSS sg13g2_decap_8
XFILLER_12_231 VDD VSS sg13g2_decap_8
XFILLER_9_714 VDD VSS sg13g2_decap_8
X_12513_ _15000_/D _12513_/A _12513_/B VDD VSS sg13g2_nor2_1
XFILLER_34_1129 VDD VSS sg13g2_decap_8
X_13493_ _13493_/Y _13493_/A1 _13493_/A2 _15126_/Q VDD VSS sg13g2_o21ai_1
XFILLER_51_1421 VDD VSS sg13g2_decap_8
XFILLER_40_573 VDD VSS sg13g2_fill_1
XFILLER_13_798 VDD VSS sg13g2_decap_8
XFILLER_8_224 VDD VSS sg13g2_decap_8
XFILLER_51_1432 VDD VSS sg13g2_fill_1
XFILLER_185_567 VDD VSS sg13g2_decap_8
XFILLER_157_269 VDD VSS sg13g2_fill_1
X_15232_ _15232_/Q _15249_/CLK _15232_/D _15232_/RESET_B VDD VSS sg13g2_dfrbpq_1
X_12444_ _12457_/A _10213_/A _07737_/B _13545_/A VDD VSS sg13g2_a21oi_1
XFILLER_172_217 VDD VSS sg13g2_decap_8
XFILLER_126_623 VDD VSS sg13g2_decap_8
XFILLER_172_228 VDD VSS sg13g2_fill_1
XFILLER_67_9 VDD VSS sg13g2_fill_1
XFILLER_60_84 VDD VSS sg13g2_decap_8
XFILLER_12_1449 VDD VSS sg13g2_decap_8
X_15163_ _15163_/Q clkload89/A _15163_/D _15163_/RESET_B VDD VSS sg13g2_dfrbpq_1
XFILLER_125_111 VDD VSS sg13g2_decap_8
XFILLER_153_420 VDD VSS sg13g2_fill_1
X_12375_ _12375_/X _14557_/Q _14589_/Q _14621_/Q _14653_/Q _12618_/S0 _12618_/S1 VDD
+ VSS sg13g2_mux4_1
XFILLER_5_931 VDD VSS sg13g2_decap_8
XFILLER_176_84 VDD VSS sg13g2_decap_8
X_14114_ _14114_/Q _14656_/CLK _14114_/D _14114_/RESET_B VDD VSS sg13g2_dfrbpq_1
XFILLER_114_818 VDD VSS sg13g2_decap_8
X_11326_ _11326_/Y _11326_/A _11326_/B VDD VSS sg13g2_nand2_1
XFILLER_5_35 VDD VSS sg13g2_decap_8
XFILLER_4_441 VDD VSS sg13g2_decap_8
X_15094_ _15094_/Q _15219_/CLK _15094_/D _15094_/RESET_B VDD VSS sg13g2_dfrbpq_1
XFILLER_10_1162 VDD VSS sg13g2_decap_8
XFILLER_113_317 VDD VSS sg13g2_fill_2
XFILLER_113_328 VDD VSS sg13g2_fill_2
XFILLER_107_892 VDD VSS sg13g2_fill_1
X_14045_ _14045_/Q clkload59/A _14045_/D _14045_/RESET_B VDD VSS sg13g2_dfrbpq_1
XFILLER_125_199 VDD VSS sg13g2_decap_8
XFILLER_180_294 VDD VSS sg13g2_decap_8
Xclkbuf_leaf_104_clk_i _14222_/CLK clkload3/A VDD VSS sg13g2_buf_8
X_11257_ _11257_/X _13724_/Q _14076_/Q _14428_/Q _14524_/Q _11218_/S _12319_/B1 VDD
+ VSS sg13g2_mux4_1
XFILLER_171_1211 VDD VSS sg13g2_fill_1
XFILLER_49_1383 VDD VSS sg13g2_fill_2
XFILLER_122_851 VDD VSS sg13g2_decap_8
XFILLER_136_1342 VDD VSS sg13g2_fill_1
XFILLER_79_231 VDD VSS sg13g2_decap_8
XFILLER_45_1225 VDD VSS sg13g2_decap_8
XFILLER_69_93 VDD VSS sg13g2_decap_8
XFILLER_122_862 VDD VSS sg13g2_fill_2
X_10208_ _10209_/B _14765_/Q _14749_/Q VDD VSS sg13g2_nand2b_1
XFILLER_45_1247 VDD VSS sg13g2_decap_8
X_11188_ _11188_/Y _11186_/B _11187_/Y _11186_/Y _11197_/B _11188_/C1 VDD VSS sg13g2_a221oi_1
XFILLER_122_895 VDD VSS sg13g2_decap_4
XFILLER_171_1266 VDD VSS sg13g2_decap_8
XFILLER_121_372 VDD VSS sg13g2_decap_8
X_10139_ _14716_/D _14716_/Q _10139_/A1 _10169_/S VDD VSS sg13g2_mux2_1
XFILLER_95_757 VDD VSS sg13g2_decap_4
XFILLER_95_779 VDD VSS sg13g2_decap_4
XFILLER_94_256 VDD VSS sg13g2_fill_1
XFILLER_94_267 VDD VSS sg13g2_decap_8
Xclkbuf_leaf_119_clk_i _14740_/CLK clkbuf_5_7__f_clk_i/X VDD VSS sg13g2_buf_8
X_14947_ _14947_/Q _14947_/CLK _14947_/D _14947_/RESET_B VDD VSS sg13g2_dfrbpq_1
X_13948__2324 _13948_/RESET_B VDD VSS sg13g2_tiehi
XFILLER_63_632 VDD VSS sg13g2_decap_4
XFILLER_35_323 VDD VSS sg13g2_decap_8
XFILLER_1_1330 VDD VSS sg13g2_decap_8
XFILLER_36_857 VDD VSS sg13g2_decap_4
X_14878_ _14878_/Q clkload61/A _14878_/D _14878_/RESET_B VDD VSS sg13g2_dfrbpq_1
XFILLER_39_1007 VDD VSS sg13g2_decap_8
XFILLER_36_879 VDD VSS sg13g2_fill_2
XFILLER_35_356 VDD VSS sg13g2_decap_8
XFILLER_165_1026 VDD VSS sg13g2_decap_8
XFILLER_21_1291 VDD VSS sg13g2_decap_8
X_15061__2582 _15061_/RESET_B VDD VSS sg13g2_tiehi
XFILLER_62_153 VDD VSS sg13g2_decap_8
X_13829_ _13829_/Q clkload12/A _13829_/D _13829_/RESET_B VDD VSS sg13g2_dfrbpq_1
XFILLER_16_581 VDD VSS sg13g2_decap_8
XFILLER_44_890 VDD VSS sg13g2_decap_8
XFILLER_143_1313 VDD VSS sg13g2_decap_4
XFILLER_176_501 VDD VSS sg13g2_decap_8
XFILLER_17_1327 VDD VSS sg13g2_decap_8
XFILLER_91_1256 VDD VSS sg13g2_decap_8
XFILLER_56_1376 VDD VSS sg13g2_decap_8
XFILLER_56_1387 VDD VSS sg13g2_fill_1
XFILLER_91_1278 VDD VSS sg13g2_decap_8
XFILLER_104_1319 VDD VSS sg13g2_decap_4
X_14859__2919 _14859_/RESET_B VDD VSS sg13g2_tiehi
X_09020_ _13764_/D _13764_/Q _10080_/A0 _09153_/S VDD VSS sg13g2_mux2_1
XFILLER_176_578 VDD VSS sg13g2_decap_8
XFILLER_79_0 VDD VSS sg13g2_decap_8
XFILLER_102_1010 VDD VSS sg13g2_decap_8
XFILLER_129_461 VDD VSS sg13g2_decap_8
XFILLER_15_1095 VDD VSS sg13g2_decap_8
XFILLER_176_1100 VDD VSS sg13g2_decap_8
XFILLER_8_791 VDD VSS sg13g2_decap_8
XFILLER_102_1065 VDD VSS sg13g2_decap_4
XFILLER_145_965 VDD VSS sg13g2_decap_8
XFILLER_176_1133 VDD VSS sg13g2_decap_8
XFILLER_89_1196 VDD VSS sg13g2_fill_1
XFILLER_102_1098 VDD VSS sg13g2_decap_8
XFILLER_104_317 VDD VSS sg13g2_decap_8
XFILLER_85_1049 VDD VSS sg13g2_decap_4
XFILLER_144_486 VDD VSS sg13g2_decap_8
XFILLER_28_1401 VDD VSS sg13g2_decap_8
XFILLER_104_328 VDD VSS sg13g2_fill_1
XFILLER_132_637 VDD VSS sg13g2_decap_8
X_09922_ _14507_/D _14507_/Q _09922_/A1 _09929_/S VDD VSS sg13g2_mux2_1
Xfanout704 _08659_/B _08174_/B VDD VSS sg13g2_buf_1
Xfanout715 _13248_/B _13138_/B1 VDD VSS sg13g2_buf_1
XFILLER_154_1453 VDD VSS sg13g2_decap_8
Xfanout726 _13279_/D _07703_/Y VDD VSS sg13g2_buf_1
XFILLER_63_1336 VDD VSS sg13g2_decap_8
XFILLER_131_169 VDD VSS sg13g2_decap_8
Xfanout737 _07684_/B _12294_/B1 VDD VSS sg13g2_buf_1
X_09853_ _14440_/D _14440_/Q _10051_/A0 _09862_/S VDD VSS sg13g2_mux2_1
XFILLER_154_1464 VDD VSS sg13g2_fill_2
XFILLER_24_1309 VDD VSS sg13g2_decap_8
XFILLER_105_14 VDD VSS sg13g2_decap_8
Xfanout748 _10187_/S hold3171/X VDD VSS sg13g2_buf_1
XFILLER_85_201 VDD VSS sg13g2_decap_8
XFILLER_28_1478 VDD VSS sg13g2_fill_1
Xfanout759 _12101_/B _12253_/B VDD VSS sg13g2_buf_1
XFILLER_112_383 VDD VSS sg13g2_decap_8
XFILLER_115_1448 VDD VSS sg13g2_fill_2
XFILLER_58_437 VDD VSS sg13g2_decap_4
X_08804_ _08805_/B _13686_/Q _13482_/B VDD VSS sg13g2_nor2_1
X_09784_ _14373_/D _09883_/A0 _14373_/Q _09797_/S VDD VSS sg13g2_mux2_1
XFILLER_86_779 VDD VSS sg13g2_decap_8
XFILLER_26_1180 VDD VSS sg13g2_decap_8
XFILLER_39_651 VDD VSS sg13g2_decap_8
X_08735_ _13663_/D _08765_/A1 _08733_/Y _08734_/Y VDD VSS sg13g2_a21oi_1
XFILLER_6_1274 VDD VSS sg13g2_decap_8
XFILLER_22_1044 VDD VSS sg13g2_decap_8
XFILLER_67_982 VDD VSS sg13g2_decap_4
XFILLER_67_993 VDD VSS sg13g2_fill_1
XFILLER_39_684 VDD VSS sg13g2_fill_1
XFILLER_26_301 VDD VSS sg13g2_decap_8
XFILLER_2_1127 VDD VSS sg13g2_decap_8
XFILLER_148_1202 VDD VSS sg13g2_decap_8
XFILLER_148_1213 VDD VSS sg13g2_fill_2
X_14538__1734 _14538_/RESET_B VDD VSS sg13g2_tiehi
X_08666_ _08666_/X _08678_/A _08666_/B VDD VSS sg13g2_xor2_1
XFILLER_121_46 VDD VSS sg13g2_decap_8
Xclkbuf_leaf_83_clk_i clkload56/A clkbuf_leaf_83_clk_i/A VDD VSS sg13g2_buf_8
XFILLER_96_1167 VDD VSS sg13g2_decap_8
XFILLER_53_142 VDD VSS sg13g2_decap_8
X_07617_ _09011_/A _14902_/Q VDD VSS sg13g2_inv_1
XFILLER_53_153 VDD VSS sg13g2_fill_2
XFILLER_14_518 VDD VSS sg13g2_decap_8
XFILLER_26_378 VDD VSS sg13g2_decap_8
X_08597_ _08600_/C _08599_/A _08597_/B _08597_/C VDD VSS sg13g2_nor3_1
XFILLER_157_7 VDD VSS sg13g2_decap_8
XFILLER_179_350 VDD VSS sg13g2_decap_8
XFILLER_167_501 VDD VSS sg13g2_decap_8
XFILLER_22_540 VDD VSS sg13g2_decap_8
XFILLER_14_77 VDD VSS sg13g2_decap_8
XFILLER_161_1468 VDD VSS sg13g2_fill_2
XFILLER_10_735 VDD VSS sg13g2_decap_8
Xclkbuf_leaf_98_clk_i clkload63/A clkload4/A VDD VSS sg13g2_buf_8
X_09218_ _13829_/D _09883_/A0 _13829_/Q _09231_/S VDD VSS sg13g2_mux2_1
XFILLER_182_504 VDD VSS sg13g2_decap_8
X_10490_ _14850_/D _10580_/B _10490_/B _10498_/D VDD VSS sg13g2_nor3_1
XFILLER_6_728 VDD VSS sg13g2_decap_8
XFILLER_120_1132 VDD VSS sg13g2_decap_8
XFILLER_148_792 VDD VSS sg13g2_decap_8
X_09149_ _09151_/B _09157_/C _09157_/D _14923_/Q VDD VSS sg13g2_a21o_1
XFILLER_30_21 VDD VSS sg13g2_decap_8
X_14182__2090 _14182_/RESET_B VDD VSS sg13g2_tiehi
XFILLER_5_238 VDD VSS sg13g2_decap_8
XFILLER_135_453 VDD VSS sg13g2_decap_8
XFILLER_146_21 VDD VSS sg13g2_decap_8
Xclkbuf_leaf_21_clk_i clkload39/A clkbuf_leaf_48_clk_i/A VDD VSS sg13g2_buf_8
X_12160_ _12160_/Y _12186_/A _14230_/Q _12166_/B VDD VSS sg13g2_a21oi_1
XFILLER_108_689 VDD VSS sg13g2_decap_8
XFILLER_68_1247 VDD VSS sg13g2_decap_8
XFILLER_155_1206 VDD VSS sg13g2_decap_8
XFILLER_107_177 VDD VSS sg13g2_decap_8
XFILLER_122_103 VDD VSS sg13g2_decap_8
X_11111_ _11111_/Y _11109_/B _10764_/X _11154_/B1 VDD VSS sg13g2_o21ai_1
XFILLER_2_945 VDD VSS sg13g2_decap_8
X_12091_ _12092_/B _12091_/A _12091_/B _12091_/C VDD VSS sg13g2_nand3_1
XFILLER_1_455 VDD VSS sg13g2_decap_8
X_11042_ _11078_/D _11042_/A _11042_/B _11042_/C _11042_/D VDD VSS sg13g2_nand4_1
Xclkbuf_leaf_36_clk_i _14729_/CLK clkbuf_leaf_37_clk_i/A VDD VSS sg13g2_buf_8
XFILLER_39_63 VDD VSS sg13g2_decap_8
XFILLER_118_1094 VDD VSS sg13g2_decap_8
XFILLER_162_42 VDD VSS sg13g2_decap_8
XFILLER_39_74 VDD VSS sg13g2_fill_1
XFILLER_77_757 VDD VSS sg13g2_decap_8
XFILLER_49_448 VDD VSS sg13g2_decap_8
XFILLER_183_0 VDD VSS sg13g2_decap_8
X_14801_ _14801_/Q clkload66/A _14801_/D _14801_/RESET_B VDD VSS sg13g2_dfrbpq_1
XFILLER_92_716 VDD VSS sg13g2_decap_4
XFILLER_91_204 VDD VSS sg13g2_decap_4
XFILLER_92_738 VDD VSS sg13g2_decap_8
XFILLER_17_301 VDD VSS sg13g2_decap_8
X_12993_ _12995_/C _13058_/D _12993_/B _12993_/C VDD VSS sg13g2_nand3b_1
XFILLER_92_749 VDD VSS sg13g2_fill_2
XFILLER_40_1166 VDD VSS sg13g2_decap_8
XFILLER_45_632 VDD VSS sg13g2_decap_8
XFILLER_18_857 VDD VSS sg13g2_decap_8
X_14732_ _14732_/Q clkload26/A _14732_/D _14732_/RESET_B VDD VSS sg13g2_dfrbpq_1
XFILLER_79_1354 VDD VSS sg13g2_fill_2
X_11944_ _11944_/Y _11940_/Y _11941_/Y _11943_/Y _11942_/Y _11964_/B VDD VSS sg13g2_a221oi_1
XFILLER_40_1188 VDD VSS sg13g2_decap_8
XFILLER_60_602 VDD VSS sg13g2_decap_8
XFILLER_17_378 VDD VSS sg13g2_decap_8
XFILLER_45_687 VDD VSS sg13g2_decap_8
X_14663_ _14663_/Q _14727_/CLK _14663_/D _14663_/RESET_B VDD VSS sg13g2_dfrbpq_1
X_11875_ _11875_/X _11875_/A _11875_/B VDD VSS sg13g2_and2_1
XFILLER_32_337 VDD VSS sg13g2_decap_8
X_13614_ _15168_/D _08842_/S _16854_/A _13613_/Y VDD VSS sg13g2_a21o_1
X_10826_ _10841_/A _12347_/B _10851_/D VDD VSS sg13g2_nor2_1
XFILLER_60_668 VDD VSS sg13g2_decap_8
XFILLER_186_810 VDD VSS sg13g2_fill_1
X_14392__1880 _14392_/RESET_B VDD VSS sg13g2_tiehi
X_14594_ _14594_/Q clkload45/A _14594_/D _14594_/RESET_B VDD VSS sg13g2_dfrbpq_1
XFILLER_158_534 VDD VSS sg13g2_fill_1
XFILLER_9_511 VDD VSS sg13g2_decap_8
X_13545_ _13545_/X _13545_/A _13555_/C VDD VSS sg13g2_and2_1
X_10757_ _10757_/Y _10757_/A _10757_/B VDD VSS sg13g2_nor2_1
XFILLER_40_370 VDD VSS sg13g2_fill_1
XFILLER_13_595 VDD VSS sg13g2_decap_8
XFILLER_40_381 VDD VSS sg13g2_decap_8
XFILLER_146_707 VDD VSS sg13g2_decap_8
XFILLER_186_876 VDD VSS sg13g2_decap_8
XFILLER_125_1087 VDD VSS sg13g2_fill_1
XFILLER_186_887 VDD VSS sg13g2_decap_8
XFILLER_185_364 VDD VSS sg13g2_decap_8
XFILLER_186_898 VDD VSS sg13g2_fill_1
X_13476_ _15112_/D _15178_/D _15112_/Q _13480_/S VDD VSS sg13g2_mux2_1
XFILLER_72_7 VDD VSS sg13g2_decap_4
XFILLER_127_910 VDD VSS sg13g2_decap_4
X_10688_ _10851_/C _08992_/B _10691_/S _08852_/Y VDD VSS sg13g2_a21o_1
XFILLER_139_781 VDD VSS sg13g2_decap_8
XFILLER_9_588 VDD VSS sg13g2_decap_8
XFILLER_145_228 VDD VSS sg13g2_decap_8
XFILLER_173_548 VDD VSS sg13g2_decap_8
X_15215_ _15215_/Q _15216_/CLK _15215_/D _15215_/RESET_B VDD VSS sg13g2_dfrbpq_1
X_12427_ _12427_/X _12425_/X _12424_/X _12421_/X _12420_/X _12691_/S1 _12553_/S VDD
+ VSS sg13g2_mux4_1
XFILLER_12_1246 VDD VSS sg13g2_decap_8
XFILLER_51_1295 VDD VSS sg13g2_fill_2
X_14012__2260 _14012_/RESET_B VDD VSS sg13g2_tiehi
XFILLER_103_1385 VDD VSS sg13g2_decap_8
XFILLER_127_976 VDD VSS sg13g2_fill_2
X_15146_ _15146_/Q clkload78/A _15146_/D _15146_/RESET_B VDD VSS sg13g2_dfrbpq_1
X_12358_ _12358_/Y _15217_/Q _12358_/B VDD VSS sg13g2_nand2b_1
XFILLER_141_401 VDD VSS sg13g2_decap_8
XFILLER_142_924 VDD VSS sg13g2_decap_4
XFILLER_181_581 VDD VSS sg13g2_decap_8
XFILLER_99_326 VDD VSS sg13g2_decap_8
XFILLER_114_648 VDD VSS sg13g2_decap_4
XFILLER_173_1328 VDD VSS sg13g2_decap_8
X_11309_ _11309_/Y _11328_/S0 _14429_/Q VDD VSS sg13g2_nand2b_1
XFILLER_138_1459 VDD VSS sg13g2_decap_8
X_14616__1656 _14616_/RESET_B VDD VSS sg13g2_tiehi
X_15077_ _15077_/Q clkload87/A _15077_/D _15077_/RESET_B VDD VSS sg13g2_dfrbpq_1
XFILLER_141_445 VDD VSS sg13g2_decap_8
Xclkbuf_5_25__f_clk_i clkload5/A clkbuf_4_12_0_clk_i/X VDD VSS sg13g2_buf_16
X_12289_ _12289_/X _12283_/X _12284_/X _12287_/X _12288_/X _11443_/A _11446_/A VDD
+ VSS sg13g2_mux4_1
XFILLER_142_979 VDD VSS sg13g2_decap_8
XFILLER_141_467 VDD VSS sg13g2_decap_4
X_14028_ _14028_/Q clkload17/A _14028_/D _14028_/RESET_B VDD VSS sg13g2_dfrbpq_1
XFILLER_171_1041 VDD VSS sg13g2_decap_8
XFILLER_45_1055 VDD VSS sg13g2_fill_2
XFILLER_136_1194 VDD VSS sg13g2_decap_8
X_13880__2392 _13880_/RESET_B VDD VSS sg13g2_tiehi
XFILLER_95_543 VDD VSS sg13g2_decap_8
XFILLER_56_908 VDD VSS sg13g2_decap_8
XFILLER_45_1088 VDD VSS sg13g2_decap_8
XFILLER_110_865 VDD VSS sg13g2_decap_8
XFILLER_3_1414 VDD VSS sg13g2_decap_8
XFILLER_110_898 VDD VSS sg13g2_decap_4
XFILLER_36_610 VDD VSS sg13g2_decap_8
XFILLER_110_1323 VDD VSS sg13g2_decap_4
XFILLER_110_1334 VDD VSS sg13g2_decap_8
X_08520_ _08520_/X _08457_/X _08597_/C _08597_/B VDD VSS sg13g2_mux2_1
XFILLER_82_237 VDD VSS sg13g2_fill_2
XFILLER_23_1386 VDD VSS sg13g2_decap_8
XFILLER_97_1454 VDD VSS sg13g2_fill_1
XFILLER_110_1356 VDD VSS sg13g2_fill_1
XFILLER_97_1465 VDD VSS sg13g2_decap_8
XFILLER_58_1416 VDD VSS sg13g2_decap_8
XFILLER_36_654 VDD VSS sg13g2_decap_8
XFILLER_91_760 VDD VSS sg13g2_decap_8
XFILLER_110_1378 VDD VSS sg13g2_decap_8
X_08451_ _08462_/B _08659_/A _08087_/X _08688_/C VDD VSS sg13g2_o21ai_1
XFILLER_50_101 VDD VSS sg13g2_decap_8
XFILLER_184_1468 VDD VSS sg13g2_decap_8
XFILLER_51_646 VDD VSS sg13g2_decap_8
X_08382_ _08382_/X _08383_/A _08383_/B VDD VSS sg13g2_and2_1
XFILLER_17_1124 VDD VSS sg13g2_decap_8
XFILLER_32_860 VDD VSS sg13g2_decap_8
XFILLER_31_392 VDD VSS sg13g2_decap_8
XFILLER_143_1187 VDD VSS sg13g2_decap_8
XFILLER_176_364 VDD VSS sg13g2_decap_8
XFILLER_30_1302 VDD VSS sg13g2_decap_8
XFILLER_121_1430 VDD VSS sg13g2_decap_8
X_09003_ _09003_/X _15028_/Q _15225_/Q _09009_/S VDD VSS sg13g2_mux2_1
XFILLER_121_1441 VDD VSS sg13g2_fill_2
XFILLER_136_239 VDD VSS sg13g2_decap_8
XFILLER_178_1239 VDD VSS sg13g2_fill_1
X_15109__2836 _15109_/RESET_B VDD VSS sg13g2_tiehi
XFILLER_133_924 VDD VSS sg13g2_decap_8
XFILLER_145_795 VDD VSS sg13g2_decap_8
XFILLER_144_272 VDD VSS sg13g2_decap_8
XFILLER_160_721 VDD VSS sg13g2_decap_8
XFILLER_104_125 VDD VSS sg13g2_fill_1
XFILLER_133_968 VDD VSS sg13g2_decap_8
XFILLER_104_147 VDD VSS sg13g2_fill_1
XFILLER_132_456 VDD VSS sg13g2_decap_8
XFILLER_67_1280 VDD VSS sg13g2_decap_8
XFILLER_120_607 VDD VSS sg13g2_decap_8
X_09905_ _09925_/S _09905_/A _10105_/C _10004_/A _10070_/B VDD VSS sg13g2_and4_1
XFILLER_28_1242 VDD VSS sg13g2_decap_8
Xfanout523 _09373_/S _09371_/S VDD VSS sg13g2_buf_1
XFILLER_115_1212 VDD VSS sg13g2_decap_8
Xfanout534 _10109_/A0 _08989_/X VDD VSS sg13g2_buf_1
XFILLER_113_681 VDD VSS sg13g2_decap_8
Xfanout545 _08588_/B _08000_/X VDD VSS sg13g2_buf_1
XFILLER_76_28 VDD VSS sg13g2_decap_8
XFILLER_24_1117 VDD VSS sg13g2_fill_1
XFILLER_150_1125 VDD VSS sg13g2_decap_8
XFILLER_8_1358 VDD VSS sg13g2_decap_8
XFILLER_101_854 VDD VSS sg13g2_fill_1
X_13710__2562 _13710_/RESET_B VDD VSS sg13g2_tiehi
Xfanout567 _12841_/B _12798_/Y VDD VSS sg13g2_buf_1
X_09836_ _14424_/D _10100_/A0 _14424_/Q _09837_/S VDD VSS sg13g2_mux2_1
XFILLER_115_1256 VDD VSS sg13g2_decap_8
XFILLER_59_768 VDD VSS sg13g2_decap_8
XFILLER_58_245 VDD VSS sg13g2_decap_8
XFILLER_101_865 VDD VSS sg13g2_decap_8
Xfanout589 _10071_/A0 _10138_/A1 VDD VSS sg13g2_buf_1
XFILLER_111_1109 VDD VSS sg13g2_fill_2
XFILLER_100_375 VDD VSS sg13g2_decap_8
X_09767_ _14357_/D _14357_/Q _09899_/A0 _09771_/S VDD VSS sg13g2_mux2_1
XFILLER_6_1071 VDD VSS sg13g2_decap_8
XFILLER_39_470 VDD VSS sg13g2_fill_1
XFILLER_73_237 VDD VSS sg13g2_decap_8
XFILLER_67_790 VDD VSS sg13g2_fill_2
XFILLER_39_481 VDD VSS sg13g2_decap_8
XFILLER_132_56 VDD VSS sg13g2_fill_2
X_08718_ _15212_/D _15191_/D _15121_/Q _13656_/S VDD VSS sg13g2_mux2_1
X_09698_ _14290_/D _09896_/A0 _14290_/Q _09698_/S VDD VSS sg13g2_mux2_1
XFILLER_55_963 VDD VSS sg13g2_decap_8
X_14054__2218 _14054_/RESET_B VDD VSS sg13g2_tiehi
XFILLER_92_49 VDD VSS sg13g2_decap_4
X_08649_ _08650_/B _08662_/B _08647_/Y _08649_/S VDD VSS sg13g2_mux2_1
XFILLER_25_21 VDD VSS sg13g2_decap_8
XFILLER_14_315 VDD VSS sg13g2_decap_8
XFILLER_70_933 VDD VSS sg13g2_fill_1
XFILLER_15_849 VDD VSS sg13g2_decap_8
XFILLER_81_281 VDD VSS sg13g2_decap_8
XFILLER_41_112 VDD VSS sg13g2_decap_4
X_11660_ _11771_/A _11661_/A _13680_/Q VDD VSS sg13g2_nor2_1
XFILLER_39_1371 VDD VSS sg13g2_fill_1
XFILLER_41_156 VDD VSS sg13g2_decap_8
X_10611_ _14879_/D _10611_/A _10611_/B _10611_/C VDD VSS sg13g2_and3_1
XFILLER_126_1352 VDD VSS sg13g2_decap_8
XFILLER_74_1284 VDD VSS sg13g2_decap_8
X_11591_ _11636_/C _11591_/A _13682_/Q VDD VSS sg13g2_xor2_1
XFILLER_70_1126 VDD VSS sg13g2_fill_2
XFILLER_35_1246 VDD VSS sg13g2_decap_8
XFILLER_128_707 VDD VSS sg13g2_fill_1
XFILLER_10_532 VDD VSS sg13g2_decap_8
XFILLER_126_1385 VDD VSS sg13g2_decap_8
XFILLER_161_1265 VDD VSS sg13g2_decap_4
X_13330_ _13502_/B hold3139/X _13333_/S _13329_/Y VDD VSS sg13g2_o21ai_1
XFILLER_128_718 VDD VSS sg13g2_fill_1
X_10542_ _10544_/A _10566_/D _10547_/D _14863_/Q VDD VSS sg13g2_a21o_1
XFILLER_161_1298 VDD VSS sg13g2_decap_8
XFILLER_182_301 VDD VSS sg13g2_decap_8
XFILLER_41_42 VDD VSS sg13g2_decap_8
XFILLER_155_537 VDD VSS sg13g2_decap_8
XFILLER_6_525 VDD VSS sg13g2_decap_8
XFILLER_157_42 VDD VSS sg13g2_decap_8
X_13261_ _13261_/Y _14829_/Q _13274_/A2 _13249_/B _14893_/Q _13274_/C1 VDD VSS sg13g2_a221oi_1
X_10473_ _10484_/D _10486_/D _14845_/Q _10500_/A _10473_/D VDD VSS sg13g2_and4_1
XFILLER_68_1011 VDD VSS sg13g2_fill_1
X_15000_ _15000_/Q _15019_/CLK _15000_/D _15000_/RESET_B VDD VSS sg13g2_dfrbpq_1
X_12212_ _12212_/X _13751_/Q _14103_/Q _14455_/Q _14551_/Q _12213_/S0 _12215_/S1 VDD
+ VSS sg13g2_mux4_1
XFILLER_170_518 VDD VSS sg13g2_decap_8
XFILLER_182_378 VDD VSS sg13g2_decap_8
XFILLER_68_1022 VDD VSS sg13g2_fill_2
X_13192_ _13192_/X input21/X _13272_/A2 _13264_/B1 VDD VSS sg13g2_a21o_1
XFILLER_151_721 VDD VSS sg13g2_decap_8
XFILLER_155_1003 VDD VSS sg13g2_fill_2
XFILLER_123_423 VDD VSS sg13g2_decap_8
X_12143_ _12144_/B _12291_/A _12143_/B VDD VSS sg13g2_nor2_1
XFILLER_9_0 VDD VSS sg13g2_decap_8
XFILLER_150_231 VDD VSS sg13g2_decap_4
XFILLER_151_754 VDD VSS sg13g2_decap_8
XFILLER_2_742 VDD VSS sg13g2_decap_8
XFILLER_97_819 VDD VSS sg13g2_decap_8
XFILLER_155_1058 VDD VSS sg13g2_decap_8
XFILLER_150_264 VDD VSS sg13g2_decap_8
XFILLER_1_252 VDD VSS sg13g2_decap_8
X_12074_ _12075_/B _12071_/X _12070_/X _12067_/X _12066_/X _12188_/C _11559_/C VDD
+ VSS sg13g2_mux4_1
XFILLER_173_63 VDD VSS sg13g2_decap_8
XFILLER_104_692 VDD VSS sg13g2_decap_8
XFILLER_133_1323 VDD VSS sg13g2_decap_8
XFILLER_2_14 VDD VSS sg13g2_decap_8
X_11025_ _11025_/Y _11022_/Y _11064_/B _11043_/A VDD VSS sg13g2_a21oi_1
XFILLER_133_1345 VDD VSS sg13g2_fill_2
XFILLER_46_1397 VDD VSS sg13g2_fill_2
X_16882_ _16882_/X _16882_/A VDD VSS sg13g2_buf_1
X_14300__1972 _14300_/RESET_B VDD VSS sg13g2_tiehi
XFILLER_37_418 VDD VSS sg13g2_decap_8
XFILLER_66_72 VDD VSS sg13g2_decap_8
XFILLER_18_621 VDD VSS sg13g2_decap_4
XFILLER_131_1080 VDD VSS sg13g2_decap_8
XFILLER_64_259 VDD VSS sg13g2_decap_8
XFILLER_46_963 VDD VSS sg13g2_decap_8
X_12976_ _12976_/Y _14842_/Q _13218_/B VDD VSS sg13g2_nand2_1
X_14715_ _14715_/Q clkload60/A _14715_/D _14715_/RESET_B VDD VSS sg13g2_dfrbpq_1
XFILLER_61_922 VDD VSS sg13g2_decap_8
X_11927_ _11929_/B _12046_/C _11927_/B VDD VSS sg13g2_nor2_1
XFILLER_79_1195 VDD VSS sg13g2_decap_8
XFILLER_17_175 VDD VSS sg13g2_decap_8
XFILLER_60_410 VDD VSS sg13g2_decap_8
XFILLER_32_112 VDD VSS sg13g2_decap_4
X_14927__2783 _14927_/RESET_B VDD VSS sg13g2_tiehi
XFILLER_75_1059 VDD VSS sg13g2_decap_8
X_14646_ _14646_/Q clkload43/A _14646_/D _14646_/RESET_B VDD VSS sg13g2_dfrbpq_1
X_11858_ _11858_/Y _12001_/A _11858_/B VDD VSS sg13g2_nor2_1
XFILLER_82_93 VDD VSS sg13g2_decap_4
XFILLER_144_1430 VDD VSS sg13g2_decap_8
XFILLER_18_1444 VDD VSS sg13g2_decap_8
XANTENNA_19 wire556/X VDD VSS sg13g2_antennanp
XFILLER_144_1452 VDD VSS sg13g2_fill_2
XFILLER_14_882 VDD VSS sg13g2_decap_8
XFILLER_20_329 VDD VSS sg13g2_decap_8
X_10809_ _10809_/Y _10869_/A _10809_/B VDD VSS sg13g2_nor2_1
X_14577_ _14577_/Q clkload7/A _14577_/D _14577_/RESET_B VDD VSS sg13g2_dfrbpq_1
X_11789_ _11789_/X _11781_/X _11782_/X _11785_/X _11786_/X _11953_/C _11999_/S1 VDD
+ VSS sg13g2_mux4_1
XFILLER_53_1368 VDD VSS sg13g2_decap_8
XFILLER_13_392 VDD VSS sg13g2_decap_8
XFILLER_174_813 VDD VSS sg13g2_decap_8
X_13528_ _15142_/D _13535_/B _13526_/Y _13527_/Y VDD VSS sg13g2_a21oi_1
XFILLER_173_301 VDD VSS sg13g2_fill_2
XFILLER_185_161 VDD VSS sg13g2_decap_8
XFILLER_118_217 VDD VSS sg13g2_decap_8
X_13898__2374 _13898_/RESET_B VDD VSS sg13g2_tiehi
XFILLER_9_385 VDD VSS sg13g2_decap_8
XFILLER_173_345 VDD VSS sg13g2_decap_8
X_13459_ _13459_/Y _15196_/Q _15200_/Q _13459_/C _13459_/D VDD VSS sg13g2_nand4_1
XFILLER_127_751 VDD VSS sg13g2_decap_8
XFILLER_12_1043 VDD VSS sg13g2_decap_8
XFILLER_126_250 VDD VSS sg13g2_decap_8
XFILLER_161_529 VDD VSS sg13g2_decap_8
Xoutput104 mem_axi_wdata[0] _15132_/Q VDD VSS sg13g2_buf_1
Xoutput115 mem_axi_wdata[1] _15133_/Q VDD VSS sg13g2_buf_1
XFILLER_115_946 VDD VSS sg13g2_fill_1
Xoutput126 mem_axi_wdata[2] _15134_/Q VDD VSS sg13g2_buf_1
Xoutput137 mem_axi_wstrb[1] _15165_/Q VDD VSS sg13g2_buf_1
X_15129_ _15129_/Q clkload84/A _15129_/D _15129_/RESET_B VDD VSS sg13g2_dfrbpq_1
XFILLER_82_1008 VDD VSS sg13g2_decap_8
XFILLER_47_1128 VDD VSS sg13g2_decap_8
XFILLER_173_1125 VDD VSS sg13g2_fill_1
XFILLER_99_145 VDD VSS sg13g2_fill_2
XFILLER_114_467 VDD VSS sg13g2_decap_8
XFILLER_130_927 VDD VSS sg13g2_decap_4
X_07951_ _07951_/Y _15010_/Q _07818_/B VDD VSS sg13g2_nor2b_1
XFILLER_138_1289 VDD VSS sg13g2_fill_2
XFILLER_99_189 VDD VSS sg13g2_decap_8
XFILLER_141_286 VDD VSS sg13g2_decap_8
XFILLER_68_532 VDD VSS sg13g2_decap_8
XFILLER_101_139 VDD VSS sg13g2_decap_8
XFILLER_60_1317 VDD VSS sg13g2_decap_8
X_07882_ _07882_/Y _07913_/A _13609_/A VDD VSS sg13g2_nor2_1
XFILLER_25_1448 VDD VSS sg13g2_decap_8
XFILLER_96_863 VDD VSS sg13g2_decap_8
XFILLER_112_1407 VDD VSS sg13g2_fill_1
XFILLER_112_1418 VDD VSS sg13g2_fill_1
XFILLER_28_407 VDD VSS sg13g2_decap_4
X_09621_ _14217_/D _09621_/A0 _14217_/Q _09637_/S VDD VSS sg13g2_mux2_1
XFILLER_3_1211 VDD VSS sg13g2_decap_8
XFILLER_83_546 VDD VSS sg13g2_fill_1
X_09552_ _14150_/D _09618_/A0 _14150_/Q _09563_/S VDD VSS sg13g2_mux2_1
XFILLER_37_952 VDD VSS sg13g2_fill_1
XFILLER_23_1183 VDD VSS sg13g2_decap_8
XFILLER_149_1330 VDD VSS sg13g2_decap_8
XFILLER_184_1210 VDD VSS sg13g2_decap_4
X_08503_ _08503_/Y _07821_/B _07636_/Y _08497_/A VDD VSS sg13g2_o21ai_1
XFILLER_3_1288 VDD VSS sg13g2_decap_8
X_09483_ _14083_/D _10079_/A0 _14083_/Q _09501_/S VDD VSS sg13g2_mux2_1
XFILLER_52_922 VDD VSS sg13g2_decap_8
XFILLER_51_410 VDD VSS sg13g2_decap_8
XFILLER_52_944 VDD VSS sg13g2_decap_8
XFILLER_23_112 VDD VSS sg13g2_decap_8
X_08434_ _08442_/B _07828_/B _08434_/B VDD VSS sg13g2_nand2b_1
XFILLER_145_1227 VDD VSS sg13g2_decap_8
XFILLER_24_668 VDD VSS sg13g2_decap_8
XFILLER_12_819 VDD VSS sg13g2_decap_8
X_08365_ _08411_/C _07782_/A _15002_/Q _07786_/A _08351_/B VDD VSS sg13g2_a22oi_1
XFILLER_11_329 VDD VSS sg13g2_decap_8
XFILLER_177_651 VDD VSS sg13g2_decap_4
XFILLER_108_1082 VDD VSS sg13g2_decap_8
XFILLER_165_824 VDD VSS sg13g2_decap_8
XFILLER_176_161 VDD VSS sg13g2_decap_8
X_08296_ _08296_/Y _08296_/A1 _08276_/B _08369_/B VDD VSS sg13g2_a21oi_1
XFILLER_149_397 VDD VSS sg13g2_fill_2
X_13728__2544 _13728_/RESET_B VDD VSS sg13g2_tiehi
XFILLER_137_559 VDD VSS sg13g2_decap_8
XFILLER_178_1025 VDD VSS sg13g2_decap_8
X_14488__1784 _14488_/RESET_B VDD VSS sg13g2_tiehi
XFILLER_165_879 VDD VSS sg13g2_fill_1
XFILLER_105_401 VDD VSS sg13g2_decap_8
XFILLER_11_56 VDD VSS sg13g2_decap_8
XFILLER_180_838 VDD VSS sg13g2_decap_8
XFILLER_173_890 VDD VSS sg13g2_fill_1
XFILLER_3_539 VDD VSS sg13g2_decap_8
XFILLER_127_56 VDD VSS sg13g2_decap_8
XFILLER_106_979 VDD VSS sg13g2_fill_2
XFILLER_2_7 VDD VSS sg13g2_decap_8
XFILLER_156_1356 VDD VSS sg13g2_fill_2
XFILLER_117_1318 VDD VSS sg13g2_decap_8
XFILLER_132_253 VDD VSS sg13g2_decap_4
XFILLER_120_404 VDD VSS sg13g2_fill_2
X_14108__2164 _14108_/RESET_B VDD VSS sg13g2_tiehi
Xfanout1307 _11625_/C _11999_/S1 VDD VSS sg13g2_buf_1
XFILLER_120_426 VDD VSS sg13g2_fill_1
Xfanout320 _09744_/A1 _08983_/X VDD VSS sg13g2_buf_1
XFILLER_28_1050 VDD VSS sg13g2_decap_4
Xfanout1318 _11498_/A1 _12221_/B1 VDD VSS sg13g2_buf_1
XFILLER_143_11 VDD VSS sg13g2_decap_8
Xfanout331 _10163_/S wire334/X VDD VSS sg13g2_buf_1
Xfanout1329 _11953_/C _12308_/C VDD VSS sg13g2_buf_1
XFILLER_143_22 VDD VSS sg13g2_fill_2
Xfanout342 _09964_/S _09970_/S VDD VSS sg13g2_buf_1
Xfanout353 _09937_/S _09925_/S VDD VSS sg13g2_buf_1
XFILLER_8_1155 VDD VSS sg13g2_decap_8
Xfanout364 _09764_/S _09770_/S VDD VSS sg13g2_buf_1
XFILLER_87_863 VDD VSS sg13g2_decap_8
XFILLER_86_340 VDD VSS sg13g2_decap_8
Xfanout375 _09698_/S _09704_/S VDD VSS sg13g2_buf_1
XFILLER_101_662 VDD VSS sg13g2_fill_2
XFILLER_143_55 VDD VSS sg13g2_fill_2
XFILLER_4_1008 VDD VSS sg13g2_decap_8
Xfanout386 _09497_/S _09500_/S VDD VSS sg13g2_buf_1
XFILLER_47_727 VDD VSS sg13g2_decap_4
Xfanout397 _09327_/S _09339_/S VDD VSS sg13g2_buf_1
X_09819_ _14407_/D _09885_/A0 _14407_/Q _09833_/S VDD VSS sg13g2_mux2_1
XFILLER_143_88 VDD VSS sg13g2_decap_8
XFILLER_86_384 VDD VSS sg13g2_decap_8
XFILLER_98_1037 VDD VSS sg13g2_decap_8
X_12830_ _12830_/Y _14801_/Q _12851_/B _07728_/B _14833_/Q _13248_/B VDD VSS sg13g2_a221oi_1
XFILLER_98_1059 VDD VSS sg13g2_decap_8
XFILLER_46_248 VDD VSS sg13g2_decap_8
XFILLER_28_952 VDD VSS sg13g2_decap_8
XFILLER_46_259 VDD VSS sg13g2_fill_1
XFILLER_41_1283 VDD VSS sg13g2_decap_8
XFILLER_185_1029 VDD VSS sg13g2_fill_1
XFILLER_43_900 VDD VSS sg13g2_decap_8
XFILLER_36_42 VDD VSS sg13g2_decap_8
XFILLER_76_1313 VDD VSS sg13g2_fill_2
XFILLER_15_602 VDD VSS sg13g2_decap_8
X_13976__2296 _13976_/RESET_B VDD VSS sg13g2_tiehi
XFILLER_55_771 VDD VSS sg13g2_decap_8
XFILLER_55_782 VDD VSS sg13g2_fill_1
XFILLER_28_996 VDD VSS sg13g2_decap_8
X_12761_ _12761_/X _12759_/X _12758_/X _12755_/X _12754_/X _12761_/S0 _12761_/S1 VDD
+ VSS sg13g2_mux4_1
XFILLER_27_484 VDD VSS sg13g2_decap_8
XFILLER_14_112 VDD VSS sg13g2_decap_8
XFILLER_167_1474 VDD VSS sg13g2_decap_4
XFILLER_82_590 VDD VSS sg13g2_decap_8
XFILLER_42_421 VDD VSS sg13g2_decap_8
X_14500_ _14500_/Q _14744_/CLK _14500_/D _14500_/RESET_B VDD VSS sg13g2_dfrbpq_1
X_11712_ _11712_/X _14121_/Q _14153_/Q _14185_/Q _14217_/Q _11713_/S0 _11713_/S1 VDD
+ VSS sg13g2_mux4_1
X_12692_ _12692_/X _12691_/X _12690_/X _12692_/S VDD VSS sg13g2_mux2_1
XFILLER_159_117 VDD VSS sg13g2_decap_8
XFILLER_15_679 VDD VSS sg13g2_decap_8
XFILLER_146_0 VDD VSS sg13g2_decap_8
X_14431_ _14431_/Q clkload21/A _14431_/D _14431_/RESET_B VDD VSS sg13g2_dfrbpq_1
X_11643_ _11643_/Y _11643_/A _11643_/B VDD VSS sg13g2_xnor2_1
XFILLER_14_189 VDD VSS sg13g2_decap_8
XFILLER_52_41 VDD VSS sg13g2_fill_1
XFILLER_74_1081 VDD VSS sg13g2_decap_8
XFILLER_35_1043 VDD VSS sg13g2_decap_8
XFILLER_161_1051 VDD VSS sg13g2_decap_8
XFILLER_168_662 VDD VSS sg13g2_decap_8
XFILLER_161_1062 VDD VSS sg13g2_fill_2
XFILLER_168_673 VDD VSS sg13g2_decap_8
XFILLER_122_1024 VDD VSS sg13g2_decap_8
X_14362_ _14362_/Q _14620_/CLK _14362_/D _14362_/RESET_B VDD VSS sg13g2_dfrbpq_1
X_11574_ _11574_/X _13733_/Q _14085_/Q _14437_/Q _14533_/Q _11996_/S0 _11996_/S1 VDD
+ VSS sg13g2_mux4_1
XFILLER_167_161 VDD VSS sg13g2_decap_8
XFILLER_168_63 VDD VSS sg13g2_decap_8
XFILLER_7_812 VDD VSS sg13g2_decap_8
XFILLER_183_621 VDD VSS sg13g2_decap_8
Xinput17 input17/X input17/A VDD VSS sg13g2_buf_1
Xinput28 input28/X input28/A VDD VSS sg13g2_buf_1
XFILLER_11_896 VDD VSS sg13g2_decap_8
XFILLER_128_548 VDD VSS sg13g2_decap_8
XFILLER_13_1330 VDD VSS sg13g2_decap_8
X_13313_ _13316_/C _07691_/Y _07677_/B _13312_/Y VDD VSS sg13g2_a21oi_1
X_10525_ _10525_/Y _10558_/C _10531_/D _13499_/B VDD VSS sg13g2_o21ai_1
X_14293_ _14293_/Q clkload32/A _14293_/D _14293_/RESET_B VDD VSS sg13g2_dfrbpq_1
XFILLER_6_322 VDD VSS sg13g2_decap_8
X_14318__1954 _14318_/RESET_B VDD VSS sg13g2_tiehi
X_13244_ _13247_/B _13232_/A _13244_/B _13246_/C VDD VSS sg13g2_nand3b_1
XFILLER_7_889 VDD VSS sg13g2_decap_8
XFILLER_100_1333 VDD VSS sg13g2_decap_8
X_10456_ _14841_/D _14841_/Q _10453_/X _10455_/Y VDD VSS sg13g2_a21oi_1
XFILLER_182_175 VDD VSS sg13g2_decap_8
XFILLER_100_1355 VDD VSS sg13g2_decap_4
XFILLER_6_399 VDD VSS sg13g2_decap_8
XFILLER_48_1426 VDD VSS sg13g2_decap_8
X_13175_ _13176_/C _14917_/Q _13670_/Q _13145_/A _13169_/Y _13174_/Y VDD VSS sg13g2_a221oi_1
XFILLER_100_1388 VDD VSS sg13g2_decap_8
X_10387_ _10387_/X _14818_/Q _14819_/Q _14820_/Q _10396_/C VDD VSS sg13g2_and4_1
XFILLER_100_1399 VDD VSS sg13g2_fill_2
XFILLER_124_765 VDD VSS sg13g2_decap_8
XFILLER_184_84 VDD VSS sg13g2_decap_8
XFILLER_97_616 VDD VSS sg13g2_decap_8
XFILLER_174_1467 VDD VSS sg13g2_fill_2
X_15249__2588 _15249_/RESET_B VDD VSS sg13g2_tiehi
X_12126_ _12149_/A _12126_/A _12128_/A VDD VSS sg13g2_nand2_1
XFILLER_97_638 VDD VSS sg13g2_decap_8
XFILLER_35_7 VDD VSS sg13g2_decap_8
XFILLER_46_1150 VDD VSS sg13g2_decap_8
XFILLER_78_830 VDD VSS sg13g2_fill_2
XFILLER_111_448 VDD VSS sg13g2_decap_8
XFILLER_133_1120 VDD VSS sg13g2_fill_1
X_12057_ _12062_/A _11778_/A _11778_/B _12056_/X VDD VSS sg13g2_o21ai_1
XFILLER_172_1191 VDD VSS sg13g2_decap_8
XFILLER_133_1153 VDD VSS sg13g2_decap_8
XFILLER_38_716 VDD VSS sg13g2_decap_8
X_11008_ _11010_/B _10974_/Y _10989_/Y _10988_/Y VDD VSS sg13g2_a21o_1
X_16865_ _16865_/X _16865_/A VDD VSS sg13g2_buf_1
XFILLER_37_226 VDD VSS sg13g2_fill_1
XFILLER_133_1197 VDD VSS sg13g2_decap_8
XFILLER_20_1301 VDD VSS sg13g2_decap_8
XFILLER_24_1470 VDD VSS sg13g2_decap_8
XFILLER_92_354 VDD VSS sg13g2_fill_1
XFILLER_18_462 VDD VSS sg13g2_decap_8
XFILLER_93_899 VDD VSS sg13g2_fill_1
XFILLER_19_996 VDD VSS sg13g2_decap_4
X_13806__2466 _13806_/RESET_B VDD VSS sg13g2_tiehi
X_15134__2782 _15134_/RESET_B VDD VSS sg13g2_tiehi
XFILLER_93_70 VDD VSS sg13g2_decap_8
XFILLER_80_527 VDD VSS sg13g2_decap_8
XFILLER_20_1378 VDD VSS sg13g2_decap_8
X_12959_ _12959_/X _14903_/Q _13684_/Q _12945_/Y VDD VSS sg13g2_a21o_1
XFILLER_45_281 VDD VSS sg13g2_decap_8
XFILLER_55_1419 VDD VSS sg13g2_decap_8
XFILLER_179_938 VDD VSS sg13g2_decap_8
XFILLER_60_240 VDD VSS sg13g2_fill_1
XFILLER_34_988 VDD VSS sg13g2_decap_4
XFILLER_33_465 VDD VSS sg13g2_fill_2
XFILLER_61_785 VDD VSS sg13g2_decap_8
XFILLER_60_262 VDD VSS sg13g2_decap_8
XFILLER_178_448 VDD VSS sg13g2_decap_8
XFILLER_18_1241 VDD VSS sg13g2_decap_8
X_14629_ _14629_/Q _14725_/CLK _14629_/D _14629_/RESET_B VDD VSS sg13g2_dfrbpq_1
XFILLER_92_1170 VDD VSS sg13g2_fill_2
XFILLER_105_1200 VDD VSS sg13g2_decap_8
XFILLER_20_126 VDD VSS sg13g2_decap_8
XFILLER_53_1143 VDD VSS sg13g2_fill_2
X_08150_ _08150_/X _08013_/X _08146_/A _08397_/B _08011_/X _08511_/S _08241_/A VDD
+ VSS sg13g2_mux4_1
XFILLER_144_1282 VDD VSS sg13g2_decap_4
XFILLER_14_1127 VDD VSS sg13g2_decap_8
XFILLER_159_684 VDD VSS sg13g2_fill_1
XFILLER_174_610 VDD VSS sg13g2_decap_8
X_13673__2619 _13673_/RESET_B VDD VSS sg13g2_tiehi
XFILLER_53_1187 VDD VSS sg13g2_decap_8
XFILLER_147_857 VDD VSS sg13g2_decap_8
XFILLER_105_1277 VDD VSS sg13g2_fill_1
XFILLER_146_334 VDD VSS sg13g2_decap_8
X_08081_ _08081_/X _07853_/B _07965_/B _07972_/B _08653_/B _08598_/S0 _07627_/A VDD
+ VSS sg13g2_mux4_1
XFILLER_9_182 VDD VSS sg13g2_decap_8
XFILLER_61_0 VDD VSS sg13g2_decap_8
XFILLER_173_175 VDD VSS sg13g2_decap_8
XFILLER_127_592 VDD VSS sg13g2_decap_4
XFILLER_115_743 VDD VSS sg13g2_decap_8
XFILLER_114_231 VDD VSS sg13g2_decap_8
XFILLER_177_1080 VDD VSS sg13g2_fill_1
XFILLER_138_1042 VDD VSS sg13g2_fill_2
XFILLER_142_562 VDD VSS sg13g2_decap_8
XFILLER_130_724 VDD VSS sg13g2_decap_8
XFILLER_114_286 VDD VSS sg13g2_fill_1
X_08983_ _08983_/X _09006_/A _08980_/X _08982_/Y VDD VSS sg13g2_a21o_1
XFILLER_9_1442 VDD VSS sg13g2_decap_8
X_15180__2940 _15180_/RESET_B VDD VSS sg13g2_tiehi
X_07934_ _07934_/Y _08351_/B _07786_/A VDD VSS sg13g2_nor2b_1
XFILLER_151_1231 VDD VSS sg13g2_decap_8
XFILLER_96_660 VDD VSS sg13g2_fill_2
XFILLER_25_1245 VDD VSS sg13g2_decap_8
XFILLER_111_971 VDD VSS sg13g2_decap_4
XFILLER_29_716 VDD VSS sg13g2_decap_8
XFILLER_21_1109 VDD VSS sg13g2_decap_8
X_07865_ _07867_/D _08641_/A _08641_/B _08641_/C _08641_/D VDD VSS sg13g2_nand4_1
XFILLER_99_1324 VDD VSS sg13g2_decap_8
XFILLER_60_1158 VDD VSS sg13g2_decap_8
XFILLER_68_384 VDD VSS sg13g2_decap_4
XFILLER_56_524 VDD VSS sg13g2_decap_8
XFILLER_29_749 VDD VSS sg13g2_decap_4
XFILLER_95_181 VDD VSS sg13g2_decap_8
X_09604_ _14201_/D _14201_/Q _09637_/A0 _09604_/S VDD VSS sg13g2_mux2_1
XFILLER_84_877 VDD VSS sg13g2_decap_8
XFILLER_44_708 VDD VSS sg13g2_fill_2
X_07796_ _07796_/Y _07796_/A _07796_/B _07797_/D VDD VSS sg13g2_nor3_1
XFILLER_83_365 VDD VSS sg13g2_decap_8
XFILLER_84_899 VDD VSS sg13g2_decap_4
XFILLER_83_376 VDD VSS sg13g2_fill_1
X_09535_ _14134_/D _09933_/A1 _14134_/Q _09538_/S VDD VSS sg13g2_mux2_1
XFILLER_3_1085 VDD VSS sg13g2_decap_8
XFILLER_97_1092 VDD VSS sg13g2_decap_8
XFILLER_58_1043 VDD VSS sg13g2_decap_8
X_09466_ _14067_/D _10095_/A0 _14067_/Q _09472_/S VDD VSS sg13g2_mux2_1
XFILLER_12_616 VDD VSS sg13g2_decap_8
X_08417_ _08417_/Y _08418_/B _08417_/B VDD VSS sg13g2_nand2_1
X_09397_ _14000_/D _10026_/A0 _14000_/Q _09399_/S VDD VSS sg13g2_mux2_1
XFILLER_36_1341 VDD VSS sg13g2_fill_1
XFILLER_11_126 VDD VSS sg13g2_decap_8
XFILLER_71_1232 VDD VSS sg13g2_fill_1
XFILLER_40_958 VDD VSS sg13g2_decap_8
XFILLER_8_609 VDD VSS sg13g2_decap_8
X_08348_ _08348_/Y _07786_/A _08351_/B _08369_/B VDD VSS sg13g2_a21oi_1
XFILLER_178_993 VDD VSS sg13g2_decap_8
X_15048__2622 _15048_/RESET_B VDD VSS sg13g2_tiehi
XFILLER_32_1216 VDD VSS sg13g2_fill_2
X_14611__1661 _14611_/RESET_B VDD VSS sg13g2_tiehi
XFILLER_7_119 VDD VSS sg13g2_decap_8
XFILLER_36_1396 VDD VSS sg13g2_decap_4
XFILLER_149_172 VDD VSS sg13g2_decap_8
XFILLER_32_1249 VDD VSS sg13g2_decap_4
XFILLER_20_682 VDD VSS sg13g2_fill_2
X_08279_ _08279_/X _08279_/A _08452_/D VDD VSS sg13g2_and2_1
XFILLER_22_77 VDD VSS sg13g2_decap_8
XFILLER_180_602 VDD VSS sg13g2_decap_8
X_10310_ _10327_/C _14796_/Q _14797_/Q VDD VSS sg13g2_and2_1
XFILLER_153_838 VDD VSS sg13g2_fill_1
X_11290_ _11338_/A _11290_/A _12836_/B VDD VSS sg13g2_nor2_1
XFILLER_4_826 VDD VSS sg13g2_decap_8
XFILLER_138_99 VDD VSS sg13g2_decap_8
XFILLER_105_220 VDD VSS sg13g2_fill_2
X_10241_ _10241_/Y _14775_/Q _10237_/Y _10350_/C VDD VSS sg13g2_o21ai_1
XFILLER_3_336 VDD VSS sg13g2_decap_8
XFILLER_106_754 VDD VSS sg13g2_fill_1
XFILLER_156_1142 VDD VSS sg13g2_decap_8
XFILLER_154_21 VDD VSS sg13g2_decap_8
XFILLER_79_627 VDD VSS sg13g2_fill_1
XFILLER_154_43 VDD VSS sg13g2_decap_8
X_10172_ _10185_/B _13507_/A _14766_/Q _10172_/C _13600_/A VDD VSS sg13g2_or4_1
XFILLER_26_1009 VDD VSS sg13g2_decap_8
XFILLER_105_286 VDD VSS sg13g2_fill_2
Xfanout1104 _08035_/A _14993_/Q VDD VSS sg13g2_buf_1
XFILLER_78_126 VDD VSS sg13g2_decap_8
Xfanout1115 _08244_/B _08142_/B VDD VSS sg13g2_buf_1
XFILLER_78_137 VDD VSS sg13g2_fill_1
XFILLER_47_1470 VDD VSS sg13g2_decap_8
XFILLER_152_1039 VDD VSS sg13g2_fill_2
Xfanout1126 _08669_/B1 _08598_/S1 VDD VSS sg13g2_buf_1
XFILLER_78_148 VDD VSS sg13g2_decap_8
XFILLER_120_245 VDD VSS sg13g2_decap_8
X_14980_ _14980_/Q _14982_/CLK _14980_/D _14980_/RESET_B VDD VSS sg13g2_dfrbpq_1
Xfanout1137 _08054_/B _08635_/S0 VDD VSS sg13g2_buf_1
Xfanout150 _09472_/A0 fanout152/X VDD VSS sg13g2_buf_1
Xfanout1148 _13517_/A _14989_/Q VDD VSS sg13g2_buf_1
XFILLER_75_800 VDD VSS sg13g2_decap_8
Xfanout161 _10099_/A0 fanout162/X VDD VSS sg13g2_buf_1
Xfanout1159 _12152_/A _14984_/Q VDD VSS sg13g2_buf_1
XFILLER_43_1345 VDD VSS sg13g2_decap_8
XFILLER_102_982 VDD VSS sg13g2_decap_8
Xfanout172 _10163_/A1 _09799_/A0 VDD VSS sg13g2_buf_1
XFILLER_59_362 VDD VSS sg13g2_decap_8
X_13931_ _13931_/Q clkload6/A _13931_/D _13931_/RESET_B VDD VSS sg13g2_dfrbpq_1
Xfanout183 _09597_/A1 _09929_/A1 VDD VSS sg13g2_buf_1
Xfanout194 _09627_/A0 _09462_/A0 VDD VSS sg13g2_buf_1
XFILLER_47_52 VDD VSS sg13g2_decap_8
XFILLER_43_1389 VDD VSS sg13g2_decap_8
XFILLER_170_42 VDD VSS sg13g2_decap_8
XFILLER_19_259 VDD VSS sg13g2_decap_8
X_13862_ _13862_/Q _14726_/CLK _13862_/D _13862_/RESET_B VDD VSS sg13g2_dfrbpq_1
XFILLER_47_96 VDD VSS sg13g2_fill_2
XFILLER_90_825 VDD VSS sg13g2_decap_8
XFILLER_62_516 VDD VSS sg13g2_decap_8
X_12813_ _12813_/X _12899_/A _12814_/C _12899_/C input21/X VDD VSS sg13g2_and4_1
X_13793_ _13793_/Q clkload44/A _13793_/D _13793_/RESET_B VDD VSS sg13g2_dfrbpq_1
XFILLER_90_869 VDD VSS sg13g2_decap_8
XFILLER_167_1271 VDD VSS sg13g2_fill_1
XFILLER_16_966 VDD VSS sg13g2_decap_8
XFILLER_37_1105 VDD VSS sg13g2_fill_1
X_12744_ _12744_/X _14391_/Q _14423_/Q _14487_/Q _14519_/Q _12745_/S0 _12745_/S1 VDD
+ VSS sg13g2_mux4_1
XFILLER_43_774 VDD VSS sg13g2_decap_8
XFILLER_15_476 VDD VSS sg13g2_decap_8
XFILLER_70_582 VDD VSS sg13g2_decap_8
XFILLER_31_947 VDD VSS sg13g2_fill_1
XFILLER_30_424 VDD VSS sg13g2_decap_8
XFILLER_128_1288 VDD VSS sg13g2_decap_4
X_12675_ _12675_/X _13970_/Q _14002_/Q _14034_/Q _14066_/Q _12675_/S0 _12675_/S1 VDD
+ VSS sg13g2_mux4_1
XFILLER_15_1403 VDD VSS sg13g2_decap_8
XFILLER_179_84 VDD VSS sg13g2_decap_8
XFILLER_30_435 VDD VSS sg13g2_fill_2
XFILLER_175_418 VDD VSS sg13g2_decap_8
X_14414_ _14414_/Q _14685_/CLK _14414_/D _14414_/RESET_B VDD VSS sg13g2_dfrbpq_1
XFILLER_8_35 VDD VSS sg13g2_decap_8
X_11626_ _11626_/Y _11606_/Y _11608_/X _11975_/A VDD VSS sg13g2_o21ai_1
XFILLER_54_1474 VDD VSS sg13g2_fill_1
XFILLER_168_470 VDD VSS sg13g2_fill_2
XFILLER_129_846 VDD VSS sg13g2_decap_8
X_14345_ _14345_/Q clkload34/A _14345_/D _14345_/RESET_B VDD VSS sg13g2_dfrbpq_1
XFILLER_11_693 VDD VSS sg13g2_decap_8
XFILLER_129_879 VDD VSS sg13g2_decap_8
XFILLER_141_1477 VDD VSS sg13g2_fill_2
X_11557_ _11557_/Y _11533_/Y _11535_/Y _12046_/C VDD VSS sg13g2_a21oi_1
XFILLER_183_462 VDD VSS sg13g2_decap_8
XFILLER_155_164 VDD VSS sg13g2_decap_8
XFILLER_116_529 VDD VSS sg13g2_decap_8
XFILLER_128_389 VDD VSS sg13g2_decap_8
Xwire584 wire584/X wire584/A VDD VSS sg13g2_buf_2
X_10508_ _10509_/D _10508_/A _14850_/Q _10508_/C VDD VSS sg13g2_nand3_1
X_14276_ _14276_/Q clkload15/A _14276_/D _14276_/RESET_B VDD VSS sg13g2_dfrbpq_1
X_11488_ _11488_/X _14242_/Q _14274_/Q _14306_/Q _14338_/Q _11489_/S0 _11489_/S1 VDD
+ VSS sg13g2_mux4_1
XFILLER_7_686 VDD VSS sg13g2_decap_8
XFILLER_170_112 VDD VSS sg13g2_decap_8
XFILLER_171_635 VDD VSS sg13g2_decap_8
X_13227_ _13228_/C _14921_/Q _13666_/Q _13199_/X VDD VSS sg13g2_o21ai_1
X_10439_ _10459_/B _14836_/Q _14835_/Q _14834_/Q _14833_/Q VDD VSS sg13g2_nand4_1
XFILLER_6_196 VDD VSS sg13g2_decap_8
XFILLER_100_1174 VDD VSS sg13g2_decap_8
XFILLER_174_1231 VDD VSS sg13g2_fill_1
XFILLER_124_573 VDD VSS sg13g2_decap_8
XFILLER_139_1373 VDD VSS sg13g2_decap_8
XFILLER_83_1136 VDD VSS sg13g2_decap_8
XFILLER_174_1264 VDD VSS sg13g2_decap_8
XFILLER_88_70 VDD VSS sg13g2_decap_4
XFILLER_152_893 VDD VSS sg13g2_decap_8
X_13158_ _13160_/C _13174_/A _13158_/B _13170_/D VDD VSS sg13g2_nand3_1
XFILLER_48_1289 VDD VSS sg13g2_decap_8
XFILLER_135_1259 VDD VSS sg13g2_decap_8
X_12109_ _12109_/Y _12100_/S0 _13844_/Q VDD VSS sg13g2_nand2b_1
X_13089_ _13112_/A _14912_/Q _13675_/Q VDD VSS sg13g2_xnor2_1
XFILLER_66_800 VDD VSS sg13g2_decap_8
XFILLER_22_1429 VDD VSS sg13g2_decap_8
X_14653__1619 _14653_/RESET_B VDD VSS sg13g2_tiehi
XFILLER_65_332 VDD VSS sg13g2_decap_8
X_07650_ _10818_/A _15122_/Q VDD VSS sg13g2_inv_1
XFILLER_19_771 VDD VSS sg13g2_decap_8
XFILLER_93_685 VDD VSS sg13g2_fill_1
XFILLER_66_899 VDD VSS sg13g2_fill_2
XFILLER_4_1372 VDD VSS sg13g2_decap_8
XFILLER_94_1210 VDD VSS sg13g2_decap_4
XFILLER_0_1247 VDD VSS sg13g2_decap_8
XFILLER_20_1175 VDD VSS sg13g2_decap_8
X_09320_ _13927_/D _09918_/A1 _13927_/Q _09338_/S VDD VSS sg13g2_mux2_1
XFILLER_55_1216 VDD VSS sg13g2_decap_8
XFILLER_61_560 VDD VSS sg13g2_fill_2
XFILLER_59_1396 VDD VSS sg13g2_decap_8
XFILLER_146_1355 VDD VSS sg13g2_fill_2
XFILLER_90_1118 VDD VSS sg13g2_decap_8
XFILLER_55_1238 VDD VSS sg13g2_decap_8
X_09251_ _13860_/D _13860_/Q _09882_/A0 _09271_/S VDD VSS sg13g2_mux2_1
XFILLER_167_908 VDD VSS sg13g2_decap_8
XFILLER_179_768 VDD VSS sg13g2_decap_8
XFILLER_178_245 VDD VSS sg13g2_decap_8
XFILLER_21_435 VDD VSS sg13g2_decap_8
X_08202_ _08211_/D _08234_/B _08198_/X _08201_/Y VDD VSS sg13g2_o21ai_1
X_15021__2659 _15021_/RESET_B VDD VSS sg13g2_tiehi
X_09182_ _13798_/D _13798_/Q _10149_/A1 _09193_/S VDD VSS sg13g2_mux2_1
XFILLER_105_1052 VDD VSS sg13g2_decap_8
X_08133_ _08133_/X _08142_/C _11454_/A _07912_/B _11461_/A _08300_/S1 _13517_/A VDD
+ VSS sg13g2_mux4_1
XFILLER_105_1063 VDD VSS sg13g2_fill_1
XFILLER_88_1003 VDD VSS sg13g2_fill_2
XFILLER_88_1014 VDD VSS sg13g2_decap_8
XFILLER_147_676 VDD VSS sg13g2_decap_8
XFILLER_147_687 VDD VSS sg13g2_decap_4
X_08064_ _08064_/X _11291_/A _11384_/A _11335_/A _11428_/A _08033_/A _08023_/A VDD
+ VSS sg13g2_mux4_1
XFILLER_108_14 VDD VSS sg13g2_fill_2
XFILLER_174_495 VDD VSS sg13g2_decap_8
XFILLER_134_348 VDD VSS sg13g2_decap_8
XFILLER_150_808 VDD VSS sg13g2_decap_8
XFILLER_162_668 VDD VSS sg13g2_decap_8
XFILLER_103_702 VDD VSS sg13g2_decap_8
Xhold3201 _13636_/A _13744_/Q VDD VSS sg13g2_dlygate4sd3_1
XFILLER_157_1473 VDD VSS sg13g2_fill_2
Xhold3212 _13633_/A _13741_/Q VDD VSS sg13g2_dlygate4sd3_1
XFILLER_27_1307 VDD VSS sg13g2_decap_8
XFILLER_103_724 VDD VSS sg13g2_decap_8
XFILLER_118_1435 VDD VSS sg13g2_decap_8
XFILLER_130_510 VDD VSS sg13g2_fill_1
Xhold3223 _13641_/A _13749_/Q VDD VSS sg13g2_dlygate4sd3_1
XFILLER_118_1446 VDD VSS sg13g2_fill_2
Xhold3234 _13531_/A _15143_/Q VDD VSS sg13g2_dlygate4sd3_1
Xhold3245 hold3245/X _14795_/Q VDD VSS sg13g2_dlygate4sd3_1
XFILLER_102_234 VDD VSS sg13g2_decap_8
Xhold3256 hold3256/X _14894_/Q VDD VSS sg13g2_dlygate4sd3_1
X_08966_ _08966_/Y _15060_/Q _10697_/B VDD VSS sg13g2_nor2b_1
XFILLER_88_479 VDD VSS sg13g2_decap_8
XFILLER_76_619 VDD VSS sg13g2_decap_8
XFILLER_102_267 VDD VSS sg13g2_decap_8
X_14868__2901 _14868_/RESET_B VDD VSS sg13g2_tiehi
XFILLER_151_1050 VDD VSS sg13g2_decap_8
X_07917_ _08160_/C _07917_/A _07917_/B _07917_/C VDD VSS sg13g2_nor3_1
X_08897_ _08897_/Y _10793_/A _10793_/B _15038_/Q VDD VSS sg13g2_nand3_1
XFILLER_99_1132 VDD VSS sg13g2_decap_4
XFILLER_68_181 VDD VSS sg13g2_decap_8
XFILLER_25_1075 VDD VSS sg13g2_fill_2
XFILLER_84_652 VDD VSS sg13g2_fill_1
XFILLER_5_1169 VDD VSS sg13g2_decap_8
X_14629__1643 _14629_/RESET_B VDD VSS sg13g2_tiehi
X_07848_ _08643_/C _15016_/Q _07965_/B VDD VSS sg13g2_or2_1
XFILLER_84_685 VDD VSS sg13g2_decap_4
XFILLER_83_162 VDD VSS sg13g2_fill_2
XFILLER_186_1146 VDD VSS sg13g2_decap_8
XFILLER_71_313 VDD VSS sg13g2_decap_8
XFILLER_140_34 VDD VSS sg13g2_decap_8
XFILLER_186_1157 VDD VSS sg13g2_decap_8
XFILLER_56_398 VDD VSS sg13g2_decap_8
X_07779_ _07779_/Y _08318_/C _08318_/D VDD VSS sg13g2_nor2_1
XFILLER_77_1441 VDD VSS sg13g2_fill_2
XFILLER_37_590 VDD VSS sg13g2_fill_2
XFILLER_17_77 VDD VSS sg13g2_decap_8
XFILLER_164_1411 VDD VSS sg13g2_decap_8
X_09518_ _14117_/D _09949_/A1 _14117_/Q _09530_/S VDD VSS sg13g2_mux2_1
XFILLER_13_903 VDD VSS sg13g2_decap_8
X_10790_ _10790_/Y _14924_/Q _11156_/B VDD VSS sg13g2_nand2_1
XFILLER_73_1338 VDD VSS sg13g2_decap_8
XFILLER_38_1458 VDD VSS sg13g2_decap_8
XFILLER_12_413 VDD VSS sg13g2_decap_8
XFILLER_158_908 VDD VSS sg13g2_fill_1
XFILLER_25_796 VDD VSS sg13g2_decap_8
XFILLER_24_273 VDD VSS sg13g2_fill_2
X_09449_ _14050_/D _10045_/A0 _14050_/Q _09462_/S VDD VSS sg13g2_mux2_1
XFILLER_33_21 VDD VSS sg13g2_decap_8
XFILLER_157_407 VDD VSS sg13g2_decap_8
XFILLER_149_21 VDD VSS sg13g2_decap_8
XFILLER_8_406 VDD VSS sg13g2_decap_8
X_12460_ _12460_/X _14691_/Q _14723_/Q _13763_/Q _13795_/Q _12769_/S0 _12769_/S1 VDD
+ VSS sg13g2_mux4_1
XFILLER_123_1130 VDD VSS sg13g2_decap_8
XFILLER_36_1182 VDD VSS sg13g2_decap_8
XFILLER_33_98 VDD VSS sg13g2_decap_8
X_11411_ _11411_/Y _11407_/Y _11408_/Y _11410_/Y _11409_/Y _11822_/B VDD VSS sg13g2_a221oi_1
XFILLER_137_131 VDD VSS sg13g2_decap_8
X_12391_ _12391_/X _14558_/Q _14590_/Q _14622_/Q _14654_/Q _12411_/S0 _12411_/S1 VDD
+ VSS sg13g2_mux4_1
XFILLER_71_1095 VDD VSS sg13g2_decap_4
XFILLER_181_900 VDD VSS sg13g2_decap_8
XFILLER_123_1196 VDD VSS sg13g2_decap_8
X_14130_ _14130_/Q _14674_/CLK _14130_/D _14130_/RESET_B VDD VSS sg13g2_dfrbpq_1
X_11342_ _11342_/Y _11821_/S0 _13822_/Q VDD VSS sg13g2_nand2b_1
XFILLER_137_175 VDD VSS sg13g2_decap_4
XFILLER_158_1215 VDD VSS sg13g2_fill_2
XFILLER_4_623 VDD VSS sg13g2_decap_8
XFILLER_10_1344 VDD VSS sg13g2_decap_8
XFILLER_109_0 VDD VSS sg13g2_decap_8
XFILLER_165_42 VDD VSS sg13g2_decap_8
X_14061_ _14061_/Q clkload18/A _14061_/D _14061_/RESET_B VDD VSS sg13g2_dfrbpq_1
X_11273_ _11273_/Y _11275_/S0 _14492_/Q _11872_/B1 VDD VSS sg13g2_a21oi_1
XFILLER_3_133 VDD VSS sg13g2_decap_8
XFILLER_181_999 VDD VSS sg13g2_decap_8
XFILLER_180_476 VDD VSS sg13g2_decap_8
XFILLER_79_402 VDD VSS sg13g2_decap_8
X_13012_ _13012_/Y _13012_/A _13026_/C VDD VSS sg13g2_nor2_1
X_10224_ _10227_/C _14769_/Q _10219_/X _14770_/Q VDD VSS sg13g2_a21oi_1
XFILLER_79_457 VDD VSS sg13g2_decap_8
X_10155_ _14732_/D _14732_/Q _10155_/A1 _10169_/S VDD VSS sg13g2_mux2_1
XFILLER_0_862 VDD VSS sg13g2_decap_8
XFILLER_82_1191 VDD VSS sg13g2_decap_4
XFILLER_48_822 VDD VSS sg13g2_decap_8
XFILLER_181_63 VDD VSS sg13g2_decap_8
X_14963_ _14963_/Q clkload76/A _14963_/D _14963_/RESET_B VDD VSS sg13g2_dfrbpq_1
X_10086_ _14666_/D _10086_/A0 _14666_/Q _10093_/S VDD VSS sg13g2_mux2_1
XFILLER_48_833 VDD VSS sg13g2_fill_1
XFILLER_87_490 VDD VSS sg13g2_decap_4
XFILLER_130_1134 VDD VSS sg13g2_decap_8
XFILLER_47_332 VDD VSS sg13g2_fill_2
X_13914_ _13914_/Q clkload51/A _13914_/D _13914_/RESET_B VDD VSS sg13g2_dfrbpq_1
XFILLER_169_1333 VDD VSS sg13g2_fill_2
X_14894_ _14894_/Q clkload63/A _14894_/D _14894_/RESET_B VDD VSS sg13g2_dfrbpq_1
XFILLER_75_674 VDD VSS sg13g2_fill_2
XFILLER_74_173 VDD VSS sg13g2_decap_8
XFILLER_21_1473 VDD VSS sg13g2_decap_4
X_13845_ _13845_/Q clkload28/A _13845_/D _13845_/RESET_B VDD VSS sg13g2_dfrbpq_1
XFILLER_90_666 VDD VSS sg13g2_decap_8
XFILLER_16_763 VDD VSS sg13g2_decap_8
XFILLER_62_368 VDD VSS sg13g2_decap_8
X_13776_ _13776_/Q clkload10/A _13776_/D _13776_/RESET_B VDD VSS sg13g2_dfrbpq_1
X_10988_ _10988_/Y _15116_/Q _10995_/B VDD VSS sg13g2_nor2b_1
X_15173__3042 _15173_/RESET_B VDD VSS sg13g2_tiehi
XFILLER_15_273 VDD VSS sg13g2_decap_8
XFILLER_149_908 VDD VSS sg13g2_fill_1
X_12727_ _12727_/X _13974_/Q _14006_/Q _14038_/Q _14070_/Q _12730_/S0 _12730_/S1 VDD
+ VSS sg13g2_mux4_1
XFILLER_176_716 VDD VSS sg13g2_fill_2
XFILLER_15_1200 VDD VSS sg13g2_decap_8
XFILLER_148_429 VDD VSS sg13g2_fill_1
XFILLER_90_71 VDD VSS sg13g2_decap_4
X_12658_ _12658_/X _13841_/Q _13873_/Q _13905_/Q _13937_/Q _12659_/S0 _12659_/S1 VDD
+ VSS sg13g2_mux4_1
XFILLER_106_1350 VDD VSS sg13g2_fill_2
XFILLER_12_980 VDD VSS sg13g2_decap_8
X_14067__2205 _14067_/RESET_B VDD VSS sg13g2_tiehi
XFILLER_180_1290 VDD VSS sg13g2_fill_1
XFILLER_30_287 VDD VSS sg13g2_decap_8
XFILLER_129_654 VDD VSS sg13g2_fill_1
XFILLER_141_1252 VDD VSS sg13g2_decap_8
XFILLER_175_259 VDD VSS sg13g2_decap_8
X_11609_ _11609_/Y _11621_/S0 _14374_/Q VDD VSS sg13g2_nand2b_1
XFILLER_117_816 VDD VSS sg13g2_decap_8
XFILLER_11_490 VDD VSS sg13g2_decap_8
XFILLER_141_1274 VDD VSS sg13g2_decap_8
XFILLER_15_1277 VDD VSS sg13g2_decap_8
X_12589_ _12589_/X _14572_/Q _14604_/Q _14636_/Q _14668_/Q _12783_/S0 _12783_/S1 VDD
+ VSS sg13g2_mux4_1
XFILLER_144_602 VDD VSS sg13g2_decap_8
XFILLER_8_973 VDD VSS sg13g2_decap_8
XFILLER_176_1304 VDD VSS sg13g2_fill_1
X_14328_ _14328_/Q _14664_/CLK _14328_/D _14328_/RESET_B VDD VSS sg13g2_dfrbpq_1
XFILLER_128_175 VDD VSS sg13g2_decap_8
XFILLER_176_1326 VDD VSS sg13g2_decap_8
XFILLER_7_483 VDD VSS sg13g2_decap_8
XFILLER_143_123 VDD VSS sg13g2_decap_8
XFILLER_144_646 VDD VSS sg13g2_decap_4
XFILLER_172_988 VDD VSS sg13g2_decap_8
X_14259_ _14259_/Q clkload39/A _14259_/D _14259_/RESET_B VDD VSS sg13g2_dfrbpq_1
X_14707__1565 _14707_/RESET_B VDD VSS sg13g2_tiehi
XFILLER_143_189 VDD VSS sg13g2_fill_1
XFILLER_112_510 VDD VSS sg13g2_fill_2
XFILLER_97_210 VDD VSS sg13g2_decap_8
XFILLER_174_1061 VDD VSS sg13g2_fill_1
Xfanout908 _12452_/S1 _12425_/S1 VDD VSS sg13g2_buf_1
XFILLER_98_744 VDD VSS sg13g2_decap_8
XFILLER_135_1023 VDD VSS sg13g2_decap_8
Xfanout919 _12604_/S0 fanout932/X VDD VSS sg13g2_buf_1
X_08820_ _08820_/Y _13482_/A _15191_/Q VDD VSS sg13g2_nand2_1
XFILLER_98_766 VDD VSS sg13g2_decap_8
XFILLER_86_917 VDD VSS sg13g2_decap_8
XFILLER_97_265 VDD VSS sg13g2_decap_8
XFILLER_61_1231 VDD VSS sg13g2_decap_4
XFILLER_24_0 VDD VSS sg13g2_decap_8
XFILLER_100_738 VDD VSS sg13g2_decap_8
XFILLER_26_1362 VDD VSS sg13g2_decap_8
X_08751_ _08751_/Y _07720_/A _07720_/B _15193_/Q VDD VSS sg13g2_o21ai_1
XFILLER_61_1253 VDD VSS sg13g2_decap_8
XFILLER_38_310 VDD VSS sg13g2_fill_1
XFILLER_6_1456 VDD VSS sg13g2_decap_8
XFILLER_38_321 VDD VSS sg13g2_decap_4
XFILLER_22_1226 VDD VSS sg13g2_decap_8
Xfanout1490 _10499_/C fanout1507/X VDD VSS sg13g2_buf_1
X_07702_ _07702_/X _10647_/A _10441_/C VDD VSS sg13g2_and2_1
XFILLER_2_1309 VDD VSS sg13g2_decap_8
XFILLER_66_663 VDD VSS sg13g2_decap_8
XFILLER_39_877 VDD VSS sg13g2_fill_2
X_08682_ _08682_/Y _08678_/Y _08647_/Y _08681_/Y VDD VSS sg13g2_o21ai_1
XFILLER_94_983 VDD VSS sg13g2_fill_1
XFILLER_81_600 VDD VSS sg13g2_decap_8
XFILLER_65_162 VDD VSS sg13g2_decap_4
XFILLER_54_825 VDD VSS sg13g2_fill_2
X_07633_ _08203_/B _14995_/Q VDD VSS sg13g2_inv_1
XFILLER_53_335 VDD VSS sg13g2_decap_8
XFILLER_0_1044 VDD VSS sg13g2_decap_8
XFILLER_0_91 VDD VSS sg13g2_decap_8
XFILLER_81_677 VDD VSS sg13g2_decap_8
XFILLER_22_700 VDD VSS sg13g2_decap_8
XFILLER_146_1130 VDD VSS sg13g2_fill_2
XFILLER_179_532 VDD VSS sg13g2_decap_8
XFILLER_62_880 VDD VSS sg13g2_decap_8
XFILLER_34_571 VDD VSS sg13g2_decap_8
X_09303_ _13911_/D _13911_/Q _10166_/A1 _09303_/S VDD VSS sg13g2_mux2_1
XFILLER_21_210 VDD VSS sg13g2_decap_8
XFILLER_146_1174 VDD VSS sg13g2_decap_8
XFILLER_146_1185 VDD VSS sg13g2_fill_1
XFILLER_10_917 VDD VSS sg13g2_decap_8
X_09234_ _13845_/D _10164_/A1 _13845_/Q _09238_/S VDD VSS sg13g2_mux2_1
XFILLER_148_930 VDD VSS sg13g2_decap_8
XFILLER_166_259 VDD VSS sg13g2_decap_8
X_09165_ _09165_/Y _09157_/C _09164_/X _14925_/Q _09158_/C VDD VSS sg13g2_a22oi_1
XFILLER_120_1336 VDD VSS sg13g2_fill_2
X_08116_ _08116_/Y _13427_/C _07916_/Y _08115_/Y VDD VSS sg13g2_a21oi_1
XFILLER_33_1399 VDD VSS sg13g2_decap_8
XFILLER_107_315 VDD VSS sg13g2_decap_8
X_09096_ _09136_/B _14915_/Q _09103_/C _09103_/D VDD VSS sg13g2_and3_1
XFILLER_120_1358 VDD VSS sg13g2_decap_8
XFILLER_119_197 VDD VSS sg13g2_decap_8
XFILLER_120_1369 VDD VSS sg13g2_fill_1
XFILLER_162_432 VDD VSS sg13g2_decap_8
XFILLER_163_966 VDD VSS sg13g2_decap_8
XFILLER_107_359 VDD VSS sg13g2_decap_8
X_08047_ _08047_/Y _08046_/B _08653_/B _08046_/Y VDD VSS sg13g2_o21ai_1
XFILLER_102_7 VDD VSS sg13g2_fill_2
XFILLER_122_307 VDD VSS sg13g2_fill_1
XFILLER_89_711 VDD VSS sg13g2_fill_1
XFILLER_27_1104 VDD VSS sg13g2_decap_8
XFILLER_1_637 VDD VSS sg13g2_decap_8
X_13765__2507 _13765_/RESET_B VDD VSS sg13g2_tiehi
XFILLER_89_744 VDD VSS sg13g2_decap_8
XFILLER_89_755 VDD VSS sg13g2_fill_2
XFILLER_62_1006 VDD VSS sg13g2_decap_8
XFILLER_0_147 VDD VSS sg13g2_decap_8
XFILLER_103_565 VDD VSS sg13g2_fill_1
XFILLER_131_874 VDD VSS sg13g2_decap_4
X_13801__2471 _13801_/RESET_B VDD VSS sg13g2_tiehi
X_09998_ _14581_/D _09998_/A0 _14581_/Q _09998_/S VDD VSS sg13g2_mux2_1
XFILLER_103_587 VDD VSS sg13g2_decap_8
XFILLER_88_287 VDD VSS sg13g2_decap_8
XFILLER_44_1462 VDD VSS sg13g2_decap_8
X_08949_ _08949_/Y _10725_/A _14955_/Q VDD VSS sg13g2_nand2_1
XFILLER_28_21 VDD VSS sg13g2_decap_8
XFILLER_91_408 VDD VSS sg13g2_fill_1
X_11960_ _11960_/Y _11738_/S _14480_/Q VDD VSS sg13g2_nand2b_1
XFILLER_85_983 VDD VSS sg13g2_decap_8
XFILLER_72_600 VDD VSS sg13g2_decap_8
X_14145__2127 _14145_/RESET_B VDD VSS sg13g2_tiehi
XFILLER_85_994 VDD VSS sg13g2_fill_1
XFILLER_57_685 VDD VSS sg13g2_fill_1
XFILLER_151_66 VDD VSS sg13g2_fill_1
X_10911_ _10911_/Y _10910_/Y _10908_/Y _10907_/Y _10924_/B1 _08723_/B VDD VSS sg13g2_a221oi_1
XFILLER_151_88 VDD VSS sg13g2_decap_8
XFILLER_84_493 VDD VSS sg13g2_fill_2
X_11891_ _11891_/X _11891_/A _11900_/B VDD VSS sg13g2_and2_1
XFILLER_72_655 VDD VSS sg13g2_decap_8
XFILLER_60_806 VDD VSS sg13g2_decap_8
X_13630_ _13738_/D _13630_/A VDD VSS sg13g2_buf_1
XFILLER_60_817 VDD VSS sg13g2_fill_1
XFILLER_32_508 VDD VSS sg13g2_decap_8
X_10842_ _10843_/B _10841_/A _10841_/C _10841_/B VDD VSS sg13g2_o21ai_1
XFILLER_13_700 VDD VSS sg13g2_decap_8
XFILLER_44_42 VDD VSS sg13g2_decap_8
XFILLER_32_519 VDD VSS sg13g2_fill_2
XFILLER_25_560 VDD VSS sg13g2_fill_1
XFILLER_72_699 VDD VSS sg13g2_decap_8
XFILLER_12_210 VDD VSS sg13g2_decap_8
X_13561_ _13561_/X _07911_/A _15009_/Q _13561_/S VDD VSS sg13g2_mux2_1
X_10773_ _11164_/A _14951_/Q _08933_/S _10772_/X VDD VSS sg13g2_a21oi_1
XFILLER_34_1108 VDD VSS sg13g2_decap_8
XFILLER_160_1116 VDD VSS sg13g2_fill_1
X_12512_ _12513_/B _13682_/Q _12693_/A2 _12511_/X _12415_/A _12791_/C1 VDD VSS sg13g2_a221oi_1
XFILLER_73_1179 VDD VSS sg13g2_fill_1
XFILLER_51_1400 VDD VSS sg13g2_decap_8
XFILLER_13_777 VDD VSS sg13g2_decap_8
XFILLER_157_215 VDD VSS sg13g2_fill_2
XFILLER_8_203 VDD VSS sg13g2_decap_8
X_13492_ _15125_/D _13492_/A VDD VSS sg13g2_inv_1
XFILLER_90_1460 VDD VSS sg13g2_decap_8
XFILLER_139_941 VDD VSS sg13g2_decap_8
XFILLER_185_546 VDD VSS sg13g2_decap_8
XFILLER_12_287 VDD VSS sg13g2_decap_8
X_15231_ _15231_/Q _15237_/CLK _15231_/D _15231_/RESET_B VDD VSS sg13g2_dfrbpq_1
X_12443_ _14995_/D _08203_/B _12443_/A2 _12442_/Y VDD VSS sg13g2_a21oi_1
XFILLER_60_63 VDD VSS sg13g2_decap_8
XFILLER_12_1428 VDD VSS sg13g2_decap_8
XFILLER_138_462 VDD VSS sg13g2_fill_2
XFILLER_139_996 VDD VSS sg13g2_decap_8
XFILLER_5_910 VDD VSS sg13g2_decap_8
XFILLER_166_793 VDD VSS sg13g2_fill_2
X_15162_ _15162_/Q clkload89/A _15162_/D _15162_/RESET_B VDD VSS sg13g2_dfrbpq_1
XFILLER_176_63 VDD VSS sg13g2_decap_8
X_12374_ _14990_/D _07913_/A _12443_/A2 _12373_/Y _12372_/Y VDD VSS sg13g2_a22oi_1
XFILLER_165_292 VDD VSS sg13g2_fill_2
XFILLER_5_14 VDD VSS sg13g2_decap_8
XFILLER_4_420 VDD VSS sg13g2_decap_8
X_14113_ _14113_/Q clkload38/A _14113_/D _14113_/RESET_B VDD VSS sg13g2_dfrbpq_1
XFILLER_10_1141 VDD VSS sg13g2_decap_8
XFILLER_114_808 VDD VSS sg13g2_decap_4
XFILLER_154_977 VDD VSS sg13g2_decap_8
XFILLER_158_1045 VDD VSS sg13g2_decap_8
X_11325_ _11326_/A _11328_/S0 _14205_/Q _11872_/B1 VDD VSS sg13g2_a21oi_1
X_15093_ _15093_/Q _15219_/CLK _15093_/D _15093_/RESET_B VDD VSS sg13g2_dfrbpq_1
XFILLER_99_519 VDD VSS sg13g2_fill_2
XFILLER_101_1280 VDD VSS sg13g2_decap_8
XFILLER_107_871 VDD VSS sg13g2_decap_8
XFILLER_84_1220 VDD VSS sg13g2_decap_8
XFILLER_5_987 VDD VSS sg13g2_decap_8
XFILLER_119_1029 VDD VSS sg13g2_decap_8
XFILLER_125_178 VDD VSS sg13g2_decap_8
XFILLER_180_273 VDD VSS sg13g2_decap_8
X_14044_ _14044_/Q _14652_/CLK _14044_/D _14044_/RESET_B VDD VSS sg13g2_dfrbpq_1
X_11256_ _11256_/Y _11251_/Y _11252_/Y _12324_/B VDD VSS sg13g2_a21oi_1
XFILLER_79_210 VDD VSS sg13g2_decap_8
XFILLER_49_1373 VDD VSS sg13g2_fill_1
XFILLER_4_497 VDD VSS sg13g2_decap_8
XFILLER_106_392 VDD VSS sg13g2_fill_2
X_15182__2932 _15182_/RESET_B VDD VSS sg13g2_tiehi
X_14355__1917 _14355_/RESET_B VDD VSS sg13g2_tiehi
X_10207_ _10207_/Y hold3141/X _07661_/Y _14762_/Q VDD VSS sg13g2_a21oi_1
XFILLER_136_1365 VDD VSS sg13g2_decap_8
X_11187_ _11187_/Y _11171_/B _11181_/A _11197_/B VDD VSS sg13g2_a21oi_1
XFILLER_84_1297 VDD VSS sg13g2_decap_4
XFILLER_95_736 VDD VSS sg13g2_decap_8
X_10138_ _14715_/D _14715_/Q _10138_/A1 _10169_/S VDD VSS sg13g2_mux2_1
XFILLER_67_438 VDD VSS sg13g2_decap_8
X_14946_ _14946_/Q _14947_/CLK _14946_/D _14946_/RESET_B VDD VSS sg13g2_dfrbpq_1
X_10069_ _14650_/D _10102_/A0 _14650_/Q _10069_/S VDD VSS sg13g2_mux2_1
XFILLER_85_82 VDD VSS sg13g2_fill_1
XFILLER_47_151 VDD VSS sg13g2_fill_1
XFILLER_36_825 VDD VSS sg13g2_decap_8
X_14570__1702 _14570_/RESET_B VDD VSS sg13g2_tiehi
XFILLER_47_184 VDD VSS sg13g2_decap_8
X_14877_ _14877_/Q clkload61/A _14877_/D _14877_/RESET_B VDD VSS sg13g2_dfrbpq_1
XFILLER_21_1270 VDD VSS sg13g2_decap_8
XFILLER_78_1057 VDD VSS sg13g2_fill_1
XFILLER_63_655 VDD VSS sg13g2_decap_8
XFILLER_36_869 VDD VSS sg13g2_decap_4
XFILLER_63_666 VDD VSS sg13g2_fill_2
XFILLER_51_806 VDD VSS sg13g2_fill_1
X_13828_ _13828_/Q clkload39/A _13828_/D _13828_/RESET_B VDD VSS sg13g2_dfrbpq_1
XFILLER_90_463 VDD VSS sg13g2_decap_4
XFILLER_16_560 VDD VSS sg13g2_decap_8
XFILLER_1_1386 VDD VSS sg13g2_decap_8
XFILLER_95_1371 VDD VSS sg13g2_decap_8
X_14852__2933 _14852_/RESET_B VDD VSS sg13g2_tiehi
XFILLER_56_1344 VDD VSS sg13g2_decap_4
XFILLER_17_1306 VDD VSS sg13g2_decap_8
XFILLER_182_1352 VDD VSS sg13g2_decap_8
X_13759_ _13759_/Q clkload20/A _13759_/D _13759_/RESET_B VDD VSS sg13g2_dfrbpq_1
XFILLER_182_1396 VDD VSS sg13g2_fill_2
XFILLER_143_1358 VDD VSS sg13g2_decap_4
X_13843__2429 _13843_/RESET_B VDD VSS sg13g2_tiehi
XFILLER_176_557 VDD VSS sg13g2_decap_8
X_13989__2283 _13989_/RESET_B VDD VSS sg13g2_tiehi
XFILLER_129_440 VDD VSS sg13g2_decap_8
XFILLER_15_1074 VDD VSS sg13g2_decap_8
X_14885__2867 _14885_/RESET_B VDD VSS sg13g2_tiehi
XFILLER_129_484 VDD VSS sg13g2_fill_1
XFILLER_8_770 VDD VSS sg13g2_decap_8
XFILLER_102_1044 VDD VSS sg13g2_decap_8
XFILLER_141_1093 VDD VSS sg13g2_fill_1
XFILLER_172_730 VDD VSS sg13g2_decap_4
XFILLER_184_590 VDD VSS sg13g2_decap_8
XFILLER_144_432 VDD VSS sg13g2_fill_1
XFILLER_172_752 VDD VSS sg13g2_decap_8
XFILLER_89_1175 VDD VSS sg13g2_decap_8
XFILLER_7_280 VDD VSS sg13g2_decap_8
XFILLER_102_1077 VDD VSS sg13g2_decap_8
Xclkbuf_leaf_2_clk_i _14513_/CLK clkbuf_leaf_5_clk_i/A VDD VSS sg13g2_buf_8
XFILLER_85_1017 VDD VSS sg13g2_decap_8
XFILLER_145_988 VDD VSS sg13g2_fill_2
XFILLER_144_465 VDD VSS sg13g2_decap_8
XFILLER_171_251 VDD VSS sg13g2_fill_2
X_14223__2049 _14223_/RESET_B VDD VSS sg13g2_tiehi
XFILLER_172_1009 VDD VSS sg13g2_decap_8
X_09921_ _14506_/D _14506_/Q _09921_/A1 _09921_/S VDD VSS sg13g2_mux2_1
XFILLER_154_1410 VDD VSS sg13g2_fill_2
XFILLER_171_284 VDD VSS sg13g2_decap_8
XFILLER_67_1462 VDD VSS sg13g2_decap_8
XFILLER_63_1304 VDD VSS sg13g2_fill_1
XFILLER_113_841 VDD VSS sg13g2_decap_4
XFILLER_131_148 VDD VSS sg13g2_decap_8
Xfanout716 _12917_/B1 _13138_/B1 VDD VSS sg13g2_buf_1
XFILLER_98_552 VDD VSS sg13g2_decap_8
XFILLER_112_340 VDD VSS sg13g2_decap_8
Xfanout727 _11154_/B1 _11183_/B1 VDD VSS sg13g2_buf_1
X_09852_ _14439_/D _14439_/Q _09951_/A1 _09866_/S VDD VSS sg13g2_mux2_1
XFILLER_28_1457 VDD VSS sg13g2_decap_8
XFILLER_112_351 VDD VSS sg13g2_fill_1
Xfanout738 _11340_/A1 _12294_/B1 VDD VSS sg13g2_buf_1
XFILLER_86_714 VDD VSS sg13g2_decap_8
Xfanout749 _11975_/A _11765_/A VDD VSS sg13g2_buf_1
XFILLER_113_896 VDD VSS sg13g2_decap_8
X_08803_ _08805_/A _10823_/B _14753_/Q _08727_/X _15196_/Q _13490_/B VDD VSS sg13g2_a221oi_1
XFILLER_100_524 VDD VSS sg13g2_decap_4
X_09783_ _14372_/D _09882_/A0 _14372_/Q _09800_/S VDD VSS sg13g2_mux2_1
XFILLER_86_758 VDD VSS sg13g2_decap_8
XFILLER_39_630 VDD VSS sg13g2_decap_8
XFILLER_67_950 VDD VSS sg13g2_decap_8
XFILLER_22_1023 VDD VSS sg13g2_decap_8
XFILLER_6_1253 VDD VSS sg13g2_decap_8
X_08734_ _08734_/Y _13663_/Q _08801_/B VDD VSS sg13g2_nor2_1
XFILLER_85_268 VDD VSS sg13g2_fill_2
XFILLER_73_419 VDD VSS sg13g2_decap_8
XFILLER_2_1106 VDD VSS sg13g2_decap_8
XFILLER_82_931 VDD VSS sg13g2_decap_8
XFILLER_66_482 VDD VSS sg13g2_decap_8
XFILLER_27_836 VDD VSS sg13g2_decap_8
XFILLER_121_14 VDD VSS sg13g2_fill_2
X_08665_ _08666_/B _08663_/X _08662_/Y _08678_/B _08664_/Y VDD VSS sg13g2_a22oi_1
XFILLER_38_184 VDD VSS sg13g2_decap_8
XFILLER_27_869 VDD VSS sg13g2_decap_8
XFILLER_57_1108 VDD VSS sg13g2_fill_2
XFILLER_26_357 VDD VSS sg13g2_decap_8
X_07616_ _07616_/Y _14944_/Q VDD VSS sg13g2_inv_1
XFILLER_54_677 VDD VSS sg13g2_decap_8
XFILLER_81_463 VDD VSS sg13g2_fill_2
X_08596_ _15243_/D _08596_/A _08596_/B _08596_/C _08596_/D VDD VSS sg13g2_nand4_1
XFILLER_42_839 VDD VSS sg13g2_decap_8
XFILLER_74_1422 VDD VSS sg13g2_decap_8
XFILLER_41_349 VDD VSS sg13g2_decap_8
XFILLER_35_1406 VDD VSS sg13g2_decap_8
XFILLER_34_390 VDD VSS sg13g2_decap_8
XFILLER_74_1477 VDD VSS sg13g2_fill_2
XFILLER_70_1319 VDD VSS sg13g2_fill_1
XFILLER_10_714 VDD VSS sg13g2_decap_8
XFILLER_14_56 VDD VSS sg13g2_decap_8
X_14433__1839 _14433_/RESET_B VDD VSS sg13g2_tiehi
XFILLER_22_596 VDD VSS sg13g2_decap_8
XFILLER_155_708 VDD VSS sg13g2_fill_1
XFILLER_167_568 VDD VSS sg13g2_decap_8
X_13819__2453 _13819_/RESET_B VDD VSS sg13g2_tiehi
X_09217_ _13828_/D _10080_/A0 _13828_/Q _09237_/S VDD VSS sg13g2_mux2_1
XFILLER_155_719 VDD VSS sg13g2_decap_8
X_14579__1693 _14579_/RESET_B VDD VSS sg13g2_tiehi
XFILLER_6_707 VDD VSS sg13g2_decap_8
XFILLER_124_1280 VDD VSS sg13g2_decap_8
XFILLER_33_1174 VDD VSS sg13g2_decap_8
X_09148_ _09148_/Y _09161_/S _15050_/Q _09147_/Y VDD VSS sg13g2_o21ai_1
XFILLER_5_217 VDD VSS sg13g2_decap_8
XFILLER_108_635 VDD VSS sg13g2_decap_8
XFILLER_135_432 VDD VSS sg13g2_decap_8
XFILLER_136_955 VDD VSS sg13g2_decap_8
X_09079_ _09079_/Y _09078_/B _15040_/Q _09078_/Y VDD VSS sg13g2_o21ai_1
XFILLER_107_156 VDD VSS sg13g2_decap_8
XFILLER_151_925 VDD VSS sg13g2_fill_2
XFILLER_163_785 VDD VSS sg13g2_decap_8
XFILLER_151_936 VDD VSS sg13g2_decap_8
XFILLER_162_262 VDD VSS sg13g2_decap_8
X_11110_ _11110_/Y _11106_/Y _11104_/Y _11109_/Y VDD VSS sg13g2_a21oi_1
XFILLER_159_1387 VDD VSS sg13g2_decap_8
XFILLER_2_924 VDD VSS sg13g2_decap_8
X_12090_ _12091_/B _12090_/A _14228_/Q VDD VSS sg13g2_nand2_1
XFILLER_123_649 VDD VSS sg13g2_fill_1
XFILLER_104_841 VDD VSS sg13g2_decap_8
XFILLER_1_434 VDD VSS sg13g2_decap_8
XFILLER_89_541 VDD VSS sg13g2_decap_8
X_11041_ _11068_/A _11052_/A _11052_/B _11052_/D VDD VSS sg13g2_nor3_1
XFILLER_89_552 VDD VSS sg13g2_fill_2
XFILLER_81_1426 VDD VSS sg13g2_decap_8
XFILLER_150_479 VDD VSS sg13g2_decap_8
XFILLER_103_351 VDD VSS sg13g2_fill_2
XFILLER_39_42 VDD VSS sg13g2_decap_8
XFILLER_162_21 VDD VSS sg13g2_decap_8
XFILLER_89_596 VDD VSS sg13g2_decap_8
XFILLER_77_736 VDD VSS sg13g2_decap_8
XFILLER_49_427 VDD VSS sg13g2_decap_8
X_14800_ _14800_/Q _14864_/CLK _14800_/D _14800_/RESET_B VDD VSS sg13g2_dfrbpq_1
XFILLER_64_419 VDD VSS sg13g2_fill_2
XFILLER_58_972 VDD VSS sg13g2_decap_4
XFILLER_40_1134 VDD VSS sg13g2_decap_4
X_12992_ _12994_/A _12993_/B _12993_/C VDD VSS sg13g2_nand2_1
XFILLER_29_162 VDD VSS sg13g2_fill_1
XFILLER_176_0 VDD VSS sg13g2_decap_8
X_14731_ _14731_/Q clkload9/A _14731_/D _14731_/RESET_B VDD VSS sg13g2_dfrbpq_1
X_11943_ _11943_/Y _11948_/S _14224_/Q _11967_/B VDD VSS sg13g2_a21oi_1
XFILLER_79_1366 VDD VSS sg13g2_fill_1
XFILLER_17_357 VDD VSS sg13g2_decap_8
XFILLER_55_63 VDD VSS sg13g2_decap_8
XFILLER_72_452 VDD VSS sg13g2_decap_4
X_14662_ _14662_/Q _14662_/CLK _14662_/D _14662_/RESET_B VDD VSS sg13g2_dfrbpq_1
XFILLER_72_463 VDD VSS sg13g2_decap_8
XFILLER_44_154 VDD VSS sg13g2_decap_8
X_11874_ _11875_/A _14702_/Q _14734_/Q _13774_/Q _13806_/Q _11874_/S0 _11366_/C VDD
+ VSS sg13g2_mux4_1
XFILLER_73_997 VDD VSS sg13g2_decap_8
XFILLER_32_316 VDD VSS sg13g2_decap_8
XFILLER_166_1369 VDD VSS sg13g2_decap_8
X_13613_ _13613_/Y _13613_/A _13613_/B _13613_/C _13613_/D VDD VSS sg13g2_nor4_1
XFILLER_44_187 VDD VSS sg13g2_fill_1
X_10825_ _14928_/D hold3263/X _10850_/B _10824_/Y VDD VSS sg13g2_a21o_1
X_14593_ _14593_/Q clkload38/A _14593_/D _14593_/RESET_B VDD VSS sg13g2_dfrbpq_1
XFILLER_41_850 VDD VSS sg13g2_decap_8
XFILLER_164_1071 VDD VSS sg13g2_decap_8
XFILLER_186_822 VDD VSS sg13g2_decap_8
XFILLER_164_1082 VDD VSS sg13g2_fill_1
XFILLER_186_833 VDD VSS sg13g2_decap_8
X_13544_ _15146_/D _13562_/S _13542_/Y _13543_/Y VDD VSS sg13g2_a21oi_1
XFILLER_13_574 VDD VSS sg13g2_decap_8
X_10756_ _14916_/D _10756_/A VDD VSS sg13g2_inv_1
XFILLER_185_343 VDD VSS sg13g2_decap_8
X_13475_ _15178_/D hold3133/X _15178_/Q _13477_/S VDD VSS sg13g2_mux2_1
X_14409__1863 _14409_/RESET_B VDD VSS sg13g2_tiehi
XFILLER_9_567 VDD VSS sg13g2_decap_8
XFILLER_51_1241 VDD VSS sg13g2_fill_1
XFILLER_103_1320 VDD VSS sg13g2_decap_4
XFILLER_125_1099 VDD VSS sg13g2_decap_8
X_10687_ _10876_/A _08992_/B _10691_/S _08852_/Y VDD VSS sg13g2_a21oi_1
XFILLER_173_527 VDD VSS sg13g2_decap_4
XFILLER_12_1225 VDD VSS sg13g2_decap_8
X_15214_ _15214_/Q clkload91/A _15214_/D _15214_/RESET_B VDD VSS sg13g2_dfrbpq_1
XFILLER_51_1274 VDD VSS sg13g2_decap_8
XFILLER_127_933 VDD VSS sg13g2_decap_8
X_12426_ _12426_/X _12423_/X _12422_/X _12419_/X _12418_/X _12775_/S1 _12553_/S VDD
+ VSS sg13g2_mux4_1
XFILLER_126_421 VDD VSS sg13g2_fill_1
XFILLER_127_944 VDD VSS sg13g2_fill_1
XFILLER_65_7 VDD VSS sg13g2_decap_8
XFILLER_142_903 VDD VSS sg13g2_decap_8
X_15145_ _15145_/Q clkload78/A _15145_/D _15145_/RESET_B VDD VSS sg13g2_dfrbpq_1
X_12357_ _12358_/B _12348_/A _15126_/Q VDD VSS sg13g2_nand2b_1
XFILLER_177_1465 VDD VSS sg13g2_decap_4
XFILLER_181_560 VDD VSS sg13g2_decap_8
XFILLER_99_305 VDD VSS sg13g2_decap_8
XFILLER_86_1348 VDD VSS sg13g2_decap_8
XFILLER_154_785 VDD VSS sg13g2_decap_8
XFILLER_173_1307 VDD VSS sg13g2_decap_8
XFILLER_114_627 VDD VSS sg13g2_decap_8
XFILLER_5_784 VDD VSS sg13g2_decap_8
X_11308_ _11308_/Y _11328_/S0 _14077_/Q _11897_/C VDD VSS sg13g2_a21oi_1
X_15076_ _15076_/Q _15216_/CLK _15076_/D _15076_/RESET_B VDD VSS sg13g2_dfrbpq_1
X_14770__3036 _14770_/RESET_B VDD VSS sg13g2_tiehi
X_12288_ _12288_/X _14265_/Q _14297_/Q _14329_/Q _14361_/Q _12288_/S0 _12288_/S1 VDD
+ VSS sg13g2_mux4_1
XFILLER_4_294 VDD VSS sg13g2_decap_8
XFILLER_49_1181 VDD VSS sg13g2_decap_8
XFILLER_171_1020 VDD VSS sg13g2_decap_8
X_14027_ _14027_/Q clkload11/A _14027_/D _14027_/RESET_B VDD VSS sg13g2_dfrbpq_1
X_11239_ _11239_/Y _12866_/A _15123_/Q _11340_/A1 VDD VSS sg13g2_o21ai_1
XFILLER_45_1034 VDD VSS sg13g2_decap_8
XFILLER_136_1151 VDD VSS sg13g2_decap_8
XFILLER_150_991 VDD VSS sg13g2_decap_8
XFILLER_110_844 VDD VSS sg13g2_decap_8
XFILLER_171_1086 VDD VSS sg13g2_decap_8
XFILLER_49_972 VDD VSS sg13g2_fill_1
XFILLER_55_419 VDD VSS sg13g2_decap_8
XFILLER_23_1365 VDD VSS sg13g2_decap_8
XFILLER_48_471 VDD VSS sg13g2_decap_4
XFILLER_97_1433 VDD VSS sg13g2_decap_8
XFILLER_76_791 VDD VSS sg13g2_decap_8
X_14929_ _14929_/Q _15224_/CLK _14929_/D _14929_/RESET_B VDD VSS sg13g2_dfrbpq_1
X_08450_ _08462_/A _07948_/A _08448_/Y _08449_/Y VDD VSS sg13g2_o21ai_1
XFILLER_184_1447 VDD VSS sg13g2_decap_8
XFILLER_24_828 VDD VSS sg13g2_decap_8
XFILLER_24_839 VDD VSS sg13g2_decap_4
XFILLER_91_794 VDD VSS sg13g2_decap_8
XFILLER_1_1183 VDD VSS sg13g2_decap_8
X_08381_ _08381_/Y _08381_/A _08688_/D _08688_/A _08688_/B VDD VSS sg13g2_nand4_1
XFILLER_108_1220 VDD VSS sg13g2_fill_2
XFILLER_17_1103 VDD VSS sg13g2_decap_8
XFILLER_91_1032 VDD VSS sg13g2_decap_4
XFILLER_143_1111 VDD VSS sg13g2_fill_1
XFILLER_91_0 VDD VSS sg13g2_decap_8
XFILLER_147_1280 VDD VSS sg13g2_decap_8
XFILLER_52_1005 VDD VSS sg13g2_decap_8
XFILLER_50_157 VDD VSS sg13g2_decap_8
XFILLER_147_1291 VDD VSS sg13g2_fill_2
XFILLER_149_524 VDD VSS sg13g2_decap_8
XFILLER_182_1171 VDD VSS sg13g2_decap_8
XFILLER_177_844 VDD VSS sg13g2_decap_8
XFILLER_50_179 VDD VSS sg13g2_decap_4
XFILLER_104_1106 VDD VSS sg13g2_decap_8
XFILLER_176_343 VDD VSS sg13g2_decap_8
XFILLER_52_1049 VDD VSS sg13g2_decap_8
XFILLER_108_1297 VDD VSS sg13g2_decap_8
XFILLER_104_1139 VDD VSS sg13g2_decap_8
XFILLER_178_1207 VDD VSS sg13g2_decap_4
XFILLER_136_218 VDD VSS sg13g2_decap_8
X_09002_ _13761_/D _13761_/Q _10144_/A1 _09160_/S VDD VSS sg13g2_mux2_1
XFILLER_178_1218 VDD VSS sg13g2_fill_2
XFILLER_121_1453 VDD VSS sg13g2_fill_1
XFILLER_145_730 VDD VSS sg13g2_decap_8
XFILLER_117_443 VDD VSS sg13g2_decap_8
XFILLER_118_966 VDD VSS sg13g2_decap_4
XFILLER_30_1358 VDD VSS sg13g2_decap_8
XFILLER_30_1369 VDD VSS sg13g2_decap_4
XFILLER_144_251 VDD VSS sg13g2_decap_8
XFILLER_145_774 VDD VSS sg13g2_decap_8
XFILLER_145_785 VDD VSS sg13g2_fill_2
XFILLER_105_627 VDD VSS sg13g2_decap_4
XFILLER_132_424 VDD VSS sg13g2_fill_1
XFILLER_133_947 VDD VSS sg13g2_decap_8
XFILLER_116_14 VDD VSS sg13g2_fill_2
XFILLER_28_1221 VDD VSS sg13g2_decap_8
Xfanout502 _09461_/S wire504/A VDD VSS sg13g2_buf_1
X_09904_ _14490_/D _10169_/A1 _14490_/Q _09904_/S VDD VSS sg13g2_mux2_1
XFILLER_63_1112 VDD VSS sg13g2_decap_8
Xfanout513 _09405_/S _09404_/S VDD VSS sg13g2_buf_1
XFILLER_160_788 VDD VSS sg13g2_decap_8
Xfanout524 _09371_/S _09374_/S VDD VSS sg13g2_buf_1
XFILLER_99_883 VDD VSS sg13g2_decap_8
XFILLER_98_360 VDD VSS sg13g2_decap_4
XFILLER_116_69 VDD VSS sg13g2_decap_8
XFILLER_154_1262 VDD VSS sg13g2_decap_8
Xfanout535 _08932_/S _08938_/S VDD VSS sg13g2_buf_1
XFILLER_99_894 VDD VSS sg13g2_fill_2
XFILLER_8_1337 VDD VSS sg13g2_decap_8
XFILLER_150_1104 VDD VSS sg13g2_decap_8
XFILLER_154_1273 VDD VSS sg13g2_decap_4
Xfanout546 _13652_/S _13651_/S VDD VSS sg13g2_buf_1
XFILLER_115_1235 VDD VSS sg13g2_decap_8
X_13682__2601 _13682_/RESET_B VDD VSS sg13g2_tiehi
Xfanout557 _13519_/B _13520_/A1 VDD VSS sg13g2_buf_1
X_09835_ _14423_/D _09934_/A1 _14423_/Q _09837_/S VDD VSS sg13g2_mux2_1
XFILLER_59_747 VDD VSS sg13g2_decap_8
Xfanout568 _12707_/A2 _12624_/A2 VDD VSS sg13g2_buf_1
XFILLER_28_1298 VDD VSS sg13g2_decap_8
XFILLER_41_1410 VDD VSS sg13g2_decap_8
XFILLER_6_1050 VDD VSS sg13g2_decap_8
XFILLER_41_1432 VDD VSS sg13g2_decap_4
X_09766_ _14356_/D _14356_/Q _09799_/A0 _09766_/S VDD VSS sg13g2_mux2_1
XFILLER_86_588 VDD VSS sg13g2_decap_8
XFILLER_86_599 VDD VSS sg13g2_decap_8
XFILLER_132_35 VDD VSS sg13g2_decap_8
XFILLER_73_216 VDD VSS sg13g2_decap_8
X_08717_ _15191_/D hold3175/X _15191_/Q _13333_/S VDD VSS sg13g2_mux2_1
XFILLER_55_942 VDD VSS sg13g2_decap_8
X_09697_ _14289_/D _09928_/A1 _14289_/Q _09698_/S VDD VSS sg13g2_mux2_1
XFILLER_92_28 VDD VSS sg13g2_decap_8
XFILLER_82_761 VDD VSS sg13g2_decap_8
X_14062__2210 _14062_/RESET_B VDD VSS sg13g2_tiehi
XFILLER_148_1033 VDD VSS sg13g2_decap_8
XFILLER_15_828 VDD VSS sg13g2_decap_8
X_08648_ _08662_/B _07867_/D _07960_/Y _07969_/D VDD VSS sg13g2_o21ai_1
XFILLER_27_688 VDD VSS sg13g2_decap_8
XFILLER_26_165 VDD VSS sg13g2_decap_8
XFILLER_54_485 VDD VSS sg13g2_fill_2
XFILLER_42_636 VDD VSS sg13g2_fill_2
X_08579_ _08579_/Y _08641_/D _08578_/Y _08667_/A1 VDD VSS sg13g2_a21oi_1
XFILLER_74_1241 VDD VSS sg13g2_decap_4
XFILLER_41_135 VDD VSS sg13g2_decap_8
XFILLER_148_1099 VDD VSS sg13g2_fill_2
XFILLER_168_811 VDD VSS sg13g2_decap_8
XFILLER_25_77 VDD VSS sg13g2_decap_8
X_14666__1606 _14666_/RESET_B VDD VSS sg13g2_tiehi
Xclkbuf_leaf_103_clk_i clkload59/A clkbuf_leaf_99_clk_i/A VDD VSS sg13g2_buf_8
X_10610_ _10611_/A _14879_/Q _14878_/Q _14877_/Q _10610_/D VDD VSS sg13g2_nand4_1
XFILLER_35_1225 VDD VSS sg13g2_decap_8
X_11590_ _11590_/Y _11591_/A _13682_/Q VDD VSS sg13g2_nor2_1
XFILLER_10_511 VDD VSS sg13g2_decap_8
X_14702__1570 _14702_/RESET_B VDD VSS sg13g2_tiehi
XFILLER_70_1149 VDD VSS sg13g2_fill_1
XFILLER_167_354 VDD VSS sg13g2_decap_8
X_10541_ _14862_/D _10566_/D _10547_/D _10540_/Y VDD VSS sg13g2_a21oi_1
XFILLER_41_21 VDD VSS sg13g2_decap_8
XFILLER_22_393 VDD VSS sg13g2_decap_8
XFILLER_109_900 VDD VSS sg13g2_decap_8
XFILLER_155_516 VDD VSS sg13g2_decap_8
X_14095__2177 _14095_/RESET_B VDD VSS sg13g2_tiehi
XFILLER_6_504 VDD VSS sg13g2_decap_8
XFILLER_167_387 VDD VSS sg13g2_decap_8
XFILLER_157_21 VDD VSS sg13g2_decap_8
XFILLER_108_410 VDD VSS sg13g2_decap_8
X_13260_ _13260_/Y _14861_/Q _13260_/B VDD VSS sg13g2_nand2_1
XFILLER_108_421 VDD VSS sg13g2_fill_1
XFILLER_10_588 VDD VSS sg13g2_decap_8
X_10472_ _14845_/D _10492_/C _10633_/A _10472_/C VDD VSS sg13g2_nor3_1
Xclkbuf_leaf_118_clk_i clkload26/A clkbuf_5_7__f_clk_i/X VDD VSS sg13g2_buf_8
XFILLER_182_357 VDD VSS sg13g2_decap_8
XFILLER_41_98 VDD VSS sg13g2_decap_8
X_12211_ _12211_/X _14583_/Q _14615_/Q _14647_/Q _14679_/Q _12213_/S0 _12169_/C VDD
+ VSS sg13g2_mux4_1
XFILLER_108_454 VDD VSS sg13g2_fill_2
X_13191_ _13191_/Y _13191_/A _13202_/A _13191_/C _13271_/C VDD VSS sg13g2_nand4_1
XFILLER_136_796 VDD VSS sg13g2_fill_1
XFILLER_135_273 VDD VSS sg13g2_fill_1
X_15034__2646 _15034_/RESET_B VDD VSS sg13g2_tiehi
XFILLER_150_210 VDD VSS sg13g2_decap_8
XFILLER_163_593 VDD VSS sg13g2_decap_8
X_12142_ _12143_/B _12133_/X _12134_/X _12139_/X _12140_/X _11542_/B _12191_/B1 VDD
+ VSS sg13g2_mux4_1
XFILLER_2_721 VDD VSS sg13g2_decap_8
XFILLER_135_295 VDD VSS sg13g2_decap_8
XFILLER_159_1195 VDD VSS sg13g2_fill_1
XFILLER_1_231 VDD VSS sg13g2_decap_8
XFILLER_173_42 VDD VSS sg13g2_decap_8
XFILLER_81_1212 VDD VSS sg13g2_decap_8
XFILLER_172_1340 VDD VSS sg13g2_decap_8
X_12073_ _12073_/X _14707_/Q _14739_/Q _13779_/Q _13811_/Q _12171_/S0 _12073_/S1 VDD
+ VSS sg13g2_mux4_1
XFILLER_110_107 VDD VSS sg13g2_fill_1
XFILLER_104_671 VDD VSS sg13g2_decap_8
XFILLER_2_798 VDD VSS sg13g2_decap_8
XFILLER_172_1373 VDD VSS sg13g2_decap_8
X_11024_ _11064_/B _15118_/Q _11052_/A VDD VSS sg13g2_xnor2_1
XFILLER_46_1376 VDD VSS sg13g2_decap_8
XFILLER_172_1384 VDD VSS sg13g2_fill_1
X_16881_ _16881_/X _16881_/A VDD VSS sg13g2_buf_1
XFILLER_106_80 VDD VSS sg13g2_decap_8
XFILLER_66_40 VDD VSS sg13g2_decap_8
XFILLER_133_1379 VDD VSS sg13g2_decap_8
XFILLER_92_503 VDD VSS sg13g2_decap_8
XFILLER_18_600 VDD VSS sg13g2_decap_8
XFILLER_64_238 VDD VSS sg13g2_decap_8
XFILLER_46_942 VDD VSS sg13g2_decap_8
X_12975_ _12975_/X _12988_/D _12975_/B VDD VSS sg13g2_xor2_1
XFILLER_61_901 VDD VSS sg13g2_decap_8
X_14714_ _14714_/Q clkload53/A _14714_/D _14714_/RESET_B VDD VSS sg13g2_dfrbpq_1
XFILLER_17_154 VDD VSS sg13g2_decap_8
X_11926_ _11927_/B _11918_/X _11919_/X _11924_/X _11925_/X _12029_/B _12048_/A1 VDD
+ VSS sg13g2_mux4_1
XFILLER_79_1174 VDD VSS sg13g2_decap_8
XFILLER_2_1470 VDD VSS sg13g2_decap_4
XFILLER_75_1038 VDD VSS sg13g2_decap_8
X_14645_ _14645_/Q clkload28/A _14645_/D _14645_/RESET_B VDD VSS sg13g2_dfrbpq_1
X_11857_ _11857_/X _11849_/X _11850_/X _11853_/X _11854_/X _11615_/B _11625_/C VDD
+ VSS sg13g2_mux4_1
XFILLER_32_135 VDD VSS sg13g2_decap_4
XFILLER_159_811 VDD VSS sg13g2_decap_8
XFILLER_166_1188 VDD VSS sg13g2_decap_8
XFILLER_82_72 VDD VSS sg13g2_decap_8
XFILLER_61_978 VDD VSS sg13g2_fill_2
XFILLER_18_1423 VDD VSS sg13g2_decap_8
XFILLER_92_1352 VDD VSS sg13g2_fill_1
XFILLER_14_861 VDD VSS sg13g2_decap_8
XFILLER_53_1314 VDD VSS sg13g2_decap_8
XFILLER_159_833 VDD VSS sg13g2_decap_8
XFILLER_20_308 VDD VSS sg13g2_decap_8
X_10808_ _10809_/B _12346_/A _10807_/B _10807_/C VDD VSS sg13g2_a21oi_1
XFILLER_53_1325 VDD VSS sg13g2_fill_2
X_14576_ _14576_/Q clkload10/A _14576_/D _14576_/RESET_B VDD VSS sg13g2_dfrbpq_1
X_14788__3018 _14788_/RESET_B VDD VSS sg13g2_tiehi
XFILLER_60_488 VDD VSS sg13g2_decap_8
XFILLER_32_179 VDD VSS sg13g2_decap_8
XFILLER_105_1404 VDD VSS sg13g2_fill_1
X_11788_ _11788_/X _13963_/Q _13995_/Q _14027_/Q _14059_/Q _11850_/S0 _07654_/A VDD
+ VSS sg13g2_mux4_1
XFILLER_13_371 VDD VSS sg13g2_decap_8
XFILLER_92_1396 VDD VSS sg13g2_decap_8
XFILLER_53_1347 VDD VSS sg13g2_decap_8
XFILLER_14_1309 VDD VSS sg13g2_decap_8
XFILLER_185_140 VDD VSS sg13g2_decap_8
X_13527_ _13527_/Y _13527_/A _13535_/B VDD VSS sg13g2_nor2_1
XFILLER_146_505 VDD VSS sg13g2_fill_1
X_10739_ _11052_/B _07616_/Y _09079_/Y _10743_/S VDD VSS sg13g2_mux2_1
XFILLER_9_364 VDD VSS sg13g2_decap_8
XFILLER_186_696 VDD VSS sg13g2_decap_8
X_13760__2512 _13760_/RESET_B VDD VSS sg13g2_tiehi
XFILLER_173_324 VDD VSS sg13g2_decap_8
XFILLER_12_1022 VDD VSS sg13g2_decap_8
X_13458_ _13458_/Y _13412_/B _08723_/B _07729_/B VDD VSS sg13g2_o21ai_1
XFILLER_127_763 VDD VSS sg13g2_decap_8
XFILLER_161_508 VDD VSS sg13g2_decap_8
X_12409_ _12409_/X _13727_/Q _14079_/Q _14431_/Q _14527_/Q _12411_/S0 _12411_/S1 VDD
+ VSS sg13g2_mux4_1
XFILLER_127_785 VDD VSS sg13g2_decap_8
XFILLER_177_1251 VDD VSS sg13g2_decap_8
X_13389_ _13389_/Y _13401_/C _13401_/B _13396_/C _13391_/C VDD VSS sg13g2_nor4_1
Xoutput105 mem_axi_wdata[10] _15142_/Q VDD VSS sg13g2_buf_1
XFILLER_114_402 VDD VSS sg13g2_decap_8
XFILLER_182_880 VDD VSS sg13g2_decap_8
Xoutput116 mem_axi_wdata[20] _15152_/Q VDD VSS sg13g2_buf_1
XFILLER_86_1145 VDD VSS sg13g2_decap_8
XFILLER_12_1099 VDD VSS sg13g2_decap_8
Xoutput127 mem_axi_wdata[30] _15162_/Q VDD VSS sg13g2_buf_1
X_15128_ _15128_/Q _15200_/CLK _15128_/D _15128_/RESET_B VDD VSS sg13g2_dfrbpq_1
Xoutput138 mem_axi_wstrb[2] _15166_/Q VDD VSS sg13g2_buf_1
XFILLER_5_581 VDD VSS sg13g2_decap_8
Xclkbuf_leaf_82_clk_i _14947_/CLK clkbuf_leaf_83_clk_i/A VDD VSS sg13g2_buf_8
XFILLER_141_232 VDD VSS sg13g2_decap_8
XFILLER_141_243 VDD VSS sg13g2_fill_2
XFILLER_99_157 VDD VSS sg13g2_decap_8
X_14140__2132 _14140_/RESET_B VDD VSS sg13g2_tiehi
X_15059_ _15059_/Q _15113_/CLK _15059_/D _15059_/RESET_B VDD VSS sg13g2_dfrbpq_1
X_07950_ _07950_/Y _07950_/A _07950_/B _07950_/C VDD VSS sg13g2_nand3_1
X_13793__2479 _13793_/RESET_B VDD VSS sg13g2_tiehi
XFILLER_64_1443 VDD VSS sg13g2_fill_2
XFILLER_101_118 VDD VSS sg13g2_decap_8
X_14819__2987 _14819_/RESET_B VDD VSS sg13g2_tiehi
XFILLER_25_1427 VDD VSS sg13g2_decap_8
XFILLER_96_842 VDD VSS sg13g2_fill_1
X_07881_ _08073_/A _08079_/S _13609_/A VDD VSS sg13g2_nand2_1
X_14744__1528 _14744_/RESET_B VDD VSS sg13g2_tiehi
X_09620_ _14216_/D _09620_/A0 _14216_/Q _09630_/S VDD VSS sg13g2_mux2_1
Xclkbuf_leaf_97_clk_i _14890_/CLK clkload4/A VDD VSS sg13g2_buf_8
XFILLER_110_685 VDD VSS sg13g2_decap_8
XFILLER_83_525 VDD VSS sg13g2_decap_8
XFILLER_83_536 VDD VSS sg13g2_fill_1
XFILLER_23_1162 VDD VSS sg13g2_decap_8
X_09551_ _14149_/D _10115_/A0 _14149_/Q _09563_/S VDD VSS sg13g2_mux2_1
X_14173__2099 _14173_/RESET_B VDD VSS sg13g2_tiehi
XFILLER_3_1267 VDD VSS sg13g2_decap_8
X_08502_ _08502_/Y _07636_/Y _07821_/B _08434_/B _07829_/B _07950_/Y VDD VSS sg13g2_a221oi_1
XFILLER_52_901 VDD VSS sg13g2_decap_8
XFILLER_36_463 VDD VSS sg13g2_decap_8
X_09482_ _14082_/D _10078_/A0 _14082_/Q _09501_/S VDD VSS sg13g2_mux2_1
XFILLER_70_219 VDD VSS sg13g2_fill_1
Xclkbuf_leaf_20_clk_i _14744_/CLK clkbuf_leaf_48_clk_i/A VDD VSS sg13g2_buf_8
XFILLER_58_1236 VDD VSS sg13g2_fill_2
XFILLER_63_271 VDD VSS sg13g2_decap_4
XFILLER_145_1206 VDD VSS sg13g2_decap_8
XFILLER_93_1138 VDD VSS sg13g2_decap_8
XFILLER_36_496 VDD VSS sg13g2_fill_1
X_08433_ _08441_/A _07799_/X _08470_/A _08432_/Y _07798_/X _08431_/X VDD VSS sg13g2_a221oi_1
XFILLER_11_308 VDD VSS sg13g2_decap_8
XFILLER_23_168 VDD VSS sg13g2_decap_8
X_08364_ _08373_/B _08637_/B _08363_/X _08361_/Y VDD VSS sg13g2_a21oi_1
XFILLER_71_1425 VDD VSS sg13g2_decap_8
XFILLER_177_630 VDD VSS sg13g2_decap_8
XFILLER_108_1061 VDD VSS sg13g2_decap_8
XFILLER_149_343 VDD VSS sg13g2_fill_1
XFILLER_176_140 VDD VSS sg13g2_decap_8
Xclkbuf_leaf_35_clk_i clkload34/A clkbuf_leaf_37_clk_i/A VDD VSS sg13g2_buf_8
X_08295_ _08295_/Y _08276_/A _08276_/B _08289_/Y VDD VSS sg13g2_o21ai_1
XFILLER_31_190 VDD VSS sg13g2_decap_8
XFILLER_149_376 VDD VSS sg13g2_fill_2
XFILLER_20_875 VDD VSS sg13g2_fill_2
X_14350__1922 _14350_/RESET_B VDD VSS sg13g2_tiehi
XFILLER_34_1291 VDD VSS sg13g2_decap_8
XFILLER_118_741 VDD VSS sg13g2_fill_2
XFILLER_11_35 VDD VSS sg13g2_decap_8
XFILLER_180_817 VDD VSS sg13g2_decap_8
XFILLER_3_518 VDD VSS sg13g2_decap_8
XFILLER_30_1177 VDD VSS sg13g2_decap_8
XFILLER_127_35 VDD VSS sg13g2_decap_8
XFILLER_156_1313 VDD VSS sg13g2_decap_8
XFILLER_65_1207 VDD VSS sg13g2_decap_8
XFILLER_106_958 VDD VSS sg13g2_decap_8
XFILLER_79_809 VDD VSS sg13g2_decap_8
XFILLER_105_457 VDD VSS sg13g2_decap_4
Xfanout310 _10080_/A0 _09019_/Y VDD VSS sg13g2_buf_1
Xfanout1308 _11999_/S1 fanout1314/X VDD VSS sg13g2_buf_1
Xfanout1319 _12221_/B1 _13661_/Q VDD VSS sg13g2_buf_1
X_14383__1889 _14383_/RESET_B VDD VSS sg13g2_tiehi
Xfanout332 _10169_/S wire334/A VDD VSS sg13g2_buf_1
XFILLER_132_298 VDD VSS sg13g2_decap_4
XFILLER_8_1134 VDD VSS sg13g2_decap_8
XFILLER_87_853 VDD VSS sg13g2_fill_1
XFILLER_101_641 VDD VSS sg13g2_decap_8
XFILLER_154_1081 VDD VSS sg13g2_decap_8
Xfanout354 _09862_/S _09871_/S VDD VSS sg13g2_buf_1
Xfanout365 _09771_/S _09770_/S VDD VSS sg13g2_buf_1
XFILLER_28_1095 VDD VSS sg13g2_decap_8
Xfanout376 _09705_/S _09704_/S VDD VSS sg13g2_buf_1
XFILLER_100_140 VDD VSS sg13g2_decap_8
XFILLER_143_67 VDD VSS sg13g2_decap_8
X_09818_ _14406_/D _09917_/A1 _14406_/Q _09830_/S VDD VSS sg13g2_mux2_1
Xfanout398 _09298_/S fanout402/X VDD VSS sg13g2_buf_1
XFILLER_87_897 VDD VSS sg13g2_decap_8
XFILLER_74_514 VDD VSS sg13g2_decap_8
XFILLER_101_685 VDD VSS sg13g2_decap_4
XFILLER_59_599 VDD VSS sg13g2_decap_8
XFILLER_46_227 VDD VSS sg13g2_decap_8
XFILLER_28_931 VDD VSS sg13g2_decap_8
XFILLER_41_1262 VDD VSS sg13g2_decap_8
XFILLER_132_1390 VDD VSS sg13g2_decap_8
X_09749_ _14339_/D _14339_/Q _09881_/A0 _09771_/S VDD VSS sg13g2_mux2_1
XFILLER_36_21 VDD VSS sg13g2_decap_8
X_14003__2269 _14003_/RESET_B VDD VSS sg13g2_tiehi
XFILLER_55_750 VDD VSS sg13g2_decap_8
XFILLER_27_463 VDD VSS sg13g2_decap_8
X_12760_ _12760_/X _12757_/X _12756_/X _12753_/X _12752_/X _12760_/S0 _12761_/S1 VDD
+ VSS sg13g2_mux4_1
XFILLER_42_400 VDD VSS sg13g2_decap_8
XFILLER_36_87 VDD VSS sg13g2_decap_8
XFILLER_128_1426 VDD VSS sg13g2_decap_8
X_11711_ _11711_/X _14697_/Q _14729_/Q _13769_/Q _13801_/Q _12284_/S0 _12284_/S1 VDD
+ VSS sg13g2_mux4_1
XFILLER_43_956 VDD VSS sg13g2_fill_2
XFILLER_15_658 VDD VSS sg13g2_decap_8
X_12691_ _12691_/X _12683_/X _12687_/X _12682_/X _12686_/X _12776_/S _12691_/S1 VDD
+ VSS sg13g2_mux4_1
XFILLER_42_466 VDD VSS sg13g2_decap_8
XFILLER_35_1000 VDD VSS sg13g2_decap_8
XFILLER_14_168 VDD VSS sg13g2_decap_8
X_14430_ _14430_/Q clkload48/A _14430_/D _14430_/RESET_B VDD VSS sg13g2_dfrbpq_1
X_11642_ _11663_/B _11643_/B _11643_/A VDD VSS sg13g2_nand2_1
XFILLER_35_1022 VDD VSS sg13g2_decap_8
XFILLER_126_1150 VDD VSS sg13g2_decap_8
XFILLER_161_1030 VDD VSS sg13g2_decap_8
XFILLER_30_639 VDD VSS sg13g2_fill_1
XFILLER_156_803 VDD VSS sg13g2_decap_8
XFILLER_139_0 VDD VSS sg13g2_decap_8
XFILLER_167_140 VDD VSS sg13g2_decap_8
XFILLER_168_42 VDD VSS sg13g2_decap_8
X_14361_ _14361_/Q clkload36/A _14361_/D _14361_/RESET_B VDD VSS sg13g2_dfrbpq_1
X_11573_ _11573_/X _14565_/Q _14597_/Q _14629_/Q _14661_/Q _11996_/S0 _11996_/S1 VDD
+ VSS sg13g2_mux4_1
XFILLER_161_1074 VDD VSS sg13g2_fill_1
XFILLER_11_875 VDD VSS sg13g2_decap_8
XFILLER_128_527 VDD VSS sg13g2_decap_8
Xinput18 input18/X input18/A VDD VSS sg13g2_buf_1
X_13312_ _13312_/Y _13312_/A _15205_/Q VDD VSS sg13g2_nor2b_1
XFILLER_6_301 VDD VSS sg13g2_decap_8
XFILLER_35_1099 VDD VSS sg13g2_decap_4
Xinput29 input29/X input29/A VDD VSS sg13g2_buf_1
X_10524_ _10543_/C _10538_/A _10538_/B _10567_/A VDD VSS sg13g2_nor3_1
X_14292_ _14292_/Q _14740_/CLK _14292_/D _14292_/RESET_B VDD VSS sg13g2_dfrbpq_1
XFILLER_10_385 VDD VSS sg13g2_decap_8
XFILLER_7_868 VDD VSS sg13g2_decap_8
XFILLER_100_1312 VDD VSS sg13g2_decap_8
XFILLER_171_817 VDD VSS sg13g2_fill_1
XFILLER_183_677 VDD VSS sg13g2_decap_8
XFILLER_182_154 VDD VSS sg13g2_decap_8
X_13243_ _13243_/Y _13244_/B _13246_/C VDD VSS sg13g2_nand2_1
X_10455_ _10455_/Y _14841_/Q _10462_/D _10626_/B VDD VSS sg13g2_o21ai_1
XFILLER_13_1386 VDD VSS sg13g2_decap_8
XFILLER_6_378 VDD VSS sg13g2_decap_8
XFILLER_83_1307 VDD VSS sg13g2_decap_8
XFILLER_184_63 VDD VSS sg13g2_decap_8
X_13174_ _13174_/Y _13174_/A _13174_/B VDD VSS sg13g2_nor2_1
X_10386_ _14819_/D _10633_/A _10386_/B _10386_/C VDD VSS sg13g2_nor3_1
XFILLER_83_1329 VDD VSS sg13g2_fill_1
XFILLER_151_563 VDD VSS sg13g2_fill_2
X_12125_ _14982_/D _12125_/A _12125_/B VDD VSS sg13g2_nor2_1
XFILLER_111_405 VDD VSS sg13g2_decap_8
XFILLER_124_788 VDD VSS sg13g2_fill_1
XFILLER_111_427 VDD VSS sg13g2_decap_8
XFILLER_133_1110 VDD VSS sg13g2_fill_2
XFILLER_2_595 VDD VSS sg13g2_decap_8
X_12056_ _12056_/X _12056_/A _12056_/B _12056_/C VDD VSS sg13g2_and3_1
XFILLER_46_1173 VDD VSS sg13g2_decap_8
XFILLER_77_330 VDD VSS sg13g2_decap_4
XFILLER_28_7 VDD VSS sg13g2_decap_8
X_15101__2860 _15101_/RESET_B VDD VSS sg13g2_tiehi
X_11007_ _11010_/A _11007_/A _11007_/B VDD VSS sg13g2_or2_1
XFILLER_93_812 VDD VSS sg13g2_fill_1
XFILLER_78_897 VDD VSS sg13g2_decap_4
X_16864_ _16864_/X _16864_/A VDD VSS sg13g2_buf_1
XFILLER_93_867 VDD VSS sg13g2_fill_1
XFILLER_18_441 VDD VSS sg13g2_decap_8
XFILLER_92_366 VDD VSS sg13g2_decap_8
XFILLER_20_1357 VDD VSS sg13g2_decap_8
XFILLER_0_1429 VDD VSS sg13g2_decap_8
X_12958_ _12961_/C _14903_/Q _12942_/B _12945_/Y VDD VSS sg13g2_a21oi_1
XFILLER_33_411 VDD VSS sg13g2_fill_1
XFILLER_179_917 VDD VSS sg13g2_decap_8
XFILLER_33_422 VDD VSS sg13g2_decap_8
X_11909_ _11913_/A _11864_/Y _11908_/Y _11907_/X VDD VSS sg13g2_o21ai_1
XFILLER_33_433 VDD VSS sg13g2_fill_1
XFILLER_181_1417 VDD VSS sg13g2_fill_2
XFILLER_34_967 VDD VSS sg13g2_decap_8
X_12889_ _12889_/Y _12874_/A _12877_/C _12872_/X VDD VSS sg13g2_a21oi_1
XFILLER_61_764 VDD VSS sg13g2_decap_8
XFILLER_178_427 VDD VSS sg13g2_decap_8
XFILLER_18_1220 VDD VSS sg13g2_decap_8
X_14628_ _14628_/Q clkload33/A _14628_/D _14628_/RESET_B VDD VSS sg13g2_dfrbpq_1
XFILLER_20_105 VDD VSS sg13g2_decap_8
XFILLER_33_488 VDD VSS sg13g2_decap_8
XFILLER_53_1122 VDD VSS sg13g2_decap_8
X_14158__2114 _14158_/RESET_B VDD VSS sg13g2_tiehi
XFILLER_14_1106 VDD VSS sg13g2_decap_8
X_14559_ _14559_/Q _14662_/CLK _14559_/D _14559_/RESET_B VDD VSS sg13g2_dfrbpq_1
XFILLER_147_836 VDD VSS sg13g2_decap_8
XFILLER_18_1297 VDD VSS sg13g2_decap_8
XFILLER_105_1256 VDD VSS sg13g2_decap_8
XFILLER_140_1136 VDD VSS sg13g2_decap_4
XFILLER_146_313 VDD VSS sg13g2_decap_8
XFILLER_159_696 VDD VSS sg13g2_fill_2
XFILLER_9_161 VDD VSS sg13g2_decap_8
XFILLER_119_538 VDD VSS sg13g2_fill_1
X_08080_ _08080_/Y _08048_/A _12203_/A _08079_/S VDD VSS sg13g2_a21oi_1
XFILLER_173_154 VDD VSS sg13g2_decap_8
XFILLER_179_1379 VDD VSS sg13g2_decap_8
XFILLER_115_722 VDD VSS sg13g2_decap_8
XFILLER_54_0 VDD VSS sg13g2_decap_8
XFILLER_114_210 VDD VSS sg13g2_decap_8
X_14950__2737 _14950_/RESET_B VDD VSS sg13g2_tiehi
X_08982_ _08982_/Y _10681_/A _10674_/A _08981_/Y VDD VSS sg13g2_a21oi_1
XFILLER_9_1421 VDD VSS sg13g2_decap_8
XFILLER_69_831 VDD VSS sg13g2_fill_1
XFILLER_130_758 VDD VSS sg13g2_fill_1
X_07933_ _07933_/Y _15002_/Q _07782_/A VDD VSS sg13g2_nor2b_1
XFILLER_25_1224 VDD VSS sg13g2_decap_8
XFILLER_111_950 VDD VSS sg13g2_decap_8
XFILLER_69_864 VDD VSS sg13g2_decap_8
XFILLER_69_875 VDD VSS sg13g2_fill_1
XFILLER_64_1295 VDD VSS sg13g2_decap_8
XFILLER_116_1363 VDD VSS sg13g2_fill_1
X_14965__2715 _14965_/RESET_B VDD VSS sg13g2_tiehi
X_07864_ _07864_/Y _08608_/A _08608_/B _08641_/C VDD VSS sg13g2_o21ai_1
XFILLER_84_823 VDD VSS sg13g2_decap_8
XFILLER_3_91 VDD VSS sg13g2_decap_8
XFILLER_116_1396 VDD VSS sg13g2_decap_8
XFILLER_95_160 VDD VSS sg13g2_decap_8
XFILLER_28_216 VDD VSS sg13g2_decap_8
X_09603_ _14200_/D _14200_/Q _09770_/A1 _09603_/S VDD VSS sg13g2_mux2_1
XFILLER_110_493 VDD VSS sg13g2_decap_8
XFILLER_83_344 VDD VSS sg13g2_decap_8
X_07795_ _07797_/D _07795_/A _08414_/C VDD VSS sg13g2_nand2_1
X_14368__1904 _14368_/RESET_B VDD VSS sg13g2_tiehi
X_09534_ _14133_/D _10097_/A0 _14133_/Q _09534_/S VDD VSS sg13g2_mux2_1
XFILLER_43_208 VDD VSS sg13g2_fill_1
XFILLER_3_1064 VDD VSS sg13g2_decap_8
XFILLER_71_528 VDD VSS sg13g2_decap_8
XFILLER_37_783 VDD VSS sg13g2_decap_8
XFILLER_97_1071 VDD VSS sg13g2_decap_8
XFILLER_58_1022 VDD VSS sg13g2_decap_8
XFILLER_64_591 VDD VSS sg13g2_decap_8
XFILLER_36_282 VDD VSS sg13g2_decap_8
XFILLER_145_1003 VDD VSS sg13g2_decap_8
X_09465_ _14066_/D _09597_/A1 _14066_/Q wire504/X VDD VSS sg13g2_mux2_1
XFILLER_24_444 VDD VSS sg13g2_fill_1
XFILLER_149_1183 VDD VSS sg13g2_fill_2
XFILLER_169_416 VDD VSS sg13g2_decap_4
XFILLER_19_1017 VDD VSS sg13g2_decap_8
XFILLER_51_230 VDD VSS sg13g2_decap_8
XFILLER_145_1025 VDD VSS sg13g2_decap_4
XFILLER_52_764 VDD VSS sg13g2_decap_8
XFILLER_51_241 VDD VSS sg13g2_fill_1
XFILLER_25_989 VDD VSS sg13g2_decap_8
XFILLER_145_1036 VDD VSS sg13g2_fill_1
X_08416_ _08575_/A _08418_/B _08417_/B VDD VSS sg13g2_and2_1
XFILLER_11_105 VDD VSS sg13g2_decap_8
XFILLER_169_449 VDD VSS sg13g2_decap_8
XFILLER_40_937 VDD VSS sg13g2_decap_8
X_09396_ _13999_/D _09627_/A0 _13999_/Q _09396_/S VDD VSS sg13g2_mux2_1
XFILLER_51_274 VDD VSS sg13g2_decap_8
XFILLER_145_1069 VDD VSS sg13g2_decap_8
XFILLER_75_1391 VDD VSS sg13g2_decap_8
XFILLER_51_296 VDD VSS sg13g2_fill_2
XFILLER_123_1312 VDD VSS sg13g2_decap_8
XFILLER_178_972 VDD VSS sg13g2_decap_8
X_08347_ _08347_/Y _08381_/A _08336_/Y _08341_/Y _08637_/B _08346_/Y VDD VSS sg13g2_a221oi_1
XFILLER_71_1255 VDD VSS sg13g2_decap_8
XFILLER_132_7 VDD VSS sg13g2_decap_8
XFILLER_123_1334 VDD VSS sg13g2_decap_8
XFILLER_20_661 VDD VSS sg13g2_decap_8
XFILLER_71_1277 VDD VSS sg13g2_decap_4
XFILLER_71_1299 VDD VSS sg13g2_decap_4
XFILLER_138_23 VDD VSS sg13g2_decap_4
X_08278_ _08279_/A _08296_/A1 _08258_/C _07929_/B _08219_/A _08046_/B _08278_/S1 VDD
+ VSS sg13g2_mux4_1
XFILLER_22_56 VDD VSS sg13g2_decap_8
XFILLER_138_45 VDD VSS sg13g2_fill_2
XFILLER_153_817 VDD VSS sg13g2_decap_8
XFILLER_4_805 VDD VSS sg13g2_decap_8
XFILLER_153_828 VDD VSS sg13g2_fill_2
XFILLER_165_699 VDD VSS sg13g2_fill_2
XFILLER_164_187 VDD VSS sg13g2_decap_4
XFILLER_3_315 VDD VSS sg13g2_decap_8
XFILLER_106_733 VDD VSS sg13g2_decap_8
XFILLER_98_49 VDD VSS sg13g2_decap_8
X_10240_ _10250_/D _14775_/Q _10247_/D VDD VSS sg13g2_and2_1
XFILLER_145_390 VDD VSS sg13g2_decap_8
XFILLER_69_1173 VDD VSS sg13g2_decap_8
XFILLER_65_1004 VDD VSS sg13g2_fill_1
XFILLER_133_541 VDD VSS sg13g2_decap_4
XFILLER_161_850 VDD VSS sg13g2_decap_4
X_13856__2416 _13856_/RESET_B VDD VSS sg13g2_tiehi
XFILLER_69_1195 VDD VSS sg13g2_decap_8
XFILLER_105_254 VDD VSS sg13g2_decap_4
X_10171_ _10178_/A _15054_/Q _13507_/A _14766_/Q _10171_/D VDD VSS sg13g2_or4_1
XFILLER_65_1037 VDD VSS sg13g2_decap_8
XFILLER_161_883 VDD VSS sg13g2_decap_8
XFILLER_117_1127 VDD VSS sg13g2_decap_4
XFILLER_121_736 VDD VSS sg13g2_decap_8
XFILLER_121_747 VDD VSS sg13g2_fill_1
Xfanout1105 _13533_/A _14993_/Q VDD VSS sg13g2_buf_1
Xfanout1116 _08154_/A _08142_/B VDD VSS sg13g2_buf_1
Xfanout1127 _08598_/S1 _08278_/S1 VDD VSS sg13g2_buf_1
XFILLER_154_88 VDD VSS sg13g2_decap_8
Xfanout1138 _08635_/S0 _08598_/S0 VDD VSS sg13g2_buf_1
XFILLER_43_1324 VDD VSS sg13g2_decap_8
Xfanout151 _09637_/A0 fanout152/X VDD VSS sg13g2_buf_1
Xfanout1149 _08048_/B _12300_/A VDD VSS sg13g2_buf_1
XFILLER_59_341 VDD VSS sg13g2_decap_8
XFILLER_120_268 VDD VSS sg13g2_fill_1
Xfanout162 fanout162/X _09145_/Y VDD VSS sg13g2_buf_1
XFILLER_82_1395 VDD VSS sg13g2_decap_4
X_13930_ _13930_/Q clkload16/A _13930_/D _13930_/RESET_B VDD VSS sg13g2_dfrbpq_1
Xfanout173 _09799_/A0 _09931_/A1 VDD VSS sg13g2_buf_1
XFILLER_93_119 VDD VSS sg13g2_fill_2
Xfanout184 _10161_/A1 _09929_/A1 VDD VSS sg13g2_buf_1
XFILLER_86_160 VDD VSS sg13g2_fill_2
XFILLER_130_1327 VDD VSS sg13g2_decap_8
XFILLER_170_21 VDD VSS sg13g2_decap_8
X_14236__2036 _14236_/RESET_B VDD VSS sg13g2_tiehi
Xfanout195 _10158_/A1 _09926_/A1 VDD VSS sg13g2_buf_1
XFILLER_130_1349 VDD VSS sg13g2_decap_8
XFILLER_19_238 VDD VSS sg13g2_decap_8
XFILLER_74_333 VDD VSS sg13g2_decap_8
X_13861_ _13861_/Q clkload12/A _13861_/D _13861_/RESET_B VDD VSS sg13g2_dfrbpq_1
XFILLER_41_1070 VDD VSS sg13g2_decap_8
X_12812_ _15021_/D _13211_/A _12812_/B VDD VSS sg13g2_nor2_1
XFILLER_34_219 VDD VSS sg13g2_decap_8
XFILLER_170_98 VDD VSS sg13g2_decap_8
X_13792_ _13792_/Q _14720_/CLK _13792_/D _13792_/RESET_B VDD VSS sg13g2_dfrbpq_1
XFILLER_90_848 VDD VSS sg13g2_fill_1
XFILLER_16_945 VDD VSS sg13g2_decap_8
X_12743_ _12743_/X _13975_/Q _14007_/Q _14039_/Q _14071_/Q _12745_/S0 _12745_/S1 VDD
+ VSS sg13g2_mux4_1
XFILLER_43_753 VDD VSS sg13g2_decap_8
XFILLER_15_455 VDD VSS sg13g2_decap_8
XFILLER_167_1283 VDD VSS sg13g2_fill_2
XFILLER_163_1147 VDD VSS sg13g2_decap_8
XFILLER_54_1420 VDD VSS sg13g2_fill_1
XFILLER_124_1109 VDD VSS sg13g2_decap_8
XFILLER_179_63 VDD VSS sg13g2_decap_8
X_12674_ _12674_/X _14130_/Q _14162_/Q _14194_/Q _14226_/Q _12674_/S0 _12674_/S1 VDD
+ VSS sg13g2_mux4_1
XFILLER_128_1278 VDD VSS sg13g2_decap_4
XFILLER_8_14 VDD VSS sg13g2_decap_8
X_14413_ _14413_/Q clkload19/A _14413_/D _14413_/RESET_B VDD VSS sg13g2_dfrbpq_1
XFILLER_180_1461 VDD VSS sg13g2_decap_8
X_11625_ _11625_/Y _11623_/Y _11625_/B _11625_/C VDD VSS sg13g2_nand3b_1
XFILLER_168_482 VDD VSS sg13g2_decap_8
XFILLER_11_672 VDD VSS sg13g2_decap_8
XFILLER_129_858 VDD VSS sg13g2_decap_8
XFILLER_15_1459 VDD VSS sg13g2_decap_8
X_14344_ _14344_/Q clkload27/A _14344_/D _14344_/RESET_B VDD VSS sg13g2_dfrbpq_1
X_11556_ _11556_/X _12239_/B _11555_/X _11554_/Y VDD VSS sg13g2_a21o_1
XFILLER_102_1429 VDD VSS sg13g2_decap_8
XFILLER_183_441 VDD VSS sg13g2_decap_8
X_15137__2776 _15137_/RESET_B VDD VSS sg13g2_tiehi
XFILLER_10_182 VDD VSS sg13g2_decap_8
XFILLER_128_368 VDD VSS sg13g2_decap_8
X_10507_ _10509_/C _14852_/Q _14845_/Q _10514_/A _10507_/D VDD VSS sg13g2_nand4_1
XFILLER_7_665 VDD VSS sg13g2_decap_8
X_14275_ _14275_/Q clkload29/A _14275_/D _14275_/RESET_B VDD VSS sg13g2_dfrbpq_1
XFILLER_156_699 VDD VSS sg13g2_fill_1
X_11487_ _11487_/X _14690_/Q _14722_/Q _13762_/Q _13794_/Q _11489_/S0 _11489_/S1 VDD
+ VSS sg13g2_mux4_1
XFILLER_13_1183 VDD VSS sg13g2_decap_8
XFILLER_6_175 VDD VSS sg13g2_decap_8
X_13226_ _13228_/B _13202_/B _13226_/B VDD VSS sg13g2_nand2b_1
X_10438_ _10441_/A _14835_/Q _10443_/D _14836_/Q VDD VSS sg13g2_a21o_1
XFILLER_178_1390 VDD VSS sg13g2_decap_8
XFILLER_139_1352 VDD VSS sg13g2_decap_8
XFILLER_170_157 VDD VSS sg13g2_fill_2
XFILLER_83_1115 VDD VSS sg13g2_decap_8
XFILLER_152_872 VDD VSS sg13g2_decap_8
X_14446__1826 _14446_/RESET_B VDD VSS sg13g2_tiehi
XFILLER_135_1205 VDD VSS sg13g2_decap_4
X_13157_ _13170_/D _14917_/Q _13670_/Q VDD VSS sg13g2_xnor2_1
X_10369_ _10370_/A wire220/X _10400_/B _10400_/C VDD VSS sg13g2_nor3_1
XFILLER_48_1268 VDD VSS sg13g2_decap_8
XFILLER_3_882 VDD VSS sg13g2_decap_8
XFILLER_112_747 VDD VSS sg13g2_decap_8
XFILLER_151_393 VDD VSS sg13g2_decap_8
X_12108_ _12108_/X _12108_/A _12317_/B VDD VSS sg13g2_and2_1
XFILLER_112_758 VDD VSS sg13g2_fill_2
XFILLER_97_458 VDD VSS sg13g2_decap_8
XFILLER_69_149 VDD VSS sg13g2_decap_8
X_13088_ _13088_/X _13088_/A _13675_/Q VDD VSS sg13g2_and2_1
XFILLER_2_392 VDD VSS sg13g2_decap_8
X_12039_ _12039_/Y _12040_/A1 _14194_/Q VDD VSS sg13g2_nand2b_1
XFILLER_22_1408 VDD VSS sg13g2_decap_8
XFILLER_78_683 VDD VSS sg13g2_decap_8
XFILLER_66_834 VDD VSS sg13g2_fill_2
XFILLER_65_322 VDD VSS sg13g2_decap_4
X_14661__1611 _14661_/RESET_B VDD VSS sg13g2_tiehi
XFILLER_168_1003 VDD VSS sg13g2_decap_8
XFILLER_93_653 VDD VSS sg13g2_fill_1
XFILLER_19_750 VDD VSS sg13g2_decap_8
XFILLER_81_804 VDD VSS sg13g2_decap_8
XFILLER_66_878 VDD VSS sg13g2_fill_1
XFILLER_4_1351 VDD VSS sg13g2_decap_8
XFILLER_81_826 VDD VSS sg13g2_decap_8
XFILLER_65_377 VDD VSS sg13g2_decap_8
XFILLER_0_1226 VDD VSS sg13g2_decap_8
XFILLER_20_1154 VDD VSS sg13g2_decap_8
XFILLER_98_1380 VDD VSS sg13g2_decap_8
X_14090__2182 _14090_/RESET_B VDD VSS sg13g2_tiehi
XFILLER_59_1353 VDD VSS sg13g2_decap_8
XFILLER_185_1372 VDD VSS sg13g2_decap_8
X_15183__2912 _15183_/RESET_B VDD VSS sg13g2_tiehi
XFILLER_59_1375 VDD VSS sg13g2_decap_8
XFILLER_22_904 VDD VSS sg13g2_fill_1
XFILLER_146_1334 VDD VSS sg13g2_decap_8
XFILLER_179_747 VDD VSS sg13g2_decap_8
XFILLER_181_1225 VDD VSS sg13g2_decap_8
XFILLER_94_1277 VDD VSS sg13g2_fill_2
XFILLER_107_1307 VDD VSS sg13g2_fill_1
XFILLER_178_224 VDD VSS sg13g2_decap_8
X_09250_ _13859_/D _13859_/Q _10146_/A1 _09272_/S VDD VSS sg13g2_mux2_1
XFILLER_61_594 VDD VSS sg13g2_decap_8
XFILLER_181_1269 VDD VSS sg13g2_decap_4
X_13934__2338 _13934_/RESET_B VDD VSS sg13g2_tiehi
X_14694__1578 _14694_/RESET_B VDD VSS sg13g2_tiehi
X_08201_ _08201_/Y _08201_/A wire719/X _08201_/C _08201_/D VDD VSS sg13g2_nor4_1
X_09181_ _13797_/D _13797_/Q _09883_/A0 _09193_/S VDD VSS sg13g2_mux2_1
XFILLER_144_1080 VDD VSS sg13g2_decap_8
XFILLER_18_1094 VDD VSS sg13g2_decap_8
XFILLER_144_1091 VDD VSS sg13g2_fill_1
X_08132_ _08132_/X _08219_/A _08258_/C _07929_/B _08276_/A _08300_/S1 _07900_/B VDD
+ VSS sg13g2_mux4_1
XFILLER_30_981 VDD VSS sg13g2_decap_8
XFILLER_147_655 VDD VSS sg13g2_decap_8
XFILLER_105_1086 VDD VSS sg13g2_fill_1
X_08063_ _08063_/Y _08063_/A _08063_/B VDD VSS sg13g2_nand2_1
XFILLER_174_485 VDD VSS sg13g2_decap_4
XFILLER_179_1176 VDD VSS sg13g2_decap_8
XFILLER_31_1272 VDD VSS sg13g2_fill_2
XFILLER_134_327 VDD VSS sg13g2_decap_8
XFILLER_108_37 VDD VSS sg13g2_decap_8
XFILLER_157_1441 VDD VSS sg13g2_fill_2
XFILLER_1_819 VDD VSS sg13g2_decap_8
Xhold3202 _13638_/A _13746_/Q VDD VSS sg13g2_dlygate4sd3_1
Xhold3213 _13645_/A _13753_/Q VDD VSS sg13g2_dlygate4sd3_1
XFILLER_115_585 VDD VSS sg13g2_fill_1
Xhold3224 _11170_/A _14954_/Q VDD VSS sg13g2_dlygate4sd3_1
XFILLER_88_425 VDD VSS sg13g2_decap_8
XFILLER_0_329 VDD VSS sg13g2_decap_8
Xhold3235 _13593_/A _15163_/Q VDD VSS sg13g2_dlygate4sd3_1
XFILLER_89_959 VDD VSS sg13g2_fill_2
XFILLER_66_1379 VDD VSS sg13g2_decap_8
Xhold3246 _11048_/A _14945_/Q VDD VSS sg13g2_dlygate4sd3_1
XFILLER_103_769 VDD VSS sg13g2_decap_8
Xhold3257 _13581_/A _15159_/Q VDD VSS sg13g2_dlygate4sd3_1
X_08965_ _08965_/Y _10137_/A _09240_/A _10137_/B _09707_/C VDD VSS sg13g2_nor4_1
XFILLER_124_14 VDD VSS sg13g2_decap_8
XFILLER_130_577 VDD VSS sg13g2_decap_4
X_07916_ _07916_/Y _07914_/Y _07904_/C _07878_/Y VDD VSS sg13g2_o21ai_1
X_08896_ _13707_/D _16869_/A _08895_/X _08932_/S VDD VSS sg13g2_mux2_1
XFILLER_9_1295 VDD VSS sg13g2_decap_8
XFILLER_68_160 VDD VSS sg13g2_decap_8
XFILLER_124_69 VDD VSS sg13g2_fill_2
XFILLER_5_1148 VDD VSS sg13g2_decap_8
XFILLER_112_1035 VDD VSS sg13g2_decap_8
XFILLER_151_1095 VDD VSS sg13g2_fill_1
XFILLER_186_1103 VDD VSS sg13g2_decap_8
X_07847_ _07847_/Y _08678_/B _08678_/C _08678_/A VDD VSS sg13g2_a21oi_1
XFILLER_84_664 VDD VSS sg13g2_decap_8
XFILLER_29_569 VDD VSS sg13g2_decap_8
X_14783__3023 _14783_/RESET_B VDD VSS sg13g2_tiehi
XFILLER_44_517 VDD VSS sg13g2_fill_2
XFILLER_77_1420 VDD VSS sg13g2_decap_8
XFILLER_17_56 VDD VSS sg13g2_decap_8
X_07778_ _08318_/D _08276_/A _08276_/B VDD VSS sg13g2_xor2_1
X_09517_ _14116_/D _09616_/A0 _14116_/Q _09534_/S VDD VSS sg13g2_mux2_1
XFILLER_38_1437 VDD VSS sg13g2_decap_8
XFILLER_52_561 VDD VSS sg13g2_fill_2
XFILLER_25_775 VDD VSS sg13g2_decap_8
XFILLER_24_252 VDD VSS sg13g2_decap_8
XFILLER_169_224 VDD VSS sg13g2_fill_2
XFILLER_169_235 VDD VSS sg13g2_fill_1
X_09448_ _14049_/D _09945_/A1 _14049_/Q _09462_/S VDD VSS sg13g2_mux2_1
XFILLER_13_959 VDD VSS sg13g2_decap_8
XFILLER_169_257 VDD VSS sg13g2_fill_1
X_14524__1748 _14524_/RESET_B VDD VSS sg13g2_tiehi
XFILLER_12_469 VDD VSS sg13g2_decap_8
X_09379_ _13982_/D _10041_/A0 _13982_/Q _09395_/S VDD VSS sg13g2_mux2_1
XFILLER_36_1161 VDD VSS sg13g2_decap_8
XFILLER_166_920 VDD VSS sg13g2_decap_4
XFILLER_33_77 VDD VSS sg13g2_decap_8
X_11410_ _11410_/Y _11410_/A1 _14495_/Q _12304_/B VDD VSS sg13g2_a21oi_1
XFILLER_137_110 VDD VSS sg13g2_decap_8
X_12390_ _12390_/X _13822_/Q _13854_/Q _13886_/Q _13918_/Q _12585_/S0 _12591_/S1 VDD
+ VSS sg13g2_mux4_1
XFILLER_123_1164 VDD VSS sg13g2_fill_2
XFILLER_166_964 VDD VSS sg13g2_decap_8
XFILLER_20_491 VDD VSS sg13g2_decap_8
XFILLER_153_603 VDD VSS sg13g2_decap_8
XFILLER_165_463 VDD VSS sg13g2_decap_8
XFILLER_14_1470 VDD VSS sg13g2_decap_4
X_11341_ _14959_/D _11335_/A _11248_/B _11340_/Y VDD VSS sg13g2_a21o_1
X_14814__2992 _14814_/RESET_B VDD VSS sg13g2_tiehi
XFILLER_4_602 VDD VSS sg13g2_decap_8
XFILLER_10_1323 VDD VSS sg13g2_decap_8
XFILLER_125_327 VDD VSS sg13g2_fill_2
XFILLER_165_21 VDD VSS sg13g2_decap_8
X_14060_ _14060_/Q clkload17/A _14060_/D _14060_/RESET_B VDD VSS sg13g2_dfrbpq_1
XFILLER_3_112 VDD VSS sg13g2_decap_8
XFILLER_101_1473 VDD VSS sg13g2_fill_2
XFILLER_118_390 VDD VSS sg13g2_decap_8
XFILLER_181_978 VDD VSS sg13g2_decap_8
X_11272_ _11272_/Y _11275_/S0 _14460_/Q VDD VSS sg13g2_nand2b_1
XFILLER_180_455 VDD VSS sg13g2_decap_8
X_15079__2928 _15079_/RESET_B VDD VSS sg13g2_tiehi
X_13011_ _13012_/A _13009_/A _13010_/B _13271_/C VDD VSS sg13g2_o21ai_1
XFILLER_4_679 VDD VSS sg13g2_decap_8
X_10223_ _14769_/D _14769_/Q _10219_/X _10222_/Y VDD VSS sg13g2_a21oi_1
XFILLER_84_1446 VDD VSS sg13g2_decap_8
XFILLER_134_883 VDD VSS sg13g2_decap_8
XFILLER_165_98 VDD VSS sg13g2_decap_4
XFILLER_171_1416 VDD VSS sg13g2_decap_4
XFILLER_3_189 VDD VSS sg13g2_decap_8
XFILLER_171_1438 VDD VSS sg13g2_decap_4
XFILLER_0_841 VDD VSS sg13g2_decap_8
X_10154_ _14731_/D _14731_/Q _10154_/A1 _10160_/S VDD VSS sg13g2_mux2_1
XFILLER_82_1170 VDD VSS sg13g2_decap_8
XFILLER_48_801 VDD VSS sg13g2_decap_8
XFILLER_181_42 VDD VSS sg13g2_decap_8
XFILLER_88_981 VDD VSS sg13g2_decap_8
X_14962_ _14962_/Q _15224_/CLK _14962_/D _14962_/RESET_B VDD VSS sg13g2_dfrbpq_1
XFILLER_121_599 VDD VSS sg13g2_decap_8
X_10085_ _14665_/D _10085_/A0 _14665_/Q _10097_/S VDD VSS sg13g2_mux2_1
XFILLER_130_1113 VDD VSS sg13g2_decap_8
XFILLER_47_311 VDD VSS sg13g2_decap_8
XFILLER_134_1293 VDD VSS sg13g2_decap_8
XFILLER_169_1312 VDD VSS sg13g2_decap_8
X_13913_ _13913_/Q _14745_/CLK _13913_/D _13913_/RESET_B VDD VSS sg13g2_dfrbpq_1
X_14893_ _14893_/Q clkload63/A _14893_/D _14893_/RESET_B VDD VSS sg13g2_dfrbpq_1
XFILLER_63_804 VDD VSS sg13g2_decap_8
XFILLER_74_152 VDD VSS sg13g2_decap_8
XFILLER_48_889 VDD VSS sg13g2_fill_1
XFILLER_21_1452 VDD VSS sg13g2_decap_8
XFILLER_63_826 VDD VSS sg13g2_decap_8
XFILLER_62_303 VDD VSS sg13g2_decap_8
XFILLER_35_517 VDD VSS sg13g2_decap_8
X_13844_ _13844_/Q _14740_/CLK _13844_/D _13844_/RESET_B VDD VSS sg13g2_dfrbpq_1
XFILLER_78_1239 VDD VSS sg13g2_decap_8
XFILLER_75_697 VDD VSS sg13g2_decap_8
XFILLER_62_314 VDD VSS sg13g2_fill_2
XFILLER_35_539 VDD VSS sg13g2_decap_8
XFILLER_90_645 VDD VSS sg13g2_decap_8
XFILLER_16_742 VDD VSS sg13g2_decap_8
X_13775_ _13775_/Q clkload12/A _13775_/D _13775_/RESET_B VDD VSS sg13g2_dfrbpq_1
X_10987_ _10987_/Y _10987_/A _11021_/B VDD VSS sg13g2_nand2_1
XFILLER_15_252 VDD VSS sg13g2_decap_8
XFILLER_43_561 VDD VSS sg13g2_decap_4
X_12726_ _12726_/X _14134_/Q _14166_/Q _14198_/Q _14230_/Q _12730_/S0 _12730_/S1 VDD
+ VSS sg13g2_mux4_1
XFILLER_71_892 VDD VSS sg13g2_decap_8
XFILLER_95_7 VDD VSS sg13g2_decap_8
XFILLER_43_594 VDD VSS sg13g2_decap_8
XFILLER_128_1075 VDD VSS sg13g2_decap_4
X_12657_ _12657_/X _13969_/Q _14001_/Q _14033_/Q _14065_/Q _12659_/S0 _12659_/S1 VDD
+ VSS sg13g2_mux4_1
XFILLER_157_931 VDD VSS sg13g2_decap_8
XFILLER_19_1392 VDD VSS sg13g2_decap_8
Xclkbuf_5_19__f_clk_i clkbuf_leaf_83_clk_i/A clkbuf_4_9_0_clk_i/X VDD VSS sg13g2_buf_16
XFILLER_31_789 VDD VSS sg13g2_decap_8
XFILLER_30_266 VDD VSS sg13g2_decap_8
XFILLER_175_238 VDD VSS sg13g2_decap_8
X_11608_ _11608_/X _11608_/A _11615_/B VDD VSS sg13g2_and2_1
XFILLER_89_1302 VDD VSS sg13g2_decap_8
XFILLER_15_1256 VDD VSS sg13g2_decap_8
X_12588_ _12588_/X _14252_/Q _14284_/Q _14316_/Q _14348_/Q _12588_/S0 _12588_/S1 VDD
+ VSS sg13g2_mux4_1
XFILLER_8_952 VDD VSS sg13g2_decap_8
XFILLER_50_1147 VDD VSS sg13g2_decap_8
XFILLER_106_1395 VDD VSS sg13g2_fill_2
XFILLER_141_1286 VDD VSS sg13g2_decap_8
X_14327_ _14327_/Q clkload42/A _14327_/D _14327_/RESET_B VDD VSS sg13g2_dfrbpq_1
XFILLER_171_400 VDD VSS sg13g2_fill_1
X_11539_ _11539_/Y _12070_/S0 _14660_/Q _12233_/B VDD VSS sg13g2_a21oi_1
XFILLER_7_462 VDD VSS sg13g2_decap_8
XFILLER_143_102 VDD VSS sg13g2_decap_8
XFILLER_172_967 VDD VSS sg13g2_decap_8
X_14258_ _14258_/Q clkload22/A _14258_/D _14258_/RESET_B VDD VSS sg13g2_dfrbpq_1
XFILLER_171_466 VDD VSS sg13g2_fill_2
X_13209_ _13209_/Y _13206_/Y _13207_/Y _13208_/Y VDD VSS sg13g2_a21oi_1
XFILLER_98_723 VDD VSS sg13g2_decap_8
X_14189_ _14189_/Q _14669_/CLK _14189_/D _14189_/RESET_B VDD VSS sg13g2_dfrbpq_1
XFILLER_152_680 VDD VSS sg13g2_decap_8
XFILLER_139_1182 VDD VSS sg13g2_decap_8
XFILLER_152_691 VDD VSS sg13g2_fill_2
Xfanout909 _12450_/S1 _12425_/S1 VDD VSS sg13g2_buf_1
XFILLER_139_1193 VDD VSS sg13g2_fill_1
XFILLER_61_1210 VDD VSS sg13g2_decap_8
XFILLER_79_970 VDD VSS sg13g2_decap_8
XFILLER_26_1341 VDD VSS sg13g2_decap_8
X_08750_ _13668_/D _08753_/A1 _08748_/Y _08749_/Y VDD VSS sg13g2_a21oi_1
XFILLER_57_119 VDD VSS sg13g2_decap_8
XFILLER_6_1435 VDD VSS sg13g2_decap_8
XFILLER_22_1205 VDD VSS sg13g2_decap_8
XFILLER_85_439 VDD VSS sg13g2_decap_8
XFILLER_66_620 VDD VSS sg13g2_decap_8
XFILLER_17_0 VDD VSS sg13g2_decap_8
X_07701_ _07705_/C _15085_/Q _07701_/B VDD VSS sg13g2_nand2_1
XFILLER_39_856 VDD VSS sg13g2_fill_2
Xfanout1480 _13507_/A _13021_/A VDD VSS sg13g2_buf_1
Xfanout1491 _10337_/C _10544_/C VDD VSS sg13g2_buf_1
X_08681_ _08681_/Y _08698_/B _08681_/B VDD VSS sg13g2_nor2_1
XFILLER_54_804 VDD VSS sg13g2_decap_8
XFILLER_38_355 VDD VSS sg13g2_decap_8
XFILLER_96_1317 VDD VSS sg13g2_decap_8
XFILLER_94_995 VDD VSS sg13g2_decap_8
X_07632_ _08203_/A _11461_/A VDD VSS sg13g2_inv_1
XFILLER_113_1399 VDD VSS sg13g2_fill_1
XFILLER_66_697 VDD VSS sg13g2_decap_8
XFILLER_0_1023 VDD VSS sg13g2_decap_8
XFILLER_0_70 VDD VSS sg13g2_decap_8
XFILLER_81_656 VDD VSS sg13g2_decap_8
XFILLER_80_144 VDD VSS sg13g2_decap_8
XFILLER_179_511 VDD VSS sg13g2_decap_8
X_09302_ _13910_/D _13910_/Q _09634_/A0 _09303_/S VDD VSS sg13g2_mux2_1
XFILLER_181_1022 VDD VSS sg13g2_decap_8
XFILLER_110_49 VDD VSS sg13g2_decap_8
X_09233_ _13844_/D _10163_/A1 _13844_/Q _09233_/S VDD VSS sg13g2_mux2_1
XFILLER_179_588 VDD VSS sg13g2_decap_8
XFILLER_181_1077 VDD VSS sg13g2_decap_8
XFILLER_167_739 VDD VSS sg13g2_fill_2
XFILLER_21_266 VDD VSS sg13g2_decap_4
XFILLER_166_238 VDD VSS sg13g2_decap_8
XFILLER_72_1383 VDD VSS sg13g2_decap_4
X_09164_ _09164_/X _14923_/Q _13245_/A _09164_/C _09164_/D VDD VSS sg13g2_and4_1
XFILLER_124_1473 VDD VSS sg13g2_fill_2
XFILLER_119_132 VDD VSS sg13g2_decap_8
XFILLER_119_143 VDD VSS sg13g2_fill_2
XFILLER_147_463 VDD VSS sg13g2_decap_4
X_08115_ _08115_/Y _13427_/C _08115_/B VDD VSS sg13g2_nor2_1
XFILLER_33_1378 VDD VSS sg13g2_decap_4
XFILLER_108_828 VDD VSS sg13g2_decap_8
XFILLER_163_923 VDD VSS sg13g2_decap_4
XFILLER_119_176 VDD VSS sg13g2_decap_8
X_09095_ _09097_/B _09103_/C _09103_/D _14915_/Q VDD VSS sg13g2_a21oi_1
XFILLER_162_411 VDD VSS sg13g2_decap_8
XFILLER_79_18 VDD VSS sg13g2_fill_2
XFILLER_135_658 VDD VSS sg13g2_fill_2
X_08046_ _08046_/Y _08673_/B _08046_/B VDD VSS sg13g2_nand2b_1
XFILLER_66_1110 VDD VSS sg13g2_decap_8
XFILLER_116_872 VDD VSS sg13g2_fill_1
XFILLER_122_319 VDD VSS sg13g2_decap_8
XFILLER_1_616 VDD VSS sg13g2_decap_8
XFILLER_89_723 VDD VSS sg13g2_fill_2
XFILLER_115_371 VDD VSS sg13g2_decap_8
XFILLER_115_382 VDD VSS sg13g2_fill_2
XFILLER_143_691 VDD VSS sg13g2_decap_4
XFILLER_0_126 VDD VSS sg13g2_decap_8
XFILLER_118_1244 VDD VSS sg13g2_decap_4
XFILLER_157_1293 VDD VSS sg13g2_fill_1
X_15103__2852 _15103_/RESET_B VDD VSS sg13g2_tiehi
XFILLER_103_555 VDD VSS sg13g2_decap_4
XFILLER_135_68 VDD VSS sg13g2_fill_2
X_09997_ _14580_/D _09997_/A0 _14580_/Q _09997_/S VDD VSS sg13g2_mux2_1
XFILLER_153_1157 VDD VSS sg13g2_decap_8
XFILLER_88_266 VDD VSS sg13g2_decap_8
XFILLER_44_1441 VDD VSS sg13g2_decap_8
XFILLER_118_1288 VDD VSS sg13g2_decap_8
XFILLER_131_1400 VDD VSS sg13g2_decap_4
X_08948_ _08948_/Y _10793_/A _10793_/B _15051_/Q VDD VSS sg13g2_nand3_1
XFILLER_9_1092 VDD VSS sg13g2_decap_8
XFILLER_40_1305 VDD VSS sg13g2_fill_1
X_08879_ _08879_/X _08878_/X _08879_/A1 _08940_/S VDD VSS sg13g2_mux2_1
XFILLER_28_77 VDD VSS sg13g2_decap_8
X_10910_ _10910_/Y wire276/X _10936_/D _11027_/B1 VDD VSS sg13g2_a21oi_1
XFILLER_84_472 VDD VSS sg13g2_decap_8
XFILLER_17_539 VDD VSS sg13g2_decap_8
X_11890_ _11891_/A _14254_/Q _14286_/Q _14318_/Q _14350_/Q _11365_/A _11366_/C VDD
+ VSS sg13g2_mux4_1
XFILLER_29_399 VDD VSS sg13g2_decap_8
XFILLER_44_336 VDD VSS sg13g2_fill_2
X_10841_ _10841_/Y _10841_/A _10841_/B _10841_/C VDD VSS sg13g2_nor3_1
XFILLER_44_21 VDD VSS sg13g2_decap_8
XFILLER_77_1272 VDD VSS sg13g2_decap_8
XFILLER_77_1283 VDD VSS sg13g2_fill_1
XFILLER_129_1362 VDD VSS sg13g2_decap_8
X_13560_ _15151_/D _15151_/Q _13559_/Y _13562_/S VDD VSS sg13g2_mux2_1
X_10772_ _10772_/X _10772_/A _10793_/B _10793_/A VDD VSS sg13g2_and3_1
XFILLER_129_1373 VDD VSS sg13g2_fill_2
XFILLER_52_391 VDD VSS sg13g2_decap_8
XFILLER_13_756 VDD VSS sg13g2_decap_8
XFILLER_158_717 VDD VSS sg13g2_decap_8
X_12511_ _12511_/X _12510_/X _12509_/X _12664_/S VDD VSS sg13g2_mux2_1
XFILLER_73_1158 VDD VSS sg13g2_decap_8
XFILLER_164_1286 VDD VSS sg13g2_decap_8
XFILLER_185_525 VDD VSS sg13g2_decap_8
X_13491_ _13492_/A _15125_/Q _13437_/A _13414_/Y _15129_/Q _13490_/Y VDD VSS sg13g2_a221oi_1
XFILLER_40_564 VDD VSS sg13g2_decap_8
XFILLER_12_266 VDD VSS sg13g2_decap_8
X_14186__2086 _14186_/RESET_B VDD VSS sg13g2_tiehi
X_15230_ _15230_/Q _15249_/CLK _15230_/D _15230_/RESET_B VDD VSS sg13g2_dfrbpq_1
XFILLER_9_749 VDD VSS sg13g2_decap_8
XFILLER_40_586 VDD VSS sg13g2_decap_8
XFILLER_100_82 VDD VSS sg13g2_decap_8
X_12442_ _12442_/Y _13687_/Q _12442_/A2 _12441_/X _12386_/A _12443_/A2 VDD VSS sg13g2_a221oi_1
XFILLER_138_430 VDD VSS sg13g2_fill_2
XFILLER_60_42 VDD VSS sg13g2_decap_8
XFILLER_12_1407 VDD VSS sg13g2_decap_8
XFILLER_51_1456 VDD VSS sg13g2_decap_8
XFILLER_121_0 VDD VSS sg13g2_decap_8
XFILLER_139_975 VDD VSS sg13g2_decap_8
XFILLER_166_761 VDD VSS sg13g2_decap_8
XFILLER_8_259 VDD VSS sg13g2_decap_8
XFILLER_154_912 VDD VSS sg13g2_decap_8
XFILLER_176_42 VDD VSS sg13g2_decap_8
X_15161_ _15161_/Q _15216_/CLK _15161_/D _15161_/RESET_B VDD VSS sg13g2_dfrbpq_1
X_12373_ _12373_/Y _15120_/Q _12348_/A _12442_/A2 _12836_/B _13282_/A1 VDD VSS sg13g2_a221oi_1
XFILLER_10_1120 VDD VSS sg13g2_decap_8
XFILLER_154_956 VDD VSS sg13g2_decap_8
X_14112_ _14112_/Q clkload46/A _14112_/D _14112_/RESET_B VDD VSS sg13g2_dfrbpq_1
X_11324_ _11326_/B _11328_/S0 _14173_/Q VDD VSS sg13g2_nand2b_1
XFILLER_126_669 VDD VSS sg13g2_fill_1
X_14960__2720 _14960_/RESET_B VDD VSS sg13g2_tiehi
X_15092_ _15092_/Q _15224_/CLK _15092_/D _15092_/RESET_B VDD VSS sg13g2_dfrbpq_1
XFILLER_5_966 VDD VSS sg13g2_decap_8
XFILLER_180_252 VDD VSS sg13g2_decap_8
XFILLER_181_786 VDD VSS sg13g2_decap_8
XFILLER_88_1390 VDD VSS sg13g2_decap_4
X_14043_ _14043_/Q _14734_/CLK _14043_/D _14043_/RESET_B VDD VSS sg13g2_dfrbpq_1
X_11255_ _11255_/Y _11255_/A _11255_/B VDD VSS sg13g2_nand2_1
XFILLER_4_476 VDD VSS sg13g2_decap_8
XFILLER_69_51 VDD VSS sg13g2_fill_1
XFILLER_10_1197 VDD VSS sg13g2_decap_8
XFILLER_136_1333 VDD VSS sg13g2_decap_8
XFILLER_175_1382 VDD VSS sg13g2_decap_8
XFILLER_69_73 VDD VSS sg13g2_decap_8
X_10206_ _14761_/D _15200_/D _11203_/A1 _13656_/S VDD VSS sg13g2_mux2_1
XFILLER_84_1276 VDD VSS sg13g2_decap_8
XFILLER_136_1355 VDD VSS sg13g2_fill_2
X_11186_ _11186_/Y _11186_/A _11186_/B VDD VSS sg13g2_nand2_1
XFILLER_68_929 VDD VSS sg13g2_fill_2
XFILLER_121_352 VDD VSS sg13g2_decap_8
XFILLER_67_417 VDD VSS sg13g2_decap_8
X_10137_ wire334/A _10137_/A _10137_/B _10137_/C VDD VSS sg13g2_nor3_1
XFILLER_94_225 VDD VSS sg13g2_decap_8
XFILLER_0_693 VDD VSS sg13g2_decap_8
XFILLER_125_90 VDD VSS sg13g2_decap_8
X_14993__2687 _14993_/RESET_B VDD VSS sg13g2_tiehi
XFILLER_10_7 VDD VSS sg13g2_decap_8
XFILLER_48_653 VDD VSS sg13g2_decap_8
X_14945_ _14945_/Q _14947_/CLK _14945_/D _14945_/RESET_B VDD VSS sg13g2_dfrbpq_1
X_10068_ _14649_/D _10101_/A0 _14649_/Q _10068_/S VDD VSS sg13g2_mux2_1
XFILLER_36_804 VDD VSS sg13g2_decap_8
XFILLER_75_461 VDD VSS sg13g2_fill_2
XFILLER_78_1025 VDD VSS sg13g2_fill_1
XFILLER_36_848 VDD VSS sg13g2_decap_4
X_14876_ _14876_/Q _14876_/CLK _14876_/D _14876_/RESET_B VDD VSS sg13g2_dfrbpq_1
XFILLER_62_111 VDD VSS sg13g2_decap_8
X_14396__1876 _14396_/RESET_B VDD VSS sg13g2_tiehi
XFILLER_1_1365 VDD VSS sg13g2_decap_8
X_13827_ _13827_/Q _14723_/CLK _13827_/D _13827_/RESET_B VDD VSS sg13g2_dfrbpq_1
XFILLER_56_1323 VDD VSS sg13g2_decap_8
XFILLER_182_1331 VDD VSS sg13g2_decap_8
X_13758_ _13758_/Q clkload50/A _13758_/D _13758_/RESET_B VDD VSS sg13g2_dfrbpq_1
XFILLER_62_188 VDD VSS sg13g2_decap_8
XFILLER_108_1424 VDD VSS sg13g2_decap_8
XFILLER_43_380 VDD VSS sg13g2_decap_8
XFILLER_31_531 VDD VSS sg13g2_decap_8
X_12709_ _12722_/A _12751_/A1 _12737_/A2 _15015_/Q VDD VSS sg13g2_a21oi_1
XFILLER_148_205 VDD VSS sg13g2_fill_1
X_13689_ _13689_/Q clkload84/A _13689_/D _13689_/RESET_B VDD VSS sg13g2_dfrbpq_1
XFILLER_176_536 VDD VSS sg13g2_decap_8
X_13851__2421 _13851_/RESET_B VDD VSS sg13g2_tiehi
X_14016__2256 _14016_/RESET_B VDD VSS sg13g2_tiehi
XFILLER_15_1053 VDD VSS sg13g2_decap_8
XFILLER_157_772 VDD VSS sg13g2_decap_8
XFILLER_117_625 VDD VSS sg13g2_decap_8
XFILLER_141_1083 VDD VSS sg13g2_fill_2
XFILLER_117_636 VDD VSS sg13g2_fill_1
XFILLER_145_945 VDD VSS sg13g2_decap_4
XFILLER_89_1154 VDD VSS sg13g2_decap_8
XFILLER_116_146 VDD VSS sg13g2_fill_2
XFILLER_117_669 VDD VSS sg13g2_fill_2
XFILLER_160_915 VDD VSS sg13g2_decap_8
X_13661__1517 _13661_/RESET_B VDD VSS sg13g2_tiehi
XFILLER_116_168 VDD VSS sg13g2_decap_8
XFILLER_137_1119 VDD VSS sg13g2_decap_8
X_14231__2041 _14231_/RESET_B VDD VSS sg13g2_tiehi
X_09920_ _14505_/D _14505_/Q _09920_/A1 _09936_/S VDD VSS sg13g2_mux2_1
XFILLER_67_1441 VDD VSS sg13g2_decap_8
XFILLER_160_937 VDD VSS sg13g2_decap_8
XFILLER_172_797 VDD VSS sg13g2_decap_4
XFILLER_125_680 VDD VSS sg13g2_decap_8
XFILLER_131_127 VDD VSS sg13g2_decap_8
X_13884__2388 _13884_/RESET_B VDD VSS sg13g2_tiehi
XFILLER_98_520 VDD VSS sg13g2_fill_1
XFILLER_98_531 VDD VSS sg13g2_fill_2
XFILLER_28_1436 VDD VSS sg13g2_decap_8
Xfanout717 _13138_/B1 _07727_/Y VDD VSS sg13g2_buf_1
X_09851_ _14438_/D _14438_/Q _10082_/A0 _09858_/S VDD VSS sg13g2_mux2_1
Xfanout728 _11183_/B1 _11056_/B1 VDD VSS sg13g2_buf_1
Xfanout739 _12294_/B1 _07683_/X VDD VSS sg13g2_buf_1
XFILLER_100_503 VDD VSS sg13g2_decap_8
XFILLER_115_1428 VDD VSS sg13g2_fill_2
X_08802_ _13685_/D _08802_/A _08802_/B VDD VSS sg13g2_nor2_1
XFILLER_86_737 VDD VSS sg13g2_decap_8
X_09782_ _14371_/D _09881_/A0 _14371_/Q _09800_/S VDD VSS sg13g2_mux2_1
XFILLER_22_1002 VDD VSS sg13g2_decap_8
XFILLER_6_1232 VDD VSS sg13g2_decap_8
X_08733_ _08733_/Y _07719_/A _11288_/A _15199_/Q VDD VSS sg13g2_o21ai_1
XFILLER_61_1084 VDD VSS sg13g2_decap_8
XFILLER_27_804 VDD VSS sg13g2_decap_8
XFILLER_96_1114 VDD VSS sg13g2_decap_8
XFILLER_66_472 VDD VSS sg13g2_decap_4
XFILLER_54_612 VDD VSS sg13g2_decap_8
XFILLER_113_1185 VDD VSS sg13g2_decap_8
X_08664_ _08664_/Y _08647_/Y _08678_/C _08698_/B VDD VSS sg13g2_a21oi_1
XFILLER_22_1079 VDD VSS sg13g2_decap_8
XFILLER_26_336 VDD VSS sg13g2_decap_8
XFILLER_54_656 VDD VSS sg13g2_decap_8
X_07615_ _07615_/Y _14945_/Q VDD VSS sg13g2_inv_1
XFILLER_148_1248 VDD VSS sg13g2_decap_8
X_08595_ _08596_/D _08110_/D _08592_/X _08590_/Y VDD VSS sg13g2_a21oi_1
XFILLER_82_987 VDD VSS sg13g2_decap_8
XFILLER_74_1401 VDD VSS sg13g2_decap_8
XFILLER_42_818 VDD VSS sg13g2_decap_8
XFILLER_148_1259 VDD VSS sg13g2_fill_2
XFILLER_14_35 VDD VSS sg13g2_decap_8
XFILLER_139_216 VDD VSS sg13g2_decap_4
XFILLER_179_385 VDD VSS sg13g2_decap_8
XFILLER_50_873 VDD VSS sg13g2_fill_1
XFILLER_22_575 VDD VSS sg13g2_decap_8
X_09216_ _13827_/D _10146_/A1 _13827_/Q _09238_/S VDD VSS sg13g2_mux2_1
XFILLER_139_249 VDD VSS sg13g2_fill_2
X_14441__1831 _14441_/RESET_B VDD VSS sg13g2_tiehi
XFILLER_154_219 VDD VSS sg13g2_decap_8
X_09147_ _09147_/Y _15247_/Q _09147_/B VDD VSS sg13g2_nand2b_1
XFILLER_182_539 VDD VSS sg13g2_decap_8
XFILLER_135_411 VDD VSS sg13g2_decap_8
XFILLER_68_1205 VDD VSS sg13g2_fill_2
XFILLER_163_742 VDD VSS sg13g2_fill_1
XFILLER_107_135 VDD VSS sg13g2_decap_8
XFILLER_120_1167 VDD VSS sg13g2_decap_8
XFILLER_163_764 VDD VSS sg13g2_decap_8
X_09078_ _09078_/Y _15237_/Q _09078_/B VDD VSS sg13g2_nand2b_1
XFILLER_30_56 VDD VSS sg13g2_decap_8
XFILLER_162_241 VDD VSS sg13g2_decap_8
XFILLER_159_1366 VDD VSS sg13g2_decap_8
XFILLER_2_903 VDD VSS sg13g2_decap_8
XFILLER_135_488 VDD VSS sg13g2_decap_4
X_08029_ _08029_/Y _08244_/B _08236_/S VDD VSS sg13g2_nor2_1
XFILLER_150_425 VDD VSS sg13g2_decap_8
XFILLER_104_820 VDD VSS sg13g2_decap_8
XFILLER_1_413 VDD VSS sg13g2_decap_8
X_13714__2558 _13714_/RESET_B VDD VSS sg13g2_tiehi
X_14474__1798 _14474_/RESET_B VDD VSS sg13g2_tiehi
X_11040_ _11042_/C _11040_/A _11052_/B VDD VSS sg13g2_nor2_1
XFILLER_115_190 VDD VSS sg13g2_fill_2
XFILLER_39_21 VDD VSS sg13g2_decap_8
XFILLER_104_864 VDD VSS sg13g2_decap_4
XFILLER_118_1052 VDD VSS sg13g2_decap_8
XFILLER_131_650 VDD VSS sg13g2_fill_2
XFILLER_77_715 VDD VSS sg13g2_decap_8
XFILLER_118_1063 VDD VSS sg13g2_fill_1
XFILLER_7_1029 VDD VSS sg13g2_decap_8
XFILLER_103_396 VDD VSS sg13g2_decap_8
XFILLER_76_258 VDD VSS sg13g2_decap_4
X_12991_ _12993_/C _14905_/Q _13682_/Q _12959_/X _12987_/Y _12990_/X VDD VSS sg13g2_a221oi_1
XFILLER_92_729 VDD VSS sg13g2_fill_1
XFILLER_57_450 VDD VSS sg13g2_decap_8
XFILLER_79_1323 VDD VSS sg13g2_decap_8
X_14730_ _14730_/Q clkload16/A _14730_/D _14730_/RESET_B VDD VSS sg13g2_dfrbpq_1
X_11942_ _11942_/Y _11948_/S _14192_/Q VDD VSS sg13g2_nand2b_1
XFILLER_79_1345 VDD VSS sg13g2_decap_4
XFILLER_29_185 VDD VSS sg13g2_fill_2
XFILLER_79_1356 VDD VSS sg13g2_fill_1
XFILLER_55_42 VDD VSS sg13g2_decap_8
XFILLER_17_336 VDD VSS sg13g2_decap_8
X_15185__2904 _15185_/RESET_B VDD VSS sg13g2_tiehi
XFILLER_44_133 VDD VSS sg13g2_decap_4
X_14661_ _14661_/Q _14725_/CLK _14661_/D _14661_/RESET_B VDD VSS sg13g2_dfrbpq_1
XFILLER_73_976 VDD VSS sg13g2_decap_8
XFILLER_169_0 VDD VSS sg13g2_decap_8
X_11873_ _11873_/Y _11869_/Y _11870_/Y _11872_/Y _11871_/Y _11875_/B VDD VSS sg13g2_a221oi_1
XFILLER_166_1348 VDD VSS sg13g2_decap_8
X_13612_ _13613_/D _15054_/Q _08831_/B _13508_/C VDD VSS sg13g2_o21ai_1
X_14978__2702 _14978_/RESET_B VDD VSS sg13g2_tiehi
X_10824_ _10824_/Y _10818_/B _10801_/Y _10823_/Y _10815_/Y _13279_/D VDD VSS sg13g2_a221oi_1
XFILLER_26_892 VDD VSS sg13g2_decap_8
X_14592_ _14592_/Q _14656_/CLK _14592_/D _14592_/RESET_B VDD VSS sg13g2_dfrbpq_1
XFILLER_77_1080 VDD VSS sg13g2_fill_2
XFILLER_60_659 VDD VSS sg13g2_decap_4
XFILLER_186_801 VDD VSS sg13g2_fill_1
XFILLER_25_391 VDD VSS sg13g2_decap_8
XFILLER_129_1181 VDD VSS sg13g2_decap_8
XFILLER_111_92 VDD VSS sg13g2_decap_8
XFILLER_13_553 VDD VSS sg13g2_decap_8
X_13543_ _13543_/Y _15146_/Q _13562_/S VDD VSS sg13g2_nor2_1
X_10755_ _10756_/A _13142_/A _11113_/B _11154_/B1 _10754_/X VDD VSS sg13g2_a22oi_1
XFILLER_185_322 VDD VSS sg13g2_decap_8
XFILLER_40_361 VDD VSS sg13g2_decap_8
XFILLER_38_1097 VDD VSS sg13g2_fill_2
XFILLER_125_1067 VDD VSS sg13g2_decap_8
XFILLER_9_546 VDD VSS sg13g2_decap_8
XFILLER_51_1220 VDD VSS sg13g2_decap_8
X_13474_ _15111_/D _15177_/D _15111_/Q _13480_/S VDD VSS sg13g2_mux2_1
X_10686_ _14898_/D _07705_/B _10827_/B _10685_/Y VDD VSS sg13g2_o21ai_1
XFILLER_139_761 VDD VSS sg13g2_fill_1
XFILLER_173_506 VDD VSS sg13g2_decap_8
XFILLER_12_1204 VDD VSS sg13g2_decap_8
XFILLER_145_208 VDD VSS sg13g2_decap_4
X_15213_ _15213_/Q clkload82/A _15213_/D _15213_/RESET_B VDD VSS sg13g2_dfrbpq_1
XFILLER_16_1384 VDD VSS sg13g2_decap_8
X_12425_ _12425_/X _14688_/Q _14720_/Q _13760_/Q _13792_/Q _12425_/S0 _12425_/S1 VDD
+ VSS sg13g2_mux4_1
XFILLER_185_399 VDD VSS sg13g2_decap_8
XFILLER_51_1297 VDD VSS sg13g2_fill_1
XFILLER_177_1422 VDD VSS sg13g2_fill_2
XFILLER_138_293 VDD VSS sg13g2_decap_8
XFILLER_177_1433 VDD VSS sg13g2_decap_8
X_15144_ _15144_/Q clkload78/A _15144_/D _15144_/RESET_B VDD VSS sg13g2_dfrbpq_1
XFILLER_127_978 VDD VSS sg13g2_fill_1
X_12356_ _12356_/Y _12386_/A _12356_/B VDD VSS sg13g2_nand2_1
XFILLER_86_1327 VDD VSS sg13g2_decap_8
XFILLER_154_764 VDD VSS sg13g2_decap_8
X_14855__2927 _14855_/RESET_B VDD VSS sg13g2_tiehi
XFILLER_127_989 VDD VSS sg13g2_decap_8
XFILLER_5_763 VDD VSS sg13g2_decap_8
XFILLER_58_7 VDD VSS sg13g2_decap_8
X_11307_ _11307_/Y _11328_/S0 _13725_/Q VDD VSS sg13g2_nand2b_1
X_15075_ _15075_/Q clkload87/A _15075_/D _15075_/RESET_B VDD VSS sg13g2_dfrbpq_1
XFILLER_113_116 VDD VSS sg13g2_decap_8
X_12287_ _12287_/X _14393_/Q _14425_/Q _14489_/Q _14521_/Q _12288_/S0 _12288_/S1 VDD
+ VSS sg13g2_mux4_1
XFILLER_4_273 VDD VSS sg13g2_decap_8
XFILLER_113_127 VDD VSS sg13g2_fill_2
X_14026_ _14026_/Q clkload16/A _14026_/D _14026_/RESET_B VDD VSS sg13g2_dfrbpq_1
X_14304__1968 _14304_/RESET_B VDD VSS sg13g2_tiehi
XFILLER_136_1130 VDD VSS sg13g2_decap_8
X_11238_ _11292_/A _12866_/A _15123_/Q VDD VSS sg13g2_nand2_1
XFILLER_45_1013 VDD VSS sg13g2_decap_8
XFILLER_122_650 VDD VSS sg13g2_decap_4
XFILLER_150_970 VDD VSS sg13g2_decap_8
XFILLER_95_501 VDD VSS sg13g2_decap_8
XFILLER_110_823 VDD VSS sg13g2_decap_8
XFILLER_122_683 VDD VSS sg13g2_decap_8
XFILLER_1_980 VDD VSS sg13g2_decap_8
XFILLER_110_834 VDD VSS sg13g2_fill_2
XFILLER_122_694 VDD VSS sg13g2_fill_2
X_11169_ _14953_/D _11168_/X _11167_/Y _11156_/Y VDD VSS sg13g2_o21ai_1
XFILLER_171_1076 VDD VSS sg13g2_fill_2
XFILLER_68_759 VDD VSS sg13g2_decap_8
XFILLER_49_940 VDD VSS sg13g2_decap_4
XFILLER_0_490 VDD VSS sg13g2_decap_8
XFILLER_67_247 VDD VSS sg13g2_decap_8
XFILLER_67_258 VDD VSS sg13g2_fill_2
XFILLER_48_450 VDD VSS sg13g2_decap_8
XFILLER_23_1344 VDD VSS sg13g2_decap_8
X_13869__2403 _13869_/RESET_B VDD VSS sg13g2_tiehi
XFILLER_97_1412 VDD VSS sg13g2_decap_8
X_14928_ _14928_/Q _15219_/CLK _14928_/D _14928_/RESET_B VDD VSS sg13g2_dfrbpq_1
XFILLER_3_1449 VDD VSS sg13g2_decap_8
XFILLER_184_1415 VDD VSS sg13g2_decap_8
XFILLER_64_976 VDD VSS sg13g2_decap_8
XFILLER_63_453 VDD VSS sg13g2_decap_8
X_14859_ _14859_/Q clkload67/A _14859_/D _14859_/RESET_B VDD VSS sg13g2_dfrbpq_1
XFILLER_1_1162 VDD VSS sg13g2_decap_8
XFILLER_36_689 VDD VSS sg13g2_decap_8
XFILLER_35_188 VDD VSS sg13g2_fill_1
X_08380_ _08380_/Y _08621_/A _08378_/Y _08379_/Y VDD VSS sg13g2_o21ai_1
XFILLER_108_1210 VDD VSS sg13g2_fill_1
XFILLER_50_136 VDD VSS sg13g2_decap_8
XFILLER_149_503 VDD VSS sg13g2_decap_8
X_14249__2023 _14249_/RESET_B VDD VSS sg13g2_tiehi
XFILLER_56_1164 VDD VSS sg13g2_decap_8
XFILLER_91_1066 VDD VSS sg13g2_fill_1
XFILLER_176_322 VDD VSS sg13g2_decap_8
XFILLER_52_1028 VDD VSS sg13g2_decap_8
XFILLER_149_558 VDD VSS sg13g2_decap_8
XFILLER_17_1159 VDD VSS sg13g2_decap_8
XFILLER_84_0 VDD VSS sg13g2_decap_8
XFILLER_104_1118 VDD VSS sg13g2_decap_8
XFILLER_143_1167 VDD VSS sg13g2_decap_4
X_09001_ _09001_/X _09006_/A _08998_/X _09000_/Y VDD VSS sg13g2_a21o_1
XFILLER_34_1473 VDD VSS sg13g2_decap_4
XFILLER_117_400 VDD VSS sg13g2_fill_2
XFILLER_176_399 VDD VSS sg13g2_decap_8
XFILLER_121_1465 VDD VSS sg13g2_decap_4
Xclkbuf_4_13_0_clk_i clkbuf_4_13_0_clk_i/X clkbuf_0_clk_i/X VDD VSS sg13g2_buf_8
XFILLER_145_753 VDD VSS sg13g2_decap_8
XFILLER_104_105 VDD VSS sg13g2_decap_8
XFILLER_105_639 VDD VSS sg13g2_decap_8
XFILLER_6_91 VDD VSS sg13g2_decap_8
XFILLER_28_1200 VDD VSS sg13g2_decap_8
XFILLER_160_767 VDD VSS sg13g2_decap_8
X_09903_ _14489_/D _09936_/A1 _14489_/Q _09903_/S VDD VSS sg13g2_mux2_1
Xfanout503 wire504/A _09473_/S VDD VSS sg13g2_buf_1
XFILLER_116_48 VDD VSS sg13g2_decap_4
XFILLER_154_1241 VDD VSS sg13g2_decap_8
XFILLER_8_1316 VDD VSS sg13g2_decap_8
XFILLER_119_1372 VDD VSS sg13g2_fill_2
Xfanout525 _09374_/S _09342_/Y VDD VSS sg13g2_buf_1
Xfanout536 _08938_/S _08956_/S VDD VSS sg13g2_buf_1
XFILLER_59_726 VDD VSS sg13g2_decap_8
Xfanout547 _13651_/S _13653_/S VDD VSS sg13g2_buf_1
X_09834_ _14422_/D _09933_/A1 _14422_/Q _09837_/S VDD VSS sg13g2_mux2_1
XFILLER_28_1277 VDD VSS sg13g2_decap_8
XFILLER_112_160 VDD VSS sg13g2_decap_8
XFILLER_112_171 VDD VSS sg13g2_fill_2
Xfanout558 _13535_/B _13520_/A1 VDD VSS sg13g2_buf_1
Xfanout569 _12791_/A2 _12624_/A2 VDD VSS sg13g2_buf_1
XFILLER_86_567 VDD VSS sg13g2_fill_1
X_09765_ _14355_/D _14355_/Q _09831_/A0 _09769_/S VDD VSS sg13g2_mux2_1
XFILLER_132_14 VDD VSS sg13g2_decap_8
XFILLER_27_601 VDD VSS sg13g2_decap_8
X_14459__1813 _14459_/RESET_B VDD VSS sg13g2_tiehi
X_08716_ _15211_/D _15190_/D _12346_/A _13654_/S VDD VSS sg13g2_mux2_1
XFILLER_41_1477 VDD VSS sg13g2_fill_2
XFILLER_132_58 VDD VSS sg13g2_fill_1
X_09696_ _14288_/D _10092_/A0 _14288_/Q _09698_/S VDD VSS sg13g2_mux2_1
XFILLER_132_69 VDD VSS sg13g2_decap_8
XFILLER_66_291 VDD VSS sg13g2_decap_8
XFILLER_54_431 VDD VSS sg13g2_decap_8
XFILLER_148_1012 VDD VSS sg13g2_decap_8
X_08647_ _08647_/Y _08576_/Y _08641_/Y _08646_/Y VDD VSS sg13g2_a21oi_1
XFILLER_162_7 VDD VSS sg13g2_decap_8
XFILLER_54_464 VDD VSS sg13g2_decap_8
XFILLER_81_250 VDD VSS sg13g2_decap_4
XFILLER_55_998 VDD VSS sg13g2_decap_8
XFILLER_54_475 VDD VSS sg13g2_fill_1
XFILLER_42_615 VDD VSS sg13g2_fill_2
XFILLER_82_795 VDD VSS sg13g2_decap_8
XFILLER_109_1018 VDD VSS sg13g2_decap_8
X_08578_ _08578_/Y _08577_/A _08576_/Y _08577_/Y VDD VSS sg13g2_a21oi_1
XFILLER_25_56 VDD VSS sg13g2_decap_8
XFILLER_39_1362 VDD VSS sg13g2_decap_8
XFILLER_74_1253 VDD VSS sg13g2_decap_4
XFILLER_35_1204 VDD VSS sg13g2_decap_8
XFILLER_126_1332 VDD VSS sg13g2_fill_2
XFILLER_161_1212 VDD VSS sg13g2_decap_8
XFILLER_165_1392 VDD VSS sg13g2_fill_1
XFILLER_168_856 VDD VSS sg13g2_fill_2
XFILLER_179_182 VDD VSS sg13g2_decap_8
XFILLER_70_1128 VDD VSS sg13g2_fill_1
XFILLER_167_333 VDD VSS sg13g2_decap_8
XFILLER_23_895 VDD VSS sg13g2_decap_8
X_10540_ _10540_/Y _10566_/D _10547_/D _10544_/C VDD VSS sg13g2_o21ai_1
XFILLER_168_878 VDD VSS sg13g2_decap_8
XFILLER_109_923 VDD VSS sg13g2_decap_8
XFILLER_10_567 VDD VSS sg13g2_decap_8
XFILLER_183_848 VDD VSS sg13g2_fill_1
X_10471_ _10492_/C _14845_/Q _10500_/A _10471_/C _10471_/D VDD VSS sg13g2_and4_1
XFILLER_182_336 VDD VSS sg13g2_decap_8
XFILLER_41_77 VDD VSS sg13g2_decap_8
X_12210_ _12217_/B _12219_/S _12210_/B VDD VSS sg13g2_nor2_1
XFILLER_157_77 VDD VSS sg13g2_decap_8
X_13190_ _13191_/C _13190_/A _13190_/B _13225_/B VDD VSS sg13g2_nand3_1
XFILLER_68_1024 VDD VSS sg13g2_fill_1
XFILLER_159_1152 VDD VSS sg13g2_fill_1
X_13947__2325 _13947_/RESET_B VDD VSS sg13g2_tiehi
XFILLER_163_572 VDD VSS sg13g2_decap_8
XFILLER_2_700 VDD VSS sg13g2_decap_8
XFILLER_124_937 VDD VSS sg13g2_decap_8
X_12141_ _12141_/X _12135_/X _12136_/X _12138_/X _12137_/X _11542_/B _12191_/B1 VDD
+ VSS sg13g2_mux4_1
XFILLER_29_1008 VDD VSS sg13g2_decap_8
XFILLER_11_1281 VDD VSS sg13g2_decap_8
XFILLER_159_1185 VDD VSS sg13g2_decap_4
XFILLER_155_1027 VDD VSS sg13g2_decap_8
XFILLER_1_210 VDD VSS sg13g2_decap_8
XFILLER_155_1038 VDD VSS sg13g2_fill_1
XFILLER_173_21 VDD VSS sg13g2_decap_8
XFILLER_123_458 VDD VSS sg13g2_fill_2
X_12072_ _12072_/X _13843_/Q _13875_/Q _13907_/Q _13939_/Q _12171_/S0 _12073_/S1 VDD
+ VSS sg13g2_mux4_1
XFILLER_151_789 VDD VSS sg13g2_fill_2
XFILLER_2_777 VDD VSS sg13g2_decap_8
XFILLER_46_1355 VDD VSS sg13g2_fill_2
X_11023_ _11023_/Y _11023_/A _11052_/A VDD VSS sg13g2_nor2_1
XFILLER_103_160 VDD VSS sg13g2_decap_4
XFILLER_150_299 VDD VSS sg13g2_decap_8
XFILLER_173_98 VDD VSS sg13g2_decap_8
XFILLER_1_287 VDD VSS sg13g2_decap_8
X_16880_ _16880_/X _16880_/A VDD VSS sg13g2_buf_1
XFILLER_77_534 VDD VSS sg13g2_decap_8
XFILLER_2_49 VDD VSS sg13g2_decap_8
XFILLER_133_1358 VDD VSS sg13g2_decap_8
XFILLER_65_718 VDD VSS sg13g2_decap_8
XFILLER_44_1090 VDD VSS sg13g2_decap_8
XFILLER_64_217 VDD VSS sg13g2_decap_8
XFILLER_131_1060 VDD VSS sg13g2_fill_2
X_12974_ _12975_/B _12957_/A _13683_/Q _12960_/Y VDD VSS sg13g2_a21oi_1
XFILLER_79_1142 VDD VSS sg13g2_decap_8
XFILLER_17_133 VDD VSS sg13g2_decap_8
XFILLER_73_751 VDD VSS sg13g2_decap_4
X_14713_ _14713_/Q _14745_/CLK _14713_/D _14713_/RESET_B VDD VSS sg13g2_dfrbpq_1
X_11925_ _11925_/X _13967_/Q _13999_/Q _14031_/Q _14063_/Q _11925_/S0 _11925_/S1 VDD
+ VSS sg13g2_mux4_1
Xclkbuf_leaf_1_clk_i clkload7/A clkbuf_leaf_5_clk_i/A VDD VSS sg13g2_buf_8
XFILLER_75_1017 VDD VSS sg13g2_decap_8
XFILLER_72_250 VDD VSS sg13g2_decap_8
XFILLER_166_1167 VDD VSS sg13g2_decap_8
XFILLER_178_609 VDD VSS sg13g2_decap_8
X_14644_ _14644_/Q _14982_/CLK _14644_/D _14644_/RESET_B VDD VSS sg13g2_dfrbpq_1
X_11856_ _11858_/B _12000_/A _11856_/B VDD VSS sg13g2_nor2_1
XFILLER_82_51 VDD VSS sg13g2_decap_8
XFILLER_61_957 VDD VSS sg13g2_decap_8
XFILLER_162_1009 VDD VSS sg13g2_decap_8
XFILLER_18_1402 VDD VSS sg13g2_decap_8
XFILLER_92_1331 VDD VSS sg13g2_fill_2
XFILLER_14_840 VDD VSS sg13g2_decap_8
XFILLER_177_119 VDD VSS sg13g2_decap_8
X_10807_ _10807_/Y _12346_/A _10807_/B _10807_/C VDD VSS sg13g2_nand3_1
XFILLER_60_467 VDD VSS sg13g2_decap_8
XFILLER_32_158 VDD VSS sg13g2_decap_8
X_14575_ _14575_/Q clkload12/A _14575_/D _14575_/RESET_B VDD VSS sg13g2_dfrbpq_1
XFILLER_92_1364 VDD VSS sg13g2_decap_8
XFILLER_13_350 VDD VSS sg13g2_decap_8
X_11787_ _11787_/X _14123_/Q _14155_/Q _14187_/Q _14219_/Q _11850_/S0 _07654_/A VDD
+ VSS sg13g2_mux4_1
XFILLER_92_1375 VDD VSS sg13g2_decap_8
XFILLER_144_1454 VDD VSS sg13g2_fill_1
X_14796__3010 _14796_/RESET_B VDD VSS sg13g2_tiehi
XFILLER_186_642 VDD VSS sg13g2_decap_8
XFILLER_158_344 VDD VSS sg13g2_decap_8
XFILLER_186_653 VDD VSS sg13g2_decap_8
XFILLER_159_878 VDD VSS sg13g2_fill_2
X_13526_ _13526_/Y _08621_/B _13533_/B _08276_/B _13546_/B2 VDD VSS sg13g2_a22oi_1
X_10738_ _14912_/D _09204_/C _11040_/A _10737_/Y VDD VSS sg13g2_o21ai_1
XFILLER_140_1318 VDD VSS sg13g2_decap_8
XFILLER_9_343 VDD VSS sg13g2_decap_8
XFILLER_12_1001 VDD VSS sg13g2_decap_8
XFILLER_173_314 VDD VSS sg13g2_fill_1
XFILLER_16_1181 VDD VSS sg13g2_decap_8
XFILLER_174_848 VDD VSS sg13g2_decap_4
X_13457_ _15105_/D _13449_/X _13456_/X _13446_/Y VDD VSS sg13g2_o21ai_1
X_10669_ _10807_/B _14926_/Q _08971_/X _10669_/S VDD VSS sg13g2_mux2_1
XFILLER_185_196 VDD VSS sg13g2_decap_8
XFILLER_103_1151 VDD VSS sg13g2_decap_8
X_12408_ _12408_/X _14559_/Q _14591_/Q _14623_/Q _14655_/Q _12411_/S0 _12411_/S1 VDD
+ VSS sg13g2_mux4_1
XFILLER_51_1094 VDD VSS sg13g2_fill_2
X_13388_ _13391_/C _15127_/Q _13507_/B VDD VSS sg13g2_nand2_1
XFILLER_103_1184 VDD VSS sg13g2_decap_4
Xoutput106 mem_axi_wdata[11] _15143_/Q VDD VSS sg13g2_buf_1
XFILLER_86_1124 VDD VSS sg13g2_decap_8
XFILLER_103_1195 VDD VSS sg13g2_fill_1
XFILLER_12_1078 VDD VSS sg13g2_decap_8
XFILLER_142_712 VDD VSS sg13g2_decap_4
XFILLER_115_937 VDD VSS sg13g2_decap_8
X_14537__1735 _14537_/RESET_B VDD VSS sg13g2_tiehi
Xoutput117 mem_axi_wdata[21] _15153_/Q VDD VSS sg13g2_buf_1
XFILLER_5_560 VDD VSS sg13g2_decap_8
X_15127_ _15127_/Q clkload84/A _15127_/D _15127_/RESET_B VDD VSS sg13g2_dfrbpq_1
Xoutput128 mem_axi_wdata[31] _15163_/Q VDD VSS sg13g2_buf_1
X_12339_ _12340_/A _11868_/A _12338_/Y _12298_/B VDD VSS sg13g2_o21ai_1
XFILLER_47_1108 VDD VSS sg13g2_fill_2
XFILLER_142_734 VDD VSS sg13g2_decap_8
Xoutput139 mem_axi_wstrb[3] _15167_/Q VDD VSS sg13g2_buf_1
XFILLER_114_436 VDD VSS sg13g2_decap_8
XFILLER_138_1247 VDD VSS sg13g2_decap_8
X_15105__2844 _15105_/RESET_B VDD VSS sg13g2_tiehi
X_15058_ _15058_/Q clkload84/A _15058_/D _15058_/RESET_B VDD VSS sg13g2_dfrbpq_1
XFILLER_87_309 VDD VSS sg13g2_fill_2
XFILLER_141_266 VDD VSS sg13g2_decap_8
X_14009_ _14009_/Q clkload34/A _14009_/D _14009_/RESET_B VDD VSS sg13g2_dfrbpq_1
XFILLER_25_1406 VDD VSS sg13g2_decap_8
XFILLER_110_620 VDD VSS sg13g2_fill_1
XFILLER_151_1425 VDD VSS sg13g2_decap_8
X_07880_ _08090_/B _07884_/A _08063_/B VDD VSS sg13g2_nor2_1
XFILLER_110_653 VDD VSS sg13g2_decap_8
XFILLER_110_664 VDD VSS sg13g2_fill_1
XFILLER_96_898 VDD VSS sg13g2_decap_8
XFILLER_23_1141 VDD VSS sg13g2_decap_8
XFILLER_95_386 VDD VSS sg13g2_decap_8
X_09550_ _14148_/D _09616_/A0 _14148_/Q _09567_/S VDD VSS sg13g2_mux2_1
XFILLER_7_1393 VDD VSS sg13g2_decap_8
XFILLER_3_1246 VDD VSS sg13g2_decap_8
XFILLER_110_1133 VDD VSS sg13g2_decap_8
XFILLER_110_1144 VDD VSS sg13g2_fill_1
X_08501_ _15238_/D _08501_/A _08501_/B _08501_/C _08501_/D VDD VSS sg13g2_nand4_1
X_14181__2091 _14181_/RESET_B VDD VSS sg13g2_tiehi
X_09481_ _14081_/D _10077_/A0 _14081_/Q _09501_/S VDD VSS sg13g2_mux2_1
XFILLER_97_1275 VDD VSS sg13g2_decap_8
XFILLER_63_250 VDD VSS sg13g2_decap_8
XFILLER_91_570 VDD VSS sg13g2_decap_8
XFILLER_149_1365 VDD VSS sg13g2_decap_8
X_08432_ _08432_/Y _07799_/X _08001_/A _08238_/B VDD VSS sg13g2_o21ai_1
XFILLER_24_648 VDD VSS sg13g2_decap_8
XFILLER_23_147 VDD VSS sg13g2_decap_8
XFILLER_168_119 VDD VSS sg13g2_decap_8
XFILLER_71_1404 VDD VSS sg13g2_decap_4
X_08363_ _08363_/X _08207_/X _08362_/X _08452_/A _08279_/A _08452_/C _08599_/B VDD
+ VSS sg13g2_mux4_1
X_08294_ _08294_/Y _08318_/D _08286_/Y _07777_/Y VDD VSS sg13g2_o21ai_1
XFILLER_20_854 VDD VSS sg13g2_decap_8
XFILLER_177_697 VDD VSS sg13g2_decap_8
XFILLER_118_720 VDD VSS sg13g2_decap_8
XFILLER_149_399 VDD VSS sg13g2_fill_1
XFILLER_176_196 VDD VSS sg13g2_decap_8
XFILLER_30_1123 VDD VSS sg13g2_decap_8
XFILLER_11_14 VDD VSS sg13g2_decap_8
XFILLER_69_1311 VDD VSS sg13g2_decap_4
XFILLER_30_1134 VDD VSS sg13g2_fill_1
XFILLER_117_241 VDD VSS sg13g2_fill_1
XFILLER_145_550 VDD VSS sg13g2_decap_8
XFILLER_69_1333 VDD VSS sg13g2_decap_8
XFILLER_30_1156 VDD VSS sg13g2_decap_8
XFILLER_127_14 VDD VSS sg13g2_decap_8
XFILLER_106_937 VDD VSS sg13g2_decap_8
XFILLER_173_881 VDD VSS sg13g2_decap_8
XFILLER_118_797 VDD VSS sg13g2_fill_1
XFILLER_105_436 VDD VSS sg13g2_decap_8
XFILLER_172_380 VDD VSS sg13g2_decap_8
XFILLER_132_222 VDD VSS sg13g2_decap_8
XFILLER_69_1388 VDD VSS sg13g2_decap_4
XFILLER_133_778 VDD VSS sg13g2_decap_8
XFILLER_160_564 VDD VSS sg13g2_decap_8
Xfanout300 _09437_/S _09440_/S VDD VSS sg13g2_buf_1
Xfanout311 _09912_/A1 _09613_/A0 VDD VSS sg13g2_buf_1
XFILLER_59_501 VDD VSS sg13g2_decap_8
XFILLER_132_277 VDD VSS sg13g2_decap_8
Xfanout1309 _12048_/A1 fanout1314/X VDD VSS sg13g2_buf_1
XFILLER_8_1113 VDD VSS sg13g2_decap_8
X_14391__1881 _14391_/RESET_B VDD VSS sg13g2_tiehi
XFILLER_99_692 VDD VSS sg13g2_decap_8
XFILLER_87_832 VDD VSS sg13g2_fill_2
XFILLER_115_1022 VDD VSS sg13g2_decap_8
XFILLER_154_1071 VDD VSS sg13g2_fill_1
Xfanout344 _09970_/S wire348/X VDD VSS sg13g2_buf_1
XFILLER_28_1074 VDD VSS sg13g2_decap_8
Xfanout366 _09769_/S _09770_/S VDD VSS sg13g2_buf_1
XFILLER_101_664 VDD VSS sg13g2_fill_1
Xfanout377 _09704_/S _09703_/S VDD VSS sg13g2_buf_1
X_09817_ _14405_/D _09883_/A0 _14405_/Q _09830_/S VDD VSS sg13g2_mux2_1
Xfanout388 _09478_/S _09474_/X VDD VSS sg13g2_buf_1
XFILLER_98_1006 VDD VSS sg13g2_decap_8
XFILLER_59_578 VDD VSS sg13g2_fill_2
XFILLER_115_1077 VDD VSS sg13g2_decap_8
Xfanout399 _09304_/S fanout402/X VDD VSS sg13g2_buf_1
XFILLER_46_206 VDD VSS sg13g2_decap_8
XFILLER_28_910 VDD VSS sg13g2_decap_8
X_09748_ _14338_/D _14338_/Q _09913_/A1 _09769_/S VDD VSS sg13g2_mux2_1
XFILLER_27_442 VDD VSS sg13g2_decap_8
X_14011__2261 _14011_/RESET_B VDD VSS sg13g2_tiehi
X_09679_ _14271_/D _10142_/A1 _14271_/Q _09706_/S VDD VSS sg13g2_mux2_1
XFILLER_36_77 VDD VSS sg13g2_decap_4
X_11710_ _11710_/X _13833_/Q _13865_/Q _13897_/Q _13929_/Q _11713_/S0 _11713_/S1 VDD
+ VSS sg13g2_mux4_1
XFILLER_15_637 VDD VSS sg13g2_decap_8
X_12690_ _12690_/X _12685_/X _12689_/X _12684_/X _12688_/X _12776_/S _12690_/S1 VDD
+ VSS sg13g2_mux4_1
XFILLER_14_147 VDD VSS sg13g2_decap_8
X_14615__1657 _14615_/RESET_B VDD VSS sg13g2_tiehi
X_11641_ _11643_/B _11506_/B _11776_/A _11774_/A VDD VSS sg13g2_a21o_1
XFILLER_70_776 VDD VSS sg13g2_decap_8
XFILLER_30_618 VDD VSS sg13g2_decap_8
XFILLER_39_1192 VDD VSS sg13g2_fill_2
XFILLER_168_21 VDD VSS sg13g2_decap_8
XFILLER_168_642 VDD VSS sg13g2_decap_8
X_14360_ _14360_/Q _14664_/CLK _14360_/D _14360_/RESET_B VDD VSS sg13g2_dfrbpq_1
X_11572_ _11572_/X _11572_/A _11638_/C VDD VSS sg13g2_xor2_1
XFILLER_11_854 VDD VSS sg13g2_decap_8
XFILLER_128_506 VDD VSS sg13g2_decap_8
X_14923__2791 _14923_/RESET_B VDD VSS sg13g2_tiehi
X_13311_ _15060_/D _08992_/A _13308_/Y _07987_/Y _13310_/Y _13266_/A VDD VSS sg13g2_a221oi_1
XFILLER_35_1078 VDD VSS sg13g2_decap_8
Xinput19 input19/X input19/A VDD VSS sg13g2_buf_1
X_10523_ _10567_/A _10558_/C _14856_/Q _14855_/Q VDD VSS sg13g2_nand3_1
XFILLER_122_1048 VDD VSS sg13g2_fill_2
XFILLER_155_325 VDD VSS sg13g2_decap_8
X_14291_ _14291_/Q clkload39/A _14291_/D _14291_/RESET_B VDD VSS sg13g2_dfrbpq_1
XFILLER_10_364 VDD VSS sg13g2_decap_8
XFILLER_122_1059 VDD VSS sg13g2_decap_8
XFILLER_155_336 VDD VSS sg13g2_fill_1
XFILLER_7_847 VDD VSS sg13g2_decap_8
XFILLER_167_196 VDD VSS sg13g2_decap_8
XFILLER_168_98 VDD VSS sg13g2_decap_8
XFILLER_52_1392 VDD VSS sg13g2_fill_2
XFILLER_182_133 VDD VSS sg13g2_decap_8
XFILLER_183_656 VDD VSS sg13g2_decap_8
X_13242_ _13247_/A _13242_/A _13242_/B VDD VSS sg13g2_nand2_1
XFILLER_13_1365 VDD VSS sg13g2_decap_8
XFILLER_155_369 VDD VSS sg13g2_decap_8
X_10454_ _14840_/D _14840_/Q _10450_/C _10452_/Y VDD VSS sg13g2_a21oi_1
XFILLER_6_357 VDD VSS sg13g2_decap_8
XFILLER_109_775 VDD VSS sg13g2_decap_8
XFILLER_171_829 VDD VSS sg13g2_decap_4
XFILLER_108_263 VDD VSS sg13g2_decap_8
XFILLER_184_42 VDD VSS sg13g2_decap_8
XFILLER_174_1414 VDD VSS sg13g2_decap_8
X_13173_ _13176_/B _13066_/A _13066_/C _13172_/X VDD VSS sg13g2_o21ai_1
XFILLER_123_211 VDD VSS sg13g2_decap_4
X_10385_ _10386_/C _14818_/Q _14819_/Q _10391_/C _10396_/C VDD VSS sg13g2_and4_1
X_12124_ _12125_/B _12086_/X _12124_/A2 _12123_/Y VDD VSS sg13g2_a21oi_1
XFILLER_112_929 VDD VSS sg13g2_fill_2
XFILLER_174_1469 VDD VSS sg13g2_fill_1
XFILLER_2_574 VDD VSS sg13g2_decap_8
XFILLER_123_299 VDD VSS sg13g2_decap_4
X_12055_ _12056_/C _12055_/A _12055_/B _12055_/C _12055_/D VDD VSS sg13g2_nor4_1
XFILLER_96_128 VDD VSS sg13g2_decap_8
XFILLER_81_1043 VDD VSS sg13g2_fill_1
XFILLER_78_832 VDD VSS sg13g2_fill_1
XFILLER_89_191 VDD VSS sg13g2_decap_8
X_11006_ _11012_/C _10893_/A _10893_/B _11005_/X VDD VSS sg13g2_a21oi_1
XFILLER_77_84 VDD VSS sg13g2_decap_8
X_16863_ _16863_/X _16863_/A VDD VSS sg13g2_buf_1
XFILLER_77_375 VDD VSS sg13g2_decap_8
XFILLER_65_526 VDD VSS sg13g2_fill_2
XFILLER_168_1218 VDD VSS sg13g2_decap_8
XFILLER_18_420 VDD VSS sg13g2_decap_8
XFILLER_111_1442 VDD VSS sg13g2_fill_2
XFILLER_93_879 VDD VSS sg13g2_decap_4
XFILLER_0_1408 VDD VSS sg13g2_decap_8
XFILLER_20_1336 VDD VSS sg13g2_decap_8
X_12957_ _12988_/C _12957_/A _13683_/Q VDD VSS sg13g2_xnor2_1
XFILLER_34_924 VDD VSS sg13g2_fill_2
XFILLER_46_784 VDD VSS sg13g2_decap_4
XFILLER_18_497 VDD VSS sg13g2_decap_8
XFILLER_61_732 VDD VSS sg13g2_decap_4
XFILLER_34_946 VDD VSS sg13g2_decap_8
X_11908_ _11908_/Y _11843_/A _13675_/Q _13674_/Q _11865_/A VDD VSS sg13g2_a22oi_1
XFILLER_94_1459 VDD VSS sg13g2_decap_8
XFILLER_178_406 VDD VSS sg13g2_decap_8
X_12888_ _15026_/D _12878_/Y _12887_/Y _13211_/A VDD VSS sg13g2_a21oi_1
X_14627_ _14627_/Q _14729_/CLK _14627_/D _14627_/RESET_B VDD VSS sg13g2_dfrbpq_1
XFILLER_53_1101 VDD VSS sg13g2_decap_8
X_11839_ _14974_/D _11839_/A _11839_/B VDD VSS sg13g2_nor2_1
XFILLER_109_1382 VDD VSS sg13g2_decap_8
XFILLER_53_1145 VDD VSS sg13g2_fill_1
XFILLER_147_815 VDD VSS sg13g2_decap_8
XFILLER_18_1276 VDD VSS sg13g2_decap_8
X_14558_ _14558_/Q clkload49/A _14558_/D _14558_/RESET_B VDD VSS sg13g2_dfrbpq_1
XFILLER_105_1235 VDD VSS sg13g2_decap_8
XFILLER_9_140 VDD VSS sg13g2_decap_8
X_13509_ _15132_/D _15132_/Q _13518_/A1 _13519_/B VDD VSS sg13g2_mux2_1
XFILLER_70_1470 VDD VSS sg13g2_decap_4
XFILLER_174_645 VDD VSS sg13g2_fill_2
X_14489_ _14489_/Q clkload36/A _14489_/D _14489_/RESET_B VDD VSS sg13g2_dfrbpq_1
XFILLER_88_1219 VDD VSS sg13g2_decap_8
XFILLER_173_133 VDD VSS sg13g2_decap_8
XFILLER_134_509 VDD VSS sg13g2_decap_8
XFILLER_146_369 VDD VSS sg13g2_decap_8
XFILLER_179_1358 VDD VSS sg13g2_decap_8
XFILLER_162_829 VDD VSS sg13g2_decap_8
XFILLER_115_701 VDD VSS sg13g2_decap_8
XFILLER_31_1476 VDD VSS sg13g2_fill_2
XFILLER_161_328 VDD VSS sg13g2_fill_2
X_14053__2219 _14053_/RESET_B VDD VSS sg13g2_tiehi
XFILLER_177_1071 VDD VSS sg13g2_decap_8
X_14199__2073 _14199_/RESET_B VDD VSS sg13g2_tiehi
XFILLER_138_1044 VDD VSS sg13g2_fill_1
XFILLER_103_918 VDD VSS sg13g2_decap_8
XFILLER_47_0 VDD VSS sg13g2_decap_8
X_08981_ _08981_/Y _10681_/A _10674_/A _09024_/A VDD VSS sg13g2_o21ai_1
XFILLER_9_1400 VDD VSS sg13g2_decap_8
XFILLER_103_929 VDD VSS sg13g2_decap_4
XFILLER_114_266 VDD VSS sg13g2_decap_4
XFILLER_142_597 VDD VSS sg13g2_decap_8
X_07932_ _07932_/Y _08286_/A _08286_/B VDD VSS sg13g2_nor2_1
XFILLER_25_1203 VDD VSS sg13g2_decap_8
Xclkbuf_leaf_102_clk_i _14685_/CLK clkload3/A VDD VSS sg13g2_buf_8
XFILLER_69_843 VDD VSS sg13g2_decap_8
XFILLER_3_70 VDD VSS sg13g2_decap_8
X_07863_ _08641_/D _08608_/A _08608_/B VDD VSS sg13g2_or2_1
XFILLER_69_887 VDD VSS sg13g2_decap_8
XFILLER_116_1386 VDD VSS sg13g2_decap_4
XFILLER_151_1266 VDD VSS sg13g2_decap_8
XFILLER_96_684 VDD VSS sg13g2_decap_8
XFILLER_110_472 VDD VSS sg13g2_decap_8
XFILLER_112_1239 VDD VSS sg13g2_decap_4
X_09602_ _14199_/D _14199_/Q _10099_/A0 _09604_/S VDD VSS sg13g2_mux2_1
XFILLER_84_846 VDD VSS sg13g2_fill_1
XFILLER_83_323 VDD VSS sg13g2_decap_8
XFILLER_99_1359 VDD VSS sg13g2_decap_8
X_07794_ _08414_/C _08383_/A _08383_/B VDD VSS sg13g2_xnor2_1
XFILLER_7_1190 VDD VSS sg13g2_decap_8
XFILLER_56_559 VDD VSS sg13g2_fill_1
XFILLER_3_1043 VDD VSS sg13g2_decap_8
Xclkbuf_leaf_117_clk_i clkload55/A clkbuf_leaf_18_clk_i/A VDD VSS sg13g2_buf_8
X_09533_ _14132_/D _09997_/A0 _14132_/Q _09537_/S VDD VSS sg13g2_mux2_1
XFILLER_71_507 VDD VSS sg13g2_decap_8
XFILLER_37_762 VDD VSS sg13g2_decap_8
XFILLER_25_913 VDD VSS sg13g2_decap_8
XFILLER_36_261 VDD VSS sg13g2_decap_8
XFILLER_149_1140 VDD VSS sg13g2_fill_2
X_09464_ _14065_/D _09596_/A1 _14065_/Q wire504/X VDD VSS sg13g2_mux2_1
X_08415_ _08417_/B _08415_/A _08415_/B VDD VSS sg13g2_nand2_1
XFILLER_40_916 VDD VSS sg13g2_decap_8
XFILLER_51_253 VDD VSS sg13g2_decap_8
XFILLER_145_1048 VDD VSS sg13g2_fill_2
X_09395_ _13998_/D _10024_/A0 _13998_/Q _09395_/S VDD VSS sg13g2_mux2_1
XFILLER_75_1370 VDD VSS sg13g2_decap_8
XFILLER_52_787 VDD VSS sg13g2_decap_8
XFILLER_36_1332 VDD VSS sg13g2_decap_8
XFILLER_162_1340 VDD VSS sg13g2_decap_8
XFILLER_127_1460 VDD VSS sg13g2_fill_2
XFILLER_127_1471 VDD VSS sg13g2_decap_4
XFILLER_178_962 VDD VSS sg13g2_decap_4
X_08346_ _08346_/Y _08346_/A _08346_/B _08346_/C VDD VSS sg13g2_nand3_1
XFILLER_20_640 VDD VSS sg13g2_decap_8
XFILLER_36_1376 VDD VSS sg13g2_decap_4
XFILLER_138_826 VDD VSS sg13g2_decap_8
XFILLER_32_1218 VDD VSS sg13g2_fill_1
XFILLER_162_1395 VDD VSS sg13g2_fill_1
XFILLER_32_1229 VDD VSS sg13g2_decap_4
XFILLER_177_483 VDD VSS sg13g2_decap_8
XFILLER_22_35 VDD VSS sg13g2_decap_8
X_08277_ _08277_/Y _08318_/D _08037_/C _08404_/B1 _08276_/X _08275_/Y VDD VSS sg13g2_a221oi_1
XFILLER_125_7 VDD VSS sg13g2_decap_8
XFILLER_137_336 VDD VSS sg13g2_fill_2
XFILLER_20_684 VDD VSS sg13g2_fill_1
XFILLER_165_678 VDD VSS sg13g2_decap_8
XFILLER_138_79 VDD VSS sg13g2_fill_2
XFILLER_98_28 VDD VSS sg13g2_decap_8
XFILLER_152_328 VDD VSS sg13g2_fill_2
XFILLER_156_1100 VDD VSS sg13g2_decap_8
XFILLER_180_637 VDD VSS sg13g2_decap_8
XFILLER_133_520 VDD VSS sg13g2_decap_8
XFILLER_105_233 VDD VSS sg13g2_decap_8
X_14029__2243 _14029_/RESET_B VDD VSS sg13g2_tiehi
XFILLER_117_1106 VDD VSS sg13g2_decap_8
X_10170_ _10185_/A _13613_/B _14748_/Q _13508_/C VDD VSS sg13g2_nand3_1
XFILLER_156_1177 VDD VSS sg13g2_fill_1
XFILLER_120_214 VDD VSS sg13g2_decap_8
XFILLER_156_1188 VDD VSS sg13g2_fill_2
Xfanout1106 _07911_/A _14993_/Q VDD VSS sg13g2_buf_1
Xfanout1117 _08142_/B _14992_/Q VDD VSS sg13g2_buf_1
Xfanout1128 _07627_/A _08278_/S1 VDD VSS sg13g2_buf_1
XFILLER_82_1374 VDD VSS sg13g2_decap_8
Xfanout1139 _08598_/S0 fanout1144/X VDD VSS sg13g2_buf_1
Xfanout152 fanout152/X _09159_/Y VDD VSS sg13g2_buf_1
Xfanout163 _10165_/A1 _09634_/A0 VDD VSS sg13g2_buf_1
XFILLER_130_1306 VDD VSS sg13g2_decap_8
Xfanout174 _09997_/A0 _10096_/A0 VDD VSS sg13g2_buf_1
XFILLER_47_504 VDD VSS sg13g2_fill_1
XFILLER_47_21 VDD VSS sg13g2_decap_8
XFILLER_43_1358 VDD VSS sg13g2_fill_2
Xfanout185 _10128_/A0 _09929_/A1 VDD VSS sg13g2_buf_1
XFILLER_87_684 VDD VSS sg13g2_decap_4
XFILLER_47_32 VDD VSS sg13g2_fill_2
XFILLER_19_217 VDD VSS sg13g2_decap_8
XFILLER_75_835 VDD VSS sg13g2_decap_8
Xfanout196 _09926_/A1 _09462_/A0 VDD VSS sg13g2_buf_1
XFILLER_59_397 VDD VSS sg13g2_decap_8
X_13860_ _13860_/Q _14744_/CLK _13860_/D _13860_/RESET_B VDD VSS sg13g2_dfrbpq_1
X_13897__2375 _13897_/RESET_B VDD VSS sg13g2_tiehi
XFILLER_170_77 VDD VSS sg13g2_decap_8
X_12811_ _12812_/B _12878_/D _15123_/Q _12805_/Y _07683_/A _12810_/Y VDD VSS sg13g2_a221oi_1
XFILLER_16_924 VDD VSS sg13g2_decap_8
X_13791_ _13791_/Q clkload20/A _13791_/D _13791_/RESET_B VDD VSS sg13g2_dfrbpq_1
XFILLER_43_732 VDD VSS sg13g2_decap_8
XFILLER_15_434 VDD VSS sg13g2_decap_8
XFILLER_167_1262 VDD VSS sg13g2_decap_8
X_12742_ _12742_/X _14135_/Q _14167_/Q _14199_/Q _14231_/Q _12742_/S0 _12756_/S1 VDD
+ VSS sg13g2_mux4_1
XFILLER_128_1235 VDD VSS sg13g2_decap_8
XFILLER_163_1115 VDD VSS sg13g2_decap_8
XFILLER_151_0 VDD VSS sg13g2_decap_8
XFILLER_163_1126 VDD VSS sg13g2_fill_2
Xclkbuf_leaf_81_clk_i clkload72/A clkbuf_leaf_81_clk_i/A VDD VSS sg13g2_buf_8
XFILLER_70_551 VDD VSS sg13g2_decap_8
XFILLER_37_1129 VDD VSS sg13g2_decap_8
XFILLER_179_42 VDD VSS sg13g2_decap_8
X_12673_ _12673_/X _13746_/Q _14098_/Q _14450_/Q _14546_/Q _12675_/S0 _12675_/S1 VDD
+ VSS sg13g2_mux4_1
XFILLER_76_1189 VDD VSS sg13g2_decap_8
X_15130__2790 _15130_/RESET_B VDD VSS sg13g2_tiehi
XFILLER_63_97 VDD VSS sg13g2_decap_8
XFILLER_169_951 VDD VSS sg13g2_fill_1
XFILLER_180_1440 VDD VSS sg13g2_decap_8
XFILLER_42_286 VDD VSS sg13g2_decap_8
X_14412_ _14412_/Q clkload51/A _14412_/D _14412_/RESET_B VDD VSS sg13g2_dfrbpq_1
X_11624_ _11625_/B _11613_/Y _11615_/X _12000_/A VDD VSS sg13g2_o21ai_1
XFILLER_42_297 VDD VSS sg13g2_fill_1
XFILLER_156_601 VDD VSS sg13g2_decap_8
XFILLER_11_651 VDD VSS sg13g2_decap_8
XFILLER_15_1438 VDD VSS sg13g2_decap_8
XFILLER_102_1408 VDD VSS sg13g2_decap_8
X_14343_ _14343_/Q _14610_/CLK _14343_/D _14343_/RESET_B VDD VSS sg13g2_dfrbpq_1
X_11555_ _11555_/X _14692_/Q _14724_/Q _13764_/Q _13796_/Q _12245_/S0 _12245_/S1 VDD
+ VSS sg13g2_mux4_1
XFILLER_156_645 VDD VSS sg13g2_fill_1
XFILLER_183_420 VDD VSS sg13g2_decap_8
XFILLER_10_161 VDD VSS sg13g2_decap_8
Xclkbuf_leaf_96_clk_i clkload62/A clkload4/A VDD VSS sg13g2_buf_8
XFILLER_128_347 VDD VSS sg13g2_decap_8
XFILLER_155_133 VDD VSS sg13g2_fill_2
XFILLER_7_644 VDD VSS sg13g2_decap_8
X_10506_ _10575_/C _10538_/A _10654_/A VDD VSS sg13g2_nor2_1
XFILLER_156_678 VDD VSS sg13g2_fill_2
X_14274_ _14274_/Q clkload40/A _14274_/D _14274_/RESET_B VDD VSS sg13g2_dfrbpq_1
XFILLER_13_1162 VDD VSS sg13g2_decap_8
X_11486_ _11486_/X _13826_/Q _13858_/Q _13890_/Q _13922_/Q _11493_/S0 _11493_/S1 VDD
+ VSS sg13g2_mux4_1
XFILLER_137_870 VDD VSS sg13g2_decap_8
XFILLER_6_154 VDD VSS sg13g2_decap_8
XFILLER_137_881 VDD VSS sg13g2_fill_2
XFILLER_183_497 VDD VSS sg13g2_decap_8
X_13225_ _13225_/X _13225_/A _13225_/B _13226_/B VDD VSS sg13g2_and3_1
XFILLER_109_594 VDD VSS sg13g2_fill_2
XFILLER_155_199 VDD VSS sg13g2_decap_8
X_10437_ _14835_/D _14835_/Q _10443_/D _10436_/Y VDD VSS sg13g2_a21oi_1
XFILLER_124_531 VDD VSS sg13g2_decap_4
XFILLER_139_1331 VDD VSS sg13g2_decap_8
XFILLER_152_840 VDD VSS sg13g2_decap_8
XFILLER_152_851 VDD VSS sg13g2_fill_2
XFILLER_170_147 VDD VSS sg13g2_decap_4
XFILLER_174_1222 VDD VSS sg13g2_decap_8
XFILLER_48_1225 VDD VSS sg13g2_decap_8
XFILLER_128_90 VDD VSS sg13g2_decap_8
X_13156_ _13174_/B _14917_/Q _13670_/Q VDD VSS sg13g2_nor2_1
XFILLER_48_1247 VDD VSS sg13g2_decap_8
XFILLER_40_7 VDD VSS sg13g2_decap_8
X_10368_ _10391_/C wire220/X _10397_/B _10395_/A _10400_/C VDD VSS sg13g2_nor4_1
XFILLER_3_861 VDD VSS sg13g2_decap_8
XFILLER_151_372 VDD VSS sg13g2_decap_8
X_12107_ _12108_/A _14260_/Q _14292_/Q _14324_/Q _14356_/Q _12330_/S0 _12307_/C VDD
+ VSS sg13g2_mux4_1
XFILLER_69_128 VDD VSS sg13g2_decap_8
XFILLER_2_371 VDD VSS sg13g2_decap_8
X_13087_ _15038_/D _13127_/A _13087_/B VDD VSS sg13g2_nor2_1
X_10299_ _10299_/Y _10299_/A _10299_/B _10299_/C VDD VSS sg13g2_nor3_1
XFILLER_61_1425 VDD VSS sg13g2_decap_8
X_12038_ _12038_/Y _12040_/A1 _14162_/Q _12038_/B1 VDD VSS sg13g2_a21oi_1
XFILLER_78_662 VDD VSS sg13g2_decap_8
XFILLER_120_781 VDD VSS sg13g2_fill_1
Xclkbuf_leaf_34_clk_i _14745_/CLK clkbuf_leaf_39_clk_i/A VDD VSS sg13g2_buf_8
XFILLER_65_301 VDD VSS sg13g2_decap_8
XFILLER_38_526 VDD VSS sg13g2_decap_8
XFILLER_66_857 VDD VSS sg13g2_decap_8
XFILLER_4_1330 VDD VSS sg13g2_decap_8
X_13727__2545 _13727_/RESET_B VDD VSS sg13g2_tiehi
X_14487__1785 _14487_/RESET_B VDD VSS sg13g2_tiehi
XFILLER_20_1133 VDD VSS sg13g2_decap_8
XFILLER_0_1205 VDD VSS sg13g2_decap_8
XFILLER_111_1261 VDD VSS sg13g2_decap_4
XFILLER_81_838 VDD VSS sg13g2_fill_2
XFILLER_59_1321 VDD VSS sg13g2_decap_4
X_13989_ _13989_/Q _14725_/CLK _13989_/D _13989_/RESET_B VDD VSS sg13g2_dfrbpq_1
XFILLER_59_1332 VDD VSS sg13g2_decap_8
XFILLER_46_581 VDD VSS sg13g2_decap_8
XFILLER_185_1351 VDD VSS sg13g2_decap_8
XFILLER_146_1313 VDD VSS sg13g2_decap_8
XFILLER_18_294 VDD VSS sg13g2_decap_8
XFILLER_94_1245 VDD VSS sg13g2_fill_1
XFILLER_181_1204 VDD VSS sg13g2_decap_8
Xclkbuf_leaf_49_clk_i clkload41/A clkbuf_leaf_51_clk_i/A VDD VSS sg13g2_buf_8
XFILLER_178_203 VDD VSS sg13g2_decap_8
XFILLER_61_562 VDD VSS sg13g2_fill_1
XFILLER_146_1357 VDD VSS sg13g2_fill_1
XFILLER_33_264 VDD VSS sg13g2_fill_2
XFILLER_181_1248 VDD VSS sg13g2_decap_8
XFILLER_15_990 VDD VSS sg13g2_decap_8
X_14107__2165 _14107_/RESET_B VDD VSS sg13g2_tiehi
X_08200_ _08201_/D _08244_/B _08234_/A _08200_/C VDD VSS sg13g2_nor3_1
X_13942__2330 _13942_/RESET_B VDD VSS sg13g2_tiehi
X_09180_ _13796_/D _13796_/Q _09882_/A0 _09200_/S VDD VSS sg13g2_mux2_1
XFILLER_18_1073 VDD VSS sg13g2_decap_8
X_08131_ _08131_/Y _08223_/S _08128_/X _08130_/Y VDD VSS sg13g2_o21ai_1
XFILLER_147_634 VDD VSS sg13g2_fill_2
XFILLER_135_807 VDD VSS sg13g2_fill_2
X_08062_ _08256_/A _08428_/S _08059_/X _08061_/Y VDD VSS sg13g2_o21ai_1
XFILLER_135_829 VDD VSS sg13g2_fill_2
XFILLER_174_464 VDD VSS sg13g2_decap_8
XFILLER_134_306 VDD VSS sg13g2_decap_8
XFILLER_31_1262 VDD VSS sg13g2_fill_2
XFILLER_122_1390 VDD VSS sg13g2_decap_8
X_15044__2630 _15044_/RESET_B VDD VSS sg13g2_tiehi
XFILLER_161_136 VDD VSS sg13g2_fill_2
X_13975__2297 _13975_/RESET_B VDD VSS sg13g2_tiehi
XFILLER_66_1325 VDD VSS sg13g2_decap_8
XFILLER_115_564 VDD VSS sg13g2_decap_8
XFILLER_143_873 VDD VSS sg13g2_decap_8
XFILLER_161_169 VDD VSS sg13g2_decap_8
Xhold3203 _10837_/A _14930_/Q VDD VSS sg13g2_dlygate4sd3_1
XFILLER_88_404 VDD VSS sg13g2_decap_8
XFILLER_0_308 VDD VSS sg13g2_decap_8
Xhold3214 _13635_/A _13743_/Q VDD VSS sg13g2_dlygate4sd3_1
XFILLER_102_203 VDD VSS sg13g2_decap_8
XFILLER_89_949 VDD VSS sg13g2_decap_4
Xhold3225 _11001_/A _14942_/Q VDD VSS sg13g2_dlygate4sd3_1
XFILLER_153_1328 VDD VSS sg13g2_fill_2
Xhold3236 _10850_/A _14931_/Q VDD VSS sg13g2_dlygate4sd3_1
Xhold3247 _13575_/A _15157_/Q VDD VSS sg13g2_dlygate4sd3_1
XFILLER_130_545 VDD VSS sg13g2_fill_1
Xhold3258 _11133_/A _14951_/Q VDD VSS sg13g2_dlygate4sd3_1
X_08964_ _09839_/D _09240_/A _09441_/C _09441_/A VDD VSS sg13g2_nand3b_1
XFILLER_64_1060 VDD VSS sg13g2_decap_8
XFILLER_29_1180 VDD VSS sg13g2_decap_8
XFILLER_69_662 VDD VSS sg13g2_fill_2
X_07915_ _07917_/C _07884_/Y _07900_/Y _07914_/Y VDD VSS sg13g2_a21oi_1
XFILLER_9_1274 VDD VSS sg13g2_decap_8
XFILLER_75_109 VDD VSS sg13g2_decap_8
X_08895_ _08895_/X _08894_/X _11770_/A _08895_/S VDD VSS sg13g2_mux2_1
XFILLER_112_1003 VDD VSS sg13g2_decap_8
XFILLER_84_610 VDD VSS sg13g2_fill_1
XFILLER_5_1127 VDD VSS sg13g2_decap_8
XFILLER_57_824 VDD VSS sg13g2_decap_8
XFILLER_56_312 VDD VSS sg13g2_decap_8
XFILLER_25_1066 VDD VSS sg13g2_decap_4
X_07846_ _08650_/A _08678_/B _08678_/C VDD VSS sg13g2_and2_1
XFILLER_99_1156 VDD VSS sg13g2_decap_8
XFILLER_99_1178 VDD VSS sg13g2_fill_2
XFILLER_17_35 VDD VSS sg13g2_decap_8
X_14317__1955 _14317_/RESET_B VDD VSS sg13g2_tiehi
XFILLER_72_827 VDD VSS sg13g2_decap_4
XFILLER_140_14 VDD VSS sg13g2_fill_2
X_07777_ _07777_/Y _08276_/B _08276_/A VDD VSS sg13g2_nand2b_1
XFILLER_83_175 VDD VSS sg13g2_decap_8
X_09516_ _14115_/D _09582_/A1 _14115_/Q _09534_/S VDD VSS sg13g2_mux2_1
XFILLER_38_1405 VDD VSS sg13g2_decap_4
XFILLER_37_592 VDD VSS sg13g2_fill_1
XFILLER_25_754 VDD VSS sg13g2_decap_8
X_09447_ _14048_/D _10076_/A0 _14048_/Q _09472_/S VDD VSS sg13g2_mux2_1
XFILLER_13_938 VDD VSS sg13g2_decap_8
XFILLER_80_893 VDD VSS sg13g2_fill_1
XFILLER_125_1419 VDD VSS sg13g2_decap_8
XFILLER_164_1468 VDD VSS sg13g2_decap_8
XFILLER_24_286 VDD VSS sg13g2_decap_8
XFILLER_185_707 VDD VSS sg13g2_fill_1
XFILLER_12_448 VDD VSS sg13g2_decap_8
X_14532__1740 _14532_/RESET_B VDD VSS sg13g2_tiehi
X_09378_ _13981_/D _09842_/A1 _13981_/Q _09395_/S VDD VSS sg13g2_mux2_1
XFILLER_71_1031 VDD VSS sg13g2_decap_4
XFILLER_33_56 VDD VSS sg13g2_decap_8
XFILLER_32_1004 VDD VSS sg13g2_decap_8
XFILLER_149_56 VDD VSS sg13g2_decap_8
XFILLER_166_932 VDD VSS sg13g2_decap_4
X_08329_ _08329_/Y _08329_/A _08329_/B VDD VSS sg13g2_nand2_1
XFILLER_32_1015 VDD VSS sg13g2_fill_1
XFILLER_149_67 VDD VSS sg13g2_fill_2
XFILLER_177_280 VDD VSS sg13g2_decap_8
XFILLER_165_431 VDD VSS sg13g2_decap_4
XFILLER_32_1037 VDD VSS sg13g2_decap_8
XFILLER_138_656 VDD VSS sg13g2_decap_8
XFILLER_20_470 VDD VSS sg13g2_decap_8
XFILLER_149_89 VDD VSS sg13g2_decap_8
X_11340_ _11340_/Y _11340_/A1 _11339_/Y wire232/X _11333_/Y _11248_/B VDD VSS sg13g2_a221oi_1
XFILLER_10_1302 VDD VSS sg13g2_decap_8
XFILLER_137_166 VDD VSS sg13g2_decap_4
X_15090__2898 _15090_/RESET_B VDD VSS sg13g2_tiehi
XFILLER_181_935 VDD VSS sg13g2_decap_8
XFILLER_101_1441 VDD VSS sg13g2_decap_8
XFILLER_158_1228 VDD VSS sg13g2_decap_8
XFILLER_101_1452 VDD VSS sg13g2_decap_8
XFILLER_180_434 VDD VSS sg13g2_decap_8
X_11271_ _11271_/Y _11275_/S0 _14396_/Q _11262_/B VDD VSS sg13g2_a21oi_1
XFILLER_153_659 VDD VSS sg13g2_decap_8
XFILLER_106_542 VDD VSS sg13g2_decap_8
X_13010_ _13026_/C _13010_/A _13010_/B VDD VSS sg13g2_nor2_1
X_13805__2467 _13805_/RESET_B VDD VSS sg13g2_tiehi
XFILLER_4_658 VDD VSS sg13g2_decap_8
XFILLER_10_1379 VDD VSS sg13g2_decap_8
X_10222_ _10222_/Y _14769_/Q _10219_/X _10337_/C VDD VSS sg13g2_o21ai_1
XFILLER_165_77 VDD VSS sg13g2_decap_8
XFILLER_45_1409 VDD VSS sg13g2_decap_8
XFILLER_3_168 VDD VSS sg13g2_decap_8
XFILLER_0_820 VDD VSS sg13g2_decap_8
XFILLER_121_523 VDD VSS sg13g2_fill_2
X_10153_ _14730_/D _14730_/Q _10153_/A1 _10163_/S VDD VSS sg13g2_mux2_1
XFILLER_181_21 VDD VSS sg13g2_decap_8
XFILLER_95_919 VDD VSS sg13g2_decap_8
XFILLER_121_567 VDD VSS sg13g2_decap_8
XFILLER_58_64 VDD VSS sg13g2_decap_8
X_14961_ _14961_/Q clkload76/A _14961_/D _14961_/RESET_B VDD VSS sg13g2_dfrbpq_1
X_10084_ _14664_/D _10151_/A1 _14664_/Q _10093_/S VDD VSS sg13g2_mux2_1
XFILLER_0_897 VDD VSS sg13g2_decap_8
XFILLER_134_1272 VDD VSS sg13g2_decap_8
XFILLER_102_792 VDD VSS sg13g2_fill_2
X_13912_ _13912_/Q clkload25/A _13912_/D _13912_/RESET_B VDD VSS sg13g2_dfrbpq_1
XFILLER_48_857 VDD VSS sg13g2_decap_8
XFILLER_75_643 VDD VSS sg13g2_decap_4
XFILLER_181_98 VDD VSS sg13g2_decap_8
X_14892_ _14892_/Q clkload63/A _14892_/D _14892_/RESET_B VDD VSS sg13g2_dfrbpq_1
XFILLER_74_131 VDD VSS sg13g2_decap_8
XFILLER_114_70 VDD VSS sg13g2_decap_8
XFILLER_169_1335 VDD VSS sg13g2_fill_1
XFILLER_21_1431 VDD VSS sg13g2_decap_8
XFILLER_74_30 VDD VSS sg13g2_decap_8
X_13843_ _13843_/Q clkload41/A _13843_/D _13843_/RESET_B VDD VSS sg13g2_dfrbpq_1
XFILLER_90_613 VDD VSS sg13g2_decap_8
XFILLER_74_52 VDD VSS sg13g2_decap_8
XFILLER_16_721 VDD VSS sg13g2_decap_8
X_13774_ _13774_/Q _14734_/CLK _13774_/D _13774_/RESET_B VDD VSS sg13g2_dfrbpq_1
X_10986_ _14940_/D _10985_/X _10984_/Y _10973_/Y VDD VSS sg13g2_o21ai_1
XFILLER_74_96 VDD VSS sg13g2_decap_8
XFILLER_15_231 VDD VSS sg13g2_decap_8
X_12725_ _12725_/X _14390_/Q _14422_/Q _14486_/Q _14518_/Q _12742_/S0 _12756_/S1 VDD
+ VSS sg13g2_mux4_1
XFILLER_91_1429 VDD VSS sg13g2_decap_8
XFILLER_16_798 VDD VSS sg13g2_decap_4
XFILLER_31_735 VDD VSS sg13g2_decap_8
XFILLER_176_718 VDD VSS sg13g2_fill_1
XFILLER_157_910 VDD VSS sg13g2_fill_1
XFILLER_19_1371 VDD VSS sg13g2_decap_8
X_12656_ _12656_/X _14129_/Q _14161_/Q _14193_/Q _14225_/Q _12659_/S0 _12659_/S1 VDD
+ VSS sg13g2_mux4_1
XFILLER_31_768 VDD VSS sg13g2_decap_8
XFILLER_175_217 VDD VSS sg13g2_decap_8
XFILLER_88_7 VDD VSS sg13g2_decap_8
XFILLER_54_1262 VDD VSS sg13g2_decap_8
XFILLER_30_245 VDD VSS sg13g2_decap_8
XFILLER_169_781 VDD VSS sg13g2_decap_8
XFILLER_169_792 VDD VSS sg13g2_fill_2
XFILLER_15_1235 VDD VSS sg13g2_decap_8
X_11607_ _11608_/A _13734_/Q _14086_/Q _14438_/Q _14534_/Q _11597_/A _11598_/C VDD
+ VSS sg13g2_mux4_1
XFILLER_129_645 VDD VSS sg13g2_decap_8
X_12587_ _12587_/X _14380_/Q _14412_/Q _14476_/Q _14508_/Q _12591_/S0 _12591_/S1 VDD
+ VSS sg13g2_mux4_1
XFILLER_8_931 VDD VSS sg13g2_decap_8
X_14326_ _14326_/Q _14518_/CLK _14326_/D _14326_/RESET_B VDD VSS sg13g2_dfrbpq_1
XFILLER_7_441 VDD VSS sg13g2_decap_8
X_11538_ _11538_/Y _12070_/S0 _14628_/Q VDD VSS sg13g2_nand2b_1
XFILLER_89_1358 VDD VSS sg13g2_decap_8
XFILLER_116_317 VDD VSS sg13g2_decap_8
XFILLER_172_946 VDD VSS sg13g2_decap_8
XFILLER_171_434 VDD VSS sg13g2_fill_1
XFILLER_183_294 VDD VSS sg13g2_decap_8
X_14257_ _14257_/Q _14513_/CLK _14257_/D _14257_/RESET_B VDD VSS sg13g2_dfrbpq_1
X_11469_ _11469_/X _14369_/Q _14401_/Q _14465_/Q _14497_/Q _11489_/S0 _11489_/S1 VDD
+ VSS sg13g2_mux4_1
XFILLER_125_851 VDD VSS sg13g2_decap_8
XFILLER_143_158 VDD VSS sg13g2_decap_8
XFILLER_99_93 VDD VSS sg13g2_decap_8
X_13208_ _13208_/Y _14793_/Q _13208_/A2 _13208_/B1 VDD VSS sg13g2_o21ai_1
XFILLER_98_702 VDD VSS sg13g2_decap_8
XFILLER_48_1033 VDD VSS sg13g2_decap_8
XFILLER_125_884 VDD VSS sg13g2_decap_8
X_14188_ _14188_/Q _14540_/CLK _14188_/D _14188_/RESET_B VDD VSS sg13g2_dfrbpq_1
XFILLER_174_1052 VDD VSS sg13g2_fill_1
XFILLER_174_1074 VDD VSS sg13g2_fill_2
X_13139_ _13139_/Y _13139_/A _13139_/B VDD VSS sg13g2_nand2_1
XFILLER_112_545 VDD VSS sg13g2_decap_8
XFILLER_97_245 VDD VSS sg13g2_decap_8
XFILLER_61_1200 VDD VSS sg13g2_fill_2
XFILLER_26_1320 VDD VSS sg13g2_decap_8
XFILLER_135_1058 VDD VSS sg13g2_decap_8
XFILLER_65_1380 VDD VSS sg13g2_decap_4
XFILLER_140_887 VDD VSS sg13g2_decap_8
XFILLER_6_1414 VDD VSS sg13g2_decap_8
XFILLER_113_1301 VDD VSS sg13g2_fill_1
XFILLER_38_301 VDD VSS sg13g2_decap_8
X_07700_ _15202_/D _07700_/A _07700_/B _07700_/C VDD VSS sg13g2_nand3_1
Xfanout1470 _10347_/B fanout1476/X VDD VSS sg13g2_buf_1
XFILLER_94_941 VDD VSS sg13g2_decap_8
XFILLER_78_492 VDD VSS sg13g2_decap_8
X_14610__1662 _14610_/RESET_B VDD VSS sg13g2_tiehi
Xfanout1481 _10209_/A _13198_/B1 VDD VSS sg13g2_buf_1
X_08680_ _08681_/B _08678_/C _08654_/A _07841_/Y VDD VSS sg13g2_o21ai_1
XFILLER_26_1397 VDD VSS sg13g2_decap_8
XFILLER_61_1288 VDD VSS sg13g2_fill_1
XFILLER_39_868 VDD VSS sg13g2_decap_4
Xfanout1492 _10544_/C _10441_/C VDD VSS sg13g2_buf_1
XFILLER_93_440 VDD VSS sg13g2_fill_1
X_07631_ _07631_/Y _08234_/A VDD VSS sg13g2_inv_1
XFILLER_93_473 VDD VSS sg13g2_decap_8
XFILLER_54_827 VDD VSS sg13g2_fill_1
XFILLER_53_304 VDD VSS sg13g2_decap_8
XFILLER_26_518 VDD VSS sg13g2_decap_8
XFILLER_0_1002 VDD VSS sg13g2_decap_8
XFILLER_53_315 VDD VSS sg13g2_fill_2
XFILLER_38_389 VDD VSS sg13g2_decap_4
XFILLER_148_1419 VDD VSS sg13g2_fill_1
XFILLER_93_495 VDD VSS sg13g2_decap_8
XFILLER_81_635 VDD VSS sg13g2_decap_8
XFILLER_80_112 VDD VSS sg13g2_fill_2
X_09301_ _13909_/D _13909_/Q _10164_/A1 _09305_/S VDD VSS sg13g2_mux2_1
XFILLER_0_1079 VDD VSS sg13g2_decap_8
XFILLER_185_1181 VDD VSS sg13g2_decap_4
XFILLER_110_28 VDD VSS sg13g2_decap_8
XFILLER_107_1116 VDD VSS sg13g2_decap_8
XFILLER_179_567 VDD VSS sg13g2_decap_8
X_09232_ _13843_/D _10162_/A1 _13843_/Q _09237_/S VDD VSS sg13g2_mux2_1
X_14897__2843 _14897_/RESET_B VDD VSS sg13g2_tiehi
XFILLER_22_768 VDD VSS sg13g2_fill_2
XFILLER_21_245 VDD VSS sg13g2_decap_8
XFILLER_33_1302 VDD VSS sg13g2_decap_8
XFILLER_166_217 VDD VSS sg13g2_decap_8
X_09163_ _09164_/D _14925_/Q _14924_/Q VDD VSS sg13g2_nor2b_1
XFILLER_9_91 VDD VSS sg13g2_decap_8
XFILLER_120_1305 VDD VSS sg13g2_decap_4
XFILLER_147_442 VDD VSS sg13g2_decap_8
XFILLER_33_1357 VDD VSS sg13g2_decap_8
XFILLER_120_1316 VDD VSS sg13g2_decap_8
X_08114_ _08115_/B _07879_/A _13525_/A _08113_/Y VDD VSS sg13g2_a21oi_1
XFILLER_120_1338 VDD VSS sg13g2_fill_1
X_09094_ _10747_/B _09134_/S _15042_/Q _09093_/Y VDD VSS sg13g2_o21ai_1
XFILLER_119_48 VDD VSS sg13g2_fill_1
X_08045_ _08045_/Y _08428_/S _08044_/X _08043_/Y VDD VSS sg13g2_o21ai_1
XFILLER_174_294 VDD VSS sg13g2_fill_2
XFILLER_134_169 VDD VSS sg13g2_fill_1
XFILLER_143_670 VDD VSS sg13g2_decap_8
XFILLER_162_489 VDD VSS sg13g2_decap_8
XFILLER_0_105 VDD VSS sg13g2_decap_8
XFILLER_157_1272 VDD VSS sg13g2_decap_8
XFILLER_118_1234 VDD VSS sg13g2_decap_4
XFILLER_66_1166 VDD VSS sg13g2_fill_1
XFILLER_118_1256 VDD VSS sg13g2_decap_8
XFILLER_153_1136 VDD VSS sg13g2_fill_2
XFILLER_27_1139 VDD VSS sg13g2_decap_8
X_09996_ _14579_/D _10029_/A0 _14579_/Q _10002_/S VDD VSS sg13g2_mux2_1
XFILLER_88_245 VDD VSS sg13g2_decap_8
XFILLER_44_1420 VDD VSS sg13g2_decap_8
X_08947_ _13720_/D _08956_/S _08945_/Y _08946_/Y VDD VSS sg13g2_a21oi_1
XFILLER_131_1412 VDD VSS sg13g2_decap_8
XFILLER_9_1071 VDD VSS sg13g2_decap_8
XFILLER_69_470 VDD VSS sg13g2_decap_8
XFILLER_131_1423 VDD VSS sg13g2_fill_1
XFILLER_57_621 VDD VSS sg13g2_decap_8
XFILLER_130_397 VDD VSS sg13g2_decap_8
XFILLER_85_941 VDD VSS sg13g2_decap_8
XFILLER_131_1456 VDD VSS sg13g2_decap_8
X_08878_ _08878_/X _15033_/Q _10788_/S _08877_/Y VDD VSS sg13g2_a21o_1
XFILLER_29_345 VDD VSS sg13g2_decap_8
XFILLER_28_56 VDD VSS sg13g2_decap_8
XFILLER_17_518 VDD VSS sg13g2_decap_8
XFILLER_29_378 VDD VSS sg13g2_decap_8
XFILLER_28_89 VDD VSS sg13g2_decap_8
X_07829_ _07906_/B _07829_/A _07829_/B VDD VSS sg13g2_and2_1
XFILLER_84_495 VDD VSS sg13g2_fill_1
XFILLER_56_186 VDD VSS sg13g2_decap_8
XFILLER_56_197 VDD VSS sg13g2_fill_2
X_10840_ _10841_/C _10851_/D _12347_/B _10821_/C _10821_/A _10818_/Y VDD VSS sg13g2_a221oi_1
X_10771_ _14919_/D _11045_/B1 _11147_/A _10770_/Y VDD VSS sg13g2_o21ai_1
XFILLER_77_1295 VDD VSS sg13g2_decap_8
XFILLER_52_370 VDD VSS sg13g2_decap_8
XFILLER_13_735 VDD VSS sg13g2_decap_8
XFILLER_164_1254 VDD VSS sg13g2_decap_8
XFILLER_160_1107 VDD VSS sg13g2_decap_8
X_12510_ _12510_/X _12506_/X _12505_/X _12504_/X _12503_/X _12663_/S1 _12636_/S VDD
+ VSS sg13g2_mux4_1
XFILLER_129_1396 VDD VSS sg13g2_decap_8
XFILLER_185_504 VDD VSS sg13g2_decap_8
X_13490_ _13490_/Y _15198_/Q _13490_/B _13490_/C _13490_/D VDD VSS sg13g2_nor4_1
XFILLER_40_543 VDD VSS sg13g2_decap_8
XFILLER_12_245 VDD VSS sg13g2_decap_8
XFILLER_9_728 VDD VSS sg13g2_decap_8
XFILLER_90_1451 VDD VSS sg13g2_fill_1
XFILLER_100_61 VDD VSS sg13g2_decap_8
X_12441_ _12441_/X _12439_/X _12440_/X _12720_/S VDD VSS sg13g2_mux2_1
XFILLER_60_21 VDD VSS sg13g2_decap_8
XFILLER_8_238 VDD VSS sg13g2_decap_8
XFILLER_176_21 VDD VSS sg13g2_decap_8
XFILLER_126_604 VDD VSS sg13g2_decap_8
X_15160_ _15160_/Q _15216_/CLK _15160_/D _15160_/RESET_B VDD VSS sg13g2_dfrbpq_1
X_12372_ _12372_/Y _12386_/A _12372_/B VDD VSS sg13g2_nand2_1
XFILLER_138_475 VDD VSS sg13g2_decap_8
XFILLER_166_795 VDD VSS sg13g2_fill_1
XFILLER_126_637 VDD VSS sg13g2_decap_8
XFILLER_181_721 VDD VSS sg13g2_decap_8
XFILLER_60_98 VDD VSS sg13g2_decap_8
XFILLER_114_0 VDD VSS sg13g2_decap_8
X_14111_ _14111_/Q clkload21/A _14111_/D _14111_/RESET_B VDD VSS sg13g2_dfrbpq_1
X_11323_ _11323_/Y _11328_/S0 _14141_/Q _11328_/S1 VDD VSS sg13g2_a21oi_1
XFILLER_125_125 VDD VSS sg13g2_decap_8
X_15091_ _15091_/Q clkload87/A _15091_/D _15091_/RESET_B VDD VSS sg13g2_dfrbpq_1
XFILLER_5_945 VDD VSS sg13g2_decap_8
XFILLER_107_840 VDD VSS sg13g2_decap_4
XFILLER_176_98 VDD VSS sg13g2_decap_8
XFILLER_180_231 VDD VSS sg13g2_decap_8
XFILLER_181_765 VDD VSS sg13g2_decap_8
XFILLER_141_607 VDD VSS sg13g2_fill_2
XFILLER_158_1058 VDD VSS sg13g2_decap_4
XFILLER_5_49 VDD VSS sg13g2_decap_8
XFILLER_4_455 VDD VSS sg13g2_decap_8
XFILLER_106_350 VDD VSS sg13g2_decap_8
XFILLER_109_81 VDD VSS sg13g2_decap_8
X_14042_ _14042_/Q clkload53/A _14042_/D _14042_/RESET_B VDD VSS sg13g2_dfrbpq_1
X_11254_ _11255_/A _11218_/S _14652_/Q _11872_/B1 VDD VSS sg13g2_a21oi_1
XFILLER_69_30 VDD VSS sg13g2_decap_8
XFILLER_10_1176 VDD VSS sg13g2_decap_8
XFILLER_84_1255 VDD VSS sg13g2_decap_8
XFILLER_45_1206 VDD VSS sg13g2_fill_1
X_10205_ _15200_/D hold3162/X _13448_/B _13333_/S VDD VSS sg13g2_mux2_1
X_11185_ _11197_/B _11185_/A _11185_/B VDD VSS sg13g2_xnor2_1
XFILLER_121_331 VDD VSS sg13g2_decap_8
XFILLER_79_245 VDD VSS sg13g2_decap_8
X_10136_ _14714_/D _10169_/A1 _14714_/Q _10136_/S VDD VSS sg13g2_mux2_1
XFILLER_39_109 VDD VSS sg13g2_fill_2
XFILLER_79_278 VDD VSS sg13g2_decap_8
XFILLER_0_672 VDD VSS sg13g2_decap_8
XFILLER_79_289 VDD VSS sg13g2_fill_1
XFILLER_121_386 VDD VSS sg13g2_decap_8
XFILLER_48_632 VDD VSS sg13g2_decap_8
X_14944_ _14944_/Q _14947_/CLK _14944_/D _14944_/RESET_B VDD VSS sg13g2_dfrbpq_1
X_10067_ _14648_/D _10067_/A0 _14648_/Q _10068_/S VDD VSS sg13g2_mux2_1
XFILLER_76_974 VDD VSS sg13g2_decap_8
XFILLER_91_911 VDD VSS sg13g2_fill_2
XFILLER_169_1132 VDD VSS sg13g2_decap_8
XFILLER_169_1143 VDD VSS sg13g2_fill_2
X_14875_ _14875_/Q clkload61/A _14875_/D _14875_/RESET_B VDD VSS sg13g2_dfrbpq_1
XFILLER_169_1154 VDD VSS sg13g2_decap_4
XFILLER_35_337 VDD VSS sg13g2_decap_8
XFILLER_1_1344 VDD VSS sg13g2_decap_8
X_13826_ _13826_/Q clkload45/A _13826_/D _13826_/RESET_B VDD VSS sg13g2_dfrbpq_1
XFILLER_91_977 VDD VSS sg13g2_decap_8
XFILLER_95_1351 VDD VSS sg13g2_decap_8
XFILLER_63_679 VDD VSS sg13g2_decap_8
XFILLER_182_1310 VDD VSS sg13g2_decap_8
XFILLER_62_167 VDD VSS sg13g2_decap_8
XFILLER_108_1403 VDD VSS sg13g2_decap_8
X_13757_ _13757_/Q clkload58/A _13757_/D _13757_/RESET_B VDD VSS sg13g2_dfrbpq_1
X_10969_ _10969_/Y _10969_/A _11044_/C VDD VSS sg13g2_nand2_1
XFILLER_31_510 VDD VSS sg13g2_decap_8
XFILLER_16_595 VDD VSS sg13g2_decap_8
XFILLER_149_718 VDD VSS sg13g2_decap_8
X_12708_ _15014_/D _12708_/A wire321/X VDD VSS sg13g2_nor2_1
XFILLER_176_515 VDD VSS sg13g2_decap_8
XFILLER_148_217 VDD VSS sg13g2_decap_8
X_13688_ _13688_/Q clkload80/A _13688_/D _13688_/RESET_B VDD VSS sg13g2_dfrbpq_1
XFILLER_15_1032 VDD VSS sg13g2_decap_8
X_12639_ _12652_/A _12751_/A1 _12737_/A2 _15010_/Q VDD VSS sg13g2_a21oi_1
XFILLER_157_751 VDD VSS sg13g2_decap_8
XFILLER_89_1100 VDD VSS sg13g2_fill_2
XFILLER_141_1051 VDD VSS sg13g2_decap_8
XFILLER_129_475 VDD VSS sg13g2_decap_8
XFILLER_145_924 VDD VSS sg13g2_fill_1
XFILLER_89_1133 VDD VSS sg13g2_decap_8
XFILLER_144_423 VDD VSS sg13g2_decap_4
XFILLER_156_283 VDD VSS sg13g2_fill_1
XFILLER_116_125 VDD VSS sg13g2_decap_8
XFILLER_156_294 VDD VSS sg13g2_decap_8
XFILLER_176_1114 VDD VSS sg13g2_decap_4
X_14309_ _14309_/Q clkload14/A _14309_/D _14309_/RESET_B VDD VSS sg13g2_dfrbpq_1
X_14628__1644 _14628_/RESET_B VDD VSS sg13g2_tiehi
XFILLER_176_1125 VDD VSS sg13g2_decap_4
XFILLER_145_979 VDD VSS sg13g2_decap_4
XFILLER_67_1420 VDD VSS sg13g2_decap_8
XFILLER_176_1147 VDD VSS sg13g2_decap_8
XFILLER_131_106 VDD VSS sg13g2_fill_2
XFILLER_153_990 VDD VSS sg13g2_decap_4
XFILLER_28_1415 VDD VSS sg13g2_decap_8
X_13892__2380 _13892_/RESET_B VDD VSS sg13g2_tiehi
Xfanout707 _13208_/A2 _13220_/A2 VDD VSS sg13g2_buf_1
X_09850_ _14437_/D _14437_/Q _09949_/A1 _09862_/S VDD VSS sg13g2_mux2_1
XFILLER_124_191 VDD VSS sg13g2_decap_8
Xfanout729 _11056_/B1 _07753_/B VDD VSS sg13g2_buf_1
X_08801_ _08802_/B _13685_/Q _08801_/B VDD VSS sg13g2_nor2_1
XFILLER_105_28 VDD VSS sg13g2_decap_8
X_09781_ _14370_/D _09913_/A1 _14370_/Q _09800_/S VDD VSS sg13g2_mux2_1
XFILLER_85_215 VDD VSS sg13g2_decap_8
XFILLER_6_1211 VDD VSS sg13g2_decap_8
XFILLER_113_1120 VDD VSS sg13g2_decap_8
X_08732_ _13662_/D _08765_/A1 _08730_/Y _08731_/Y VDD VSS sg13g2_a21oi_1
XFILLER_26_1194 VDD VSS sg13g2_decap_8
XFILLER_82_900 VDD VSS sg13g2_decap_8
XFILLER_66_451 VDD VSS sg13g2_decap_8
XFILLER_113_1164 VDD VSS sg13g2_decap_8
XFILLER_6_1288 VDD VSS sg13g2_decap_8
XFILLER_27_816 VDD VSS sg13g2_fill_2
XFILLER_22_1058 VDD VSS sg13g2_decap_8
X_08663_ _08663_/X _08663_/A _08698_/B VDD VSS sg13g2_and2_1
XFILLER_26_315 VDD VSS sg13g2_decap_8
XFILLER_121_16 VDD VSS sg13g2_fill_1
XFILLER_148_1227 VDD VSS sg13g2_decap_8
X_07614_ _07614_/Y _14955_/Q VDD VSS sg13g2_inv_1
XFILLER_82_966 VDD VSS sg13g2_decap_8
X_08594_ _08596_/C _08653_/A _07858_/X _07857_/X _08593_/Y VDD VSS sg13g2_a22oi_1
XFILLER_183_1129 VDD VSS sg13g2_decap_4
XFILLER_81_465 VDD VSS sg13g2_fill_1
XFILLER_41_307 VDD VSS sg13g2_decap_4
XFILLER_53_189 VDD VSS sg13g2_decap_8
XFILLER_62_690 VDD VSS sg13g2_fill_2
XFILLER_14_14 VDD VSS sg13g2_decap_8
XFILLER_179_364 VDD VSS sg13g2_decap_8
XFILLER_167_515 VDD VSS sg13g2_decap_4
XFILLER_50_852 VDD VSS sg13g2_decap_8
XFILLER_22_554 VDD VSS sg13g2_decap_8
XFILLER_50_885 VDD VSS sg13g2_decap_8
XFILLER_33_1110 VDD VSS sg13g2_decap_8
X_09215_ _13826_/D _10145_/A1 _13826_/Q _09238_/S VDD VSS sg13g2_mux2_1
XFILLER_10_749 VDD VSS sg13g2_decap_8
XFILLER_124_1260 VDD VSS sg13g2_fill_2
XFILLER_136_913 VDD VSS sg13g2_decap_8
XFILLER_182_518 VDD VSS sg13g2_decap_8
X_09146_ _13783_/D _13783_/Q _10166_/A1 _09167_/S VDD VSS sg13g2_mux2_1
XFILLER_163_721 VDD VSS sg13g2_decap_8
XFILLER_120_1146 VDD VSS sg13g2_decap_8
XFILLER_159_1323 VDD VSS sg13g2_decap_8
XFILLER_30_35 VDD VSS sg13g2_decap_8
X_09077_ _13773_/D _13773_/Q _10156_/A1 _09106_/S VDD VSS sg13g2_mux2_1
XFILLER_136_979 VDD VSS sg13g2_fill_2
XFILLER_11_1463 VDD VSS sg13g2_decap_8
XFILLER_135_467 VDD VSS sg13g2_decap_8
XFILLER_146_35 VDD VSS sg13g2_decap_8
XFILLER_11_1474 VDD VSS sg13g2_fill_1
XFILLER_151_927 VDD VSS sg13g2_fill_1
X_08028_ _08031_/C _11428_/A _11452_/A _11503_/A1 _11483_/A _08023_/A _07884_/A VDD
+ VSS sg13g2_mux4_1
XFILLER_150_404 VDD VSS sg13g2_decap_8
XFILLER_122_139 VDD VSS sg13g2_decap_8
X_13722__2550 _13722_/RESET_B VDD VSS sg13g2_tiehi
X_14482__1790 _14482_/RESET_B VDD VSS sg13g2_tiehi
XFILLER_2_959 VDD VSS sg13g2_decap_8
XFILLER_157_1080 VDD VSS sg13g2_fill_2
XFILLER_157_1091 VDD VSS sg13g2_decap_8
XFILLER_7_1008 VDD VSS sg13g2_decap_8
XFILLER_103_353 VDD VSS sg13g2_fill_1
XFILLER_1_469 VDD VSS sg13g2_decap_8
XFILLER_103_375 VDD VSS sg13g2_decap_4
X_09979_ _14562_/D _10045_/A0 _14562_/Q _09998_/S VDD VSS sg13g2_mux2_1
XFILLER_130_183 VDD VSS sg13g2_fill_1
XFILLER_162_56 VDD VSS sg13g2_fill_2
XFILLER_44_1261 VDD VSS sg13g2_decap_4
XFILLER_130_194 VDD VSS sg13g2_decap_4
XFILLER_170_1280 VDD VSS sg13g2_decap_8
XFILLER_92_708 VDD VSS sg13g2_fill_1
X_12990_ _12990_/X _12990_/A _13683_/Q _14904_/Q VDD VSS sg13g2_and3_1
X_14066__2206 _14066_/RESET_B VDD VSS sg13g2_tiehi
XFILLER_79_1302 VDD VSS sg13g2_decap_8
XFILLER_29_153 VDD VSS sg13g2_decap_8
XFILLER_18_827 VDD VSS sg13g2_fill_1
X_14102__2170 _14102_/RESET_B VDD VSS sg13g2_tiehi
XFILLER_45_613 VDD VSS sg13g2_fill_2
X_11941_ _11941_/Y _11948_/S _14160_/Q _11997_/S1 VDD VSS sg13g2_a21oi_1
XFILLER_55_21 VDD VSS sg13g2_decap_8
XFILLER_17_315 VDD VSS sg13g2_decap_8
XFILLER_73_933 VDD VSS sg13g2_decap_8
XFILLER_72_410 VDD VSS sg13g2_decap_8
XFILLER_57_495 VDD VSS sg13g2_decap_8
XFILLER_166_1305 VDD VSS sg13g2_decap_8
XFILLER_166_1327 VDD VSS sg13g2_decap_8
X_14660_ _14660_/Q clkload33/A _14660_/D _14660_/RESET_B VDD VSS sg13g2_dfrbpq_1
X_11872_ _11872_/Y _11874_/S0 _13934_/Q _11872_/B1 VDD VSS sg13g2_a21oi_1
XFILLER_60_616 VDD VSS sg13g2_decap_4
X_13611_ _15167_/D _13610_/Y _13508_/C _13608_/Y VDD VSS sg13g2_a21oi_1
X_14706__1566 _14706_/RESET_B VDD VSS sg13g2_tiehi
XFILLER_26_871 VDD VSS sg13g2_decap_8
X_10823_ _10823_/Y _10823_/A _10823_/B _10823_/C VDD VSS sg13g2_nand3_1
X_14591_ _14591_/Q _14662_/CLK _14591_/D _14591_/RESET_B VDD VSS sg13g2_dfrbpq_1
XFILLER_60_638 VDD VSS sg13g2_decap_8
XFILLER_111_71 VDD VSS sg13g2_decap_8
XFILLER_13_532 VDD VSS sg13g2_decap_8
X_13542_ _13542_/Y _14995_/Q _13566_/C _15003_/Q _13546_/B2 VDD VSS sg13g2_a22oi_1
XFILLER_129_1193 VDD VSS sg13g2_decap_8
XFILLER_185_301 VDD VSS sg13g2_decap_8
X_10754_ _10754_/X _14947_/Q _10757_/A _10752_/Y VDD VSS sg13g2_a21o_1
XFILLER_71_42 VDD VSS sg13g2_decap_8
XFILLER_71_53 VDD VSS sg13g2_fill_1
XFILLER_125_1046 VDD VSS sg13g2_decap_8
XFILLER_164_1095 VDD VSS sg13g2_decap_4
XFILLER_9_525 VDD VSS sg13g2_decap_8
XFILLER_71_75 VDD VSS sg13g2_decap_8
X_13473_ _15177_/D hold3137/X _15177_/Q _13477_/S VDD VSS sg13g2_mux2_1
X_10685_ _10685_/Y _12859_/A _10850_/B VDD VSS sg13g2_nand2_1
XFILLER_90_1281 VDD VSS sg13g2_decap_4
XFILLER_16_1363 VDD VSS sg13g2_decap_8
XFILLER_40_395 VDD VSS sg13g2_fill_2
X_15212_ _15212_/Q _15212_/CLK _15212_/D _15212_/RESET_B VDD VSS sg13g2_dfrbpq_1
XFILLER_185_378 VDD VSS sg13g2_decap_8
X_12424_ _12424_/X _13824_/Q _13856_/Q _13888_/Q _13920_/Q _12424_/S0 _12424_/S1 VDD
+ VSS sg13g2_mux4_1
XFILLER_126_412 VDD VSS sg13g2_decap_8
XFILLER_139_795 VDD VSS sg13g2_decap_8
XFILLER_177_1412 VDD VSS sg13g2_fill_1
XFILLER_86_1306 VDD VSS sg13g2_decap_8
XFILLER_127_957 VDD VSS sg13g2_fill_2
X_15143_ _15143_/Q clkload78/A _15143_/D _15143_/RESET_B VDD VSS sg13g2_dfrbpq_1
X_12355_ _12356_/B _12353_/X _12354_/X _12355_/S VDD VSS sg13g2_mux2_1
XFILLER_126_456 VDD VSS sg13g2_decap_8
XFILLER_5_742 VDD VSS sg13g2_decap_8
XFILLER_103_1399 VDD VSS sg13g2_decap_8
X_11306_ _11306_/Y _11302_/Y _11303_/Y _11305_/Y _11304_/Y _11329_/B1 VDD VSS sg13g2_a221oi_1
XFILLER_153_275 VDD VSS sg13g2_decap_8
X_14881__2875 _14881_/RESET_B VDD VSS sg13g2_tiehi
X_15074_ _15074_/Q _15216_/CLK _15074_/D _15074_/RESET_B VDD VSS sg13g2_dfrbpq_1
X_12286_ _12286_/X _13977_/Q _14009_/Q _14041_/Q _14073_/Q _12286_/S0 _12286_/S1 VDD
+ VSS sg13g2_mux4_1
XFILLER_4_252 VDD VSS sg13g2_decap_8
XFILLER_181_595 VDD VSS sg13g2_decap_8
XFILLER_49_1150 VDD VSS sg13g2_decap_4
X_14025_ _14025_/Q clkload35/A _14025_/D _14025_/RESET_B VDD VSS sg13g2_dfrbpq_1
X_11237_ _11237_/Y _12217_/A _11231_/X _11236_/Y VDD VSS sg13g2_o21ai_1
XFILLER_141_459 VDD VSS sg13g2_fill_2
X_14312__1960 _14312_/RESET_B VDD VSS sg13g2_tiehi
XFILLER_110_802 VDD VSS sg13g2_fill_2
XFILLER_84_1085 VDD VSS sg13g2_decap_8
XFILLER_136_1175 VDD VSS sg13g2_fill_1
XFILLER_171_1055 VDD VSS sg13g2_decap_8
X_11168_ _11168_/X _11164_/C _13412_/C _11168_/B1 VDD VSS sg13g2_a21o_1
XFILLER_67_226 VDD VSS sg13g2_fill_2
XFILLER_121_183 VDD VSS sg13g2_decap_8
X_10119_ _14697_/D _10152_/A1 _14697_/Q _10135_/S VDD VSS sg13g2_mux2_1
XFILLER_95_557 VDD VSS sg13g2_decap_8
XFILLER_23_1323 VDD VSS sg13g2_decap_8
XFILLER_110_879 VDD VSS sg13g2_decap_4
X_11099_ _11099_/Y _11098_/Y _11096_/Y _11095_/Y _11140_/B2 _11193_/A2 VDD VSS sg13g2_a221oi_1
XFILLER_95_579 VDD VSS sg13g2_decap_8
XFILLER_62_1394 VDD VSS sg13g2_decap_8
XFILLER_3_1428 VDD VSS sg13g2_decap_8
X_14927_ _14927_/Q clkload79/A _14927_/D _14927_/RESET_B VDD VSS sg13g2_dfrbpq_1
XFILLER_63_410 VDD VSS sg13g2_decap_8
XFILLER_48_484 VDD VSS sg13g2_decap_8
XFILLER_35_134 VDD VSS sg13g2_decap_8
XFILLER_1_1141 VDD VSS sg13g2_decap_8
X_14858_ _14858_/Q clkload64/A _14858_/D _14858_/RESET_B VDD VSS sg13g2_dfrbpq_1
XFILLER_36_668 VDD VSS sg13g2_decap_8
XFILLER_91_774 VDD VSS sg13g2_decap_8
XFILLER_17_882 VDD VSS sg13g2_decap_8
X_13809_ _13809_/Q clkload8/A _13809_/D _13809_/RESET_B VDD VSS sg13g2_dfrbpq_1
XFILLER_90_273 VDD VSS sg13g2_fill_2
XFILLER_95_1170 VDD VSS sg13g2_decap_8
XFILLER_50_115 VDD VSS sg13g2_decap_8
X_14789_ _14789_/Q _14890_/CLK _14789_/D _14789_/RESET_B VDD VSS sg13g2_dfrbpq_1
XFILLER_56_1143 VDD VSS sg13g2_decap_8
XFILLER_16_392 VDD VSS sg13g2_decap_8
XFILLER_176_301 VDD VSS sg13g2_decap_8
XFILLER_182_1162 VDD VSS sg13g2_decap_4
X_13764__2508 _13764_/RESET_B VDD VSS sg13g2_tiehi
XFILLER_17_1138 VDD VSS sg13g2_decap_8
XFILLER_182_1184 VDD VSS sg13g2_decap_8
XFILLER_56_1187 VDD VSS sg13g2_decap_8
XFILLER_32_874 VDD VSS sg13g2_decap_8
XFILLER_143_1146 VDD VSS sg13g2_decap_8
XFILLER_182_1195 VDD VSS sg13g2_decap_4
XFILLER_91_1078 VDD VSS sg13g2_decap_8
XFILLER_56_1198 VDD VSS sg13g2_fill_1
X_13800__2472 _13800_/RESET_B VDD VSS sg13g2_tiehi
XFILLER_34_1430 VDD VSS sg13g2_fill_1
XFILLER_177_879 VDD VSS sg13g2_decap_8
X_09000_ _09000_/Y _14900_/Q _08993_/X _08999_/Y VDD VSS sg13g2_a21oi_1
XFILLER_34_1452 VDD VSS sg13g2_decap_8
XFILLER_118_902 VDD VSS sg13g2_decap_8
XFILLER_118_913 VDD VSS sg13g2_fill_1
XFILLER_176_378 VDD VSS sg13g2_decap_8
XFILLER_77_0 VDD VSS sg13g2_decap_8
XFILLER_30_1316 VDD VSS sg13g2_decap_8
XFILLER_129_283 VDD VSS sg13g2_decap_8
XFILLER_157_592 VDD VSS sg13g2_decap_8
XFILLER_129_294 VDD VSS sg13g2_fill_2
XFILLER_145_743 VDD VSS sg13g2_decap_4
XFILLER_118_979 VDD VSS sg13g2_fill_2
XFILLER_133_905 VDD VSS sg13g2_fill_1
X_14144__2128 _14144_/RESET_B VDD VSS sg13g2_tiehi
XFILLER_117_467 VDD VSS sg13g2_fill_2
XFILLER_160_702 VDD VSS sg13g2_fill_2
XFILLER_6_70 VDD VSS sg13g2_decap_8
XFILLER_144_286 VDD VSS sg13g2_decap_8
XFILLER_160_735 VDD VSS sg13g2_decap_8
XFILLER_144_297 VDD VSS sg13g2_fill_2
XFILLER_116_16 VDD VSS sg13g2_fill_1
XFILLER_160_757 VDD VSS sg13g2_fill_2
X_09902_ _14488_/D _10167_/A1 _14488_/Q _09902_/S VDD VSS sg13g2_mux2_1
XFILLER_116_27 VDD VSS sg13g2_decap_8
Xfanout515 _09406_/S _09404_/S VDD VSS sg13g2_buf_1
XFILLER_67_1294 VDD VSS sg13g2_decap_8
XFILLER_59_705 VDD VSS sg13g2_decap_8
Xfanout526 _09231_/S _09233_/S VDD VSS sg13g2_buf_1
XFILLER_28_1256 VDD VSS sg13g2_decap_8
Xfanout537 _08956_/S _08834_/X VDD VSS sg13g2_buf_1
X_09833_ _14421_/D _09899_/A0 _14421_/Q _09833_/S VDD VSS sg13g2_mux2_1
XFILLER_58_204 VDD VSS sg13g2_decap_8
XFILLER_141_993 VDD VSS sg13g2_decap_8
Xfanout548 _13653_/S _13502_/A VDD VSS sg13g2_buf_1
XFILLER_101_835 VDD VSS sg13g2_decap_8
XFILLER_113_695 VDD VSS sg13g2_decap_8
Xfanout559 _13547_/B _13520_/A1 VDD VSS sg13g2_buf_1
XFILLER_100_323 VDD VSS sg13g2_decap_8
XFILLER_112_183 VDD VSS sg13g2_decap_8
XFILLER_150_1139 VDD VSS sg13g2_decap_8
X_09764_ _14354_/D _14354_/Q _09896_/A0 _09764_/S VDD VSS sg13g2_mux2_1
XFILLER_58_259 VDD VSS sg13g2_decap_8
XFILLER_101_879 VDD VSS sg13g2_decap_8
X_08715_ _15190_/D hold3167/X _15190_/Q _08719_/S VDD VSS sg13g2_mux2_1
XFILLER_100_389 VDD VSS sg13g2_decap_4
XFILLER_6_1085 VDD VSS sg13g2_decap_8
X_09695_ _14287_/D _09926_/A1 _14287_/Q _09698_/S VDD VSS sg13g2_mux2_1
X_08646_ _08646_/Y _08646_/A _08646_/B _08646_/C VDD VSS sg13g2_nand3_1
XFILLER_55_977 VDD VSS sg13g2_decap_8
XFILLER_25_35 VDD VSS sg13g2_decap_8
XFILLER_14_329 VDD VSS sg13g2_decap_8
XFILLER_54_498 VDD VSS sg13g2_decap_8
XFILLER_42_638 VDD VSS sg13g2_fill_1
XFILLER_155_7 VDD VSS sg13g2_decap_8
X_08577_ _08577_/Y _08577_/A _08577_/B VDD VSS sg13g2_nor2_1
XFILLER_81_295 VDD VSS sg13g2_decap_8
XFILLER_165_1371 VDD VSS sg13g2_decap_8
Xclkbuf_5_0__f_clk_i clkbuf_leaf_5_clk_i/A clkbuf_4_0_0_clk_i/X VDD VSS sg13g2_buf_16
XFILLER_167_301 VDD VSS sg13g2_decap_8
XFILLER_179_161 VDD VSS sg13g2_decap_8
XFILLER_39_1385 VDD VSS sg13g2_decap_4
XFILLER_168_835 VDD VSS sg13g2_decap_8
X_14354__1918 _14354_/RESET_B VDD VSS sg13g2_tiehi
XFILLER_23_874 VDD VSS sg13g2_decap_8
XFILLER_126_1366 VDD VSS sg13g2_decap_4
XFILLER_74_1298 VDD VSS sg13g2_decap_8
XFILLER_122_1208 VDD VSS sg13g2_fill_2
XFILLER_10_546 VDD VSS sg13g2_decap_8
XFILLER_126_1399 VDD VSS sg13g2_decap_4
X_10470_ _10477_/C _14845_/Q _10500_/A _10471_/C _10471_/D VDD VSS sg13g2_and4_1
XFILLER_182_315 VDD VSS sg13g2_decap_8
XFILLER_41_56 VDD VSS sg13g2_decap_8
XFILLER_6_539 VDD VSS sg13g2_decap_8
X_09129_ _09129_/Y _13200_/A _09157_/C _09162_/A VDD VSS sg13g2_o21ai_1
XFILLER_109_979 VDD VSS sg13g2_decap_8
XFILLER_124_916 VDD VSS sg13g2_decap_8
XFILLER_11_1260 VDD VSS sg13g2_decap_8
XFILLER_136_787 VDD VSS sg13g2_decap_8
X_12140_ _12140_/X _13973_/Q _14005_/Q _14037_/Q _14069_/Q _12140_/S0 _12140_/S1 VDD
+ VSS sg13g2_mux4_1
XFILLER_159_1164 VDD VSS sg13g2_decap_8
XFILLER_151_735 VDD VSS sg13g2_decap_8
XFILLER_151_746 VDD VSS sg13g2_fill_2
XFILLER_85_1350 VDD VSS sg13g2_decap_8
X_12071_ _12071_/X _13747_/Q _14099_/Q _14451_/Q _14547_/Q _12138_/S0 _12138_/S1 VDD
+ VSS sg13g2_mux4_1
XFILLER_151_768 VDD VSS sg13g2_decap_8
XFILLER_172_1320 VDD VSS sg13g2_fill_2
XFILLER_2_756 VDD VSS sg13g2_decap_8
XFILLER_89_351 VDD VSS sg13g2_fill_2
X_11022_ _11022_/Y _11022_/A _11022_/B VDD VSS sg13g2_nand2_1
XFILLER_81_1236 VDD VSS sg13g2_decap_8
XFILLER_150_278 VDD VSS sg13g2_decap_8
XFILLER_1_266 VDD VSS sg13g2_decap_8
XFILLER_77_513 VDD VSS sg13g2_decap_8
XFILLER_173_77 VDD VSS sg13g2_decap_8
XFILLER_89_373 VDD VSS sg13g2_decap_8
XFILLER_2_28 VDD VSS sg13g2_decap_8
X_13988__2284 _13988_/RESET_B VDD VSS sg13g2_tiehi
XFILLER_181_0 VDD VSS sg13g2_decap_8
XFILLER_46_911 VDD VSS sg13g2_decap_4
XFILLER_92_538 VDD VSS sg13g2_decap_8
X_12973_ _12988_/D _14905_/Q _13682_/Q VDD VSS sg13g2_xnor2_1
XFILLER_79_1121 VDD VSS sg13g2_decap_8
XFILLER_66_86 VDD VSS sg13g2_decap_8
XFILLER_17_112 VDD VSS sg13g2_decap_8
XFILLER_66_97 VDD VSS sg13g2_fill_1
X_14712_ _14712_/Q _14744_/CLK _14712_/D _14712_/RESET_B VDD VSS sg13g2_dfrbpq_1
X_11924_ _11924_/X _14127_/Q _14159_/Q _14191_/Q _14223_/Q _11925_/S0 _11925_/S1 VDD
+ VSS sg13g2_mux4_1
XFILLER_46_977 VDD VSS sg13g2_decap_8
XFILLER_166_1146 VDD VSS sg13g2_decap_8
XFILLER_82_30 VDD VSS sg13g2_decap_8
XFILLER_61_936 VDD VSS sg13g2_decap_8
X_14643_ _14643_/Q clkload31/A _14643_/D _14643_/RESET_B VDD VSS sg13g2_dfrbpq_1
XFILLER_92_1310 VDD VSS sg13g2_decap_8
XFILLER_17_189 VDD VSS sg13g2_decap_8
X_11855_ _11856_/B _11847_/X _11848_/X _11851_/X _11852_/X _11615_/B _11625_/C VDD
+ VSS sg13g2_mux4_1
XFILLER_60_424 VDD VSS sg13g2_fill_1
XFILLER_33_649 VDD VSS sg13g2_decap_8
XFILLER_57_1452 VDD VSS sg13g2_decap_8
X_10806_ _10807_/C _15121_/Q _10813_/A VDD VSS sg13g2_xnor2_1
X_14574_ _14574_/Q clkload52/A _14574_/D _14574_/RESET_B VDD VSS sg13g2_dfrbpq_1
X_11786_ _11786_/X _14379_/Q _14411_/Q _14475_/Q _14507_/Q _11951_/A _11997_/S1 VDD
+ VSS sg13g2_mux4_1
XFILLER_53_1327 VDD VSS sg13g2_fill_1
XFILLER_18_1458 VDD VSS sg13g2_decap_8
XFILLER_144_1466 VDD VSS sg13g2_decap_8
XFILLER_14_896 VDD VSS sg13g2_decap_8
X_13525_ _13525_/X _13525_/A _13533_/B VDD VSS sg13g2_and2_1
XFILLER_9_322 VDD VSS sg13g2_decap_8
X_10737_ _10737_/Y _13088_/A _11048_/B VDD VSS sg13g2_nand2_1
XFILLER_40_181 VDD VSS sg13g2_decap_8
XFILLER_174_827 VDD VSS sg13g2_decap_8
Xmax_cap1300 output64/A _16858_/A VDD VSS sg13g2_buf_4
XFILLER_16_1160 VDD VSS sg13g2_decap_8
XFILLER_185_175 VDD VSS sg13g2_decap_8
X_13456_ _13456_/X _15190_/Q _15191_/Q _15192_/Q _13463_/D VDD VSS sg13g2_or4_1
XFILLER_70_7 VDD VSS sg13g2_decap_8
X_10668_ _10802_/A _15060_/Q _10697_/B _14926_/Q VDD VSS sg13g2_a21oi_1
XFILLER_51_1073 VDD VSS sg13g2_decap_8
XFILLER_9_399 VDD VSS sg13g2_decap_8
X_12407_ _12407_/X _14239_/Q _14271_/Q _14303_/Q _14335_/Q _12411_/S0 _12411_/S1 VDD
+ VSS sg13g2_mux4_1
XFILLER_103_1163 VDD VSS sg13g2_decap_8
XFILLER_173_359 VDD VSS sg13g2_decap_8
XFILLER_12_1057 VDD VSS sg13g2_decap_8
X_13387_ _15082_/D _13367_/Y _13378_/C _13386_/Y VDD VSS sg13g2_o21ai_1
X_10599_ _14876_/D _10608_/B _10599_/B _10610_/D VDD VSS sg13g2_nor3_1
XFILLER_177_1242 VDD VSS sg13g2_fill_2
XFILLER_154_562 VDD VSS sg13g2_decap_8
Xoutput107 mem_axi_wdata[12] _15144_/Q VDD VSS sg13g2_buf_1
XFILLER_126_264 VDD VSS sg13g2_decap_8
X_15126_ _15126_/Q _15219_/CLK _15126_/D _15126_/RESET_B VDD VSS sg13g2_dfrbpq_1
Xoutput118 mem_axi_wdata[22] _15154_/Q VDD VSS sg13g2_buf_1
XFILLER_126_275 VDD VSS sg13g2_fill_2
Xoutput129 mem_axi_wdata[3] _15135_/Q VDD VSS sg13g2_buf_1
X_12338_ _12338_/Y _14925_/Q _11792_/B _12334_/Y _12337_/Y VDD VSS sg13g2_a22oi_1
XFILLER_138_1226 VDD VSS sg13g2_decap_8
XFILLER_141_201 VDD VSS sg13g2_decap_8
XFILLER_138_1237 VDD VSS sg13g2_fill_2
XFILLER_86_1169 VDD VSS sg13g2_decap_8
XFILLER_181_392 VDD VSS sg13g2_decap_8
XFILLER_177_1297 VDD VSS sg13g2_decap_8
XFILLER_142_768 VDD VSS sg13g2_decap_8
X_15057_ _15057_/Q _15219_/CLK _15057_/D _15057_/RESET_B VDD VSS sg13g2_dfrbpq_1
XFILLER_130_919 VDD VSS sg13g2_decap_4
X_12269_ _12270_/B _12231_/X _12156_/A _12268_/Y VDD VSS sg13g2_a21oi_1
XFILLER_151_1404 VDD VSS sg13g2_decap_8
X_14008_ _14008_/Q clkload24/A _14008_/D _14008_/RESET_B VDD VSS sg13g2_dfrbpq_1
XFILLER_96_833 VDD VSS sg13g2_decap_8
XFILLER_110_632 VDD VSS sg13g2_decap_8
XFILLER_68_546 VDD VSS sg13g2_decap_8
XFILLER_95_332 VDD VSS sg13g2_fill_2
XFILLER_96_877 VDD VSS sg13g2_decap_8
XFILLER_23_1120 VDD VSS sg13g2_decap_8
XFILLER_95_365 VDD VSS sg13g2_decap_8
XFILLER_110_676 VDD VSS sg13g2_fill_2
X_13818__2454 _13818_/RESET_B VDD VSS sg13g2_tiehi
XFILLER_7_1372 VDD VSS sg13g2_decap_8
X_14578__1694 _14578_/RESET_B VDD VSS sg13g2_tiehi
XFILLER_37_911 VDD VSS sg13g2_fill_2
XFILLER_3_1225 VDD VSS sg13g2_decap_8
XFILLER_97_1221 VDD VSS sg13g2_decap_8
X_08500_ _08501_/B _08527_/B _08498_/Y _08499_/Y VDD VSS sg13g2_a21o_1
XFILLER_48_292 VDD VSS sg13g2_decap_8
XFILLER_58_1205 VDD VSS sg13g2_decap_8
XFILLER_36_443 VDD VSS sg13g2_fill_2
XFILLER_23_1197 VDD VSS sg13g2_decap_8
X_09480_ _14080_/D _10043_/A0 _14080_/Q _09501_/S VDD VSS sg13g2_mux2_1
XFILLER_110_1178 VDD VSS sg13g2_decap_4
XFILLER_149_1344 VDD VSS sg13g2_fill_2
XFILLER_58_1227 VDD VSS sg13g2_fill_2
XFILLER_58_1238 VDD VSS sg13g2_fill_1
XFILLER_110_1189 VDD VSS sg13g2_decap_8
X_08431_ _08431_/X _08431_/A _08544_/B _08452_/C _08431_/D VDD VSS sg13g2_and4_1
XFILLER_24_627 VDD VSS sg13g2_decap_8
XFILLER_51_424 VDD VSS sg13g2_decap_4
XFILLER_52_958 VDD VSS sg13g2_decap_8
XFILLER_52_969 VDD VSS sg13g2_fill_2
XFILLER_149_1399 VDD VSS sg13g2_decap_8
X_08362_ _08362_/X _07790_/A _07782_/A _07786_/A _08306_/C _08598_/S0 _08598_/S1 VDD
+ VSS sg13g2_mux4_1
XFILLER_149_312 VDD VSS sg13g2_decap_4
XFILLER_147_1090 VDD VSS sg13g2_decap_8
XFILLER_20_833 VDD VSS sg13g2_decap_8
X_08293_ _15228_/D _08293_/A _08293_/B VDD VSS sg13g2_nand2_1
XFILLER_177_676 VDD VSS sg13g2_decap_8
XFILLER_108_1096 VDD VSS sg13g2_decap_8
XFILLER_149_378 VDD VSS sg13g2_fill_1
XFILLER_165_838 VDD VSS sg13g2_decap_8
XFILLER_176_175 VDD VSS sg13g2_decap_8
XFILLER_178_1039 VDD VSS sg13g2_decap_8
XFILLER_173_860 VDD VSS sg13g2_decap_8
XFILLER_106_916 VDD VSS sg13g2_decap_8
XFILLER_105_415 VDD VSS sg13g2_decap_8
XFILLER_132_201 VDD VSS sg13g2_decap_8
XFILLER_133_735 VDD VSS sg13g2_decap_8
XFILLER_145_595 VDD VSS sg13g2_decap_4
XFILLER_156_1326 VDD VSS sg13g2_decap_8
XFILLER_156_1348 VDD VSS sg13g2_decap_4
XFILLER_160_543 VDD VSS sg13g2_decap_8
XFILLER_121_908 VDD VSS sg13g2_fill_2
XFILLER_28_1020 VDD VSS sg13g2_fill_1
Xfanout301 _09440_/S _09408_/Y VDD VSS sg13g2_buf_1
XFILLER_28_1031 VDD VSS sg13g2_fill_1
Xfanout312 _10144_/A1 _09613_/A0 VDD VSS sg13g2_buf_1
XFILLER_119_1170 VDD VSS sg13g2_decap_4
XFILLER_115_1012 VDD VSS sg13g2_decap_4
XFILLER_87_844 VDD VSS sg13g2_decap_8
Xfanout345 _09965_/S _09969_/S VDD VSS sg13g2_buf_1
XFILLER_113_492 VDD VSS sg13g2_decap_4
Xfanout356 _09865_/S _09871_/S VDD VSS sg13g2_buf_1
Xfanout367 _09770_/S fanout367/A VDD VSS sg13g2_buf_1
X_09816_ _14404_/D _09882_/A0 _14404_/Q _09833_/S VDD VSS sg13g2_mux2_1
XFILLER_8_1169 VDD VSS sg13g2_decap_8
Xfanout378 _09706_/S _09703_/S VDD VSS sg13g2_buf_1
XFILLER_87_877 VDD VSS sg13g2_decap_4
XFILLER_41_1220 VDD VSS sg13g2_decap_8
XFILLER_28_900 VDD VSS sg13g2_decap_4
X_14408__1864 _14408_/RESET_B VDD VSS sg13g2_tiehi
X_09747_ _14337_/D _14337_/Q _09912_/A1 _09771_/S VDD VSS sg13g2_mux2_1
XFILLER_39_270 VDD VSS sg13g2_decap_4
XFILLER_27_421 VDD VSS sg13g2_decap_8
XFILLER_167_1422 VDD VSS sg13g2_decap_8
XFILLER_41_1297 VDD VSS sg13g2_decap_8
X_09678_ _14270_/D _10141_/A1 _14270_/Q _09706_/S VDD VSS sg13g2_mux2_1
XFILLER_36_56 VDD VSS sg13g2_decap_8
XFILLER_15_616 VDD VSS sg13g2_decap_8
XFILLER_76_1338 VDD VSS sg13g2_decap_8
XFILLER_128_1417 VDD VSS sg13g2_decap_4
X_08629_ _08629_/Y _08641_/B _08611_/Y _07966_/Y VDD VSS sg13g2_a21oi_1
XFILLER_27_498 VDD VSS sg13g2_decap_8
XFILLER_43_958 VDD VSS sg13g2_fill_1
XFILLER_14_126 VDD VSS sg13g2_decap_8
XFILLER_70_755 VDD VSS sg13g2_decap_8
XFILLER_74_1040 VDD VSS sg13g2_fill_1
X_11640_ _11774_/A _11638_/X _11639_/Y _11590_/Y VDD VSS sg13g2_a21oi_1
XFILLER_52_11 VDD VSS sg13g2_fill_1
XFILLER_35_1013 VDD VSS sg13g2_decap_4
XFILLER_165_1190 VDD VSS sg13g2_fill_2
XFILLER_11_833 VDD VSS sg13g2_decap_8
X_11571_ _11571_/Y _11638_/A _11638_/C _11571_/C VDD VSS sg13g2_nor3_1
XFILLER_126_1174 VDD VSS sg13g2_decap_8
XFILLER_35_1057 VDD VSS sg13g2_decap_8
XFILLER_183_602 VDD VSS sg13g2_fill_2
XFILLER_155_304 VDD VSS sg13g2_decap_8
XFILLER_168_687 VDD VSS sg13g2_fill_2
X_13310_ _13310_/Y _15071_/Q _13305_/B _13307_/Y _13310_/B2 _13308_/Y VDD VSS sg13g2_a221oi_1
XFILLER_10_343 VDD VSS sg13g2_decap_8
XFILLER_122_1038 VDD VSS sg13g2_decap_4
XFILLER_156_838 VDD VSS sg13g2_fill_1
X_10522_ _14856_/D _13155_/A _10522_/B _10531_/D VDD VSS sg13g2_nor3_1
XFILLER_52_99 VDD VSS sg13g2_decap_8
XFILLER_168_77 VDD VSS sg13g2_decap_8
X_14290_ _14290_/Q clkload22/A _14290_/D _14290_/RESET_B VDD VSS sg13g2_dfrbpq_1
XFILLER_7_826 VDD VSS sg13g2_decap_8
XFILLER_182_112 VDD VSS sg13g2_decap_8
XFILLER_183_635 VDD VSS sg13g2_decap_4
XFILLER_52_1371 VDD VSS sg13g2_decap_8
XFILLER_109_732 VDD VSS sg13g2_decap_8
XFILLER_13_1344 VDD VSS sg13g2_decap_8
XFILLER_155_348 VDD VSS sg13g2_fill_2
XFILLER_171_808 VDD VSS sg13g2_decap_8
X_13241_ _13242_/B _13245_/A _13665_/Q _13246_/C VDD VSS sg13g2_a21oi_1
X_10453_ _10453_/X _14840_/Q _14839_/Q _10453_/C _10514_/A VDD VSS sg13g2_and4_1
XFILLER_87_1412 VDD VSS sg13g2_decap_8
XFILLER_6_336 VDD VSS sg13g2_decap_8
XFILLER_108_242 VDD VSS sg13g2_fill_2
XFILLER_109_765 VDD VSS sg13g2_fill_1
XFILLER_87_1434 VDD VSS sg13g2_fill_2
XFILLER_184_21 VDD VSS sg13g2_decap_8
XFILLER_136_573 VDD VSS sg13g2_decap_8
XFILLER_182_189 VDD VSS sg13g2_decap_8
X_13172_ _13172_/X _13172_/A _13172_/B _13172_/C _13172_/D VDD VSS sg13g2_and4_1
X_10384_ _10398_/D _14818_/Q _14819_/Q _10396_/C VDD VSS sg13g2_and3_1
XFILLER_136_595 VDD VSS sg13g2_decap_8
XFILLER_87_1467 VDD VSS sg13g2_decap_8
XFILLER_87_1478 VDD VSS sg13g2_fill_1
XFILLER_112_908 VDD VSS sg13g2_decap_4
X_12123_ _12123_/Y _12124_/A2 _12122_/Y _12082_/B VDD VSS sg13g2_o21ai_1
XFILLER_7_0 VDD VSS sg13g2_decap_8
XFILLER_184_98 VDD VSS sg13g2_decap_8
XFILLER_2_553 VDD VSS sg13g2_decap_8
XFILLER_123_278 VDD VSS sg13g2_decap_8
X_12054_ _12054_/Y _12055_/C _12055_/D VDD VSS sg13g2_nor2_1
XFILLER_81_1022 VDD VSS sg13g2_decap_8
XFILLER_89_170 VDD VSS sg13g2_decap_8
XFILLER_81_1055 VDD VSS sg13g2_decap_4
XFILLER_42_1006 VDD VSS sg13g2_fill_2
XFILLER_77_63 VDD VSS sg13g2_decap_8
XFILLER_172_1183 VDD VSS sg13g2_decap_4
X_11005_ _11005_/X _11005_/A _11007_/A VDD VSS sg13g2_or2_1
X_16862_ _16862_/X _16862_/A VDD VSS sg13g2_buf_1
XFILLER_77_354 VDD VSS sg13g2_decap_8
XFILLER_133_1167 VDD VSS sg13g2_fill_2
XFILLER_19_911 VDD VSS sg13g2_decap_8
XFILLER_93_825 VDD VSS sg13g2_decap_8
XFILLER_120_996 VDD VSS sg13g2_decap_8
Xfanout890 _12787_/S1 _12702_/S1 VDD VSS sg13g2_buf_1
XFILLER_93_836 VDD VSS sg13g2_fill_1
XFILLER_20_1315 VDD VSS sg13g2_decap_8
XFILLER_93_858 VDD VSS sg13g2_fill_2
XFILLER_92_335 VDD VSS sg13g2_fill_1
X_15108__2838 _15108_/RESET_B VDD VSS sg13g2_tiehi
X_12956_ _15030_/D _12956_/A _12956_/B VDD VSS sg13g2_and2_1
XFILLER_46_763 VDD VSS sg13g2_decap_8
XFILLER_34_903 VDD VSS sg13g2_decap_8
XFILLER_18_476 VDD VSS sg13g2_decap_8
XFILLER_93_84 VDD VSS sg13g2_decap_8
X_11907_ _11907_/X _11907_/A _11907_/B _11910_/B _11910_/C VDD VSS sg13g2_or4_1
X_12887_ _12887_/Y _12886_/Y _13048_/B _12882_/Y VDD VSS sg13g2_a21oi_1
XFILLER_45_295 VDD VSS sg13g2_decap_8
X_14626_ _14626_/Q clkload45/A _14626_/D _14626_/RESET_B VDD VSS sg13g2_dfrbpq_1
X_11838_ _11839_/B _11800_/Y _11868_/A _11837_/Y VDD VSS sg13g2_a21oi_1
XFILLER_61_799 VDD VSS sg13g2_decap_8
X_15149__2752 _15149_/RESET_B VDD VSS sg13g2_tiehi
XFILLER_60_276 VDD VSS sg13g2_decap_8
XFILLER_57_1293 VDD VSS sg13g2_decap_8
XFILLER_159_643 VDD VSS sg13g2_decap_8
XFILLER_18_1255 VDD VSS sg13g2_decap_8
XFILLER_14_693 VDD VSS sg13g2_decap_8
X_14557_ _14557_/Q _14685_/CLK _14557_/D _14557_/RESET_B VDD VSS sg13g2_dfrbpq_1
XFILLER_105_1214 VDD VSS sg13g2_decap_8
XFILLER_144_1263 VDD VSS sg13g2_decap_8
X_11769_ _14972_/D _11729_/Y _11768_/Y _11724_/Y VDD VSS sg13g2_a21oi_1
XFILLER_140_1105 VDD VSS sg13g2_decap_8
XFILLER_186_462 VDD VSS sg13g2_decap_8
XFILLER_186_473 VDD VSS sg13g2_decap_8
X_13508_ _13508_/X _13613_/A _13508_/B _13508_/C VDD VSS sg13g2_and3_1
XFILLER_159_698 VDD VSS sg13g2_fill_1
XFILLER_174_624 VDD VSS sg13g2_decap_8
XFILLER_179_1304 VDD VSS sg13g2_decap_8
X_14488_ _14488_/Q clkload25/A _14488_/D _14488_/RESET_B VDD VSS sg13g2_dfrbpq_1
XFILLER_173_112 VDD VSS sg13g2_decap_8
XFILLER_146_348 VDD VSS sg13g2_decap_8
XFILLER_9_196 VDD VSS sg13g2_decap_8
XFILLER_162_808 VDD VSS sg13g2_decap_8
X_13439_ _15101_/D _13435_/B _13438_/Y _13437_/Y VDD VSS sg13g2_o21ai_1
XFILLER_31_1455 VDD VSS sg13g2_decap_8
XFILLER_161_307 VDD VSS sg13g2_decap_8
XFILLER_127_562 VDD VSS sg13g2_fill_2
XFILLER_173_189 VDD VSS sg13g2_decap_8
XFILLER_177_1050 VDD VSS sg13g2_decap_8
XFILLER_170_841 VDD VSS sg13g2_decap_8
X_14061__2211 _14061_/RESET_B VDD VSS sg13g2_tiehi
X_15109_ _15109_/Q clkload87/A _15109_/D _15109_/RESET_B VDD VSS sg13g2_dfrbpq_1
XFILLER_114_245 VDD VSS sg13g2_decap_8
XFILLER_138_1056 VDD VSS sg13g2_fill_1
X_08980_ _08980_/X _15024_/Q _15221_/Q _13305_/A VDD VSS sg13g2_mux2_1
XFILLER_102_407 VDD VSS sg13g2_fill_2
XFILLER_142_576 VDD VSS sg13g2_decap_8
XFILLER_87_107 VDD VSS sg13g2_decap_8
XFILLER_69_811 VDD VSS sg13g2_decap_8
XFILLER_130_738 VDD VSS sg13g2_decap_8
X_07931_ _08286_/B _14998_/Q _08258_/C VDD VSS sg13g2_nor2b_1
XFILLER_130_749 VDD VSS sg13g2_fill_2
XFILLER_64_1253 VDD VSS sg13g2_decap_8
XFILLER_29_1373 VDD VSS sg13g2_fill_2
XFILLER_123_790 VDD VSS sg13g2_decap_8
X_14665__1607 _14665_/RESET_B VDD VSS sg13g2_tiehi
XFILLER_116_1343 VDD VSS sg13g2_decap_8
XFILLER_9_1456 VDD VSS sg13g2_decap_8
XFILLER_60_1128 VDD VSS sg13g2_decap_8
XFILLER_5_1309 VDD VSS sg13g2_decap_8
XFILLER_151_1245 VDD VSS sg13g2_decap_8
X_14701__1571 _14701_/RESET_B VDD VSS sg13g2_tiehi
X_07862_ _07862_/Y _08608_/A _08608_/B VDD VSS sg13g2_nor2_1
XFILLER_110_451 VDD VSS sg13g2_decap_8
XFILLER_25_1259 VDD VSS sg13g2_decap_8
X_09601_ _14198_/D _14198_/Q _09933_/A1 _09601_/S VDD VSS sg13g2_mux2_1
XFILLER_99_1338 VDD VSS sg13g2_decap_8
X_14094__2178 _14094_/RESET_B VDD VSS sg13g2_tiehi
XFILLER_56_538 VDD VSS sg13g2_decap_8
XFILLER_186_1308 VDD VSS sg13g2_decap_8
X_07793_ _07793_/Y _08383_/B _08383_/A VDD VSS sg13g2_nor2b_1
XFILLER_95_195 VDD VSS sg13g2_decap_8
XFILLER_3_1022 VDD VSS sg13g2_decap_8
XFILLER_186_1319 VDD VSS sg13g2_decap_8
XFILLER_37_741 VDD VSS sg13g2_decap_8
X_09532_ _14131_/D _10095_/A0 _14131_/Q _09534_/S VDD VSS sg13g2_mux2_1
XFILLER_97_1062 VDD VSS sg13g2_decap_4
XFILLER_92_880 VDD VSS sg13g2_decap_4
XFILLER_3_1099 VDD VSS sg13g2_decap_8
X_09463_ _14064_/D _10026_/A0 _14064_/Q wire504/X VDD VSS sg13g2_mux2_1
XFILLER_24_435 VDD VSS sg13g2_decap_8
X_15033__2647 _15033_/RESET_B VDD VSS sg13g2_tiehi
XFILLER_58_1057 VDD VSS sg13g2_decap_8
XFILLER_149_1196 VDD VSS sg13g2_fill_2
X_08414_ _08415_/B _08414_/A _08414_/B _08414_/C _08414_/D VDD VSS sg13g2_nor4_1
XFILLER_36_1300 VDD VSS sg13g2_decap_4
XFILLER_36_1311 VDD VSS sg13g2_decap_8
X_09394_ _13997_/D _09625_/A0 _13997_/Q _09394_/S VDD VSS sg13g2_mux2_1
XFILLER_178_941 VDD VSS sg13g2_decap_8
X_08345_ _08346_/B _08241_/A _08177_/X _08344_/Y VDD VSS sg13g2_o21ai_1
XFILLER_51_298 VDD VSS sg13g2_fill_1
XFILLER_149_131 VDD VSS sg13g2_decap_8
XFILLER_177_462 VDD VSS sg13g2_decap_8
XFILLER_22_14 VDD VSS sg13g2_decap_8
XFILLER_165_613 VDD VSS sg13g2_decap_4
X_08276_ _08276_/X _08276_/A _08276_/B VDD VSS sg13g2_or2_1
XFILLER_138_849 VDD VSS sg13g2_decap_8
XFILLER_149_186 VDD VSS sg13g2_decap_8
XFILLER_164_112 VDD VSS sg13g2_fill_2
XFILLER_165_646 VDD VSS sg13g2_decap_8
XFILLER_121_1060 VDD VSS sg13g2_decap_8
XFILLER_138_58 VDD VSS sg13g2_decap_8
XFILLER_180_616 VDD VSS sg13g2_decap_8
Xclkbuf_leaf_0_clk_i clkload6/A clkbuf_leaf_5_clk_i/A VDD VSS sg13g2_buf_8
XFILLER_0_7 VDD VSS sg13g2_decap_8
XFILLER_156_1156 VDD VSS sg13g2_decap_8
XFILLER_154_35 VDD VSS sg13g2_decap_4
XFILLER_152_1009 VDD VSS sg13g2_decap_8
X_14926__2785 _14926_/RESET_B VDD VSS sg13g2_tiehi
XFILLER_154_57 VDD VSS sg13g2_decap_8
Xfanout1107 _08560_/A _08599_/A VDD VSS sg13g2_buf_1
XFILLER_102_930 VDD VSS sg13g2_decap_4
Xfanout1118 _08194_/B _08599_/B VDD VSS sg13g2_buf_1
XFILLER_82_1353 VDD VSS sg13g2_decap_8
Xfanout1129 _08278_/S1 _13521_/A VDD VSS sg13g2_buf_1
XFILLER_87_630 VDD VSS sg13g2_decap_8
XFILLER_59_321 VDD VSS sg13g2_fill_2
Xfanout142 _09739_/A0 _09638_/A0 VDD VSS sg13g2_buf_1
XFILLER_120_259 VDD VSS sg13g2_decap_8
XFILLER_134_1454 VDD VSS sg13g2_fill_1
X_14787__3019 _14787_/RESET_B VDD VSS sg13g2_tiehi
Xfanout153 _09770_/A1 _10167_/A1 VDD VSS sg13g2_buf_1
XFILLER_87_663 VDD VSS sg13g2_decap_8
Xfanout164 _09933_/A1 _09634_/A0 VDD VSS sg13g2_buf_1
XFILLER_75_814 VDD VSS sg13g2_decap_8
Xfanout175 _10096_/A0 _09931_/A1 VDD VSS sg13g2_buf_1
XFILLER_102_996 VDD VSS sg13g2_decap_8
Xfanout186 _09929_/A1 _09111_/Y VDD VSS sg13g2_buf_1
XFILLER_86_162 VDD VSS sg13g2_fill_1
XFILLER_59_376 VDD VSS sg13g2_decap_8
Xfanout197 _09462_/A0 _09091_/Y VDD VSS sg13g2_buf_1
XFILLER_86_184 VDD VSS sg13g2_decap_8
XFILLER_47_66 VDD VSS sg13g2_decap_4
XFILLER_170_56 VDD VSS sg13g2_decap_8
X_12810_ _12810_/Y _12806_/Y _12807_/Y _12809_/Y VDD VSS sg13g2_a21oi_1
XFILLER_28_752 VDD VSS sg13g2_decap_8
X_13790_ _13790_/Q clkload50/A _13790_/D _13790_/RESET_B VDD VSS sg13g2_dfrbpq_1
XFILLER_90_839 VDD VSS sg13g2_decap_8
XFILLER_43_711 VDD VSS sg13g2_decap_8
XFILLER_27_262 VDD VSS sg13g2_decap_8
XFILLER_15_413 VDD VSS sg13g2_decap_8
X_12741_ _12741_/X _14711_/Q _14743_/Q _13783_/Q _13815_/Q _12742_/S0 _12756_/S1 VDD
+ VSS sg13g2_mux4_1
XFILLER_63_21 VDD VSS sg13g2_fill_2
XFILLER_55_593 VDD VSS sg13g2_decap_8
XFILLER_128_1214 VDD VSS sg13g2_fill_2
XFILLER_70_530 VDD VSS sg13g2_decap_8
XFILLER_179_21 VDD VSS sg13g2_decap_8
X_15009__2671 _15009_/RESET_B VDD VSS sg13g2_tiehi
X_12672_ _12672_/X _14578_/Q _14610_/Q _14642_/Q _14674_/Q _12675_/S0 _12675_/S1 VDD
+ VSS sg13g2_mux4_1
XFILLER_93_1471 VDD VSS sg13g2_decap_8
XFILLER_43_788 VDD VSS sg13g2_decap_4
XFILLER_42_265 VDD VSS sg13g2_decap_8
XFILLER_144_0 VDD VSS sg13g2_decap_8
X_14411_ _14411_/Q _14513_/CLK _14411_/D _14411_/RESET_B VDD VSS sg13g2_dfrbpq_1
XFILLER_70_596 VDD VSS sg13g2_decap_4
XFILLER_54_1433 VDD VSS sg13g2_decap_8
X_11623_ _11623_/Y _11599_/Y _11601_/Y _12000_/A VDD VSS sg13g2_a21oi_1
XFILLER_54_1444 VDD VSS sg13g2_fill_2
XFILLER_169_963 VDD VSS sg13g2_decap_8
XFILLER_11_630 VDD VSS sg13g2_decap_8
XFILLER_15_1417 VDD VSS sg13g2_decap_8
XFILLER_179_98 VDD VSS sg13g2_decap_8
XFILLER_129_816 VDD VSS sg13g2_decap_8
X_14818__2988 _14818_/RESET_B VDD VSS sg13g2_tiehi
XFILLER_50_1308 VDD VSS sg13g2_decap_8
XFILLER_8_49 VDD VSS sg13g2_decap_8
XFILLER_50_1319 VDD VSS sg13g2_fill_2
X_14342_ _14342_/Q _14662_/CLK _14342_/D _14342_/RESET_B VDD VSS sg13g2_dfrbpq_1
XFILLER_10_140 VDD VSS sg13g2_decap_8
X_11554_ _11554_/Y _11550_/Y _11551_/Y _11553_/Y _11552_/Y _12239_/B VDD VSS sg13g2_a221oi_1
XFILLER_128_326 VDD VSS sg13g2_decap_8
XFILLER_155_112 VDD VSS sg13g2_decap_8
X_14743__1529 _14743_/RESET_B VDD VSS sg13g2_tiehi
XFILLER_7_623 VDD VSS sg13g2_decap_8
XFILLER_156_657 VDD VSS sg13g2_decap_8
XFILLER_13_1141 VDD VSS sg13g2_decap_8
X_10505_ _10654_/A _10514_/A _10505_/B _10505_/C _10505_/D VDD VSS sg13g2_nand4_1
X_14273_ _14273_/Q _14745_/CLK _14273_/D _14273_/RESET_B VDD VSS sg13g2_dfrbpq_1
XFILLER_6_133 VDD VSS sg13g2_decap_8
X_11485_ _11485_/Y _11485_/A _11485_/B VDD VSS sg13g2_xnor2_1
XFILLER_183_476 VDD VSS sg13g2_decap_8
XFILLER_104_1291 VDD VSS sg13g2_decap_8
XFILLER_155_178 VDD VSS sg13g2_decap_8
XFILLER_109_573 VDD VSS sg13g2_decap_8
XFILLER_143_329 VDD VSS sg13g2_decap_8
X_13224_ _13226_/B _13224_/A _13215_/A VDD VSS sg13g2_nor2b_1
X_10436_ _10436_/Y _14835_/Q _10443_/D _10544_/C VDD VSS sg13g2_o21ai_1
XFILLER_12_91 VDD VSS sg13g2_decap_8
XFILLER_170_126 VDD VSS sg13g2_decap_8
XFILLER_171_649 VDD VSS sg13g2_decap_8
XFILLER_48_1204 VDD VSS sg13g2_decap_8
XFILLER_3_840 VDD VSS sg13g2_decap_8
XFILLER_100_1188 VDD VSS sg13g2_decap_8
XFILLER_151_340 VDD VSS sg13g2_fill_1
XFILLER_170_159 VDD VSS sg13g2_fill_1
X_13155_ _15043_/D _13155_/A _13155_/B VDD VSS sg13g2_nor2_1
X_10367_ _10400_/C _14812_/Q _14813_/Q _14814_/Q VDD VSS sg13g2_nand3_1
XFILLER_98_928 VDD VSS sg13g2_decap_8
XFILLER_151_351 VDD VSS sg13g2_decap_8
XFILLER_139_1387 VDD VSS sg13g2_decap_8
XFILLER_69_107 VDD VSS sg13g2_decap_8
XFILLER_2_350 VDD VSS sg13g2_decap_8
X_12106_ _12106_/Y _12102_/Y _12103_/Y _12105_/Y _12104_/Y _12317_/B VDD VSS sg13g2_a221oi_1
XFILLER_124_598 VDD VSS sg13g2_decap_8
XFILLER_33_7 VDD VSS sg13g2_decap_8
X_13086_ _13087_/B _13166_/A1 _13081_/X _13085_/Y _13140_/B2 _13080_/Y VDD VSS sg13g2_a221oi_1
X_10298_ _10299_/C _14791_/Q _14792_/Q _14793_/Q _10298_/D VDD VSS sg13g2_nand4_1
XFILLER_61_1404 VDD VSS sg13g2_decap_8
X_12037_ _12037_/Y _12040_/A1 _14130_/Q VDD VSS sg13g2_nand2b_1
XFILLER_61_1459 VDD VSS sg13g2_decap_8
XFILLER_120_793 VDD VSS sg13g2_decap_8
XFILLER_92_110 VDD VSS sg13g2_fill_2
XFILLER_20_1112 VDD VSS sg13g2_decap_8
XFILLER_65_346 VDD VSS sg13g2_decap_8
XFILLER_24_1281 VDD VSS sg13g2_decap_8
XFILLER_111_1240 VDD VSS sg13g2_decap_8
XFILLER_53_508 VDD VSS sg13g2_fill_2
X_13988_ _13988_/Q _14503_/CLK _13988_/D _13988_/RESET_B VDD VSS sg13g2_dfrbpq_1
XFILLER_19_785 VDD VSS sg13g2_fill_2
XFILLER_4_1386 VDD VSS sg13g2_decap_8
XFILLER_185_1330 VDD VSS sg13g2_decap_8
XFILLER_18_273 VDD VSS sg13g2_decap_8
X_12939_ _12939_/Y _12934_/Y _12938_/Y _12933_/Y VDD VSS sg13g2_o21ai_1
XFILLER_92_198 VDD VSS sg13g2_decap_8
XFILLER_20_1189 VDD VSS sg13g2_decap_8
XFILLER_22_939 VDD VSS sg13g2_decap_8
X_14609_ _14609_/Q clkload7/A _14609_/D _14609_/RESET_B VDD VSS sg13g2_dfrbpq_1
XFILLER_178_259 VDD VSS sg13g2_decap_8
XFILLER_57_1090 VDD VSS sg13g2_decap_8
XFILLER_18_1052 VDD VSS sg13g2_decap_8
XFILLER_21_449 VDD VSS sg13g2_decap_8
XFILLER_109_1180 VDD VSS sg13g2_decap_8
XFILLER_14_490 VDD VSS sg13g2_decap_8
XFILLER_105_1022 VDD VSS sg13g2_decap_4
XFILLER_109_1191 VDD VSS sg13g2_fill_1
X_08130_ _08130_/Y _08129_/X _08223_/S VDD VSS sg13g2_nand2b_1
XFILLER_119_315 VDD VSS sg13g2_fill_2
XFILLER_175_955 VDD VSS sg13g2_decap_4
XFILLER_175_966 VDD VSS sg13g2_fill_1
XFILLER_179_1123 VDD VSS sg13g2_fill_1
XFILLER_174_443 VDD VSS sg13g2_decap_8
X_14719__1553 _14719_/RESET_B VDD VSS sg13g2_tiehi
X_08061_ _08061_/Y _08060_/X _08428_/S VDD VSS sg13g2_nand2b_1
XFILLER_162_605 VDD VSS sg13g2_decap_8
XFILLER_179_1145 VDD VSS sg13g2_decap_8
XFILLER_105_1099 VDD VSS sg13g2_decap_4
XFILLER_128_871 VDD VSS sg13g2_decap_8
XFILLER_161_104 VDD VSS sg13g2_decap_8
XFILLER_127_370 VDD VSS sg13g2_decap_4
XFILLER_157_1421 VDD VSS sg13g2_decap_8
XFILLER_66_1304 VDD VSS sg13g2_decap_8
XFILLER_157_1432 VDD VSS sg13g2_fill_1
XFILLER_115_543 VDD VSS sg13g2_decap_8
XFILLER_143_852 VDD VSS sg13g2_decap_8
XFILLER_161_148 VDD VSS sg13g2_decap_8
XFILLER_89_906 VDD VSS sg13g2_decap_8
XFILLER_89_917 VDD VSS sg13g2_fill_2
XFILLER_157_1454 VDD VSS sg13g2_fill_1
XFILLER_103_716 VDD VSS sg13g2_fill_2
Xhold3204 _13639_/A _13747_/Q VDD VSS sg13g2_dlygate4sd3_1
XFILLER_66_1348 VDD VSS sg13g2_decap_8
Xhold3215 _13629_/A _13737_/Q VDD VSS sg13g2_dlygate4sd3_1
XFILLER_170_682 VDD VSS sg13g2_decap_8
Xhold3226 _10903_/A _14935_/Q VDD VSS sg13g2_dlygate4sd3_1
XFILLER_103_738 VDD VSS sg13g2_decap_8
Xhold3237 _10929_/A _14937_/Q VDD VSS sg13g2_dlygate4sd3_1
X_08963_ _10037_/B _10004_/B _09707_/C VDD VSS sg13g2_nor2_1
Xhold3248 _10875_/A _14933_/Q VDD VSS sg13g2_dlygate4sd3_1
Xhold3259 _13523_/A _15141_/Q VDD VSS sg13g2_dlygate4sd3_1
XFILLER_102_248 VDD VSS sg13g2_decap_4
XFILLER_9_1253 VDD VSS sg13g2_decap_8
XFILLER_69_641 VDD VSS sg13g2_decap_8
X_07914_ _07914_/Y _08105_/A _08103_/B _07913_/Y VDD VSS sg13g2_o21ai_1
XFILLER_25_1023 VDD VSS sg13g2_decap_4
XFILLER_5_1106 VDD VSS sg13g2_decap_8
X_08894_ _08894_/X _15037_/Q _10743_/S _08893_/Y VDD VSS sg13g2_a21o_1
XFILLER_69_674 VDD VSS sg13g2_decap_8
XFILLER_151_1064 VDD VSS sg13g2_fill_2
XFILLER_84_622 VDD VSS sg13g2_decap_8
XFILLER_151_1075 VDD VSS sg13g2_decap_4
X_07845_ _08678_/C _15017_/Q _07972_/B VDD VSS sg13g2_nand2_1
XFILLER_99_1146 VDD VSS sg13g2_decap_4
XFILLER_68_195 VDD VSS sg13g2_decap_8
XFILLER_17_14 VDD VSS sg13g2_decap_8
XFILLER_83_132 VDD VSS sg13g2_decap_8
XFILLER_77_1400 VDD VSS sg13g2_decap_8
X_07776_ _07776_/Y _08276_/B _08276_/A VDD VSS sg13g2_nor2b_1
XFILLER_37_560 VDD VSS sg13g2_fill_1
X_09515_ _14114_/D _10078_/A0 _14114_/Q _09534_/S VDD VSS sg13g2_mux2_1
XFILLER_83_187 VDD VSS sg13g2_decap_8
XFILLER_71_327 VDD VSS sg13g2_decap_8
XFILLER_140_48 VDD VSS sg13g2_decap_4
XFILLER_25_733 VDD VSS sg13g2_decap_8
XFILLER_164_1425 VDD VSS sg13g2_decap_4
XFILLER_77_1477 VDD VSS sg13g2_fill_2
XFILLER_13_917 VDD VSS sg13g2_decap_8
X_09446_ _14047_/D _10075_/A0 _14047_/Q _09461_/S VDD VSS sg13g2_mux2_1
XFILLER_80_872 VDD VSS sg13g2_decap_8
XFILLER_52_563 VDD VSS sg13g2_fill_1
XFILLER_169_226 VDD VSS sg13g2_fill_1
XFILLER_52_585 VDD VSS sg13g2_decap_8
XFILLER_12_427 VDD VSS sg13g2_decap_8
XFILLER_71_1010 VDD VSS sg13g2_decap_8
XFILLER_33_35 VDD VSS sg13g2_decap_8
X_09377_ _13980_/D _10039_/A0 _13980_/Q _09395_/S VDD VSS sg13g2_mux2_1
XFILLER_149_35 VDD VSS sg13g2_decap_8
XFILLER_138_613 VDD VSS sg13g2_decap_8
XFILLER_184_229 VDD VSS sg13g2_decap_8
X_08328_ _08329_/A _08235_/X _08327_/X _08511_/S VDD VSS sg13g2_mux2_1
XFILLER_123_1144 VDD VSS sg13g2_fill_2
XFILLER_21_983 VDD VSS sg13g2_decap_4
XFILLER_36_1196 VDD VSS sg13g2_decap_8
XFILLER_137_145 VDD VSS sg13g2_decap_8
XFILLER_181_914 VDD VSS sg13g2_decap_8
X_15072__2954 _15072_/RESET_B VDD VSS sg13g2_tiehi
X_08259_ _08259_/Y _08315_/A _08238_/B _08258_/Y VDD VSS sg13g2_o21ai_1
XFILLER_119_871 VDD VSS sg13g2_fill_1
XFILLER_180_413 VDD VSS sg13g2_decap_8
XFILLER_119_893 VDD VSS sg13g2_decap_8
XFILLER_153_638 VDD VSS sg13g2_decap_8
X_11270_ _11270_/Y _11275_/S0 _14364_/Q VDD VSS sg13g2_nand2b_1
XFILLER_106_521 VDD VSS sg13g2_decap_8
XFILLER_146_690 VDD VSS sg13g2_decap_8
XFILLER_4_637 VDD VSS sg13g2_decap_8
XFILLER_10_1358 VDD VSS sg13g2_decap_8
XFILLER_84_1404 VDD VSS sg13g2_decap_8
XFILLER_84_1415 VDD VSS sg13g2_fill_2
XFILLER_165_56 VDD VSS sg13g2_decap_8
X_15087__2910 _15087_/RESET_B VDD VSS sg13g2_tiehi
X_15133__2784 _15133_/RESET_B VDD VSS sg13g2_tiehi
X_10221_ _14768_/D _14767_/Q _14768_/Q _10220_/Y VDD VSS sg13g2_a21oi_1
XFILLER_133_340 VDD VSS sg13g2_decap_8
XFILLER_3_147 VDD VSS sg13g2_decap_8
XFILLER_121_502 VDD VSS sg13g2_decap_8
XFILLER_79_416 VDD VSS sg13g2_decap_8
XFILLER_84_1459 VDD VSS sg13g2_decap_8
X_10152_ _14729_/D _14729_/Q _10152_/A1 _10168_/S VDD VSS sg13g2_mux2_1
XFILLER_79_427 VDD VSS sg13g2_fill_1
XFILLER_133_384 VDD VSS sg13g2_decap_8
XFILLER_82_1150 VDD VSS sg13g2_decap_8
XFILLER_82_1161 VDD VSS sg13g2_fill_1
X_14960_ _14960_/Q clkload76/A _14960_/D _14960_/RESET_B VDD VSS sg13g2_dfrbpq_1
X_10083_ _14663_/D _10117_/A0 _14663_/Q _10097_/S VDD VSS sg13g2_mux2_1
XFILLER_94_408 VDD VSS sg13g2_decap_8
XFILLER_43_1123 VDD VSS sg13g2_decap_8
XFILLER_0_876 VDD VSS sg13g2_decap_8
XFILLER_134_1251 VDD VSS sg13g2_decap_8
X_14157__2115 _14157_/RESET_B VDD VSS sg13g2_tiehi
XFILLER_102_771 VDD VSS sg13g2_decap_8
XFILLER_59_151 VDD VSS sg13g2_fill_1
XFILLER_43_1145 VDD VSS sg13g2_fill_2
X_13911_ _13911_/Q _15017_/CLK _13911_/D _13911_/RESET_B VDD VSS sg13g2_dfrbpq_1
XFILLER_75_622 VDD VSS sg13g2_decap_8
XFILLER_181_77 VDD VSS sg13g2_decap_8
X_14891_ _14891_/Q clkload63/A _14891_/D _14891_/RESET_B VDD VSS sg13g2_dfrbpq_1
XFILLER_74_110 VDD VSS sg13g2_decap_8
XFILLER_21_1410 VDD VSS sg13g2_decap_8
XFILLER_130_1148 VDD VSS sg13g2_fill_1
X_13842_ _13842_/Q clkload15/A _13842_/D _13842_/RESET_B VDD VSS sg13g2_dfrbpq_1
XFILLER_47_368 VDD VSS sg13g2_decap_8
XFILLER_75_688 VDD VSS sg13g2_decap_4
XFILLER_16_700 VDD VSS sg13g2_decap_8
XFILLER_56_880 VDD VSS sg13g2_decap_8
XFILLER_74_187 VDD VSS sg13g2_decap_8
XFILLER_62_327 VDD VSS sg13g2_decap_8
XFILLER_15_210 VDD VSS sg13g2_decap_8
X_13773_ _13773_/Q _14733_/CLK _13773_/D _13773_/RESET_B VDD VSS sg13g2_dfrbpq_1
XFILLER_28_593 VDD VSS sg13g2_decap_8
X_10985_ _10985_/X _10995_/A _11207_/A2 _11207_/B1 VDD VSS sg13g2_a21o_1
XFILLER_128_1011 VDD VSS sg13g2_fill_2
XFILLER_167_1071 VDD VSS sg13g2_fill_1
XFILLER_91_1408 VDD VSS sg13g2_decap_8
XFILLER_16_777 VDD VSS sg13g2_decap_8
X_12724_ _12724_/X _14262_/Q _14294_/Q _14326_/Q _14358_/Q _12759_/S0 _12759_/S1 VDD
+ VSS sg13g2_mux4_1
XFILLER_31_714 VDD VSS sg13g2_decap_8
XFILLER_128_1055 VDD VSS sg13g2_fill_2
XFILLER_15_287 VDD VSS sg13g2_decap_8
XFILLER_30_213 VDD VSS sg13g2_decap_8
XFILLER_130_92 VDD VSS sg13g2_fill_2
XFILLER_19_1350 VDD VSS sg13g2_decap_8
XFILLER_31_747 VDD VSS sg13g2_decap_8
X_12655_ _12655_/X _13745_/Q _14097_/Q _14449_/Q _14545_/Q _12659_/S0 _12659_/S1 VDD
+ VSS sg13g2_mux4_1
XFILLER_54_1241 VDD VSS sg13g2_decap_8
XFILLER_169_760 VDD VSS sg13g2_decap_8
Xclkbuf_leaf_101_clk_i clkload58/A clkbuf_leaf_99_clk_i/A VDD VSS sg13g2_buf_8
XFILLER_15_1214 VDD VSS sg13g2_decap_8
XFILLER_141_1222 VDD VSS sg13g2_decap_8
X_11606_ _11606_/Y _11602_/Y _11603_/Y _11605_/Y _11604_/Y _11615_/B VDD VSS sg13g2_a221oi_1
XFILLER_8_910 VDD VSS sg13g2_decap_8
XFILLER_141_1233 VDD VSS sg13g2_fill_1
X_14964__2716 _14964_/RESET_B VDD VSS sg13g2_tiehi
X_12586_ _12586_/X _13964_/Q _13996_/Q _14028_/Q _14060_/Q _12591_/S0 _12591_/S1 VDD
+ VSS sg13g2_mux4_1
XFILLER_54_1296 VDD VSS sg13g2_decap_8
XFILLER_12_994 VDD VSS sg13g2_decap_8
XFILLER_156_432 VDD VSS sg13g2_decap_8
XFILLER_157_966 VDD VSS sg13g2_decap_8
XFILLER_7_420 VDD VSS sg13g2_decap_8
XFILLER_129_668 VDD VSS sg13g2_decap_8
XFILLER_141_1266 VDD VSS sg13g2_fill_2
XFILLER_157_977 VDD VSS sg13g2_fill_2
X_14325_ _14325_/Q clkload32/A _14325_/D _14325_/RESET_B VDD VSS sg13g2_dfrbpq_1
XFILLER_106_1397 VDD VSS sg13g2_fill_1
X_11537_ _11537_/Y _12070_/S0 _14596_/Q _12073_/S1 VDD VSS sg13g2_a21oi_1
XFILLER_144_616 VDD VSS sg13g2_decap_8
XFILLER_172_925 VDD VSS sg13g2_decap_8
Xwire362 wire362/X wire363/X VDD VSS sg13g2_buf_2
XFILLER_8_987 VDD VSS sg13g2_decap_8
XFILLER_156_487 VDD VSS sg13g2_decap_8
XFILLER_183_273 VDD VSS sg13g2_decap_8
X_14256_ _14256_/Q clkload19/A _14256_/D _14256_/RESET_B VDD VSS sg13g2_dfrbpq_1
Xclkbuf_leaf_116_clk_i clkload54/A clkbuf_leaf_18_clk_i/A VDD VSS sg13g2_buf_8
X_11468_ _11468_/X _14241_/Q _14273_/Q _14305_/Q _14337_/Q _11489_/S0 _11489_/S1 VDD
+ VSS sg13g2_mux4_1
XFILLER_7_497 VDD VSS sg13g2_decap_8
XFILLER_143_137 VDD VSS sg13g2_decap_8
X_14367__1905 _14367_/RESET_B VDD VSS sg13g2_tiehi
XFILLER_99_72 VDD VSS sg13g2_decap_8
XFILLER_109_392 VDD VSS sg13g2_decap_8
X_13207_ _13207_/Y _10558_/C _07727_/B _07727_/C _14889_/Q _13193_/B VDD VSS sg13g2_a221oi_1
XFILLER_48_1012 VDD VSS sg13g2_decap_8
X_10419_ _10421_/B _14828_/Q _14829_/Q _10422_/D VDD VSS sg13g2_nand3_1
X_14187_ _14187_/Q clkload9/A _14187_/D _14187_/RESET_B VDD VSS sg13g2_dfrbpq_1
X_11399_ _11401_/A _11415_/S _14623_/Q VDD VSS sg13g2_nand2b_1
XFILLER_125_896 VDD VSS sg13g2_decap_8
XFILLER_135_1004 VDD VSS sg13g2_decap_8
XFILLER_180_991 VDD VSS sg13g2_decap_8
XFILLER_112_524 VDD VSS sg13g2_decap_8
X_13138_ _13139_/B _14852_/Q _13150_/B _13138_/B1 _14788_/Q VDD VSS sg13g2_a22oi_1
XFILLER_97_224 VDD VSS sg13g2_decap_8
XFILLER_135_1037 VDD VSS sg13g2_decap_8
XFILLER_48_1089 VDD VSS sg13g2_decap_8
Xclkbuf_5_28__f_clk_i clkbuf_leaf_88_clk_i/A clkbuf_4_14_0_clk_i/X VDD VSS sg13g2_buf_16
XFILLER_85_408 VDD VSS sg13g2_decap_8
X_13069_ _13069_/Y _14847_/Q _13150_/B _13180_/B1 _14879_/Q _13082_/B VDD VSS sg13g2_a221oi_1
XFILLER_65_1392 VDD VSS sg13g2_decap_8
XFILLER_97_279 VDD VSS sg13g2_decap_4
XFILLER_78_460 VDD VSS sg13g2_decap_8
XFILLER_39_836 VDD VSS sg13g2_fill_1
XFILLER_26_1376 VDD VSS sg13g2_decap_8
Xfanout1460 _11444_/S0 _12215_/S0 VDD VSS sg13g2_buf_1
XFILLER_61_1267 VDD VSS sg13g2_fill_2
X_15047__2624 _15047_/RESET_B VDD VSS sg13g2_tiehi
Xfanout1471 _13155_/A fanout1476/X VDD VSS sg13g2_buf_1
XFILLER_113_1346 VDD VSS sg13g2_fill_1
Xfanout1493 _10441_/C _13499_/B VDD VSS sg13g2_buf_1
XFILLER_94_964 VDD VSS sg13g2_decap_8
X_07630_ _08105_/A _07879_/A VDD VSS sg13g2_inv_1
XFILLER_93_452 VDD VSS sg13g2_decap_8
XFILLER_81_614 VDD VSS sg13g2_decap_8
XFILLER_4_1183 VDD VSS sg13g2_decap_8
XFILLER_53_349 VDD VSS sg13g2_decap_8
XFILLER_0_1058 VDD VSS sg13g2_decap_8
XFILLER_185_1160 VDD VSS sg13g2_decap_8
X_09300_ _13908_/D _13908_/Q _09799_/A0 _09304_/S VDD VSS sg13g2_mux2_1
XFILLER_94_1043 VDD VSS sg13g2_decap_8
XFILLER_59_1163 VDD VSS sg13g2_fill_1
X_13855__2417 _13855_/RESET_B VDD VSS sg13g2_tiehi
XFILLER_22_714 VDD VSS sg13g2_decap_8
XFILLER_179_546 VDD VSS sg13g2_decap_8
XFILLER_62_894 VDD VSS sg13g2_decap_8
XFILLER_59_1196 VDD VSS sg13g2_decap_8
XFILLER_34_585 VDD VSS sg13g2_decap_8
XFILLER_22_725 VDD VSS sg13g2_fill_2
XFILLER_107_1106 VDD VSS sg13g2_decap_4
X_09231_ _13842_/D _10128_/A0 _13842_/Q _09231_/S VDD VSS sg13g2_mux2_1
XFILLER_181_1057 VDD VSS sg13g2_decap_8
XFILLER_21_224 VDD VSS sg13g2_decap_8
XFILLER_37_1472 VDD VSS sg13g2_decap_8
X_09162_ _09162_/Y _09162_/A _10793_/C VDD VSS sg13g2_nor2_1
XFILLER_9_70 VDD VSS sg13g2_decap_8
XFILLER_119_112 VDD VSS sg13g2_decap_8
XFILLER_148_944 VDD VSS sg13g2_decap_4
XFILLER_72_1396 VDD VSS sg13g2_decap_8
X_08113_ _08113_/Y _07913_/A _13609_/A _08105_/A _08138_/B _08090_/C VDD VSS sg13g2_a221oi_1
XFILLER_30_791 VDD VSS sg13g2_fill_1
XFILLER_119_27 VDD VSS sg13g2_decap_8
X_14235__2037 _14235_/RESET_B VDD VSS sg13g2_tiehi
X_09093_ _09093_/Y _15239_/Q _09147_/B VDD VSS sg13g2_nand2b_1
XFILLER_174_273 VDD VSS sg13g2_decap_8
XFILLER_107_329 VDD VSS sg13g2_fill_2
X_08044_ _08044_/X _08119_/A2 _08591_/A3 _08598_/A3 _07861_/B _08635_/S0 _08635_/S1
+ VDD VSS sg13g2_mux4_1
XFILLER_116_841 VDD VSS sg13g2_decap_8
XFILLER_162_446 VDD VSS sg13g2_fill_2
XFILLER_157_1251 VDD VSS sg13g2_decap_8
XFILLER_118_1213 VDD VSS sg13g2_decap_8
XFILLER_89_725 VDD VSS sg13g2_fill_1
XFILLER_66_1145 VDD VSS sg13g2_decap_8
XFILLER_27_1118 VDD VSS sg13g2_decap_8
Xclkbuf_leaf_80_clk_i clkload75/A clkload5/A VDD VSS sg13g2_buf_8
XFILLER_88_224 VDD VSS sg13g2_decap_8
XFILLER_115_395 VDD VSS sg13g2_decap_8
XFILLER_130_321 VDD VSS sg13g2_fill_2
X_09995_ _14578_/D _10161_/A1 _14578_/Q _10003_/S VDD VSS sg13g2_mux2_1
XFILLER_66_1189 VDD VSS sg13g2_decap_8
X_08946_ _08946_/Y _13608_/A1 _08835_/B _16882_/A VDD VSS sg13g2_a21oi_1
XFILLER_9_1050 VDD VSS sg13g2_decap_8
XFILLER_76_419 VDD VSS sg13g2_fill_2
XFILLER_97_791 VDD VSS sg13g2_decap_8
XFILLER_44_1476 VDD VSS sg13g2_fill_2
XFILLER_56_110 VDD VSS sg13g2_decap_4
XFILLER_28_35 VDD VSS sg13g2_decap_8
XFILLER_151_14 VDD VSS sg13g2_decap_8
X_08877_ _08877_/Y _10788_/S _14937_/Q VDD VSS sg13g2_nor2b_1
XFILLER_151_25 VDD VSS sg13g2_fill_2
XFILLER_185_7 VDD VSS sg13g2_decap_8
XFILLER_56_143 VDD VSS sg13g2_decap_8
Xclkbuf_leaf_95_clk_i clkload61/A clkload4/A VDD VSS sg13g2_buf_8
X_07828_ _07829_/B _08574_/A _07828_/B _07828_/C VDD VSS sg13g2_nor3_1
XFILLER_71_124 VDD VSS sg13g2_fill_2
XFILLER_44_338 VDD VSS sg13g2_fill_1
X_07759_ _07759_/Y _13281_/C _07755_/Y _07758_/Y VDD VSS sg13g2_a21oi_1
XFILLER_77_1241 VDD VSS sg13g2_decap_8
XFILLER_72_669 VDD VSS sg13g2_decap_8
XFILLER_38_1214 VDD VSS sg13g2_fill_2
XFILLER_13_714 VDD VSS sg13g2_decap_8
XFILLER_164_1233 VDD VSS sg13g2_decap_8
X_10770_ _10770_/Y _14919_/Q _11113_/B VDD VSS sg13g2_nand2_1
XFILLER_73_1116 VDD VSS sg13g2_decap_8
XFILLER_53_883 VDD VSS sg13g2_decap_8
XFILLER_44_56 VDD VSS sg13g2_fill_2
X_14445__1827 _14445_/RESET_B VDD VSS sg13g2_tiehi
XFILLER_52_360 VDD VSS sg13g2_decap_4
XFILLER_125_1206 VDD VSS sg13g2_decap_8
XFILLER_125_1217 VDD VSS sg13g2_fill_2
XFILLER_12_224 VDD VSS sg13g2_decap_8
X_09429_ _14031_/D _09462_/A0 _14031_/Q _09429_/S VDD VSS sg13g2_mux2_1
XFILLER_9_707 VDD VSS sg13g2_decap_8
XFILLER_51_1414 VDD VSS sg13g2_decap_8
X_12440_ _12440_/X _12434_/X _12438_/X _12433_/X _12437_/X _12553_/S _12691_/S1 VDD
+ VSS sg13g2_mux4_1
XFILLER_8_217 VDD VSS sg13g2_decap_8
XFILLER_90_1474 VDD VSS sg13g2_decap_4
XFILLER_166_730 VDD VSS sg13g2_decap_4
XFILLER_138_432 VDD VSS sg13g2_fill_1
Xclkbuf_leaf_33_clk_i clkload36/A clkbuf_leaf_39_clk_i/A VDD VSS sg13g2_buf_8
X_12371_ _12372_/B _12370_/X _12369_/X _12371_/S VDD VSS sg13g2_mux2_1
XFILLER_165_251 VDD VSS sg13g2_decap_8
XFILLER_181_700 VDD VSS sg13g2_decap_8
XFILLER_60_77 VDD VSS sg13g2_decap_8
XFILLER_125_104 VDD VSS sg13g2_decap_8
XFILLER_158_1004 VDD VSS sg13g2_decap_8
X_14110_ _14110_/Q clkload48/A _14110_/D _14110_/RESET_B VDD VSS sg13g2_dfrbpq_1
X_14660__1612 _14660_/RESET_B VDD VSS sg13g2_tiehi
XFILLER_5_924 VDD VSS sg13g2_decap_8
X_11322_ _11322_/Y _11328_/S0 _14109_/Q VDD VSS sg13g2_nand2b_1
XFILLER_176_77 VDD VSS sg13g2_decap_8
XFILLER_180_210 VDD VSS sg13g2_decap_8
X_15090_ _15090_/Q clkload87/A _15090_/D _15090_/RESET_B VDD VSS sg13g2_dfrbpq_1
XFILLER_101_1250 VDD VSS sg13g2_decap_4
XFILLER_5_28 VDD VSS sg13g2_decap_8
XFILLER_4_434 VDD VSS sg13g2_decap_8
XFILLER_84_1201 VDD VSS sg13g2_fill_1
XFILLER_49_1321 VDD VSS sg13g2_fill_1
XFILLER_107_0 VDD VSS sg13g2_decap_8
XFILLER_10_1155 VDD VSS sg13g2_decap_8
X_14041_ _14041_/Q clkload34/A _14041_/D _14041_/RESET_B VDD VSS sg13g2_dfrbpq_1
X_11253_ _11255_/B _11218_/S _14620_/Q VDD VSS sg13g2_nand2b_1
XFILLER_101_1294 VDD VSS sg13g2_decap_4
XFILLER_107_885 VDD VSS sg13g2_decap_8
XFILLER_122_811 VDD VSS sg13g2_decap_4
XFILLER_84_1234 VDD VSS sg13g2_decap_4
XFILLER_180_287 VDD VSS sg13g2_decap_8
Xclkbuf_leaf_48_clk_i clkload40/A clkbuf_leaf_48_clk_i/A VDD VSS sg13g2_buf_8
X_10204_ _14759_/D _15183_/D _14759_/Q _13480_/S VDD VSS sg13g2_mux2_1
XFILLER_121_310 VDD VSS sg13g2_decap_8
XFILLER_133_170 VDD VSS sg13g2_decap_8
XFILLER_79_224 VDD VSS sg13g2_decap_8
XFILLER_45_1218 VDD VSS sg13g2_decap_8
XFILLER_122_844 VDD VSS sg13g2_decap_8
X_11184_ _14954_/D _11183_/Y _11182_/Y _11170_/Y VDD VSS sg13g2_o21ai_1
XFILLER_69_86 VDD VSS sg13g2_decap_8
XFILLER_0_651 VDD VSS sg13g2_decap_8
XFILLER_136_1379 VDD VSS sg13g2_fill_2
XFILLER_171_1259 VDD VSS sg13g2_decap_8
X_13933__2339 _13933_/RESET_B VDD VSS sg13g2_tiehi
X_10135_ _14713_/D _10168_/A1 _14713_/Q _10135_/S VDD VSS sg13g2_mux2_1
XFILLER_122_888 VDD VSS sg13g2_decap_8
X_14693__1579 _14693_/RESET_B VDD VSS sg13g2_tiehi
XFILLER_88_780 VDD VSS sg13g2_decap_8
X_14943_ _14943_/Q clkload56/A _14943_/D _14943_/RESET_B VDD VSS sg13g2_dfrbpq_1
X_10066_ _14647_/D _10066_/A0 _14647_/Q _10068_/S VDD VSS sg13g2_mux2_1
XFILLER_94_249 VDD VSS sg13g2_decap_8
XFILLER_85_41 VDD VSS sg13g2_decap_4
XFILLER_91_901 VDD VSS sg13g2_decap_4
X_14874_ _14874_/Q clkload68/A _14874_/D _14874_/RESET_B VDD VSS sg13g2_dfrbpq_1
XFILLER_91_923 VDD VSS sg13g2_fill_2
XFILLER_76_997 VDD VSS sg13g2_fill_2
XFILLER_5_1470 VDD VSS sg13g2_decap_8
XFILLER_48_688 VDD VSS sg13g2_decap_4
XFILLER_35_316 VDD VSS sg13g2_decap_8
XFILLER_1_1323 VDD VSS sg13g2_decap_8
XFILLER_91_945 VDD VSS sg13g2_decap_8
XFILLER_63_636 VDD VSS sg13g2_fill_1
X_13825_ _13825_/Q clkload44/A _13825_/D _13825_/RESET_B VDD VSS sg13g2_dfrbpq_1
XFILLER_47_198 VDD VSS sg13g2_fill_2
XFILLER_95_1330 VDD VSS sg13g2_decap_4
XFILLER_165_1019 VDD VSS sg13g2_decap_8
XFILLER_21_1284 VDD VSS sg13g2_decap_8
XFILLER_147_1420 VDD VSS sg13g2_decap_4
X_13756_ _13756_/Q _14716_/CLK _13756_/D _13756_/RESET_B VDD VSS sg13g2_dfrbpq_1
XFILLER_16_574 VDD VSS sg13g2_decap_8
X_10968_ _10969_/A _11015_/C _11015_/A _10966_/Y VDD VSS sg13g2_o21ai_1
XFILLER_90_488 VDD VSS sg13g2_decap_8
XFILLER_44_883 VDD VSS sg13g2_decap_8
X_12707_ wire321/A _13668_/Q _12707_/A2 _12706_/X _12707_/B2 _12707_/C1 VDD VSS sg13g2_a221oi_1
XFILLER_143_1317 VDD VSS sg13g2_fill_2
XFILLER_182_1366 VDD VSS sg13g2_fill_2
X_13687_ _13687_/Q clkload80/A _13687_/D _13687_/RESET_B VDD VSS sg13g2_dfrbpq_1
XFILLER_108_1459 VDD VSS sg13g2_decap_8
X_10899_ _10899_/Y wire276/X _10898_/X _15250_/Q VDD VSS sg13g2_o21ai_1
XFILLER_15_1011 VDD VSS sg13g2_decap_8
X_12638_ _15009_/D _07636_/Y _12749_/C1 _12637_/Y VDD VSS sg13g2_a21oi_1
XFILLER_157_730 VDD VSS sg13g2_fill_2
XFILLER_141_1030 VDD VSS sg13g2_decap_8
X_14867__2903 _14867_/RESET_B VDD VSS sg13g2_tiehi
XFILLER_102_1003 VDD VSS sg13g2_decap_8
XFILLER_12_791 VDD VSS sg13g2_decap_8
XFILLER_145_903 VDD VSS sg13g2_fill_2
XFILLER_89_1112 VDD VSS sg13g2_decap_8
XFILLER_129_454 VDD VSS sg13g2_decap_8
XFILLER_184_560 VDD VSS sg13g2_decap_8
X_12569_ _15004_/D _12569_/A _12569_/B VDD VSS sg13g2_nor2_1
XFILLER_144_402 VDD VSS sg13g2_decap_8
XFILLER_184_571 VDD VSS sg13g2_decap_8
XFILLER_15_1088 VDD VSS sg13g2_decap_8
XFILLER_156_273 VDD VSS sg13g2_decap_4
X_14308_ _14308_/Q clkload33/A _14308_/D _14308_/RESET_B VDD VSS sg13g2_dfrbpq_1
XFILLER_8_784 VDD VSS sg13g2_decap_8
XFILLER_102_1058 VDD VSS sg13g2_fill_2
XFILLER_145_958 VDD VSS sg13g2_decap_8
XFILLER_171_221 VDD VSS sg13g2_fill_2
X_14782__3024 _14782_/RESET_B VDD VSS sg13g2_tiehi
Xwire192 wire192/X wire192/A VDD VSS sg13g2_buf_2
XFILLER_116_148 VDD VSS sg13g2_fill_1
XFILLER_172_766 VDD VSS sg13g2_fill_2
XFILLER_89_1189 VDD VSS sg13g2_decap_8
XFILLER_7_294 VDD VSS sg13g2_decap_8
XFILLER_132_608 VDD VSS sg13g2_fill_2
XFILLER_116_159 VDD VSS sg13g2_decap_4
X_14239_ _14239_/Q clkload20/A _14239_/D _14239_/RESET_B VDD VSS sg13g2_dfrbpq_1
XFILLER_144_479 VDD VSS sg13g2_decap_8
XFILLER_171_298 VDD VSS sg13g2_decap_4
Xfanout708 _13220_/A2 _13236_/A2 VDD VSS sg13g2_buf_1
XFILLER_154_1446 VDD VSS sg13g2_decap_8
X_08800_ _08802_/A _10823_/B _14754_/Q _08727_/X _15197_/Q _13490_/B VDD VSS sg13g2_a221oi_1
XFILLER_98_566 VDD VSS sg13g2_fill_1
X_09780_ _14369_/D _09912_/A1 _14369_/Q _09800_/S VDD VSS sg13g2_mux2_1
XFILLER_86_728 VDD VSS sg13g2_decap_4
XFILLER_112_376 VDD VSS sg13g2_decap_8
XFILLER_22_0 VDD VSS sg13g2_decap_8
X_14523__1749 _14523_/RESET_B VDD VSS sg13g2_tiehi
X_13909__2363 _13909_/RESET_B VDD VSS sg13g2_tiehi
X_08731_ _08731_/Y _13662_/Q _08775_/B VDD VSS sg13g2_nor2_1
XFILLER_100_549 VDD VSS sg13g2_decap_4
XFILLER_117_1290 VDD VSS sg13g2_decap_8
XFILLER_26_1173 VDD VSS sg13g2_decap_8
XFILLER_39_644 VDD VSS sg13g2_decap_8
XFILLER_67_964 VDD VSS sg13g2_fill_1
XFILLER_22_1037 VDD VSS sg13g2_decap_8
XFILLER_6_1267 VDD VSS sg13g2_decap_8
XFILLER_67_986 VDD VSS sg13g2_fill_1
X_08662_ _08662_/Y _08650_/A _08662_/B VDD VSS sg13g2_nand2b_1
XFILLER_53_102 VDD VSS sg13g2_decap_4
XFILLER_66_496 VDD VSS sg13g2_decap_8
X_14813__2993 _14813_/RESET_B VDD VSS sg13g2_tiehi
X_07613_ _08992_/A _10781_/C VDD VSS sg13g2_inv_1
XFILLER_93_282 VDD VSS sg13g2_fill_2
X_08593_ _08593_/Y _07858_/X _08623_/A2 _08654_/B VDD VSS sg13g2_o21ai_1
XFILLER_53_135 VDD VSS sg13g2_decap_8
XFILLER_121_39 VDD VSS sg13g2_decap_8
XFILLER_74_1436 VDD VSS sg13g2_fill_1
XFILLER_179_343 VDD VSS sg13g2_decap_8
XFILLER_22_533 VDD VSS sg13g2_decap_8
XFILLER_167_538 VDD VSS sg13g2_fill_2
X_09214_ _13825_/D _10144_/A1 _13825_/Q _09238_/S VDD VSS sg13g2_mux2_1
XFILLER_10_728 VDD VSS sg13g2_decap_8
XFILLER_148_763 VDD VSS sg13g2_fill_2
X_09145_ _09145_/Y _09145_/A _09145_/B VDD VSS sg13g2_nand2_1
XFILLER_148_774 VDD VSS sg13g2_fill_2
XFILLER_163_700 VDD VSS sg13g2_decap_8
XFILLER_120_1125 VDD VSS sg13g2_fill_2
XFILLER_124_1294 VDD VSS sg13g2_decap_8
XFILLER_159_1302 VDD VSS sg13g2_decap_8
XFILLER_30_14 VDD VSS sg13g2_decap_8
XFILLER_175_582 VDD VSS sg13g2_decap_8
XFILLER_68_1207 VDD VSS sg13g2_fill_1
XFILLER_108_649 VDD VSS sg13g2_fill_1
X_09076_ wire216/A _09126_/A1 _10735_/B _09075_/X VDD VSS sg13g2_o21ai_1
XFILLER_11_1442 VDD VSS sg13g2_decap_8
XFILLER_135_446 VDD VSS sg13g2_decap_8
XFILLER_136_969 VDD VSS sg13g2_fill_2
XFILLER_146_14 VDD VSS sg13g2_decap_8
X_08027_ _08027_/Y _07911_/A _08027_/B VDD VSS sg13g2_nand2b_1
XFILLER_100_7 VDD VSS sg13g2_decap_8
XFILLER_163_799 VDD VSS sg13g2_decap_4
XFILLER_144_980 VDD VSS sg13g2_decap_8
Xmax_cap470 _09990_/S _09994_/S VDD VSS sg13g2_buf_4
XFILLER_2_938 VDD VSS sg13g2_decap_8
XFILLER_116_693 VDD VSS sg13g2_decap_8
XFILLER_1_448 VDD VSS sg13g2_decap_8
X_09978_ _14561_/D _10077_/A0 _14561_/Q _09998_/S VDD VSS sg13g2_mux2_1
XFILLER_39_56 VDD VSS sg13g2_decap_8
XFILLER_118_1087 VDD VSS sg13g2_decap_8
XFILLER_162_35 VDD VSS sg13g2_decap_8
X_08929_ _13715_/D _16877_/A _08928_/X _08932_/S VDD VSS sg13g2_mux2_1
XFILLER_29_121 VDD VSS sg13g2_decap_4
X_11940_ _11940_/Y _11948_/S _14128_/Q VDD VSS sg13g2_nand2b_1
XFILLER_40_1159 VDD VSS sg13g2_decap_8
XFILLER_45_625 VDD VSS sg13g2_decap_8
XFILLER_166_1317 VDD VSS sg13g2_decap_4
X_11871_ _11871_/Y _11874_/S0 _13902_/Q VDD VSS sg13g2_nand2b_1
XFILLER_26_850 VDD VSS sg13g2_decap_8
X_13610_ _13610_/Y _13609_/Y _13600_/Y _08830_/X VDD VSS sg13g2_o21ai_1
X_10822_ _10823_/A _10821_/A _10821_/B _10821_/C VDD VSS sg13g2_a21o_1
XFILLER_55_99 VDD VSS sg13g2_decap_8
XFILLER_44_168 VDD VSS sg13g2_fill_1
X_14590_ _14590_/Q clkload49/A _14590_/D _14590_/RESET_B VDD VSS sg13g2_dfrbpq_1
XFILLER_25_360 VDD VSS sg13g2_decap_8
XFILLER_13_511 VDD VSS sg13g2_decap_8
XFILLER_77_1093 VDD VSS sg13g2_decap_4
X_13541_ _13541_/X _14995_/Q _13566_/C VDD VSS sg13g2_and2_1
XFILLER_71_21 VDD VSS sg13g2_decap_8
X_10753_ _11097_/A _14947_/Q _10757_/A _10752_/Y VDD VSS sg13g2_a21oi_1
XFILLER_9_504 VDD VSS sg13g2_decap_8
XFILLER_41_864 VDD VSS sg13g2_fill_1
XFILLER_38_1099 VDD VSS sg13g2_fill_1
XFILLER_13_588 VDD VSS sg13g2_decap_8
XFILLER_186_858 VDD VSS sg13g2_decap_8
X_13472_ _15110_/D _15176_/D _15110_/Q _13480_/S VDD VSS sg13g2_mux2_1
XFILLER_90_1260 VDD VSS sg13g2_decap_8
XFILLER_16_1342 VDD VSS sg13g2_decap_8
XFILLER_186_869 VDD VSS sg13g2_decap_8
X_10684_ _10851_/D _08985_/X _08848_/A _08848_/Y VDD VSS sg13g2_a21o_1
XFILLER_55_1391 VDD VSS sg13g2_decap_8
XFILLER_139_752 VDD VSS sg13g2_decap_8
XFILLER_185_357 VDD VSS sg13g2_decap_8
X_15211_ _15211_/Q clkload73/A _15211_/D _15211_/RESET_B VDD VSS sg13g2_dfrbpq_1
XFILLER_127_903 VDD VSS sg13g2_decap_8
X_12423_ _12423_/X _13728_/Q _14080_/Q _14432_/Q _14528_/Q _12424_/S0 _12424_/S1 VDD
+ VSS sg13g2_mux4_1
XFILLER_90_1293 VDD VSS sg13g2_fill_2
XFILLER_127_914 VDD VSS sg13g2_fill_2
XFILLER_139_774 VDD VSS sg13g2_decap_8
XFILLER_12_1239 VDD VSS sg13g2_decap_8
XFILLER_154_722 VDD VSS sg13g2_decap_8
XFILLER_103_1356 VDD VSS sg13g2_fill_2
X_15142_ _15142_/Q clkload77/A _15142_/D _15142_/RESET_B VDD VSS sg13g2_dfrbpq_1
X_12354_ _12354_/X _12342_/X _12343_/X _12352_/X _12351_/X wire856/X _12790_/S VDD
+ VSS sg13g2_mux4_1
XFILLER_5_721 VDD VSS sg13g2_decap_8
XFILLER_103_1378 VDD VSS sg13g2_decap_8
XFILLER_127_969 VDD VSS sg13g2_decap_8
XFILLER_114_608 VDD VSS sg13g2_fill_2
XFILLER_142_917 VDD VSS sg13g2_decap_8
X_11305_ _11305_/Y _11317_/A1 _14653_/Q _11894_/B VDD VSS sg13g2_a21oi_1
XFILLER_4_231 VDD VSS sg13g2_decap_8
XFILLER_142_928 VDD VSS sg13g2_fill_1
X_15073_ _15073_/Q clkload87/A _15073_/D _15073_/RESET_B VDD VSS sg13g2_dfrbpq_1
XFILLER_181_574 VDD VSS sg13g2_decap_8
X_12285_ _12285_/X _14137_/Q _14169_/Q _14201_/Q _14233_/Q _12286_/S0 _12286_/S1 VDD
+ VSS sg13g2_mux4_1
XFILLER_99_319 VDD VSS sg13g2_decap_8
XFILLER_154_799 VDD VSS sg13g2_decap_8
XFILLER_101_1091 VDD VSS sg13g2_decap_8
XFILLER_84_1031 VDD VSS sg13g2_fill_1
XFILLER_5_798 VDD VSS sg13g2_decap_8
XFILLER_141_438 VDD VSS sg13g2_decap_8
X_14024_ _14024_/Q clkload23/A _14024_/D _14024_/RESET_B VDD VSS sg13g2_dfrbpq_1
XFILLER_107_693 VDD VSS sg13g2_fill_2
X_11236_ _11236_/Y _11236_/A _13289_/C _12223_/A wire275/X VDD VSS sg13g2_nor4_1
XFILLER_20_91 VDD VSS sg13g2_decap_8
XFILLER_171_1034 VDD VSS sg13g2_decap_8
XFILLER_45_1048 VDD VSS sg13g2_decap_8
X_11167_ _11167_/Y _11161_/X _11158_/Y _11166_/Y VDD VSS sg13g2_a21oi_1
XFILLER_121_162 VDD VSS sg13g2_decap_8
XFILLER_136_1187 VDD VSS sg13g2_decap_8
XFILLER_23_1302 VDD VSS sg13g2_decap_8
X_10118_ _14696_/D _10151_/A1 _14696_/Q _10127_/S VDD VSS sg13g2_mux2_1
XFILLER_110_858 VDD VSS sg13g2_decap_8
XFILLER_96_95 VDD VSS sg13g2_fill_2
X_11098_ _11098_/Y _11138_/B _10759_/X _11140_/B2 VDD VSS sg13g2_a21oi_1
XFILLER_3_1407 VDD VSS sg13g2_decap_8
XFILLER_36_603 VDD VSS sg13g2_decap_8
XFILLER_110_1316 VDD VSS sg13g2_decap_8
X_14926_ _14926_/Q clkload91/A _14926_/D _14926_/RESET_B VDD VSS sg13g2_dfrbpq_1
X_10049_ _14630_/D _10082_/A0 _14630_/Q _10060_/S VDD VSS sg13g2_mux2_1
XFILLER_64_923 VDD VSS sg13g2_fill_1
XFILLER_110_1327 VDD VSS sg13g2_fill_2
XFILLER_23_1379 VDD VSS sg13g2_decap_8
XFILLER_97_1447 VDD VSS sg13g2_decap_8
XFILLER_1_1120 VDD VSS sg13g2_decap_8
XFILLER_58_1409 VDD VSS sg13g2_decap_8
X_14857_ _14857_/Q clkload64/A _14857_/D _14857_/RESET_B VDD VSS sg13g2_dfrbpq_1
XFILLER_91_753 VDD VSS sg13g2_decap_8
XFILLER_56_1100 VDD VSS sg13g2_fill_1
X_13808_ _13808_/Q clkload10/A _13808_/D _13808_/RESET_B VDD VSS sg13g2_dfrbpq_1
X_14788_ _14788_/Q _14890_/CLK _14788_/D _14788_/RESET_B VDD VSS sg13g2_dfrbpq_1
XFILLER_56_1122 VDD VSS sg13g2_decap_8
XFILLER_16_371 VDD VSS sg13g2_decap_8
XFILLER_51_639 VDD VSS sg13g2_decap_8
XFILLER_44_680 VDD VSS sg13g2_decap_8
XFILLER_1_1197 VDD VSS sg13g2_decap_8
X_13739_ _13739_/Q clkload9/A _13739_/D _13739_/RESET_B VDD VSS sg13g2_dfrbpq_1
XFILLER_32_842 VDD VSS sg13g2_decap_8
XFILLER_17_1117 VDD VSS sg13g2_decap_8
X_13772__2500 _13772_/RESET_B VDD VSS sg13g2_tiehi
XFILLER_52_1019 VDD VSS sg13g2_fill_1
XFILLER_149_538 VDD VSS sg13g2_fill_2
XFILLER_176_357 VDD VSS sg13g2_decap_8
X_15074__2946 _15074_/RESET_B VDD VSS sg13g2_tiehi
XFILLER_121_1423 VDD VSS sg13g2_decap_8
XFILLER_157_571 VDD VSS sg13g2_decap_8
XFILLER_8_581 VDD VSS sg13g2_decap_8
X_15089__2902 _15089_/RESET_B VDD VSS sg13g2_tiehi
X_14152__2120 _14152_/RESET_B VDD VSS sg13g2_tiehi
XFILLER_133_917 VDD VSS sg13g2_decap_8
XFILLER_144_265 VDD VSS sg13g2_decap_8
XFILLER_160_714 VDD VSS sg13g2_decap_8
X_09901_ _14487_/D _09934_/A1 _14487_/Q _09901_/S VDD VSS sg13g2_mux2_1
XFILLER_119_1341 VDD VSS sg13g2_decap_4
Xfanout505 _09471_/S _09472_/S VDD VSS sg13g2_buf_1
XFILLER_28_1235 VDD VSS sg13g2_decap_8
Xfanout516 _09404_/S _09407_/S VDD VSS sg13g2_buf_1
XFILLER_63_1126 VDD VSS sg13g2_fill_1
XFILLER_115_1205 VDD VSS sg13g2_decap_8
XFILLER_119_1374 VDD VSS sg13g2_fill_1
Xfanout527 _09238_/S _09233_/S VDD VSS sg13g2_buf_1
X_09832_ _14420_/D _09931_/A1 _14420_/Q _09838_/S VDD VSS sg13g2_mux2_1
XFILLER_113_674 VDD VSS sg13g2_decap_8
Xfanout538 _08941_/S _08834_/X VDD VSS sg13g2_buf_1
XFILLER_119_1385 VDD VSS sg13g2_decap_4
Xfanout549 _13480_/S _13656_/S VDD VSS sg13g2_buf_1
XFILLER_140_482 VDD VSS sg13g2_decap_8
XFILLER_150_1118 VDD VSS sg13g2_decap_8
XFILLER_115_1249 VDD VSS sg13g2_decap_8
XFILLER_140_493 VDD VSS sg13g2_fill_2
XFILLER_58_238 VDD VSS sg13g2_decap_8
X_09763_ _14353_/D _14353_/Q _09928_/A1 _09764_/S VDD VSS sg13g2_mux2_1
X_14185__2087 _14185_/RESET_B VDD VSS sg13g2_tiehi
XFILLER_100_368 VDD VSS sg13g2_decap_8
X_08714_ _15210_/D _15189_/D _15119_/Q _13651_/S VDD VSS sg13g2_mux2_1
XFILLER_6_1064 VDD VSS sg13g2_decap_8
X_09694_ _14286_/D _09727_/A0 _14286_/Q _09703_/S VDD VSS sg13g2_mux2_1
XFILLER_67_783 VDD VSS sg13g2_decap_8
XFILLER_132_49 VDD VSS sg13g2_decap_8
XFILLER_26_102 VDD VSS sg13g2_fill_1
XFILLER_55_956 VDD VSS sg13g2_decap_8
X_08645_ _08645_/X _08646_/A _08646_/B _08646_/C VDD VSS sg13g2_and3_1
XFILLER_14_308 VDD VSS sg13g2_decap_8
XFILLER_42_617 VDD VSS sg13g2_fill_1
XFILLER_25_14 VDD VSS sg13g2_decap_8
XFILLER_148_1047 VDD VSS sg13g2_decap_4
X_08576_ _08576_/Y _08421_/Y _08575_/B _08573_/Y VDD VSS sg13g2_o21ai_1
XFILLER_41_105 VDD VSS sg13g2_decap_8
XFILLER_26_179 VDD VSS sg13g2_decap_4
XFILLER_148_1069 VDD VSS sg13g2_fill_2
XFILLER_41_116 VDD VSS sg13g2_fill_1
XFILLER_179_140 VDD VSS sg13g2_decap_8
XFILLER_41_149 VDD VSS sg13g2_decap_8
XFILLER_168_825 VDD VSS sg13g2_decap_4
XFILLER_126_1345 VDD VSS sg13g2_decap_8
XFILLER_148_7 VDD VSS sg13g2_decap_8
X_14362__1910 _14362_/RESET_B VDD VSS sg13g2_tiehi
XFILLER_35_1239 VDD VSS sg13g2_decap_8
XFILLER_168_858 VDD VSS sg13g2_fill_1
Xclkbuf_4_7_0_clk_i clkbuf_4_7_0_clk_i/X clkbuf_0_clk_i/X VDD VSS sg13g2_buf_8
XFILLER_10_525 VDD VSS sg13g2_decap_8
XFILLER_126_1378 VDD VSS sg13g2_decap_8
XFILLER_161_1258 VDD VSS sg13g2_decap_8
XFILLER_161_1269 VDD VSS sg13g2_fill_2
XFILLER_167_368 VDD VSS sg13g2_fill_1
XFILLER_41_35 VDD VSS sg13g2_decap_8
XFILLER_109_914 VDD VSS sg13g2_fill_1
X_14992__2688 _14992_/RESET_B VDD VSS sg13g2_tiehi
XFILLER_6_518 VDD VSS sg13g2_decap_8
XFILLER_124_1080 VDD VSS sg13g2_fill_2
XFILLER_176_880 VDD VSS sg13g2_decap_8
XFILLER_148_582 VDD VSS sg13g2_decap_8
XFILLER_157_35 VDD VSS sg13g2_decap_8
XFILLER_176_891 VDD VSS sg13g2_decap_4
X_09128_ _10772_/A _15047_/Q _15244_/Q _09134_/S VDD VSS sg13g2_mux2_1
XFILLER_135_221 VDD VSS sg13g2_fill_2
XFILLER_175_390 VDD VSS sg13g2_decap_8
XFILLER_68_1004 VDD VSS sg13g2_decap_8
XFILLER_68_1037 VDD VSS sg13g2_decap_4
XFILLER_151_714 VDD VSS sg13g2_decap_8
X_09059_ _13770_/D _13770_/Q _10086_/A0 _09059_/S VDD VSS sg13g2_mux2_1
XFILLER_123_416 VDD VSS sg13g2_decap_8
X_14395__1877 _14395_/RESET_B VDD VSS sg13g2_tiehi
XFILLER_150_224 VDD VSS sg13g2_decap_8
XFILLER_46_1302 VDD VSS sg13g2_decap_8
XFILLER_2_735 VDD VSS sg13g2_decap_8
X_12070_ _12070_/X _14579_/Q _14611_/Q _14643_/Q _14675_/Q _12070_/S0 _12073_/S1 VDD
+ VSS sg13g2_mux4_1
XFILLER_46_1313 VDD VSS sg13g2_fill_1
XFILLER_104_652 VDD VSS sg13g2_decap_8
XFILLER_1_245 VDD VSS sg13g2_decap_8
X_14851__2935 _14851_/RESET_B VDD VSS sg13g2_tiehi
XFILLER_173_56 VDD VSS sg13g2_decap_8
X_11021_ _11021_/X _14943_/Q _11021_/B VDD VSS sg13g2_and2_1
XFILLER_81_1226 VDD VSS sg13g2_decap_4
XFILLER_172_1354 VDD VSS sg13g2_fill_1
XFILLER_104_685 VDD VSS sg13g2_decap_8
XFILLER_132_994 VDD VSS sg13g2_decap_4
X_13850__2422 _13850_/RESET_B VDD VSS sg13g2_tiehi
X_14015__2257 _14015_/RESET_B VDD VSS sg13g2_tiehi
XFILLER_106_94 VDD VSS sg13g2_fill_2
XFILLER_66_54 VDD VSS sg13g2_decap_8
XFILLER_79_1100 VDD VSS sg13g2_decap_8
XFILLER_66_65 VDD VSS sg13g2_decap_8
XFILLER_18_614 VDD VSS sg13g2_decap_8
X_12972_ _12990_/A _14905_/Q _13682_/Q VDD VSS sg13g2_or2_1
XFILLER_131_1062 VDD VSS sg13g2_fill_1
XFILLER_18_625 VDD VSS sg13g2_fill_1
XFILLER_131_1073 VDD VSS sg13g2_decap_8
X_14884__2869 _14884_/RESET_B VDD VSS sg13g2_tiehi
XFILLER_174_0 VDD VSS sg13g2_decap_8
X_14711_ _14711_/Q _15017_/CLK _14711_/D _14711_/RESET_B VDD VSS sg13g2_dfrbpq_1
X_11923_ _11923_/X _14383_/Q _14415_/Q _14479_/Q _14511_/Q _12025_/A _12026_/C VDD
+ VSS sg13g2_mux4_1
XFILLER_46_956 VDD VSS sg13g2_decap_8
XFILLER_166_1103 VDD VSS sg13g2_fill_2
XFILLER_61_915 VDD VSS sg13g2_decap_8
XFILLER_17_168 VDD VSS sg13g2_decap_8
X_14642_ _14642_/Q _14674_/CLK _14642_/D _14642_/RESET_B VDD VSS sg13g2_dfrbpq_1
XFILLER_79_1188 VDD VSS sg13g2_fill_2
XFILLER_60_403 VDD VSS sg13g2_decap_8
X_11854_ _11854_/X _14253_/Q _14285_/Q _14317_/Q _14349_/Q _11854_/S0 _11598_/C VDD
+ VSS sg13g2_mux4_1
XFILLER_32_105 VDD VSS sg13g2_decap_8
X_14230__2042 _14230_/RESET_B VDD VSS sg13g2_tiehi
XFILLER_32_116 VDD VSS sg13g2_fill_1
XFILLER_92_1333 VDD VSS sg13g2_fill_1
XFILLER_60_436 VDD VSS sg13g2_fill_2
X_10805_ _10805_/Y _15121_/Q _10805_/B _10805_/C VDD VSS sg13g2_nor3_1
X_13883__2389 _13883_/RESET_B VDD VSS sg13g2_tiehi
X_14573_ _14573_/Q _14669_/CLK _14573_/D _14573_/RESET_B VDD VSS sg13g2_dfrbpq_1
X_11785_ _11785_/X _14251_/Q _14283_/Q _14315_/Q _14347_/Q _11850_/S0 _07654_/A VDD
+ VSS sg13g2_mux4_1
XFILLER_82_86 VDD VSS sg13g2_decap_8
XFILLER_18_1437 VDD VSS sg13g2_decap_8
XFILLER_82_97 VDD VSS sg13g2_fill_1
XFILLER_14_875 VDD VSS sg13g2_decap_8
XFILLER_9_301 VDD VSS sg13g2_decap_8
XFILLER_159_847 VDD VSS sg13g2_fill_2
X_13524_ _15141_/D _13535_/B _13522_/Y _13523_/Y VDD VSS sg13g2_a21oi_1
X_10736_ _10736_/Y _14943_/Q _10740_/A1 _10735_/Y VDD VSS sg13g2_a21oi_1
XFILLER_15_91 VDD VSS sg13g2_decap_8
XFILLER_13_385 VDD VSS sg13g2_decap_8
XFILLER_174_806 VDD VSS sg13g2_decap_8
X_15064__3044 _15064_/RESET_B VDD VSS sg13g2_tiehi
XFILLER_185_154 VDD VSS sg13g2_decap_8
X_13455_ _13463_/D _13455_/A _13455_/B _13455_/C _13455_/D VDD VSS sg13g2_or4_1
Xmax_cap1301 output63/A _16857_/A VDD VSS sg13g2_buf_4
X_10667_ _14894_/D _10667_/A _10667_/B _10667_/C VDD VSS sg13g2_nor3_1
XFILLER_51_1052 VDD VSS sg13g2_decap_8
XFILLER_9_378 VDD VSS sg13g2_decap_8
XFILLER_173_338 VDD VSS sg13g2_decap_8
X_12406_ _12406_/X _14367_/Q _14399_/Q _14463_/Q _14495_/Q _12406_/S0 _12406_/S1 VDD
+ VSS sg13g2_mux4_1
XFILLER_127_744 VDD VSS sg13g2_decap_8
XFILLER_12_1036 VDD VSS sg13g2_decap_8
X_13386_ _13386_/Y _13493_/A1 _13307_/B _15082_/Q VDD VSS sg13g2_o21ai_1
XFILLER_63_7 VDD VSS sg13g2_decap_8
XFILLER_154_541 VDD VSS sg13g2_decap_8
X_10598_ _10607_/D _14876_/Q _14875_/Q VDD VSS sg13g2_and2_1
XFILLER_126_243 VDD VSS sg13g2_decap_8
XFILLER_127_777 VDD VSS sg13g2_fill_2
X_15125_ _15125_/Q _15219_/CLK _15125_/D _15125_/RESET_B VDD VSS sg13g2_dfrbpq_1
Xoutput108 mem_axi_wdata[13] _15145_/Q VDD VSS sg13g2_buf_1
X_12337_ _12337_/Y _12335_/Y _12336_/Y _12223_/A VDD VSS sg13g2_a21oi_1
Xoutput119 mem_axi_wdata[23] _15155_/Q VDD VSS sg13g2_buf_1
XFILLER_114_416 VDD VSS sg13g2_decap_4
XFILLER_181_371 VDD VSS sg13g2_decap_8
XFILLER_182_894 VDD VSS sg13g2_decap_8
XFILLER_173_1118 VDD VSS sg13g2_decap_8
X_15056_ _15056_/Q clkload88/A _15056_/D _15056_/RESET_B VDD VSS sg13g2_dfrbpq_1
XFILLER_99_138 VDD VSS sg13g2_decap_8
XFILLER_5_595 VDD VSS sg13g2_decap_8
X_12268_ _12268_/Y _12156_/A _12267_/Y _12227_/B VDD VSS sg13g2_o21ai_1
X_14007_ _14007_/Q _15017_/CLK _14007_/D _14007_/RESET_B VDD VSS sg13g2_dfrbpq_1
X_11219_ _11219_/X _11218_/X _11262_/B _11875_/B VDD VSS sg13g2_a21o_1
XFILLER_96_812 VDD VSS sg13g2_decap_8
XFILLER_110_611 VDD VSS sg13g2_fill_2
XFILLER_150_780 VDD VSS sg13g2_decap_8
X_12199_ _12200_/A _12155_/A _12151_/Y _12153_/B VDD VSS sg13g2_o21ai_1
XFILLER_68_525 VDD VSS sg13g2_decap_8
Xoutput90 mem_axi_awaddr[29] _16882_/X VDD VSS sg13g2_buf_1
XFILLER_96_856 VDD VSS sg13g2_decap_8
XFILLER_151_1449 VDD VSS sg13g2_fill_1
XFILLER_7_1351 VDD VSS sg13g2_decap_8
X_14440__1832 _14440_/RESET_B VDD VSS sg13g2_tiehi
XFILLER_3_1204 VDD VSS sg13g2_decap_8
XFILLER_110_1102 VDD VSS sg13g2_decap_8
XFILLER_110_699 VDD VSS sg13g2_decap_8
XFILLER_110_1113 VDD VSS sg13g2_fill_1
XFILLER_114_1293 VDD VSS sg13g2_decap_4
XFILLER_37_945 VDD VSS sg13g2_decap_8
XFILLER_36_422 VDD VSS sg13g2_decap_8
XFILLER_23_1176 VDD VSS sg13g2_decap_8
X_14909_ _14909_/Q clkload75/A _14909_/D _14909_/RESET_B VDD VSS sg13g2_dfrbpq_1
XFILLER_149_1323 VDD VSS sg13g2_decap_8
XFILLER_97_1255 VDD VSS sg13g2_decap_8
XFILLER_184_1214 VDD VSS sg13g2_fill_1
XFILLER_97_1266 VDD VSS sg13g2_decap_4
XFILLER_64_764 VDD VSS sg13g2_decap_4
XFILLER_52_915 VDD VSS sg13g2_decap_8
X_08430_ _08441_/D _08340_/A _08428_/X _08429_/Y VDD VSS sg13g2_o21ai_1
XFILLER_51_403 VDD VSS sg13g2_decap_8
XFILLER_52_937 VDD VSS sg13g2_decap_8
XFILLER_23_105 VDD VSS sg13g2_decap_8
X_08361_ _08361_/Y _08270_/B _08195_/Y _08360_/Y VDD VSS sg13g2_a21oi_1
X_13713__2559 _13713_/RESET_B VDD VSS sg13g2_tiehi
XFILLER_177_611 VDD VSS sg13g2_fill_1
X_14473__1799 _14473_/RESET_B VDD VSS sg13g2_tiehi
XFILLER_20_812 VDD VSS sg13g2_decap_8
XFILLER_71_1439 VDD VSS sg13g2_fill_2
XFILLER_177_644 VDD VSS sg13g2_decap_8
X_08292_ _08293_/A _08318_/D _08290_/X _08291_/Y VDD VSS sg13g2_o21ai_1
XFILLER_108_1075 VDD VSS sg13g2_decap_8
XFILLER_176_154 VDD VSS sg13g2_decap_8
XFILLER_30_1103 VDD VSS sg13g2_fill_2
XFILLER_178_1007 VDD VSS sg13g2_decap_4
XFILLER_121_1231 VDD VSS sg13g2_decap_8
XFILLER_178_1018 VDD VSS sg13g2_decap_8
XFILLER_34_1283 VDD VSS sg13g2_fill_2
XFILLER_157_390 VDD VSS sg13g2_decap_8
XFILLER_69_1324 VDD VSS sg13g2_decap_4
XFILLER_118_777 VDD VSS sg13g2_fill_2
XFILLER_11_49 VDD VSS sg13g2_decap_8
XFILLER_118_788 VDD VSS sg13g2_fill_1
XFILLER_117_276 VDD VSS sg13g2_decap_4
XFILLER_127_49 VDD VSS sg13g2_decap_8
XFILLER_160_522 VDD VSS sg13g2_decap_8
XFILLER_132_246 VDD VSS sg13g2_decap_8
XFILLER_132_257 VDD VSS sg13g2_fill_1
X_14977__2703 _14977_/RESET_B VDD VSS sg13g2_tiehi
XFILLER_99_650 VDD VSS sg13g2_decap_8
Xfanout302 _09949_/A1 _10115_/A0 VDD VSS sg13g2_buf_1
XFILLER_132_268 VDD VSS sg13g2_fill_1
Xfanout313 _10077_/A0 _09945_/A1 VDD VSS sg13g2_buf_1
XFILLER_28_1043 VDD VSS sg13g2_decap_8
XFILLER_154_1051 VDD VSS sg13g2_decap_8
XFILLER_28_1054 VDD VSS sg13g2_fill_2
XFILLER_154_1062 VDD VSS sg13g2_decap_8
Xfanout335 _10093_/S _10102_/S VDD VSS sg13g2_buf_1
XFILLER_87_834 VDD VSS sg13g2_fill_1
Xfanout346 _09969_/S wire347/X VDD VSS sg13g2_buf_1
XFILLER_100_110 VDD VSS sg13g2_fill_2
X_09815_ _14403_/D _09881_/A0 _14403_/Q _09833_/S VDD VSS sg13g2_mux2_1
XFILLER_8_1148 VDD VSS sg13g2_decap_8
XFILLER_101_655 VDD VSS sg13g2_decap_8
XFILLER_140_290 VDD VSS sg13g2_decap_8
XFILLER_154_1095 VDD VSS sg13g2_decap_8
Xfanout368 _09766_/S _09772_/S VDD VSS sg13g2_buf_1
Xfanout379 _09703_/S _09674_/X VDD VSS sg13g2_buf_1
XFILLER_86_377 VDD VSS sg13g2_decap_8
X_09746_ _14336_/D _14336_/Q _09911_/A1 _09771_/S VDD VSS sg13g2_mux2_1
XFILLER_74_528 VDD VSS sg13g2_decap_8
XFILLER_101_699 VDD VSS sg13g2_fill_1
XFILLER_27_400 VDD VSS sg13g2_decap_8
XFILLER_28_945 VDD VSS sg13g2_decap_8
XFILLER_41_1276 VDD VSS sg13g2_decap_8
XFILLER_36_35 VDD VSS sg13g2_decap_8
X_09677_ _14269_/D _10140_/A1 _14269_/Q _09706_/S VDD VSS sg13g2_mux2_1
XFILLER_54_230 VDD VSS sg13g2_decap_4
XFILLER_76_1306 VDD VSS sg13g2_decap_8
XFILLER_55_764 VDD VSS sg13g2_decap_8
XFILLER_28_989 VDD VSS sg13g2_decap_8
XFILLER_128_1407 VDD VSS sg13g2_fill_2
X_08628_ _08628_/Y _07855_/A _08610_/Y _08627_/Y VDD VSS sg13g2_o21ai_1
XFILLER_27_477 VDD VSS sg13g2_fill_2
XFILLER_14_105 VDD VSS sg13g2_decap_8
XFILLER_82_583 VDD VSS sg13g2_decap_8
XFILLER_42_414 VDD VSS sg13g2_decap_8
XFILLER_167_1467 VDD VSS sg13g2_decap_8
XFILLER_167_1478 VDD VSS sg13g2_fill_1
X_08559_ _08560_/C _07861_/B _08598_/A3 _08591_/A3 _07818_/B _08635_/S0 _08635_/S1
+ VDD VSS sg13g2_mux4_1
X_14303__1969 _14303_/RESET_B VDD VSS sg13g2_tiehi
XFILLER_74_1063 VDD VSS sg13g2_decap_8
XFILLER_39_1183 VDD VSS sg13g2_decap_4
XFILLER_11_812 VDD VSS sg13g2_decap_8
XFILLER_74_1074 VDD VSS sg13g2_fill_2
XFILLER_39_1194 VDD VSS sg13g2_fill_1
X_11570_ _11638_/C _11570_/A _13683_/Q VDD VSS sg13g2_xnor2_1
XFILLER_35_1036 VDD VSS sg13g2_decap_8
XFILLER_126_1164 VDD VSS sg13g2_fill_2
XFILLER_161_1044 VDD VSS sg13g2_decap_8
XFILLER_10_322 VDD VSS sg13g2_decap_8
XFILLER_156_817 VDD VSS sg13g2_fill_1
XFILLER_22_182 VDD VSS sg13g2_decap_8
XFILLER_122_1017 VDD VSS sg13g2_decap_8
XFILLER_167_154 VDD VSS sg13g2_decap_8
XFILLER_168_56 VDD VSS sg13g2_decap_8
X_10521_ _10531_/D _14856_/Q _14855_/Q _10521_/C _10521_/D VDD VSS sg13g2_and4_1
XFILLER_7_805 VDD VSS sg13g2_decap_8
XFILLER_183_614 VDD VSS sg13g2_decap_8
XFILLER_109_711 VDD VSS sg13g2_decap_8
XFILLER_161_1088 VDD VSS sg13g2_decap_4
XFILLER_11_889 VDD VSS sg13g2_decap_8
XFILLER_13_1323 VDD VSS sg13g2_decap_8
XFILLER_161_1099 VDD VSS sg13g2_decap_4
XFILLER_109_722 VDD VSS sg13g2_decap_4
XFILLER_6_315 VDD VSS sg13g2_decap_8
X_13240_ _13246_/C _14923_/Q _13664_/Q VDD VSS sg13g2_xor2_1
XFILLER_108_221 VDD VSS sg13g2_decap_8
X_10452_ _10452_/Y _14840_/Q _10450_/C _10626_/B VDD VSS sg13g2_o21ai_1
XFILLER_10_399 VDD VSS sg13g2_decap_8
X_13868__2404 _13868_/RESET_B VDD VSS sg13g2_tiehi
XFILLER_100_1326 VDD VSS sg13g2_decap_8
XFILLER_164_861 VDD VSS sg13g2_decap_8
XFILLER_182_168 VDD VSS sg13g2_decap_8
X_13171_ _13176_/A _13171_/A _13172_/D VDD VSS sg13g2_nand2_1
XFILLER_100_1348 VDD VSS sg13g2_decap_8
XFILLER_109_799 VDD VSS sg13g2_fill_2
X_10383_ _10386_/B _10378_/D _10380_/X _14819_/Q VDD VSS sg13g2_a21oi_1
XFILLER_100_1359 VDD VSS sg13g2_fill_2
XFILLER_48_1419 VDD VSS sg13g2_fill_2
XFILLER_108_287 VDD VSS sg13g2_fill_2
XFILLER_124_736 VDD VSS sg13g2_decap_4
XFILLER_163_382 VDD VSS sg13g2_decap_8
X_12122_ _12122_/Y _14919_/Q _12122_/A2 _12118_/Y _12121_/Y VDD VSS sg13g2_a22oi_1
XFILLER_124_758 VDD VSS sg13g2_decap_8
XFILLER_184_77 VDD VSS sg13g2_decap_8
XFILLER_2_532 VDD VSS sg13g2_decap_8
XFILLER_105_950 VDD VSS sg13g2_fill_1
XFILLER_97_609 VDD VSS sg13g2_decap_8
XFILLER_111_419 VDD VSS sg13g2_fill_2
X_12053_ _14980_/D _12053_/A _12053_/B VDD VSS sg13g2_nor2_1
XFILLER_46_1143 VDD VSS sg13g2_decap_8
XFILLER_117_82 VDD VSS sg13g2_fill_2
X_14248__2024 _14248_/RESET_B VDD VSS sg13g2_tiehi
XFILLER_77_42 VDD VSS sg13g2_decap_8
XFILLER_104_482 VDD VSS sg13g2_fill_2
XFILLER_132_791 VDD VSS sg13g2_fill_2
XFILLER_172_1162 VDD VSS sg13g2_decap_8
X_11004_ _11007_/A _11004_/A _11004_/B _11009_/D _11009_/C VDD VSS sg13g2_nand4_1
XFILLER_46_1187 VDD VSS sg13g2_decap_4
XFILLER_133_1146 VDD VSS sg13g2_decap_8
X_16861_ _16861_/X _16861_/A VDD VSS sg13g2_buf_1
XFILLER_38_709 VDD VSS sg13g2_decap_8
Xfanout880 fanout880/X _15211_/Q VDD VSS sg13g2_buf_1
Xfanout891 _12702_/S1 fanout894/X VDD VSS sg13g2_buf_1
XFILLER_65_528 VDD VSS sg13g2_fill_1
XFILLER_37_219 VDD VSS sg13g2_decap_8
XFILLER_24_1463 VDD VSS sg13g2_decap_8
XFILLER_133_70 VDD VSS sg13g2_decap_8
XFILLER_46_731 VDD VSS sg13g2_fill_2
XFILLER_92_347 VDD VSS sg13g2_decap_8
X_12955_ _12956_/A _12945_/Y _12946_/Y _12954_/Y VDD VSS sg13g2_o21ai_1
XFILLER_18_455 VDD VSS sg13g2_decap_8
XFILLER_93_63 VDD VSS sg13g2_decap_8
XFILLER_45_241 VDD VSS sg13g2_decap_8
X_11906_ _14976_/D _11868_/Y _11905_/Y _11863_/Y VDD VSS sg13g2_a21oi_1
X_12886_ _12886_/Y _12914_/A _12884_/Y _12885_/Y VDD VSS sg13g2_o21ai_1
XFILLER_60_200 VDD VSS sg13g2_fill_2
XFILLER_2_1281 VDD VSS sg13g2_decap_8
X_14625_ _14625_/Q clkload38/A _14625_/D _14625_/RESET_B VDD VSS sg13g2_dfrbpq_1
X_11837_ _11837_/Y _12124_/A2 _11836_/Y _12082_/B VDD VSS sg13g2_o21ai_1
XFILLER_61_778 VDD VSS sg13g2_decap_8
XFILLER_57_1272 VDD VSS sg13g2_decap_8
XFILLER_92_1163 VDD VSS sg13g2_decap_8
XFILLER_14_672 VDD VSS sg13g2_decap_8
XFILLER_18_1234 VDD VSS sg13g2_decap_8
XFILLER_57_1283 VDD VSS sg13g2_fill_2
XFILLER_20_119 VDD VSS sg13g2_decap_8
X_14556_ _14556_/Q _14620_/CLK _14556_/D _14556_/RESET_B VDD VSS sg13g2_dfrbpq_1
X_11768_ _11768_/Y _11767_/X _12301_/B1 _12126_/A VDD VSS sg13g2_a21oi_1
XFILLER_53_1136 VDD VSS sg13g2_decap_8
XFILLER_41_480 VDD VSS sg13g2_decap_4
XFILLER_13_182 VDD VSS sg13g2_decap_8
XFILLER_159_677 VDD VSS sg13g2_decap_8
XFILLER_174_603 VDD VSS sg13g2_decap_8
XFILLER_144_1286 VDD VSS sg13g2_fill_2
X_13507_ _15131_/D _13507_/A _13507_/B _13507_/C VDD VSS sg13g2_nor3_1
X_13681__2603 _13681_/RESET_B VDD VSS sg13g2_tiehi
X_10719_ _14907_/D _11168_/B1 _10954_/C _10718_/Y VDD VSS sg13g2_o21ai_1
X_14487_ _14487_/Q clkload42/A _14487_/D _14487_/RESET_B VDD VSS sg13g2_dfrbpq_1
XFILLER_70_1450 VDD VSS sg13g2_fill_2
X_11699_ wire246/A _11698_/Y _11688_/Y _11680_/Y _11672_/Y _12001_/A VDD VSS sg13g2_a221oi_1
XFILLER_146_327 VDD VSS sg13g2_decap_8
XFILLER_9_175 VDD VSS sg13g2_decap_8
X_13438_ _13438_/Y _13438_/A _13438_/B _15130_/Q _13438_/D VDD VSS sg13g2_nand4_1
XFILLER_127_541 VDD VSS sg13g2_decap_8
X_14458__1814 _14458_/RESET_B VDD VSS sg13g2_tiehi
XFILLER_173_168 VDD VSS sg13g2_decap_8
XFILLER_31_1478 VDD VSS sg13g2_fill_1
X_13369_ _13369_/Y _13440_/A _13440_/B _15076_/Q VDD VSS sg13g2_nand3_1
XFILLER_127_585 VDD VSS sg13g2_fill_2
XFILLER_170_820 VDD VSS sg13g2_decap_8
XFILLER_6_882 VDD VSS sg13g2_decap_8
XFILLER_115_736 VDD VSS sg13g2_decap_8
XFILLER_142_522 VDD VSS sg13g2_fill_2
XFILLER_114_224 VDD VSS sg13g2_decap_8
X_15108_ _15108_/Q _15200_/CLK _15108_/D _15108_/RESET_B VDD VSS sg13g2_dfrbpq_1
XFILLER_5_392 VDD VSS sg13g2_decap_8
XFILLER_130_717 VDD VSS sg13g2_decap_8
XFILLER_170_886 VDD VSS sg13g2_decap_8
X_15039_ _15039_/Q clkload65/A _15039_/D _15039_/RESET_B VDD VSS sg13g2_dfrbpq_1
X_07930_ _08286_/A _07930_/A _08318_/B VDD VSS sg13g2_nor2_1
XFILLER_9_1435 VDD VSS sg13g2_decap_8
XFILLER_116_1322 VDD VSS sg13g2_decap_8
XFILLER_68_311 VDD VSS sg13g2_fill_1
XFILLER_96_642 VDD VSS sg13g2_decap_8
XFILLER_29_1396 VDD VSS sg13g2_fill_2
X_07861_ _08608_/B _15013_/Q _07861_/B VDD VSS sg13g2_and2_1
XFILLER_25_1238 VDD VSS sg13g2_decap_8
XFILLER_111_964 VDD VSS sg13g2_decap_8
X_09600_ _14197_/D _14197_/Q _10097_/A0 _09601_/S VDD VSS sg13g2_mux2_1
XFILLER_99_1317 VDD VSS sg13g2_decap_8
XFILLER_112_1219 VDD VSS sg13g2_decap_4
XFILLER_68_377 VDD VSS sg13g2_decap_8
XFILLER_56_517 VDD VSS sg13g2_decap_8
XFILLER_68_388 VDD VSS sg13g2_fill_2
XFILLER_3_1001 VDD VSS sg13g2_decap_8
X_07792_ _07795_/A _08391_/B _08412_/A VDD VSS sg13g2_nand2b_1
XFILLER_95_174 VDD VSS sg13g2_decap_8
XFILLER_37_720 VDD VSS sg13g2_decap_8
XFILLER_49_591 VDD VSS sg13g2_fill_1
X_09531_ _14130_/D _09597_/A1 _14130_/Q _09537_/S VDD VSS sg13g2_mux2_1
XFILLER_97_1030 VDD VSS sg13g2_fill_2
XFILLER_83_358 VDD VSS sg13g2_decap_8
XFILLER_97_1041 VDD VSS sg13g2_decap_8
XFILLER_3_1078 VDD VSS sg13g2_decap_8
XFILLER_149_1142 VDD VSS sg13g2_fill_1
X_09462_ _14063_/D _09462_/A0 _14063_/Q _09462_/S VDD VSS sg13g2_mux2_1
XFILLER_37_797 VDD VSS sg13g2_decap_8
X_13946__2326 _13946_/RESET_B VDD VSS sg13g2_tiehi
XFILLER_97_1085 VDD VSS sg13g2_decap_8
XFILLER_58_1036 VDD VSS sg13g2_decap_8
XFILLER_51_200 VDD VSS sg13g2_decap_8
XFILLER_52_734 VDD VSS sg13g2_fill_2
XFILLER_51_211 VDD VSS sg13g2_fill_1
XFILLER_36_296 VDD VSS sg13g2_decap_8
X_08413_ _08418_/B _08383_/A _08383_/B _08415_/A _08411_/Y _08412_/Y VDD VSS sg13g2_a221oi_1
XFILLER_145_1017 VDD VSS sg13g2_fill_2
XFILLER_12_609 VDD VSS sg13g2_decap_8
X_09393_ _13996_/D _09558_/A0 _13996_/Q _09395_/S VDD VSS sg13g2_mux2_1
XFILLER_52_778 VDD VSS sg13g2_decap_4
XFILLER_71_1214 VDD VSS sg13g2_decap_4
XFILLER_11_119 VDD VSS sg13g2_decap_8
XFILLER_149_110 VDD VSS sg13g2_decap_8
X_08344_ _08344_/Y _08168_/Y _08241_/A _08027_/Y VDD VSS sg13g2_a21oi_1
XFILLER_71_1225 VDD VSS sg13g2_decap_8
XFILLER_177_441 VDD VSS sg13g2_decap_8
XFILLER_32_480 VDD VSS sg13g2_decap_8
XFILLER_178_986 VDD VSS sg13g2_decap_8
XFILLER_32_1209 VDD VSS sg13g2_decap_8
XFILLER_36_1389 VDD VSS sg13g2_decap_8
XFILLER_149_165 VDD VSS sg13g2_decap_8
X_08275_ _08275_/Y _08275_/A _08275_/B VDD VSS sg13g2_nor2_1
XFILLER_123_1348 VDD VSS sg13g2_decap_4
XFILLER_20_675 VDD VSS sg13g2_decap_8
XFILLER_4_819 VDD VSS sg13g2_decap_8
XFILLER_105_202 VDD VSS sg13g2_decap_8
XFILLER_3_329 VDD VSS sg13g2_decap_8
XFILLER_106_747 VDD VSS sg13g2_decap_8
XFILLER_156_1135 VDD VSS sg13g2_decap_8
XFILLER_69_1187 VDD VSS sg13g2_fill_2
XFILLER_154_14 VDD VSS sg13g2_decap_8
XFILLER_160_341 VDD VSS sg13g2_decap_8
XFILLER_105_279 VDD VSS sg13g2_decap_8
XFILLER_82_1332 VDD VSS sg13g2_fill_2
XFILLER_78_119 VDD VSS sg13g2_decap_8
Xfanout1108 _08599_/A _08460_/A1 VDD VSS sg13g2_buf_1
XFILLER_59_300 VDD VSS sg13g2_decap_8
XFILLER_47_1463 VDD VSS sg13g2_decap_8
XFILLER_134_1422 VDD VSS sg13g2_decap_4
Xfanout1119 _08338_/B _08599_/B VDD VSS sg13g2_buf_1
XFILLER_99_491 VDD VSS sg13g2_decap_8
XFILLER_120_238 VDD VSS sg13g2_decap_8
Xfanout143 _09638_/A0 _09772_/A1 VDD VSS sg13g2_buf_1
X_14795__3011 _14795_/RESET_B VDD VSS sg13g2_tiehi
Xfanout154 _10134_/A0 _10167_/A1 VDD VSS sg13g2_buf_1
XFILLER_43_1338 VDD VSS sg13g2_decap_8
XFILLER_101_441 VDD VSS sg13g2_decap_4
XFILLER_134_1466 VDD VSS sg13g2_decap_4
Xfanout165 _09634_/A0 _09138_/X VDD VSS sg13g2_buf_1
XFILLER_59_355 VDD VSS sg13g2_decap_8
XFILLER_102_975 VDD VSS sg13g2_decap_8
Xfanout176 _09931_/A1 _09126_/Y VDD VSS sg13g2_buf_1
Xfanout187 _10093_/A0 _09596_/A1 VDD VSS sg13g2_buf_1
XFILLER_170_35 VDD VSS sg13g2_decap_8
XFILLER_28_731 VDD VSS sg13g2_decap_8
XFILLER_74_347 VDD VSS sg13g2_decap_8
X_09729_ _14320_/D _10092_/A0 _14320_/Q _09731_/S VDD VSS sg13g2_mux2_1
XFILLER_62_509 VDD VSS sg13g2_decap_8
XFILLER_41_1084 VDD VSS sg13g2_decap_4
X_12740_ _12740_/X _13847_/Q _13879_/Q _13911_/Q _13943_/Q _12742_/S0 _12756_/S1 VDD
+ VSS sg13g2_mux4_1
XFILLER_55_572 VDD VSS sg13g2_decap_8
XFILLER_167_1242 VDD VSS sg13g2_fill_2
XFILLER_28_797 VDD VSS sg13g2_fill_2
XFILLER_16_959 VDD VSS sg13g2_decap_8
X_14536__1736 _14536_/RESET_B VDD VSS sg13g2_tiehi
X_12671_ _12671_/X _14706_/Q _14738_/Q _13778_/Q _13810_/Q _12755_/S0 _12758_/S1 VDD
+ VSS sg13g2_mux4_1
XFILLER_43_767 VDD VSS sg13g2_decap_8
XFILLER_15_469 VDD VSS sg13g2_decap_8
XFILLER_93_1450 VDD VSS sg13g2_decap_8
XFILLER_169_931 VDD VSS sg13g2_decap_8
X_14410_ _14410_/Q clkload17/A _14410_/D _14410_/RESET_B VDD VSS sg13g2_dfrbpq_1
X_11622_ _11622_/X _11763_/B _11621_/X _11620_/Y VDD VSS sg13g2_a21o_1
XFILLER_30_417 VDD VSS sg13g2_decap_8
X_15076__2938 _15076_/RESET_B VDD VSS sg13g2_tiehi
XFILLER_179_77 VDD VSS sg13g2_decap_8
XFILLER_8_28 VDD VSS sg13g2_decap_8
XFILLER_54_1467 VDD VSS sg13g2_decap_8
XFILLER_137_0 VDD VSS sg13g2_decap_8
XFILLER_168_463 VDD VSS sg13g2_decap_8
X_14341_ _14341_/Q clkload14/A _14341_/D _14341_/RESET_B VDD VSS sg13g2_dfrbpq_1
XFILLER_141_1437 VDD VSS sg13g2_fill_2
X_14826__2980 _14826_/RESET_B VDD VSS sg13g2_tiehi
X_11553_ _11553_/Y _12245_/S0 _13924_/Q _12184_/B VDD VSS sg13g2_a21oi_1
XFILLER_7_602 VDD VSS sg13g2_decap_8
XFILLER_129_839 VDD VSS sg13g2_decap_8
XFILLER_11_686 VDD VSS sg13g2_decap_8
XFILLER_13_1120 VDD VSS sg13g2_decap_8
X_10504_ _10505_/D _14854_/Q _14853_/Q _14846_/Q _14845_/Q VDD VSS sg13g2_and4_1
XFILLER_6_112 VDD VSS sg13g2_decap_8
XFILLER_109_530 VDD VSS sg13g2_fill_2
XFILLER_155_135 VDD VSS sg13g2_fill_1
X_14272_ _14272_/Q _14720_/CLK _14272_/D _14272_/RESET_B VDD VSS sg13g2_dfrbpq_1
XFILLER_183_455 VDD VSS sg13g2_decap_8
X_11484_ _11485_/B _11503_/A1 _13687_/Q _11463_/Y VDD VSS sg13g2_a21oi_1
Xwire566 wire566/X wire566/A VDD VSS sg13g2_buf_2
XFILLER_10_196 VDD VSS sg13g2_decap_8
XFILLER_155_157 VDD VSS sg13g2_decap_8
X_13223_ _15048_/D _13216_/Y _13222_/Y _13021_/A VDD VSS sg13g2_a21oi_1
XFILLER_7_679 VDD VSS sg13g2_decap_8
XFILLER_12_70 VDD VSS sg13g2_decap_8
XFILLER_170_105 VDD VSS sg13g2_decap_8
X_10435_ _14834_/D _10577_/B _10435_/B _10443_/D VDD VSS sg13g2_nor3_1
XFILLER_100_1145 VDD VSS sg13g2_fill_2
XFILLER_13_1197 VDD VSS sg13g2_decap_8
XFILLER_152_820 VDD VSS sg13g2_decap_8
XFILLER_174_1202 VDD VSS sg13g2_fill_2
XFILLER_136_382 VDD VSS sg13g2_decap_8
X_14180__2092 _14180_/RESET_B VDD VSS sg13g2_tiehi
XFILLER_6_189 VDD VSS sg13g2_decap_8
XFILLER_87_1265 VDD VSS sg13g2_decap_4
X_13154_ _13155_/B _13166_/A1 _13149_/X _13148_/Y _13303_/A _13153_/Y VDD VSS sg13g2_a221oi_1
X_10366_ _10370_/C _10366_/A _10365_/B VDD VSS sg13g2_nor2b_1
XFILLER_83_1129 VDD VSS sg13g2_decap_8
XFILLER_139_1366 VDD VSS sg13g2_decap_8
XFILLER_88_63 VDD VSS sg13g2_decap_8
XFILLER_152_886 VDD VSS sg13g2_decap_8
X_12105_ _12105_/Y _12330_/S0 _14516_/Q _12105_/B1 VDD VSS sg13g2_a21oi_1
XFILLER_88_74 VDD VSS sg13g2_fill_2
XFILLER_174_1279 VDD VSS sg13g2_fill_1
X_13085_ _13085_/Y _13085_/A _13085_/B _13085_/C VDD VSS sg13g2_nand3_1
X_10297_ _10311_/B _10297_/A _10297_/B _10297_/C VDD VSS sg13g2_nor3_1
XFILLER_3_896 VDD VSS sg13g2_decap_8
X_12036_ _12036_/X _12036_/A _12253_/B VDD VSS sg13g2_and2_1
XFILLER_26_7 VDD VSS sg13g2_decap_8
XFILLER_78_697 VDD VSS sg13g2_decap_8
XFILLER_24_1260 VDD VSS sg13g2_decap_8
XFILLER_19_764 VDD VSS sg13g2_decap_8
XFILLER_4_1365 VDD VSS sg13g2_decap_8
X_13987_ _13987_/Q _14723_/CLK _13987_/D _13987_/RESET_B VDD VSS sg13g2_dfrbpq_1
XFILLER_18_252 VDD VSS sg13g2_decap_8
XFILLER_94_1203 VDD VSS sg13g2_decap_8
XFILLER_46_572 VDD VSS sg13g2_decap_4
XFILLER_20_1168 VDD VSS sg13g2_decap_8
X_12938_ _12938_/Y input20/X _12795_/Y _12937_/Y VDD VSS sg13g2_o21ai_1
XFILLER_98_1394 VDD VSS sg13g2_decap_8
XFILLER_55_1209 VDD VSS sg13g2_decap_8
XFILLER_61_553 VDD VSS sg13g2_decap_8
XFILLER_59_1389 VDD VSS sg13g2_decap_8
XFILLER_146_1348 VDD VSS sg13g2_fill_1
XFILLER_185_1397 VDD VSS sg13g2_decap_8
X_12869_ _12869_/Y _12914_/A _12867_/Y _12868_/Y VDD VSS sg13g2_o21ai_1
XFILLER_181_1239 VDD VSS sg13g2_decap_4
XFILLER_33_266 VDD VSS sg13g2_fill_1
XFILLER_178_238 VDD VSS sg13g2_decap_8
XFILLER_21_428 VDD VSS sg13g2_decap_8
X_14608_ _14608_/Q clkload10/A _14608_/D _14608_/RESET_B VDD VSS sg13g2_dfrbpq_1
XFILLER_159_430 VDD VSS sg13g2_decap_8
XFILLER_144_1061 VDD VSS sg13g2_decap_8
X_14390__1882 _14390_/RESET_B VDD VSS sg13g2_tiehi
XFILLER_175_923 VDD VSS sg13g2_fill_2
X_14539_ _14539_/Q clkload9/A _14539_/D _14539_/RESET_B VDD VSS sg13g2_dfrbpq_1
XFILLER_105_1045 VDD VSS sg13g2_decap_8
XFILLER_147_636 VDD VSS sg13g2_fill_1
XFILLER_174_422 VDD VSS sg13g2_decap_8
XFILLER_186_282 VDD VSS sg13g2_decap_8
XFILLER_146_124 VDD VSS sg13g2_decap_8
XFILLER_186_293 VDD VSS sg13g2_decap_8
XFILLER_30_995 VDD VSS sg13g2_decap_8
X_08060_ _08060_/X _11526_/A _11570_/A _11591_/A _11635_/A _08009_/S _07627_/A VDD
+ VSS sg13g2_mux4_1
XFILLER_135_809 VDD VSS sg13g2_fill_1
XFILLER_147_669 VDD VSS sg13g2_decap_8
XFILLER_128_850 VDD VSS sg13g2_fill_2
XFILLER_128_861 VDD VSS sg13g2_decap_4
XFILLER_31_1264 VDD VSS sg13g2_fill_1
XFILLER_143_831 VDD VSS sg13g2_decap_8
X_14010__2262 _14010_/RESET_B VDD VSS sg13g2_tiehi
XFILLER_52_0 VDD VSS sg13g2_decap_8
Xhold3205 _13627_/A _13735_/Q VDD VSS sg13g2_dlygate4sd3_1
XFILLER_89_929 VDD VSS sg13g2_fill_2
Xhold3216 _13621_/A _13729_/Q VDD VSS sg13g2_dlygate4sd3_1
Xhold3227 _10914_/A _14936_/Q VDD VSS sg13g2_dlygate4sd3_1
X_08962_ _09707_/C _09441_/A _09441_/C VDD VSS sg13g2_nand2_1
Xhold3238 _13584_/A _15160_/Q VDD VSS sg13g2_dlygate4sd3_1
XFILLER_88_439 VDD VSS sg13g2_decap_4
XFILLER_102_227 VDD VSS sg13g2_decap_8
X_14614__1658 _14614_/RESET_B VDD VSS sg13g2_tiehi
Xhold3249 hold3249/X _14827_/Q VDD VSS sg13g2_dlygate4sd3_1
XFILLER_9_1232 VDD VSS sg13g2_decap_8
XFILLER_69_631 VDD VSS sg13g2_decap_4
X_07913_ _07913_/Y _07913_/A _08063_/B VDD VSS sg13g2_nand2_1
X_08893_ _08893_/Y _10743_/S _14941_/Q VDD VSS sg13g2_nor2b_1
XFILLER_84_601 VDD VSS sg13g2_decap_8
XFILLER_111_772 VDD VSS sg13g2_fill_1
X_07844_ _07844_/X _15017_/Q _07972_/B VDD VSS sg13g2_and2_1
XFILLER_68_174 VDD VSS sg13g2_decap_8
XFILLER_110_293 VDD VSS sg13g2_decap_8
XFILLER_112_1049 VDD VSS sg13g2_decap_4
XFILLER_72_807 VDD VSS sg13g2_decap_4
XFILLER_56_358 VDD VSS sg13g2_decap_4
X_07775_ _08318_/C _08304_/A _08306_/B VDD VSS sg13g2_xor2_1
XFILLER_84_678 VDD VSS sg13g2_decap_8
XFILLER_186_1128 VDD VSS sg13g2_decap_8
XFILLER_83_155 VDD VSS sg13g2_decap_8
XFILLER_140_16 VDD VSS sg13g2_fill_1
XFILLER_186_1139 VDD VSS sg13g2_decap_8
XFILLER_84_689 VDD VSS sg13g2_fill_1
XFILLER_71_306 VDD VSS sg13g2_decap_8
X_09514_ _14113_/D _10077_/A0 _14113_/Q _09534_/S VDD VSS sg13g2_mux2_1
XFILLER_65_881 VDD VSS sg13g2_decap_8
XFILLER_140_27 VDD VSS sg13g2_decap_8
XFILLER_77_1434 VDD VSS sg13g2_decap_8
X_14929__2779 _14929_/RESET_B VDD VSS sg13g2_tiehi
XFILLER_164_1404 VDD VSS sg13g2_decap_8
X_09445_ _14046_/D _10074_/A0 _14046_/Q _09461_/S VDD VSS sg13g2_mux2_1
XFILLER_80_851 VDD VSS sg13g2_decap_8
XFILLER_73_1309 VDD VSS sg13g2_decap_4
XFILLER_12_406 VDD VSS sg13g2_decap_8
XFILLER_25_789 VDD VSS sg13g2_decap_8
XFILLER_24_266 VDD VSS sg13g2_decap_8
XFILLER_40_726 VDD VSS sg13g2_decap_8
XFILLER_33_14 VDD VSS sg13g2_decap_8
X_09376_ _13979_/D _10071_/A0 _13979_/Q _09395_/S VDD VSS sg13g2_mux2_1
XFILLER_123_1101 VDD VSS sg13g2_fill_1
XFILLER_149_14 VDD VSS sg13g2_decap_8
XFILLER_184_219 VDD VSS sg13g2_decap_4
X_08327_ _08327_/X _11635_/A _11591_/A _11570_/A _11526_/A _08635_/S0 _08635_/S1 VDD
+ VSS sg13g2_mux4_1
XFILLER_123_1123 VDD VSS sg13g2_decap_8
XFILLER_130_7 VDD VSS sg13g2_decap_4
XFILLER_178_783 VDD VSS sg13g2_decap_8
XFILLER_36_1175 VDD VSS sg13g2_decap_8
XFILLER_178_794 VDD VSS sg13g2_fill_1
XFILLER_71_1088 VDD VSS sg13g2_decap_8
XFILLER_137_124 VDD VSS sg13g2_decap_8
XFILLER_71_1099 VDD VSS sg13g2_fill_1
X_08258_ _08258_/Y _08470_/A _14998_/Q _08258_/C VDD VSS sg13g2_nand3_1
XFILLER_123_1189 VDD VSS sg13g2_decap_8
XFILLER_153_617 VDD VSS sg13g2_fill_1
XFILLER_165_477 VDD VSS sg13g2_fill_2
XFILLER_153_628 VDD VSS sg13g2_decap_4
XFILLER_106_500 VDD VSS sg13g2_decap_8
XFILLER_137_179 VDD VSS sg13g2_fill_1
XFILLER_4_616 VDD VSS sg13g2_decap_8
X_08189_ _08190_/B _07909_/B _07910_/A _08188_/Y VDD VSS sg13g2_a21oi_1
XFILLER_10_1337 VDD VSS sg13g2_decap_8
XFILLER_165_35 VDD VSS sg13g2_decap_8
X_10220_ _10220_/Y _14767_/Q _14768_/Q _10337_/C VDD VSS sg13g2_o21ai_1
XFILLER_3_126 VDD VSS sg13g2_decap_8
XFILLER_180_469 VDD VSS sg13g2_decap_8
XFILLER_161_650 VDD VSS sg13g2_decap_8
XFILLER_134_897 VDD VSS sg13g2_decap_8
X_10151_ _14728_/D _14728_/Q _10151_/A1 _10160_/S VDD VSS sg13g2_mux2_1
XFILLER_121_525 VDD VSS sg13g2_fill_1
XFILLER_161_694 VDD VSS sg13g2_fill_2
XFILLER_160_182 VDD VSS sg13g2_decap_8
XFILLER_0_855 VDD VSS sg13g2_decap_8
XFILLER_47_1282 VDD VSS sg13g2_decap_8
X_10082_ _14662_/D _10082_/A0 _14662_/Q _10093_/S VDD VSS sg13g2_mux2_1
XFILLER_58_55 VDD VSS sg13g2_decap_4
XFILLER_82_1184 VDD VSS sg13g2_decap_8
XFILLER_75_601 VDD VSS sg13g2_decap_8
XFILLER_48_815 VDD VSS sg13g2_decap_8
XFILLER_181_56 VDD VSS sg13g2_decap_8
XFILLER_88_995 VDD VSS sg13g2_fill_2
XFILLER_82_1195 VDD VSS sg13g2_fill_2
X_13910_ _13910_/Q clkload39/A _13910_/D _13910_/RESET_B VDD VSS sg13g2_dfrbpq_1
XFILLER_58_99 VDD VSS sg13g2_decap_8
XFILLER_87_483 VDD VSS sg13g2_decap_8
XFILLER_130_1127 VDD VSS sg13g2_decap_8
X_14890_ _14890_/Q _14890_/CLK _14890_/D _14890_/RESET_B VDD VSS sg13g2_dfrbpq_1
XFILLER_87_494 VDD VSS sg13g2_fill_2
XFILLER_47_325 VDD VSS sg13g2_decap_8
XFILLER_43_1179 VDD VSS sg13g2_fill_1
XFILLER_101_282 VDD VSS sg13g2_fill_1
XFILLER_59_196 VDD VSS sg13g2_decap_8
XFILLER_169_1326 VDD VSS sg13g2_decap_8
X_13841_ _13841_/Q _14513_/CLK _13841_/D _13841_/RESET_B VDD VSS sg13g2_dfrbpq_1
XFILLER_74_166 VDD VSS sg13g2_decap_8
XFILLER_21_1466 VDD VSS sg13g2_decap_8
X_14759__3050 _14759_/RESET_B VDD VSS sg13g2_tiehi
XFILLER_21_1477 VDD VSS sg13g2_fill_2
X_13772_ _13772_/Q clkload26/A _13772_/D _13772_/RESET_B VDD VSS sg13g2_dfrbpq_1
X_10984_ _10984_/Y _10984_/A _10981_/Y VDD VSS sg13g2_nor2b_1
XFILLER_43_520 VDD VSS sg13g2_fill_2
XFILLER_90_659 VDD VSS sg13g2_decap_8
XFILLER_74_87 VDD VSS sg13g2_decap_4
XFILLER_16_756 VDD VSS sg13g2_decap_8
X_12723_ _12736_/A _12779_/A1 _12737_/A2 _15016_/Q VDD VSS sg13g2_a21oi_1
X_14198__2074 _14198_/RESET_B VDD VSS sg13g2_tiehi
XFILLER_15_266 VDD VSS sg13g2_decap_8
XFILLER_54_1220 VDD VSS sg13g2_decap_8
X_12654_ _12654_/X _14577_/Q _14609_/Q _14641_/Q _14673_/Q _12654_/S0 _12654_/S1 VDD
+ VSS sg13g2_mux4_1
XFILLER_176_709 VDD VSS sg13g2_decap_8
XFILLER_157_901 VDD VSS sg13g2_decap_8
X_11605_ _11605_/Y _11621_/S0 _14662_/Q _11967_/B VDD VSS sg13g2_a21oi_1
XFILLER_106_1332 VDD VSS sg13g2_decap_8
XFILLER_90_75 VDD VSS sg13g2_fill_1
XFILLER_12_973 VDD VSS sg13g2_decap_8
XFILLER_145_1392 VDD VSS sg13g2_decap_8
XFILLER_156_411 VDD VSS sg13g2_decap_8
X_12585_ _12585_/X _14124_/Q _14156_/Q _14188_/Q _14220_/Q _12585_/S0 _12591_/S1 VDD
+ VSS sg13g2_mux4_1
XFILLER_168_271 VDD VSS sg13g2_decap_8
XFILLER_180_1283 VDD VSS sg13g2_decap_8
XFILLER_106_1365 VDD VSS sg13g2_fill_2
XFILLER_141_1245 VDD VSS sg13g2_decap_8
XFILLER_128_124 VDD VSS sg13g2_fill_2
XFILLER_11_483 VDD VSS sg13g2_decap_8
X_14324_ _14324_/Q clkload55/A _14324_/D _14324_/RESET_B VDD VSS sg13g2_dfrbpq_1
X_11536_ _11536_/Y _12070_/S0 _14564_/Q VDD VSS sg13g2_nand2b_1
XFILLER_89_1316 VDD VSS sg13g2_fill_1
XFILLER_117_809 VDD VSS sg13g2_decap_8
XFILLER_8_966 VDD VSS sg13g2_decap_8
XFILLER_23_91 VDD VSS sg13g2_decap_8
XFILLER_183_252 VDD VSS sg13g2_decap_8
Xwire363 wire363/X wire363/A VDD VSS sg13g2_buf_2
XFILLER_128_168 VDD VSS sg13g2_decap_8
XFILLER_139_91 VDD VSS sg13g2_decap_8
X_14255_ _14255_/Q clkload12/A _14255_/D _14255_/RESET_B VDD VSS sg13g2_dfrbpq_1
XFILLER_7_476 VDD VSS sg13g2_decap_8
XFILLER_143_116 VDD VSS sg13g2_decap_8
XFILLER_176_1319 VDD VSS sg13g2_decap_8
X_11467_ _11467_/X _13953_/Q _13985_/Q _14017_/Q _14049_/Q _11713_/S0 _11713_/S1 VDD
+ VSS sg13g2_mux4_1
XFILLER_99_51 VDD VSS sg13g2_decap_8
X_13206_ _13206_/Y _14825_/Q _13206_/B VDD VSS sg13g2_nand2_1
X_10418_ _10420_/A _14828_/Q _10422_/D _14829_/Q VDD VSS sg13g2_a21o_1
X_14186_ _14186_/Q clkload27/A _14186_/D _14186_/RESET_B VDD VSS sg13g2_dfrbpq_1
X_11398_ _11398_/Y _11415_/S _14591_/Q _11401_/C VDD VSS sg13g2_a21oi_1
XFILLER_152_661 VDD VSS sg13g2_fill_1
XFILLER_140_823 VDD VSS sg13g2_fill_2
X_13137_ _13139_/A _14820_/Q _13068_/B _13180_/B1 _14884_/Q VDD VSS sg13g2_a22oi_1
XFILLER_98_737 VDD VSS sg13g2_decap_8
XFILLER_97_203 VDD VSS sg13g2_decap_8
X_10349_ _10350_/B _14809_/Q _10352_/C VDD VSS sg13g2_nand2_1
XFILLER_3_693 VDD VSS sg13g2_decap_8
XFILLER_112_558 VDD VSS sg13g2_decap_4
XFILLER_112_569 VDD VSS sg13g2_fill_2
X_13068_ _13068_/Y _14815_/Q _13068_/B VDD VSS sg13g2_nand2_1
XFILLER_117_1461 VDD VSS sg13g2_decap_8
XFILLER_61_1224 VDD VSS sg13g2_decap_8
XFILLER_152_1352 VDD VSS sg13g2_decap_8
XFILLER_79_984 VDD VSS sg13g2_decap_4
XFILLER_26_1355 VDD VSS sg13g2_decap_8
Xfanout1450 _12186_/A _12171_/S0 VDD VSS sg13g2_buf_1
X_12019_ _12019_/Y _12019_/A _12019_/B _12237_/C VDD VSS sg13g2_nand3_1
XFILLER_152_1374 VDD VSS sg13g2_fill_2
Xfanout1461 _12243_/A1 _12168_/A VDD VSS sg13g2_buf_1
XFILLER_6_1449 VDD VSS sg13g2_decap_8
XFILLER_22_1219 VDD VSS sg13g2_decap_8
Xfanout1472 _13127_/A fanout1476/X VDD VSS sg13g2_buf_1
XFILLER_66_634 VDD VSS sg13g2_fill_2
XFILLER_38_325 VDD VSS sg13g2_fill_2
Xfanout1483 _13198_/B1 _07625_/Y VDD VSS sg13g2_buf_1
Xfanout1494 _13499_/B fanout1507/X VDD VSS sg13g2_buf_1
XFILLER_65_155 VDD VSS sg13g2_decap_8
XFILLER_54_818 VDD VSS sg13g2_decap_8
XFILLER_4_1162 VDD VSS sg13g2_decap_8
XFILLER_65_166 VDD VSS sg13g2_fill_1
XFILLER_53_328 VDD VSS sg13g2_decap_8
XFILLER_111_1071 VDD VSS sg13g2_fill_1
XFILLER_0_1037 VDD VSS sg13g2_decap_8
XFILLER_111_1082 VDD VSS sg13g2_fill_1
XFILLER_0_84 VDD VSS sg13g2_decap_8
XFILLER_146_1112 VDD VSS sg13g2_decap_8
XFILLER_80_158 VDD VSS sg13g2_fill_1
XFILLER_179_525 VDD VSS sg13g2_decap_8
X_14028__2244 _14028_/RESET_B VDD VSS sg13g2_tiehi
XFILLER_34_564 VDD VSS sg13g2_decap_8
XFILLER_94_1077 VDD VSS sg13g2_fill_2
XFILLER_181_1036 VDD VSS sg13g2_decap_8
XFILLER_21_203 VDD VSS sg13g2_decap_8
X_09230_ _13841_/D _09730_/A0 _13841_/Q _09231_/S VDD VSS sg13g2_mux2_1
XFILLER_142_1009 VDD VSS sg13g2_fill_1
XFILLER_148_923 VDD VSS sg13g2_fill_2
X_09161_ _10793_/C _15052_/Q _15249_/Q _09161_/S VDD VSS sg13g2_mux2_1
XFILLER_175_731 VDD VSS sg13g2_decap_8
X_08112_ _15220_/D _08112_/A _08112_/B _08112_/C _08112_/D VDD VSS sg13g2_nand4_1
X_09092_ _13775_/D _13775_/Q _09926_/A1 _09106_/S VDD VSS sg13g2_mux2_1
XFILLER_174_252 VDD VSS sg13g2_decap_8
XFILLER_147_488 VDD VSS sg13g2_decap_4
X_08043_ _08043_/Y _08042_/X _08428_/S VDD VSS sg13g2_nand2b_1
X_13896__2376 _13896_/RESET_B VDD VSS sg13g2_tiehi
XFILLER_31_1061 VDD VSS sg13g2_fill_1
XFILLER_162_425 VDD VSS sg13g2_decap_8
XFILLER_128_691 VDD VSS sg13g2_decap_4
XFILLER_163_959 VDD VSS sg13g2_decap_8
XFILLER_174_296 VDD VSS sg13g2_fill_1
XFILLER_66_1124 VDD VSS sg13g2_fill_1
XFILLER_115_352 VDD VSS sg13g2_decap_8
XFILLER_115_363 VDD VSS sg13g2_decap_4
XFILLER_103_514 VDD VSS sg13g2_decap_4
XFILLER_171_992 VDD VSS sg13g2_decap_8
XFILLER_89_737 VDD VSS sg13g2_decap_8
XFILLER_135_38 VDD VSS sg13g2_decap_4
Xmax_cap696 _08574_/B _07828_/B VDD VSS sg13g2_buf_2
X_09994_ _14577_/D _10093_/A0 _14577_/Q _09994_/S VDD VSS sg13g2_mux2_1
XFILLER_130_333 VDD VSS sg13g2_fill_1
XFILLER_131_867 VDD VSS sg13g2_decap_8
XFILLER_83_1471 VDD VSS sg13g2_decap_4
XFILLER_131_878 VDD VSS sg13g2_fill_2
X_08945_ _08945_/Y _12229_/A _08955_/S _08944_/Y VDD VSS sg13g2_a21oi_1
XFILLER_170_1441 VDD VSS sg13g2_fill_1
XFILLER_69_450 VDD VSS sg13g2_fill_1
XFILLER_44_1455 VDD VSS sg13g2_decap_8
XFILLER_97_781 VDD VSS sg13g2_decap_4
XFILLER_28_14 VDD VSS sg13g2_decap_8
X_08876_ _13702_/D _16864_/A _08875_/X _08941_/S VDD VSS sg13g2_mux2_1
X_07827_ _07828_/B _15005_/Q _07946_/B VDD VSS sg13g2_xor2_1
XFILLER_85_976 VDD VSS sg13g2_decap_8
XFILLER_57_678 VDD VSS sg13g2_decap_8
X_15136__2778 _15136_/RESET_B VDD VSS sg13g2_tiehi
XFILLER_178_7 VDD VSS sg13g2_decap_8
XFILLER_42_1190 VDD VSS sg13g2_decap_8
XFILLER_38_870 VDD VSS sg13g2_decap_8
XFILLER_84_486 VDD VSS sg13g2_decap_8
X_07758_ _07758_/Y wire705/X _12443_/A2 _07757_/Y VDD VSS sg13g2_o21ai_1
XFILLER_77_1220 VDD VSS sg13g2_decap_8
XFILLER_72_648 VDD VSS sg13g2_decap_8
XFILLER_164_1212 VDD VSS sg13g2_decap_8
XFILLER_44_35 VDD VSS sg13g2_decap_8
XFILLER_129_1332 VDD VSS sg13g2_fill_1
X_07689_ _07690_/A _13438_/A _13281_/C VDD VSS sg13g2_nand2_1
XFILLER_38_1237 VDD VSS sg13g2_fill_2
XFILLER_12_203 VDD VSS sg13g2_decap_8
X_09428_ _14030_/D _10024_/A0 _14030_/Q _09428_/S VDD VSS sg13g2_mux2_1
XFILLER_40_512 VDD VSS sg13g2_decap_8
XFILLER_40_523 VDD VSS sg13g2_fill_2
XFILLER_139_912 VDD VSS sg13g2_decap_8
XFILLER_138_400 VDD VSS sg13g2_decap_8
XFILLER_185_539 VDD VSS sg13g2_decap_8
X_09359_ _13963_/D _09724_/A0 _13963_/Q _09365_/S VDD VSS sg13g2_mux2_1
XFILLER_139_934 VDD VSS sg13g2_decap_8
XFILLER_21_770 VDD VSS sg13g2_fill_1
XFILLER_100_96 VDD VSS sg13g2_decap_8
XFILLER_21_781 VDD VSS sg13g2_decap_8
XFILLER_165_230 VDD VSS sg13g2_decap_8
X_12370_ _12370_/X _12366_/X _12365_/X _12364_/X _12363_/X _12789_/S0 _12705_/S1 VDD
+ VSS sg13g2_mux4_1
XFILLER_60_56 VDD VSS sg13g2_decap_8
XFILLER_20_280 VDD VSS sg13g2_decap_8
XFILLER_5_903 VDD VSS sg13g2_decap_8
XFILLER_154_926 VDD VSS sg13g2_decap_4
XFILLER_176_56 VDD VSS sg13g2_decap_8
X_11321_ _11321_/Y _11319_/Y _11318_/Y _11329_/B1 _11320_/X VDD VSS sg13g2_a22oi_1
XFILLER_14_1281 VDD VSS sg13g2_decap_8
XFILLER_158_1016 VDD VSS sg13g2_fill_1
X_13726__2546 _13726_/RESET_B VDD VSS sg13g2_tiehi
XFILLER_4_413 VDD VSS sg13g2_decap_8
X_14486__1786 _14486_/RESET_B VDD VSS sg13g2_tiehi
XFILLER_10_1134 VDD VSS sg13g2_decap_8
XFILLER_158_1038 VDD VSS sg13g2_fill_2
X_14040_ _14040_/Q clkload24/A _14040_/D _14040_/RESET_B VDD VSS sg13g2_dfrbpq_1
XFILLER_107_853 VDD VSS sg13g2_fill_2
X_11252_ _11252_/Y _11218_/S _14588_/Q _12319_/B1 VDD VSS sg13g2_a21oi_1
XFILLER_88_1371 VDD VSS sg13g2_decap_8
XFILLER_101_1273 VDD VSS sg13g2_decap_8
XFILLER_107_864 VDD VSS sg13g2_decap_8
XFILLER_153_469 VDD VSS sg13g2_decap_4
XFILLER_175_1330 VDD VSS sg13g2_decap_8
XFILLER_84_1213 VDD VSS sg13g2_decap_8
XFILLER_180_266 VDD VSS sg13g2_decap_8
XFILLER_175_1352 VDD VSS sg13g2_fill_2
X_10203_ _15183_/D hold3146/X _15183_/Q _13333_/S VDD VSS sg13g2_mux2_1
XFILLER_79_203 VDD VSS sg13g2_decap_8
XFILLER_136_1314 VDD VSS sg13g2_fill_1
XFILLER_49_1366 VDD VSS sg13g2_decap_8
X_11183_ _11183_/Y _10926_/C _11181_/A _11183_/B1 VDD VSS sg13g2_o21ai_1
XFILLER_161_480 VDD VSS sg13g2_decap_8
XFILLER_175_1396 VDD VSS sg13g2_decap_4
XFILLER_0_630 VDD VSS sg13g2_decap_8
X_10134_ _14712_/D _10134_/A0 _14712_/Q _10134_/S VDD VSS sg13g2_mux2_1
XFILLER_122_878 VDD VSS sg13g2_fill_2
X_14106__2166 _14106_/RESET_B VDD VSS sg13g2_tiehi
XFILLER_121_366 VDD VSS sg13g2_fill_2
XFILLER_125_60 VDD VSS sg13g2_decap_4
X_13941__2331 _13941_/RESET_B VDD VSS sg13g2_tiehi
XFILLER_95_729 VDD VSS sg13g2_decap_8
XFILLER_48_612 VDD VSS sg13g2_fill_2
X_14942_ _14942_/Q _14947_/CLK _14942_/D _14942_/RESET_B VDD VSS sg13g2_dfrbpq_1
X_10065_ _14646_/D _10098_/A0 _14646_/Q _10068_/S VDD VSS sg13g2_mux2_1
XFILLER_87_280 VDD VSS sg13g2_decap_8
XFILLER_169_1101 VDD VSS sg13g2_decap_8
XFILLER_169_1112 VDD VSS sg13g2_fill_1
XFILLER_36_818 VDD VSS sg13g2_decap_8
X_14873_ _14873_/Q clkload67/A _14873_/D _14873_/RESET_B VDD VSS sg13g2_dfrbpq_1
XFILLER_91_913 VDD VSS sg13g2_fill_1
XFILLER_1_1302 VDD VSS sg13g2_decap_8
XFILLER_47_177 VDD VSS sg13g2_decap_8
XFILLER_21_1263 VDD VSS sg13g2_decap_8
X_13824_ _13824_/Q _14720_/CLK _13824_/D _13824_/RESET_B VDD VSS sg13g2_dfrbpq_1
XFILLER_112_1391 VDD VSS sg13g2_decap_8
XFILLER_18_91 VDD VSS sg13g2_decap_8
XFILLER_62_125 VDD VSS sg13g2_fill_1
XFILLER_95_1342 VDD VSS sg13g2_decap_4
XFILLER_141_81 VDD VSS sg13g2_decap_8
XFILLER_90_456 VDD VSS sg13g2_decap_8
XFILLER_16_553 VDD VSS sg13g2_decap_8
XFILLER_1_1379 VDD VSS sg13g2_decap_8
X_13974__2298 _13974_/RESET_B VDD VSS sg13g2_tiehi
XFILLER_44_862 VDD VSS sg13g2_decap_8
X_13755_ _13755_/Q clkload60/A _13755_/D _13755_/RESET_B VDD VSS sg13g2_dfrbpq_1
X_10967_ _10995_/C _10967_/A _11015_/C VDD VSS sg13g2_nand2_1
XFILLER_44_873 VDD VSS sg13g2_fill_2
XFILLER_147_1443 VDD VSS sg13g2_fill_2
XFILLER_56_1337 VDD VSS sg13g2_decap_8
XFILLER_182_1345 VDD VSS sg13g2_decap_8
XFILLER_56_1348 VDD VSS sg13g2_fill_1
X_12706_ _12706_/X _12705_/X _12704_/X _12790_/S VDD VSS sg13g2_mux2_1
XFILLER_93_7 VDD VSS sg13g2_decap_8
XFILLER_43_394 VDD VSS sg13g2_decap_4
X_13686_ _13686_/Q clkload80/A _13686_/D _13686_/RESET_B VDD VSS sg13g2_dfrbpq_1
X_10898_ _10898_/X _10923_/D _10923_/A _10898_/B1 VDD VSS sg13g2_a21o_1
XFILLER_31_545 VDD VSS sg13g2_decap_4
X_12637_ _12637_/Y _13673_/Q _12707_/A2 _12636_/X _12707_/B2 _12707_/C1 VDD VSS sg13g2_a221oi_1
XFILLER_12_770 VDD VSS sg13g2_decap_8
XFILLER_129_433 VDD VSS sg13g2_decap_8
XFILLER_54_1094 VDD VSS sg13g2_decap_4
X_12568_ _12569_/B _13678_/Q _12777_/A2 _12567_/X _12400_/A _12791_/C1 VDD VSS sg13g2_a221oi_1
XFILLER_11_280 VDD VSS sg13g2_decap_8
XFILLER_15_1067 VDD VSS sg13g2_decap_8
XFILLER_156_252 VDD VSS sg13g2_decap_8
X_14893__2851 _14893_/RESET_B VDD VSS sg13g2_tiehi
XFILLER_8_763 VDD VSS sg13g2_decap_8
XFILLER_102_1037 VDD VSS sg13g2_decap_8
X_14307_ _14307_/Q clkload29/A _14307_/D _14307_/RESET_B VDD VSS sg13g2_dfrbpq_1
X_11519_ _11519_/Y _11446_/A _11517_/X _11518_/Y VDD VSS sg13g2_o21ai_1
XFILLER_172_734 VDD VSS sg13g2_fill_2
X_12499_ _14999_/D _12499_/A wire324/X VDD VSS sg13g2_nor2_1
XFILLER_89_1168 VDD VSS sg13g2_decap_8
XFILLER_7_273 VDD VSS sg13g2_decap_8
XFILLER_32_1392 VDD VSS sg13g2_decap_8
X_14316__1956 _14316_/RESET_B VDD VSS sg13g2_tiehi
XFILLER_144_458 VDD VSS sg13g2_decap_8
X_14238_ _14238_/Q clkload49/A _14238_/D _14238_/RESET_B VDD VSS sg13g2_dfrbpq_1
XFILLER_125_650 VDD VSS sg13g2_decap_8
XFILLER_160_929 VDD VSS sg13g2_decap_4
XFILLER_172_789 VDD VSS sg13g2_fill_2
XFILLER_131_108 VDD VSS sg13g2_fill_1
XFILLER_171_277 VDD VSS sg13g2_decap_8
XFILLER_67_1455 VDD VSS sg13g2_decap_8
X_14169_ _14169_/Q clkload37/A _14169_/D _14169_/RESET_B VDD VSS sg13g2_dfrbpq_1
XFILLER_4_980 VDD VSS sg13g2_decap_8
XFILLER_125_694 VDD VSS sg13g2_decap_8
XFILLER_140_620 VDD VSS sg13g2_fill_2
XFILLER_113_845 VDD VSS sg13g2_fill_1
Xfanout709 _13236_/A2 _12918_/A2 VDD VSS sg13g2_buf_1
XFILLER_98_545 VDD VSS sg13g2_decap_8
XFILLER_86_707 VDD VSS sg13g2_decap_8
XFILLER_3_490 VDD VSS sg13g2_decap_8
XFILLER_113_889 VDD VSS sg13g2_decap_8
XFILLER_100_517 VDD VSS sg13g2_decap_8
XFILLER_100_528 VDD VSS sg13g2_fill_1
X_14531__1741 _14531_/RESET_B VDD VSS sg13g2_tiehi
X_08730_ _08730_/Y _07719_/A _11288_/A _13448_/B VDD VSS sg13g2_o21ai_1
XFILLER_26_1152 VDD VSS sg13g2_decap_8
XFILLER_67_943 VDD VSS sg13g2_decap_8
XFILLER_22_1016 VDD VSS sg13g2_decap_8
XFILLER_6_1246 VDD VSS sg13g2_decap_8
XFILLER_38_111 VDD VSS sg13g2_decap_8
XFILLER_15_0 VDD VSS sg13g2_decap_8
XFILLER_94_740 VDD VSS sg13g2_decap_4
XFILLER_61_1076 VDD VSS sg13g2_decap_4
X_08661_ _08661_/X _08661_/A _08661_/B _08661_/C _08661_/D VDD VSS sg13g2_and4_1
XFILLER_38_144 VDD VSS sg13g2_fill_1
XFILLER_61_1098 VDD VSS sg13g2_fill_1
XFILLER_82_924 VDD VSS sg13g2_decap_8
XFILLER_27_829 VDD VSS sg13g2_decap_8
X_07612_ _07612_/Y _13427_/C VDD VSS sg13g2_inv_1
XFILLER_96_1128 VDD VSS sg13g2_decap_4
XFILLER_93_272 VDD VSS sg13g2_fill_2
XFILLER_54_626 VDD VSS sg13g2_decap_8
XFILLER_38_177 VDD VSS sg13g2_decap_8
XFILLER_113_1199 VDD VSS sg13g2_decap_8
X_08592_ _08592_/X _08337_/X _08427_/X _08510_/X _08591_/X _08511_/S _08329_/B VDD
+ VSS sg13g2_mux4_1
XFILLER_74_1415 VDD VSS sg13g2_decap_8
X_13804__2468 _13804_/RESET_B VDD VSS sg13g2_tiehi
XFILLER_179_322 VDD VSS sg13g2_decap_8
XFILLER_22_501 VDD VSS sg13g2_fill_1
XFILLER_22_512 VDD VSS sg13g2_decap_8
XFILLER_62_692 VDD VSS sg13g2_fill_1
XFILLER_34_383 VDD VSS sg13g2_decap_8
X_09213_ _13824_/D _10143_/A1 _13824_/Q _09238_/S VDD VSS sg13g2_mux2_1
XFILLER_10_707 VDD VSS sg13g2_decap_8
XFILLER_14_49 VDD VSS sg13g2_decap_8
XFILLER_179_399 VDD VSS sg13g2_decap_8
XFILLER_72_1161 VDD VSS sg13g2_decap_8
XFILLER_22_589 VDD VSS sg13g2_decap_8
X_09144_ _09145_/B _13245_/A _09137_/C _09143_/Y VDD VSS sg13g2_o21ai_1
XFILLER_124_1273 VDD VSS sg13g2_decap_8
XFILLER_175_561 VDD VSS sg13g2_decap_8
XFILLER_108_628 VDD VSS sg13g2_decap_8
XFILLER_11_1421 VDD VSS sg13g2_decap_8
XFILLER_147_274 VDD VSS sg13g2_decap_4
X_09075_ _09075_/X _13088_/A _09103_/C _09074_/Y VDD VSS sg13g2_a21o_1
XFILLER_135_425 VDD VSS sg13g2_decap_8
XFILLER_107_149 VDD VSS sg13g2_decap_8
X_08026_ _08397_/A _08201_/A wire719/X VDD VSS sg13g2_nor2_1
XFILLER_123_609 VDD VSS sg13g2_fill_1
XFILLER_151_918 VDD VSS sg13g2_decap_8
XFILLER_163_778 VDD VSS sg13g2_decap_8
XFILLER_162_255 VDD VSS sg13g2_decap_8
XFILLER_2_917 VDD VSS sg13g2_decap_8
XFILLER_116_672 VDD VSS sg13g2_decap_8
XFILLER_104_834 VDD VSS sg13g2_decap_8
XFILLER_150_439 VDD VSS sg13g2_fill_2
XFILLER_162_299 VDD VSS sg13g2_decap_8
XFILLER_1_427 VDD VSS sg13g2_decap_8
XFILLER_89_534 VDD VSS sg13g2_decap_8
XFILLER_81_1419 VDD VSS sg13g2_decap_8
XFILLER_162_14 VDD VSS sg13g2_decap_8
XFILLER_39_35 VDD VSS sg13g2_decap_8
X_09977_ _14560_/D _10043_/A0 _14560_/Q _09998_/S VDD VSS sg13g2_mux2_1
XFILLER_89_589 VDD VSS sg13g2_decap_8
XFILLER_77_729 VDD VSS sg13g2_decap_8
XFILLER_131_686 VDD VSS sg13g2_decap_4
Xclkbuf_4_3_0_clk_i clkbuf_4_3_0_clk_i/X clkbuf_0_clk_i/X VDD VSS sg13g2_buf_8
XFILLER_76_217 VDD VSS sg13g2_decap_4
Xclkbuf_leaf_100_clk_i _14883_/CLK clkbuf_leaf_99_clk_i/A VDD VSS sg13g2_buf_8
XFILLER_135_1380 VDD VSS sg13g2_fill_2
X_08928_ _08928_/X _08927_/X _12061_/A _08931_/S VDD VSS sg13g2_mux2_1
XFILLER_58_943 VDD VSS sg13g2_fill_2
XFILLER_69_280 VDD VSS sg13g2_decap_4
XFILLER_85_740 VDD VSS sg13g2_fill_1
XFILLER_73_902 VDD VSS sg13g2_decap_8
XFILLER_58_976 VDD VSS sg13g2_fill_1
X_08859_ _08859_/X _15028_/Q _14932_/Q _10675_/A VDD VSS sg13g2_mux2_1
XFILLER_84_261 VDD VSS sg13g2_decap_8
XFILLER_79_1337 VDD VSS sg13g2_decap_4
XFILLER_44_103 VDD VSS sg13g2_fill_2
X_11870_ _11870_/Y _11874_/S0 _13870_/Q _11366_/C VDD VSS sg13g2_a21oi_1
XFILLER_72_423 VDD VSS sg13g2_fill_1
XFILLER_55_56 VDD VSS sg13g2_decap_8
XFILLER_72_456 VDD VSS sg13g2_fill_2
XFILLER_44_147 VDD VSS sg13g2_decap_8
Xclkbuf_leaf_115_clk_i clkload57/A clkbuf_leaf_83_clk_i/A VDD VSS sg13g2_buf_8
X_10821_ _10823_/C _10821_/A _10821_/B _10821_/C VDD VSS sg13g2_nand3_1
XFILLER_32_309 VDD VSS sg13g2_decap_8
XFILLER_164_1031 VDD VSS sg13g2_decap_8
XFILLER_81_990 VDD VSS sg13g2_decap_8
X_13540_ _15145_/D _13547_/B _13538_/Y _13539_/Y VDD VSS sg13g2_a21oi_1
X_10752_ _10752_/Y _10757_/A _10752_/B VDD VSS sg13g2_nor2_1
XFILLER_53_692 VDD VSS sg13g2_decap_8
XFILLER_41_843 VDD VSS sg13g2_decap_8
XFILLER_40_320 VDD VSS sg13g2_fill_1
XFILLER_164_1064 VDD VSS sg13g2_decap_8
XFILLER_186_815 VDD VSS sg13g2_decap_8
XFILLER_13_567 VDD VSS sg13g2_decap_8
XFILLER_40_342 VDD VSS sg13g2_fill_1
XFILLER_16_1321 VDD VSS sg13g2_decap_8
X_13471_ _15176_/D hold3116/X _15176_/Q _13477_/S VDD VSS sg13g2_mux2_1
X_10683_ _10827_/B _08985_/X _08848_/A _08848_/Y VDD VSS sg13g2_a21oi_1
XFILLER_139_731 VDD VSS sg13g2_decap_8
XFILLER_185_336 VDD VSS sg13g2_decap_8
XFILLER_142_1340 VDD VSS sg13g2_decap_8
XFILLER_142_1351 VDD VSS sg13g2_fill_1
X_15210_ _15210_/Q _15212_/CLK _15210_/D _15210_/RESET_B VDD VSS sg13g2_dfrbpq_1
X_12422_ _12422_/X _14560_/Q _14592_/Q _14624_/Q _14656_/Q _12424_/S0 _12424_/S1 VDD
+ VSS sg13g2_mux4_1
XFILLER_51_1234 VDD VSS sg13g2_fill_2
XFILLER_103_1313 VDD VSS sg13g2_decap_8
XFILLER_138_241 VDD VSS sg13g2_decap_8
X_13959__2313 _13959_/RESET_B VDD VSS sg13g2_tiehi
XFILLER_103_1324 VDD VSS sg13g2_fill_1
XFILLER_154_701 VDD VSS sg13g2_decap_8
XFILLER_127_926 VDD VSS sg13g2_decap_8
XFILLER_12_1218 VDD VSS sg13g2_decap_8
XFILLER_51_1267 VDD VSS sg13g2_decap_8
XFILLER_16_1398 VDD VSS sg13g2_decap_8
XFILLER_5_700 VDD VSS sg13g2_decap_8
X_15141_ _15141_/Q clkload77/A _15141_/D _15141_/RESET_B VDD VSS sg13g2_dfrbpq_1
X_12353_ _12353_/X _12345_/X _12350_/X _12344_/X _12349_/X _12790_/S wire856/A VDD
+ VSS sg13g2_mux4_1
XFILLER_127_959 VDD VSS sg13g2_fill_1
XFILLER_153_222 VDD VSS sg13g2_decap_8
XFILLER_4_210 VDD VSS sg13g2_decap_8
XFILLER_177_1447 VDD VSS sg13g2_decap_8
X_11304_ _11304_/Y _11317_/A1 _14621_/Q VDD VSS sg13g2_nand2b_1
XFILLER_177_1458 VDD VSS sg13g2_decap_8
XFILLER_181_553 VDD VSS sg13g2_decap_8
X_15072_ _15072_/Q clkload87/A _15072_/D _15072_/RESET_B VDD VSS sg13g2_dfrbpq_1
XFILLER_154_778 VDD VSS sg13g2_decap_8
X_12284_ _12284_/X _14713_/Q _14745_/Q _13785_/Q _13817_/Q _12284_/S0 _12284_/S1 VDD
+ VSS sg13g2_mux4_1
XFILLER_177_1469 VDD VSS sg13g2_fill_1
XFILLER_5_777 VDD VSS sg13g2_decap_8
XFILLER_107_672 VDD VSS sg13g2_decap_8
X_14023_ _14023_/Q _14607_/CLK _14023_/D _14023_/RESET_B VDD VSS sg13g2_dfrbpq_1
XFILLER_20_70 VDD VSS sg13g2_decap_8
X_11235_ _11235_/X _11232_/Y _11233_/Y _15217_/Q VDD VSS sg13g2_a21o_1
XFILLER_4_287 VDD VSS sg13g2_decap_8
XFILLER_106_182 VDD VSS sg13g2_fill_1
XFILLER_171_1013 VDD VSS sg13g2_decap_8
XFILLER_106_193 VDD VSS sg13g2_decap_8
XFILLER_136_1144 VDD VSS sg13g2_decap_8
XFILLER_45_1027 VDD VSS sg13g2_decap_8
X_11166_ _11166_/Y _11162_/Y _11165_/X _10926_/C VDD VSS sg13g2_o21ai_1
XFILLER_121_141 VDD VSS sg13g2_decap_8
XFILLER_150_984 VDD VSS sg13g2_decap_8
XFILLER_95_515 VDD VSS sg13g2_fill_1
XFILLER_62_1330 VDD VSS sg13g2_fill_2
XFILLER_1_994 VDD VSS sg13g2_decap_8
X_10117_ _14695_/D _10117_/A0 _14695_/Q _10135_/S VDD VSS sg13g2_mux2_1
XFILLER_67_228 VDD VSS sg13g2_fill_1
XFILLER_27_1461 VDD VSS sg13g2_decap_8
XFILLER_114_1431 VDD VSS sg13g2_fill_1
X_11097_ _11097_/Y _11097_/A _11115_/A _11097_/C VDD VSS sg13g2_nor3_1
X_14925_ _14925_/Q clkload72/A _14925_/D _14925_/RESET_B VDD VSS sg13g2_dfrbpq_1
X_10048_ _14629_/D _10115_/A0 _14629_/Q _10060_/S VDD VSS sg13g2_mux2_1
XFILLER_48_464 VDD VSS sg13g2_decap_8
XFILLER_23_1358 VDD VSS sg13g2_decap_8
XFILLER_75_272 VDD VSS sg13g2_decap_8
XFILLER_91_732 VDD VSS sg13g2_decap_8
XFILLER_184_1407 VDD VSS sg13g2_decap_4
X_14856_ _14856_/Q clkload68/A _14856_/D _14856_/RESET_B VDD VSS sg13g2_dfrbpq_1
XFILLER_97_1459 VDD VSS sg13g2_fill_2
XFILLER_184_1429 VDD VSS sg13g2_decap_8
XFILLER_90_242 VDD VSS sg13g2_decap_4
X_13807_ _13807_/Q clkload13/A _13807_/D _13807_/RESET_B VDD VSS sg13g2_dfrbpq_1
XFILLER_91_787 VDD VSS sg13g2_decap_8
XFILLER_35_169 VDD VSS sg13g2_fill_1
XFILLER_16_350 VDD VSS sg13g2_decap_8
XFILLER_1_1176 VDD VSS sg13g2_decap_8
X_14787_ _14787_/Q _14890_/CLK _14787_/D _14787_/RESET_B VDD VSS sg13g2_dfrbpq_1
X_11999_ _12000_/B _11997_/X _11996_/X _11991_/X _11990_/X _11953_/C _11999_/S1 VDD
+ VSS sg13g2_mux4_1
XFILLER_32_821 VDD VSS sg13g2_decap_8
XFILLER_91_1025 VDD VSS sg13g2_decap_8
X_13738_ _13738_/Q clkload19/A _13738_/D _13738_/RESET_B VDD VSS sg13g2_dfrbpq_1
XFILLER_91_1036 VDD VSS sg13g2_fill_1
XFILLER_143_1104 VDD VSS sg13g2_decap_8
XFILLER_147_1273 VDD VSS sg13g2_decap_8
XFILLER_149_517 VDD VSS sg13g2_decap_8
XFILLER_31_331 VDD VSS sg13g2_decap_8
XFILLER_56_1178 VDD VSS sg13g2_fill_2
XFILLER_177_837 VDD VSS sg13g2_decap_8
XFILLER_34_1421 VDD VSS sg13g2_decap_8
XFILLER_176_336 VDD VSS sg13g2_decap_8
X_13669_ _13669_/Q clkload81/A _13669_/D _13669_/RESET_B VDD VSS sg13g2_dfrbpq_1
XFILLER_160_1462 VDD VSS sg13g2_decap_8
XFILLER_160_1473 VDD VSS sg13g2_fill_2
XFILLER_145_701 VDD VSS sg13g2_decap_4
X_14549__1723 _14549_/RESET_B VDD VSS sg13g2_tiehi
XFILLER_129_263 VDD VSS sg13g2_decap_8
XFILLER_185_881 VDD VSS sg13g2_decap_8
XFILLER_8_560 VDD VSS sg13g2_decap_8
XFILLER_145_723 VDD VSS sg13g2_decap_8
XFILLER_117_436 VDD VSS sg13g2_decap_8
XFILLER_118_959 VDD VSS sg13g2_decap_8
Xclkbuf_leaf_94_clk_i _14876_/CLK clkbuf_leaf_94_clk_i/A VDD VSS sg13g2_buf_8
XFILLER_144_244 VDD VSS sg13g2_decap_8
XFILLER_145_767 VDD VSS sg13g2_decap_8
XFILLER_104_119 VDD VSS sg13g2_fill_2
X_09900_ _14486_/D _09933_/A1 _14486_/Q _09901_/S VDD VSS sg13g2_mux2_1
XFILLER_99_843 VDD VSS sg13g2_fill_2
XFILLER_28_1214 VDD VSS sg13g2_decap_8
XFILLER_63_1105 VDD VSS sg13g2_decap_8
XFILLER_113_642 VDD VSS sg13g2_decap_4
XFILLER_141_962 VDD VSS sg13g2_decap_8
Xfanout517 _09407_/S _09375_/Y VDD VSS sg13g2_buf_1
X_09831_ _14419_/D _09831_/A0 _14419_/Q _09837_/S VDD VSS sg13g2_mux2_1
XFILLER_99_876 VDD VSS sg13g2_decap_8
XFILLER_98_353 VDD VSS sg13g2_decap_8
XFILLER_154_1255 VDD VSS sg13g2_decap_8
Xfanout528 _09237_/S _09233_/S VDD VSS sg13g2_buf_1
XFILLER_98_364 VDD VSS sg13g2_fill_1
Xfanout539 _08858_/S _08834_/X VDD VSS sg13g2_buf_1
XFILLER_100_303 VDD VSS sg13g2_fill_2
XFILLER_115_1228 VDD VSS sg13g2_decap_8
Xclkbuf_5_12__f_clk_i clkbuf_leaf_48_clk_i/A clkbuf_4_6_0_clk_i/X VDD VSS sg13g2_buf_16
XFILLER_41_1403 VDD VSS sg13g2_decap_8
X_09762_ _14352_/D _14352_/Q _10092_/A0 _09764_/S VDD VSS sg13g2_mux2_1
XFILLER_6_1043 VDD VSS sg13g2_decap_8
XFILLER_41_1425 VDD VSS sg13g2_decap_8
XFILLER_39_442 VDD VSS sg13g2_decap_8
X_08713_ _15189_/D input16/X _15189_/Q _08719_/S VDD VSS sg13g2_mux2_1
XFILLER_67_762 VDD VSS sg13g2_decap_8
XFILLER_132_28 VDD VSS sg13g2_decap_8
X_09693_ _14285_/D _09924_/A1 _14285_/Q _09698_/S VDD VSS sg13g2_mux2_1
XFILLER_73_209 VDD VSS sg13g2_decap_8
Xclkbuf_leaf_32_clk_i clkload30/A clkbuf_5_8__f_clk_i/X VDD VSS sg13g2_buf_8
X_08644_ _08646_/C _15016_/Q _12152_/A _07855_/B VDD VSS sg13g2_o21ai_1
XFILLER_82_754 VDD VSS sg13g2_decap_8
XFILLER_54_445 VDD VSS sg13g2_fill_1
XFILLER_148_1026 VDD VSS sg13g2_decap_8
XFILLER_26_158 VDD VSS sg13g2_decap_8
X_08575_ _08575_/Y _08575_/A _08575_/B _08575_/C VDD VSS sg13g2_nor3_1
XFILLER_78_1370 VDD VSS sg13g2_fill_1
XFILLER_70_938 VDD VSS sg13g2_fill_1
XFILLER_42_629 VDD VSS sg13g2_decap_8
XFILLER_74_1234 VDD VSS sg13g2_decap_8
XFILLER_41_128 VDD VSS sg13g2_decap_8
XFILLER_35_692 VDD VSS sg13g2_decap_8
XFILLER_168_804 VDD VSS sg13g2_decap_8
XFILLER_74_1245 VDD VSS sg13g2_fill_1
Xclkbuf_leaf_47_clk_i _14720_/CLK clkbuf_leaf_47_clk_i/A VDD VSS sg13g2_buf_8
XFILLER_35_1218 VDD VSS sg13g2_decap_8
XFILLER_22_342 VDD VSS sg13g2_fill_2
XFILLER_161_1226 VDD VSS sg13g2_decap_4
XFILLER_10_504 VDD VSS sg13g2_decap_8
XFILLER_179_196 VDD VSS sg13g2_decap_8
XFILLER_167_347 VDD VSS sg13g2_decap_8
XFILLER_41_14 VDD VSS sg13g2_decap_8
XFILLER_155_509 VDD VSS sg13g2_decap_8
XFILLER_157_14 VDD VSS sg13g2_decap_8
XFILLER_108_403 VDD VSS sg13g2_decap_8
X_09127_ _13780_/D _13780_/Q _10163_/A1 _09127_/S VDD VSS sg13g2_mux2_1
XFILLER_109_948 VDD VSS sg13g2_decap_4
XFILLER_159_1100 VDD VSS sg13g2_fill_1
XFILLER_108_447 VDD VSS sg13g2_decap_8
XFILLER_124_907 VDD VSS sg13g2_decap_4
X_09058_ _09058_/Y _09024_/A _10725_/B _09057_/X VDD VSS sg13g2_o21ai_1
XFILLER_150_203 VDD VSS sg13g2_decap_8
XFILLER_163_586 VDD VSS sg13g2_decap_8
XFILLER_2_714 VDD VSS sg13g2_decap_8
XFILLER_135_288 VDD VSS sg13g2_decap_8
X_08009_ _08009_/X _08673_/B _08048_/B _08009_/S VDD VSS sg13g2_mux2_1
XFILLER_11_1295 VDD VSS sg13g2_decap_8
XFILLER_104_620 VDD VSS sg13g2_decap_8
XFILLER_116_480 VDD VSS sg13g2_decap_8
X_15060__2586 _15060_/RESET_B VDD VSS sg13g2_tiehi
XFILLER_104_631 VDD VSS sg13g2_fill_1
XFILLER_1_224 VDD VSS sg13g2_decap_8
XFILLER_173_35 VDD VSS sg13g2_decap_8
XFILLER_172_1333 VDD VSS sg13g2_decap_8
X_11020_ _14942_/D _11019_/Y _11018_/Y _11001_/Y VDD VSS sg13g2_o21ai_1
XFILLER_172_1366 VDD VSS sg13g2_decap_8
XFILLER_46_1369 VDD VSS sg13g2_decap_8
XFILLER_66_11 VDD VSS sg13g2_fill_2
XFILLER_49_239 VDD VSS sg13g2_fill_1
X_12971_ _15031_/D _12962_/Y _12970_/Y _13266_/A VDD VSS sg13g2_a21oi_1
XFILLER_100_881 VDD VSS sg13g2_decap_8
XFILLER_85_581 VDD VSS sg13g2_decap_8
XFILLER_46_935 VDD VSS sg13g2_decap_8
XFILLER_45_412 VDD VSS sg13g2_decap_8
X_14710_ _14710_/Q _14744_/CLK _14710_/D _14710_/RESET_B VDD VSS sg13g2_dfrbpq_1
X_11922_ _11922_/X _14255_/Q _14287_/Q _14319_/Q _14351_/Q _11925_/S0 _11925_/S1 VDD
+ VSS sg13g2_mux4_1
XFILLER_79_1156 VDD VSS sg13g2_decap_8
XFILLER_72_231 VDD VSS sg13g2_fill_1
XFILLER_22_1380 VDD VSS sg13g2_decap_8
XFILLER_17_147 VDD VSS sg13g2_decap_8
X_14627__1645 _14627_/RESET_B VDD VSS sg13g2_tiehi
XFILLER_79_1167 VDD VSS sg13g2_decap_8
XFILLER_45_456 VDD VSS sg13g2_decap_4
XFILLER_2_1463 VDD VSS sg13g2_decap_8
XFILLER_167_0 VDD VSS sg13g2_decap_8
X_14641_ _14641_/Q clkload7/A _14641_/D _14641_/RESET_B VDD VSS sg13g2_dfrbpq_1
XFILLER_2_1474 VDD VSS sg13g2_fill_1
X_11853_ _11853_/X _14381_/Q _14413_/Q _14477_/Q _14509_/Q _11738_/S _11963_/S1 VDD
+ VSS sg13g2_mux4_1
XFILLER_32_128 VDD VSS sg13g2_decap_8
X_10804_ _10804_/Y _10805_/B _10805_/C _15121_/Q VDD VSS sg13g2_o21ai_1
XFILLER_82_65 VDD VSS sg13g2_decap_8
XFILLER_159_804 VDD VSS sg13g2_decap_8
XFILLER_18_1416 VDD VSS sg13g2_decap_8
X_14572_ _14572_/Q clkload26/A _14572_/D _14572_/RESET_B VDD VSS sg13g2_dfrbpq_1
X_11784_ _11784_/X _13739_/Q _14091_/Q _14443_/Q _14539_/Q _11850_/S0 _07654_/A VDD
+ VSS sg13g2_mux4_1
XFILLER_92_1345 VDD VSS sg13g2_decap_8
XFILLER_32_139 VDD VSS sg13g2_fill_1
XFILLER_25_180 VDD VSS sg13g2_fill_1
XFILLER_14_854 VDD VSS sg13g2_decap_8
XFILLER_183_1473 VDD VSS sg13g2_decap_4
X_13891__2381 _13891_/RESET_B VDD VSS sg13g2_tiehi
XFILLER_53_1307 VDD VSS sg13g2_decap_8
XFILLER_159_826 VDD VSS sg13g2_decap_8
XFILLER_15_70 VDD VSS sg13g2_decap_8
X_13523_ _13523_/Y _13523_/A _13535_/B VDD VSS sg13g2_nor2_1
XFILLER_13_364 VDD VSS sg13g2_decap_8
X_10735_ _10735_/Y _10747_/A _10735_/B VDD VSS sg13g2_nor2_1
XFILLER_92_1389 VDD VSS sg13g2_decap_8
XFILLER_185_133 VDD VSS sg13g2_decap_8
XFILLER_51_1031 VDD VSS sg13g2_decap_8
XFILLER_186_678 VDD VSS sg13g2_decap_8
X_13454_ _13455_/D _15169_/Q _15170_/Q _13454_/C _13454_/D VDD VSS sg13g2_nand4_1
X_10666_ _10667_/C _14894_/Q _14893_/Q _14892_/Q _10666_/D VDD VSS sg13g2_and4_1
XFILLER_9_357 VDD VSS sg13g2_decap_8
XFILLER_186_689 VDD VSS sg13g2_decap_8
XFILLER_142_1170 VDD VSS sg13g2_decap_8
XFILLER_12_1015 VDD VSS sg13g2_decap_8
XFILLER_139_572 VDD VSS sg13g2_decap_4
X_12405_ _12405_/X _13951_/Q _13983_/Q _14015_/Q _14047_/Q _12411_/S0 _12411_/S1 VDD
+ VSS sg13g2_mux4_1
XFILLER_16_1195 VDD VSS sg13g2_decap_8
X_13385_ _15081_/D _13435_/A _13378_/C _13384_/Y VDD VSS sg13g2_o21ai_1
XFILLER_126_222 VDD VSS sg13g2_decap_8
X_10597_ _10610_/D _14876_/Q _14875_/Q _14874_/Q _10597_/D VDD VSS sg13g2_and4_1
XFILLER_166_391 VDD VSS sg13g2_decap_8
X_15124_ _15124_/Q clkload84/A _15124_/D _15124_/RESET_B VDD VSS sg13g2_dfrbpq_1
XFILLER_177_1244 VDD VSS sg13g2_fill_1
XFILLER_182_873 VDD VSS sg13g2_decap_8
Xoutput109 mem_axi_wdata[14] _15146_/Q VDD VSS sg13g2_buf_1
X_12336_ _12336_/Y _12331_/X _11224_/A _12334_/C VDD VSS sg13g2_a21oi_1
XFILLER_181_350 VDD VSS sg13g2_decap_8
XFILLER_86_1138 VDD VSS sg13g2_decap_8
XFILLER_56_7 VDD VSS sg13g2_decap_8
XFILLER_5_574 VDD VSS sg13g2_decap_8
X_15055_ _15055_/Q clkload88/A _15055_/D _15055_/RESET_B VDD VSS sg13g2_dfrbpq_1
X_12267_ _12267_/Y _14923_/Q _11792_/B _12263_/Y _12266_/Y VDD VSS sg13g2_a22oi_1
X_14006_ _14006_/Q _14739_/CLK _14006_/D _14006_/RESET_B VDD VSS sg13g2_dfrbpq_1
X_11218_ _11218_/X _14619_/Q _14651_/Q _11218_/S VDD VSS sg13g2_mux2_1
X_12198_ _12200_/B _12198_/A _12198_/B _12198_/C _12198_/D VDD VSS sg13g2_nor4_1
Xoutput80 mem_axi_awaddr[19] _16872_/X VDD VSS sg13g2_buf_1
Xoutput91 mem_axi_awaddr[2] _16855_/X VDD VSS sg13g2_buf_1
XFILLER_151_1439 VDD VSS sg13g2_decap_4
X_11149_ _11151_/B _11150_/B _11150_/A VDD VSS sg13g2_nor2_1
XFILLER_1_791 VDD VSS sg13g2_decap_8
XFILLER_7_1330 VDD VSS sg13g2_decap_8
XFILLER_62_1182 VDD VSS sg13g2_fill_1
XFILLER_83_518 VDD VSS sg13g2_decap_8
XFILLER_37_913 VDD VSS sg13g2_fill_1
XFILLER_114_1272 VDD VSS sg13g2_decap_8
XFILLER_23_1155 VDD VSS sg13g2_decap_8
XFILLER_149_1302 VDD VSS sg13g2_decap_8
X_14908_ _14908_/Q clkload75/A _14908_/D _14908_/RESET_B VDD VSS sg13g2_dfrbpq_1
XFILLER_36_445 VDD VSS sg13g2_fill_1
XFILLER_36_456 VDD VSS sg13g2_decap_8
XFILLER_149_1346 VDD VSS sg13g2_fill_1
XFILLER_58_1229 VDD VSS sg13g2_fill_1
X_14839_ _14839_/Q clkload68/A _14839_/D _14839_/RESET_B VDD VSS sg13g2_dfrbpq_1
XFILLER_97_1289 VDD VSS sg13g2_fill_2
XFILLER_63_264 VDD VSS sg13g2_decap_8
XFILLER_91_584 VDD VSS sg13g2_decap_8
XFILLER_63_275 VDD VSS sg13g2_fill_1
XFILLER_36_489 VDD VSS sg13g2_decap_8
XFILLER_149_1379 VDD VSS sg13g2_decap_8
XFILLER_63_286 VDD VSS sg13g2_fill_1
X_08360_ _08360_/Y _08244_/B _08198_/X _08397_/A VDD VSS sg13g2_o21ai_1
XFILLER_51_459 VDD VSS sg13g2_decap_4
X_13721__2551 _13721_/RESET_B VDD VSS sg13g2_tiehi
X_14481__1791 _14481_/RESET_B VDD VSS sg13g2_tiehi
XFILLER_71_1418 VDD VSS sg13g2_decap_8
XFILLER_32_651 VDD VSS sg13g2_decap_8
XFILLER_177_623 VDD VSS sg13g2_decap_8
X_08291_ _08291_/Y _08290_/X _08318_/D _08039_/A VDD VSS sg13g2_a21oi_1
XFILLER_108_1054 VDD VSS sg13g2_decap_8
XFILLER_176_133 VDD VSS sg13g2_decap_8
XFILLER_82_0 VDD VSS sg13g2_decap_8
XFILLER_149_358 VDD VSS sg13g2_fill_1
XFILLER_31_183 VDD VSS sg13g2_decap_8
XFILLER_149_369 VDD VSS sg13g2_decap_8
XFILLER_20_868 VDD VSS sg13g2_decap_8
X_14065__2207 _14065_/RESET_B VDD VSS sg13g2_tiehi
XFILLER_118_734 VDD VSS sg13g2_decap_8
XFILLER_145_520 VDD VSS sg13g2_fill_2
XFILLER_11_28 VDD VSS sg13g2_decap_8
X_14101__2171 _14101_/RESET_B VDD VSS sg13g2_tiehi
XFILLER_127_28 VDD VSS sg13g2_decap_8
XFILLER_160_501 VDD VSS sg13g2_decap_8
XFILLER_173_895 VDD VSS sg13g2_decap_8
XFILLER_172_394 VDD VSS sg13g2_decap_8
XFILLER_114_940 VDD VSS sg13g2_decap_8
XFILLER_114_951 VDD VSS sg13g2_fill_1
X_14705__1567 _14705_/RESET_B VDD VSS sg13g2_tiehi
XFILLER_28_1011 VDD VSS sg13g2_decap_8
XFILLER_114_962 VDD VSS sg13g2_decap_8
XFILLER_160_578 VDD VSS sg13g2_decap_8
Xfanout303 _10115_/A0 _09025_/X VDD VSS sg13g2_buf_1
Xfanout314 _09945_/A1 _09613_/A0 VDD VSS sg13g2_buf_1
Xfanout325 _11052_/A _11040_/A VDD VSS sg13g2_buf_1
XFILLER_59_515 VDD VSS sg13g2_fill_2
XFILLER_8_1127 VDD VSS sg13g2_decap_8
Xfanout336 _10096_/S _10102_/S VDD VSS sg13g2_buf_1
X_09814_ _14402_/D _09913_/A1 _14402_/Q _09833_/S VDD VSS sg13g2_mux2_1
XFILLER_101_634 VDD VSS sg13g2_decap_8
Xfanout358 _09871_/S wire363/X VDD VSS sg13g2_buf_1
XFILLER_28_1088 VDD VSS sg13g2_decap_8
XFILLER_100_133 VDD VSS sg13g2_decap_8
XFILLER_101_678 VDD VSS sg13g2_decap_8
X_09745_ _14335_/D _14335_/Q _10109_/A0 _09766_/S VDD VSS sg13g2_mux2_1
XFILLER_101_689 VDD VSS sg13g2_fill_2
XFILLER_28_924 VDD VSS sg13g2_decap_8
XFILLER_41_1255 VDD VSS sg13g2_decap_8
XFILLER_132_1383 VDD VSS sg13g2_decap_8
XFILLER_36_14 VDD VSS sg13g2_decap_8
XFILLER_100_199 VDD VSS sg13g2_decap_8
XFILLER_55_743 VDD VSS sg13g2_decap_8
X_09676_ _14268_/D _10139_/A1 _14268_/Q _09706_/S VDD VSS sg13g2_mux2_1
XFILLER_82_540 VDD VSS sg13g2_fill_2
XFILLER_27_456 VDD VSS sg13g2_decap_8
X_14854__2929 _14854_/RESET_B VDD VSS sg13g2_tiehi
X_08627_ _08627_/Y _15015_/Q _08627_/A2 _08698_/B VDD VSS sg13g2_a21oi_1
XFILLER_160_7 VDD VSS sg13g2_decap_8
XFILLER_36_990 VDD VSS sg13g2_fill_2
XFILLER_54_297 VDD VSS sg13g2_decap_8
X_08558_ _08581_/C _08201_/A _08243_/Y _08557_/Y VDD VSS sg13g2_o21ai_1
XFILLER_42_459 VDD VSS sg13g2_decap_8
XFILLER_168_601 VDD VSS sg13g2_decap_8
XFILLER_39_1162 VDD VSS sg13g2_decap_8
XFILLER_51_960 VDD VSS sg13g2_decap_8
XFILLER_51_971 VDD VSS sg13g2_fill_1
XFILLER_161_1023 VDD VSS sg13g2_fill_2
X_14311__1961 _14311_/RESET_B VDD VSS sg13g2_tiehi
XFILLER_126_1143 VDD VSS sg13g2_decap_8
XFILLER_165_1192 VDD VSS sg13g2_fill_1
X_08489_ _08489_/Y _08599_/B _08406_/A _08560_/A VDD VSS sg13g2_a21oi_1
XFILLER_51_982 VDD VSS sg13g2_decap_8
XFILLER_10_301 VDD VSS sg13g2_decap_8
XFILLER_22_161 VDD VSS sg13g2_decap_8
XFILLER_167_133 VDD VSS sg13g2_decap_8
XFILLER_168_35 VDD VSS sg13g2_decap_8
XFILLER_168_656 VDD VSS sg13g2_fill_2
X_13687__2591 _13687_/RESET_B VDD VSS sg13g2_tiehi
X_10520_ _10522_/B _14855_/Q _10579_/B _14856_/Q VDD VSS sg13g2_a21oi_1
XFILLER_17_1460 VDD VSS sg13g2_decap_8
XFILLER_50_492 VDD VSS sg13g2_decap_8
XFILLER_13_1302 VDD VSS sg13g2_decap_8
XFILLER_11_868 VDD VSS sg13g2_decap_8
XFILLER_108_200 VDD VSS sg13g2_decap_8
X_10451_ _10462_/D _14840_/Q _14839_/Q _10453_/C _10514_/A VDD VSS sg13g2_and4_1
XFILLER_10_378 VDD VSS sg13g2_decap_8
XFILLER_87_1403 VDD VSS sg13g2_fill_2
XFILLER_100_1305 VDD VSS sg13g2_decap_8
XFILLER_182_147 VDD VSS sg13g2_decap_8
XFILLER_108_244 VDD VSS sg13g2_fill_1
XFILLER_13_1379 VDD VSS sg13g2_decap_8
X_13170_ _13172_/D _13170_/A _13170_/B _13170_/C _13170_/D VDD VSS sg13g2_nor4_1
X_14938__2761 _14938_/RESET_B VDD VSS sg13g2_tiehi
X_10382_ _14818_/D _10378_/D _10380_/X _10381_/Y VDD VSS sg13g2_a21oi_1
XFILLER_87_1447 VDD VSS sg13g2_fill_2
XFILLER_109_789 VDD VSS sg13g2_fill_2
XFILLER_108_277 VDD VSS sg13g2_decap_4
XFILLER_164_895 VDD VSS sg13g2_fill_1
XFILLER_184_56 VDD VSS sg13g2_decap_8
X_12121_ _12121_/Y _12119_/Y _12120_/Y _12266_/B1 VDD VSS sg13g2_a21oi_1
XFILLER_174_1428 VDD VSS sg13g2_decap_8
XFILLER_2_511 VDD VSS sg13g2_decap_8
XFILLER_11_1092 VDD VSS sg13g2_decap_8
XFILLER_151_556 VDD VSS sg13g2_decap_8
XFILLER_105_962 VDD VSS sg13g2_decap_8
X_12052_ _12053_/B _12011_/X _12013_/Y _12051_/Y VDD VSS sg13g2_a21oi_1
XFILLER_123_269 VDD VSS sg13g2_decap_4
XFILLER_85_1182 VDD VSS sg13g2_decap_8
XFILLER_77_21 VDD VSS sg13g2_decap_8
XFILLER_104_461 VDD VSS sg13g2_decap_8
XFILLER_2_588 VDD VSS sg13g2_decap_8
X_11003_ _11064_/A _15117_/Q _11042_/D VDD VSS sg13g2_xor2_1
XFILLER_137_1283 VDD VSS sg13g2_fill_2
X_13763__2509 _13763_/RESET_B VDD VSS sg13g2_tiehi
XFILLER_77_323 VDD VSS sg13g2_decap_8
XFILLER_42_1008 VDD VSS sg13g2_fill_1
X_16860_ _16860_/X _16860_/A VDD VSS sg13g2_buf_1
XFILLER_77_334 VDD VSS sg13g2_fill_1
XFILLER_120_954 VDD VSS sg13g2_decap_4
XFILLER_78_868 VDD VSS sg13g2_fill_2
Xfanout870 _12606_/S1 _12564_/S1 VDD VSS sg13g2_buf_1
XFILLER_93_805 VDD VSS sg13g2_fill_1
XFILLER_77_98 VDD VSS sg13g2_decap_4
XFILLER_24_1442 VDD VSS sg13g2_decap_8
XFILLER_133_1169 VDD VSS sg13g2_fill_1
Xfanout881 _12411_/S1 _12588_/S1 VDD VSS sg13g2_buf_1
Xfanout892 _12366_/S1 _12368_/S1 VDD VSS sg13g2_buf_1
XFILLER_18_434 VDD VSS sg13g2_decap_8
X_12954_ _12954_/Y _12953_/Y _07683_/A _12950_/Y VDD VSS sg13g2_a21oi_1
X_15116__2820 _15116_/RESET_B VDD VSS sg13g2_tiehi
XFILLER_93_42 VDD VSS sg13g2_decap_8
XFILLER_92_359 VDD VSS sg13g2_decap_8
X_14143__2129 _14143_/RESET_B VDD VSS sg13g2_tiehi
X_11905_ _11905_/Y _11904_/X _11664_/A _12126_/A VDD VSS sg13g2_a21oi_1
XFILLER_33_404 VDD VSS sg13g2_decap_8
XFILLER_2_1260 VDD VSS sg13g2_decap_8
X_12885_ _12885_/Y input31/X _12841_/B _12803_/X input8/X _12883_/X VDD VSS sg13g2_a221oi_1
XFILLER_73_595 VDD VSS sg13g2_decap_8
XFILLER_60_212 VDD VSS sg13g2_fill_1
X_14624_ _14624_/Q _14656_/CLK _14624_/D _14624_/RESET_B VDD VSS sg13g2_dfrbpq_1
X_11836_ _11836_/Y _14911_/Q _12122_/A2 _11832_/Y _11835_/Y VDD VSS sg13g2_a22oi_1
XFILLER_159_601 VDD VSS sg13g2_decap_8
XFILLER_57_1251 VDD VSS sg13g2_decap_8
XFILLER_26_91 VDD VSS sg13g2_fill_2
XFILLER_159_612 VDD VSS sg13g2_fill_1
XFILLER_18_1213 VDD VSS sg13g2_decap_8
XFILLER_14_651 VDD VSS sg13g2_decap_8
XFILLER_53_1115 VDD VSS sg13g2_decap_8
X_14555_ _14555_/Q _14652_/CLK _14555_/D _14555_/RESET_B VDD VSS sg13g2_dfrbpq_1
X_11767_ _11767_/X _14909_/Q _11655_/B wire245/X VDD VSS sg13g2_a21o_1
XFILLER_13_161 VDD VSS sg13g2_decap_8
XFILLER_109_1396 VDD VSS sg13g2_decap_8
X_13506_ _13507_/C _13506_/A _07721_/B VDD VSS sg13g2_nor2b_1
X_10718_ _10718_/Y _14907_/Q _11196_/B VDD VSS sg13g2_nand2_1
XFILLER_70_1440 VDD VSS sg13g2_fill_1
XFILLER_105_1249 VDD VSS sg13g2_decap_8
XFILLER_140_1129 VDD VSS sg13g2_decap_8
XFILLER_146_306 VDD VSS sg13g2_decap_8
XFILLER_147_829 VDD VSS sg13g2_decap_8
X_14486_ _14486_/Q _14518_/CLK _14486_/D _14486_/RESET_B VDD VSS sg13g2_dfrbpq_1
X_11698_ _11698_/Y _11698_/A _12263_/C VDD VSS sg13g2_nor2b_1
XFILLER_9_154 VDD VSS sg13g2_decap_8
X_13437_ _13437_/Y _13437_/A _13440_/B _15101_/Q VDD VSS sg13g2_nand3_1
X_10649_ _10652_/B _14874_/Q _10649_/B _14872_/Q _14871_/Q VDD VSS sg13g2_nand4_1
XFILLER_173_147 VDD VSS sg13g2_decap_8
XFILLER_155_873 VDD VSS sg13g2_decap_4
XFILLER_6_861 VDD VSS sg13g2_decap_8
XFILLER_115_715 VDD VSS sg13g2_decap_8
X_13368_ _15075_/D _13361_/C _13367_/Y _13366_/Y VDD VSS sg13g2_o21ai_1
XFILLER_155_895 VDD VSS sg13g2_decap_4
XFILLER_114_203 VDD VSS sg13g2_decap_8
XFILLER_154_383 VDD VSS sg13g2_decap_4
X_15107_ _15107_/Q _15200_/CLK _15107_/D _15107_/RESET_B VDD VSS sg13g2_dfrbpq_1
XFILLER_5_371 VDD VSS sg13g2_decap_8
X_12319_ _12319_/Y _11277_/S _14426_/Q _12319_/B1 VDD VSS sg13g2_a21oi_1
X_13299_ _13299_/Y _07988_/D _13298_/X _13297_/X VDD VSS sg13g2_a21oi_1
X_15038_ _15038_/Q clkload83/A _15038_/D _15038_/RESET_B VDD VSS sg13g2_dfrbpq_1
XFILLER_9_1414 VDD VSS sg13g2_decap_8
XFILLER_151_1203 VDD VSS sg13g2_decap_4
XFILLER_96_621 VDD VSS sg13g2_decap_8
XFILLER_29_1375 VDD VSS sg13g2_fill_1
XFILLER_25_1217 VDD VSS sg13g2_decap_8
XFILLER_111_943 VDD VSS sg13g2_decap_8
X_07860_ _08608_/A _15013_/Q _07861_/B VDD VSS sg13g2_nor2_1
XFILLER_69_857 VDD VSS sg13g2_decap_8
X_14353__1919 _14353_/RESET_B VDD VSS sg13g2_tiehi
X_13739__2533 _13739_/RESET_B VDD VSS sg13g2_tiehi
X_14499__1773 _14499_/RESET_B VDD VSS sg13g2_tiehi
XFILLER_68_356 VDD VSS sg13g2_decap_4
XFILLER_3_84 VDD VSS sg13g2_decap_8
XFILLER_95_153 VDD VSS sg13g2_decap_8
X_07791_ _08415_/A _08391_/B _08412_/A VDD VSS sg13g2_nor2b_1
XFILLER_96_698 VDD VSS sg13g2_decap_8
XFILLER_49_570 VDD VSS sg13g2_fill_1
XFILLER_110_486 VDD VSS sg13g2_decap_8
XFILLER_83_337 VDD VSS sg13g2_decap_8
XFILLER_114_1080 VDD VSS sg13g2_decap_8
X_09530_ _14129_/D _09596_/A1 _14129_/Q _09530_/S VDD VSS sg13g2_mux2_1
XFILLER_3_1057 VDD VSS sg13g2_decap_8
X_09461_ _14062_/D _10024_/A0 _14062_/Q _09461_/S VDD VSS sg13g2_mux2_1
XFILLER_58_1015 VDD VSS sg13g2_decap_8
XFILLER_52_702 VDD VSS sg13g2_decap_8
XFILLER_37_776 VDD VSS sg13g2_decap_8
XFILLER_25_927 VDD VSS sg13g2_fill_2
XFILLER_64_584 VDD VSS sg13g2_decap_8
XFILLER_36_275 VDD VSS sg13g2_decap_8
X_14119__2153 _14119_/RESET_B VDD VSS sg13g2_tiehi
XFILLER_91_370 VDD VSS sg13g2_decap_8
X_08412_ _08412_/Y _08412_/A _08412_/B VDD VSS sg13g2_nor2_1
XFILLER_51_223 VDD VSS sg13g2_decap_8
XFILLER_169_409 VDD VSS sg13g2_decap_8
X_09392_ _13995_/D _09724_/A0 _13995_/Q _09399_/S VDD VSS sg13g2_mux2_1
XFILLER_52_757 VDD VSS sg13g2_decap_8
XFILLER_145_1029 VDD VSS sg13g2_fill_2
XFILLER_178_921 VDD VSS sg13g2_decap_8
X_08343_ _08346_/C _08692_/A _07784_/B _08522_/C _07796_/A VDD VSS sg13g2_a22oi_1
XFILLER_51_267 VDD VSS sg13g2_decap_8
XFILLER_177_420 VDD VSS sg13g2_decap_8
XFILLER_75_1384 VDD VSS sg13g2_decap_8
XFILLER_123_1305 VDD VSS sg13g2_decap_8
XFILLER_71_1248 VDD VSS sg13g2_decap_8
X_08274_ _08275_/A _08276_/A _08276_/B VDD VSS sg13g2_nand2_1
XFILLER_20_654 VDD VSS sg13g2_decap_8
XFILLER_164_114 VDD VSS sg13g2_fill_1
XFILLER_177_497 VDD VSS sg13g2_decap_8
XFILLER_34_1070 VDD VSS sg13g2_decap_8
XFILLER_22_49 VDD VSS sg13g2_decap_8
XFILLER_138_27 VDD VSS sg13g2_fill_2
X_13987__2285 _13987_/RESET_B VDD VSS sg13g2_tiehi
XFILLER_118_531 VDD VSS sg13g2_fill_1
XFILLER_138_38 VDD VSS sg13g2_decap_8
XFILLER_146_873 VDD VSS sg13g2_fill_2
XFILLER_164_169 VDD VSS sg13g2_decap_4
XFILLER_69_1122 VDD VSS sg13g2_decap_4
XFILLER_3_308 VDD VSS sg13g2_decap_8
XFILLER_106_726 VDD VSS sg13g2_decap_8
XFILLER_173_681 VDD VSS sg13g2_fill_1
XFILLER_145_383 VDD VSS sg13g2_decap_8
XFILLER_161_832 VDD VSS sg13g2_decap_4
XFILLER_133_534 VDD VSS sg13g2_decap_8
XFILLER_161_843 VDD VSS sg13g2_decap_8
XFILLER_160_320 VDD VSS sg13g2_decap_8
XFILLER_161_854 VDD VSS sg13g2_fill_1
XFILLER_105_247 VDD VSS sg13g2_decap_8
XFILLER_105_258 VDD VSS sg13g2_fill_1
XFILLER_161_876 VDD VSS sg13g2_decap_8
XFILLER_82_1311 VDD VSS sg13g2_decap_8
XFILLER_47_1442 VDD VSS sg13g2_decap_4
XFILLER_121_729 VDD VSS sg13g2_decap_8
XFILLER_114_770 VDD VSS sg13g2_decap_4
Xfanout1109 _08241_/A _08340_/A VDD VSS sg13g2_buf_1
XFILLER_99_470 VDD VSS sg13g2_decap_8
Xfanout144 _10102_/A0 _09772_/A1 VDD VSS sg13g2_buf_1
XFILLER_59_334 VDD VSS sg13g2_decap_8
XFILLER_86_120 VDD VSS sg13g2_decap_8
Xfanout155 _10167_/A1 _09152_/Y VDD VSS sg13g2_buf_1
XFILLER_86_131 VDD VSS sg13g2_fill_2
XFILLER_82_1388 VDD VSS sg13g2_decap_8
X_14329__1943 _14329_/RESET_B VDD VSS sg13g2_tiehi
Xfanout166 _09966_/A1 _09138_/X VDD VSS sg13g2_buf_1
Xfanout177 _10029_/A0 _09930_/A1 VDD VSS sg13g2_buf_1
Xfanout188 _09596_/A1 _10160_/A1 VDD VSS sg13g2_buf_1
XFILLER_170_14 VDD VSS sg13g2_decap_8
Xfanout199 _10378_/D _10370_/A VDD VSS sg13g2_buf_1
X_07989_ _07989_/Y _10172_/C _07989_/B _13283_/A VDD VSS sg13g2_nand3_1
XFILLER_75_849 VDD VSS sg13g2_fill_1
XFILLER_74_326 VDD VSS sg13g2_decap_8
X_09728_ _14319_/D _09926_/A1 _14319_/Q _09731_/S VDD VSS sg13g2_mux2_1
XFILLER_41_1063 VDD VSS sg13g2_decap_8
XFILLER_132_1191 VDD VSS sg13g2_decap_4
XFILLER_27_220 VDD VSS sg13g2_decap_4
XFILLER_55_551 VDD VSS sg13g2_decap_4
XFILLER_83_882 VDD VSS sg13g2_decap_8
XFILLER_16_938 VDD VSS sg13g2_decap_8
X_09659_ _14252_/D _09956_/A1 _14252_/Q _09673_/S VDD VSS sg13g2_mux2_1
XFILLER_63_23 VDD VSS sg13g2_fill_1
XFILLER_42_201 VDD VSS sg13g2_decap_8
XFILLER_128_1205 VDD VSS sg13g2_decap_4
XFILLER_128_1216 VDD VSS sg13g2_fill_1
XFILLER_43_746 VDD VSS sg13g2_decap_8
XFILLER_42_223 VDD VSS sg13g2_fill_2
XFILLER_15_448 VDD VSS sg13g2_decap_8
XFILLER_167_1276 VDD VSS sg13g2_decap_8
X_12670_ _12670_/X _13842_/Q _13874_/Q _13906_/Q _13938_/Q _12755_/S0 _12758_/S1 VDD
+ VSS sg13g2_mux4_1
XFILLER_169_910 VDD VSS sg13g2_decap_8
XFILLER_179_56 VDD VSS sg13g2_decap_8
X_11621_ _11621_/X _14694_/Q _14726_/Q _13766_/Q _13798_/Q _11621_/S0 _11742_/C VDD
+ VSS sg13g2_mux4_1
XFILLER_24_993 VDD VSS sg13g2_decap_8
XFILLER_168_442 VDD VSS sg13g2_decap_8
XFILLER_180_1454 VDD VSS sg13g2_decap_8
X_14340_ _14340_/Q clkload33/A _14340_/D _14340_/RESET_B VDD VSS sg13g2_dfrbpq_1
X_11552_ _11552_/Y _12245_/S0 _13892_/Q VDD VSS sg13g2_nand2b_1
XFILLER_156_615 VDD VSS sg13g2_decap_4
XFILLER_11_665 VDD VSS sg13g2_decap_8
X_10503_ _10507_/D _14854_/Q _14853_/Q VDD VSS sg13g2_and2_1
XFILLER_183_434 VDD VSS sg13g2_decap_8
X_14271_ _14271_/Q clkload20/A _14271_/D _14271_/RESET_B VDD VSS sg13g2_dfrbpq_1
X_11483_ _11485_/A _11483_/A _13686_/Q VDD VSS sg13g2_xnor2_1
XFILLER_10_175 VDD VSS sg13g2_decap_8
X_13817__2455 _13817_/RESET_B VDD VSS sg13g2_tiehi
X_15145__2760 _15145_/RESET_B VDD VSS sg13g2_tiehi
Xwire556 wire556/X wire556/A VDD VSS sg13g2_buf_4
X_14577__1695 _14577_/RESET_B VDD VSS sg13g2_tiehi
XFILLER_7_658 VDD VSS sg13g2_decap_8
XFILLER_109_553 VDD VSS sg13g2_fill_2
X_13222_ _13222_/Y _13253_/B2 _13217_/X _13221_/Y VDD VSS sg13g2_a21oi_1
X_10434_ _10443_/D _14834_/Q _14833_/Q _10434_/C VDD VSS sg13g2_and3_1
XFILLER_13_1176 VDD VSS sg13g2_decap_8
XFILLER_124_501 VDD VSS sg13g2_decap_8
XFILLER_152_810 VDD VSS sg13g2_fill_1
XFILLER_87_1233 VDD VSS sg13g2_fill_1
XFILLER_6_168 VDD VSS sg13g2_decap_8
XFILLER_124_512 VDD VSS sg13g2_fill_2
XFILLER_137_895 VDD VSS sg13g2_fill_2
XFILLER_139_1312 VDD VSS sg13g2_decap_8
XFILLER_178_1383 VDD VSS sg13g2_decap_8
X_13153_ _13153_/Y _13150_/Y _13151_/Y _13152_/Y VDD VSS sg13g2_a21oi_1
X_10365_ _14813_/D _10365_/A _10365_/B _10365_/C VDD VSS sg13g2_and3_1
XFILLER_139_1345 VDD VSS sg13g2_decap_8
XFILLER_151_331 VDD VSS sg13g2_decap_8
XFILLER_152_865 VDD VSS sg13g2_decap_8
XFILLER_88_42 VDD VSS sg13g2_decap_8
X_12104_ _12104_/Y _12330_/S0 _14484_/Q VDD VSS sg13g2_nand2b_1
X_13084_ _13085_/C _14848_/Q _13150_/B VDD VSS sg13g2_nand2_1
XFILLER_3_875 VDD VSS sg13g2_decap_8
X_10296_ _10297_/C _14788_/Q _14789_/Q _14791_/Q _14792_/Q VDD VSS sg13g2_nand4_1
XFILLER_151_386 VDD VSS sg13g2_decap_8
XFILLER_88_97 VDD VSS sg13g2_decap_8
XFILLER_105_792 VDD VSS sg13g2_decap_8
X_12035_ _12036_/A _14258_/Q _14290_/Q _14322_/Q _14354_/Q _12035_/S0 _11970_/C VDD
+ VSS sg13g2_mux4_1
XFILLER_2_385 VDD VSS sg13g2_decap_8
XFILLER_104_280 VDD VSS sg13g2_decap_8
XFILLER_137_1080 VDD VSS sg13g2_decap_8
XFILLER_61_1439 VDD VSS sg13g2_decap_4
XFILLER_78_676 VDD VSS sg13g2_decap_8
XFILLER_19_7 VDD VSS sg13g2_decap_8
XFILLER_65_315 VDD VSS sg13g2_decap_8
XFILLER_19_721 VDD VSS sg13g2_decap_4
XFILLER_92_112 VDD VSS sg13g2_fill_1
XFILLER_65_326 VDD VSS sg13g2_fill_2
XFILLER_93_646 VDD VSS sg13g2_decap_8
XFILLER_4_1344 VDD VSS sg13g2_decap_8
XFILLER_150_1280 VDD VSS sg13g2_decap_8
XFILLER_19_743 VDD VSS sg13g2_decap_8
XFILLER_18_231 VDD VSS sg13g2_decap_8
X_13986_ _13986_/Q clkload44/A _13986_/D _13986_/RESET_B VDD VSS sg13g2_dfrbpq_1
XFILLER_46_551 VDD VSS sg13g2_decap_8
XFILLER_20_1147 VDD VSS sg13g2_decap_8
XFILLER_0_1219 VDD VSS sg13g2_decap_8
XFILLER_19_787 VDD VSS sg13g2_fill_1
XFILLER_98_1373 VDD VSS sg13g2_decap_8
X_12937_ _12937_/Y _12937_/A _12936_/Y VDD VSS sg13g2_nor2b_1
XFILLER_74_882 VDD VSS sg13g2_decap_8
XFILLER_59_1346 VDD VSS sg13g2_decap_8
XFILLER_46_595 VDD VSS sg13g2_decap_8
XFILLER_160_91 VDD VSS sg13g2_decap_8
XFILLER_73_381 VDD VSS sg13g2_decap_8
XFILLER_185_1365 VDD VSS sg13g2_decap_8
XFILLER_73_392 VDD VSS sg13g2_fill_2
XFILLER_146_1327 VDD VSS sg13g2_decap_8
XFILLER_181_1218 VDD VSS sg13g2_decap_8
X_12868_ _12868_/Y input30/X _12841_/B _12803_/X input7/X _12866_/X VDD VSS sg13g2_a221oi_1
XFILLER_178_217 VDD VSS sg13g2_decap_8
X_14607_ _14607_/Q _14607_/CLK _14607_/D _14607_/RESET_B VDD VSS sg13g2_dfrbpq_1
X_11819_ _11819_/Y _11819_/A1 _14508_/Q _12304_/B VDD VSS sg13g2_a21oi_1
X_12799_ _12799_/X _13601_/A _12936_/B VDD VSS sg13g2_and2_1
XFILLER_42_790 VDD VSS sg13g2_decap_8
XFILLER_30_941 VDD VSS sg13g2_decap_8
XFILLER_147_604 VDD VSS sg13g2_fill_2
X_14538_ _14538_/Q clkload19/A _14538_/D _14538_/RESET_B VDD VSS sg13g2_dfrbpq_1
XFILLER_174_401 VDD VSS sg13g2_decap_8
XFILLER_119_317 VDD VSS sg13g2_fill_1
XFILLER_18_1087 VDD VSS sg13g2_decap_8
XFILLER_30_974 VDD VSS sg13g2_decap_8
XFILLER_175_946 VDD VSS sg13g2_decap_4
XFILLER_147_648 VDD VSS sg13g2_decap_8
X_14469_ _14469_/Q clkload14/A _14469_/D _14469_/RESET_B VDD VSS sg13g2_dfrbpq_1
XFILLER_105_1079 VDD VSS sg13g2_decap_8
X_14407__1865 _14407_/RESET_B VDD VSS sg13g2_tiehi
XFILLER_174_478 VDD VSS sg13g2_decap_8
XFILLER_143_810 VDD VSS sg13g2_decap_8
XFILLER_174_489 VDD VSS sg13g2_fill_2
XFILLER_154_191 VDD VSS sg13g2_decap_8
XFILLER_118_1407 VDD VSS sg13g2_fill_1
XFILLER_66_1339 VDD VSS sg13g2_decap_4
Xhold3206 _13644_/A _13752_/Q VDD VSS sg13g2_dlygate4sd3_1
XFILLER_45_0 VDD VSS sg13g2_decap_8
XFILLER_103_718 VDD VSS sg13g2_fill_1
XFILLER_115_578 VDD VSS sg13g2_decap_8
Xhold3217 _13642_/A _13750_/Q VDD VSS sg13g2_dlygate4sd3_1
XFILLER_88_418 VDD VSS sg13g2_decap_8
X_08961_ _09641_/D _10781_/C _09016_/C _11183_/B1 VDD VSS sg13g2_o21ai_1
Xhold3228 hold3228/X _15105_/Q VDD VSS sg13g2_dlygate4sd3_1
XFILLER_9_1211 VDD VSS sg13g2_decap_8
XFILLER_69_610 VDD VSS sg13g2_decap_8
Xhold3239 _13423_/C _15095_/Q VDD VSS sg13g2_dlygate4sd3_1
X_14622__1650 _14622_/RESET_B VDD VSS sg13g2_tiehi
X_07912_ _07912_/Y _07911_/A _07912_/B VDD VSS sg13g2_nand2b_1
XFILLER_25_1003 VDD VSS sg13g2_fill_2
X_08892_ _13706_/D _16868_/A _08891_/X _08938_/S VDD VSS sg13g2_mux2_1
XFILLER_64_1074 VDD VSS sg13g2_decap_4
XFILLER_97_974 VDD VSS sg13g2_decap_4
XFILLER_57_805 VDD VSS sg13g2_fill_1
XFILLER_9_1288 VDD VSS sg13g2_decap_8
XFILLER_68_153 VDD VSS sg13g2_decap_8
X_07843_ _08678_/B _15017_/Q _07972_/B VDD VSS sg13g2_or2_1
XFILLER_97_996 VDD VSS sg13g2_decap_8
XFILLER_112_1017 VDD VSS sg13g2_fill_1
XFILLER_151_1066 VDD VSS sg13g2_fill_1
X_14922__2793 _14922_/RESET_B VDD VSS sg13g2_tiehi
XFILLER_83_101 VDD VSS sg13g2_fill_1
XFILLER_57_838 VDD VSS sg13g2_decap_4
XFILLER_110_272 VDD VSS sg13g2_decap_8
XFILLER_112_1028 VDD VSS sg13g2_decap_8
XFILLER_151_1088 VDD VSS sg13g2_decap_8
XFILLER_83_123 VDD VSS sg13g2_decap_4
XFILLER_84_657 VDD VSS sg13g2_decap_8
X_07774_ _08315_/B _08304_/A _08306_/B VDD VSS sg13g2_xnor2_1
XFILLER_77_1413 VDD VSS sg13g2_decap_8
XFILLER_65_860 VDD VSS sg13g2_decap_8
XFILLER_37_551 VDD VSS sg13g2_decap_8
XFILLER_17_49 VDD VSS sg13g2_decap_8
X_09513_ _14112_/D _10043_/A0 _14112_/Q _09534_/S VDD VSS sg13g2_mux2_1
X_13660__3060 _13660_/RESET_B VDD VSS sg13g2_tiehi
XFILLER_25_724 VDD VSS sg13g2_decap_4
XFILLER_24_212 VDD VSS sg13g2_decap_8
X_09444_ _14045_/D _09842_/A1 _14045_/Q _09461_/S VDD VSS sg13g2_mux2_1
XFILLER_25_768 VDD VSS sg13g2_decap_8
XFILLER_169_217 VDD VSS sg13g2_decap_8
X_09375_ _09375_/Y _10004_/B _10004_/C _09441_/D VDD VSS sg13g2_nand3_1
XFILLER_162_1151 VDD VSS sg13g2_decap_8
XFILLER_178_762 VDD VSS sg13g2_decap_8
XFILLER_36_1154 VDD VSS sg13g2_decap_8
XFILLER_166_913 VDD VSS sg13g2_decap_8
X_08326_ _08335_/B _08414_/B _08692_/A _07796_/B _08522_/C _08325_/Y VDD VSS sg13g2_a221oi_1
XFILLER_137_103 VDD VSS sg13g2_decap_8
XFILLER_123_1146 VDD VSS sg13g2_fill_1
XFILLER_166_946 VDD VSS sg13g2_decap_8
XFILLER_123_1157 VDD VSS sg13g2_decap_8
XFILLER_177_294 VDD VSS sg13g2_decap_8
X_08257_ _08257_/Y _08045_/Y _08340_/A _08027_/Y VDD VSS sg13g2_a21oi_1
XFILLER_123_7 VDD VSS sg13g2_decap_8
XFILLER_20_484 VDD VSS sg13g2_decap_8
XFILLER_119_851 VDD VSS sg13g2_decap_8
XFILLER_119_862 VDD VSS sg13g2_fill_2
XFILLER_14_1463 VDD VSS sg13g2_decap_8
XFILLER_14_1474 VDD VSS sg13g2_fill_1
XFILLER_10_1316 VDD VSS sg13g2_decap_8
XFILLER_118_350 VDD VSS sg13g2_decap_8
XFILLER_152_106 VDD VSS sg13g2_fill_1
X_08188_ _08188_/Y _08188_/A _08188_/B _08188_/C VDD VSS sg13g2_nor3_1
XFILLER_118_361 VDD VSS sg13g2_fill_2
XFILLER_165_14 VDD VSS sg13g2_decap_8
XFILLER_3_105 VDD VSS sg13g2_decap_8
XFILLER_134_832 VDD VSS sg13g2_decap_8
XFILLER_101_1466 VDD VSS sg13g2_decap_8
XFILLER_180_448 VDD VSS sg13g2_decap_8
XFILLER_84_1439 VDD VSS sg13g2_decap_8
XFILLER_134_876 VDD VSS sg13g2_decap_8
XFILLER_161_662 VDD VSS sg13g2_decap_8
X_10150_ _14727_/D _14727_/Q _10150_/A1 _10168_/S VDD VSS sg13g2_mux2_1
XFILLER_161_673 VDD VSS sg13g2_decap_4
XFILLER_160_161 VDD VSS sg13g2_decap_8
XFILLER_0_834 VDD VSS sg13g2_decap_8
XFILLER_47_1261 VDD VSS sg13g2_decap_8
X_10081_ _14661_/D _10115_/A0 _14661_/Q _10093_/S VDD VSS sg13g2_mux2_1
XFILLER_181_35 VDD VSS sg13g2_decap_8
XFILLER_130_1106 VDD VSS sg13g2_decap_8
XFILLER_47_304 VDD VSS sg13g2_decap_8
XFILLER_134_1286 VDD VSS sg13g2_decap_8
XFILLER_169_1305 VDD VSS sg13g2_decap_8
X_13840_ _13840_/Q clkload22/A _13840_/D _13840_/RESET_B VDD VSS sg13g2_dfrbpq_1
XFILLER_74_11 VDD VSS sg13g2_fill_1
XFILLER_60_1472 VDD VSS sg13g2_decap_8
XFILLER_74_145 VDD VSS sg13g2_decap_8
XFILLER_63_819 VDD VSS sg13g2_decap_8
XFILLER_21_1445 VDD VSS sg13g2_decap_8
XFILLER_74_44 VDD VSS sg13g2_decap_4
XFILLER_28_573 VDD VSS sg13g2_fill_2
X_13771_ _13771_/Q clkload6/A _13771_/D _13771_/RESET_B VDD VSS sg13g2_dfrbpq_1
XFILLER_90_638 VDD VSS sg13g2_decap_8
X_10983_ _10984_/A _11027_/B1 _10982_/X _11082_/A1 VDD VSS sg13g2_o21ai_1
XFILLER_16_735 VDD VSS sg13g2_decap_8
XFILLER_71_830 VDD VSS sg13g2_fill_2
X_12722_ _15015_/D _12722_/A _12722_/B VDD VSS sg13g2_nor2_1
X_14060__2212 _14060_/RESET_B VDD VSS sg13g2_tiehi
XFILLER_15_245 VDD VSS sg13g2_decap_8
XFILLER_43_554 VDD VSS sg13g2_decap_8
XFILLER_43_565 VDD VSS sg13g2_fill_2
XFILLER_31_705 VDD VSS sg13g2_decap_4
XFILLER_167_1095 VDD VSS sg13g2_fill_1
XFILLER_71_885 VDD VSS sg13g2_decap_8
XFILLER_90_21 VDD VSS sg13g2_decap_8
XFILLER_128_1068 VDD VSS sg13g2_decap_8
X_12653_ _12666_/A _12751_/A1 _12737_/A2 _07956_/A VDD VSS sg13g2_a21oi_1
XFILLER_90_32 VDD VSS sg13g2_fill_2
XFILLER_106_1300 VDD VSS sg13g2_fill_1
XFILLER_128_1079 VDD VSS sg13g2_fill_2
XFILLER_106_1311 VDD VSS sg13g2_decap_8
XFILLER_145_1371 VDD VSS sg13g2_decap_8
X_11604_ _11604_/Y _11621_/S0 _14630_/Q VDD VSS sg13g2_nand2b_1
XFILLER_12_952 VDD VSS sg13g2_decap_8
XFILLER_19_1385 VDD VSS sg13g2_decap_8
X_14664__1608 _14664_/RESET_B VDD VSS sg13g2_tiehi
XFILLER_180_1273 VDD VSS sg13g2_decap_4
X_12584_ _12597_/A _12751_/A1 _12779_/A2 _15006_/Q VDD VSS sg13g2_a21oi_1
XFILLER_30_259 VDD VSS sg13g2_decap_8
XFILLER_11_462 VDD VSS sg13g2_decap_8
XFILLER_15_1249 VDD VSS sg13g2_decap_8
X_14323_ _14323_/Q clkload39/A _14323_/D _14323_/RESET_B VDD VSS sg13g2_dfrbpq_1
X_14700__1572 _14700_/RESET_B VDD VSS sg13g2_tiehi
XFILLER_23_70 VDD VSS sg13g2_decap_8
X_11535_ _11535_/Y _11535_/A _11542_/B VDD VSS sg13g2_nand2_1
XFILLER_8_945 VDD VSS sg13g2_decap_8
XFILLER_106_1388 VDD VSS sg13g2_decap_8
XFILLER_141_1268 VDD VSS sg13g2_fill_1
XFILLER_183_231 VDD VSS sg13g2_decap_8
XFILLER_139_70 VDD VSS sg13g2_decap_8
X_14093__2179 _14093_/RESET_B VDD VSS sg13g2_tiehi
XFILLER_7_455 VDD VSS sg13g2_decap_8
X_14254_ _14254_/Q _14685_/CLK _14254_/D _14254_/RESET_B VDD VSS sg13g2_dfrbpq_1
XFILLER_99_30 VDD VSS sg13g2_decap_8
X_11466_ _11466_/X _14113_/Q _14145_/Q _14177_/Q _14209_/Q _11493_/S0 _11493_/S1 VDD
+ VSS sg13g2_mux4_1
XFILLER_137_692 VDD VSS sg13g2_decap_8
X_13205_ _13205_/X input22/X _13272_/A2 _13264_/B1 VDD VSS sg13g2_a21o_1
X_10417_ _14828_/D _14828_/Q _10415_/A _10416_/Y VDD VSS sg13g2_a21oi_1
XFILLER_152_640 VDD VSS sg13g2_decap_8
X_14185_ _14185_/Q clkload35/A _14185_/D _14185_/RESET_B VDD VSS sg13g2_dfrbpq_1
X_11397_ _11397_/Y _11415_/S _14559_/Q VDD VSS sg13g2_nand2b_1
XFILLER_140_802 VDD VSS sg13g2_decap_8
XFILLER_98_716 VDD VSS sg13g2_decap_8
XFILLER_152_673 VDD VSS sg13g2_decap_8
X_13136_ _13136_/X input17/X _13161_/A2 _13161_/B1 VDD VSS sg13g2_a21o_1
XFILLER_139_1175 VDD VSS sg13g2_decap_8
X_15032__2648 _15032_/RESET_B VDD VSS sg13g2_tiehi
X_10348_ _10350_/A _14809_/Q _10352_/C VDD VSS sg13g2_or2_1
XFILLER_48_1058 VDD VSS sg13g2_fill_1
XFILLER_3_672 VDD VSS sg13g2_decap_8
XFILLER_155_91 VDD VSS sg13g2_decap_8
XFILLER_151_194 VDD VSS sg13g2_fill_2
XFILLER_152_1320 VDD VSS sg13g2_decap_4
XFILLER_65_1372 VDD VSS sg13g2_fill_2
XFILLER_117_1440 VDD VSS sg13g2_fill_2
X_13067_ _13067_/Y _13066_/Y _13160_/B _13067_/C VDD VSS sg13g2_nand3b_1
X_10279_ _14787_/D _10667_/A _10279_/B _10311_/A VDD VSS sg13g2_nor3_1
XFILLER_97_259 VDD VSS sg13g2_fill_2
XFILLER_2_182 VDD VSS sg13g2_decap_8
XFILLER_79_963 VDD VSS sg13g2_decap_8
XFILLER_26_1334 VDD VSS sg13g2_decap_8
Xfanout1440 fanout1440/X _13657_/Q VDD VSS sg13g2_buf_1
XFILLER_94_911 VDD VSS sg13g2_decap_8
XFILLER_6_1428 VDD VSS sg13g2_decap_8
X_12018_ _12019_/B _12018_/A _12018_/B _12236_/C VDD VSS sg13g2_nand3_1
XFILLER_66_613 VDD VSS sg13g2_decap_8
XFILLER_61_1247 VDD VSS sg13g2_fill_2
Xfanout1451 _12171_/S0 fanout1452/X VDD VSS sg13g2_buf_1
Xfanout1462 _12168_/A _12213_/S0 VDD VSS sg13g2_buf_1
XFILLER_39_849 VDD VSS sg13g2_decap_8
XFILLER_120_581 VDD VSS sg13g2_decap_8
Xfanout1473 _10577_/B _13328_/A VDD VSS sg13g2_buf_1
XFILLER_61_1269 VDD VSS sg13g2_fill_1
Xfanout1484 _10630_/C _10626_/B VDD VSS sg13g2_buf_1
XFILLER_94_955 VDD VSS sg13g2_fill_2
Xfanout1495 _12751_/A1 _12779_/A1 VDD VSS sg13g2_buf_1
XFILLER_38_348 VDD VSS sg13g2_decap_8
XFILLER_4_1141 VDD VSS sg13g2_decap_8
XFILLER_93_487 VDD VSS sg13g2_fill_1
XFILLER_59_1110 VDD VSS sg13g2_decap_8
XFILLER_0_1016 VDD VSS sg13g2_decap_8
X_13969_ _13969_/Q clkload6/A _13969_/D _13969_/RESET_B VDD VSS sg13g2_dfrbpq_1
XFILLER_0_63 VDD VSS sg13g2_decap_8
XFILLER_81_649 VDD VSS sg13g2_decap_8
XFILLER_80_137 VDD VSS sg13g2_decap_8
XFILLER_179_504 VDD VSS sg13g2_decap_8
XFILLER_72_1332 VDD VSS sg13g2_decap_8
XFILLER_148_902 VDD VSS sg13g2_decap_8
X_09160_ _13785_/D _13785_/Q _10168_/A1 _09160_/S VDD VSS sg13g2_mux2_1
XFILLER_124_1422 VDD VSS sg13g2_decap_8
XFILLER_21_259 VDD VSS sg13g2_decap_8
X_08111_ _08112_/A _08246_/A1 _08087_/X _08098_/Y _08104_/Y _08093_/Y VDD VSS sg13g2_a221oi_1
XFILLER_72_1387 VDD VSS sg13g2_fill_1
XFILLER_119_125 VDD VSS sg13g2_decap_8
XFILLER_124_1466 VDD VSS sg13g2_decap_8
XFILLER_159_294 VDD VSS sg13g2_decap_8
X_09091_ _09091_/Y _09090_/A _09086_/Y _09090_/Y VDD VSS sg13g2_o21ai_1
XFILLER_174_231 VDD VSS sg13g2_decap_8
XFILLER_147_456 VDD VSS sg13g2_decap_8
XFILLER_175_765 VDD VSS sg13g2_decap_4
XFILLER_135_607 VDD VSS sg13g2_decap_4
XFILLER_163_916 VDD VSS sg13g2_decap_8
X_08042_ _08042_/X _08487_/A3 _08510_/A3 _08510_/A2 _08510_/A1 _08009_/S _07627_/A
+ VDD VSS sg13g2_mux4_1
XFILLER_162_404 VDD VSS sg13g2_decap_8
XFILLER_175_798 VDD VSS sg13g2_decap_8
XFILLER_116_821 VDD VSS sg13g2_fill_2
XFILLER_122_1190 VDD VSS sg13g2_decap_8
XFILLER_156_990 VDD VSS sg13g2_decap_8
XFILLER_134_128 VDD VSS sg13g2_decap_8
XFILLER_66_1103 VDD VSS sg13g2_decap_8
XFILLER_1_609 VDD VSS sg13g2_decap_8
XFILLER_66_1136 VDD VSS sg13g2_decap_4
XFILLER_143_684 VDD VSS sg13g2_decap_8
XFILLER_153_1106 VDD VSS sg13g2_decap_4
X_09993_ _14576_/D _10026_/A0 _14576_/Q _09994_/S VDD VSS sg13g2_mux2_1
XFILLER_0_119 VDD VSS sg13g2_decap_8
XFILLER_157_1286 VDD VSS sg13g2_decap_8
XFILLER_118_1248 VDD VSS sg13g2_fill_1
X_15008__2672 _15008_/RESET_B VDD VSS sg13g2_tiehi
XFILLER_83_1450 VDD VSS sg13g2_decap_8
XFILLER_103_548 VDD VSS sg13g2_decap_8
X_08944_ _08944_/Y _08942_/Y _08943_/Y _08955_/S VDD VSS sg13g2_a21oi_1
XFILLER_88_259 VDD VSS sg13g2_decap_8
XFILLER_44_1434 VDD VSS sg13g2_decap_8
XFILLER_97_760 VDD VSS sg13g2_decap_8
X_14817__2989 _14817_/RESET_B VDD VSS sg13g2_tiehi
X_08875_ _08875_/X _08874_/X _08306_/C _08940_/S VDD VSS sg13g2_mux2_1
XFILLER_9_1085 VDD VSS sg13g2_decap_8
XFILLER_44_1478 VDD VSS sg13g2_fill_1
XFILLER_85_955 VDD VSS sg13g2_decap_4
XFILLER_84_432 VDD VSS sg13g2_decap_8
X_07826_ _07826_/X _15005_/Q _07946_/B VDD VSS sg13g2_and2_1
XFILLER_29_359 VDD VSS sg13g2_fill_1
XFILLER_42_1180 VDD VSS sg13g2_decap_4
XFILLER_85_999 VDD VSS sg13g2_decap_8
X_07757_ _07757_/Y _07751_/Y _13304_/B _13305_/B VDD VSS sg13g2_a21oi_1
XFILLER_44_329 VDD VSS sg13g2_decap_8
XFILLER_38_893 VDD VSS sg13g2_decap_8
XFILLER_25_510 VDD VSS sg13g2_decap_8
XFILLER_44_14 VDD VSS sg13g2_decap_8
XFILLER_53_841 VDD VSS sg13g2_fill_1
XFILLER_77_1265 VDD VSS sg13g2_decap_8
X_07688_ _07696_/A _07697_/A _12997_/B VDD VSS sg13g2_nand2_1
XFILLER_44_58 VDD VSS sg13g2_fill_1
XFILLER_129_1355 VDD VSS sg13g2_decap_8
X_09427_ _14029_/D _09625_/A0 _14029_/Q _09427_/S VDD VSS sg13g2_mux2_1
XFILLER_13_749 VDD VSS sg13g2_decap_8
XFILLER_164_1268 VDD VSS sg13g2_decap_4
XFILLER_52_384 VDD VSS sg13g2_decap_8
XFILLER_164_1279 VDD VSS sg13g2_decap_8
X_14279__1993 _14279_/RESET_B VDD VSS sg13g2_tiehi
XFILLER_90_1443 VDD VSS sg13g2_fill_2
XFILLER_100_42 VDD VSS sg13g2_decap_8
XFILLER_185_518 VDD VSS sg13g2_decap_8
XFILLER_40_557 VDD VSS sg13g2_decap_8
XFILLER_12_259 VDD VSS sg13g2_decap_8
X_09358_ _13962_/D _09622_/A0 _13962_/Q _09365_/S VDD VSS sg13g2_mux2_1
XFILLER_100_75 VDD VSS sg13g2_decap_8
XFILLER_178_581 VDD VSS sg13g2_decap_8
XFILLER_166_743 VDD VSS sg13g2_fill_1
X_08309_ _08312_/B _13529_/A _08122_/Y _08308_/X VDD VSS sg13g2_a21oi_1
XFILLER_60_35 VDD VSS sg13g2_decap_8
XFILLER_139_968 VDD VSS sg13g2_decap_8
XFILLER_154_905 VDD VSS sg13g2_decap_8
X_09289_ _13897_/D _13897_/Q _09621_/A0 _09305_/S VDD VSS sg13g2_mux2_1
XFILLER_176_35 VDD VSS sg13g2_decap_8
XFILLER_14_1260 VDD VSS sg13g2_decap_8
X_11320_ _11320_/X _14237_/Q _14269_/Q _14301_/Q _14333_/Q _11320_/S0 _11328_/S1 VDD
+ VSS sg13g2_mux4_1
XFILLER_138_489 VDD VSS sg13g2_fill_1
XFILLER_101_1230 VDD VSS sg13g2_fill_1
XFILLER_10_1113 VDD VSS sg13g2_decap_8
XFILLER_154_949 VDD VSS sg13g2_decap_8
XFILLER_181_735 VDD VSS sg13g2_fill_2
XFILLER_88_1350 VDD VSS sg13g2_decap_8
XFILLER_125_139 VDD VSS sg13g2_fill_1
X_11251_ _11251_/Y _11218_/S _14556_/Q VDD VSS sg13g2_nand2b_1
XFILLER_5_959 VDD VSS sg13g2_decap_8
XFILLER_106_320 VDD VSS sg13g2_decap_8
XFILLER_118_180 VDD VSS sg13g2_fill_2
XFILLER_69_11 VDD VSS sg13g2_fill_1
XFILLER_180_245 VDD VSS sg13g2_decap_8
XFILLER_181_779 VDD VSS sg13g2_decap_8
XFILLER_134_651 VDD VSS sg13g2_fill_2
XFILLER_88_1383 VDD VSS sg13g2_decap_8
XFILLER_88_1394 VDD VSS sg13g2_fill_2
XFILLER_4_469 VDD VSS sg13g2_decap_8
XFILLER_109_95 VDD VSS sg13g2_decap_8
X_10202_ _14758_/D _15182_/D _14758_/Q _13654_/S VDD VSS sg13g2_mux2_1
XFILLER_69_44 VDD VSS sg13g2_decap_8
XFILLER_106_364 VDD VSS sg13g2_decap_8
XFILLER_107_898 VDD VSS sg13g2_fill_2
X_11182_ _11182_/Y _11181_/X _11151_/A _11179_/X _11177_/X _11193_/A2 VDD VSS sg13g2_a221oi_1
XFILLER_171_1217 VDD VSS sg13g2_fill_2
XFILLER_84_1269 VDD VSS sg13g2_decap_8
X_10133_ _14711_/D _10166_/A1 _14711_/Q _10136_/S VDD VSS sg13g2_mux2_1
XFILLER_121_345 VDD VSS sg13g2_decap_8
XFILLER_79_259 VDD VSS sg13g2_fill_2
XFILLER_125_72 VDD VSS sg13g2_fill_1
X_14941_ _14941_/Q _14947_/CLK _14941_/D _14941_/RESET_B VDD VSS sg13g2_dfrbpq_1
X_10064_ _14645_/D _10097_/A0 _14645_/Q _10064_/S VDD VSS sg13g2_mux2_1
XFILLER_0_686 VDD VSS sg13g2_decap_8
XFILLER_125_83 VDD VSS sg13g2_decap_8
X_15209__3070 _15209_/RESET_B VDD VSS sg13g2_tiehi
XFILLER_75_432 VDD VSS sg13g2_fill_1
XFILLER_48_646 VDD VSS sg13g2_decap_8
X_14872_ _14872_/Q clkload68/A _14872_/D _14872_/RESET_B VDD VSS sg13g2_dfrbpq_1
XFILLER_75_454 VDD VSS sg13g2_decap_8
X_14718__1554 _14718_/RESET_B VDD VSS sg13g2_tiehi
XFILLER_78_1018 VDD VSS sg13g2_decap_8
XFILLER_21_1242 VDD VSS sg13g2_decap_8
XFILLER_76_999 VDD VSS sg13g2_fill_1
X_13823_ _13823_/Q clkload20/A _13823_/D _13823_/RESET_B VDD VSS sg13g2_dfrbpq_1
XFILLER_62_104 VDD VSS sg13g2_decap_8
XFILLER_29_882 VDD VSS sg13g2_fill_1
XFILLER_18_70 VDD VSS sg13g2_decap_8
XFILLER_29_893 VDD VSS sg13g2_decap_8
X_15043__2632 _15043_/RESET_B VDD VSS sg13g2_tiehi
XFILLER_16_532 VDD VSS sg13g2_decap_8
XFILLER_1_1358 VDD VSS sg13g2_decap_8
X_13754_ _13754_/Q clkload26/A _13754_/D _13754_/RESET_B VDD VSS sg13g2_dfrbpq_1
XFILLER_56_1305 VDD VSS sg13g2_decap_4
X_10966_ _10966_/Y _11015_/A _11015_/C _11027_/B1 VDD VSS sg13g2_a21oi_1
XFILLER_95_1365 VDD VSS sg13g2_fill_1
XFILLER_182_1324 VDD VSS sg13g2_decap_8
X_13982__2290 _13982_/RESET_B VDD VSS sg13g2_tiehi
XFILLER_71_660 VDD VSS sg13g2_decap_8
X_12705_ _12705_/X _12703_/X _12702_/X _12697_/X _12696_/X _12789_/S0 _12705_/S1 VDD
+ VSS sg13g2_mux4_1
XFILLER_91_1229 VDD VSS sg13g2_decap_4
XFILLER_108_1417 VDD VSS sg13g2_decap_8
XFILLER_43_373 VDD VSS sg13g2_decap_8
XFILLER_147_1477 VDD VSS sg13g2_fill_2
X_13685_ _13685_/Q clkload73/A _13685_/D _13685_/RESET_B VDD VSS sg13g2_dfrbpq_1
XFILLER_71_693 VDD VSS sg13g2_decap_8
XFILLER_31_524 VDD VSS sg13g2_decap_8
XFILLER_108_1439 VDD VSS sg13g2_fill_2
XFILLER_182_1368 VDD VSS sg13g2_fill_1
X_10897_ wire276/A _10897_/A _10897_/B _10923_/A _10897_/D VDD VSS sg13g2_nor4_1
XFILLER_176_529 VDD VSS sg13g2_decap_8
X_12636_ _12636_/X _12634_/X _12635_/X _12636_/S VDD VSS sg13g2_mux2_1
XFILLER_19_1182 VDD VSS sg13g2_decap_8
XFILLER_157_732 VDD VSS sg13g2_fill_1
XFILLER_169_592 VDD VSS sg13g2_decap_8
XFILLER_156_220 VDD VSS sg13g2_decap_8
XFILLER_15_1046 VDD VSS sg13g2_decap_8
XFILLER_180_1092 VDD VSS sg13g2_decap_8
X_12567_ _12567_/X _12566_/X _12565_/X _12664_/S VDD VSS sg13g2_mux2_1
XFILLER_8_742 VDD VSS sg13g2_decap_8
XFILLER_157_765 VDD VSS sg13g2_decap_8
XFILLER_106_1185 VDD VSS sg13g2_fill_2
XFILLER_141_1065 VDD VSS sg13g2_decap_4
XFILLER_141_1076 VDD VSS sg13g2_decap_8
X_14306_ _14306_/Q clkload31/A _14306_/D _14306_/RESET_B VDD VSS sg13g2_dfrbpq_1
XFILLER_145_938 VDD VSS sg13g2_decap_8
X_11518_ _11518_/Y _11446_/A _11516_/Y _12292_/A VDD VSS sg13g2_a21oi_1
XFILLER_89_1147 VDD VSS sg13g2_decap_8
XFILLER_7_252 VDD VSS sg13g2_decap_8
XFILLER_141_1098 VDD VSS sg13g2_decap_8
XFILLER_32_1371 VDD VSS sg13g2_fill_2
XFILLER_145_949 VDD VSS sg13g2_fill_1
X_12498_ wire324/A _13683_/Q _12693_/A2 _12497_/X _12415_/A _12763_/C1 VDD VSS sg13g2_a221oi_1
XFILLER_116_139 VDD VSS sg13g2_decap_8
XFILLER_171_223 VDD VSS sg13g2_fill_1
X_14237_ _14237_/Q clkload59/A _14237_/D _14237_/RESET_B VDD VSS sg13g2_dfrbpq_1
XFILLER_172_768 VDD VSS sg13g2_fill_1
X_11449_ _11449_/X _11441_/X _11440_/X _11435_/X _11434_/X _11494_/S0 _11498_/A1 VDD
+ VSS sg13g2_mux4_1
XFILLER_67_1434 VDD VSS sg13g2_decap_8
XFILLER_113_802 VDD VSS sg13g2_decap_8
XFILLER_153_971 VDD VSS sg13g2_fill_2
XFILLER_125_673 VDD VSS sg13g2_decap_8
XFILLER_98_513 VDD VSS sg13g2_decap_8
XFILLER_152_470 VDD VSS sg13g2_decap_8
X_14168_ _14168_/Q clkload24/A _14168_/D _14168_/RESET_B VDD VSS sg13g2_dfrbpq_1
XFILLER_28_1429 VDD VSS sg13g2_decap_8
X_13119_ _13132_/A _13170_/A _13120_/A VDD VSS sg13g2_nor2_1
X_14099_ _14099_/Q clkload32/A _14099_/D _14099_/RESET_B VDD VSS sg13g2_dfrbpq_1
XFILLER_26_1131 VDD VSS sg13g2_decap_8
XFILLER_39_602 VDD VSS sg13g2_decap_8
XFILLER_67_922 VDD VSS sg13g2_decap_8
XFILLER_85_229 VDD VSS sg13g2_fill_2
XFILLER_6_1225 VDD VSS sg13g2_decap_8
XFILLER_113_1134 VDD VSS sg13g2_fill_2
Xfanout1270 _10511_/D _14843_/Q VDD VSS sg13g2_buf_1
X_08660_ _08661_/D _08678_/A _08522_/C _08341_/Y _08544_/B _08654_/Y VDD VSS sg13g2_a221oi_1
XFILLER_66_465 VDD VSS sg13g2_decap_8
XFILLER_54_605 VDD VSS sg13g2_decap_8
XFILLER_113_1178 VDD VSS sg13g2_decap_8
XFILLER_66_476 VDD VSS sg13g2_fill_2
XFILLER_94_796 VDD VSS sg13g2_fill_2
XFILLER_26_329 VDD VSS sg13g2_decap_8
X_08591_ _08591_/X _07859_/B _07861_/B _08598_/A3 _08591_/A3 _08054_/B _08669_/B1
+ VDD VSS sg13g2_mux4_1
XFILLER_93_284 VDD VSS sg13g2_fill_1
XFILLER_93_295 VDD VSS sg13g2_decap_8
XFILLER_54_649 VDD VSS sg13g2_decap_8
XFILLER_19_392 VDD VSS sg13g2_decap_8
XFILLER_179_301 VDD VSS sg13g2_decap_8
X_13812__2460 _13812_/RESET_B VDD VSS sg13g2_tiehi
XFILLER_34_362 VDD VSS sg13g2_decap_8
XFILLER_14_28 VDD VSS sg13g2_decap_8
XFILLER_139_209 VDD VSS sg13g2_decap_8
XFILLER_179_378 VDD VSS sg13g2_decap_8
X_09212_ _13823_/D _10142_/A1 _13823_/Q _09227_/S VDD VSS sg13g2_mux2_1
XFILLER_72_1140 VDD VSS sg13g2_decap_8
XFILLER_50_866 VDD VSS sg13g2_decap_8
XFILLER_22_568 VDD VSS sg13g2_decap_8
XFILLER_148_721 VDD VSS sg13g2_decap_8
XFILLER_50_899 VDD VSS sg13g2_decap_4
XFILLER_37_1282 VDD VSS sg13g2_decap_8
XFILLER_33_1124 VDD VSS sg13g2_fill_2
X_14156__2116 _14156_/RESET_B VDD VSS sg13g2_tiehi
X_09143_ _09143_/Y _10793_/B _09141_/A _09157_/D _09157_/C VDD VSS sg13g2_a22oi_1
XFILLER_33_1135 VDD VSS sg13g2_fill_1
XFILLER_175_540 VDD VSS sg13g2_decap_8
XFILLER_33_1146 VDD VSS sg13g2_fill_1
XFILLER_148_765 VDD VSS sg13g2_fill_1
XFILLER_30_590 VDD VSS sg13g2_decap_8
XFILLER_11_1400 VDD VSS sg13g2_decap_8
XFILLER_136_927 VDD VSS sg13g2_fill_1
XFILLER_135_404 VDD VSS sg13g2_decap_8
X_09074_ _09074_/Y _13088_/A _09103_/C _09126_/A1 VDD VSS sg13g2_o21ai_1
XFILLER_162_201 VDD VSS sg13g2_decap_8
XFILLER_163_735 VDD VSS sg13g2_decap_8
XFILLER_107_128 VDD VSS sg13g2_decap_8
XFILLER_162_212 VDD VSS sg13g2_fill_1
XFILLER_159_1337 VDD VSS sg13g2_fill_1
XFILLER_30_49 VDD VSS sg13g2_decap_8
XFILLER_162_234 VDD VSS sg13g2_decap_8
XFILLER_163_757 VDD VSS sg13g2_decap_8
X_08025_ _08032_/C _08154_/A _08103_/B _08025_/C VDD VSS sg13g2_nor3_1
XFILLER_116_640 VDD VSS sg13g2_decap_8
XFILLER_159_1359 VDD VSS sg13g2_decap_8
XFILLER_116_651 VDD VSS sg13g2_fill_2
XFILLER_146_49 VDD VSS sg13g2_decap_4
XFILLER_104_802 VDD VSS sg13g2_decap_4
XFILLER_104_813 VDD VSS sg13g2_decap_8
XFILLER_150_418 VDD VSS sg13g2_decap_8
XFILLER_1_406 VDD VSS sg13g2_decap_8
XFILLER_143_481 VDD VSS sg13g2_fill_1
XFILLER_171_790 VDD VSS sg13g2_fill_2
XFILLER_131_632 VDD VSS sg13g2_decap_8
XFILLER_104_857 VDD VSS sg13g2_decap_8
XFILLER_39_14 VDD VSS sg13g2_decap_8
XFILLER_104_868 VDD VSS sg13g2_fill_1
XFILLER_118_1045 VDD VSS sg13g2_decap_8
X_15172__3046 _15172_/RESET_B VDD VSS sg13g2_tiehi
XFILLER_77_708 VDD VSS sg13g2_decap_8
X_09976_ _14559_/D _09976_/A0 _14559_/Q _09997_/S VDD VSS sg13g2_mux2_1
XFILLER_44_1231 VDD VSS sg13g2_fill_2
X_08927_ _08927_/X _15045_/Q _14949_/Q _10767_/A VDD VSS sg13g2_mux2_1
XFILLER_58_922 VDD VSS sg13g2_decap_8
XFILLER_131_1212 VDD VSS sg13g2_decap_8
XFILLER_170_1294 VDD VSS sg13g2_decap_8
X_14963__2717 _14963_/RESET_B VDD VSS sg13g2_tiehi
XFILLER_57_443 VDD VSS sg13g2_decap_8
XFILLER_44_1297 VDD VSS sg13g2_decap_8
X_08858_ _13697_/D _16859_/A _08857_/X _08858_/S VDD VSS sg13g2_mux2_1
XFILLER_84_240 VDD VSS sg13g2_decap_4
XFILLER_79_1316 VDD VSS sg13g2_decap_8
X_07809_ _08553_/A _15012_/Q _08541_/B VDD VSS sg13g2_xor2_1
XFILLER_79_1349 VDD VSS sg13g2_fill_1
XFILLER_55_35 VDD VSS sg13g2_decap_8
XFILLER_17_329 VDD VSS sg13g2_decap_8
XFILLER_73_947 VDD VSS sg13g2_decap_4
X_08789_ _13681_/D _08728_/Y _08788_/Y _08787_/Y VDD VSS sg13g2_a21oi_1
XFILLER_73_958 VDD VSS sg13g2_decap_8
XFILLER_73_969 VDD VSS sg13g2_decap_8
X_10820_ _10821_/C _10803_/Y _10805_/Y _10804_/Y VDD VSS sg13g2_o21ai_1
X_14366__1906 _14366_/RESET_B VDD VSS sg13g2_tiehi
XFILLER_129_1141 VDD VSS sg13g2_decap_4
XFILLER_26_885 VDD VSS sg13g2_decap_8
XFILLER_111_52 VDD VSS sg13g2_fill_2
X_14402__1870 _14402_/RESET_B VDD VSS sg13g2_tiehi
XFILLER_0_1380 VDD VSS sg13g2_decap_8
X_10751_ _14915_/D _09204_/C _11078_/B _10750_/Y VDD VSS sg13g2_o21ai_1
XFILLER_129_1174 VDD VSS sg13g2_decap_8
XFILLER_111_85 VDD VSS sg13g2_decap_8
XFILLER_13_546 VDD VSS sg13g2_decap_8
XFILLER_16_1300 VDD VSS sg13g2_decap_8
XFILLER_125_1038 VDD VSS sg13g2_fill_2
XFILLER_139_710 VDD VSS sg13g2_decap_8
XFILLER_185_315 VDD VSS sg13g2_decap_8
X_13470_ _15109_/D _15109_/Q _13470_/A2 _13469_/X VDD VSS sg13g2_a21o_1
X_10682_ _14897_/D _07705_/B _10818_/B _10681_/Y VDD VSS sg13g2_o21ai_1
XFILLER_55_1371 VDD VSS sg13g2_decap_8
XFILLER_51_1202 VDD VSS sg13g2_fill_1
XFILLER_40_354 VDD VSS sg13g2_decap_8
XFILLER_51_1213 VDD VSS sg13g2_fill_2
XFILLER_9_539 VDD VSS sg13g2_decap_8
X_12421_ _12421_/X _14240_/Q _14272_/Q _14304_/Q _14336_/Q _12452_/S0 _12452_/S1 VDD
+ VSS sg13g2_mux4_1
XFILLER_16_1377 VDD VSS sg13g2_decap_8
XFILLER_21_590 VDD VSS sg13g2_decap_8
X_15140_ _15140_/Q clkload77/A _15140_/D _15140_/RESET_B VDD VSS sg13g2_dfrbpq_1
X_12352_ _12352_/X _14235_/Q _14267_/Q _14299_/Q _14331_/Q _12378_/S0 _12378_/S1 VDD
+ VSS sg13g2_mux4_1
XFILLER_126_426 VDD VSS sg13g2_decap_4
XFILLER_138_286 VDD VSS sg13g2_decap_8
XFILLER_112_0 VDD VSS sg13g2_decap_8
XFILLER_181_532 VDD VSS sg13g2_decap_8
XFILLER_154_757 VDD VSS sg13g2_decap_8
X_11303_ _11303_/Y _11317_/A1 _14589_/Q _11897_/C VDD VSS sg13g2_a21oi_1
X_14863__2911 _14863_/RESET_B VDD VSS sg13g2_tiehi
X_15071_ _15071_/Q clkload84/A _15071_/D _15071_/RESET_B VDD VSS sg13g2_dfrbpq_1
XFILLER_107_640 VDD VSS sg13g2_decap_8
X_12283_ _12283_/X _13849_/Q _13881_/Q _13913_/Q _13945_/Q _12286_/S0 _12286_/S1 VDD
+ VSS sg13g2_mux4_1
XFILLER_5_756 VDD VSS sg13g2_decap_8
XFILLER_101_1071 VDD VSS sg13g2_fill_2
XFILLER_135_971 VDD VSS sg13g2_fill_1
X_14022_ _14022_/Q _14662_/CLK _14022_/D _14022_/RESET_B VDD VSS sg13g2_dfrbpq_1
X_11234_ wire579/A _11232_/Y _11233_/Y _15217_/Q VDD VSS sg13g2_a21oi_1
XFILLER_4_266 VDD VSS sg13g2_decap_8
XFILLER_106_161 VDD VSS sg13g2_decap_8
XFILLER_107_695 VDD VSS sg13g2_fill_1
XFILLER_134_481 VDD VSS sg13g2_decap_8
XFILLER_136_1123 VDD VSS sg13g2_fill_2
XFILLER_45_1006 VDD VSS sg13g2_decap_8
XFILLER_122_643 VDD VSS sg13g2_decap_8
X_13854__2418 _13854_/RESET_B VDD VSS sg13g2_tiehi
XFILLER_121_120 VDD VSS sg13g2_decap_8
XFILLER_122_654 VDD VSS sg13g2_fill_2
XFILLER_150_963 VDD VSS sg13g2_decap_8
X_11165_ _11165_/X _11191_/A _11181_/B VDD VSS sg13g2_or2_1
XFILLER_110_816 VDD VSS sg13g2_decap_8
XFILLER_27_1440 VDD VSS sg13g2_decap_8
XFILLER_1_973 VDD VSS sg13g2_decap_8
XFILLER_114_1410 VDD VSS sg13g2_decap_8
XFILLER_171_1069 VDD VSS sg13g2_decap_8
X_14896__2845 _14896_/RESET_B VDD VSS sg13g2_tiehi
X_10116_ _14694_/D _10149_/A1 _14694_/Q _10127_/S VDD VSS sg13g2_mux2_1
XFILLER_62_1342 VDD VSS sg13g2_decap_8
X_11096_ _11096_/Y _11097_/A _11097_/C _11115_/A VDD VSS sg13g2_o21ai_1
XFILLER_49_933 VDD VSS sg13g2_decap_8
XFILLER_103_890 VDD VSS sg13g2_decap_8
XFILLER_49_944 VDD VSS sg13g2_fill_1
XFILLER_0_483 VDD VSS sg13g2_decap_8
XFILLER_76_741 VDD VSS sg13g2_decap_8
X_14924_ _14924_/Q clkload72/A _14924_/D _14924_/RESET_B VDD VSS sg13g2_dfrbpq_1
X_10047_ _14628_/D _10047_/A0 _14628_/Q _10064_/S VDD VSS sg13g2_mux2_1
XFILLER_48_443 VDD VSS sg13g2_decap_8
XFILLER_23_1337 VDD VSS sg13g2_decap_8
XFILLER_97_1405 VDD VSS sg13g2_fill_2
XFILLER_49_977 VDD VSS sg13g2_decap_8
XFILLER_75_251 VDD VSS sg13g2_decap_8
XFILLER_91_711 VDD VSS sg13g2_decap_8
X_14234__2038 _14234_/RESET_B VDD VSS sg13g2_tiehi
X_14855_ _14855_/Q clkload64/A _14855_/D _14855_/RESET_B VDD VSS sg13g2_dfrbpq_1
XFILLER_63_424 VDD VSS sg13g2_fill_2
XFILLER_48_498 VDD VSS sg13g2_decap_8
XFILLER_17_830 VDD VSS sg13g2_fill_1
XFILLER_64_969 VDD VSS sg13g2_decap_8
X_13806_ _13806_/Q _14734_/CLK _13806_/D _13806_/RESET_B VDD VSS sg13g2_dfrbpq_1
XFILLER_35_148 VDD VSS sg13g2_decap_8
XFILLER_1_1155 VDD VSS sg13g2_decap_8
X_14786_ _14786_/Q _14890_/CLK _14786_/D _14786_/RESET_B VDD VSS sg13g2_dfrbpq_1
X_11998_ _11998_/X _11994_/X _11995_/X _11993_/X _11992_/X _11953_/C _11999_/S1 VDD
+ VSS sg13g2_mux4_1
XFILLER_186_1290 VDD VSS sg13g2_decap_8
XFILLER_147_1252 VDD VSS sg13g2_decap_8
X_13737_ _13737_/Q _14729_/CLK _13737_/D _13737_/RESET_B VDD VSS sg13g2_dfrbpq_1
XFILLER_50_129 VDD VSS sg13g2_decap_8
XFILLER_182_1143 VDD VSS sg13g2_fill_2
X_10949_ _10949_/Y _10893_/X _11005_/A _11007_/B VDD VSS sg13g2_o21ai_1
XFILLER_31_310 VDD VSS sg13g2_decap_8
XFILLER_56_1157 VDD VSS sg13g2_decap_8
XFILLER_147_1296 VDD VSS sg13g2_decap_8
XFILLER_34_1400 VDD VSS sg13g2_decap_8
XFILLER_176_315 VDD VSS sg13g2_decap_8
X_13668_ _13668_/Q clkload81/A _13668_/D _13668_/RESET_B VDD VSS sg13g2_dfrbpq_1
XFILLER_32_888 VDD VSS sg13g2_fill_1
XFILLER_160_1430 VDD VSS sg13g2_decap_8
X_12619_ _12619_/X _13838_/Q _13870_/Q _13902_/Q _13934_/Q wire940/X _12620_/S1 VDD
+ VSS sg13g2_mux4_1
X_13599_ _13599_/Y _13600_/A _08834_/B hold3233/X VDD VSS sg13g2_a21oi_1
XFILLER_34_1466 VDD VSS sg13g2_decap_8
XFILLER_34_1477 VDD VSS sg13g2_fill_2
XFILLER_121_1458 VDD VSS sg13g2_decap_8
XFILLER_172_521 VDD VSS sg13g2_decap_8
XFILLER_184_381 VDD VSS sg13g2_decap_8
XFILLER_121_1469 VDD VSS sg13g2_fill_1
XFILLER_184_392 VDD VSS sg13g2_decap_8
XFILLER_6_84 VDD VSS sg13g2_decap_8
XFILLER_160_749 VDD VSS sg13g2_decap_4
XFILLER_158_1381 VDD VSS sg13g2_decap_8
XFILLER_98_332 VDD VSS sg13g2_decap_8
XFILLER_154_1234 VDD VSS sg13g2_decap_8
Xfanout507 _09467_/S _09473_/S VDD VSS sg13g2_buf_1
X_09830_ _14418_/D _09896_/A0 _14418_/Q _09830_/S VDD VSS sg13g2_mux2_1
XFILLER_8_1309 VDD VSS sg13g2_decap_8
XFILLER_140_440 VDD VSS sg13g2_decap_8
X_14444__1828 _14444_/RESET_B VDD VSS sg13g2_tiehi
Xfanout518 _09362_/S _09374_/S VDD VSS sg13g2_buf_1
Xfanout529 _09233_/S _09227_/S VDD VSS sg13g2_buf_1
XFILLER_59_719 VDD VSS sg13g2_decap_8
XFILLER_112_153 VDD VSS sg13g2_decap_8
X_09761_ _14351_/D _14351_/Q _09926_/A1 _09764_/S VDD VSS sg13g2_mux2_1
XFILLER_6_1022 VDD VSS sg13g2_decap_8
XFILLER_112_197 VDD VSS sg13g2_decap_8
XFILLER_67_741 VDD VSS sg13g2_decap_8
X_08712_ _13661_/D _15188_/D _14760_/Q _13652_/S VDD VSS sg13g2_mux2_1
X_09692_ _14284_/D _09923_/A1 _14284_/Q _09706_/S VDD VSS sg13g2_mux2_1
XFILLER_66_251 VDD VSS sg13g2_fill_2
X_08643_ _08646_/B _08643_/A _08646_/A _08643_/C _08643_/D VDD VSS sg13g2_nand4_1
XFILLER_6_1099 VDD VSS sg13g2_decap_8
XFILLER_66_284 VDD VSS sg13g2_decap_8
XFILLER_54_457 VDD VSS sg13g2_decap_8
XFILLER_42_608 VDD VSS sg13g2_decap_8
X_08574_ _08575_/B _08574_/A _08574_/B _08574_/C _08574_/D VDD VSS sg13g2_nand4_1
XFILLER_81_254 VDD VSS sg13g2_fill_2
XFILLER_74_1202 VDD VSS sg13g2_decap_8
XFILLER_39_1322 VDD VSS sg13g2_decap_8
XFILLER_25_49 VDD VSS sg13g2_decap_8
XFILLER_39_1355 VDD VSS sg13g2_decap_8
XFILLER_126_1325 VDD VSS sg13g2_decap_8
XFILLER_161_1205 VDD VSS sg13g2_decap_8
XFILLER_165_1385 VDD VSS sg13g2_decap_8
X_15181__2936 _15181_/RESET_B VDD VSS sg13g2_tiehi
XFILLER_167_315 VDD VSS sg13g2_fill_1
XFILLER_179_175 VDD VSS sg13g2_decap_8
XFILLER_22_354 VDD VSS sg13g2_fill_2
XFILLER_167_326 VDD VSS sg13g2_decap_8
XFILLER_168_849 VDD VSS sg13g2_decap_8
XFILLER_23_888 VDD VSS sg13g2_decap_8
X_09126_ _09126_/Y _09126_/A1 _10767_/B _09125_/X VDD VSS sg13g2_o21ai_1
XFILLER_135_201 VDD VSS sg13g2_decap_4
XFILLER_182_329 VDD VSS sg13g2_decap_8
XFILLER_135_223 VDD VSS sg13g2_fill_1
XFILLER_135_234 VDD VSS sg13g2_decap_8
XFILLER_135_245 VDD VSS sg13g2_fill_2
XFILLER_159_1145 VDD VSS sg13g2_decap_8
X_09057_ _09057_/X _09057_/A _09057_/B _09089_/C VDD VSS sg13g2_or3_1
XFILLER_163_565 VDD VSS sg13g2_decap_8
XFILLER_11_1274 VDD VSS sg13g2_decap_8
XFILLER_159_1178 VDD VSS sg13g2_decap_8
X_08008_ _08008_/Y _08244_/B _08008_/B VDD VSS sg13g2_nor2_1
XFILLER_85_1331 VDD VSS sg13g2_decap_8
XFILLER_137_1421 VDD VSS sg13g2_decap_8
XFILLER_173_14 VDD VSS sg13g2_decap_8
XFILLER_1_203 VDD VSS sg13g2_decap_8
XFILLER_132_930 VDD VSS sg13g2_decap_8
XFILLER_85_1364 VDD VSS sg13g2_decap_8
XFILLER_81_1206 VDD VSS sg13g2_fill_2
XFILLER_137_1443 VDD VSS sg13g2_decap_8
XFILLER_46_1348 VDD VSS sg13g2_decap_8
XFILLER_131_451 VDD VSS sg13g2_decap_8
XFILLER_103_153 VDD VSS sg13g2_decap_8
XFILLER_103_164 VDD VSS sg13g2_fill_2
XFILLER_133_1318 VDD VSS sg13g2_fill_1
XFILLER_77_527 VDD VSS sg13g2_decap_8
XFILLER_89_387 VDD VSS sg13g2_fill_2
X_09959_ _14543_/D _14543_/Q _10091_/A0 _09961_/S VDD VSS sg13g2_mux2_1
XFILLER_44_1050 VDD VSS sg13g2_fill_2
XFILLER_103_197 VDD VSS sg13g2_decap_4
X_12970_ _12970_/Y _12969_/Y _07683_/A _12966_/Y VDD VSS sg13g2_a21oi_1
XFILLER_44_1083 VDD VSS sg13g2_decap_8
XFILLER_92_519 VDD VSS sg13g2_decap_4
XFILLER_131_1053 VDD VSS sg13g2_decap_8
XFILLER_57_251 VDD VSS sg13g2_decap_8
X_11921_ _11921_/X _14703_/Q _14735_/Q _13775_/Q _13807_/Q _11925_/S0 _11925_/S1 VDD
+ VSS sg13g2_mux4_1
XFILLER_79_1135 VDD VSS sg13g2_decap_8
XFILLER_17_126 VDD VSS sg13g2_decap_8
XFILLER_2_1442 VDD VSS sg13g2_decap_8
X_14781__3025 _14781_/RESET_B VDD VSS sg13g2_tiehi
X_14640_ _14640_/Q clkload10/A _14640_/D _14640_/RESET_B VDD VSS sg13g2_dfrbpq_1
XFILLER_72_243 VDD VSS sg13g2_decap_8
X_11852_ _11852_/X _13965_/Q _13997_/Q _14029_/Q _14061_/Q _11854_/S0 _11598_/C VDD
+ VSS sg13g2_mux4_1
XFILLER_82_44 VDD VSS sg13g2_decap_8
X_10803_ _10803_/Y _10675_/A _08971_/X _10802_/Y VDD VSS sg13g2_o21ai_1
XFILLER_92_1324 VDD VSS sg13g2_decap_8
XFILLER_14_833 VDD VSS sg13g2_decap_8
X_14571_ _14571_/Q clkload9/A _14571_/D _14571_/RESET_B VDD VSS sg13g2_dfrbpq_1
XFILLER_60_438 VDD VSS sg13g2_fill_1
XFILLER_26_693 VDD VSS sg13g2_decap_8
XFILLER_183_1452 VDD VSS sg13g2_decap_8
X_11783_ _11783_/X _14571_/Q _14603_/Q _14635_/Q _14667_/Q _11850_/S0 _07654_/A VDD
+ VSS sg13g2_mux4_1
XFILLER_57_1466 VDD VSS sg13g2_decap_4
XFILLER_92_1357 VDD VSS sg13g2_decap_8
XFILLER_13_343 VDD VSS sg13g2_decap_8
X_13522_ _13522_/Y _13521_/A _13533_/B _14998_/Q _13546_/B2 VDD VSS sg13g2_a22oi_1
XFILLER_186_624 VDD VSS sg13g2_decap_8
X_10734_ _14911_/D _10734_/A VDD VSS sg13g2_inv_1
XFILLER_41_663 VDD VSS sg13g2_decap_8
XFILLER_159_849 VDD VSS sg13g2_fill_1
XFILLER_186_635 VDD VSS sg13g2_decap_8
XFILLER_185_112 VDD VSS sg13g2_decap_8
XFILLER_9_336 VDD VSS sg13g2_decap_8
XFILLER_51_1010 VDD VSS sg13g2_decap_8
X_13453_ _13454_/D _15186_/Q _15187_/Q _15188_/Q _15171_/Q VDD VSS sg13g2_nor4_1
XFILLER_90_1070 VDD VSS sg13g2_decap_8
X_10665_ _10667_/B _14893_/Q _10661_/C hold3256/X VDD VSS sg13g2_a21oi_1
XFILLER_139_551 VDD VSS sg13g2_decap_8
X_13908__2364 _13908_/RESET_B VDD VSS sg13g2_tiehi
XFILLER_40_195 VDD VSS sg13g2_decap_8
XFILLER_173_307 VDD VSS sg13g2_decap_8
XFILLER_167_882 VDD VSS sg13g2_decap_8
XFILLER_16_1174 VDD VSS sg13g2_decap_8
X_12404_ _12404_/X _14111_/Q _14143_/Q _14175_/Q _14207_/Q _12411_/S0 _12411_/S1 VDD
+ VSS sg13g2_mux4_1
XFILLER_185_189 VDD VSS sg13g2_decap_8
XFILLER_126_201 VDD VSS sg13g2_decap_8
XFILLER_177_1201 VDD VSS sg13g2_decap_8
X_13384_ _13384_/Y _13493_/A1 _13307_/B _15081_/Q VDD VSS sg13g2_o21ai_1
X_10596_ _10599_/B _14875_/Q _10607_/C _14876_/Q VDD VSS sg13g2_a21oi_1
XFILLER_51_1087 VDD VSS sg13g2_decap_8
XFILLER_182_852 VDD VSS sg13g2_decap_8
X_15123_ _15123_/Q _15182_/CLK _15123_/D _15123_/RESET_B VDD VSS sg13g2_dfrbpq_1
XFILLER_103_1177 VDD VSS sg13g2_fill_2
X_12335_ _12335_/Y _12315_/Y _12317_/X _11378_/S VDD VSS sg13g2_o21ai_1
XFILLER_31_70 VDD VSS sg13g2_decap_8
XFILLER_103_1188 VDD VSS sg13g2_fill_1
XFILLER_142_705 VDD VSS sg13g2_decap_8
XFILLER_5_553 VDD VSS sg13g2_decap_8
XFILLER_154_576 VDD VSS sg13g2_decap_4
X_14812__2994 _14812_/RESET_B VDD VSS sg13g2_tiehi
XFILLER_142_727 VDD VSS sg13g2_decap_8
XFILLER_114_429 VDD VSS sg13g2_decap_8
X_15054_ _15054_/Q clkload88/A _15054_/D _15054_/RESET_B VDD VSS sg13g2_dfrbpq_1
XFILLER_141_215 VDD VSS sg13g2_decap_8
X_12266_ _12266_/Y _12264_/Y _12265_/Y _12266_/B1 VDD VSS sg13g2_a21oi_1
XFILLER_64_1404 VDD VSS sg13g2_decap_8
XFILLER_49_7 VDD VSS sg13g2_decap_8
X_14005_ _14005_/Q clkload29/A _14005_/D _14005_/RESET_B VDD VSS sg13g2_dfrbpq_1
X_11217_ _11217_/X _14555_/Q _14587_/Q _11218_/S VDD VSS sg13g2_mux2_1
Xoutput70 mem_axi_arvalid wire556/X VDD VSS sg13g2_buf_1
X_12197_ _12197_/Y _12197_/A _12197_/B _12198_/B _12198_/D VDD VSS sg13g2_nor4_1
XFILLER_110_613 VDD VSS sg13g2_fill_1
XFILLER_151_1418 VDD VSS sg13g2_decap_8
Xoutput81 mem_axi_awaddr[20] _16873_/X VDD VSS sg13g2_buf_1
XFILLER_1_770 VDD VSS sg13g2_decap_8
Xoutput92 mem_axi_awaddr[30] _16883_/X VDD VSS sg13g2_buf_1
XFILLER_95_313 VDD VSS sg13g2_fill_2
X_11148_ _11150_/A _11125_/A _11147_/Y _11173_/B _11128_/A VDD VSS sg13g2_a22oi_1
XFILLER_110_646 VDD VSS sg13g2_decap_8
XFILLER_0_280 VDD VSS sg13g2_decap_8
XFILLER_62_1161 VDD VSS sg13g2_decap_8
XFILLER_49_741 VDD VSS sg13g2_decap_8
XFILLER_23_1134 VDD VSS sg13g2_decap_8
X_11079_ _11079_/Y _11097_/A _11097_/C VDD VSS sg13g2_xnor2_1
XFILLER_95_379 VDD VSS sg13g2_decap_8
XFILLER_7_1386 VDD VSS sg13g2_decap_8
XFILLER_64_722 VDD VSS sg13g2_decap_8
XFILLER_49_796 VDD VSS sg13g2_decap_8
XFILLER_3_1239 VDD VSS sg13g2_decap_8
XFILLER_110_1126 VDD VSS sg13g2_decap_8
X_14907_ _14907_/Q clkload74/A _14907_/D _14907_/RESET_B VDD VSS sg13g2_dfrbpq_1
XFILLER_63_243 VDD VSS sg13g2_decap_8
X_14838_ _14838_/Q clkload83/A _14838_/D _14838_/RESET_B VDD VSS sg13g2_dfrbpq_1
XFILLER_91_563 VDD VSS sg13g2_decap_8
XFILLER_24_619 VDD VSS sg13g2_decap_4
XFILLER_149_1358 VDD VSS sg13g2_decap_8
X_14769_ _14769_/Q clkload66/A _14769_/D _14769_/RESET_B VDD VSS sg13g2_dfrbpq_1
XFILLER_32_630 VDD VSS sg13g2_decap_8
XFILLER_177_602 VDD VSS sg13g2_decap_8
XFILLER_71_1408 VDD VSS sg13g2_fill_2
X_08290_ _08290_/X _08286_/Y _08289_/Y _08290_/S VDD VSS sg13g2_mux2_1
XFILLER_60_972 VDD VSS sg13g2_decap_8
XFILLER_176_112 VDD VSS sg13g2_decap_8
XFILLER_31_162 VDD VSS sg13g2_decap_8
XFILLER_165_808 VDD VSS sg13g2_decap_4
XFILLER_20_847 VDD VSS sg13g2_decap_8
XFILLER_121_1200 VDD VSS sg13g2_fill_2
XFILLER_158_860 VDD VSS sg13g2_decap_8
XFILLER_34_1252 VDD VSS sg13g2_decap_8
XFILLER_75_0 VDD VSS sg13g2_decap_8
XFILLER_125_1391 VDD VSS sg13g2_decap_8
XFILLER_176_189 VDD VSS sg13g2_decap_8
XFILLER_30_1116 VDD VSS sg13g2_decap_8
XFILLER_69_1304 VDD VSS sg13g2_decap_8
XFILLER_69_1315 VDD VSS sg13g2_fill_2
XFILLER_30_1149 VDD VSS sg13g2_decap_8
XFILLER_145_543 VDD VSS sg13g2_decap_8
XFILLER_173_874 VDD VSS sg13g2_decap_8
XFILLER_105_429 VDD VSS sg13g2_decap_8
XFILLER_172_373 VDD VSS sg13g2_decap_8
XFILLER_132_215 VDD VSS sg13g2_decap_8
XFILLER_133_749 VDD VSS sg13g2_fill_2
Xclkbuf_leaf_114_clk_i clkload53/A clkbuf_leaf_18_clk_i/A VDD VSS sg13g2_buf_8
XFILLER_160_557 VDD VSS sg13g2_decap_8
Xfanout304 _09883_/A0 _09916_/A1 VDD VSS sg13g2_buf_1
XFILLER_8_1106 VDD VSS sg13g2_decap_8
Xfanout315 _09613_/A0 _09001_/X VDD VSS sg13g2_buf_1
Xfanout326 _11040_/A _10736_/Y VDD VSS sg13g2_buf_1
XFILLER_87_825 VDD VSS sg13g2_decap_8
Xfanout337 _10102_/S _10070_/Y VDD VSS sg13g2_buf_1
X_09813_ _14401_/D _09912_/A1 _14401_/Q _09833_/S VDD VSS sg13g2_mux2_1
XFILLER_28_1067 VDD VSS sg13g2_decap_8
XFILLER_59_549 VDD VSS sg13g2_decap_4
Xfanout359 _09866_/S _09869_/S VDD VSS sg13g2_buf_1
Xclkbuf_leaf_129_clk_i clkload19/A clkbuf_5_4__f_clk_i/X VDD VSS sg13g2_buf_8
X_09744_ _14334_/D _14334_/Q _09744_/A1 _09766_/S VDD VSS sg13g2_mux2_1
XFILLER_74_508 VDD VSS sg13g2_fill_1
XFILLER_45_1392 VDD VSS sg13g2_decap_8
XFILLER_41_1234 VDD VSS sg13g2_fill_2
XFILLER_39_251 VDD VSS sg13g2_fill_1
XFILLER_95_891 VDD VSS sg13g2_decap_8
XFILLER_67_582 VDD VSS sg13g2_decap_8
X_09675_ _14267_/D _09906_/A1 _14267_/Q _09706_/S VDD VSS sg13g2_mux2_1
XFILLER_27_435 VDD VSS sg13g2_decap_8
XFILLER_167_1436 VDD VSS sg13g2_decap_4
X_08626_ _08633_/B _08688_/C _08616_/Y _08625_/Y VDD VSS sg13g2_a21oi_1
XFILLER_167_1447 VDD VSS sg13g2_fill_1
XFILLER_70_703 VDD VSS sg13g2_decap_4
XFILLER_43_939 VDD VSS sg13g2_decap_4
XFILLER_54_287 VDD VSS sg13g2_fill_1
X_14880__2877 _14880_/RESET_B VDD VSS sg13g2_tiehi
X_08557_ _08557_/Y wire681/X _08237_/Y _08397_/Y VDD VSS sg13g2_o21ai_1
XFILLER_39_1141 VDD VSS sg13g2_decap_8
XFILLER_153_7 VDD VSS sg13g2_decap_8
XFILLER_70_769 VDD VSS sg13g2_decap_8
XFILLER_23_641 VDD VSS sg13g2_fill_1
XFILLER_161_1002 VDD VSS sg13g2_decap_8
XFILLER_126_1133 VDD VSS sg13g2_decap_4
XFILLER_22_140 VDD VSS sg13g2_decap_8
XFILLER_167_112 VDD VSS sg13g2_decap_8
XFILLER_168_14 VDD VSS sg13g2_decap_8
X_08488_ _08488_/Y _08511_/S _08488_/B VDD VSS sg13g2_nand2_1
XFILLER_74_1076 VDD VSS sg13g2_fill_1
XFILLER_50_471 VDD VSS sg13g2_decap_8
XFILLER_52_69 VDD VSS sg13g2_fill_2
XFILLER_11_847 VDD VSS sg13g2_decap_8
Xwire705 wire705/X wire706/X VDD VSS sg13g2_buf_2
XFILLER_126_1188 VDD VSS sg13g2_decap_4
XFILLER_52_1352 VDD VSS sg13g2_fill_1
XFILLER_155_318 VDD VSS sg13g2_decap_8
XFILLER_10_357 VDD VSS sg13g2_decap_8
XFILLER_167_189 VDD VSS sg13g2_decap_8
X_10450_ _14839_/D _13155_/A _10450_/B _10450_/C VDD VSS sg13g2_nor3_1
XFILLER_182_126 VDD VSS sg13g2_decap_8
XFILLER_183_649 VDD VSS sg13g2_decap_8
XFILLER_52_1385 VDD VSS sg13g2_decap_8
XFILLER_109_746 VDD VSS sg13g2_decap_4
XFILLER_13_1358 VDD VSS sg13g2_decap_8
X_09109_ _09109_/Y _10760_/A _09150_/B _09126_/A1 VDD VSS sg13g2_o21ai_1
X_10381_ _10381_/Y _14818_/Q _10379_/A _10630_/C VDD VSS sg13g2_o21ai_1
XFILLER_174_1407 VDD VSS sg13g2_decap_8
XFILLER_184_35 VDD VSS sg13g2_decap_8
X_12120_ _12120_/Y _12115_/X _11957_/A _12263_/C VDD VSS sg13g2_a21oi_1
XFILLER_11_1071 VDD VSS sg13g2_decap_8
XFILLER_123_215 VDD VSS sg13g2_fill_1
XFILLER_105_941 VDD VSS sg13g2_decap_8
X_14799__3007 _14799_/RESET_B VDD VSS sg13g2_tiehi
XFILLER_137_1240 VDD VSS sg13g2_decap_8
X_12051_ _12051_/Y _12124_/A2 _12050_/Y _12082_/B VDD VSS sg13g2_o21ai_1
XFILLER_104_440 VDD VSS sg13g2_decap_8
XFILLER_172_1131 VDD VSS sg13g2_fill_2
XFILLER_2_567 VDD VSS sg13g2_decap_8
XFILLER_137_1262 VDD VSS sg13g2_decap_8
XFILLER_77_302 VDD VSS sg13g2_decap_8
XFILLER_120_922 VDD VSS sg13g2_decap_8
X_11002_ _11022_/A _11042_/D _15117_/Q VDD VSS sg13g2_nand2_1
XFILLER_81_1036 VDD VSS sg13g2_decap_8
XFILLER_104_484 VDD VSS sg13g2_fill_1
X_13771__2501 _13771_/RESET_B VDD VSS sg13g2_tiehi
XFILLER_89_184 VDD VSS sg13g2_decap_8
XFILLER_81_1069 VDD VSS sg13g2_decap_4
XFILLER_77_77 VDD VSS sg13g2_decap_8
Xfanout860 _12690_/S1 _12760_/S0 VDD VSS sg13g2_buf_1
XFILLER_24_1421 VDD VSS sg13g2_decap_8
Xfanout871 _12643_/S1 _12564_/S1 VDD VSS sg13g2_buf_1
Xfanout882 _12406_/S1 _12588_/S1 VDD VSS sg13g2_buf_1
XFILLER_77_368 VDD VSS sg13g2_decap_8
Xfanout893 _12368_/S1 fanout894/X VDD VSS sg13g2_buf_1
XFILLER_19_925 VDD VSS sg13g2_fill_2
XFILLER_18_413 VDD VSS sg13g2_decap_8
XFILLER_111_1435 VDD VSS sg13g2_decap_8
X_12953_ _12953_/Y _12951_/Y _12952_/Y _12933_/Y VDD VSS sg13g2_o21ai_1
XFILLER_93_21 VDD VSS sg13g2_decap_8
XFILLER_46_733 VDD VSS sg13g2_fill_1
XFILLER_20_1329 VDD VSS sg13g2_decap_8
XFILLER_133_94 VDD VSS sg13g2_decap_8
XFILLER_111_1468 VDD VSS sg13g2_fill_2
Xclkbuf_leaf_93_clk_i clkload68/A clkbuf_leaf_93_clk_i/A VDD VSS sg13g2_buf_8
X_11904_ _11904_/X _14913_/Q _11288_/Y _11903_/Y VDD VSS sg13g2_a21o_1
XFILLER_46_777 VDD VSS sg13g2_decap_8
XFILLER_34_917 VDD VSS sg13g2_decap_8
X_12884_ _12884_/Y _12900_/B input17/X _12900_/C VDD VSS sg13g2_nand3_1
X_14151__2121 _14151_/RESET_B VDD VSS sg13g2_tiehi
XFILLER_46_788 VDD VSS sg13g2_fill_1
XFILLER_61_725 VDD VSS sg13g2_decap_8
XFILLER_34_939 VDD VSS sg13g2_decap_8
XFILLER_93_98 VDD VSS sg13g2_decap_8
XFILLER_60_202 VDD VSS sg13g2_fill_1
X_14623_ _14623_/Q clkload20/A _14623_/D _14623_/RESET_B VDD VSS sg13g2_dfrbpq_1
XFILLER_61_736 VDD VSS sg13g2_fill_1
X_11835_ _11835_/Y _11833_/Y _11834_/Y _12223_/A VDD VSS sg13g2_a21oi_1
XFILLER_26_70 VDD VSS sg13g2_decap_8
XFILLER_14_630 VDD VSS sg13g2_decap_8
XFILLER_92_1132 VDD VSS sg13g2_decap_8
XFILLER_26_490 VDD VSS sg13g2_decap_8
XFILLER_144_1222 VDD VSS sg13g2_decap_8
X_14554_ _14554_/Q clkload53/A _14554_/D _14554_/RESET_B VDD VSS sg13g2_dfrbpq_1
XFILLER_13_140 VDD VSS sg13g2_decap_8
XFILLER_144_1233 VDD VSS sg13g2_fill_2
X_11766_ wire245/A _11765_/Y _11755_/Y _11747_/Y _11737_/Y _12266_/B1 VDD VSS sg13g2_a221oi_1
XFILLER_183_1293 VDD VSS sg13g2_decap_4
XFILLER_109_1375 VDD VSS sg13g2_decap_8
XFILLER_18_1269 VDD VSS sg13g2_decap_8
X_13505_ _15130_/D _15130_/Q _13647_/S _13504_/Y VDD VSS sg13g2_a21o_1
X_10717_ _10965_/A _14938_/Q _10675_/A _10716_/Y VDD VSS sg13g2_a21oi_1
XFILLER_105_1228 VDD VSS sg13g2_decap_8
X_14485_ _14485_/Q clkload32/A _14485_/D _14485_/RESET_B VDD VSS sg13g2_dfrbpq_1
XFILLER_9_133 VDD VSS sg13g2_decap_8
XFILLER_158_156 VDD VSS sg13g2_fill_1
X_11697_ _11698_/A _11694_/Y _11696_/Y _11957_/A VDD VSS sg13g2_a21oi_1
X_14184__2088 _14184_/RESET_B VDD VSS sg13g2_tiehi
XFILLER_70_1463 VDD VSS sg13g2_decap_8
XFILLER_174_638 VDD VSS sg13g2_decap_8
XFILLER_186_498 VDD VSS sg13g2_decap_8
X_13436_ _15100_/D _15100_/Q _13470_/A2 _13435_/Y VDD VSS sg13g2_a21o_1
XFILLER_70_1474 VDD VSS sg13g2_fill_1
X_10648_ _10653_/C _14884_/Q _14883_/Q _14880_/Q _14879_/Q VDD VSS sg13g2_and4_1
XFILLER_42_91 VDD VSS sg13g2_decap_8
XFILLER_173_126 VDD VSS sg13g2_decap_8
XFILLER_155_852 VDD VSS sg13g2_decap_8
Xclkbuf_leaf_31_clk_i _14723_/CLK clkbuf_leaf_37_clk_i/A VDD VSS sg13g2_buf_8
XFILLER_6_840 VDD VSS sg13g2_decap_8
XFILLER_31_1469 VDD VSS sg13g2_decap_8
X_13367_ _13367_/Y _13438_/B _13438_/D VDD VSS sg13g2_nand2_1
X_10579_ _10580_/A _14871_/Q _10579_/B _10579_/C _10583_/D VDD VSS sg13g2_and4_1
XFILLER_154_362 VDD VSS sg13g2_decap_8
XFILLER_127_587 VDD VSS sg13g2_fill_1
X_15106_ _15106_/Q _15200_/CLK _15106_/D _15106_/RESET_B VDD VSS sg13g2_dfrbpq_1
XFILLER_5_350 VDD VSS sg13g2_decap_8
XFILLER_138_1015 VDD VSS sg13g2_decap_8
XFILLER_142_524 VDD VSS sg13g2_fill_1
XFILLER_177_1064 VDD VSS sg13g2_decap_8
X_12318_ _12318_/Y _12328_/A1 _14394_/Q VDD VSS sg13g2_nand2b_1
XFILLER_182_693 VDD VSS sg13g2_decap_8
XFILLER_108_790 VDD VSS sg13g2_fill_2
X_13298_ _13298_/X _13506_/A _13298_/B VDD VSS sg13g2_and2_1
XFILLER_170_855 VDD VSS sg13g2_fill_1
XFILLER_177_1097 VDD VSS sg13g2_fill_1
XFILLER_68_1370 VDD VSS sg13g2_fill_2
XFILLER_114_259 VDD VSS sg13g2_decap_8
X_15037_ _15037_/Q clkload65/A _15037_/D _15037_/RESET_B VDD VSS sg13g2_dfrbpq_1
XFILLER_64_1212 VDD VSS sg13g2_fill_2
X_12249_ _12249_/Y _12250_/A1 _14488_/Q VDD VSS sg13g2_nand2b_1
XFILLER_155_1351 VDD VSS sg13g2_decap_8
XFILLER_96_600 VDD VSS sg13g2_decap_8
XFILLER_69_825 VDD VSS sg13g2_fill_2
Xclkbuf_leaf_46_clk_i _15017_/CLK clkbuf_leaf_46_clk_i/A VDD VSS sg13g2_buf_8
XFILLER_69_836 VDD VSS sg13g2_decap_8
XFILLER_116_1357 VDD VSS sg13g2_fill_2
X_14361__1911 _14361_/RESET_B VDD VSS sg13g2_tiehi
XFILLER_3_63 VDD VSS sg13g2_decap_8
XFILLER_95_132 VDD VSS sg13g2_decap_8
XFILLER_96_666 VDD VSS sg13g2_fill_2
XFILLER_116_1379 VDD VSS sg13g2_decap_8
XFILLER_96_677 VDD VSS sg13g2_decap_8
XFILLER_110_465 VDD VSS sg13g2_decap_8
X_07790_ _08412_/A _07790_/A _15003_/Q VDD VSS sg13g2_nand2_1
XFILLER_83_316 VDD VSS sg13g2_decap_8
XFILLER_7_1183 VDD VSS sg13g2_decap_8
X_14991__2689 _14991_/RESET_B VDD VSS sg13g2_tiehi
XFILLER_3_1036 VDD VSS sg13g2_decap_8
XFILLER_36_221 VDD VSS sg13g2_decap_4
XFILLER_64_541 VDD VSS sg13g2_decap_8
XFILLER_37_755 VDD VSS sg13g2_decap_8
X_09460_ _14061_/D _09625_/A0 _14061_/Q wire504/X VDD VSS sg13g2_mux2_1
XFILLER_149_1133 VDD VSS sg13g2_decap_8
XFILLER_36_254 VDD VSS sg13g2_decap_8
X_08411_ _08411_/Y _08411_/A _08414_/C _08411_/C VDD VSS sg13g2_nor3_1
XFILLER_184_1057 VDD VSS sg13g2_decap_8
X_14394__1878 _14394_/RESET_B VDD VSS sg13g2_tiehi
X_09391_ _13994_/D _09622_/A0 _13994_/Q _09394_/S VDD VSS sg13g2_mux2_1
XFILLER_145_1019 VDD VSS sg13g2_fill_1
XFILLER_178_900 VDD VSS sg13g2_decap_8
XFILLER_17_490 VDD VSS sg13g2_decap_8
XFILLER_40_909 VDD VSS sg13g2_decap_8
XFILLER_51_246 VDD VSS sg13g2_decap_8
XFILLER_162_1311 VDD VSS sg13g2_decap_8
XFILLER_75_1363 VDD VSS sg13g2_decap_8
X_08342_ _08346_/A _08882_/A1 _15002_/Q _08674_/B1 VDD VSS sg13g2_o21ai_1
XFILLER_36_1325 VDD VSS sg13g2_decap_8
XFILLER_162_1333 VDD VSS sg13g2_decap_8
XFILLER_178_955 VDD VSS sg13g2_decap_8
XFILLER_178_966 VDD VSS sg13g2_fill_2
XFILLER_36_1369 VDD VSS sg13g2_decap_8
XFILLER_123_1328 VDD VSS sg13g2_fill_1
XFILLER_138_819 VDD VSS sg13g2_decap_8
XFILLER_20_633 VDD VSS sg13g2_decap_8
X_08273_ _08273_/Y _08603_/B VDD VSS sg13g2_inv_1
XFILLER_137_307 VDD VSS sg13g2_decap_4
XFILLER_162_1388 VDD VSS sg13g2_decap_8
XFILLER_177_476 VDD VSS sg13g2_decap_8
XFILLER_22_28 VDD VSS sg13g2_decap_8
XFILLER_137_329 VDD VSS sg13g2_decap_8
X_14014__2258 _14014_/RESET_B VDD VSS sg13g2_tiehi
XFILLER_20_699 VDD VSS sg13g2_fill_1
XFILLER_69_1101 VDD VSS sg13g2_decap_8
XFILLER_121_1074 VDD VSS sg13g2_fill_2
XFILLER_145_362 VDD VSS sg13g2_decap_8
XFILLER_121_1096 VDD VSS sg13g2_decap_8
XFILLER_133_513 VDD VSS sg13g2_decap_8
XFILLER_105_226 VDD VSS sg13g2_decap_8
X_14908__2821 _14908_/RESET_B VDD VSS sg13g2_tiehi
XFILLER_69_1189 VDD VSS sg13g2_fill_1
XFILLER_121_708 VDD VSS sg13g2_decap_4
XFILLER_86_1470 VDD VSS sg13g2_fill_2
XFILLER_47_1421 VDD VSS sg13g2_decap_8
XFILLER_102_900 VDD VSS sg13g2_fill_2
XFILLER_120_207 VDD VSS sg13g2_decap_8
XFILLER_173_1462 VDD VSS sg13g2_decap_8
XFILLER_173_1473 VDD VSS sg13g2_fill_2
XFILLER_82_1367 VDD VSS sg13g2_decap_8
Xfanout145 _10169_/A1 _09772_/A1 VDD VSS sg13g2_buf_1
XFILLER_87_644 VDD VSS sg13g2_fill_1
Xfanout156 _10067_/A0 _10100_/A0 VDD VSS sg13g2_buf_1
Xfanout167 _10098_/A0 _09138_/X VDD VSS sg13g2_buf_1
XFILLER_47_14 VDD VSS sg13g2_decap_8
XFILLER_87_677 VDD VSS sg13g2_decap_8
Xfanout178 _10095_/A0 _09930_/A1 VDD VSS sg13g2_buf_1
XFILLER_75_828 VDD VSS sg13g2_decap_8
Xfanout189 _09928_/A1 _10160_/A1 VDD VSS sg13g2_buf_1
X_07988_ _07988_/Y _13312_/A _11243_/C _13320_/C _07988_/D VDD VSS sg13g2_nor4_1
XFILLER_87_699 VDD VSS sg13g2_fill_2
XFILLER_41_1042 VDD VSS sg13g2_decap_8
X_09727_ _14318_/D _09727_/A0 _14318_/Q _09727_/S VDD VSS sg13g2_mux2_1
XFILLER_86_198 VDD VSS sg13g2_decap_4
XFILLER_55_530 VDD VSS sg13g2_decap_8
XFILLER_103_31 VDD VSS sg13g2_fill_2
XFILLER_103_42 VDD VSS sg13g2_decap_4
XFILLER_16_917 VDD VSS sg13g2_decap_8
X_09658_ _14251_/D _09063_/X _14251_/Q _09665_/S VDD VSS sg13g2_mux2_1
XFILLER_82_360 VDD VSS sg13g2_decap_8
XFILLER_167_1244 VDD VSS sg13g2_fill_1
X_15189__2882 _15189_/RESET_B VDD VSS sg13g2_tiehi
XFILLER_43_725 VDD VSS sg13g2_decap_8
XFILLER_28_799 VDD VSS sg13g2_fill_1
XFILLER_27_276 VDD VSS sg13g2_decap_4
XFILLER_15_427 VDD VSS sg13g2_decap_8
XFILLER_167_1255 VDD VSS sg13g2_decap_8
XFILLER_103_86 VDD VSS sg13g2_fill_2
X_08609_ _08643_/A _07857_/X _08608_/B _07858_/X VDD VSS sg13g2_a21o_1
XFILLER_163_1108 VDD VSS sg13g2_fill_2
XFILLER_128_1228 VDD VSS sg13g2_decap_8
X_09589_ _14186_/D _14186_/Q _09622_/A0 _09596_/S VDD VSS sg13g2_mux2_1
XFILLER_70_544 VDD VSS sg13g2_decap_8
XFILLER_42_246 VDD VSS sg13g2_decap_4
XFILLER_179_35 VDD VSS sg13g2_decap_8
X_11620_ _11620_/Y _11616_/Y _11617_/Y _11619_/Y _11618_/Y _11615_/B VDD VSS sg13g2_a221oi_1
XFILLER_180_1422 VDD VSS sg13g2_fill_1
XFILLER_168_421 VDD VSS sg13g2_decap_8
XFILLER_180_1433 VDD VSS sg13g2_decap_8
XFILLER_42_279 VDD VSS sg13g2_decap_8
XFILLER_169_977 VDD VSS sg13g2_decap_4
X_11551_ _11551_/Y _12238_/S0 _13860_/Q _12245_/S1 VDD VSS sg13g2_a21oi_1
XFILLER_11_644 VDD VSS sg13g2_decap_8
XFILLER_141_1439 VDD VSS sg13g2_fill_1
X_15119__2814 _15119_/RESET_B VDD VSS sg13g2_tiehi
XFILLER_183_413 VDD VSS sg13g2_decap_8
X_10502_ _10505_/C _10502_/A _10502_/B _10502_/C VDD VSS sg13g2_nor3_1
XFILLER_10_154 VDD VSS sg13g2_decap_8
X_14270_ _14270_/Q clkload49/A _14270_/D _14270_/RESET_B VDD VSS sg13g2_dfrbpq_1
XFILLER_155_126 VDD VSS sg13g2_decap_8
X_11482_ _11777_/A _11483_/A _13686_/Q VDD VSS sg13g2_nor2_1
XFILLER_7_637 VDD VSS sg13g2_decap_8
XFILLER_52_1182 VDD VSS sg13g2_decap_8
XFILLER_52_1193 VDD VSS sg13g2_fill_1
X_13221_ _13221_/Y _13218_/Y _13219_/Y _13220_/Y VDD VSS sg13g2_a21oi_1
XFILLER_104_1272 VDD VSS sg13g2_decap_8
XFILLER_137_863 VDD VSS sg13g2_decap_8
XFILLER_13_1155 VDD VSS sg13g2_decap_8
Xwire579 wire579/X wire579/A VDD VSS sg13g2_buf_4
X_10433_ _10435_/B _14833_/Q _10434_/C _14834_/Q VDD VSS sg13g2_a21oi_1
XFILLER_6_147 VDD VSS sg13g2_decap_8
XFILLER_128_50 VDD VSS sg13g2_decap_4
XFILLER_109_587 VDD VSS sg13g2_decap_8
XFILLER_164_682 VDD VSS sg13g2_decap_8
XFILLER_124_524 VDD VSS sg13g2_decap_8
XFILLER_152_833 VDD VSS sg13g2_decap_8
X_13152_ _13152_/Y _14789_/Q _13220_/A2 _13208_/B1 VDD VSS sg13g2_o21ai_1
XFILLER_124_535 VDD VSS sg13g2_fill_1
XFILLER_151_310 VDD VSS sg13g2_decap_8
XFILLER_174_1215 VDD VSS sg13g2_decap_8
X_10364_ _10365_/B _14812_/Q _14813_/Q _10364_/C VDD VSS sg13g2_nand3_1
XFILLER_88_21 VDD VSS sg13g2_decap_8
XFILLER_48_1218 VDD VSS sg13g2_decap_8
XFILLER_128_83 VDD VSS sg13g2_decap_8
X_12103_ _12103_/Y _12103_/A1 _14420_/Q _12307_/C VDD VSS sg13g2_a21oi_1
XFILLER_3_854 VDD VSS sg13g2_decap_8
X_14169__2103 _14169_/RESET_B VDD VSS sg13g2_tiehi
XFILLER_97_408 VDD VSS sg13g2_decap_8
XFILLER_5_0 VDD VSS sg13g2_decap_8
X_13083_ _13085_/B _14816_/Q _13068_/B _13180_/B1 _14880_/Q VDD VSS sg13g2_a22oi_1
XFILLER_151_365 VDD VSS sg13g2_decap_8
X_10295_ _14792_/D _10295_/A _10295_/B _10611_/B VDD VSS sg13g2_and3_1
XFILLER_2_364 VDD VSS sg13g2_decap_8
X_12034_ _12034_/Y _12030_/Y _12031_/Y _12033_/Y _12032_/Y _12101_/B VDD VSS sg13g2_a221oi_1
XFILLER_77_121 VDD VSS sg13g2_decap_8
XFILLER_61_1418 VDD VSS sg13g2_decap_8
XFILLER_78_655 VDD VSS sg13g2_decap_8
XFILLER_120_752 VDD VSS sg13g2_decap_8
XFILLER_144_82 VDD VSS sg13g2_decap_8
XFILLER_8_1470 VDD VSS sg13g2_decap_8
Xfanout690 _08142_/A _07996_/X VDD VSS sg13g2_buf_1
XFILLER_59_880 VDD VSS sg13g2_fill_1
XFILLER_4_1323 VDD VSS sg13g2_decap_8
XFILLER_18_210 VDD VSS sg13g2_decap_8
X_13985_ _13985_/Q clkload38/A _13985_/D _13985_/RESET_B VDD VSS sg13g2_dfrbpq_1
XFILLER_20_1126 VDD VSS sg13g2_decap_8
XFILLER_98_1352 VDD VSS sg13g2_decap_8
XFILLER_24_1295 VDD VSS sg13g2_decap_8
XFILLER_111_1254 VDD VSS sg13g2_decap_8
XFILLER_59_1314 VDD VSS sg13g2_decap_8
XFILLER_111_1265 VDD VSS sg13g2_fill_2
X_12936_ _12936_/Y _13601_/B _12936_/B VDD VSS sg13g2_nand2b_1
XFILLER_59_1325 VDD VSS sg13g2_fill_2
XFILLER_37_91 VDD VSS sg13g2_decap_8
XFILLER_160_70 VDD VSS sg13g2_decap_8
XFILLER_19_799 VDD VSS sg13g2_decap_8
XFILLER_73_360 VDD VSS sg13g2_decap_8
XFILLER_185_1344 VDD VSS sg13g2_decap_8
XFILLER_146_1306 VDD VSS sg13g2_decap_8
XFILLER_18_287 VDD VSS sg13g2_decap_8
XFILLER_33_224 VDD VSS sg13g2_fill_1
X_12867_ _12867_/Y _12900_/B input16/X _12867_/C VDD VSS sg13g2_nand3_1
XFILLER_33_257 VDD VSS sg13g2_decap_8
XFILLER_18_1011 VDD VSS sg13g2_fill_1
X_14606_ _14606_/Q clkload52/A _14606_/D _14606_/RESET_B VDD VSS sg13g2_dfrbpq_1
X_11818_ _11818_/Y _11819_/A1 _14476_/Q VDD VSS sg13g2_nand2b_1
XFILLER_57_1060 VDD VSS sg13g2_decap_8
X_14976__2704 _14976_/RESET_B VDD VSS sg13g2_tiehi
XFILLER_15_983 VDD VSS sg13g2_decap_8
X_12798_ _12798_/Y _13602_/A _12801_/B _13564_/A2 VDD VSS sg13g2_o21ai_1
X_14537_ _14537_/Q _14729_/CLK _14537_/D _14537_/RESET_B VDD VSS sg13g2_dfrbpq_1
XFILLER_18_1066 VDD VSS sg13g2_decap_8
X_11749_ _11749_/Y _11753_/S0 _14410_/Q _11742_/C VDD VSS sg13g2_a21oi_1
XFILLER_147_627 VDD VSS sg13g2_decap_8
X_14468_ _14468_/Q clkload24/A _14468_/D _14468_/RESET_B VDD VSS sg13g2_dfrbpq_1
XFILLER_174_457 VDD VSS sg13g2_decap_8
X_13419_ _13419_/Y _13493_/A1 _13493_/A2 _15094_/Q VDD VSS sg13g2_o21ai_1
XFILLER_179_1159 VDD VSS sg13g2_decap_8
XFILLER_122_1383 VDD VSS sg13g2_decap_8
X_14399_ _14399_/Q clkload49/A _14399_/D _14399_/RESET_B VDD VSS sg13g2_dfrbpq_1
XFILLER_128_885 VDD VSS sg13g2_decap_8
XFILLER_183_980 VDD VSS sg13g2_fill_1
XFILLER_182_490 VDD VSS sg13g2_decap_8
XFILLER_66_1318 VDD VSS sg13g2_decap_8
XFILLER_142_332 VDD VSS sg13g2_fill_2
XFILLER_170_641 VDD VSS sg13g2_decap_8
XFILLER_115_557 VDD VSS sg13g2_decap_8
XFILLER_143_866 VDD VSS sg13g2_decap_8
Xhold3207 _13646_/A _13754_/Q VDD VSS sg13g2_dlygate4sd3_1
X_08960_ _09441_/C _09204_/C _09204_/D VDD VSS sg13g2_nor2_1
Xhold3218 _13620_/A _13728_/Q VDD VSS sg13g2_dlygate4sd3_1
XFILLER_142_376 VDD VSS sg13g2_decap_8
Xhold3229 hold3229/X _14890_/Q VDD VSS sg13g2_dlygate4sd3_1
XFILLER_170_696 VDD VSS sg13g2_decap_8
XFILLER_130_538 VDD VSS sg13g2_decap_8
X_07911_ _07911_/Y _07911_/A _07912_/B VDD VSS sg13g2_nor2b_1
XFILLER_38_0 VDD VSS sg13g2_decap_8
XFILLER_151_1001 VDD VSS sg13g2_decap_4
XFILLER_64_1053 VDD VSS sg13g2_decap_8
XFILLER_29_1173 VDD VSS sg13g2_decap_8
X_08891_ _08891_/X _08890_/X _11726_/A _08937_/S VDD VSS sg13g2_mux2_1
XFILLER_97_953 VDD VSS sg13g2_decap_4
XFILLER_9_1267 VDD VSS sg13g2_decap_8
XFILLER_69_655 VDD VSS sg13g2_decap_8
XFILLER_25_1037 VDD VSS sg13g2_decap_4
X_07842_ _08678_/A _08654_/A _07841_/Y VDD VSS sg13g2_nor2b_1
XFILLER_57_817 VDD VSS sg13g2_decap_8
XFILLER_110_251 VDD VSS sg13g2_decap_8
XFILLER_69_688 VDD VSS sg13g2_fill_2
XFILLER_25_1059 VDD VSS sg13g2_decap_8
XFILLER_84_636 VDD VSS sg13g2_decap_4
X_07773_ _07773_/Y _08306_/B _08304_/A VDD VSS sg13g2_nor2b_1
XFILLER_17_28 VDD VSS sg13g2_decap_8
XFILLER_83_146 VDD VSS sg13g2_decap_4
XFILLER_42_1395 VDD VSS sg13g2_decap_8
X_09512_ _14111_/D _09976_/A0 _14111_/Q _09539_/S VDD VSS sg13g2_mux2_1
X_13867__2405 _13867_/RESET_B VDD VSS sg13g2_tiehi
XFILLER_83_168 VDD VSS sg13g2_decap_8
XFILLER_92_680 VDD VSS sg13g2_decap_8
XFILLER_64_371 VDD VSS sg13g2_decap_8
X_09443_ _14044_/D _10039_/A0 _14044_/Q _09461_/S VDD VSS sg13g2_mux2_1
XFILLER_64_382 VDD VSS sg13g2_fill_2
XFILLER_38_1409 VDD VSS sg13g2_fill_1
XFILLER_25_747 VDD VSS sg13g2_decap_8
XFILLER_91_190 VDD VSS sg13g2_decap_8
XFILLER_80_886 VDD VSS sg13g2_decap_8
X_09374_ _13978_/D _09638_/A0 _13978_/Q _09374_/S VDD VSS sg13g2_mux2_1
XFILLER_24_279 VDD VSS sg13g2_decap_8
XFILLER_52_599 VDD VSS sg13g2_decap_8
XFILLER_178_752 VDD VSS sg13g2_decap_4
XFILLER_71_1024 VDD VSS sg13g2_decap_8
X_08325_ _08325_/Y _08414_/A _08654_/B VDD VSS sg13g2_nor2_1
XFILLER_71_1035 VDD VSS sg13g2_fill_1
XFILLER_33_49 VDD VSS sg13g2_decap_8
X_14247__2025 _14247_/RESET_B VDD VSS sg13g2_tiehi
XFILLER_149_49 VDD VSS sg13g2_decap_8
XFILLER_138_627 VDD VSS sg13g2_decap_4
XFILLER_166_936 VDD VSS sg13g2_fill_1
XFILLER_177_273 VDD VSS sg13g2_decap_8
X_15100__2864 _15100_/RESET_B VDD VSS sg13g2_tiehi
XFILLER_138_649 VDD VSS sg13g2_decap_8
XFILLER_165_424 VDD VSS sg13g2_decap_8
XFILLER_20_463 VDD VSS sg13g2_decap_8
X_08256_ _08256_/Y _08256_/A _08329_/B VDD VSS sg13g2_nand2_1
XFILLER_119_830 VDD VSS sg13g2_decap_8
XFILLER_165_435 VDD VSS sg13g2_fill_1
XFILLER_14_1442 VDD VSS sg13g2_decap_8
XFILLER_137_159 VDD VSS sg13g2_decap_8
XFILLER_181_928 VDD VSS sg13g2_decap_8
XFILLER_165_479 VDD VSS sg13g2_fill_1
X_08187_ _15223_/D _08187_/A _08187_/B _08187_/C VDD VSS sg13g2_nand3_1
XFILLER_101_1434 VDD VSS sg13g2_decap_8
XFILLER_116_7 VDD VSS sg13g2_decap_8
XFILLER_180_427 VDD VSS sg13g2_decap_8
XFILLER_106_535 VDD VSS sg13g2_decap_8
XFILLER_134_844 VDD VSS sg13g2_fill_1
XFILLER_133_354 VDD VSS sg13g2_fill_2
XFILLER_160_140 VDD VSS sg13g2_decap_8
XFILLER_121_516 VDD VSS sg13g2_decap_8
XFILLER_0_813 VDD VSS sg13g2_decap_8
XFILLER_133_398 VDD VSS sg13g2_decap_8
XFILLER_181_14 VDD VSS sg13g2_decap_8
X_10080_ _14660_/D _10080_/A0 _14660_/Q _10097_/S VDD VSS sg13g2_mux2_1
XFILLER_134_1232 VDD VSS sg13g2_fill_2
X_15148__2754 _15148_/RESET_B VDD VSS sg13g2_tiehi
XFILLER_43_1137 VDD VSS sg13g2_decap_4
XFILLER_134_1265 VDD VSS sg13g2_fill_2
XFILLER_88_997 VDD VSS sg13g2_fill_1
XFILLER_102_785 VDD VSS sg13g2_decap_8
XFILLER_75_636 VDD VSS sg13g2_decap_8
XFILLER_60_1451 VDD VSS sg13g2_decap_8
XFILLER_74_124 VDD VSS sg13g2_decap_8
XFILLER_21_1424 VDD VSS sg13g2_decap_8
XFILLER_90_606 VDD VSS sg13g2_decap_8
XFILLER_28_552 VDD VSS sg13g2_decap_8
X_13770_ _13770_/Q clkload16/A _13770_/D _13770_/RESET_B VDD VSS sg13g2_dfrbpq_1
XFILLER_16_714 VDD VSS sg13g2_decap_8
X_14457__1815 _14457_/RESET_B VDD VSS sg13g2_tiehi
X_10982_ _10982_/X _10995_/A _11042_/A VDD VSS sg13g2_xor2_1
XFILLER_56_894 VDD VSS sg13g2_decap_8
X_12721_ _12722_/B _13667_/Q _12791_/A2 _12720_/X _12763_/B2 _12763_/C1 VDD VSS sg13g2_a221oi_1
XFILLER_43_522 VDD VSS sg13g2_fill_1
XFILLER_15_224 VDD VSS sg13g2_decap_8
XFILLER_71_842 VDD VSS sg13g2_decap_8
XFILLER_71_853 VDD VSS sg13g2_fill_2
X_12652_ _15010_/D _12652_/A _12652_/B VDD VSS sg13g2_nor2_1
XFILLER_93_1260 VDD VSS sg13g2_decap_8
XFILLER_31_728 VDD VSS sg13g2_decap_8
XFILLER_93_1271 VDD VSS sg13g2_fill_1
XFILLER_70_385 VDD VSS sg13g2_fill_1
XFILLER_12_931 VDD VSS sg13g2_decap_8
XFILLER_142_0 VDD VSS sg13g2_decap_8
XFILLER_19_1364 VDD VSS sg13g2_decap_8
X_11603_ _11603_/Y _11621_/S0 _14598_/Q _11598_/C VDD VSS sg13g2_a21oi_1
XFILLER_30_227 VDD VSS sg13g2_decap_4
XFILLER_54_1255 VDD VSS sg13g2_decap_8
XFILLER_169_774 VDD VSS sg13g2_decap_8
X_12583_ _15005_/D _12583_/A _12583_/B VDD VSS sg13g2_nor2_1
X_14672__1600 _14672_/RESET_B VDD VSS sg13g2_tiehi
XFILLER_11_441 VDD VSS sg13g2_decap_8
XFILLER_15_1228 VDD VSS sg13g2_decap_8
X_14322_ _14322_/Q clkload22/A _14322_/D _14322_/RESET_B VDD VSS sg13g2_dfrbpq_1
XFILLER_8_924 VDD VSS sg13g2_decap_8
XFILLER_129_638 VDD VSS sg13g2_decap_8
XFILLER_157_947 VDD VSS sg13g2_fill_1
XFILLER_183_210 VDD VSS sg13g2_decap_8
X_11534_ _11535_/A _13956_/Q _13988_/Q _14020_/Q _14052_/Q _11531_/A _12136_/S1 VDD
+ VSS sg13g2_mux4_1
XFILLER_168_295 VDD VSS sg13g2_fill_2
Xwire321 wire321/X wire321/A VDD VSS sg13g2_buf_2
XFILLER_156_446 VDD VSS sg13g2_fill_2
XFILLER_7_434 VDD VSS sg13g2_decap_8
X_14253_ _14253_/Q _14669_/CLK _14253_/D _14253_/RESET_B VDD VSS sg13g2_dfrbpq_1
XFILLER_171_405 VDD VSS sg13g2_fill_2
X_11465_ _11465_/Y _11463_/Y _11465_/B VDD VSS sg13g2_nand2b_1
XFILLER_172_939 VDD VSS sg13g2_fill_2
XFILLER_125_811 VDD VSS sg13g2_decap_4
XFILLER_137_671 VDD VSS sg13g2_decap_8
XFILLER_183_287 VDD VSS sg13g2_decap_8
X_13204_ _13204_/Y _13224_/A _13204_/B VDD VSS sg13g2_xnor2_1
X_10416_ _10416_/Y _14828_/Q _10415_/A _10423_/C VDD VSS sg13g2_o21ai_1
XFILLER_125_844 VDD VSS sg13g2_decap_8
X_14184_ _14184_/Q clkload27/A _14184_/D _14184_/RESET_B VDD VSS sg13g2_dfrbpq_1
XFILLER_87_1053 VDD VSS sg13g2_decap_4
X_11396_ _11396_/Y _11392_/Y _11393_/X _11395_/Y VDD VSS sg13g2_o21ai_1
XFILLER_99_86 VDD VSS sg13g2_decap_8
XFILLER_125_877 VDD VSS sg13g2_decap_8
X_13135_ _13135_/Y _13170_/B _13131_/Y _13134_/Y VDD VSS sg13g2_a21oi_1
X_13945__2327 _13945_/RESET_B VDD VSS sg13g2_tiehi
XFILLER_174_1045 VDD VSS sg13g2_decap_8
X_10347_ _14808_/D _10352_/C _10347_/B _10347_/C VDD VSS sg13g2_nor3_1
XFILLER_87_1097 VDD VSS sg13g2_decap_8
XFILLER_3_651 VDD VSS sg13g2_decap_8
XFILLER_140_825 VDD VSS sg13g2_fill_1
XFILLER_79_920 VDD VSS sg13g2_decap_4
XFILLER_155_70 VDD VSS sg13g2_decap_8
XFILLER_174_1067 VDD VSS sg13g2_fill_2
XFILLER_112_538 VDD VSS sg13g2_decap_8
XFILLER_79_931 VDD VSS sg13g2_decap_4
XFILLER_2_161 VDD VSS sg13g2_decap_8
X_13066_ _13066_/Y _13066_/A _13172_/A _13066_/C VDD VSS sg13g2_nor3_1
XFILLER_97_238 VDD VSS sg13g2_decap_8
XFILLER_31_7 VDD VSS sg13g2_decap_8
XFILLER_26_1313 VDD VSS sg13g2_decap_8
X_10278_ _10311_/A _14784_/Q _14785_/Q _10278_/C _10305_/B VDD VSS sg13g2_and4_1
XFILLER_65_1384 VDD VSS sg13g2_fill_2
XFILLER_6_1407 VDD VSS sg13g2_decap_8
Xfanout1430 _12103_/A1 _12330_/S0 VDD VSS sg13g2_buf_1
X_12017_ _12018_/B _12232_/S _13938_/Q VDD VSS sg13g2_nand2_1
Xfanout1441 _11528_/S fanout1445/X VDD VSS sg13g2_buf_1
Xfanout1452 fanout1452/X _12215_/S0 VDD VSS sg13g2_buf_1
Xfanout1463 _12213_/S0 _12215_/S0 VDD VSS sg13g2_buf_1
XFILLER_94_934 VDD VSS sg13g2_decap_8
XFILLER_78_485 VDD VSS sg13g2_decap_8
Xfanout1474 _13324_/A _13328_/A VDD VSS sg13g2_buf_1
XFILLER_120_593 VDD VSS sg13g2_decap_8
Xfanout1485 _10626_/B _10499_/C VDD VSS sg13g2_buf_1
XFILLER_93_433 VDD VSS sg13g2_decap_8
XFILLER_4_1120 VDD VSS sg13g2_decap_8
Xfanout1496 _12779_/A1 _12956_/B VDD VSS sg13g2_buf_1
XFILLER_171_91 VDD VSS sg13g2_decap_8
XFILLER_93_466 VDD VSS sg13g2_fill_2
XFILLER_0_42 VDD VSS sg13g2_decap_8
XFILLER_19_574 VDD VSS sg13g2_decap_4
XFILLER_81_628 VDD VSS sg13g2_decap_8
X_13968_ _13968_/Q _14733_/CLK _13968_/D _13968_/RESET_B VDD VSS sg13g2_dfrbpq_1
XFILLER_94_1002 VDD VSS sg13g2_decap_4
XFILLER_4_1197 VDD VSS sg13g2_decap_8
XFILLER_34_522 VDD VSS sg13g2_decap_8
XFILLER_46_393 VDD VSS sg13g2_decap_8
XFILLER_185_1152 VDD VSS sg13g2_decap_4
X_12919_ _12919_/Y _12916_/Y _12917_/Y _12918_/Y VDD VSS sg13g2_a21oi_1
X_13899_ _13899_/Q clkload6/A _13899_/D _13899_/RESET_B VDD VSS sg13g2_dfrbpq_1
XFILLER_61_330 VDD VSS sg13g2_decap_4
XFILLER_94_1057 VDD VSS sg13g2_decap_4
XFILLER_62_864 VDD VSS sg13g2_fill_1
XFILLER_62_875 VDD VSS sg13g2_fill_1
XFILLER_185_1196 VDD VSS sg13g2_decap_8
XFILLER_34_599 VDD VSS sg13g2_fill_2
XFILLER_15_791 VDD VSS sg13g2_decap_8
X_14925__2787 _14925_/RESET_B VDD VSS sg13g2_tiehi
XFILLER_37_1453 VDD VSS sg13g2_fill_1
XFILLER_21_238 VDD VSS sg13g2_decap_8
XFILLER_159_251 VDD VSS sg13g2_decap_8
X_08110_ _08112_/B _08452_/A _08138_/B _08138_/C _08110_/D VDD VSS sg13g2_nand4_1
X_14794__3012 _14794_/RESET_B VDD VSS sg13g2_tiehi
XFILLER_9_84 VDD VSS sg13g2_decap_8
XFILLER_174_210 VDD VSS sg13g2_decap_8
X_09090_ _09090_/Y _09090_/A _09090_/B _09090_/C VDD VSS sg13g2_nand3_1
XFILLER_120_1309 VDD VSS sg13g2_fill_2
XFILLER_175_777 VDD VSS sg13g2_decap_8
X_08041_ _15218_/D _08003_/Y _08040_/Y _08002_/Y VDD VSS sg13g2_a21oi_1
XFILLER_31_1052 VDD VSS sg13g2_decap_8
XFILLER_174_287 VDD VSS sg13g2_decap_8
XFILLER_116_855 VDD VSS sg13g2_decap_4
XFILLER_143_663 VDD VSS sg13g2_decap_8
X_15188__2892 _15188_/RESET_B VDD VSS sg13g2_tiehi
XFILLER_157_1265 VDD VSS sg13g2_fill_2
X_14535__1737 _14535_/RESET_B VDD VSS sg13g2_tiehi
X_09992_ _14575_/D _10091_/A0 _14575_/Q _10003_/S VDD VSS sg13g2_mux2_1
XFILLER_118_1227 VDD VSS sg13g2_decap_8
XFILLER_131_825 VDD VSS sg13g2_decap_4
XFILLER_142_162 VDD VSS sg13g2_decap_8
XFILLER_66_1159 VDD VSS sg13g2_decap_8
XFILLER_118_1238 VDD VSS sg13g2_fill_2
XFILLER_153_1129 VDD VSS sg13g2_decap_8
X_08943_ _08943_/Y _10716_/A _14954_/Q VDD VSS sg13g2_nand2_1
XFILLER_88_238 VDD VSS sg13g2_decap_8
XFILLER_170_1432 VDD VSS sg13g2_decap_8
XFILLER_9_1064 VDD VSS sg13g2_decap_8
XFILLER_85_912 VDD VSS sg13g2_decap_4
XFILLER_69_463 VDD VSS sg13g2_decap_8
X_08874_ _08874_/X _15032_/Q _10694_/S _08873_/Y VDD VSS sg13g2_a21o_1
XFILLER_57_614 VDD VSS sg13g2_fill_2
XFILLER_85_934 VDD VSS sg13g2_decap_8
XFILLER_84_411 VDD VSS sg13g2_decap_8
X_14825__2981 _14825_/RESET_B VDD VSS sg13g2_tiehi
X_07825_ _08436_/B _15005_/Q _07946_/B VDD VSS sg13g2_or2_1
XFILLER_28_49 VDD VSS sg13g2_decap_8
XFILLER_56_157 VDD VSS sg13g2_decap_4
X_07756_ _13305_/B _13499_/C _13293_/B VDD VSS sg13g2_nor2b_1
XFILLER_37_382 VDD VSS sg13g2_decap_4
XFILLER_168_1361 VDD VSS sg13g2_fill_1
XFILLER_168_1372 VDD VSS sg13g2_decap_8
X_07687_ _07697_/A _07687_/A _07687_/B _07687_/C VDD VSS sg13g2_or3_1
XFILLER_168_1383 VDD VSS sg13g2_fill_1
X_09426_ _14028_/D _09558_/A0 _14028_/Q _09428_/S VDD VSS sg13g2_mux2_1
XFILLER_77_1288 VDD VSS sg13g2_decap_8
XFILLER_13_728 VDD VSS sg13g2_decap_8
XFILLER_164_1247 VDD VSS sg13g2_decap_8
XFILLER_90_1400 VDD VSS sg13g2_fill_2
XFILLER_80_672 VDD VSS sg13g2_decap_8
XFILLER_53_897 VDD VSS sg13g2_fill_1
XFILLER_129_1389 VDD VSS sg13g2_decap_8
XFILLER_40_536 VDD VSS sg13g2_decap_8
XFILLER_12_238 VDD VSS sg13g2_decap_8
X_09357_ _13961_/D _10085_/A0 _13961_/Q _09373_/S VDD VSS sg13g2_mux2_1
XFILLER_178_560 VDD VSS sg13g2_decap_8
XFILLER_127_1080 VDD VSS sg13g2_decap_8
Xclkbuf_5_3__f_clk_i clkbuf_leaf_4_clk_i/A clkbuf_4_1_0_clk_i/X VDD VSS sg13g2_buf_16
XFILLER_60_14 VDD VSS sg13g2_decap_8
XFILLER_51_1428 VDD VSS sg13g2_decap_4
X_08308_ _08308_/X _08131_/Y _08138_/C _08027_/Y VDD VSS sg13g2_a21o_1
X_09288_ _13896_/D _13896_/Q _09919_/A1 _09304_/S VDD VSS sg13g2_mux2_1
XFILLER_176_14 VDD VSS sg13g2_decap_8
XFILLER_138_468 VDD VSS sg13g2_decap_8
X_08239_ _08239_/Y _08265_/B _08470_/A _08318_/A _08037_/C _08238_/Y VDD VSS sg13g2_a221oi_1
XFILLER_107_800 VDD VSS sg13g2_fill_2
XFILLER_181_714 VDD VSS sg13g2_decap_8
XFILLER_125_118 VDD VSS sg13g2_decap_8
XFILLER_5_938 VDD VSS sg13g2_decap_8
XFILLER_107_833 VDD VSS sg13g2_decap_8
XFILLER_180_224 VDD VSS sg13g2_decap_8
X_11250_ _14957_/D _11248_/Y _11237_/Y _11249_/Y VDD VSS sg13g2_a21oi_1
XFILLER_109_52 VDD VSS sg13g2_decap_8
XFILLER_4_448 VDD VSS sg13g2_decap_8
XFILLER_109_74 VDD VSS sg13g2_decap_8
XFILLER_106_343 VDD VSS sg13g2_decap_8
XFILLER_10_1169 VDD VSS sg13g2_decap_8
XFILLER_162_961 VDD VSS sg13g2_decap_8
X_10201_ _15182_/D hold3135/X _10201_/A1 _13477_/S VDD VSS sg13g2_mux2_1
XFILLER_133_140 VDD VSS sg13g2_decap_8
XFILLER_175_1354 VDD VSS sg13g2_fill_1
X_11181_ _11181_/X _11181_/A _11181_/B VDD VSS sg13g2_xor2_1
XFILLER_49_1379 VDD VSS sg13g2_decap_4
XFILLER_134_696 VDD VSS sg13g2_decap_8
XFILLER_121_324 VDD VSS sg13g2_decap_8
X_10132_ _14710_/D _10165_/A1 _14710_/Q _10134_/S VDD VSS sg13g2_mux2_1
XFILLER_79_238 VDD VSS sg13g2_decap_8
XFILLER_122_858 VDD VSS sg13g2_decap_4
XFILLER_88_761 VDD VSS sg13g2_decap_4
XFILLER_0_665 VDD VSS sg13g2_decap_8
XFILLER_121_379 VDD VSS sg13g2_decap_8
X_14940_ _14940_/Q clkload75/A _14940_/D _14940_/RESET_B VDD VSS sg13g2_dfrbpq_1
X_10063_ _14644_/D _10096_/A0 _14644_/Q _10063_/S VDD VSS sg13g2_mux2_1
XFILLER_48_614 VDD VSS sg13g2_fill_1
XFILLER_134_1062 VDD VSS sg13g2_fill_1
XFILLER_88_794 VDD VSS sg13g2_decap_8
XFILLER_48_625 VDD VSS sg13g2_decap_8
XFILLER_102_582 VDD VSS sg13g2_decap_8
XFILLER_134_1073 VDD VSS sg13g2_fill_2
XFILLER_76_967 VDD VSS sg13g2_decap_8
X_14871_ _14871_/Q clkload68/A _14871_/D _14871_/RESET_B VDD VSS sg13g2_dfrbpq_1
XFILLER_21_1221 VDD VSS sg13g2_decap_8
XFILLER_169_1125 VDD VSS sg13g2_decap_8
XFILLER_29_861 VDD VSS sg13g2_decap_8
X_13822_ _13822_/Q clkload50/A _13822_/D _13822_/RESET_B VDD VSS sg13g2_dfrbpq_1
XFILLER_75_477 VDD VSS sg13g2_fill_2
XFILLER_60_1292 VDD VSS sg13g2_decap_4
XFILLER_112_1371 VDD VSS sg13g2_fill_2
XFILLER_16_511 VDD VSS sg13g2_decap_8
XFILLER_1_1337 VDD VSS sg13g2_decap_8
X_13753_ _13753_/Q clkload37/A _13753_/D _13753_/RESET_B VDD VSS sg13g2_dfrbpq_1
XFILLER_28_393 VDD VSS sg13g2_decap_8
XFILLER_182_1303 VDD VSS sg13g2_decap_8
XFILLER_21_1298 VDD VSS sg13g2_decap_8
X_10965_ _11042_/A _10965_/A _10965_/B _10965_/C VDD VSS sg13g2_nor3_1
XFILLER_55_190 VDD VSS sg13g2_decap_4
XFILLER_147_1445 VDD VSS sg13g2_fill_1
X_12704_ _12704_/X _12700_/X _12701_/X _12699_/X _12698_/X _12789_/S0 _12705_/S1 VDD
+ VSS sg13g2_mux4_1
XFILLER_43_352 VDD VSS sg13g2_decap_8
XFILLER_71_672 VDD VSS sg13g2_decap_8
XFILLER_31_503 VDD VSS sg13g2_decap_8
XFILLER_16_588 VDD VSS sg13g2_decap_8
X_13684_ _13684_/Q clkload73/A _13684_/D _13684_/RESET_B VDD VSS sg13g2_dfrbpq_1
XFILLER_44_897 VDD VSS sg13g2_decap_8
X_10896_ _10896_/Y _10948_/A _10893_/X _10895_/Y VDD VSS sg13g2_a21oi_1
XFILLER_70_160 VDD VSS sg13g2_fill_1
XFILLER_176_508 VDD VSS sg13g2_decap_8
X_12635_ _12635_/X _12633_/X _12632_/X _12629_/X _12628_/X wire853/X _12678_/S VDD
+ VSS sg13g2_mux4_1
XFILLER_34_70 VDD VSS sg13g2_decap_8
XFILLER_19_1161 VDD VSS sg13g2_decap_8
X_14613__1659 _14613_/RESET_B VDD VSS sg13g2_tiehi
XFILLER_34_81 VDD VSS sg13g2_fill_2
XFILLER_129_402 VDD VSS sg13g2_decap_4
XFILLER_141_1000 VDD VSS sg13g2_decap_4
XFILLER_141_1011 VDD VSS sg13g2_fill_1
XFILLER_145_1180 VDD VSS sg13g2_decap_4
XFILLER_169_571 VDD VSS sg13g2_decap_8
XFILLER_15_1025 VDD VSS sg13g2_decap_8
XFILLER_8_721 VDD VSS sg13g2_decap_8
XFILLER_157_744 VDD VSS sg13g2_decap_8
X_12566_ _12566_/X _12562_/X _12561_/X _12558_/X _12557_/X _12761_/S0 _12761_/S1 VDD
+ VSS sg13g2_mux4_1
XFILLER_141_1044 VDD VSS sg13g2_decap_8
XFILLER_79_7 VDD VSS sg13g2_decap_8
XFILLER_102_1017 VDD VSS sg13g2_decap_8
XFILLER_7_231 VDD VSS sg13g2_decap_8
XFILLER_129_468 VDD VSS sg13g2_decap_8
X_14305_ _14305_/Q clkload36/A _14305_/D _14305_/RESET_B VDD VSS sg13g2_dfrbpq_1
X_11517_ _11517_/X _11507_/X _11508_/X _11511_/X _11512_/X _11443_/A _11654_/S VDD
+ VSS sg13g2_mux4_1
XFILLER_89_1126 VDD VSS sg13g2_decap_8
XFILLER_144_416 VDD VSS sg13g2_decap_8
X_12497_ _12497_/X _12495_/X _12496_/X _12664_/S VDD VSS sg13g2_mux2_1
XFILLER_176_1107 VDD VSS sg13g2_decap_8
XFILLER_184_585 VDD VSS sg13g2_fill_1
XFILLER_116_118 VDD VSS sg13g2_decap_8
XFILLER_144_427 VDD VSS sg13g2_fill_1
XFILLER_176_1118 VDD VSS sg13g2_fill_2
XFILLER_8_798 VDD VSS sg13g2_decap_8
X_14236_ _14236_/Q _14716_/CLK _14236_/D _14236_/RESET_B VDD VSS sg13g2_dfrbpq_1
XFILLER_50_80 VDD VSS sg13g2_decap_8
XFILLER_176_1129 VDD VSS sg13g2_fill_1
X_11448_ _11448_/X _11448_/A _12291_/A _11448_/C VDD VSS sg13g2_and3_1
XFILLER_67_1413 VDD VSS sg13g2_decap_8
XFILLER_166_91 VDD VSS sg13g2_decap_8
XFILLER_124_140 VDD VSS sg13g2_fill_1
X_14167_ _14167_/Q clkload46/A _14167_/D _14167_/RESET_B VDD VSS sg13g2_dfrbpq_1
XFILLER_28_1408 VDD VSS sg13g2_fill_2
X_11379_ _11379_/Y _11884_/B1 _11378_/X _12223_/A VDD VSS sg13g2_a21oi_1
XFILLER_124_162 VDD VSS sg13g2_fill_2
XFILLER_180_791 VDD VSS sg13g2_decap_8
X_13118_ _13170_/A _14914_/Q _13673_/Q VDD VSS sg13g2_xnor2_1
X_14098_ _14098_/Q _14610_/CLK _14098_/D _14098_/RESET_B VDD VSS sg13g2_dfrbpq_1
XFILLER_26_1110 VDD VSS sg13g2_decap_8
XFILLER_61_1001 VDD VSS sg13g2_decap_8
XFILLER_6_1204 VDD VSS sg13g2_decap_8
XFILLER_67_901 VDD VSS sg13g2_decap_8
XFILLER_152_1140 VDD VSS sg13g2_decap_8
X_13049_ _13049_/X _15062_/Q _15061_/Q VDD VSS sg13g2_or2_1
XFILLER_85_208 VDD VSS sg13g2_decap_8
XFILLER_117_1271 VDD VSS sg13g2_fill_1
XFILLER_79_794 VDD VSS sg13g2_fill_2
XFILLER_117_1282 VDD VSS sg13g2_decap_4
XFILLER_66_411 VDD VSS sg13g2_decap_8
Xfanout1260 _10649_/B _14873_/Q VDD VSS sg13g2_buf_1
Xfanout1271 _10342_/A _14798_/Q VDD VSS sg13g2_buf_1
XFILLER_26_1187 VDD VSS sg13g2_decap_8
XFILLER_39_658 VDD VSS sg13g2_decap_4
XFILLER_93_241 VDD VSS sg13g2_decap_8
X_15071__2956 _15071_/RESET_B VDD VSS sg13g2_tiehi
XFILLER_26_308 VDD VSS sg13g2_decap_8
X_08590_ _08590_/Y wire681/X _08590_/B VDD VSS sg13g2_nor2_1
XFILLER_148_1209 VDD VSS sg13g2_decap_4
XFILLER_19_371 VDD VSS sg13g2_decap_8
XFILLER_53_149 VDD VSS sg13g2_decap_4
XFILLER_35_875 VDD VSS sg13g2_fill_2
X_15132__2786 _15132_/RESET_B VDD VSS sg13g2_tiehi
XFILLER_179_357 VDD VSS sg13g2_decap_8
X_09211_ _13822_/D _10141_/A1 _13822_/Q _09227_/S VDD VSS sg13g2_mux2_1
XFILLER_61_182 VDD VSS sg13g2_decap_8
XFILLER_50_845 VDD VSS sg13g2_decap_8
XFILLER_167_508 VDD VSS sg13g2_decap_8
XFILLER_22_547 VDD VSS sg13g2_decap_8
XFILLER_167_519 VDD VSS sg13g2_fill_2
XFILLER_50_878 VDD VSS sg13g2_decap_8
XFILLER_163_1280 VDD VSS sg13g2_decap_8
XFILLER_124_1242 VDD VSS sg13g2_decap_8
X_09142_ _09157_/D _13245_/A _14921_/Q _14920_/Q VDD VSS sg13g2_and3_1
XFILLER_120_1106 VDD VSS sg13g2_decap_4
XFILLER_163_714 VDD VSS sg13g2_decap_8
X_09073_ _10735_/B _09072_/B _15039_/Q _09072_/Y VDD VSS sg13g2_o21ai_1
XFILLER_120_1139 VDD VSS sg13g2_decap_8
XFILLER_148_799 VDD VSS sg13g2_decap_4
XFILLER_159_1316 VDD VSS sg13g2_decap_8
XFILLER_30_28 VDD VSS sg13g2_decap_8
XFILLER_175_596 VDD VSS sg13g2_decap_8
X_08024_ _08025_/C _07903_/B _11291_/A _11335_/A _11384_/A _08023_/A _07884_/A VDD
+ VSS sg13g2_mux4_1
XFILLER_11_1456 VDD VSS sg13g2_decap_8
XFILLER_146_28 VDD VSS sg13g2_decap_8
X_14758__3051 _14758_/RESET_B VDD VSS sg13g2_tiehi
XFILLER_131_611 VDD VSS sg13g2_decap_8
XFILLER_144_994 VDD VSS sg13g2_decap_8
X_14197__2075 _14197_/RESET_B VDD VSS sg13g2_tiehi
XFILLER_130_121 VDD VSS sg13g2_decap_8
X_09975_ _14558_/D _10041_/A0 _14558_/Q _09997_/S VDD VSS sg13g2_mux2_1
XFILLER_44_1210 VDD VSS sg13g2_decap_8
X_08926_ _13714_/D _16876_/A _08925_/X _08932_/S VDD VSS sg13g2_mux2_1
XFILLER_103_379 VDD VSS sg13g2_fill_2
XFILLER_162_49 VDD VSS sg13g2_decap_8
XFILLER_44_1254 VDD VSS sg13g2_decap_8
XFILLER_130_187 VDD VSS sg13g2_decap_8
XFILLER_170_1262 VDD VSS sg13g2_fill_1
XFILLER_170_1273 VDD VSS sg13g2_fill_2
XFILLER_111_390 VDD VSS sg13g2_fill_1
X_08857_ _08857_/X _08856_/X _11503_/A1 _08895_/S VDD VSS sg13g2_mux2_1
XFILLER_183_7 VDD VSS sg13g2_decap_8
XFILLER_29_146 VDD VSS sg13g2_decap_8
XFILLER_55_14 VDD VSS sg13g2_decap_8
XFILLER_45_606 VDD VSS sg13g2_decap_8
XFILLER_17_308 VDD VSS sg13g2_decap_8
X_07808_ _07808_/Y _15012_/Q _08541_/B VDD VSS sg13g2_nor2_1
XFILLER_85_786 VDD VSS sg13g2_fill_1
XFILLER_73_926 VDD VSS sg13g2_decap_8
XFILLER_72_403 VDD VSS sg13g2_decap_8
XFILLER_57_488 VDD VSS sg13g2_decap_8
X_08788_ _08788_/Y _08788_/A1 _14757_/Q _10199_/A1 _07719_/X VDD VSS sg13g2_a22oi_1
XFILLER_45_639 VDD VSS sg13g2_decap_4
XFILLER_44_105 VDD VSS sg13g2_fill_1
X_07739_ _15209_/D _13284_/B _07738_/Y _07714_/Y VDD VSS sg13g2_o21ai_1
XFILLER_60_609 VDD VSS sg13g2_decap_8
XFILLER_26_864 VDD VSS sg13g2_decap_8
XFILLER_168_1191 VDD VSS sg13g2_decap_4
X_10750_ _10750_/Y _14915_/Q _11048_/B VDD VSS sg13g2_nand2_1
XFILLER_111_64 VDD VSS sg13g2_decap_8
XFILLER_13_525 VDD VSS sg13g2_decap_8
XFILLER_164_1044 VDD VSS sg13g2_decap_4
XFILLER_186_806 VDD VSS sg13g2_decap_4
X_09409_ _14011_/D _10071_/A0 _14011_/Q _09428_/S VDD VSS sg13g2_mux2_1
XFILLER_71_35 VDD VSS sg13g2_decap_8
XFILLER_52_193 VDD VSS sg13g2_decap_8
X_10681_ _10681_/Y _10681_/A _10850_/B VDD VSS sg13g2_nand2_1
XFILLER_164_1088 VDD VSS sg13g2_decap_8
XFILLER_9_518 VDD VSS sg13g2_decap_8
XFILLER_142_1331 VDD VSS sg13g2_fill_1
X_12420_ _12420_/X _14368_/Q _14400_/Q _14464_/Q _14496_/Q _12452_/S0 _12452_/S1 VDD
+ VSS sg13g2_mux4_1
XFILLER_90_1274 VDD VSS sg13g2_decap_8
XFILLER_16_1356 VDD VSS sg13g2_decap_8
XFILLER_90_1285 VDD VSS sg13g2_fill_1
XFILLER_51_1236 VDD VSS sg13g2_fill_1
XFILLER_40_388 VDD VSS sg13g2_decap_8
XFILLER_166_541 VDD VSS sg13g2_decap_8
XFILLER_142_1364 VDD VSS sg13g2_decap_4
XFILLER_142_1375 VDD VSS sg13g2_fill_1
X_15046__2626 _15046_/RESET_B VDD VSS sg13g2_tiehi
X_12351_ _12351_/X _14363_/Q _14395_/Q _14459_/Q _14491_/Q _12378_/S0 _12378_/S1 VDD
+ VSS sg13g2_mux4_1
XFILLER_126_405 VDD VSS sg13g2_fill_2
XFILLER_139_788 VDD VSS sg13g2_decap_8
XFILLER_142_1397 VDD VSS sg13g2_decap_4
XFILLER_181_511 VDD VSS sg13g2_decap_8
XFILLER_154_736 VDD VSS sg13g2_fill_2
X_11302_ _11302_/Y _11317_/A1 _14557_/Q VDD VSS sg13g2_nand2b_1
X_15070_ _15070_/Q clkload85/A _15070_/D _15070_/RESET_B VDD VSS sg13g2_dfrbpq_1
XFILLER_5_735 VDD VSS sg13g2_decap_8
XFILLER_126_449 VDD VSS sg13g2_decap_8
X_12282_ _12282_/X _13753_/Q _14105_/Q _14457_/Q _14553_/Q _12286_/S0 _12286_/S1 VDD
+ VSS sg13g2_mux4_1
XFILLER_101_1050 VDD VSS sg13g2_decap_8
XFILLER_105_0 VDD VSS sg13g2_decap_8
XFILLER_141_408 VDD VSS sg13g2_fill_2
X_14021_ _14021_/Q clkload8/A _14021_/D _14021_/RESET_B VDD VSS sg13g2_dfrbpq_1
XFILLER_4_245 VDD VSS sg13g2_decap_8
XFILLER_153_268 VDD VSS sg13g2_decap_8
X_11233_ _11233_/Y _15117_/Q _15118_/Q _14760_/Q VDD VSS sg13g2_nor3_1
XFILLER_134_460 VDD VSS sg13g2_decap_8
XFILLER_181_588 VDD VSS sg13g2_decap_8
XFILLER_49_1154 VDD VSS sg13g2_fill_2
XFILLER_175_1162 VDD VSS sg13g2_fill_1
XFILLER_150_942 VDD VSS sg13g2_decap_8
X_14027__2245 _14027_/RESET_B VDD VSS sg13g2_tiehi
X_11164_ _11181_/B _11164_/A _11164_/B _11164_/C _11190_/C VDD VSS sg13g2_nor4_1
X_13862__2410 _13862_/RESET_B VDD VSS sg13g2_tiehi
XFILLER_84_1078 VDD VSS sg13g2_decap_8
XFILLER_1_952 VDD VSS sg13g2_decap_8
XFILLER_62_1310 VDD VSS sg13g2_decap_4
XFILLER_171_1048 VDD VSS sg13g2_decap_8
X_10115_ _14693_/D _10115_/A0 _14693_/Q _10127_/S VDD VSS sg13g2_mux2_1
XFILLER_0_462 VDD VSS sg13g2_decap_8
X_11095_ _11095_/Y _11095_/A _11095_/B VDD VSS sg13g2_nor2_1
XFILLER_121_176 VDD VSS sg13g2_decap_8
XFILLER_23_1316 VDD VSS sg13g2_decap_8
X_14923_ _14923_/Q clkload72/A _14923_/D _14923_/RESET_B VDD VSS sg13g2_dfrbpq_1
X_10046_ _14627_/D _10079_/A0 _14627_/Q _10064_/S VDD VSS sg13g2_mux2_1
XFILLER_29_70 VDD VSS sg13g2_decap_8
XFILLER_97_1428 VDD VSS sg13g2_fill_1
XFILLER_36_617 VDD VSS sg13g2_fill_2
XFILLER_63_403 VDD VSS sg13g2_decap_8
X_14854_ _14854_/Q clkload68/A _14854_/D _14854_/RESET_B VDD VSS sg13g2_dfrbpq_1
X_14242__2030 _14242_/RESET_B VDD VSS sg13g2_tiehi
XFILLER_5_1281 VDD VSS sg13g2_decap_8
XFILLER_29_680 VDD VSS sg13g2_decap_8
XFILLER_35_127 VDD VSS sg13g2_decap_8
XFILLER_1_1134 VDD VSS sg13g2_decap_8
X_13895__2377 _13895_/RESET_B VDD VSS sg13g2_tiehi
X_13805_ _13805_/Q _14669_/CLK _13805_/D _13805_/RESET_B VDD VSS sg13g2_dfrbpq_1
XFILLER_91_767 VDD VSS sg13g2_decap_8
XFILLER_21_1095 VDD VSS sg13g2_decap_8
X_14785_ _14785_/Q clkload62/A _14785_/D _14785_/RESET_B VDD VSS sg13g2_dfrbpq_1
X_11997_ _11997_/X _13745_/Q _14097_/Q _14449_/Q _14545_/Q _11997_/S0 _11997_/S1 VDD
+ VSS sg13g2_mux4_1
XFILLER_17_875 VDD VSS sg13g2_decap_8
XFILLER_147_1231 VDD VSS sg13g2_decap_8
XFILLER_95_1163 VDD VSS sg13g2_fill_1
XFILLER_50_108 VDD VSS sg13g2_decap_8
X_13736_ _13736_/Q clkload22/A _13736_/D _13736_/RESET_B VDD VSS sg13g2_dfrbpq_1
X_10948_ _11005_/A _10948_/A _10948_/B _10948_/C _10948_/D VDD VSS sg13g2_or4_1
XFILLER_72_992 VDD VSS sg13g2_decap_8
XFILLER_56_1136 VDD VSS sg13g2_decap_8
XFILLER_16_385 VDD VSS sg13g2_decap_8
XFILLER_44_694 VDD VSS sg13g2_decap_8
XFILLER_177_806 VDD VSS sg13g2_fill_2
XFILLER_108_1226 VDD VSS sg13g2_decap_8
XFILLER_182_1155 VDD VSS sg13g2_decap_8
XFILLER_32_867 VDD VSS sg13g2_decap_8
XFILLER_143_1139 VDD VSS sg13g2_decap_8
X_13667_ _13667_/Q clkload81/A _13667_/D _13667_/RESET_B VDD VSS sg13g2_dfrbpq_1
X_15102__2856 _15102_/RESET_B VDD VSS sg13g2_tiehi
X_10879_ _10879_/Y _14754_/Q _10897_/A VDD VSS sg13g2_nand2b_1
XFILLER_182_1199 VDD VSS sg13g2_fill_1
XFILLER_157_530 VDD VSS sg13g2_decap_4
X_12618_ _12618_/X _13742_/Q _14094_/Q _14446_/Q _14542_/Q _12618_/S0 _12618_/S1 VDD
+ VSS sg13g2_mux4_1
XFILLER_34_1445 VDD VSS sg13g2_decap_8
X_13598_ _15164_/D _13597_/Y _08834_/B _13595_/Y VDD VSS sg13g2_a21oi_1
XFILLER_31_399 VDD VSS sg13g2_fill_1
XFILLER_30_1309 VDD VSS sg13g2_decap_8
XFILLER_185_872 VDD VSS sg13g2_decap_4
XFILLER_121_1437 VDD VSS sg13g2_decap_4
XFILLER_172_500 VDD VSS sg13g2_decap_8
X_12549_ _12549_/X _14121_/Q _14153_/Q _14185_/Q _14217_/Q _12550_/S0 _12550_/S1 VDD
+ VSS sg13g2_mux4_1
XFILLER_157_585 VDD VSS sg13g2_decap_8
XFILLER_145_747 VDD VSS sg13g2_fill_1
XFILLER_8_595 VDD VSS sg13g2_decap_8
XANTENNA_1 _15214_/Q VDD VSS sg13g2_antennanp
XFILLER_6_63 VDD VSS sg13g2_decap_8
XFILLER_67_1221 VDD VSS sg13g2_fill_1
XFILLER_144_279 VDD VSS sg13g2_decap_8
XFILLER_160_728 VDD VSS sg13g2_decap_8
X_14219_ _14219_/Q clkload9/A _14219_/D _14219_/RESET_B VDD VSS sg13g2_dfrbpq_1
XFILLER_158_1360 VDD VSS sg13g2_decap_8
X_15199_ _15199_/Q clkload81/A _15199_/D _15199_/RESET_B VDD VSS sg13g2_dfrbpq_1
XFILLER_98_311 VDD VSS sg13g2_decap_8
XFILLER_67_1287 VDD VSS sg13g2_decap_8
Xfanout519 _09366_/S _09374_/S VDD VSS sg13g2_buf_1
XFILLER_28_1249 VDD VSS sg13g2_decap_8
X_14452__1820 _14452_/RESET_B VDD VSS sg13g2_tiehi
XFILLER_115_1219 VDD VSS sg13g2_fill_1
XFILLER_101_828 VDD VSS sg13g2_decap_8
XFILLER_113_688 VDD VSS sg13g2_decap_8
X_09760_ _14350_/D _14350_/Q _10090_/A0 _09766_/S VDD VSS sg13g2_mux2_1
XFILLER_6_1001 VDD VSS sg13g2_decap_8
XFILLER_100_316 VDD VSS sg13g2_decap_8
XFILLER_20_0 VDD VSS sg13g2_decap_8
X_08711_ _15188_/D input14/X _15188_/Q _08719_/S VDD VSS sg13g2_mux2_1
X_09691_ _14283_/D _09922_/A1 _14283_/Q _09698_/S VDD VSS sg13g2_mux2_1
Xfanout1090 _08831_/B _15053_/Q VDD VSS sg13g2_buf_1
XFILLER_6_1078 VDD VSS sg13g2_decap_8
XFILLER_39_466 VDD VSS sg13g2_decap_4
X_08642_ _08642_/Y _08573_/A _08575_/Y _08641_/Y VDD VSS sg13g2_o21ai_1
XFILLER_82_723 VDD VSS sg13g2_decap_4
XFILLER_39_488 VDD VSS sg13g2_fill_1
X_13725__2547 _13725_/RESET_B VDD VSS sg13g2_tiehi
X_14485__1787 _14485_/RESET_B VDD VSS sg13g2_tiehi
X_08573_ _08573_/Y _08573_/A VDD VSS sg13g2_inv_1
XFILLER_35_661 VDD VSS sg13g2_decap_8
XFILLER_25_28 VDD VSS sg13g2_decap_8
XFILLER_165_1331 VDD VSS sg13g2_decap_8
XFILLER_81_288 VDD VSS sg13g2_decap_8
XFILLER_165_1364 VDD VSS sg13g2_decap_8
XFILLER_179_154 VDD VSS sg13g2_decap_8
Xclkbuf_5_21__f_clk_i clkload4/A clkbuf_4_10_0_clk_i/X VDD VSS sg13g2_buf_16
XFILLER_165_1397 VDD VSS sg13g2_decap_8
XFILLER_126_1359 VDD VSS sg13g2_decap_8
X_14105__2167 _14105_/RESET_B VDD VSS sg13g2_tiehi
XFILLER_10_539 VDD VSS sg13g2_decap_8
X_13940__2332 _13940_/RESET_B VDD VSS sg13g2_tiehi
XFILLER_37_1091 VDD VSS sg13g2_decap_8
XFILLER_124_1061 VDD VSS sg13g2_fill_1
XFILLER_182_308 VDD VSS sg13g2_decap_8
X_09125_ _09125_/X _09137_/A _09125_/B _09157_/C VDD VSS sg13g2_or3_1
XFILLER_41_49 VDD VSS sg13g2_decap_8
XFILLER_136_725 VDD VSS sg13g2_fill_1
XFILLER_148_596 VDD VSS sg13g2_decap_8
XFILLER_157_49 VDD VSS sg13g2_fill_1
XFILLER_159_1113 VDD VSS sg13g2_decap_4
XFILLER_163_522 VDD VSS sg13g2_decap_4
X_09056_ _09089_/C _14909_/Q _14908_/Q _09056_/C VDD VSS sg13g2_and3_1
XFILLER_11_1253 VDD VSS sg13g2_decap_8
XFILLER_159_1157 VDD VSS sg13g2_decap_8
X_08007_ _08008_/B _08005_/X _08146_/A _08234_/A VDD VSS sg13g2_mux2_1
XFILLER_151_728 VDD VSS sg13g2_decap_8
XFILLER_9_7 VDD VSS sg13g2_decap_8
X_13973__2299 _13973_/RESET_B VDD VSS sg13g2_tiehi
XFILLER_2_749 VDD VSS sg13g2_decap_8
XFILLER_103_110 VDD VSS sg13g2_fill_2
XFILLER_89_333 VDD VSS sg13g2_fill_1
XFILLER_1_259 VDD VSS sg13g2_decap_8
XFILLER_137_1477 VDD VSS sg13g2_fill_2
XFILLER_89_366 VDD VSS sg13g2_decap_8
XFILLER_77_506 VDD VSS sg13g2_decap_8
XFILLER_106_42 VDD VSS sg13g2_decap_4
XFILLER_104_699 VDD VSS sg13g2_decap_8
X_09958_ _14542_/D _14542_/Q _10024_/A0 _09958_/S VDD VSS sg13g2_mux2_1
XFILLER_58_742 VDD VSS sg13g2_decap_8
X_08909_ _08909_/Y _11865_/A _08937_/S _08908_/Y VDD VSS sg13g2_a21oi_1
XFILLER_57_230 VDD VSS sg13g2_decap_8
XFILLER_46_904 VDD VSS sg13g2_decap_8
X_14866__2905 _14866_/RESET_B VDD VSS sg13g2_tiehi
X_09889_ _14475_/D _09922_/A1 _14475_/Q _09896_/S VDD VSS sg13g2_mux2_1
XFILLER_79_1114 VDD VSS sg13g2_decap_8
XFILLER_66_79 VDD VSS sg13g2_decap_8
XFILLER_17_105 VDD VSS sg13g2_decap_8
X_11920_ _11920_/X _13839_/Q _13871_/Q _13903_/Q _13935_/Q _11925_/S0 _11925_/S1 VDD
+ VSS sg13g2_mux4_1
XFILLER_73_723 VDD VSS sg13g2_fill_1
XFILLER_2_1421 VDD VSS sg13g2_decap_8
XFILLER_131_1087 VDD VSS sg13g2_decap_4
X_11851_ _11851_/X _14125_/Q _14157_/Q _14189_/Q _14221_/Q _11854_/S0 _11598_/C VDD
+ VSS sg13g2_mux4_1
XFILLER_122_63 VDD VSS sg13g2_decap_4
XFILLER_166_1128 VDD VSS sg13g2_decap_4
X_14315__1957 _14315_/RESET_B VDD VSS sg13g2_tiehi
XFILLER_82_23 VDD VSS sg13g2_decap_8
XFILLER_61_929 VDD VSS sg13g2_decap_8
XFILLER_122_96 VDD VSS sg13g2_decap_8
XFILLER_14_812 VDD VSS sg13g2_decap_8
X_10802_ _10802_/Y _10802_/A _12346_/A VDD VSS sg13g2_nor2b_1
XFILLER_60_417 VDD VSS sg13g2_decap_8
XFILLER_183_1431 VDD VSS sg13g2_decap_8
X_14570_ _14570_/Q _14726_/CLK _14570_/D _14570_/RESET_B VDD VSS sg13g2_dfrbpq_1
XFILLER_26_672 VDD VSS sg13g2_decap_8
X_11782_ _11782_/X _13835_/Q _13867_/Q _13899_/Q _13931_/Q _11997_/S0 _11997_/S1 VDD
+ VSS sg13g2_mux4_1
X_14899__2839 _14899_/RESET_B VDD VSS sg13g2_tiehi
XFILLER_13_322 VDD VSS sg13g2_decap_8
X_13521_ _13521_/X _13521_/A _13533_/B VDD VSS sg13g2_and2_1
X_10733_ _10734_/A _14911_/Q _11048_/B _11183_/B1 _11042_/D VDD VSS sg13g2_a22oi_1
XFILLER_144_1437 VDD VSS sg13g2_fill_1
XFILLER_158_305 VDD VSS sg13g2_fill_2
XFILLER_144_1459 VDD VSS sg13g2_decap_8
XFILLER_14_889 VDD VSS sg13g2_decap_8
XFILLER_9_315 VDD VSS sg13g2_decap_8
XFILLER_41_686 VDD VSS sg13g2_decap_4
X_13452_ _13454_/C _15184_/Q _15185_/Q VDD VSS sg13g2_nor2_1
X_10664_ _14893_/D _10664_/A _10667_/A _10664_/C VDD VSS sg13g2_nor3_1
XFILLER_40_174 VDD VSS sg13g2_decap_8
XFILLER_13_399 VDD VSS sg13g2_decap_8
XFILLER_167_861 VDD VSS sg13g2_decap_8
XFILLER_16_1153 VDD VSS sg13g2_decap_8
X_14530__1742 _14530_/RESET_B VDD VSS sg13g2_tiehi
XFILLER_185_168 VDD VSS sg13g2_decap_8
X_12403_ _12403_/Y _12779_/A1 _12779_/A2 _08659_/A VDD VSS sg13g2_a21oi_1
X_13383_ _15080_/D _13378_/C _13455_/A _13380_/Y VDD VSS sg13g2_o21ai_1
XFILLER_51_1066 VDD VSS sg13g2_decap_8
XFILLER_127_725 VDD VSS sg13g2_fill_2
X_10595_ _14875_/D _10595_/A _10608_/B _10595_/C VDD VSS sg13g2_nor3_1
XFILLER_142_1194 VDD VSS sg13g2_decap_8
XFILLER_182_831 VDD VSS sg13g2_decap_8
X_15122_ _15122_/Q clkload83/A _15122_/D _15122_/RESET_B VDD VSS sg13g2_dfrbpq_1
X_12334_ _12334_/Y _12332_/Y _12334_/B _12334_/C VDD VSS sg13g2_nand3b_1
XFILLER_127_758 VDD VSS sg13g2_fill_1
XFILLER_5_532 VDD VSS sg13g2_decap_8
XFILLER_154_555 VDD VSS sg13g2_decap_8
XFILLER_126_257 VDD VSS sg13g2_decap_8
XFILLER_138_1219 VDD VSS sg13g2_decap_8
X_15053_ _15053_/Q clkload91/A _15053_/D _15053_/RESET_B VDD VSS sg13g2_dfrbpq_1
XFILLER_108_983 VDD VSS sg13g2_fill_1
X_12265_ _12265_/Y _12260_/X _12265_/A2 _11559_/C VDD VSS sg13g2_a21oi_1
XFILLER_181_385 VDD VSS sg13g2_decap_8
XFILLER_135_791 VDD VSS sg13g2_decap_8
X_14004_ _14004_/Q clkload25/A _14004_/D _14004_/RESET_B VDD VSS sg13g2_dfrbpq_1
X_13803__2469 _13803_/RESET_B VDD VSS sg13g2_tiehi
X_11216_ _11224_/B _11216_/A _11216_/B VDD VSS sg13g2_nor2_1
X_12196_ _14984_/D _12156_/Y _12195_/Y _12150_/Y VDD VSS sg13g2_a21oi_1
Xoutput60 mem_axi_araddr[30] _16883_/A VDD VSS sg13g2_buf_1
XFILLER_96_804 VDD VSS sg13g2_decap_4
Xoutput71 mem_axi_awaddr[10] _16863_/X VDD VSS sg13g2_buf_1
XFILLER_122_463 VDD VSS sg13g2_decap_8
XFILLER_123_986 VDD VSS sg13g2_decap_8
Xoutput82 mem_axi_awaddr[21] _16874_/X VDD VSS sg13g2_buf_1
XFILLER_96_826 VDD VSS sg13g2_decap_8
Xoutput93 mem_axi_awaddr[31] _16884_/X VDD VSS sg13g2_buf_1
X_11147_ _11147_/Y _11147_/A _11163_/A VDD VSS sg13g2_nand2_1
XFILLER_110_625 VDD VSS sg13g2_decap_8
XFILLER_150_794 VDD VSS sg13g2_decap_8
XFILLER_68_539 VDD VSS sg13g2_decap_8
XFILLER_95_325 VDD VSS sg13g2_decap_8
XFILLER_62_1140 VDD VSS sg13g2_decap_8
XFILLER_49_720 VDD VSS sg13g2_decap_8
XFILLER_23_1113 VDD VSS sg13g2_decap_8
X_11078_ _11138_/B _11078_/A _11078_/B _11097_/A _11078_/D VDD VSS sg13g2_nor4_1
XFILLER_7_1365 VDD VSS sg13g2_decap_8
XFILLER_27_1293 VDD VSS sg13g2_decap_8
XFILLER_49_764 VDD VSS sg13g2_decap_8
XFILLER_3_1218 VDD VSS sg13g2_decap_8
X_14906_ _14906_/Q clkload74/A _14906_/D _14906_/RESET_B VDD VSS sg13g2_dfrbpq_1
X_10029_ _14611_/D _10029_/A0 _14611_/Q _10035_/S VDD VSS sg13g2_mux2_1
XFILLER_97_1214 VDD VSS sg13g2_decap_8
XFILLER_36_403 VDD VSS sg13g2_decap_8
XFILLER_48_285 VDD VSS sg13g2_decap_8
XFILLER_36_436 VDD VSS sg13g2_decap_8
XFILLER_110_1149 VDD VSS sg13g2_fill_2
XFILLER_63_222 VDD VSS sg13g2_decap_8
XFILLER_149_1337 VDD VSS sg13g2_decap_8
X_14837_ _14837_/Q clkload83/A _14837_/D _14837_/RESET_B VDD VSS sg13g2_dfrbpq_1
XFILLER_52_929 VDD VSS sg13g2_fill_2
XFILLER_51_417 VDD VSS sg13g2_decap_8
XFILLER_45_992 VDD VSS sg13g2_decap_8
XFILLER_23_119 VDD VSS sg13g2_decap_8
X_14768_ _14768_/Q clkload66/A _14768_/D _14768_/RESET_B VDD VSS sg13g2_dfrbpq_1
XFILLER_108_1012 VDD VSS sg13g2_decap_8
XFILLER_16_182 VDD VSS sg13g2_decap_8
XFILLER_149_305 VDD VSS sg13g2_decap_8
X_13719_ _16881_/A clkload71/A _13719_/D _13719_/RESET_B VDD VSS sg13g2_dfrbpq_1
XFILLER_149_316 VDD VSS sg13g2_fill_2
X_14699_ _14699_/Q clkload6/A _14699_/D _14699_/RESET_B VDD VSS sg13g2_dfrbpq_1
XFILLER_20_826 VDD VSS sg13g2_decap_8
XFILLER_34_1220 VDD VSS sg13g2_decap_8
XFILLER_108_1089 VDD VSS sg13g2_decap_8
XFILLER_176_168 VDD VSS sg13g2_decap_8
XFILLER_157_360 VDD VSS sg13g2_fill_2
XFILLER_158_894 VDD VSS sg13g2_decap_8
XFILLER_9_882 VDD VSS sg13g2_decap_8
XFILLER_121_1245 VDD VSS sg13g2_decap_8
XFILLER_173_853 VDD VSS sg13g2_decap_8
XFILLER_68_0 VDD VSS sg13g2_fill_2
XFILLER_8_392 VDD VSS sg13g2_decap_8
XFILLER_121_1289 VDD VSS sg13g2_decap_8
XFILLER_133_706 VDD VSS sg13g2_fill_2
XFILLER_172_352 VDD VSS sg13g2_decap_8
XFILLER_105_408 VDD VSS sg13g2_decap_8
X_15184__2908 _15184_/RESET_B VDD VSS sg13g2_tiehi
XFILLER_99_620 VDD VSS sg13g2_fill_2
XFILLER_160_536 VDD VSS sg13g2_decap_8
Xfanout305 _09916_/A1 _09025_/X VDD VSS sg13g2_buf_1
Xfanout316 _10041_/A0 _10074_/A0 VDD VSS sg13g2_buf_1
XFILLER_119_1163 VDD VSS sg13g2_decap_8
XFILLER_59_517 VDD VSS sg13g2_fill_1
XFILLER_115_1005 VDD VSS sg13g2_decap_8
Xfanout327 _10954_/C _10965_/A VDD VSS sg13g2_buf_1
X_09812_ _14400_/D _09911_/A1 _14400_/Q _09837_/S VDD VSS sg13g2_mux2_1
XFILLER_86_303 VDD VSS sg13g2_decap_4
XFILLER_115_1016 VDD VSS sg13g2_fill_1
Xfanout338 _10097_/S _10101_/S VDD VSS sg13g2_buf_1
XFILLER_113_485 VDD VSS sg13g2_decap_8
Xfanout349 _09929_/S _09921_/S VDD VSS sg13g2_buf_1
XFILLER_113_496 VDD VSS sg13g2_fill_1
XFILLER_45_1371 VDD VSS sg13g2_decap_8
XFILLER_86_347 VDD VSS sg13g2_decap_4
XFILLER_41_1213 VDD VSS sg13g2_decap_8
X_09743_ _14333_/D _14333_/Q _09908_/A1 _09766_/S VDD VSS sg13g2_mux2_1
XFILLER_132_1341 VDD VSS sg13g2_fill_1
XFILLER_28_904 VDD VSS sg13g2_fill_2
X_13958__2314 _13958_/RESET_B VDD VSS sg13g2_tiehi
XFILLER_39_263 VDD VSS sg13g2_decap_8
X_09674_ _09674_/X _10137_/C _09740_/B VDD VSS sg13g2_or2_1
XFILLER_28_959 VDD VSS sg13g2_fill_1
XFILLER_167_1415 VDD VSS sg13g2_decap_8
X_08625_ _08625_/Y wire681/X _08625_/B VDD VSS sg13g2_nor2_1
XFILLER_36_49 VDD VSS sg13g2_decap_8
XFILLER_43_907 VDD VSS sg13g2_fill_1
XFILLER_15_609 VDD VSS sg13g2_decap_8
XFILLER_55_778 VDD VSS sg13g2_decap_4
XFILLER_14_119 VDD VSS sg13g2_decap_8
X_08556_ _15241_/D _08555_/Y _08553_/Y _08545_/X VDD VSS sg13g2_o21ai_1
XFILLER_82_597 VDD VSS sg13g2_decap_8
XFILLER_42_428 VDD VSS sg13g2_decap_4
XFILLER_74_1033 VDD VSS sg13g2_decap_8
XFILLER_126_1112 VDD VSS sg13g2_decap_8
X_08487_ _08488_/B _08510_/A1 _08471_/B _08510_/A3 _08487_/A3 _08635_/S0 _08635_/S1
+ VDD VSS sg13g2_mux4_1
XFILLER_146_7 VDD VSS sg13g2_decap_8
XFILLER_165_1183 VDD VSS sg13g2_decap_8
XFILLER_50_450 VDD VSS sg13g2_decap_4
XFILLER_161_1025 VDD VSS sg13g2_fill_1
XFILLER_11_826 VDD VSS sg13g2_decap_8
XFILLER_74_1088 VDD VSS sg13g2_decap_8
XFILLER_161_1058 VDD VSS sg13g2_decap_4
XFILLER_91_1380 VDD VSS sg13g2_fill_2
Xwire706 wire706/X wire706/A VDD VSS sg13g2_buf_2
XFILLER_10_336 VDD VSS sg13g2_decap_8
XFILLER_22_196 VDD VSS sg13g2_decap_8
XFILLER_104_1421 VDD VSS sg13g2_decap_8
XFILLER_143_1470 VDD VSS sg13g2_decap_4
XFILLER_167_168 VDD VSS sg13g2_decap_4
XFILLER_7_819 VDD VSS sg13g2_decap_8
XFILLER_182_105 VDD VSS sg13g2_decap_8
XFILLER_183_628 VDD VSS sg13g2_decap_8
XFILLER_52_1364 VDD VSS sg13g2_decap_8
XFILLER_13_1337 VDD VSS sg13g2_decap_8
XFILLER_164_820 VDD VSS sg13g2_decap_8
XFILLER_6_329 VDD VSS sg13g2_decap_8
X_09108_ _10757_/B _09134_/S _15044_/Q _09107_/Y VDD VSS sg13g2_o21ai_1
XFILLER_87_1405 VDD VSS sg13g2_fill_1
XFILLER_109_758 VDD VSS sg13g2_decap_8
XFILLER_108_235 VDD VSS sg13g2_decap_8
X_10380_ _10380_/X _14815_/Q _14816_/Q _14817_/Q _14818_/Q VDD VSS sg13g2_and4_1
XFILLER_184_14 VDD VSS sg13g2_decap_8
XFILLER_163_352 VDD VSS sg13g2_fill_2
XFILLER_164_875 VDD VSS sg13g2_decap_4
XFILLER_11_1050 VDD VSS sg13g2_decap_8
XFILLER_87_1449 VDD VSS sg13g2_fill_1
X_09039_ _09039_/Y _15231_/Q _09053_/B VDD VSS sg13g2_nand2b_1
XFILLER_105_920 VDD VSS sg13g2_decap_8
XFILLER_163_396 VDD VSS sg13g2_fill_2
X_12050_ _12050_/Y _10760_/A _12122_/A2 _12046_/Y _12049_/Y VDD VSS sg13g2_a22oi_1
XFILLER_2_546 VDD VSS sg13g2_decap_8
XFILLER_81_1004 VDD VSS sg13g2_fill_2
XFILLER_81_1015 VDD VSS sg13g2_decap_8
X_11001_ _11001_/Y _11001_/A _11021_/B VDD VSS sg13g2_nand2_1
XFILLER_132_772 VDD VSS sg13g2_fill_1
XFILLER_89_163 VDD VSS sg13g2_decap_8
XFILLER_46_1157 VDD VSS sg13g2_fill_2
XFILLER_105_997 VDD VSS sg13g2_decap_8
XFILLER_133_1116 VDD VSS sg13g2_decap_4
XFILLER_81_1048 VDD VSS sg13g2_decap_8
XFILLER_77_56 VDD VSS sg13g2_decap_8
XFILLER_172_1176 VDD VSS sg13g2_decap_8
XFILLER_24_1400 VDD VSS sg13g2_decap_8
XFILLER_131_282 VDD VSS sg13g2_decap_8
Xfanout850 _12748_/S _15213_/Q VDD VSS sg13g2_buf_1
XFILLER_131_293 VDD VSS sg13g2_fill_2
XFILLER_172_1198 VDD VSS sg13g2_decap_8
XFILLER_77_347 VDD VSS sg13g2_decap_8
Xfanout872 _12564_/S1 fanout880/X VDD VSS sg13g2_buf_1
XFILLER_93_818 VDD VSS sg13g2_decap_8
XFILLER_120_989 VDD VSS sg13g2_decap_8
Xfanout883 _12591_/S1 _12588_/S1 VDD VSS sg13g2_buf_1
Xfanout894 fanout894/X _15211_/Q VDD VSS sg13g2_buf_1
XFILLER_20_1308 VDD VSS sg13g2_decap_8
XFILLER_24_1477 VDD VSS sg13g2_fill_2
X_12952_ _12952_/Y input21/X _12795_/Y _12937_/Y VDD VSS sg13g2_o21ai_1
X_14548__1724 _14548_/RESET_B VDD VSS sg13g2_tiehi
XFILLER_133_84 VDD VSS sg13g2_decap_4
XFILLER_85_380 VDD VSS sg13g2_decap_8
XFILLER_172_0 VDD VSS sg13g2_decap_8
X_11903_ _11903_/Y _11902_/Y _11892_/Y _11884_/Y _11876_/Y _12223_/A VDD VSS sg13g2_a221oi_1
XFILLER_18_469 VDD VSS sg13g2_decap_8
X_12883_ _12883_/X _12899_/A _12900_/C _12899_/C input25/X VDD VSS sg13g2_and4_1
XFILLER_93_77 VDD VSS sg13g2_decap_8
XFILLER_73_564 VDD VSS sg13g2_fill_2
X_14622_ _14622_/Q clkload48/A _14622_/D _14622_/RESET_B VDD VSS sg13g2_dfrbpq_1
XFILLER_57_1220 VDD VSS sg13g2_decap_8
X_11834_ _11834_/Y _11829_/X _11224_/A _12334_/C VDD VSS sg13g2_a21oi_1
XFILLER_92_1111 VDD VSS sg13g2_decap_8
XFILLER_45_288 VDD VSS sg13g2_decap_8
XFILLER_2_1295 VDD VSS sg13g2_decap_8
XFILLER_26_93 VDD VSS sg13g2_fill_1
XFILLER_109_1332 VDD VSS sg13g2_decap_4
X_14553_ _14553_/Q clkload37/A _14553_/D _14553_/RESET_B VDD VSS sg13g2_dfrbpq_1
X_11765_ _11765_/Y _11765_/A _11765_/B VDD VSS sg13g2_nor2_1
XFILLER_42_962 VDD VSS sg13g2_decap_4
XFILLER_60_269 VDD VSS sg13g2_decap_8
XFILLER_159_636 VDD VSS sg13g2_decap_8
XFILLER_14_686 VDD VSS sg13g2_decap_8
XFILLER_18_1248 VDD VSS sg13g2_decap_8
XFILLER_42_995 VDD VSS sg13g2_fill_1
XFILLER_105_1207 VDD VSS sg13g2_decap_8
XFILLER_158_124 VDD VSS sg13g2_decap_4
X_13504_ _13504_/Y _13504_/A _15174_/D VDD VSS sg13g2_nor2b_1
X_10716_ _10716_/Y _10716_/A _10716_/B VDD VSS sg13g2_nor2_1
XFILLER_9_112 VDD VSS sg13g2_decap_8
XFILLER_41_472 VDD VSS sg13g2_decap_4
XFILLER_147_809 VDD VSS sg13g2_fill_1
XFILLER_186_444 VDD VSS sg13g2_decap_8
XFILLER_186_455 VDD VSS sg13g2_decap_8
X_14484_ _14484_/Q clkload55/A _14484_/D _14484_/RESET_B VDD VSS sg13g2_dfrbpq_1
X_11696_ _11696_/Y _11696_/A _12253_/B VDD VSS sg13g2_nand2_1
XFILLER_13_196 VDD VSS sg13g2_decap_8
XFILLER_174_617 VDD VSS sg13g2_decap_8
XFILLER_42_70 VDD VSS sg13g2_decap_8
XFILLER_173_105 VDD VSS sg13g2_decap_8
X_13435_ _13435_/Y _13435_/A _13435_/B _13444_/C VDD VSS sg13g2_nor3_1
X_10647_ _10653_/B _10647_/A _14870_/Q _10647_/C _10647_/D VDD VSS sg13g2_and4_1
X_14192__2080 _14192_/RESET_B VDD VSS sg13g2_tiehi
XFILLER_9_189 VDD VSS sg13g2_decap_8
XFILLER_139_382 VDD VSS sg13g2_decap_8
XFILLER_31_1448 VDD VSS sg13g2_decap_8
X_13366_ _13366_/Y _13407_/A _13469_/A _15075_/Q VDD VSS sg13g2_nand3_1
XFILLER_61_7 VDD VSS sg13g2_decap_8
XFILLER_127_555 VDD VSS sg13g2_decap_8
X_10578_ _10580_/C _10591_/C _10583_/D _14871_/Q VDD VSS sg13g2_a21oi_1
XFILLER_177_1043 VDD VSS sg13g2_decap_8
XFILLER_182_672 VDD VSS sg13g2_decap_8
X_15105_ _15105_/Q _15200_/CLK _15105_/D _15105_/RESET_B VDD VSS sg13g2_dfrbpq_1
X_12317_ _12317_/X _12317_/A _12317_/B VDD VSS sg13g2_and2_1
XFILLER_170_834 VDD VSS sg13g2_decap_8
X_13297_ _13297_/X _13297_/A0 wire706/X _13300_/C VDD VSS sg13g2_mux2_1
XFILLER_6_896 VDD VSS sg13g2_decap_8
XFILLER_181_182 VDD VSS sg13g2_decap_8
XFILLER_29_1311 VDD VSS sg13g2_decap_8
XFILLER_114_238 VDD VSS sg13g2_decap_8
X_15036_ _15036_/Q clkload75/A _15036_/D _15036_/RESET_B VDD VSS sg13g2_dfrbpq_1
X_12248_ _12248_/Y _12250_/A1 _14424_/Q _11760_/C VDD VSS sg13g2_a21oi_1
XFILLER_142_569 VDD VSS sg13g2_decap_8
XFILLER_68_1382 VDD VSS sg13g2_fill_2
XFILLER_69_804 VDD VSS sg13g2_decap_8
XFILLER_174_91 VDD VSS sg13g2_decap_8
XFILLER_64_1246 VDD VSS sg13g2_decap_8
XFILLER_29_1366 VDD VSS sg13g2_decap_8
XFILLER_123_783 VDD VSS sg13g2_decap_8
X_12179_ _12179_/Y _12175_/Y _12176_/Y _12178_/Y _12177_/Y _12246_/B VDD VSS sg13g2_a221oi_1
XFILLER_9_1449 VDD VSS sg13g2_decap_8
XFILLER_3_42 VDD VSS sg13g2_decap_8
XFILLER_116_1336 VDD VSS sg13g2_decap_8
XFILLER_95_111 VDD VSS sg13g2_decap_8
XFILLER_151_1238 VDD VSS sg13g2_decap_8
XFILLER_96_656 VDD VSS sg13g2_decap_4
XFILLER_110_444 VDD VSS sg13g2_decap_8
XFILLER_7_1162 VDD VSS sg13g2_decap_8
XFILLER_27_1090 VDD VSS sg13g2_decap_8
XFILLER_3_1015 VDD VSS sg13g2_decap_8
XFILLER_114_1071 VDD VSS sg13g2_fill_1
XFILLER_95_188 VDD VSS sg13g2_decap_8
XFILLER_37_734 VDD VSS sg13g2_decap_8
XFILLER_97_1055 VDD VSS sg13g2_decap_8
XFILLER_92_873 VDD VSS sg13g2_fill_2
XFILLER_92_884 VDD VSS sg13g2_fill_1
X_08410_ _08410_/X _08410_/A _08410_/B _08410_/C _08410_/D VDD VSS sg13g2_and4_1
X_09390_ _13993_/D _10085_/A0 _13993_/Q _09406_/S VDD VSS sg13g2_mux2_1
XFILLER_97_1099 VDD VSS sg13g2_decap_8
XFILLER_91_394 VDD VSS sg13g2_decap_8
XFILLER_75_1342 VDD VSS sg13g2_decap_8
XFILLER_127_1410 VDD VSS sg13g2_decap_8
X_08341_ _08341_/Y _08340_/A _08339_/Y _08340_/Y VDD VSS sg13g2_o21ai_1
XFILLER_36_1304 VDD VSS sg13g2_fill_2
XFILLER_178_934 VDD VSS sg13g2_decap_8
X_14850__2937 _14850_/RESET_B VDD VSS sg13g2_tiehi
XFILLER_149_124 VDD VSS sg13g2_decap_8
XFILLER_20_612 VDD VSS sg13g2_decap_8
X_08272_ _08603_/B _08270_/B _08082_/X _08688_/B VDD VSS sg13g2_o21ai_1
XFILLER_177_455 VDD VSS sg13g2_decap_8
XFILLER_165_606 VDD VSS sg13g2_decap_8
XFILLER_32_494 VDD VSS sg13g2_decap_8
XFILLER_165_617 VDD VSS sg13g2_fill_2
XFILLER_149_179 VDD VSS sg13g2_decap_8
X_14022__2250 _14022_/RESET_B VDD VSS sg13g2_tiehi
XFILLER_118_522 VDD VSS sg13g2_decap_8
XFILLER_146_842 VDD VSS sg13g2_decap_8
XFILLER_160_1091 VDD VSS sg13g2_fill_1
XFILLER_34_1094 VDD VSS sg13g2_decap_8
XFILLER_180_609 VDD VSS sg13g2_decap_8
XFILLER_145_341 VDD VSS sg13g2_decap_8
XFILLER_146_875 VDD VSS sg13g2_fill_1
X_14626__1646 _14626_/RESET_B VDD VSS sg13g2_tiehi
XFILLER_172_182 VDD VSS sg13g2_decap_8
XFILLER_156_1149 VDD VSS sg13g2_decap_8
XFILLER_154_28 VDD VSS sg13g2_decap_8
XFILLER_160_355 VDD VSS sg13g2_decap_4
XFILLER_102_912 VDD VSS sg13g2_fill_2
XFILLER_102_923 VDD VSS sg13g2_decap_8
XFILLER_82_1346 VDD VSS sg13g2_decap_8
X_13890__2382 _13890_/RESET_B VDD VSS sg13g2_tiehi
XFILLER_87_623 VDD VSS sg13g2_decap_8
XFILLER_59_314 VDD VSS sg13g2_decap_8
XFILLER_47_1477 VDD VSS sg13g2_fill_2
XFILLER_102_934 VDD VSS sg13g2_fill_1
XFILLER_141_591 VDD VSS sg13g2_fill_2
XFILLER_134_1447 VDD VSS sg13g2_decap_8
Xfanout146 _09772_/A1 _09166_/Y VDD VSS sg13g2_buf_1
Xfanout157 _10100_/A0 _09152_/Y VDD VSS sg13g2_buf_1
XFILLER_87_656 VDD VSS sg13g2_decap_8
Xfanout168 _09998_/A0 _10097_/A0 VDD VSS sg13g2_buf_1
XFILLER_75_807 VDD VSS sg13g2_decap_8
Xfanout179 _09831_/A0 _10162_/A1 VDD VSS sg13g2_buf_1
X_07987_ _07987_/Y _13290_/B _13293_/B _13506_/A _13290_/A VDD VSS sg13g2_nand4_1
XFILLER_59_369 VDD VSS sg13g2_decap_8
XFILLER_102_989 VDD VSS sg13g2_decap_8
XFILLER_47_59 VDD VSS sg13g2_decap_8
X_09726_ _14317_/D _09759_/A1 _14317_/Q _09731_/S VDD VSS sg13g2_mux2_1
XFILLER_170_49 VDD VSS sg13g2_decap_8
XFILLER_28_745 VDD VSS sg13g2_decap_8
XFILLER_167_1223 VDD VSS sg13g2_decap_4
X_09657_ _14250_/D _09921_/A1 _14250_/Q _09671_/S VDD VSS sg13g2_mux2_1
XFILLER_43_704 VDD VSS sg13g2_decap_8
XFILLER_41_1098 VDD VSS sg13g2_fill_1
XFILLER_27_255 VDD VSS sg13g2_decap_8
XFILLER_15_406 VDD VSS sg13g2_decap_8
XFILLER_63_14 VDD VSS sg13g2_decap_8
XFILLER_103_76 VDD VSS sg13g2_fill_2
XFILLER_55_586 VDD VSS sg13g2_decap_8
X_08608_ _08608_/Y _08608_/A _08608_/B _08641_/C VDD VSS sg13g2_nor3_1
XFILLER_70_523 VDD VSS sg13g2_decap_8
X_09588_ _14185_/D _14185_/Q _09953_/A1 _09604_/S VDD VSS sg13g2_mux2_1
XFILLER_179_14 VDD VSS sg13g2_decap_8
X_15104__2848 _15104_/RESET_B VDD VSS sg13g2_tiehi
XFILLER_24_951 VDD VSS sg13g2_decap_8
X_08539_ _08539_/Y _08378_/Y _08621_/A _08675_/A1 VDD VSS sg13g2_a21oi_1
XFILLER_93_1464 VDD VSS sg13g2_decap_8
XFILLER_54_1426 VDD VSS sg13g2_decap_8
XFILLER_169_945 VDD VSS sg13g2_fill_2
XFILLER_70_589 VDD VSS sg13g2_decap_8
XFILLER_169_956 VDD VSS sg13g2_decap_8
XFILLER_11_623 VDD VSS sg13g2_decap_8
X_11550_ _11550_/Y _12238_/S0 _13828_/Q VDD VSS sg13g2_nand2b_1
XFILLER_129_809 VDD VSS sg13g2_decap_8
XFILLER_10_133 VDD VSS sg13g2_decap_8
X_10501_ _10502_/C _14852_/Q _10508_/A _14850_/Q _14849_/Q VDD VSS sg13g2_nand4_1
XFILLER_128_319 VDD VSS sg13g2_decap_8
XFILLER_155_105 VDD VSS sg13g2_decap_8
XFILLER_7_616 VDD VSS sg13g2_decap_8
X_11481_ _14963_/D _11503_/A1 _11501_/A2 _11480_/Y VDD VSS sg13g2_a21o_1
XFILLER_52_1161 VDD VSS sg13g2_decap_8
XFILLER_17_1292 VDD VSS sg13g2_decap_8
XFILLER_137_842 VDD VSS sg13g2_decap_8
XFILLER_13_1134 VDD VSS sg13g2_decap_8
X_13220_ _13220_/Y _14794_/Q _13220_/A2 _13220_/B1 VDD VSS sg13g2_o21ai_1
XFILLER_6_126 VDD VSS sg13g2_decap_8
X_10432_ _14833_/D _14833_/Q _10434_/C _10431_/Y VDD VSS sg13g2_a21oi_1
XFILLER_183_469 VDD VSS sg13g2_decap_8
XFILLER_109_555 VDD VSS sg13g2_fill_1
XFILLER_136_341 VDD VSS sg13g2_decap_8
XFILLER_178_1330 VDD VSS sg13g2_decap_8
XFILLER_104_1284 VDD VSS sg13g2_decap_8
XFILLER_109_566 VDD VSS sg13g2_decap_8
XFILLER_12_84 VDD VSS sg13g2_decap_8
XFILLER_137_897 VDD VSS sg13g2_fill_1
XFILLER_170_119 VDD VSS sg13g2_decap_8
X_13151_ _13151_/Y _14821_/Q _13068_/B _13180_/B1 _14885_/Q _13193_/B VDD VSS sg13g2_a221oi_1
X_10363_ _10365_/A _14812_/Q _10359_/Y _14813_/Q VDD VSS sg13g2_a21o_1
XFILLER_136_396 VDD VSS sg13g2_fill_1
XFILLER_3_833 VDD VSS sg13g2_decap_8
X_12102_ _12102_/Y _12103_/A1 _14388_/Q VDD VSS sg13g2_nand2b_1
X_13082_ _13085_/A _14784_/Q _13082_/B VDD VSS sg13g2_nand2_1
X_10294_ _10295_/B _14791_/Q _14792_/Q _10294_/C VDD VSS sg13g2_nand3_1
XFILLER_2_343 VDD VSS sg13g2_decap_8
X_12033_ _12033_/Y _12033_/A1 _14514_/Q _12233_/B VDD VSS sg13g2_a21oi_1
XFILLER_78_612 VDD VSS sg13g2_decap_8
XFILLER_137_1060 VDD VSS sg13g2_fill_2
XFILLER_132_580 VDD VSS sg13g2_decap_8
X_13720__2552 _13720_/RESET_B VDD VSS sg13g2_tiehi
X_14480__1792 _14480_/RESET_B VDD VSS sg13g2_tiehi
XFILLER_144_61 VDD VSS sg13g2_decap_8
XFILLER_4_1302 VDD VSS sg13g2_decap_8
Xfanout680 _13437_/A _08724_/Y VDD VSS sg13g2_buf_1
XFILLER_59_870 VDD VSS sg13g2_decap_4
XFILLER_120_786 VDD VSS sg13g2_decap_8
XFILLER_92_103 VDD VSS sg13g2_decap_8
Xfanout691 _08522_/C _08037_/C VDD VSS sg13g2_buf_1
XFILLER_65_339 VDD VSS sg13g2_decap_8
XFILLER_59_892 VDD VSS sg13g2_decap_8
XFILLER_20_1105 VDD VSS sg13g2_decap_8
X_13984_ _13984_/Q clkload45/A _13984_/D _13984_/RESET_B VDD VSS sg13g2_dfrbpq_1
XFILLER_24_1274 VDD VSS sg13g2_decap_8
XFILLER_111_1233 VDD VSS sg13g2_decap_8
X_14064__2208 _14064_/RESET_B VDD VSS sg13g2_tiehi
XFILLER_98_1342 VDD VSS sg13g2_fill_2
XFILLER_58_391 VDD VSS sg13g2_decap_8
XFILLER_19_778 VDD VSS sg13g2_decap_8
X_12935_ _12937_/A _15061_/Q _15062_/Q VDD VSS sg13g2_nor2b_1
XFILLER_4_1379 VDD VSS sg13g2_decap_8
XFILLER_37_70 VDD VSS sg13g2_decap_8
XFILLER_185_1323 VDD VSS sg13g2_decap_8
X_14100__2172 _14100_/RESET_B VDD VSS sg13g2_tiehi
XFILLER_18_266 VDD VSS sg13g2_decap_8
X_12866_ _12866_/X _12866_/A _12867_/C _12899_/C input24/X VDD VSS sg13g2_and4_1
XFILLER_2_1092 VDD VSS sg13g2_decap_8
Xclkbuf_leaf_113_clk_i _14620_/CLK clkbuf_5_16__f_clk_i/X VDD VSS sg13g2_buf_8
X_14605_ _14605_/Q _14669_/CLK _14605_/D _14605_/RESET_B VDD VSS sg13g2_dfrbpq_1
XFILLER_15_962 VDD VSS sg13g2_decap_8
X_11817_ _11817_/Y _11819_/A1 _14412_/Q _11805_/C VDD VSS sg13g2_a21oi_1
X_14704__1568 _14704_/RESET_B VDD VSS sg13g2_tiehi
X_12797_ _12900_/B _12997_/B _12899_/A VDD VSS sg13g2_nand2b_1
XFILLER_183_1080 VDD VSS sg13g2_fill_2
XFILLER_105_1004 VDD VSS sg13g2_fill_1
XFILLER_14_483 VDD VSS sg13g2_decap_8
XFILLER_159_444 VDD VSS sg13g2_fill_1
X_14536_ _14536_/Q clkload23/A _14536_/D _14536_/RESET_B VDD VSS sg13g2_dfrbpq_1
XFILLER_109_1173 VDD VSS sg13g2_decap_8
XFILLER_175_904 VDD VSS sg13g2_decap_8
X_11748_ _11748_/Y _11741_/A _14378_/Q VDD VSS sg13g2_nand2b_1
XFILLER_159_466 VDD VSS sg13g2_fill_1
XFILLER_105_1026 VDD VSS sg13g2_fill_2
XFILLER_119_308 VDD VSS sg13g2_decap_8
XFILLER_144_1075 VDD VSS sg13g2_fill_1
XFILLER_169_91 VDD VSS sg13g2_decap_8
XFILLER_105_1059 VDD VSS sg13g2_decap_4
X_14467_ _14467_/Q clkload30/A _14467_/D _14467_/RESET_B VDD VSS sg13g2_dfrbpq_1
XFILLER_174_436 VDD VSS sg13g2_decap_8
XFILLER_175_959 VDD VSS sg13g2_fill_1
XFILLER_179_1116 VDD VSS sg13g2_decap_8
X_11679_ _11679_/X _12101_/B _11678_/X _11677_/Y VDD VSS sg13g2_a21o_1
Xclkbuf_leaf_128_clk_i _14726_/CLK clkbuf_5_4__f_clk_i/X VDD VSS sg13g2_buf_8
XFILLER_179_1138 VDD VSS sg13g2_decap_8
XFILLER_122_1362 VDD VSS sg13g2_decap_8
X_13418_ _15093_/D _13435_/B _13490_/D _13416_/Y VDD VSS sg13g2_o21ai_1
XFILLER_31_1256 VDD VSS sg13g2_fill_1
X_14398_ _14398_/Q clkload50/A _14398_/D _14398_/RESET_B VDD VSS sg13g2_dfrbpq_1
XFILLER_127_363 VDD VSS sg13g2_decap_8
XFILLER_127_374 VDD VSS sg13g2_fill_1
XFILLER_128_897 VDD VSS sg13g2_decap_8
XFILLER_142_300 VDD VSS sg13g2_fill_1
X_13349_ _15070_/D _13351_/C _13348_/Y _13345_/Y VDD VSS sg13g2_o21ai_1
XFILLER_115_536 VDD VSS sg13g2_decap_8
XFILLER_127_396 VDD VSS sg13g2_decap_8
XFILLER_143_845 VDD VSS sg13g2_decap_8
XFILLER_6_693 VDD VSS sg13g2_decap_8
XFILLER_157_1447 VDD VSS sg13g2_decap_8
XFILLER_103_709 VDD VSS sg13g2_decap_8
XFILLER_157_1469 VDD VSS sg13g2_decap_4
Xhold3208 _13619_/A _13727_/Q VDD VSS sg13g2_dlygate4sd3_1
XFILLER_130_506 VDD VSS sg13g2_decap_4
Xhold3219 _13628_/A _13736_/Q VDD VSS sg13g2_dlygate4sd3_1
XFILLER_97_910 VDD VSS sg13g2_decap_4
XFILLER_68_1190 VDD VSS sg13g2_decap_4
XFILLER_64_1032 VDD VSS sg13g2_decap_8
X_15019_ _15019_/Q _15019_/CLK _15019_/D _15019_/RESET_B VDD VSS sg13g2_dfrbpq_1
X_07910_ _07910_/Y _07910_/A _11454_/A VDD VSS sg13g2_nand2_1
X_08890_ _08890_/X _15036_/Q _14940_/Q _10716_/A VDD VSS sg13g2_mux2_1
XFILLER_116_1122 VDD VSS sg13g2_decap_4
XFILLER_9_1246 VDD VSS sg13g2_decap_8
XFILLER_68_111 VDD VSS sg13g2_decap_8
XFILLER_155_1182 VDD VSS sg13g2_decap_8
X_14310__1962 _14310_/RESET_B VDD VSS sg13g2_tiehi
XFILLER_25_1016 VDD VSS sg13g2_decap_8
XFILLER_155_1193 VDD VSS sg13g2_fill_2
XFILLER_111_753 VDD VSS sg13g2_fill_2
X_07841_ _07841_/Y _15018_/Q _08653_/B VDD VSS sg13g2_nand2_1
XFILLER_110_230 VDD VSS sg13g2_decap_8
XFILLER_116_1177 VDD VSS sg13g2_fill_2
XFILLER_151_1057 VDD VSS sg13g2_decap_8
XFILLER_84_615 VDD VSS sg13g2_decap_8
XFILLER_111_786 VDD VSS sg13g2_decap_8
XFILLER_81_1390 VDD VSS sg13g2_decap_8
X_07772_ _07797_/A _08318_/A _08318_/B VDD VSS sg13g2_or2_1
XFILLER_68_188 VDD VSS sg13g2_decap_8
XFILLER_42_1363 VDD VSS sg13g2_fill_2
XFILLER_37_520 VDD VSS sg13g2_decap_8
X_09511_ _14110_/D _10074_/A0 _14110_/Q _09539_/S VDD VSS sg13g2_mux2_1
XFILLER_64_350 VDD VSS sg13g2_decap_8
X_09442_ _14043_/D _10138_/A1 _14043_/Q _09461_/S VDD VSS sg13g2_mux2_1
XFILLER_80_832 VDD VSS sg13g2_decap_8
XFILLER_37_597 VDD VSS sg13g2_decap_8
XFILLER_164_1418 VDD VSS sg13g2_decap_8
XFILLER_164_1429 VDD VSS sg13g2_fill_2
XFILLER_80_865 VDD VSS sg13g2_decap_8
X_09373_ _13977_/D _09472_/A0 _13977_/Q _09373_/S VDD VSS sg13g2_mux2_1
XFILLER_178_731 VDD VSS sg13g2_decap_8
XFILLER_33_28 VDD VSS sg13g2_decap_8
X_08324_ _08335_/A _07796_/B _08322_/Y _08323_/Y VDD VSS sg13g2_a21o_1
XFILLER_127_1262 VDD VSS sg13g2_decap_8
XFILLER_21_932 VDD VSS sg13g2_decap_8
XFILLER_138_606 VDD VSS sg13g2_decap_8
XFILLER_149_28 VDD VSS sg13g2_decap_8
XFILLER_177_252 VDD VSS sg13g2_decap_8
XFILLER_32_291 VDD VSS sg13g2_decap_8
XFILLER_20_442 VDD VSS sg13g2_decap_8
XFILLER_123_1137 VDD VSS sg13g2_decap_8
XFILLER_21_976 VDD VSS sg13g2_decap_8
X_08255_ _08590_/B _08431_/A _08234_/Y _08329_/B _08426_/B VDD VSS sg13g2_a22oi_1
XFILLER_36_1189 VDD VSS sg13g2_decap_8
XFILLER_14_1421 VDD VSS sg13g2_decap_8
XFILLER_21_987 VDD VSS sg13g2_fill_2
XFILLER_137_138 VDD VSS sg13g2_decap_8
XFILLER_181_907 VDD VSS sg13g2_decap_8
X_08186_ _08187_/A _07876_/Y _08184_/Y _08185_/Y VDD VSS sg13g2_o21ai_1
XFILLER_180_406 VDD VSS sg13g2_decap_8
XFILLER_119_886 VDD VSS sg13g2_decap_8
XFILLER_174_981 VDD VSS sg13g2_decap_8
XFILLER_106_514 VDD VSS sg13g2_decap_8
XFILLER_134_823 VDD VSS sg13g2_decap_4
XFILLER_145_160 VDD VSS sg13g2_fill_2
Xclkbuf_leaf_92_clk_i clkload67/A clkbuf_leaf_93_clk_i/A VDD VSS sg13g2_buf_8
XFILLER_109_7 VDD VSS sg13g2_decap_8
XFILLER_165_49 VDD VSS sg13g2_decap_8
XFILLER_133_333 VDD VSS sg13g2_decap_8
XFILLER_79_409 VDD VSS sg13g2_decap_8
XFILLER_133_377 VDD VSS sg13g2_decap_8
XFILLER_58_14 VDD VSS sg13g2_fill_2
XFILLER_88_932 VDD VSS sg13g2_fill_1
XFILLER_82_1143 VDD VSS sg13g2_decap_8
XFILLER_114_580 VDD VSS sg13g2_decap_8
XFILLER_138_1391 VDD VSS sg13g2_fill_2
XFILLER_160_196 VDD VSS sg13g2_decap_8
XFILLER_99_291 VDD VSS sg13g2_decap_8
XFILLER_87_431 VDD VSS sg13g2_decap_4
XFILLER_43_1116 VDD VSS sg13g2_decap_8
XFILLER_0_869 VDD VSS sg13g2_decap_8
XFILLER_47_1296 VDD VSS sg13g2_decap_8
XFILLER_59_144 VDD VSS sg13g2_decap_8
XFILLER_75_615 VDD VSS sg13g2_decap_8
XFILLER_48_829 VDD VSS sg13g2_decap_4
XFILLER_60_1430 VDD VSS sg13g2_decap_4
X_13680__2605 _13680_/RESET_B VDD VSS sg13g2_tiehi
XFILLER_74_103 VDD VSS sg13g2_decap_8
XFILLER_21_1403 VDD VSS sg13g2_decap_8
XFILLER_28_531 VDD VSS sg13g2_decap_8
X_09709_ _14300_/D _10139_/A1 _14300_/Q _09727_/S VDD VSS sg13g2_mux2_1
X_10981_ _10981_/Y _11009_/D _10978_/Y _10980_/Y VDD VSS sg13g2_o21ai_1
XFILLER_56_873 VDD VSS sg13g2_decap_8
Xclkbuf_leaf_30_clk_i clkload29/A clkbuf_5_8__f_clk_i/X VDD VSS sg13g2_buf_8
XFILLER_15_203 VDD VSS sg13g2_decap_8
XFILLER_28_586 VDD VSS sg13g2_fill_2
X_12720_ _12720_/X _12718_/X _12719_/X _12720_/S VDD VSS sg13g2_mux2_1
XFILLER_167_1064 VDD VSS sg13g2_decap_8
XFILLER_70_353 VDD VSS sg13g2_fill_1
XFILLER_128_1048 VDD VSS sg13g2_decap_8
X_12651_ _12652_/B _13129_/B _12707_/A2 _12650_/X _12707_/B2 _12707_/C1 VDD VSS sg13g2_a221oi_1
XFILLER_12_910 VDD VSS sg13g2_decap_8
XFILLER_130_85 VDD VSS sg13g2_decap_8
XFILLER_180_1220 VDD VSS sg13g2_decap_8
XFILLER_30_206 VDD VSS sg13g2_decap_8
XFILLER_19_1343 VDD VSS sg13g2_decap_8
XFILLER_180_1231 VDD VSS sg13g2_fill_2
X_11602_ _11602_/Y _11621_/S0 _14566_/Q VDD VSS sg13g2_nand2b_1
XFILLER_54_1234 VDD VSS sg13g2_decap_8
X_12582_ _12583_/B _13064_/B _12707_/A2 _12581_/X _12707_/B2 _12707_/C1 VDD VSS sg13g2_a221oi_1
XFILLER_93_1294 VDD VSS sg13g2_fill_2
XFILLER_11_420 VDD VSS sg13g2_decap_8
XFILLER_15_1207 VDD VSS sg13g2_decap_8
Xclkbuf_leaf_45_clk_i clkload47/A clkbuf_leaf_46_clk_i/A VDD VSS sg13g2_buf_8
XFILLER_141_1215 VDD VSS sg13g2_decap_8
XFILLER_8_903 VDD VSS sg13g2_decap_8
XFILLER_106_1346 VDD VSS sg13g2_decap_4
XFILLER_135_0 VDD VSS sg13g2_decap_8
X_14321_ _14321_/Q clkload10/A _14321_/D _14321_/RESET_B VDD VSS sg13g2_dfrbpq_1
XFILLER_12_987 VDD VSS sg13g2_decap_8
X_13738__2534 _13738_/RESET_B VDD VSS sg13g2_tiehi
X_11533_ _11533_/Y _11533_/A _11533_/B _12188_/C VDD VSS sg13g2_nand3_1
XFILLER_156_425 VDD VSS sg13g2_decap_8
X_14498__1774 _14498_/RESET_B VDD VSS sg13g2_tiehi
Xwire322 wire322/X wire322/A VDD VSS sg13g2_buf_2
XFILLER_7_413 VDD VSS sg13g2_decap_8
XFILLER_141_1259 VDD VSS sg13g2_decap_8
XFILLER_184_745 VDD VSS sg13g2_decap_8
Xwire333 wire333/X wire334/X VDD VSS sg13g2_buf_2
XFILLER_11_497 VDD VSS sg13g2_decap_8
XFILLER_156_458 VDD VSS sg13g2_decap_4
XFILLER_144_609 VDD VSS sg13g2_decap_8
XFILLER_172_918 VDD VSS sg13g2_decap_8
X_14252_ _14252_/Q _14540_/CLK _14252_/D _14252_/RESET_B VDD VSS sg13g2_dfrbpq_1
X_11464_ _11465_/B _11463_/A _11463_/C _11463_/B VDD VSS sg13g2_o21ai_1
XFILLER_137_650 VDD VSS sg13g2_decap_8
XFILLER_183_266 VDD VSS sg13g2_decap_8
XFILLER_109_363 VDD VSS sg13g2_fill_2
XFILLER_104_1092 VDD VSS sg13g2_decap_8
X_13203_ _13203_/Y _13202_/A _13202_/B _13224_/A VDD VSS sg13g2_a21oi_1
X_10415_ _14827_/D _10415_/A _10667_/A _10415_/C VDD VSS sg13g2_nor3_1
XFILLER_99_65 VDD VSS sg13g2_decap_8
XFILLER_178_1160 VDD VSS sg13g2_fill_1
X_14183_ _14183_/Q clkload13/A _14183_/D _14183_/RESET_B VDD VSS sg13g2_dfrbpq_1
X_11395_ _11395_/Y _11395_/A _11422_/B VDD VSS sg13g2_nand2_1
XFILLER_180_940 VDD VSS sg13g2_decap_8
XFILLER_48_1005 VDD VSS sg13g2_decap_8
XFILLER_124_333 VDD VSS sg13g2_fill_2
XFILLER_180_951 VDD VSS sg13g2_fill_2
XFILLER_136_193 VDD VSS sg13g2_decap_8
XFILLER_174_1024 VDD VSS sg13g2_fill_2
XFILLER_3_630 VDD VSS sg13g2_decap_8
XFILLER_180_962 VDD VSS sg13g2_fill_2
X_13134_ _13134_/Y _13146_/B _13146_/C _13160_/B VDD VSS sg13g2_nand3_1
X_10346_ _10352_/C wire220/A _10397_/B VDD VSS sg13g2_nor2_1
X_14118__2154 _14118_/RESET_B VDD VSS sg13g2_tiehi
XFILLER_112_506 VDD VSS sg13g2_decap_4
XFILLER_124_366 VDD VSS sg13g2_fill_2
XFILLER_180_984 VDD VSS sg13g2_decap_8
XFILLER_112_517 VDD VSS sg13g2_decap_8
XFILLER_174_1057 VDD VSS sg13g2_decap_4
XFILLER_2_140 VDD VSS sg13g2_decap_8
XFILLER_97_217 VDD VSS sg13g2_decap_8
X_13065_ _13067_/C _13066_/A _13066_/C _13172_/A VDD VSS sg13g2_o21ai_1
X_10277_ _10305_/B _14786_/Q _14787_/Q VDD VSS sg13g2_and2_1
XFILLER_151_196 VDD VSS sg13g2_fill_1
XFILLER_78_420 VDD VSS sg13g2_decap_8
XFILLER_117_1442 VDD VSS sg13g2_fill_1
XFILLER_78_431 VDD VSS sg13g2_decap_4
Xfanout1420 _11896_/A fanout1429/X VDD VSS sg13g2_buf_1
X_12016_ _12018_/A _12232_/S _13906_/Q VDD VSS sg13g2_nand2b_1
Xfanout1431 _12306_/A _12328_/A1 VDD VSS sg13g2_buf_1
XFILLER_78_453 VDD VSS sg13g2_decap_8
XFILLER_24_7 VDD VSS sg13g2_decap_8
Xfanout1442 _11531_/A fanout1445/X VDD VSS sg13g2_buf_1
XFILLER_39_829 VDD VSS sg13g2_decap_8
XFILLER_26_1369 VDD VSS sg13g2_decap_8
XFILLER_120_561 VDD VSS sg13g2_decap_8
Xfanout1453 _12284_/S0 _12288_/S0 VDD VSS sg13g2_buf_1
Xfanout1464 _12215_/S0 _13657_/Q VDD VSS sg13g2_buf_1
XFILLER_93_412 VDD VSS sg13g2_decap_8
XFILLER_113_1339 VDD VSS sg13g2_decap_8
Xfanout1475 _13328_/A fanout1476/X VDD VSS sg13g2_buf_1
Xfanout1486 _10423_/C _10611_/B VDD VSS sg13g2_buf_1
XFILLER_94_957 VDD VSS sg13g2_fill_1
XFILLER_65_125 VDD VSS sg13g2_fill_2
XFILLER_48_91 VDD VSS sg13g2_decap_4
XFILLER_171_70 VDD VSS sg13g2_decap_8
Xfanout1497 _10213_/A _12765_/A1 VDD VSS sg13g2_buf_1
XFILLER_93_445 VDD VSS sg13g2_decap_8
XFILLER_0_21 VDD VSS sg13g2_decap_8
X_13986__2286 _13986_/RESET_B VDD VSS sg13g2_tiehi
XFILLER_81_607 VDD VSS sg13g2_decap_8
XFILLER_47_862 VDD VSS sg13g2_decap_8
X_13967_ _13967_/Q _14607_/CLK _13967_/D _13967_/RESET_B VDD VSS sg13g2_dfrbpq_1
XFILLER_4_1176 VDD VSS sg13g2_decap_8
XFILLER_34_501 VDD VSS sg13g2_decap_8
XFILLER_185_1131 VDD VSS sg13g2_decap_8
XFILLER_46_372 VDD VSS sg13g2_decap_8
X_12918_ _12918_/Y _14774_/Q _12918_/A2 _13275_/B1 VDD VSS sg13g2_o21ai_1
XFILLER_111_1096 VDD VSS sg13g2_fill_1
XFILLER_94_1036 VDD VSS sg13g2_decap_8
XFILLER_59_1156 VDD VSS sg13g2_decap_8
XFILLER_0_98 VDD VSS sg13g2_decap_8
X_13898_ _13898_/Q clkload27/A _13898_/D _13898_/RESET_B VDD VSS sg13g2_dfrbpq_1
XFILLER_181_1006 VDD VSS sg13g2_fill_2
XFILLER_146_1126 VDD VSS sg13g2_decap_4
XFILLER_185_1175 VDD VSS sg13g2_fill_2
XFILLER_22_707 VDD VSS sg13g2_decap_8
XFILLER_179_539 VDD VSS sg13g2_decap_8
XFILLER_64_90 VDD VSS sg13g2_decap_8
X_12849_ _12849_/Y _12848_/X _12846_/Y _13293_/B VDD VSS sg13g2_o21ai_1
XFILLER_62_887 VDD VSS sg13g2_decap_8
XFILLER_34_578 VDD VSS sg13g2_decap_8
XFILLER_146_1159 VDD VSS sg13g2_fill_2
XFILLER_15_770 VDD VSS sg13g2_decap_8
XFILLER_37_1432 VDD VSS sg13g2_decap_8
XFILLER_21_217 VDD VSS sg13g2_decap_8
XFILLER_14_280 VDD VSS sg13g2_decap_8
XFILLER_37_1465 VDD VSS sg13g2_decap_8
XFILLER_9_63 VDD VSS sg13g2_decap_8
XFILLER_148_937 VDD VSS sg13g2_decap_8
XFILLER_119_105 VDD VSS sg13g2_decap_8
XFILLER_148_948 VDD VSS sg13g2_fill_1
X_14519_ _14519_/Q clkload42/A _14519_/D _14519_/RESET_B VDD VSS sg13g2_dfrbpq_1
XFILLER_175_745 VDD VSS sg13g2_decap_4
X_14328__1944 _14328_/RESET_B VDD VSS sg13g2_tiehi
XFILLER_30_784 VDD VSS sg13g2_decap_8
X_08040_ _08040_/Y _08246_/A1 _08016_/Y _08021_/Y _08032_/Y _08039_/Y VDD VSS sg13g2_a221oi_1
XFILLER_31_1031 VDD VSS sg13g2_decap_8
XFILLER_70_1091 VDD VSS sg13g2_decap_8
XFILLER_174_266 VDD VSS sg13g2_decap_8
XFILLER_116_823 VDD VSS sg13g2_fill_1
XFILLER_7_980 VDD VSS sg13g2_decap_8
XFILLER_162_439 VDD VSS sg13g2_decap_8
XFILLER_115_322 VDD VSS sg13g2_decap_8
XFILLER_50_0 VDD VSS sg13g2_decap_8
XFILLER_143_642 VDD VSS sg13g2_decap_8
XFILLER_157_1233 VDD VSS sg13g2_decap_8
XFILLER_6_490 VDD VSS sg13g2_decap_8
XFILLER_157_1244 VDD VSS sg13g2_decap_8
XFILLER_171_973 VDD VSS sg13g2_fill_1
XFILLER_142_141 VDD VSS sg13g2_decap_8
X_09991_ _14574_/D _10090_/A0 _14574_/Q _09997_/S VDD VSS sg13g2_mux2_1
XFILLER_170_461 VDD VSS sg13g2_fill_2
XFILLER_88_217 VDD VSS sg13g2_decap_8
XFILLER_115_388 VDD VSS sg13g2_decap_8
XFILLER_130_314 VDD VSS sg13g2_decap_8
X_08942_ _08942_/Y _10781_/C _09016_/C _15050_/Q VDD VSS sg13g2_nand3_1
XFILLER_170_1411 VDD VSS sg13g2_decap_8
XFILLER_9_1043 VDD VSS sg13g2_decap_8
X_15083__2920 _15083_/RESET_B VDD VSS sg13g2_tiehi
X_08873_ _08873_/Y _10788_/S _14936_/Q VDD VSS sg13g2_nor2b_1
XFILLER_44_1469 VDD VSS sg13g2_decap_8
XFILLER_28_28 VDD VSS sg13g2_decap_8
XFILLER_56_103 VDD VSS sg13g2_decap_8
X_07824_ _07829_/A _08553_/A _07954_/B _08527_/A _08527_/B VDD VSS sg13g2_nor4_1
XFILLER_96_283 VDD VSS sg13g2_fill_1
XFILLER_111_594 VDD VSS sg13g2_decap_8
XFILLER_72_607 VDD VSS sg13g2_fill_2
X_13816__2456 _13816_/RESET_B VDD VSS sg13g2_tiehi
XFILLER_84_467 VDD VSS sg13g2_fill_1
X_14576__1696 _14576_/RESET_B VDD VSS sg13g2_tiehi
X_07755_ _07755_/Y _08831_/B _11458_/A _13320_/C VDD VSS sg13g2_o21ai_1
XFILLER_77_1201 VDD VSS sg13g2_fill_2
XFILLER_37_350 VDD VSS sg13g2_decap_8
XFILLER_38_884 VDD VSS sg13g2_decap_4
XFILLER_71_117 VDD VSS sg13g2_decap_8
XFILLER_129_1302 VDD VSS sg13g2_decap_8
XFILLER_77_1234 VDD VSS sg13g2_decap_8
XFILLER_53_832 VDD VSS sg13g2_decap_8
X_07686_ _07687_/C _13304_/B _07684_/B _07684_/Y VDD VSS sg13g2_o21ai_1
XFILLER_164_1226 VDD VSS sg13g2_decap_8
XFILLER_80_651 VDD VSS sg13g2_decap_8
XFILLER_73_1109 VDD VSS sg13g2_decap_8
XFILLER_44_49 VDD VSS sg13g2_decap_8
XFILLER_13_707 VDD VSS sg13g2_decap_8
X_09425_ _14027_/D _09724_/A0 _14027_/Q _09432_/S VDD VSS sg13g2_mux2_1
XFILLER_53_876 VDD VSS sg13g2_fill_2
XFILLER_52_353 VDD VSS sg13g2_decap_8
XFILLER_52_364 VDD VSS sg13g2_fill_1
XFILLER_12_217 VDD VSS sg13g2_decap_8
X_09356_ _13960_/D _09620_/A0 _13960_/Q _09365_/S VDD VSS sg13g2_mux2_1
XFILLER_51_1407 VDD VSS sg13g2_decap_8
XFILLER_90_1467 VDD VSS sg13g2_decap_8
XFILLER_138_414 VDD VSS sg13g2_fill_2
XFILLER_166_723 VDD VSS sg13g2_decap_8
X_08307_ _08312_/A _08303_/Y _08305_/Y _08306_/Y VDD VSS sg13g2_o21ai_1
XFILLER_90_1478 VDD VSS sg13g2_fill_1
XFILLER_166_734 VDD VSS sg13g2_fill_2
X_09287_ _13895_/D _13895_/Q _09918_/A1 _09305_/S VDD VSS sg13g2_mux2_1
XFILLER_139_959 VDD VSS sg13g2_fill_1
XFILLER_21_795 VDD VSS sg13g2_fill_1
XFILLER_165_244 VDD VSS sg13g2_decap_8
X_08238_ _08238_/Y _08265_/A _08238_/B VDD VSS sg13g2_nor2_1
XFILLER_119_650 VDD VSS sg13g2_fill_1
XFILLER_20_294 VDD VSS sg13g2_decap_8
XFILLER_5_917 VDD VSS sg13g2_decap_8
XFILLER_101_1221 VDD VSS sg13g2_decap_8
XFILLER_119_672 VDD VSS sg13g2_fill_2
XFILLER_180_203 VDD VSS sg13g2_decap_8
XFILLER_109_31 VDD VSS sg13g2_decap_8
XFILLER_181_737 VDD VSS sg13g2_fill_1
XFILLER_101_1243 VDD VSS sg13g2_decap_8
XFILLER_119_694 VDD VSS sg13g2_decap_4
XFILLER_14_1295 VDD VSS sg13g2_decap_8
X_08169_ _08169_/Y _08194_/B _08052_/Y _08688_/A VDD VSS sg13g2_o21ai_1
XFILLER_4_427 VDD VSS sg13g2_decap_8
XFILLER_101_1254 VDD VSS sg13g2_fill_2
XFILLER_10_1148 VDD VSS sg13g2_decap_8
X_10200_ _14757_/D _15181_/D _14757_/Q _13654_/S VDD VSS sg13g2_mux2_1
XFILLER_134_653 VDD VSS sg13g2_fill_1
XFILLER_101_1287 VDD VSS sg13g2_decap_8
XFILLER_107_878 VDD VSS sg13g2_decap_8
XFILLER_122_804 VDD VSS sg13g2_decap_8
X_11180_ _11190_/A _11180_/A _11181_/A _11180_/C VDD VSS sg13g2_nand3_1
XFILLER_84_1227 VDD VSS sg13g2_decap_8
XFILLER_101_1298 VDD VSS sg13g2_fill_2
XFILLER_84_1238 VDD VSS sg13g2_fill_1
XFILLER_122_815 VDD VSS sg13g2_fill_2
XFILLER_121_303 VDD VSS sg13g2_decap_8
XFILLER_79_217 VDD VSS sg13g2_decap_8
XFILLER_122_837 VDD VSS sg13g2_decap_8
X_10131_ _14709_/D _10164_/A1 _14709_/Q _10135_/S VDD VSS sg13g2_mux2_1
XFILLER_171_1219 VDD VSS sg13g2_fill_1
XFILLER_161_494 VDD VSS sg13g2_decap_8
XFILLER_0_644 VDD VSS sg13g2_decap_8
X_10062_ _14643_/D _10095_/A0 _14643_/Q _10068_/S VDD VSS sg13g2_mux2_1
XFILLER_102_561 VDD VSS sg13g2_decap_8
X_14870_ _14870_/Q clkload67/A _14870_/D _14870_/RESET_B VDD VSS sg13g2_dfrbpq_1
XFILLER_21_1200 VDD VSS sg13g2_decap_8
XFILLER_91_905 VDD VSS sg13g2_fill_2
XFILLER_29_851 VDD VSS sg13g2_decap_4
X_13821_ _13821_/Q clkload58/A _13821_/D _13821_/RESET_B VDD VSS sg13g2_dfrbpq_1
XFILLER_5_1463 VDD VSS sg13g2_decap_8
XFILLER_1_1316 VDD VSS sg13g2_decap_8
X_14406__1866 _14406_/RESET_B VDD VSS sg13g2_tiehi
XFILLER_91_938 VDD VSS sg13g2_decap_8
XFILLER_141_40 VDD VSS sg13g2_decap_8
XFILLER_141_51 VDD VSS sg13g2_fill_2
XFILLER_95_1323 VDD VSS sg13g2_decap_8
XFILLER_21_1277 VDD VSS sg13g2_decap_8
XFILLER_95_1334 VDD VSS sg13g2_fill_2
X_13752_ _13752_/Q _14518_/CLK _13752_/D _13752_/RESET_B VDD VSS sg13g2_dfrbpq_1
XFILLER_186_1462 VDD VSS sg13g2_decap_4
X_10964_ _10964_/Y _11004_/B _10964_/B VDD VSS sg13g2_xnor2_1
XFILLER_147_1424 VDD VSS sg13g2_fill_1
XFILLER_43_331 VDD VSS sg13g2_decap_8
XFILLER_16_567 VDD VSS sg13g2_decap_8
X_12703_ _12703_/X _13748_/Q _14100_/Q _14452_/Q _14548_/Q _12754_/S0 _12754_/S1 VDD
+ VSS sg13g2_mux4_1
XFILLER_95_1378 VDD VSS sg13g2_fill_2
X_13683_ _13683_/Q clkload73/A _13683_/D _13683_/RESET_B VDD VSS sg13g2_dfrbpq_1
X_10895_ _10895_/Y _10948_/A _10893_/X _11027_/B1 VDD VSS sg13g2_o21ai_1
XFILLER_182_1359 VDD VSS sg13g2_decap_8
XFILLER_19_1140 VDD VSS sg13g2_decap_8
XFILLER_54_1020 VDD VSS sg13g2_fill_1
X_12634_ _12634_/X _12631_/X _12630_/X _12627_/X _12626_/X wire853/X _12678_/S VDD
+ VSS sg13g2_mux4_1
XFILLER_15_1004 VDD VSS sg13g2_decap_8
X_14621__1651 _14621_/RESET_B VDD VSS sg13g2_tiehi
XFILLER_8_700 VDD VSS sg13g2_decap_8
XFILLER_34_93 VDD VSS sg13g2_decap_8
XFILLER_157_723 VDD VSS sg13g2_decap_8
XFILLER_141_1023 VDD VSS sg13g2_decap_8
X_12565_ _12565_/X _12564_/X _12563_/X _12560_/X _12559_/X _12663_/S1 _12636_/S VDD
+ VSS sg13g2_mux4_1
XFILLER_12_784 VDD VSS sg13g2_decap_8
XFILLER_184_531 VDD VSS sg13g2_fill_1
XFILLER_7_210 VDD VSS sg13g2_decap_8
XFILLER_129_447 VDD VSS sg13g2_decap_8
X_14304_ _14304_/Q _14720_/CLK _14304_/D _14304_/RESET_B VDD VSS sg13g2_dfrbpq_1
XFILLER_106_1187 VDD VSS sg13g2_fill_1
XFILLER_184_553 VDD VSS sg13g2_decap_8
X_11516_ _11516_/Y _11516_/A VDD VSS sg13g2_inv_1
XFILLER_32_1340 VDD VSS sg13g2_decap_8
XFILLER_106_1198 VDD VSS sg13g2_decap_8
XFILLER_11_294 VDD VSS sg13g2_decap_8
XFILLER_156_266 VDD VSS sg13g2_decap_8
X_12496_ _12496_/X _12494_/X _12493_/X _12490_/X _12489_/X wire853/X _12663_/S0 VDD
+ VSS sg13g2_mux4_1
XFILLER_8_777 VDD VSS sg13g2_decap_8
XFILLER_138_981 VDD VSS sg13g2_decap_4
XFILLER_156_277 VDD VSS sg13g2_fill_2
XFILLER_32_1373 VDD VSS sg13g2_fill_1
XFILLER_184_597 VDD VSS sg13g2_decap_8
XFILLER_171_214 VDD VSS sg13g2_decap_8
X_14235_ _14235_/Q clkload58/A _14235_/D _14235_/RESET_B VDD VSS sg13g2_dfrbpq_1
X_11447_ _11448_/A _12188_/C _11444_/X _11446_/Y VDD VSS sg13g2_o21ai_1
XFILLER_7_287 VDD VSS sg13g2_decap_8
XFILLER_172_759 VDD VSS sg13g2_decap_8
XFILLER_166_70 VDD VSS sg13g2_decap_8
XFILLER_153_973 VDD VSS sg13g2_fill_1
X_14166_ _14166_/Q clkload69/A _14166_/D _14166_/RESET_B VDD VSS sg13g2_dfrbpq_1
X_11378_ _11378_/X _11369_/Y _11377_/Y _11378_/S VDD VSS sg13g2_mux2_1
XFILLER_154_1406 VDD VSS sg13g2_decap_4
XFILLER_180_770 VDD VSS sg13g2_decap_8
XFILLER_67_1469 VDD VSS sg13g2_fill_2
X_13117_ _13120_/A _13078_/A _13113_/X _13171_/A VDD VSS sg13g2_a21oi_1
X_10329_ _10331_/A _10414_/B _10345_/C _14803_/Q VDD VSS sg13g2_a21o_1
XFILLER_4_994 VDD VSS sg13g2_decap_8
XFILLER_154_1439 VDD VSS sg13g2_decap_8
X_14097_ _14097_/Q clkload7/A _14097_/D _14097_/RESET_B VDD VSS sg13g2_dfrbpq_1
XFILLER_98_559 VDD VSS sg13g2_decap_8
XFILLER_112_347 VDD VSS sg13g2_decap_4
XFILLER_79_762 VDD VSS sg13g2_decap_8
XFILLER_112_369 VDD VSS sg13g2_decap_8
X_13048_ _13048_/X _13048_/A _13048_/B VDD VSS sg13g2_and2_1
XFILLER_79_773 VDD VSS sg13g2_fill_2
XFILLER_65_1193 VDD VSS sg13g2_decap_8
XFILLER_113_1103 VDD VSS sg13g2_decap_8
XFILLER_78_261 VDD VSS sg13g2_fill_1
XFILLER_182_91 VDD VSS sg13g2_decap_8
Xfanout1250 _13142_/A _14916_/Q VDD VSS sg13g2_buf_1
XFILLER_26_1166 VDD VSS sg13g2_decap_8
Xfanout1261 _10647_/C _14869_/Q VDD VSS sg13g2_buf_1
XFILLER_39_637 VDD VSS sg13g2_decap_8
XFILLER_113_1136 VDD VSS sg13g2_fill_1
XFILLER_67_957 VDD VSS sg13g2_decap_8
XFILLER_93_220 VDD VSS sg13g2_decap_8
XFILLER_38_125 VDD VSS sg13g2_fill_2
XFILLER_66_445 VDD VSS sg13g2_fill_1
XFILLER_19_350 VDD VSS sg13g2_decap_8
XFILLER_82_938 VDD VSS sg13g2_fill_1
X_14999_ _14999_/Q _15019_/CLK _14999_/D _14999_/RESET_B VDD VSS sg13g2_dfrbpq_1
XFILLER_66_489 VDD VSS sg13g2_decap_8
XFILLER_53_106 VDD VSS sg13g2_fill_2
XFILLER_47_670 VDD VSS sg13g2_fill_1
XFILLER_47_681 VDD VSS sg13g2_decap_8
XFILLER_35_821 VDD VSS sg13g2_decap_4
XFILLER_90_960 VDD VSS sg13g2_fill_2
XFILLER_74_1429 VDD VSS sg13g2_decap_8
XFILLER_90_982 VDD VSS sg13g2_decap_8
XFILLER_179_336 VDD VSS sg13g2_decap_8
XFILLER_22_526 VDD VSS sg13g2_decap_8
X_09210_ _13821_/D _09908_/A1 _13821_/Q _09227_/S VDD VSS sg13g2_mux2_1
XFILLER_98_0 VDD VSS sg13g2_decap_8
XFILLER_34_397 VDD VSS sg13g2_decap_8
XFILLER_124_1221 VDD VSS sg13g2_decap_8
X_09141_ _09145_/A _09141_/A _10781_/A _10781_/B VDD VSS sg13g2_nand3_1
XFILLER_136_907 VDD VSS sg13g2_fill_2
X_09072_ _09072_/Y _15236_/Q _09072_/B VDD VSS sg13g2_nand2b_1
XFILLER_124_1287 VDD VSS sg13g2_decap_8
XFILLER_175_575 VDD VSS sg13g2_decap_8
X_08023_ _08023_/Y _08023_/A _08063_/B VDD VSS sg13g2_nand2_1
XFILLER_50_1473 VDD VSS sg13g2_decap_4
XFILLER_11_1435 VDD VSS sg13g2_decap_8
XFILLER_135_439 VDD VSS sg13g2_decap_8
XFILLER_144_940 VDD VSS sg13g2_decap_4
XFILLER_144_973 VDD VSS sg13g2_decap_8
XFILLER_162_269 VDD VSS sg13g2_fill_2
XFILLER_115_152 VDD VSS sg13g2_decap_8
XFILLER_116_686 VDD VSS sg13g2_decap_8
XFILLER_157_1063 VDD VSS sg13g2_decap_4
XFILLER_171_792 VDD VSS sg13g2_fill_1
XFILLER_89_548 VDD VSS sg13g2_decap_4
X_09974_ _14557_/D _10140_/A1 _14557_/Q _09997_/S VDD VSS sg13g2_mux2_1
XFILLER_115_196 VDD VSS sg13g2_decap_8
X_08925_ _08925_/X _08924_/X _12009_/A _08931_/S VDD VSS sg13g2_mux2_1
XFILLER_44_1233 VDD VSS sg13g2_fill_1
XFILLER_39_49 VDD VSS sg13g2_decap_8
XFILLER_162_28 VDD VSS sg13g2_decap_8
XFILLER_170_1241 VDD VSS sg13g2_decap_8
XFILLER_83_1293 VDD VSS sg13g2_decap_8
XFILLER_112_870 VDD VSS sg13g2_fill_2
XFILLER_97_570 VDD VSS sg13g2_decap_8
XFILLER_112_892 VDD VSS sg13g2_fill_1
X_14663__1609 _14663_/RESET_B VDD VSS sg13g2_tiehi
XFILLER_29_114 VDD VSS sg13g2_decap_8
X_08856_ _08856_/X _15027_/Q _14931_/Q _10675_/A VDD VSS sg13g2_mux2_1
X_07807_ _07828_/C _07950_/A _07949_/B _07807_/C _08476_/A VDD VSS sg13g2_nand4_1
X_08787_ _08787_/Y _13681_/Q _08801_/B VDD VSS sg13g2_nor2_1
XFILLER_176_7 VDD VSS sg13g2_decap_8
XFILLER_38_681 VDD VSS sg13g2_decap_8
X_07738_ _07738_/Y _07989_/B _13300_/C _07754_/B VDD VSS sg13g2_nand3_1
XFILLER_26_843 VDD VSS sg13g2_decap_8
XFILLER_41_802 VDD VSS sg13g2_fill_2
XFILLER_25_353 VDD VSS sg13g2_decap_8
XFILLER_13_504 VDD VSS sg13g2_decap_8
X_07669_ _10172_/C _13508_/B _10187_/S _10171_/D VDD VSS sg13g2_o21ai_1
XFILLER_77_1086 VDD VSS sg13g2_decap_8
XFILLER_77_1097 VDD VSS sg13g2_fill_1
XFILLER_71_14 VDD VSS sg13g2_decap_8
XFILLER_52_172 VDD VSS sg13g2_decap_8
X_15031__2649 _15031_/RESET_B VDD VSS sg13g2_tiehi
X_09408_ _09408_/Y _10037_/B _09441_/D VDD VSS sg13g2_nand2_1
XFILLER_80_492 VDD VSS sg13g2_fill_2
X_10680_ _10844_/B _08980_/X _08848_/A _08844_/Y VDD VSS sg13g2_a21o_1
XFILLER_41_857 VDD VSS sg13g2_decap_8
XFILLER_164_1078 VDD VSS sg13g2_decap_4
XFILLER_90_1231 VDD VSS sg13g2_decap_8
XFILLER_90_1253 VDD VSS sg13g2_decap_8
XFILLER_166_520 VDD VSS sg13g2_decap_8
XFILLER_16_1335 VDD VSS sg13g2_decap_8
X_09339_ _13946_/D _09739_/A0 _13946_/Q _09339_/S VDD VSS sg13g2_mux2_1
XFILLER_139_745 VDD VSS sg13g2_decap_8
XFILLER_139_767 VDD VSS sg13g2_fill_2
XFILLER_138_255 VDD VSS sg13g2_decap_4
X_12350_ _12350_/X _14683_/Q _14715_/Q _13755_/Q _13787_/Q _12366_/S0 _12366_/S1 VDD
+ VSS sg13g2_mux4_1
XFILLER_154_715 VDD VSS sg13g2_decap_8
XFILLER_5_714 VDD VSS sg13g2_decap_8
X_11301_ _11301_/Y _11300_/X _11900_/B _11299_/Y VDD VSS sg13g2_a21oi_1
X_12281_ _12281_/X _14585_/Q _14617_/Q _14649_/Q _14681_/Q _12286_/S0 _12286_/S1 VDD
+ VSS sg13g2_mux4_1
XFILLER_14_1092 VDD VSS sg13g2_decap_8
XFILLER_4_224 VDD VSS sg13g2_decap_8
XFILLER_135_962 VDD VSS sg13g2_decap_8
XFILLER_181_567 VDD VSS sg13g2_decap_8
X_14020_ _14020_/Q _14503_/CLK _14020_/D _14020_/RESET_B VDD VSS sg13g2_dfrbpq_1
X_11232_ _11232_/Y _15115_/Q _15116_/Q VDD VSS sg13g2_nor2_1
XFILLER_101_1073 VDD VSS sg13g2_fill_1
XFILLER_106_130 VDD VSS sg13g2_decap_8
XFILLER_101_1084 VDD VSS sg13g2_decap_8
XFILLER_122_601 VDD VSS sg13g2_decap_4
XFILLER_175_1141 VDD VSS sg13g2_decap_8
XFILLER_107_686 VDD VSS sg13g2_decap_8
XFILLER_150_921 VDD VSS sg13g2_decap_8
XFILLER_20_84 VDD VSS sg13g2_decap_8
XFILLER_136_1125 VDD VSS sg13g2_fill_1
X_11163_ _11180_/A _11163_/A _11164_/C VDD VSS sg13g2_nor2_1
XFILLER_1_931 VDD VSS sg13g2_decap_8
XFILLER_49_1188 VDD VSS sg13g2_fill_2
XFILLER_171_1027 VDD VSS sg13g2_decap_8
XFILLER_175_1196 VDD VSS sg13g2_decap_8
XFILLER_136_1158 VDD VSS sg13g2_decap_4
X_10114_ _14692_/D _10147_/A1 _14692_/Q _10134_/S VDD VSS sg13g2_mux2_1
XFILLER_0_441 VDD VSS sg13g2_decap_8
XFILLER_121_155 VDD VSS sg13g2_decap_8
X_11094_ _11095_/B _11118_/C _11094_/B VDD VSS sg13g2_nor2_1
XFILLER_150_998 VDD VSS sg13g2_decap_8
XFILLER_96_88 VDD VSS sg13g2_decap_8
X_14922_ _14922_/Q clkload70/A _14922_/D _14922_/RESET_B VDD VSS sg13g2_dfrbpq_1
X_10045_ _14626_/D _10045_/A0 _14626_/Q _10064_/S VDD VSS sg13g2_mux2_1
X_14639__1633 _14639_/RESET_B VDD VSS sg13g2_tiehi
XFILLER_114_1467 VDD VSS sg13g2_fill_2
XFILLER_110_1309 VDD VSS sg13g2_decap_8
X_14853_ _14853_/Q _14876_/CLK _14853_/D _14853_/RESET_B VDD VSS sg13g2_dfrbpq_1
XFILLER_5_1260 VDD VSS sg13g2_decap_8
XFILLER_1_1113 VDD VSS sg13g2_decap_8
XFILLER_21_1041 VDD VSS sg13g2_decap_8
XFILLER_75_286 VDD VSS sg13g2_fill_2
X_13804_ _13804_/Q clkload26/A _13804_/D _13804_/RESET_B VDD VSS sg13g2_dfrbpq_1
XFILLER_91_746 VDD VSS sg13g2_decap_8
XFILLER_112_1191 VDD VSS sg13g2_decap_8
X_14784_ _14784_/Q clkload62/A _14784_/D _14784_/RESET_B VDD VSS sg13g2_dfrbpq_1
XFILLER_147_1210 VDD VSS sg13g2_decap_8
X_11996_ _11996_/X _14577_/Q _14609_/Q _14641_/Q _14673_/Q _11996_/S0 _11996_/S1 VDD
+ VSS sg13g2_mux4_1
XFILLER_95_1142 VDD VSS sg13g2_decap_8
XFILLER_72_960 VDD VSS sg13g2_fill_1
XFILLER_32_802 VDD VSS sg13g2_decap_4
X_13735_ _13735_/Q _14727_/CLK _13735_/D _13735_/RESET_B VDD VSS sg13g2_dfrbpq_1
XFILLER_56_1115 VDD VSS sg13g2_decap_8
XFILLER_16_364 VDD VSS sg13g2_decap_8
XFILLER_182_1123 VDD VSS sg13g2_decap_4
X_10947_ _11007_/B _10932_/B _10946_/Y _10945_/Y _10944_/Y VDD VSS sg13g2_a22oi_1
XFILLER_43_161 VDD VSS sg13g2_fill_1
XFILLER_108_1216 VDD VSS sg13g2_decap_4
XFILLER_32_835 VDD VSS sg13g2_decap_8
XFILLER_147_1287 VDD VSS sg13g2_decap_4
X_13666_ _13666_/Q _15212_/CLK _13666_/D _13666_/RESET_B VDD VSS sg13g2_dfrbpq_1
XFILLER_91_7 VDD VSS sg13g2_decap_8
XFILLER_182_1178 VDD VSS sg13g2_fill_1
X_15007__2673 _15007_/RESET_B VDD VSS sg13g2_tiehi
X_10878_ _10878_/Y _10923_/D _10878_/B VDD VSS sg13g2_nand2_1
XFILLER_31_345 VDD VSS sg13g2_fill_2
XFILLER_73_1473 VDD VSS sg13g2_fill_2
X_12617_ _12617_/X _14574_/Q _14606_/Q _14638_/Q _14670_/Q _12618_/S0 _12618_/S1 VDD
+ VSS sg13g2_mux4_1
XFILLER_169_380 VDD VSS sg13g2_fill_2
XFILLER_129_222 VDD VSS sg13g2_fill_2
XFILLER_185_840 VDD VSS sg13g2_fill_1
X_13597_ _13597_/Y _12798_/Y _13596_/Y _08830_/X VDD VSS sg13g2_o21ai_1
XFILLER_121_1416 VDD VSS sg13g2_decap_8
XFILLER_12_581 VDD VSS sg13g2_decap_8
XFILLER_118_918 VDD VSS sg13g2_decap_8
X_12548_ _12548_/X _13737_/Q _14089_/Q _14441_/Q _14537_/Q _12550_/S0 _12550_/S1 VDD
+ VSS sg13g2_mux4_1
XFILLER_8_574 VDD VSS sg13g2_decap_8
XFILLER_145_737 VDD VSS sg13g2_fill_1
XFILLER_177_91 VDD VSS sg13g2_decap_8
XFILLER_32_1170 VDD VSS sg13g2_decap_8
XANTENNA_2 _09037_/X VDD VSS sg13g2_antennanp
X_12479_ _12479_/X _13828_/Q _13860_/Q _13892_/Q _13924_/Q _12759_/S0 _12759_/S1 VDD
+ VSS sg13g2_mux4_1
XFILLER_6_42 VDD VSS sg13g2_decap_8
XFILLER_144_258 VDD VSS sg13g2_decap_8
X_14218_ _14218_/Q clkload17/A _14218_/D _14218_/RESET_B VDD VSS sg13g2_dfrbpq_1
XFILLER_125_461 VDD VSS sg13g2_fill_1
X_15198_ _15198_/Q clkload81/A _15198_/D _15198_/RESET_B VDD VSS sg13g2_dfrbpq_1
XFILLER_154_1225 VDD VSS sg13g2_decap_4
X_14149_ _14149_/Q clkload8/A _14149_/D _14149_/RESET_B VDD VSS sg13g2_dfrbpq_1
XFILLER_4_791 VDD VSS sg13g2_decap_8
XFILLER_28_1228 VDD VSS sg13g2_decap_8
Xfanout509 _09473_/S _09441_/Y VDD VSS sg13g2_buf_1
XFILLER_63_1119 VDD VSS sg13g2_decap_8
XFILLER_119_1389 VDD VSS sg13g2_fill_1
XFILLER_86_518 VDD VSS sg13g2_decap_8
XFILLER_140_475 VDD VSS sg13g2_decap_8
X_14278__1994 _14278_/RESET_B VDD VSS sg13g2_tiehi
XFILLER_80_1433 VDD VSS sg13g2_fill_2
XFILLER_79_570 VDD VSS sg13g2_decap_8
X_08710_ _13660_/D _15187_/D _15118_/Q _13652_/S VDD VSS sg13g2_mux2_1
XFILLER_41_1417 VDD VSS sg13g2_decap_4
X_09690_ _14282_/D _09921_/A1 _14282_/Q _09704_/S VDD VSS sg13g2_mux2_1
XFILLER_80_1477 VDD VSS sg13g2_fill_2
XFILLER_94_540 VDD VSS sg13g2_decap_8
XFILLER_6_1057 VDD VSS sg13g2_decap_8
XFILLER_13_0 VDD VSS sg13g2_decap_8
Xfanout1080 _10793_/B _09016_/C VDD VSS sg13g2_buf_1
XFILLER_82_702 VDD VSS sg13g2_decap_8
XFILLER_67_776 VDD VSS sg13g2_decap_8
Xfanout1091 _08692_/C _15020_/Q VDD VSS sg13g2_buf_1
X_08641_ _08641_/Y _08641_/A _08641_/B _08641_/C _08641_/D VDD VSS sg13g2_nor4_1
XFILLER_55_949 VDD VSS sg13g2_decap_8
X_08572_ _08573_/A _08445_/Y _08571_/Y _08570_/Y VDD VSS sg13g2_o21ai_1
XFILLER_82_768 VDD VSS sg13g2_decap_4
XFILLER_165_1310 VDD VSS sg13g2_decap_8
XFILLER_63_993 VDD VSS sg13g2_decap_8
XFILLER_34_161 VDD VSS sg13g2_decap_8
XFILLER_179_133 VDD VSS sg13g2_decap_8
XFILLER_168_818 VDD VSS sg13g2_decap_8
XFILLER_168_829 VDD VSS sg13g2_fill_2
XFILLER_23_857 VDD VSS sg13g2_decap_8
XFILLER_126_1338 VDD VSS sg13g2_decap_8
XFILLER_10_518 VDD VSS sg13g2_decap_8
XFILLER_176_840 VDD VSS sg13g2_decap_8
XFILLER_41_28 VDD VSS sg13g2_decap_8
XFILLER_109_907 VDD VSS sg13g2_decap_8
X_09124_ _09157_/C _14919_/Q _14918_/Q _10760_/A _09150_/B VDD VSS sg13g2_and4_1
XFILLER_124_1073 VDD VSS sg13g2_decap_8
XFILLER_176_873 VDD VSS sg13g2_decap_8
XFILLER_148_575 VDD VSS sg13g2_decap_8
XFILLER_157_28 VDD VSS sg13g2_decap_8
XFILLER_108_417 VDD VSS sg13g2_decap_4
XFILLER_135_214 VDD VSS sg13g2_decap_8
XFILLER_175_383 VDD VSS sg13g2_decap_8
X_09055_ _09057_/B _14908_/Q _09056_/C _14909_/Q VDD VSS sg13g2_a21oi_1
XFILLER_11_1232 VDD VSS sg13g2_decap_8
X_14717__1555 _14717_/RESET_B VDD VSS sg13g2_tiehi
XFILLER_135_247 VDD VSS sg13g2_fill_1
X_08006_ _08146_/A _07820_/B _08119_/A2 _08591_/A3 _08541_/B _08054_/B _08635_/S1
+ VDD VSS sg13g2_mux4_1
XFILLER_123_409 VDD VSS sg13g2_decap_8
XFILLER_150_217 VDD VSS sg13g2_decap_8
XFILLER_104_612 VDD VSS sg13g2_fill_1
XFILLER_89_312 VDD VSS sg13g2_decap_8
XFILLER_2_728 VDD VSS sg13g2_decap_8
XFILLER_116_494 VDD VSS sg13g2_decap_4
XFILLER_104_645 VDD VSS sg13g2_decap_8
X_13981__2291 _13981_/RESET_B VDD VSS sg13g2_tiehi
XFILLER_173_49 VDD VSS sg13g2_decap_8
XFILLER_1_238 VDD VSS sg13g2_decap_8
XFILLER_81_1219 VDD VSS sg13g2_decap_8
XFILLER_132_965 VDD VSS sg13g2_fill_2
XFILLER_172_1347 VDD VSS sg13g2_decap_8
XFILLER_104_678 VDD VSS sg13g2_decap_8
X_09957_ _14541_/D _14541_/Q _10089_/A0 _09961_/S VDD VSS sg13g2_mux2_1
XFILLER_58_721 VDD VSS sg13g2_decap_8
XFILLER_131_497 VDD VSS sg13g2_decap_8
XFILLER_98_890 VDD VSS sg13g2_fill_1
X_08908_ _08908_/Y _08906_/Y _08907_/Y _08931_/S VDD VSS sg13g2_a21oi_1
XFILLER_106_87 VDD VSS sg13g2_decap_8
XFILLER_100_840 VDD VSS sg13g2_fill_1
XFILLER_131_1022 VDD VSS sg13g2_fill_2
XFILLER_135_1191 VDD VSS sg13g2_decap_8
XFILLER_170_1071 VDD VSS sg13g2_fill_1
X_09888_ _14474_/D _09921_/A1 _14474_/Q _09902_/S VDD VSS sg13g2_mux2_1
XFILLER_66_47 VDD VSS sg13g2_decap_8
XFILLER_170_1082 VDD VSS sg13g2_decap_8
XFILLER_18_607 VDD VSS sg13g2_decap_8
XFILLER_58_776 VDD VSS sg13g2_fill_2
XFILLER_73_702 VDD VSS sg13g2_decap_8
X_08839_ _10805_/B _08848_/A _14927_/Q VDD VSS sg13g2_nor2b_1
XFILLER_2_1400 VDD VSS sg13g2_decap_8
X_14892__2853 _14892_/RESET_B VDD VSS sg13g2_tiehi
XFILLER_100_895 VDD VSS sg13g2_decap_8
XFILLER_46_949 VDD VSS sg13g2_decap_8
XFILLER_45_426 VDD VSS sg13g2_fill_2
XFILLER_122_42 VDD VSS sg13g2_decap_8
XFILLER_72_223 VDD VSS sg13g2_fill_2
X_11850_ _11850_/X _14701_/Q _14733_/Q _13773_/Q _13805_/Q _11850_/S0 _11850_/S1 VDD
+ VSS sg13g2_mux4_1
XFILLER_61_908 VDD VSS sg13g2_decap_8
XFILLER_22_1394 VDD VSS sg13g2_decap_8
XFILLER_96_1451 VDD VSS sg13g2_decap_8
XFILLER_183_1410 VDD VSS sg13g2_decap_8
X_10801_ _10801_/Y _10823_/B _10844_/A _10797_/C VDD VSS sg13g2_o21ai_1
X_11781_ _11781_/X _14699_/Q _14731_/Q _13771_/Q _13803_/Q _11850_/S0 _07654_/A VDD
+ VSS sg13g2_mux4_1
XFILLER_60_429 VDD VSS sg13g2_decap_8
XFILLER_13_301 VDD VSS sg13g2_decap_8
XFILLER_41_610 VDD VSS sg13g2_fill_2
X_13520_ _15140_/D _13520_/A1 _13518_/Y _13519_/Y VDD VSS sg13g2_a21oi_1
XFILLER_82_79 VDD VSS sg13g2_decap_8
XFILLER_159_818 VDD VSS sg13g2_fill_1
X_14806__3000 _14806_/RESET_B VDD VSS sg13g2_tiehi
X_10732_ _11042_/D _10747_/A _09066_/Y _08898_/Y VDD VSS sg13g2_o21ai_1
XFILLER_14_868 VDD VSS sg13g2_decap_8
XFILLER_15_84 VDD VSS sg13g2_decap_8
XFILLER_40_153 VDD VSS sg13g2_decap_4
XFILLER_13_378 VDD VSS sg13g2_decap_8
X_13451_ _13455_/C _15174_/Q _15175_/Q VDD VSS sg13g2_nand2_1
XFILLER_16_1132 VDD VSS sg13g2_decap_8
X_10663_ _10664_/A _14893_/Q _14892_/Q _14891_/Q _10663_/D VDD VSS sg13g2_and4_1
XFILLER_167_840 VDD VSS sg13g2_decap_8
XFILLER_185_147 VDD VSS sg13g2_decap_8
X_12402_ _14992_/D _08426_/A _12749_/C1 _12401_/Y _12400_/Y VDD VSS sg13g2_a22oi_1
XFILLER_51_1045 VDD VSS sg13g2_decap_8
XFILLER_127_715 VDD VSS sg13g2_fill_2
XFILLER_166_350 VDD VSS sg13g2_decap_4
X_13382_ _13455_/A _13401_/B _13382_/B VDD VSS sg13g2_nand2_1
X_10594_ _10595_/A _14875_/Q _14874_/Q _10649_/B _10594_/D VDD VSS sg13g2_and4_1
XFILLER_182_810 VDD VSS sg13g2_decap_8
XFILLER_12_1029 VDD VSS sg13g2_decap_8
XFILLER_154_512 VDD VSS sg13g2_decap_8
XFILLER_127_737 VDD VSS sg13g2_decap_8
X_15121_ _15121_/Q _15200_/CLK _15121_/D _15121_/RESET_B VDD VSS sg13g2_dfrbpq_1
XFILLER_154_534 VDD VSS sg13g2_fill_2
X_12333_ _12334_/B _12322_/Y _12324_/X _11224_/A VDD VSS sg13g2_o21ai_1
XFILLER_5_511 VDD VSS sg13g2_decap_8
XFILLER_126_236 VDD VSS sg13g2_decap_8
XFILLER_114_409 VDD VSS sg13g2_decap_8
XFILLER_177_1258 VDD VSS sg13g2_fill_1
XFILLER_182_887 VDD VSS sg13g2_decap_8
X_15052_ _15052_/Q clkload72/A _15052_/D _15052_/RESET_B VDD VSS sg13g2_dfrbpq_1
XFILLER_181_364 VDD VSS sg13g2_decap_8
X_12264_ _12264_/Y _12244_/Y _12246_/X _12192_/A VDD VSS sg13g2_o21ai_1
XFILLER_5_588 VDD VSS sg13g2_decap_8
X_14003_ _14003_/Q clkload32/A _14003_/D _14003_/RESET_B VDD VSS sg13g2_dfrbpq_1
XFILLER_141_239 VDD VSS sg13g2_decap_4
X_11215_ _11216_/B _11898_/C _11210_/X _11832_/C VDD VSS sg13g2_o21ai_1
XFILLER_107_494 VDD VSS sg13g2_fill_1
X_12195_ _12195_/Y _12194_/X _11664_/A _12195_/B1 VDD VSS sg13g2_a21oi_1
X_13811__2461 _13811_/RESET_B VDD VSS sg13g2_tiehi
Xoutput50 mem_axi_araddr[21] _13712_/Q VDD VSS sg13g2_buf_1
XFILLER_122_442 VDD VSS sg13g2_decap_8
Xoutput61 mem_axi_araddr[31] _16884_/A VDD VSS sg13g2_buf_1
X_15164__2610 _15164_/RESET_B VDD VSS sg13g2_tiehi
Xoutput72 mem_axi_awaddr[11] _16864_/X VDD VSS sg13g2_buf_1
XFILLER_150_773 VDD VSS sg13g2_decap_8
Xoutput83 mem_axi_awaddr[22] _16875_/X VDD VSS sg13g2_buf_1
X_11146_ _11173_/B _11146_/A _11146_/B VDD VSS sg13g2_nor2_1
XFILLER_68_518 VDD VSS sg13g2_decap_8
Xoutput94 mem_axi_awaddr[3] _16856_/X VDD VSS sg13g2_buf_1
XFILLER_163_60 VDD VSS sg13g2_fill_2
XFILLER_114_1220 VDD VSS sg13g2_fill_1
XFILLER_27_1272 VDD VSS sg13g2_decap_8
X_11077_ _11077_/Y _11118_/B _11077_/B VDD VSS sg13g2_xnor2_1
XFILLER_7_1344 VDD VSS sg13g2_decap_8
XFILLER_163_93 VDD VSS sg13g2_decap_8
X_14155__2117 _14155_/RESET_B VDD VSS sg13g2_tiehi
X_14905_ _14905_/Q _15212_/CLK _14905_/D _14905_/RESET_B VDD VSS sg13g2_dfrbpq_1
X_10028_ _14610_/D _10161_/A1 _14610_/Q _10036_/S VDD VSS sg13g2_mux2_1
XFILLER_76_573 VDD VSS sg13g2_decap_8
XFILLER_114_1286 VDD VSS sg13g2_decap_8
XFILLER_36_415 VDD VSS sg13g2_decap_8
XFILLER_23_1169 VDD VSS sg13g2_decap_8
XFILLER_63_201 VDD VSS sg13g2_decap_8
XFILLER_114_1297 VDD VSS sg13g2_fill_1
XFILLER_149_1316 VDD VSS sg13g2_decap_8
XFILLER_97_1248 VDD VSS sg13g2_decap_8
X_14836_ _14836_/Q clkload83/A _14836_/D _14836_/RESET_B VDD VSS sg13g2_dfrbpq_1
XFILLER_64_768 VDD VSS sg13g2_fill_2
XFILLER_52_908 VDD VSS sg13g2_decap_8
XFILLER_45_971 VDD VSS sg13g2_decap_8
X_14767_ _14767_/Q _15113_/CLK _14767_/D _14767_/RESET_B VDD VSS sg13g2_dfrbpq_1
XFILLER_16_161 VDD VSS sg13g2_decap_8
X_11979_ _14978_/D _11939_/Y _11978_/Y _11934_/Y VDD VSS sg13g2_a21oi_1
XFILLER_147_1040 VDD VSS sg13g2_fill_2
XFILLER_72_790 VDD VSS sg13g2_decap_8
XFILLER_60_930 VDD VSS sg13g2_decap_8
X_13718_ _16880_/A clkload70/A _13718_/D _13718_/RESET_B VDD VSS sg13g2_dfrbpq_1
X_14698_ _14698_/Q clkload19/A _14698_/D _14698_/RESET_B VDD VSS sg13g2_dfrbpq_1
XFILLER_20_805 VDD VSS sg13g2_decap_8
XFILLER_177_637 VDD VSS sg13g2_decap_8
XFILLER_32_676 VDD VSS sg13g2_decap_8
XFILLER_108_1068 VDD VSS sg13g2_decap_8
X_13649_ _15115_/D _15184_/D _15115_/Q _13651_/S VDD VSS sg13g2_mux2_1
XFILLER_73_1281 VDD VSS sg13g2_decap_8
XFILLER_176_147 VDD VSS sg13g2_decap_8
XFILLER_31_197 VDD VSS sg13g2_decap_8
XFILLER_121_1213 VDD VSS sg13g2_fill_2
XFILLER_160_1262 VDD VSS sg13g2_decap_4
XFILLER_9_861 VDD VSS sg13g2_decap_8
XFILLER_34_1276 VDD VSS sg13g2_decap_8
XFILLER_117_214 VDD VSS sg13g2_fill_1
X_14962__2718 _14962_/RESET_B VDD VSS sg13g2_tiehi
XFILLER_34_1298 VDD VSS sg13g2_decap_8
XFILLER_157_383 VDD VSS sg13g2_decap_8
XFILLER_8_371 VDD VSS sg13g2_decap_8
XFILLER_173_843 VDD VSS sg13g2_decap_4
XFILLER_172_331 VDD VSS sg13g2_decap_8
XFILLER_117_269 VDD VSS sg13g2_decap_8
XFILLER_160_515 VDD VSS sg13g2_decap_8
X_14365__1907 _14365_/RESET_B VDD VSS sg13g2_tiehi
XFILLER_28_1003 VDD VSS sg13g2_decap_4
XFILLER_141_740 VDD VSS sg13g2_fill_1
XFILLER_158_1180 VDD VSS sg13g2_decap_4
XFILLER_119_1142 VDD VSS sg13g2_decap_8
X_14401__1871 _14401_/RESET_B VDD VSS sg13g2_tiehi
Xfanout306 _09616_/A0 _10047_/A0 VDD VSS sg13g2_buf_1
XFILLER_28_1036 VDD VSS sg13g2_decap_8
XFILLER_154_1044 VDD VSS sg13g2_decap_8
Xfanout317 _10074_/A0 _09744_/A1 VDD VSS sg13g2_buf_1
X_09811_ _14399_/D _10109_/A0 _14399_/Q _09838_/S VDD VSS sg13g2_mux2_1
Xfanout328 _10160_/S _10163_/S VDD VSS sg13g2_buf_1
Xfanout339 _10101_/S _10070_/Y VDD VSS sg13g2_buf_1
XFILLER_100_103 VDD VSS sg13g2_decap_8
XFILLER_140_283 VDD VSS sg13g2_decap_8
XFILLER_154_1088 VDD VSS sg13g2_decap_8
XFILLER_101_648 VDD VSS sg13g2_decap_8
X_09742_ _14332_/D _14332_/Q _09907_/A1 _09766_/S VDD VSS sg13g2_mux2_1
X_09673_ _14266_/D _09739_/A0 _14266_/Q _09673_/S VDD VSS sg13g2_mux2_1
XFILLER_28_938 VDD VSS sg13g2_decap_8
XFILLER_41_1269 VDD VSS sg13g2_decap_8
XFILLER_36_28 VDD VSS sg13g2_decap_8
XFILLER_132_1397 VDD VSS sg13g2_decap_8
X_08624_ _08633_/C _07849_/X _08692_/A _08623_/Y _08643_/C _08622_/Y VDD VSS sg13g2_a221oi_1
XFILLER_55_757 VDD VSS sg13g2_decap_8
XFILLER_54_223 VDD VSS sg13g2_decap_8
XFILLER_82_576 VDD VSS sg13g2_decap_8
XFILLER_42_407 VDD VSS sg13g2_decap_8
X_08555_ _08555_/Y _08554_/Y _08549_/Y _08588_/B VDD VSS sg13g2_o21ai_1
XFILLER_39_1121 VDD VSS sg13g2_fill_1
XFILLER_78_1181 VDD VSS sg13g2_decap_4
XFILLER_23_610 VDD VSS sg13g2_decap_8
XFILLER_63_790 VDD VSS sg13g2_decap_8
XFILLER_35_492 VDD VSS sg13g2_decap_8
XFILLER_23_632 VDD VSS sg13g2_decap_8
XFILLER_165_1162 VDD VSS sg13g2_decap_8
XFILLER_168_615 VDD VSS sg13g2_decap_4
X_08486_ _08501_/C _07822_/B _08653_/A _08485_/Y _07820_/X _08484_/Y VDD VSS sg13g2_a221oi_1
XFILLER_74_1056 VDD VSS sg13g2_decap_8
XFILLER_39_1176 VDD VSS sg13g2_decap_8
XFILLER_35_1007 VDD VSS sg13g2_fill_2
XFILLER_11_805 VDD VSS sg13g2_decap_8
X_13853__2419 _13853_/RESET_B VDD VSS sg13g2_tiehi
XFILLER_39_1187 VDD VSS sg13g2_fill_1
XFILLER_35_1029 VDD VSS sg13g2_decap_8
XFILLER_161_1037 VDD VSS sg13g2_decap_8
X_13999__2273 _13999_/RESET_B VDD VSS sg13g2_tiehi
XFILLER_126_1157 VDD VSS sg13g2_decap_8
XFILLER_51_996 VDD VSS sg13g2_decap_8
XFILLER_10_315 VDD VSS sg13g2_decap_8
XFILLER_91_1370 VDD VSS sg13g2_fill_2
XFILLER_52_1321 VDD VSS sg13g2_decap_8
XFILLER_22_175 VDD VSS sg13g2_decap_8
XFILLER_139_7 VDD VSS sg13g2_decap_8
XFILLER_167_147 VDD VSS sg13g2_decap_8
XFILLER_168_49 VDD VSS sg13g2_decap_8
XFILLER_52_1332 VDD VSS sg13g2_fill_1
XFILLER_183_607 VDD VSS sg13g2_decap_8
XFILLER_17_1474 VDD VSS sg13g2_fill_1
XFILLER_109_704 VDD VSS sg13g2_decap_8
XFILLER_13_1316 VDD VSS sg13g2_decap_8
XFILLER_6_308 VDD VSS sg13g2_decap_8
XFILLER_109_726 VDD VSS sg13g2_fill_2
XFILLER_176_681 VDD VSS sg13g2_fill_1
XFILLER_108_214 VDD VSS sg13g2_decap_8
X_09107_ _09107_/Y _15241_/Q _09147_/B VDD VSS sg13g2_nand2b_1
XFILLER_100_1319 VDD VSS sg13g2_decap_8
X_14233__2039 _14233_/RESET_B VDD VSS sg13g2_tiehi
XFILLER_164_887 VDD VSS sg13g2_fill_1
X_09038_ _13767_/D _13767_/Q _09951_/A1 _09160_/S VDD VSS sg13g2_mux2_1
XFILLER_124_729 VDD VSS sg13g2_decap_8
XFILLER_163_375 VDD VSS sg13g2_decap_8
XFILLER_2_525 VDD VSS sg13g2_decap_8
XFILLER_172_1100 VDD VSS sg13g2_decap_8
XFILLER_89_142 VDD VSS sg13g2_decap_8
XFILLER_117_75 VDD VSS sg13g2_decap_8
XFILLER_172_1133 VDD VSS sg13g2_fill_1
X_11000_ _14941_/D _10999_/X _10998_/Y _10987_/Y VDD VSS sg13g2_o21ai_1
XFILLER_78_816 VDD VSS sg13g2_decap_4
XFILLER_46_1136 VDD VSS sg13g2_decap_8
XFILLER_85_1196 VDD VSS sg13g2_decap_8
XFILLER_77_35 VDD VSS sg13g2_decap_8
XFILLER_117_97 VDD VSS sg13g2_fill_1
XFILLER_172_1155 VDD VSS sg13g2_decap_8
XFILLER_104_475 VDD VSS sg13g2_decap_8
XFILLER_131_261 VDD VSS sg13g2_decap_8
XFILLER_132_784 VDD VSS sg13g2_decap_8
Xfanout840 _12762_/S _12747_/S0 VDD VSS sg13g2_buf_1
XFILLER_133_1139 VDD VSS sg13g2_decap_8
Xfanout851 _12663_/S1 _12761_/S0 VDD VSS sg13g2_buf_1
Xfanout862 _12775_/S1 _12760_/S0 VDD VSS sg13g2_buf_1
XFILLER_63_1472 VDD VSS sg13g2_decap_8
XFILLER_150_1431 VDD VSS sg13g2_decap_8
Xfanout873 _12654_/S1 _12674_/S1 VDD VSS sg13g2_buf_1
Xfanout884 _12588_/S1 fanout894/X VDD VSS sg13g2_buf_1
XFILLER_24_1456 VDD VSS sg13g2_decap_8
Xfanout895 _12522_/S1 fanout899/X VDD VSS sg13g2_buf_1
X_12951_ _12951_/Y _12900_/A _12900_/C input35/X VDD VSS sg13g2_a21oi_1
XFILLER_133_63 VDD VSS sg13g2_decap_8
XFILLER_100_692 VDD VSS sg13g2_decap_8
XFILLER_45_212 VDD VSS sg13g2_fill_2
X_11902_ _11902_/Y _11902_/A _11884_/B1 VDD VSS sg13g2_nor2b_1
XFILLER_18_448 VDD VSS sg13g2_decap_8
XFILLER_93_56 VDD VSS sg13g2_decap_8
X_12882_ _12882_/Y _12879_/Y _12880_/Y _12881_/Y VDD VSS sg13g2_a21oi_1
XFILLER_22_1191 VDD VSS sg13g2_decap_8
XFILLER_165_0 VDD VSS sg13g2_decap_8
X_14621_ _14621_/Q _14685_/CLK _14621_/D _14621_/RESET_B VDD VSS sg13g2_dfrbpq_1
X_11833_ _11833_/Y _11813_/Y _11815_/X _11378_/S VDD VSS sg13g2_o21ai_1
XFILLER_2_1274 VDD VSS sg13g2_decap_8
XFILLER_33_429 VDD VSS sg13g2_decap_4
XFILLER_109_1311 VDD VSS sg13g2_fill_2
XFILLER_54_790 VDD VSS sg13g2_decap_8
XFILLER_42_930 VDD VSS sg13g2_decap_8
XFILLER_183_1251 VDD VSS sg13g2_decap_8
X_14552_ _14552_/Q _14982_/CLK _14552_/D _14552_/RESET_B VDD VSS sg13g2_dfrbpq_1
X_11764_ _11765_/B _11761_/Y _11763_/Y _11625_/C VDD VSS sg13g2_a21oi_1
XFILLER_57_1265 VDD VSS sg13g2_decap_8
XFILLER_18_1227 VDD VSS sg13g2_decap_8
XFILLER_14_665 VDD VSS sg13g2_decap_8
X_13503_ _15129_/D _15174_/D _13504_/A _13501_/Y VDD VSS sg13g2_o21ai_1
X_14443__1829 _14443_/RESET_B VDD VSS sg13g2_tiehi
XFILLER_53_1129 VDD VSS sg13g2_decap_8
X_13829__2443 _13829_/RESET_B VDD VSS sg13g2_tiehi
X_10715_ _14906_/D _11168_/B1 _10954_/B _10714_/Y VDD VSS sg13g2_o21ai_1
X_14483_ _14483_/Q _14739_/CLK _14483_/D _14483_/RESET_B VDD VSS sg13g2_dfrbpq_1
X_14589__1683 _14589_/RESET_B VDD VSS sg13g2_tiehi
XFILLER_13_175 VDD VSS sg13g2_decap_8
X_11695_ _11696_/A _13960_/Q _13992_/Q _14024_/Q _14056_/Q _11969_/A _11970_/C VDD
+ VSS sg13g2_mux4_1
XFILLER_41_484 VDD VSS sg13g2_fill_2
X_13434_ _15099_/D _15099_/Q _13353_/Y _13433_/Y VDD VSS sg13g2_a21o_1
XFILLER_139_350 VDD VSS sg13g2_decap_4
X_10646_ _10655_/C _14889_/Q _10643_/C hold3229/X VDD VSS sg13g2_a21oi_1
XFILLER_9_168 VDD VSS sg13g2_decap_8
XFILLER_167_692 VDD VSS sg13g2_decap_8
XFILLER_127_534 VDD VSS sg13g2_decap_8
XFILLER_10_882 VDD VSS sg13g2_decap_8
X_13365_ _15074_/D _13361_/C _13435_/A _13363_/Y VDD VSS sg13g2_o21ai_1
X_10577_ _14870_/D _10586_/D _10577_/B _10577_/C VDD VSS sg13g2_nor3_1
XFILLER_177_1022 VDD VSS sg13g2_decap_8
XFILLER_182_651 VDD VSS sg13g2_decap_8
X_15104_ _15104_/Q clkload86/A _15104_/D _15104_/RESET_B VDD VSS sg13g2_dfrbpq_1
XFILLER_170_813 VDD VSS sg13g2_decap_8
X_12316_ _12317_/A _13754_/Q _14106_/Q _14458_/Q _14554_/Q _12328_/A1 _12330_/S1 VDD
+ VSS sg13g2_mux4_1
XFILLER_115_729 VDD VSS sg13g2_decap_8
X_14209__2063 _14209_/RESET_B VDD VSS sg13g2_tiehi
XFILLER_6_875 VDD VSS sg13g2_decap_8
XFILLER_181_161 VDD VSS sg13g2_decap_8
X_13296_ _15056_/D _13613_/A _07710_/Y _13295_/Y VDD VSS sg13g2_a21o_1
XFILLER_54_7 VDD VSS sg13g2_decap_8
XFILLER_114_217 VDD VSS sg13g2_decap_8
XFILLER_108_792 VDD VSS sg13g2_fill_1
X_15035_ _15035_/Q _15237_/CLK _15035_/D _15035_/RESET_B VDD VSS sg13g2_dfrbpq_1
XFILLER_5_385 VDD VSS sg13g2_decap_8
X_12247_ _12247_/Y _12250_/A1 _14392_/Q VDD VSS sg13g2_nand2b_1
XFILLER_155_1342 VDD VSS sg13g2_decap_4
XFILLER_170_879 VDD VSS sg13g2_decap_8
XFILLER_174_70 VDD VSS sg13g2_decap_8
XFILLER_123_762 VDD VSS sg13g2_decap_8
XFILLER_9_1428 VDD VSS sg13g2_decap_8
XFILLER_3_21 VDD VSS sg13g2_decap_8
XFILLER_116_1315 VDD VSS sg13g2_decap_8
XFILLER_68_304 VDD VSS sg13g2_decap_8
X_12178_ _12178_/Y _12243_/A1 _14518_/Q _12166_/B VDD VSS sg13g2_a21oi_1
XFILLER_96_635 VDD VSS sg13g2_decap_8
XFILLER_29_1389 VDD VSS sg13g2_decap_8
XFILLER_111_957 VDD VSS sg13g2_decap_8
X_11129_ _11129_/Y _11128_/A _11128_/B _11151_/A VDD VSS sg13g2_a21oi_1
XFILLER_96_668 VDD VSS sg13g2_fill_1
XFILLER_7_1141 VDD VSS sg13g2_decap_8
XFILLER_3_98 VDD VSS sg13g2_decap_8
XFILLER_95_167 VDD VSS sg13g2_decap_8
XFILLER_37_713 VDD VSS sg13g2_decap_8
XFILLER_77_893 VDD VSS sg13g2_decap_4
XFILLER_97_1023 VDD VSS sg13g2_decap_8
XFILLER_114_1094 VDD VSS sg13g2_decap_8
XFILLER_97_1078 VDD VSS sg13g2_decap_8
XFILLER_58_1029 VDD VSS sg13g2_decap_8
X_14819_ _14819_/Q _14886_/CLK _14819_/D _14819_/RESET_B VDD VSS sg13g2_dfrbpq_1
XFILLER_52_727 VDD VSS sg13g2_decap_8
XFILLER_64_598 VDD VSS sg13g2_decap_8
XFILLER_36_289 VDD VSS sg13g2_decap_8
XFILLER_149_1179 VDD VSS sg13g2_decap_4
XFILLER_51_237 VDD VSS sg13g2_decap_4
X_08340_ _08340_/Y _08340_/A _08340_/B VDD VSS sg13g2_nand2_1
XFILLER_33_952 VDD VSS sg13g2_decap_8
XFILLER_71_1207 VDD VSS sg13g2_decap_8
XFILLER_149_103 VDD VSS sg13g2_decap_8
XFILLER_71_1218 VDD VSS sg13g2_fill_2
XFILLER_177_434 VDD VSS sg13g2_decap_8
X_08271_ _08271_/Y _08098_/B _08234_/B _08027_/Y VDD VSS sg13g2_a21oi_1
XFILLER_75_1398 VDD VSS sg13g2_decap_8
XFILLER_60_782 VDD VSS sg13g2_decap_8
XFILLER_32_473 VDD VSS sg13g2_decap_8
XFILLER_123_1319 VDD VSS sg13g2_fill_1
XFILLER_178_979 VDD VSS sg13g2_decap_8
X_14419__1853 _14419_/RESET_B VDD VSS sg13g2_tiehi
XFILLER_80_0 VDD VSS sg13g2_decap_8
XFILLER_20_668 VDD VSS sg13g2_decap_8
XFILLER_146_821 VDD VSS sg13g2_decap_8
XFILLER_121_1032 VDD VSS sg13g2_fill_2
XFILLER_34_1084 VDD VSS sg13g2_decap_4
XFILLER_145_320 VDD VSS sg13g2_decap_8
XFILLER_161_802 VDD VSS sg13g2_decap_8
XFILLER_161_813 VDD VSS sg13g2_fill_2
XFILLER_160_301 VDD VSS sg13g2_decap_8
XFILLER_172_161 VDD VSS sg13g2_decap_8
X_14780__3026 _14780_/RESET_B VDD VSS sg13g2_tiehi
XFILLER_12_1393 VDD VSS sg13g2_decap_8
XFILLER_145_397 VDD VSS sg13g2_decap_8
XFILLER_160_334 VDD VSS sg13g2_decap_8
XFILLER_114_751 VDD VSS sg13g2_fill_1
XFILLER_173_1431 VDD VSS sg13g2_decap_8
XFILLER_173_1442 VDD VSS sg13g2_decap_8
XFILLER_82_1325 VDD VSS sg13g2_fill_2
XFILLER_47_1456 VDD VSS sg13g2_decap_8
XFILLER_114_784 VDD VSS sg13g2_decap_8
XFILLER_134_1415 VDD VSS sg13g2_decap_8
XFILLER_134_1426 VDD VSS sg13g2_fill_2
XFILLER_99_484 VDD VSS sg13g2_decap_8
XFILLER_102_946 VDD VSS sg13g2_fill_2
Xfanout147 _09936_/A1 fanout152/X VDD VSS sg13g2_buf_1
Xfanout158 _09934_/A1 fanout162/X VDD VSS sg13g2_buf_1
XFILLER_59_348 VDD VSS sg13g2_decap_8
XFILLER_101_445 VDD VSS sg13g2_fill_1
XFILLER_134_1459 VDD VSS sg13g2_decap_8
XFILLER_41_1000 VDD VSS sg13g2_decap_8
XFILLER_101_456 VDD VSS sg13g2_fill_2
Xfanout169 _10097_/A0 _09131_/X VDD VSS sg13g2_buf_1
X_07986_ _07988_/D _13290_/A _13290_/B VDD VSS sg13g2_nand2_1
XFILLER_80_1071 VDD VSS sg13g2_decap_4
XFILLER_41_1022 VDD VSS sg13g2_fill_2
XFILLER_132_1150 VDD VSS sg13g2_fill_1
X_13907__2365 _13907_/RESET_B VDD VSS sg13g2_tiehi
X_09725_ _14316_/D _09923_/A1 _14316_/Q _09727_/S VDD VSS sg13g2_mux2_1
XFILLER_170_28 VDD VSS sg13g2_decap_8
XFILLER_167_1202 VDD VSS sg13g2_decap_8
XFILLER_41_1077 VDD VSS sg13g2_decap_8
X_09656_ _14249_/D _10152_/A1 _14249_/Q _09672_/S VDD VSS sg13g2_mux2_1
XFILLER_55_565 VDD VSS sg13g2_decap_8
X_08607_ _08615_/C _08652_/B1 _08603_/Y _08606_/Y VDD VSS sg13g2_a21oi_1
XFILLER_83_896 VDD VSS sg13g2_decap_8
XFILLER_103_88 VDD VSS sg13g2_fill_1
X_14811__2995 _14811_/RESET_B VDD VSS sg13g2_tiehi
X_09587_ _14184_/D _14184_/Q _09620_/A0 _09596_/S VDD VSS sg13g2_mux2_1
XFILLER_42_215 VDD VSS sg13g2_decap_4
XFILLER_103_99 VDD VSS sg13g2_decap_8
XFILLER_36_790 VDD VSS sg13g2_decap_8
X_08538_ _08538_/X _08465_/X _08537_/X _08597_/B VDD VSS sg13g2_mux2_1
XFILLER_169_924 VDD VSS sg13g2_decap_8
XFILLER_54_1416 VDD VSS sg13g2_decap_4
XFILLER_11_602 VDD VSS sg13g2_decap_8
X_08469_ _08475_/C _08469_/A _08469_/B VDD VSS sg13g2_nor2_1
XFILLER_168_456 VDD VSS sg13g2_decap_8
XFILLER_180_1468 VDD VSS sg13g2_fill_2
XFILLER_10_112 VDD VSS sg13g2_decap_8
Xwire504 wire504/X wire504/A VDD VSS sg13g2_buf_8
X_10500_ _10502_/B _10500_/A _14840_/Q _14839_/Q VDD VSS sg13g2_nand3_1
XFILLER_52_1140 VDD VSS sg13g2_decap_8
XFILLER_168_489 VDD VSS sg13g2_decap_8
XFILLER_17_1271 VDD VSS sg13g2_decap_8
X_11480_ _11480_/Y _11479_/Y _11478_/Y _11465_/Y _07684_/B _11501_/A2 VDD VSS sg13g2_a221oi_1
XFILLER_11_679 VDD VSS sg13g2_decap_8
XFILLER_13_1113 VDD VSS sg13g2_decap_8
XFILLER_143_1290 VDD VSS sg13g2_decap_4
XFILLER_6_105 VDD VSS sg13g2_decap_8
XFILLER_104_1252 VDD VSS sg13g2_decap_8
XFILLER_183_448 VDD VSS sg13g2_decap_8
X_10431_ _10431_/Y _14833_/Q _10434_/C _10544_/C VDD VSS sg13g2_o21ai_1
XFILLER_10_189 VDD VSS sg13g2_decap_8
XFILLER_164_640 VDD VSS sg13g2_decap_8
XFILLER_148_191 VDD VSS sg13g2_decap_8
XFILLER_12_63 VDD VSS sg13g2_decap_8
X_13150_ _13150_/Y _14853_/Q _13150_/B VDD VSS sg13g2_nand2_1
XFILLER_136_375 VDD VSS sg13g2_decap_8
X_10362_ _14812_/D _14812_/Q _10359_/Y _10361_/Y VDD VSS sg13g2_a21oi_1
XFILLER_163_161 VDD VSS sg13g2_fill_2
XFILLER_3_812 VDD VSS sg13g2_decap_8
XFILLER_87_1269 VDD VSS sg13g2_fill_2
X_12101_ _12101_/X _12101_/A _12101_/B VDD VSS sg13g2_and2_1
XFILLER_178_1397 VDD VSS sg13g2_decap_8
XFILLER_139_1359 VDD VSS sg13g2_decap_8
X_13081_ _13081_/X input12/X _13161_/A2 _13161_/B1 VDD VSS sg13g2_a21o_1
X_10293_ _10295_/A _14791_/Q _10294_/C _14792_/Q VDD VSS sg13g2_a21o_1
XFILLER_2_322 VDD VSS sg13g2_decap_8
XFILLER_152_879 VDD VSS sg13g2_decap_8
XFILLER_88_56 VDD VSS sg13g2_decap_8
X_12032_ _12032_/Y _12033_/A1 _14482_/Q VDD VSS sg13g2_nand2b_1
XFILLER_3_889 VDD VSS sg13g2_decap_8
XFILLER_144_40 VDD VSS sg13g2_decap_8
XFILLER_2_399 VDD VSS sg13g2_decap_8
XFILLER_104_294 VDD VSS sg13g2_decap_8
XFILLER_137_1094 VDD VSS sg13g2_decap_8
Xfanout670 _08940_/S _08850_/S VDD VSS sg13g2_buf_1
XFILLER_115_1370 VDD VSS sg13g2_decap_8
Xfanout692 _08037_/C _07994_/X VDD VSS sg13g2_buf_1
XFILLER_24_1253 VDD VSS sg13g2_decap_8
X_13983_ _13983_/Q clkload21/A _13983_/D _13983_/RESET_B VDD VSS sg13g2_dfrbpq_1
XFILLER_58_370 VDD VSS sg13g2_decap_8
XFILLER_74_841 VDD VSS sg13g2_decap_4
XFILLER_4_1358 VDD VSS sg13g2_decap_8
XFILLER_150_1294 VDD VSS sg13g2_decap_8
XFILLER_19_757 VDD VSS sg13g2_decap_8
X_12934_ _12934_/Y _12900_/A _12900_/C input34/X VDD VSS sg13g2_a21oi_1
X_14072__2200 _14072_/RESET_B VDD VSS sg13g2_tiehi
XFILLER_185_1313 VDD VSS sg13g2_fill_2
XFILLER_18_245 VDD VSS sg13g2_decap_8
XFILLER_46_565 VDD VSS sg13g2_decap_8
XFILLER_34_716 VDD VSS sg13g2_decap_8
XFILLER_98_1387 VDD VSS sg13g2_decap_8
X_12865_ _12865_/Y _12862_/Y _12863_/Y _12864_/Y VDD VSS sg13g2_a21oi_1
XFILLER_2_1071 VDD VSS sg13g2_decap_8
XFILLER_61_535 VDD VSS sg13g2_decap_8
XFILLER_15_941 VDD VSS sg13g2_decap_8
XFILLER_185_1379 VDD VSS sg13g2_decap_8
X_14604_ _14604_/Q clkload26/A _14604_/D _14604_/RESET_B VDD VSS sg13g2_dfrbpq_1
XFILLER_61_546 VDD VSS sg13g2_decap_8
X_11816_ _11816_/Y _11819_/A1 _14380_/Q VDD VSS sg13g2_nand2b_1
X_12796_ _12801_/B _13601_/B _13601_/A VDD VSS sg13g2_nor2b_1
X_14712__1560 _14712_/RESET_B VDD VSS sg13g2_tiehi
XFILLER_14_462 VDD VSS sg13g2_decap_8
XFILLER_109_1152 VDD VSS sg13g2_decap_8
X_14535_ _14535_/Q _14727_/CLK _14535_/D _14535_/RESET_B VDD VSS sg13g2_dfrbpq_1
XFILLER_183_1092 VDD VSS sg13g2_decap_4
X_11747_ _11747_/Y _12000_/A _11747_/B VDD VSS sg13g2_nor2_1
XFILLER_105_1016 VDD VSS sg13g2_fill_1
XFILLER_175_916 VDD VSS sg13g2_decap_8
XFILLER_169_70 VDD VSS sg13g2_decap_8
XFILLER_30_955 VDD VSS sg13g2_fill_2
XFILLER_109_1196 VDD VSS sg13g2_decap_8
XFILLER_186_264 VDD VSS sg13g2_decap_8
XFILLER_35_1360 VDD VSS sg13g2_decap_4
XFILLER_105_1038 VDD VSS sg13g2_decap_8
XFILLER_144_1087 VDD VSS sg13g2_decap_4
XFILLER_174_415 VDD VSS sg13g2_decap_8
X_14466_ _14466_/Q clkload40/A _14466_/D _14466_/RESET_B VDD VSS sg13g2_dfrbpq_1
XFILLER_31_1202 VDD VSS sg13g2_decap_8
XFILLER_186_275 VDD VSS sg13g2_decap_8
X_11678_ _11678_/X _13736_/Q _14088_/Q _14440_/Q _14536_/Q _12232_/S _12236_/C VDD
+ VSS sg13g2_mux4_1
XFILLER_30_988 VDD VSS sg13g2_decap_8
XFILLER_128_821 VDD VSS sg13g2_decap_8
XFILLER_146_117 VDD VSS sg13g2_decap_8
X_13417_ _13490_/D _15129_/Q _13438_/B _13438_/D VDD VSS sg13g2_nand3_1
X_10629_ _10630_/B _14880_/Q _14879_/Q _10629_/C _10629_/D VDD VSS sg13g2_nand4_1
XFILLER_70_1295 VDD VSS sg13g2_decap_8
XFILLER_127_331 VDD VSS sg13g2_decap_8
X_14397_ _14397_/Q _14886_/CLK _14397_/D _14397_/RESET_B VDD VSS sg13g2_dfrbpq_1
XFILLER_127_342 VDD VSS sg13g2_decap_8
XFILLER_128_865 VDD VSS sg13g2_fill_2
XFILLER_155_673 VDD VSS sg13g2_decap_4
XFILLER_143_824 VDD VSS sg13g2_decap_8
X_13348_ _13348_/Y _15171_/D _13486_/C _13486_/B _13485_/B VDD VSS sg13g2_nand4_1
XFILLER_157_1415 VDD VSS sg13g2_fill_2
XFILLER_6_672 VDD VSS sg13g2_decap_8
XFILLER_154_172 VDD VSS sg13g2_fill_1
XFILLER_157_1437 VDD VSS sg13g2_decap_4
XFILLER_185_91 VDD VSS sg13g2_decap_8
Xmax_cap859 _12789_/S0 _12369_/S0 VDD VSS sg13g2_buf_8
XFILLER_5_182 VDD VSS sg13g2_decap_8
XFILLER_157_1459 VDD VSS sg13g2_fill_1
X_13279_ _13279_/Y _15071_/Q _13279_/B _13307_/B _13279_/D VDD VSS sg13g2_nor4_1
Xhold3209 _13625_/A _13733_/Q VDD VSS sg13g2_dlygate4sd3_1
XFILLER_64_1011 VDD VSS sg13g2_decap_8
X_15018_ _15018_/Q clkload43/A _15018_/D _15018_/RESET_B VDD VSS sg13g2_dfrbpq_1
XFILLER_111_710 VDD VSS sg13g2_decap_4
XFILLER_123_570 VDD VSS sg13g2_decap_4
XFILLER_9_1225 VDD VSS sg13g2_decap_8
XFILLER_69_624 VDD VSS sg13g2_decap_8
XFILLER_69_635 VDD VSS sg13g2_fill_2
XFILLER_111_732 VDD VSS sg13g2_decap_8
X_07840_ _08654_/A _15018_/Q _08653_/B VDD VSS sg13g2_nor2_1
X_13686__2593 _13686_/RESET_B VDD VSS sg13g2_tiehi
XFILLER_68_167 VDD VSS sg13g2_decap_8
XFILLER_42_1342 VDD VSS sg13g2_decap_8
X_07771_ _08318_/B _08258_/C _14998_/Q VDD VSS sg13g2_xor2_1
XFILLER_96_498 VDD VSS sg13g2_fill_2
XFILLER_110_286 VDD VSS sg13g2_decap_8
XFILLER_42_1375 VDD VSS sg13g2_decap_8
X_09510_ _14109_/D _09842_/A1 _14109_/Q _09539_/S VDD VSS sg13g2_mux2_1
XFILLER_77_1427 VDD VSS sg13g2_decap_8
XFILLER_65_874 VDD VSS sg13g2_decap_8
XFILLER_80_811 VDD VSS sg13g2_decap_4
X_09441_ _09441_/Y _09441_/A _10004_/B _09441_/C _09441_/D VDD VSS sg13g2_nand4_1
X_14937__2763 _14937_/RESET_B VDD VSS sg13g2_tiehi
XFILLER_80_844 VDD VSS sg13g2_decap_8
X_09372_ _13976_/D _10134_/A0 _13976_/Q _09372_/S VDD VSS sg13g2_mux2_1
XFILLER_24_259 VDD VSS sg13g2_decap_8
X_14798__3008 _14798_/RESET_B VDD VSS sg13g2_tiehi
XFILLER_40_719 VDD VSS sg13g2_decap_8
XFILLER_162_1110 VDD VSS sg13g2_decap_8
XFILLER_21_900 VDD VSS sg13g2_decap_4
XFILLER_162_1121 VDD VSS sg13g2_fill_1
XFILLER_33_771 VDD VSS sg13g2_decap_8
X_08323_ _08323_/Y _07796_/B _08322_/Y _08588_/B VDD VSS sg13g2_o21ai_1
XFILLER_177_231 VDD VSS sg13g2_decap_8
XFILLER_32_270 VDD VSS sg13g2_decap_8
XFILLER_123_1116 VDD VSS sg13g2_decap_8
XFILLER_162_1165 VDD VSS sg13g2_decap_8
XFILLER_178_776 VDD VSS sg13g2_decap_8
XFILLER_36_1168 VDD VSS sg13g2_decap_8
XFILLER_14_1400 VDD VSS sg13g2_decap_8
X_13770__2502 _13770_/RESET_B VDD VSS sg13g2_tiehi
X_08254_ _08426_/B _08171_/X _08253_/X _08431_/D VDD VSS sg13g2_mux2_1
XFILLER_137_117 VDD VSS sg13g2_decap_8
XFILLER_140_1430 VDD VSS sg13g2_decap_8
XFILLER_20_498 VDD VSS sg13g2_decap_8
X_08185_ _08185_/Y _08184_/Y _07876_/Y _08001_/Y VDD VSS sg13g2_a21oi_1
XFILLER_134_802 VDD VSS sg13g2_decap_8
XFILLER_4_609 VDD VSS sg13g2_decap_8
XFILLER_161_610 VDD VSS sg13g2_fill_2
XFILLER_165_28 VDD VSS sg13g2_decap_8
X_15115__2822 _15115_/RESET_B VDD VSS sg13g2_tiehi
XFILLER_133_312 VDD VSS sg13g2_decap_8
XFILLER_3_119 VDD VSS sg13g2_decap_8
XFILLER_118_397 VDD VSS sg13g2_fill_2
XFILLER_173_492 VDD VSS sg13g2_decap_8
XFILLER_12_1190 VDD VSS sg13g2_decap_8
XFILLER_145_194 VDD VSS sg13g2_decap_8
XFILLER_161_643 VDD VSS sg13g2_decap_8
X_14150__2122 _14150_/RESET_B VDD VSS sg13g2_tiehi
X_15166__2602 _15166_/RESET_B VDD VSS sg13g2_tiehi
XFILLER_88_911 VDD VSS sg13g2_decap_8
XFILLER_161_687 VDD VSS sg13g2_decap_8
X_14829__2977 _14829_/RESET_B VDD VSS sg13g2_tiehi
XFILLER_102_710 VDD VSS sg13g2_fill_1
XFILLER_160_175 VDD VSS sg13g2_decap_8
XFILLER_99_270 VDD VSS sg13g2_decap_8
XFILLER_59_101 VDD VSS sg13g2_decap_8
XFILLER_0_848 VDD VSS sg13g2_decap_8
XFILLER_47_1275 VDD VSS sg13g2_decap_8
XFILLER_102_732 VDD VSS sg13g2_decap_8
XFILLER_58_48 VDD VSS sg13g2_decap_8
XFILLER_58_59 VDD VSS sg13g2_fill_1
XFILLER_82_1177 VDD VSS sg13g2_decap_8
XFILLER_48_808 VDD VSS sg13g2_decap_8
XFILLER_181_49 VDD VSS sg13g2_decap_8
XFILLER_134_1267 VDD VSS sg13g2_fill_1
XFILLER_88_988 VDD VSS sg13g2_decap_8
XFILLER_87_476 VDD VSS sg13g2_decap_8
XFILLER_47_318 VDD VSS sg13g2_decap_8
X_07969_ _07976_/C _07969_/A _08678_/A _08650_/A _07969_/D VDD VSS sg13g2_nor4_1
XFILLER_59_189 VDD VSS sg13g2_decap_8
XFILLER_28_510 VDD VSS sg13g2_decap_8
XFILLER_169_1319 VDD VSS sg13g2_decap_8
X_14183__2089 _14183_/RESET_B VDD VSS sg13g2_tiehi
X_09708_ _14299_/D _09906_/A1 _14299_/Q _09727_/S VDD VSS sg13g2_mux2_1
X_10980_ _10980_/Y _10978_/Y _11009_/D _11043_/A VDD VSS sg13g2_a21oi_1
XFILLER_74_159 VDD VSS sg13g2_decap_8
XFILLER_21_1459 VDD VSS sg13g2_decap_8
X_09639_ _09806_/D _09905_/A _09872_/B VDD VSS sg13g2_and2_1
XFILLER_43_513 VDD VSS sg13g2_decap_8
XFILLER_16_749 VDD VSS sg13g2_decap_8
X_12650_ _12650_/X _12648_/X _12649_/X _12678_/S VDD VSS sg13g2_mux2_1
XFILLER_15_259 VDD VSS sg13g2_decap_8
XFILLER_19_1322 VDD VSS sg13g2_decap_8
XFILLER_169_732 VDD VSS sg13g2_decap_8
XFILLER_71_899 VDD VSS sg13g2_fill_2
XFILLER_54_1213 VDD VSS sg13g2_fill_1
X_11601_ _11601_/Y _11601_/A _11615_/B VDD VSS sg13g2_nand2_1
XFILLER_169_743 VDD VSS sg13g2_fill_2
X_12581_ _12581_/X _12580_/X _12579_/X _12664_/S VDD VSS sg13g2_mux2_1
XFILLER_106_1325 VDD VSS sg13g2_decap_8
XFILLER_145_1385 VDD VSS sg13g2_fill_2
X_14320_ _14320_/Q clkload19/A _14320_/D _14320_/RESET_B VDD VSS sg13g2_dfrbpq_1
XFILLER_12_966 VDD VSS sg13g2_decap_8
XFILLER_156_404 VDD VSS sg13g2_decap_8
XFILLER_19_1399 VDD VSS sg13g2_decap_8
X_11532_ _11533_/B _11532_/A _11532_/B _11532_/C VDD VSS sg13g2_nand3_1
XFILLER_141_1238 VDD VSS sg13g2_decap_8
XFILLER_157_938 VDD VSS sg13g2_decap_4
X_14360__1912 _14360_/RESET_B VDD VSS sg13g2_tiehi
Xwire323 wire323/X wire323/A VDD VSS sg13g2_buf_2
XFILLER_89_1309 VDD VSS sg13g2_decap_8
XFILLER_11_476 VDD VSS sg13g2_decap_8
XFILLER_168_297 VDD VSS sg13g2_fill_1
Xwire334 wire334/X wire334/A VDD VSS sg13g2_buf_2
XFILLER_23_84 VDD VSS sg13g2_decap_8
XFILLER_109_320 VDD VSS sg13g2_decap_8
XFILLER_128_0 VDD VSS sg13g2_decap_8
X_14251_ _14251_/Q clkload9/A _14251_/D _14251_/RESET_B VDD VSS sg13g2_dfrbpq_1
XFILLER_8_959 VDD VSS sg13g2_decap_8
XFILLER_183_245 VDD VSS sg13g2_decap_8
X_11463_ _11463_/Y _11463_/A _11463_/B _11463_/C VDD VSS sg13g2_nor3_1
XFILLER_139_84 VDD VSS sg13g2_decap_8
XFILLER_165_971 VDD VSS sg13g2_decap_8
X_13202_ _13204_/B _13202_/A _13202_/B VDD VSS sg13g2_nand2_1
XFILLER_7_469 VDD VSS sg13g2_decap_8
XFILLER_143_109 VDD VSS sg13g2_decap_8
X_10414_ _10415_/A _14827_/Q _10414_/B _10414_/C _10414_/D VDD VSS sg13g2_and4_1
XFILLER_99_44 VDD VSS sg13g2_decap_8
XFILLER_87_1022 VDD VSS sg13g2_fill_1
XFILLER_139_1101 VDD VSS sg13g2_decap_8
X_14182_ _14182_/Q _14662_/CLK _14182_/D _14182_/RESET_B VDD VSS sg13g2_dfrbpq_1
XFILLER_164_470 VDD VSS sg13g2_decap_8
X_11394_ _11395_/A _14687_/Q _14719_/Q _13759_/Q _13791_/Q _11415_/S _11401_/C VDD
+ VSS sg13g2_mux4_1
X_13133_ _13146_/C _14914_/Q _13673_/Q _13133_/C VDD VSS sg13g2_nand3_1
XFILLER_152_654 VDD VSS sg13g2_decap_8
X_10345_ _10397_/B _14807_/Q _14808_/Q _10345_/C _10345_/D VDD VSS sg13g2_nand4_1
XFILLER_140_816 VDD VSS sg13g2_decap_8
XFILLER_152_687 VDD VSS sg13g2_decap_4
X_14393__1879 _14393_/RESET_B VDD VSS sg13g2_tiehi
XFILLER_139_1189 VDD VSS sg13g2_decap_4
X_13064_ _13172_/A _13064_/A _13064_/B VDD VSS sg13g2_xor2_1
X_13779__2493 _13779_/RESET_B VDD VSS sg13g2_tiehi
XFILLER_151_175 VDD VSS sg13g2_decap_4
X_10276_ _10279_/B _14786_/Q _10305_/A _14787_/Q VDD VSS sg13g2_a21oi_1
XFILLER_65_1353 VDD VSS sg13g2_fill_1
XFILLER_3_686 VDD VSS sg13g2_decap_8
Xfanout1410 fanout1410/X fanout1440/X VDD VSS sg13g2_buf_1
X_12015_ _12019_/A _12014_/X _12233_/B VDD VSS sg13g2_nand2b_1
XFILLER_61_1217 VDD VSS sg13g2_decap_8
XFILLER_117_1454 VDD VSS sg13g2_decap_8
Xfanout1421 _11880_/A1 fanout1429/X VDD VSS sg13g2_buf_1
XFILLER_2_196 VDD VSS sg13g2_decap_8
Xfanout1432 _12328_/A1 _12330_/S0 VDD VSS sg13g2_buf_1
XFILLER_79_977 VDD VSS sg13g2_decap_8
XFILLER_26_1348 VDD VSS sg13g2_decap_8
Xfanout1443 _12140_/S0 fanout1445/X VDD VSS sg13g2_buf_1
XFILLER_79_988 VDD VSS sg13g2_fill_2
Xfanout1454 _11713_/S0 _12288_/S0 VDD VSS sg13g2_buf_1
XFILLER_94_925 VDD VSS sg13g2_decap_4
XFILLER_66_627 VDD VSS sg13g2_decap_8
Xfanout1465 _10633_/A fanout1476/X VDD VSS sg13g2_buf_1
XFILLER_48_70 VDD VSS sg13g2_decap_8
XFILLER_17_7 VDD VSS sg13g2_decap_8
Xfanout1476 fanout1476/X _13198_/B1 VDD VSS sg13g2_buf_1
Xfanout1487 _10611_/B _10499_/C VDD VSS sg13g2_buf_1
X_14013__2259 _14013_/RESET_B VDD VSS sg13g2_tiehi
Xfanout1498 _12765_/A1 _12956_/B VDD VSS sg13g2_buf_1
XFILLER_24_1061 VDD VSS sg13g2_fill_1
XFILLER_65_148 VDD VSS sg13g2_decap_8
X_13966_ _13966_/Q _14222_/CLK _13966_/D _13966_/RESET_B VDD VSS sg13g2_dfrbpq_1
XFILLER_4_1155 VDD VSS sg13g2_decap_8
XFILLER_111_1064 VDD VSS sg13g2_decap_8
X_12917_ _12917_/Y _14806_/Q _07729_/B _12917_/B1 VDD VSS sg13g2_a21oi_1
XFILLER_0_77 VDD VSS sg13g2_decap_8
X_13897_ _13897_/Q clkload34/A _13897_/D _13897_/RESET_B VDD VSS sg13g2_dfrbpq_1
XFILLER_73_181 VDD VSS sg13g2_decap_8
XFILLER_179_518 VDD VSS sg13g2_decap_8
XFILLER_34_557 VDD VSS sg13g2_decap_8
X_12848_ _12848_/X _14897_/Q _13690_/Q VDD VSS sg13g2_xor2_1
XFILLER_37_1411 VDD VSS sg13g2_decap_8
XFILLER_181_1029 VDD VSS sg13g2_decap_8
XFILLER_159_220 VDD VSS sg13g2_fill_2
X_12779_ _12792_/A _12779_/A1 _12779_/A2 _08692_/C VDD VSS sg13g2_a21oi_1
XFILLER_9_42 VDD VSS sg13g2_decap_8
XFILLER_148_916 VDD VSS sg13g2_decap_8
X_14518_ _14518_/Q _14518_/CLK _14518_/D _14518_/RESET_B VDD VSS sg13g2_dfrbpq_1
XFILLER_175_724 VDD VSS sg13g2_decap_8
XFILLER_119_139 VDD VSS sg13g2_decap_4
XFILLER_70_1070 VDD VSS sg13g2_decap_8
XFILLER_174_245 VDD VSS sg13g2_decap_8
X_14449_ _14449_/Q clkload7/A _14449_/D _14449_/RESET_B VDD VSS sg13g2_dfrbpq_1
XFILLER_35_1190 VDD VSS sg13g2_decap_8
XFILLER_128_673 VDD VSS sg13g2_decap_4
XFILLER_162_418 VDD VSS sg13g2_decap_8
XFILLER_115_301 VDD VSS sg13g2_fill_2
XFILLER_127_161 VDD VSS sg13g2_decap_8
XFILLER_143_621 VDD VSS sg13g2_decap_8
XFILLER_155_481 VDD VSS sg13g2_decap_8
XFILLER_66_1117 VDD VSS sg13g2_decap_8
XFILLER_142_120 VDD VSS sg13g2_decap_8
X_09990_ _14573_/D _10089_/A0 _14573_/Q _09990_/S VDD VSS sg13g2_mux2_1
XFILLER_157_1267 VDD VSS sg13g2_fill_1
XFILLER_171_985 VDD VSS sg13g2_decap_8
XFILLER_43_0 VDD VSS sg13g2_decap_8
XFILLER_103_518 VDD VSS sg13g2_fill_1
XFILLER_115_378 VDD VSS sg13g2_decap_4
X_08941_ _13719_/D _16881_/A _08940_/X _08941_/S VDD VSS sg13g2_mux2_1
XFILLER_69_410 VDD VSS sg13g2_fill_2
XFILLER_9_1022 VDD VSS sg13g2_decap_8
XFILLER_83_1464 VDD VSS sg13g2_decap_8
XFILLER_69_443 VDD VSS sg13g2_decap_8
X_08872_ _13701_/D _16863_/A _08871_/X _08938_/S VDD VSS sg13g2_mux2_1
XFILLER_44_1448 VDD VSS sg13g2_decap_8
XFILLER_97_774 VDD VSS sg13g2_decap_8
XFILLER_97_785 VDD VSS sg13g2_fill_2
XFILLER_57_616 VDD VSS sg13g2_fill_1
X_07823_ _07823_/Y _07822_/A _07822_/B _07818_/Y VDD VSS sg13g2_o21ai_1
Xclkbuf_5_15__f_clk_i clkbuf_leaf_46_clk_i/A clkbuf_4_7_0_clk_i/X VDD VSS sg13g2_buf_16
XFILLER_9_1099 VDD VSS sg13g2_decap_8
XFILLER_85_969 VDD VSS sg13g2_decap_8
XFILLER_38_830 VDD VSS sg13g2_decap_8
XFILLER_84_446 VDD VSS sg13g2_decap_4
X_15144__2762 _15144_/RESET_B VDD VSS sg13g2_tiehi
X_07754_ _07754_/Y _13281_/B _07754_/B VDD VSS sg13g2_nor2_1
XFILLER_38_863 VDD VSS sg13g2_decap_8
XFILLER_84_479 VDD VSS sg13g2_decap_8
XFILLER_77_1213 VDD VSS sg13g2_decap_8
XFILLER_53_811 VDD VSS sg13g2_decap_8
X_07685_ _07687_/B _15055_/Q _13293_/D _13281_/B VDD VSS sg13g2_a21o_1
XFILLER_92_490 VDD VSS sg13g2_fill_1
XFILLER_164_1205 VDD VSS sg13g2_decap_8
XFILLER_80_641 VDD VSS sg13g2_fill_2
XFILLER_44_28 VDD VSS sg13g2_decap_8
X_09424_ _14026_/D _09622_/A0 _14026_/Q _09427_/S VDD VSS sg13g2_mux2_1
XFILLER_77_1279 VDD VSS sg13g2_decap_4
XFILLER_40_505 VDD VSS sg13g2_decap_8
XFILLER_129_1369 VDD VSS sg13g2_decap_4
X_14168__2104 _14168_/RESET_B VDD VSS sg13g2_tiehi
X_09355_ _13959_/D _09951_/A1 _13959_/Q _09363_/S VDD VSS sg13g2_mux2_1
XFILLER_52_398 VDD VSS sg13g2_fill_2
XFILLER_21_730 VDD VSS sg13g2_decap_4
XFILLER_100_56 VDD VSS sg13g2_fill_1
XFILLER_139_927 VDD VSS sg13g2_decap_8
X_08306_ _08306_/Y _08470_/A _08306_/B _08306_/C VDD VSS sg13g2_nand3_1
XFILLER_21_752 VDD VSS sg13g2_decap_8
XFILLER_165_201 VDD VSS sg13g2_decap_8
X_09286_ _13894_/D _13894_/Q _10149_/A1 _09298_/S VDD VSS sg13g2_mux2_1
XFILLER_100_89 VDD VSS sg13g2_decap_8
XFILLER_178_595 VDD VSS sg13g2_decap_8
XFILLER_60_49 VDD VSS sg13g2_decap_8
XFILLER_166_768 VDD VSS sg13g2_decap_4
XFILLER_20_273 VDD VSS sg13g2_decap_8
X_08237_ _08237_/Y _08036_/A _08234_/Y _08234_/B _08236_/X VDD VSS sg13g2_a22oi_1
XFILLER_121_7 VDD VSS sg13g2_decap_8
XFILLER_154_919 VDD VSS sg13g2_decap_8
XFILLER_176_49 VDD VSS sg13g2_decap_8
XFILLER_14_1274 VDD VSS sg13g2_decap_8
XFILLER_153_418 VDD VSS sg13g2_fill_2
XFILLER_4_406 VDD VSS sg13g2_decap_8
XFILLER_10_1127 VDD VSS sg13g2_decap_8
X_08168_ _08168_/Y _08338_/B _08044_/X _08167_/X VDD VSS sg13g2_o21ai_1
XFILLER_49_1304 VDD VSS sg13g2_decap_8
XFILLER_88_1364 VDD VSS sg13g2_decap_8
XFILLER_101_1266 VDD VSS sg13g2_decap_8
XFILLER_162_941 VDD VSS sg13g2_decap_8
XFILLER_175_1323 VDD VSS sg13g2_decap_8
XFILLER_84_1206 VDD VSS sg13g2_decap_8
XFILLER_106_334 VDD VSS sg13g2_decap_4
XFILLER_162_952 VDD VSS sg13g2_fill_1
XFILLER_49_1337 VDD VSS sg13g2_decap_4
XFILLER_180_259 VDD VSS sg13g2_decap_8
XFILLER_175_1345 VDD VSS sg13g2_decap_8
X_08099_ _08200_/C _08219_/A _08258_/C _11461_/A _07929_/B _08402_/A _08063_/A VDD
+ VSS sg13g2_mux4_1
XFILLER_49_1348 VDD VSS sg13g2_fill_1
XFILLER_136_1307 VDD VSS sg13g2_decap_8
XFILLER_49_1359 VDD VSS sg13g2_decap_8
XFILLER_161_473 VDD VSS sg13g2_decap_8
XFILLER_171_1209 VDD VSS sg13g2_fill_2
X_10130_ _14708_/D _10163_/A1 _14708_/Q _10130_/S VDD VSS sg13g2_mux2_1
XFILLER_175_1389 VDD VSS sg13g2_decap_8
Xclkbuf_leaf_112_clk_i _14652_/CLK clkbuf_leaf_83_clk_i/A VDD VSS sg13g2_buf_8
XFILLER_0_623 VDD VSS sg13g2_decap_8
XFILLER_115_890 VDD VSS sg13g2_decap_8
XFILLER_125_31 VDD VSS sg13g2_fill_1
X_14975__2705 _14975_/RESET_B VDD VSS sg13g2_tiehi
X_10061_ _14642_/D _10161_/A1 _14642_/Q _10069_/S VDD VSS sg13g2_mux2_1
XFILLER_121_359 VDD VSS sg13g2_decap_8
XFILLER_134_1031 VDD VSS sg13g2_decap_8
XFILLER_173_1080 VDD VSS sg13g2_fill_2
XFILLER_125_53 VDD VSS sg13g2_decap_8
XFILLER_134_1042 VDD VSS sg13g2_fill_2
XFILLER_173_1091 VDD VSS sg13g2_fill_2
XFILLER_130_860 VDD VSS sg13g2_decap_8
XFILLER_48_605 VDD VSS sg13g2_decap_8
XFILLER_134_1075 VDD VSS sg13g2_fill_1
XFILLER_87_273 VDD VSS sg13g2_decap_8
XFILLER_125_97 VDD VSS sg13g2_decap_8
XFILLER_47_115 VDD VSS sg13g2_fill_2
XFILLER_87_295 VDD VSS sg13g2_fill_2
XFILLER_5_1442 VDD VSS sg13g2_decap_8
X_13820_ _13820_/Q clkload64/A _13820_/D _13820_/RESET_B VDD VSS sg13g2_dfrbpq_1
Xclkbuf_leaf_127_clk_i clkload18/A clkbuf_5_4__f_clk_i/X VDD VSS sg13g2_buf_8
XFILLER_25_1392 VDD VSS sg13g2_decap_8
XFILLER_112_1351 VDD VSS sg13g2_fill_1
XFILLER_95_1302 VDD VSS sg13g2_decap_8
XFILLER_90_405 VDD VSS sg13g2_decap_8
XFILLER_112_1373 VDD VSS sg13g2_fill_1
XFILLER_21_1256 VDD VSS sg13g2_decap_8
XFILLER_62_118 VDD VSS sg13g2_decap_8
XFILLER_112_1384 VDD VSS sg13g2_decap_8
XFILLER_186_1441 VDD VSS sg13g2_decap_8
XFILLER_18_84 VDD VSS sg13g2_decap_8
X_13751_ _13751_/Q clkload46/A _13751_/D _13751_/RESET_B VDD VSS sg13g2_dfrbpq_1
X_10963_ _10964_/B _10949_/Y _11004_/A _10942_/Y VDD VSS sg13g2_a21oi_1
XFILLER_43_310 VDD VSS sg13g2_decap_8
XFILLER_141_74 VDD VSS sg13g2_decap_8
XFILLER_90_449 VDD VSS sg13g2_decap_8
XFILLER_16_546 VDD VSS sg13g2_decap_8
XFILLER_44_855 VDD VSS sg13g2_decap_8
X_12702_ _12702_/X _14580_/Q _14612_/Q _14644_/Q _14676_/Q _12702_/S0 _12702_/S1 VDD
+ VSS sg13g2_mux4_1
XFILLER_147_1436 VDD VSS sg13g2_decap_8
X_13682_ _13682_/Q _15182_/CLK _13682_/D _13682_/RESET_B VDD VSS sg13g2_dfrbpq_1
XFILLER_182_1338 VDD VSS sg13g2_decap_8
X_10894_ _10904_/B _10893_/A _10893_/B _10948_/A VDD VSS sg13g2_a21o_1
X_12633_ _12633_/X _14703_/Q _14735_/Q _13775_/Q _13807_/Q _12633_/S0 _12633_/S1 VDD
+ VSS sg13g2_mux4_1
XFILLER_43_387 VDD VSS sg13g2_decap_8
XFILLER_43_398 VDD VSS sg13g2_fill_1
XFILLER_31_538 VDD VSS sg13g2_decap_8
XFILLER_31_549 VDD VSS sg13g2_fill_1
XFILLER_93_1092 VDD VSS sg13g2_fill_1
XFILLER_12_763 VDD VSS sg13g2_decap_8
X_12564_ _12564_/X _13962_/Q _13994_/Q _14026_/Q _14058_/Q _12564_/S0 _12564_/S1 VDD
+ VSS sg13g2_mux4_1
XFILLER_19_1196 VDD VSS sg13g2_decap_8
X_14303_ _14303_/Q clkload20/A _14303_/D _14303_/RESET_B VDD VSS sg13g2_dfrbpq_1
XFILLER_11_273 VDD VSS sg13g2_decap_8
XFILLER_156_234 VDD VSS sg13g2_fill_1
XFILLER_184_543 VDD VSS sg13g2_decap_4
X_11515_ _11516_/A _11509_/X _11510_/X _11513_/X _11514_/X _11515_/S0 _11654_/S VDD
+ VSS sg13g2_mux4_1
XFILLER_156_245 VDD VSS sg13g2_decap_8
XFILLER_8_756 VDD VSS sg13g2_decap_8
XFILLER_71_1390 VDD VSS sg13g2_decap_8
XFILLER_157_779 VDD VSS sg13g2_fill_1
X_14921__2795 _14921_/RESET_B VDD VSS sg13g2_tiehi
X_12495_ _12495_/X _12492_/X _12491_/X _12488_/X _12487_/X wire853/X _12663_/S0 VDD
+ VSS sg13g2_mux4_1
X_14234_ _14234_/Q clkload51/A _14234_/D _14234_/RESET_B VDD VSS sg13g2_dfrbpq_1
XFILLER_7_266 VDD VSS sg13g2_decap_8
XFILLER_125_610 VDD VSS sg13g2_decap_8
X_11446_ _11446_/Y _11446_/A _11446_/B VDD VSS sg13g2_nor2_1
XFILLER_32_1385 VDD VSS sg13g2_decap_8
X_13866__2406 _13866_/RESET_B VDD VSS sg13g2_tiehi
XFILLER_125_643 VDD VSS sg13g2_decap_8
X_14165_ _14165_/Q clkload28/A _14165_/D _14165_/RESET_B VDD VSS sg13g2_dfrbpq_1
X_13902__2370 _13902_/RESET_B VDD VSS sg13g2_tiehi
X_11377_ _11377_/Y _11375_/Y _11374_/Y _11822_/B _11376_/X VDD VSS sg13g2_a22oi_1
XFILLER_67_1448 VDD VSS sg13g2_fill_2
XFILLER_4_973 VDD VSS sg13g2_decap_8
XFILLER_125_687 VDD VSS sg13g2_decap_8
X_13116_ _13171_/A _13116_/A _13116_/B _13116_/C VDD VSS sg13g2_nand3_1
X_10328_ _14802_/D _10414_/B _10345_/C _10325_/B _07646_/Y _13328_/A VDD VSS sg13g2_a221oi_1
XFILLER_98_538 VDD VSS sg13g2_decap_8
X_14096_ _14096_/Q clkload10/A _14096_/D _14096_/RESET_B VDD VSS sg13g2_dfrbpq_1
XFILLER_106_890 VDD VSS sg13g2_fill_2
XFILLER_65_1150 VDD VSS sg13g2_decap_8
XFILLER_3_483 VDD VSS sg13g2_decap_8
X_13047_ _13048_/A _12937_/A _13046_/Y _12933_/Y VDD VSS sg13g2_o21ai_1
XFILLER_59_80 VDD VSS sg13g2_decap_8
X_10259_ _10259_/Y _10265_/A _10265_/D _10350_/C VDD VSS sg13g2_o21ai_1
XFILLER_117_1262 VDD VSS sg13g2_decap_8
XFILLER_26_1145 VDD VSS sg13g2_decap_8
XFILLER_182_70 VDD VSS sg13g2_decap_8
X_14246__2026 _14246_/RESET_B VDD VSS sg13g2_tiehi
Xfanout1240 _08063_/B _13602_/A VDD VSS sg13g2_buf_1
XFILLER_67_936 VDD VSS sg13g2_decap_8
Xfanout1251 _13088_/A _14912_/Q VDD VSS sg13g2_buf_1
XFILLER_6_1239 VDD VSS sg13g2_decap_8
XFILLER_38_104 VDD VSS sg13g2_decap_8
XFILLER_152_1175 VDD VSS sg13g2_decap_4
XFILLER_22_1009 VDD VSS sg13g2_decap_8
Xfanout1262 _10566_/D _14862_/Q VDD VSS sg13g2_buf_1
XFILLER_94_733 VDD VSS sg13g2_decap_8
Xfanout1273 _11125_/A _11202_/A VDD VSS sg13g2_buf_1
XFILLER_43_1470 VDD VSS sg13g2_fill_2
XFILLER_38_137 VDD VSS sg13g2_decap_8
XFILLER_94_766 VDD VSS sg13g2_fill_2
XFILLER_93_265 VDD VSS sg13g2_fill_2
XFILLER_54_619 VDD VSS sg13g2_decap_8
X_14998_ _14998_/Q _15019_/CLK _14998_/D _14998_/RESET_B VDD VSS sg13g2_dfrbpq_1
X_13949_ _13949_/Q _14222_/CLK _13949_/D _13949_/RESET_B VDD VSS sg13g2_dfrbpq_1
XFILLER_74_1408 VDD VSS sg13g2_fill_1
XFILLER_46_192 VDD VSS sg13g2_decap_8
Xclkbuf_leaf_91_clk_i _14864_/CLK clkbuf_leaf_93_clk_i/A VDD VSS sg13g2_buf_8
XFILLER_34_343 VDD VSS sg13g2_decap_4
XFILLER_179_315 VDD VSS sg13g2_decap_8
X_15086__2914 _15086_/RESET_B VDD VSS sg13g2_tiehi
XFILLER_34_376 VDD VSS sg13g2_decap_8
XFILLER_72_1110 VDD VSS sg13g2_fill_2
XFILLER_124_1200 VDD VSS sg13g2_decap_8
XFILLER_128_1391 VDD VSS sg13g2_decap_8
X_09140_ _10781_/A _15049_/Q _15246_/Q _09147_/B VDD VSS sg13g2_mux2_1
XFILLER_72_1154 VDD VSS sg13g2_decap_8
XFILLER_37_1296 VDD VSS sg13g2_decap_8
XFILLER_124_1266 VDD VSS sg13g2_decap_8
XFILLER_148_757 VDD VSS sg13g2_fill_2
XFILLER_175_554 VDD VSS sg13g2_decap_8
X_09071_ _13772_/D _13772_/Q _10122_/A0 _09127_/S VDD VSS sg13g2_mux2_1
XFILLER_120_1119 VDD VSS sg13g2_fill_2
XFILLER_11_1414 VDD VSS sg13g2_decap_8
XFILLER_135_418 VDD VSS sg13g2_decap_8
XFILLER_147_278 VDD VSS sg13g2_fill_1
X_08022_ _08402_/C _08070_/C _08236_/S VDD VSS sg13g2_nand2_1
XFILLER_129_993 VDD VSS sg13g2_decap_8
XFILLER_144_930 VDD VSS sg13g2_decap_4
XFILLER_128_492 VDD VSS sg13g2_decap_8
XFILLER_162_248 VDD VSS sg13g2_decap_8
X_14456__1816 _14456_/RESET_B VDD VSS sg13g2_tiehi
XFILLER_115_131 VDD VSS sg13g2_decap_8
XFILLER_116_665 VDD VSS sg13g2_decap_8
XFILLER_104_827 VDD VSS sg13g2_decap_8
XFILLER_89_527 VDD VSS sg13g2_decap_8
X_09973_ _14556_/D _10039_/A0 _14556_/Q _09997_/S VDD VSS sg13g2_mux2_1
XFILLER_115_186 VDD VSS sg13g2_decap_4
XFILLER_131_646 VDD VSS sg13g2_decap_4
XFILLER_44_1201 VDD VSS sg13g2_decap_4
XFILLER_39_28 VDD VSS sg13g2_decap_8
XFILLER_118_1059 VDD VSS sg13g2_decap_4
X_08924_ _08924_/X _15044_/Q _14948_/Q _10757_/A VDD VSS sg13g2_mux2_1
XFILLER_48_1381 VDD VSS sg13g2_decap_4
XFILLER_83_1272 VDD VSS sg13g2_decap_8
XFILLER_58_903 VDD VSS sg13g2_fill_2
XFILLER_131_679 VDD VSS sg13g2_decap_8
XFILLER_135_1373 VDD VSS sg13g2_decap_8
Xclkbuf_leaf_44_clk_i _15019_/CLK clkbuf_leaf_46_clk_i/A VDD VSS sg13g2_buf_8
XFILLER_85_722 VDD VSS sg13g2_decap_8
XFILLER_69_273 VDD VSS sg13g2_decap_8
XFILLER_58_936 VDD VSS sg13g2_decap_8
X_14671__1601 _14671_/RESET_B VDD VSS sg13g2_tiehi
X_08855_ _13696_/D _16858_/A _08854_/X _08858_/S VDD VSS sg13g2_mux2_1
XFILLER_69_284 VDD VSS sg13g2_fill_1
XFILLER_131_1226 VDD VSS sg13g2_decap_8
XFILLER_170_1275 VDD VSS sg13g2_fill_1
XFILLER_69_295 VDD VSS sg13g2_decap_8
X_07806_ _07948_/A _07807_/C _08476_/A VDD VSS sg13g2_and2_1
XFILLER_57_457 VDD VSS sg13g2_fill_2
X_08786_ _13680_/D _08728_/Y _08785_/Y _08784_/Y VDD VSS sg13g2_a21oi_1
XFILLER_84_254 VDD VSS sg13g2_decap_8
XFILLER_85_799 VDD VSS sg13g2_decap_8
XFILLER_55_49 VDD VSS sg13g2_decap_8
XFILLER_26_822 VDD VSS sg13g2_decap_8
X_07737_ _07737_/Y _10213_/A _07737_/B VDD VSS sg13g2_nand2_1
XFILLER_84_298 VDD VSS sg13g2_decap_8
XFILLER_77_1021 VDD VSS sg13g2_decap_8
Xclkbuf_leaf_59_clk_i clkload78/A clkbuf_leaf_59_clk_i/A VDD VSS sg13g2_buf_8
XFILLER_77_1032 VDD VSS sg13g2_fill_1
XFILLER_37_181 VDD VSS sg13g2_decap_8
XFILLER_169_7 VDD VSS sg13g2_decap_8
XFILLER_25_332 VDD VSS sg13g2_decap_8
XFILLER_111_22 VDD VSS sg13g2_fill_2
XFILLER_129_1122 VDD VSS sg13g2_decap_8
XFILLER_168_1171 VDD VSS sg13g2_decap_8
XFILLER_38_1005 VDD VSS sg13g2_fill_1
X_07668_ _10171_/D _13613_/B _13613_/C VDD VSS sg13g2_nand2_1
XFILLER_52_140 VDD VSS sg13g2_decap_8
XFILLER_164_1024 VDD VSS sg13g2_decap_8
XFILLER_81_983 VDD VSS sg13g2_decap_8
XFILLER_77_1076 VDD VSS sg13g2_decap_4
X_13944__2328 _13944_/RESET_B VDD VSS sg13g2_tiehi
XFILLER_53_685 VDD VSS sg13g2_decap_8
XFILLER_26_899 VDD VSS sg13g2_fill_1
X_09407_ _14010_/D _09638_/A0 _14010_/Q _09407_/S VDD VSS sg13g2_mux2_1
XFILLER_41_836 VDD VSS sg13g2_decap_8
XFILLER_0_1394 VDD VSS sg13g2_decap_8
XFILLER_90_1210 VDD VSS sg13g2_decap_8
XFILLER_25_398 VDD VSS sg13g2_decap_8
XFILLER_129_1188 VDD VSS sg13g2_fill_1
XFILLER_179_860 VDD VSS sg13g2_decap_8
XFILLER_111_99 VDD VSS sg13g2_decap_8
XFILLER_16_1314 VDD VSS sg13g2_decap_8
XFILLER_139_724 VDD VSS sg13g2_decap_8
XFILLER_185_329 VDD VSS sg13g2_decap_8
X_09338_ _13945_/D _09472_/A0 _13945_/Q _09338_/S VDD VSS sg13g2_mux2_1
XFILLER_55_1385 VDD VSS sg13g2_fill_1
XFILLER_40_368 VDD VSS sg13g2_fill_2
XFILLER_51_1227 VDD VSS sg13g2_decap_8
XFILLER_138_223 VDD VSS sg13g2_fill_1
XFILLER_103_1306 VDD VSS sg13g2_decap_8
XFILLER_178_392 VDD VSS sg13g2_decap_8
XFILLER_138_234 VDD VSS sg13g2_decap_8
X_09269_ _13878_/D _13878_/Q _09966_/A1 _09271_/S VDD VSS sg13g2_mux2_1
XFILLER_126_407 VDD VSS sg13g2_fill_1
X_11300_ _11300_/X _14685_/Q _14717_/Q _13757_/Q _13789_/Q _11212_/S _11300_/S1 VDD
+ VSS sg13g2_mux4_1
XFILLER_14_1071 VDD VSS sg13g2_decap_8
X_12280_ _12280_/Y _12280_/A _12280_/B VDD VSS sg13g2_xnor2_1
XFILLER_4_203 VDD VSS sg13g2_decap_8
XFILLER_181_546 VDD VSS sg13g2_decap_8
X_11231_ _11231_/X _11230_/X _11227_/X _11832_/C VDD VSS sg13g2_mux2_1
XFILLER_107_654 VDD VSS sg13g2_decap_4
XFILLER_107_665 VDD VSS sg13g2_fill_2
XFILLER_20_63 VDD VSS sg13g2_decap_8
XFILLER_1_910 VDD VSS sg13g2_decap_8
XFILLER_106_175 VDD VSS sg13g2_decap_8
X_11162_ _11162_/Y _14953_/Q _08933_/S _11152_/B _11180_/C _10781_/X VDD VSS sg13g2_a221oi_1
XFILLER_134_495 VDD VSS sg13g2_decap_8
XFILLER_171_1006 VDD VSS sg13g2_decap_8
XFILLER_136_1137 VDD VSS sg13g2_decap_8
XFILLER_84_1069 VDD VSS sg13g2_decap_4
XFILLER_0_420 VDD VSS sg13g2_decap_8
XFILLER_66_1470 VDD VSS sg13g2_decap_8
XFILLER_121_134 VDD VSS sg13g2_decap_8
X_10113_ _14691_/D _10146_/A1 _14691_/Q _10135_/S VDD VSS sg13g2_mux2_1
XFILLER_150_977 VDD VSS sg13g2_decap_8
XFILLER_96_45 VDD VSS sg13g2_fill_2
XFILLER_95_508 VDD VSS sg13g2_decap_8
X_11093_ _11093_/Y _11094_/B _11118_/C VDD VSS sg13g2_nand2_1
XFILLER_27_1454 VDD VSS sg13g2_decap_8
XFILLER_1_987 VDD VSS sg13g2_decap_8
XFILLER_76_711 VDD VSS sg13g2_decap_8
XFILLER_49_925 VDD VSS sg13g2_fill_2
XFILLER_114_1424 VDD VSS sg13g2_decap_8
XFILLER_62_1356 VDD VSS sg13g2_fill_2
X_14921_ _14921_/Q clkload69/A _14921_/D _14921_/RESET_B VDD VSS sg13g2_dfrbpq_1
X_10044_ _14625_/D _10077_/A0 _14625_/Q _10064_/S VDD VSS sg13g2_mux2_1
XFILLER_0_497 VDD VSS sg13g2_decap_8
XFILLER_102_381 VDD VSS sg13g2_decap_8
XFILLER_102_392 VDD VSS sg13g2_fill_1
X_14793__3013 _14793_/RESET_B VDD VSS sg13g2_tiehi
XFILLER_76_755 VDD VSS sg13g2_decap_4
XFILLER_48_457 VDD VSS sg13g2_decap_8
XFILLER_97_1419 VDD VSS sg13g2_fill_1
XFILLER_21_1020 VDD VSS sg13g2_decap_8
X_14852_ _14852_/Q _14876_/CLK _14852_/D _14852_/RESET_B VDD VSS sg13g2_dfrbpq_1
XFILLER_75_265 VDD VSS sg13g2_decap_8
XFILLER_29_660 VDD VSS sg13g2_decap_8
XFILLER_91_725 VDD VSS sg13g2_decap_8
X_13803_ _13803_/Q clkload9/A _13803_/D _13803_/RESET_B VDD VSS sg13g2_dfrbpq_1
XFILLER_112_1181 VDD VSS sg13g2_fill_1
X_14783_ _14783_/Q clkload62/A _14783_/D _14783_/RESET_B VDD VSS sg13g2_dfrbpq_1
X_11995_ _11995_/X _13841_/Q _13873_/Q _13905_/Q _13937_/Q _11997_/S0 _11997_/S1 VDD
+ VSS sg13g2_mux4_1
XFILLER_16_343 VDD VSS sg13g2_decap_8
XFILLER_1_1169 VDD VSS sg13g2_decap_8
X_13734_ _13734_/Q clkload18/A _13734_/D _13734_/RESET_B VDD VSS sg13g2_dfrbpq_1
XFILLER_44_652 VDD VSS sg13g2_fill_1
X_10946_ _10946_/Y _10946_/A _10946_/B VDD VSS sg13g2_nand2_1
X_14534__1738 _14534_/RESET_B VDD VSS sg13g2_tiehi
X_13665_ _13665_/Q clkload73/A _13665_/D _13665_/RESET_B VDD VSS sg13g2_dfrbpq_1
XFILLER_31_324 VDD VSS sg13g2_decap_8
X_10877_ _10878_/B _10897_/D _10897_/B _10897_/A VDD VSS sg13g2_o21ai_1
XFILLER_160_1411 VDD VSS sg13g2_fill_1
X_12616_ _12616_/X _14254_/Q _14286_/Q _14318_/Q _14350_/Q wire940/X _12620_/S1 VDD
+ VSS sg13g2_mux4_1
XFILLER_34_1414 VDD VSS sg13g2_decap_8
XFILLER_31_357 VDD VSS sg13g2_decap_4
XFILLER_176_329 VDD VSS sg13g2_decap_8
X_13596_ _13596_/Y _13600_/A _13600_/C VDD VSS sg13g2_nand2_1
XFILLER_84_7 VDD VSS sg13g2_fill_2
XFILLER_12_560 VDD VSS sg13g2_decap_8
XFILLER_160_1444 VDD VSS sg13g2_fill_1
X_12547_ _12547_/X _14569_/Q _14601_/Q _14633_/Q _14665_/Q _12550_/S0 _12550_/S1 VDD
+ VSS sg13g2_mux4_1
XFILLER_129_256 VDD VSS sg13g2_decap_8
X_14824__2982 _14824_/RESET_B VDD VSS sg13g2_tiehi
XFILLER_145_716 VDD VSS sg13g2_decap_8
XFILLER_8_553 VDD VSS sg13g2_decap_8
XFILLER_177_70 VDD VSS sg13g2_decap_8
XFILLER_144_204 VDD VSS sg13g2_decap_4
XFILLER_117_429 VDD VSS sg13g2_decap_8
XFILLER_6_21 VDD VSS sg13g2_decap_8
X_12478_ _12478_/X _13732_/Q _14084_/Q _14436_/Q _14532_/Q _12710_/S0 _12710_/S1 VDD
+ VSS sg13g2_mux4_1
XANTENNA_3 _09159_/Y VDD VSS sg13g2_antennanp
XFILLER_144_237 VDD VSS sg13g2_decap_8
X_14217_ _14217_/Q clkload35/A _14217_/D _14217_/RESET_B VDD VSS sg13g2_dfrbpq_1
X_11429_ _11430_/B _11385_/B _11385_/A _11383_/Y VDD VSS sg13g2_o21ai_1
X_15197_ _15197_/Q clkload73/A _15197_/D _15197_/RESET_B VDD VSS sg13g2_dfrbpq_1
XFILLER_67_1234 VDD VSS sg13g2_decap_4
XFILLER_6_98 VDD VSS sg13g2_decap_8
XFILLER_126_996 VDD VSS sg13g2_decap_8
XFILLER_28_1207 VDD VSS sg13g2_decap_8
XFILLER_141_933 VDD VSS sg13g2_fill_1
X_14148_ _14148_/Q _14503_/CLK _14148_/D _14148_/RESET_B VDD VSS sg13g2_dfrbpq_1
XFILLER_4_770 VDD VSS sg13g2_decap_8
XFILLER_112_112 VDD VSS sg13g2_decap_8
XFILLER_158_1395 VDD VSS sg13g2_decap_8
XFILLER_113_646 VDD VSS sg13g2_fill_1
XFILLER_141_955 VDD VSS sg13g2_decap_8
XFILLER_99_869 VDD VSS sg13g2_decap_8
XFILLER_98_346 VDD VSS sg13g2_decap_8
XFILLER_154_1248 VDD VSS sg13g2_decap_8
XFILLER_3_280 VDD VSS sg13g2_decap_8
XFILLER_140_454 VDD VSS sg13g2_decap_4
XFILLER_141_977 VDD VSS sg13g2_fill_2
XFILLER_80_1412 VDD VSS sg13g2_decap_8
X_14079_ _14079_/Q clkload21/A _14079_/D _14079_/RESET_B VDD VSS sg13g2_dfrbpq_1
XFILLER_112_167 VDD VSS sg13g2_decap_4
XFILLER_6_1036 VDD VSS sg13g2_decap_8
XFILLER_39_435 VDD VSS sg13g2_decap_8
XFILLER_67_755 VDD VSS sg13g2_decap_8
XFILLER_66_221 VDD VSS sg13g2_fill_2
Xfanout1070 _10793_/A _10781_/C VDD VSS sg13g2_buf_1
Xfanout1081 _09016_/C _10781_/B VDD VSS sg13g2_buf_1
X_08640_ _08640_/X _08640_/A _08640_/B _08640_/C _08640_/D VDD VSS sg13g2_and4_1
Xfanout1092 _07956_/A _15011_/Q VDD VSS sg13g2_buf_1
XFILLER_27_608 VDD VSS sg13g2_decap_8
XFILLER_54_416 VDD VSS sg13g2_fill_1
XFILLER_94_585 VDD VSS sg13g2_fill_2
X_08571_ _08571_/Y _08574_/C _08574_/D VDD VSS sg13g2_nand2_1
XFILLER_82_747 VDD VSS sg13g2_decap_8
XFILLER_66_298 VDD VSS sg13g2_decap_8
XFILLER_54_438 VDD VSS sg13g2_decap_8
XFILLER_148_1019 VDD VSS sg13g2_decap_8
XFILLER_130_1292 VDD VSS sg13g2_decap_8
XFILLER_47_490 VDD VSS sg13g2_decap_8
XFILLER_63_972 VDD VSS sg13g2_decap_8
XFILLER_74_1216 VDD VSS sg13g2_decap_8
XFILLER_39_1336 VDD VSS sg13g2_fill_2
XFILLER_179_112 VDD VSS sg13g2_decap_8
XFILLER_35_685 VDD VSS sg13g2_decap_8
XFILLER_23_825 VDD VSS sg13g2_decap_4
XFILLER_90_791 VDD VSS sg13g2_decap_8
XFILLER_39_1369 VDD VSS sg13g2_fill_2
XFILLER_161_1219 VDD VSS sg13g2_decap_8
XFILLER_50_655 VDD VSS sg13g2_fill_1
XFILLER_179_189 VDD VSS sg13g2_decap_8
XFILLER_31_880 VDD VSS sg13g2_fill_1
XFILLER_124_1052 VDD VSS sg13g2_decap_8
X_09123_ _09150_/C _14919_/Q _13190_/A _10760_/A VDD VSS sg13g2_and3_1
XFILLER_30_390 VDD VSS sg13g2_decap_4
XFILLER_175_362 VDD VSS sg13g2_decap_8
XFILLER_11_1211 VDD VSS sg13g2_decap_8
X_09054_ _10725_/B _09072_/B _15036_/Q _09053_/Y VDD VSS sg13g2_o21ai_1
X_08005_ _08005_/X _08427_/A3 _07945_/B _08456_/B _08470_/B _08253_/S0 _08033_/A VDD
+ VSS sg13g2_mux4_1
XFILLER_163_579 VDD VSS sg13g2_decap_8
XFILLER_2_707 VDD VSS sg13g2_decap_8
XFILLER_102_1394 VDD VSS sg13g2_decap_8
XFILLER_104_602 VDD VSS sg13g2_fill_1
XFILLER_116_462 VDD VSS sg13g2_decap_8
X_15042__2634 _15042_/RESET_B VDD VSS sg13g2_tiehi
XFILLER_11_1288 VDD VSS sg13g2_decap_8
XFILLER_173_28 VDD VSS sg13g2_decap_8
XFILLER_1_217 VDD VSS sg13g2_decap_8
Xclkbuf_5_30__f_clk_i clkbuf_leaf_66_clk_i/A clkbuf_4_15_0_clk_i/X VDD VSS sg13g2_buf_16
XFILLER_172_1326 VDD VSS sg13g2_decap_8
XFILLER_172_1359 VDD VSS sg13g2_decap_8
X_09956_ _14540_/D _14540_/Q _09956_/A1 _09958_/S VDD VSS sg13g2_mux2_1
XFILLER_58_700 VDD VSS sg13g2_decap_8
X_08907_ _08907_/Y _10725_/A _14944_/Q VDD VSS sg13g2_nand2_1
X_09887_ _14473_/D _09920_/A1 _14473_/Q _09903_/S VDD VSS sg13g2_mux2_1
XFILLER_57_210 VDD VSS sg13g2_decap_8
X_08838_ _08838_/Y _10781_/C _10697_/B VDD VSS sg13g2_nand2_1
XFILLER_44_1097 VDD VSS sg13g2_decap_8
XFILLER_100_874 VDD VSS sg13g2_decap_8
XFILLER_46_928 VDD VSS sg13g2_decap_8
XFILLER_57_265 VDD VSS sg13g2_decap_4
XFILLER_122_21 VDD VSS sg13g2_decap_8
XFILLER_79_1149 VDD VSS sg13g2_decap_8
X_08769_ _08769_/Y _13675_/Q _08775_/B VDD VSS sg13g2_nor2_1
XFILLER_22_1373 VDD VSS sg13g2_decap_8
XFILLER_2_1456 VDD VSS sg13g2_decap_8
XFILLER_82_14 VDD VSS sg13g2_decap_4
X_10800_ _10800_/Y _10800_/A _13294_/B VDD VSS sg13g2_nand2_1
XFILLER_72_257 VDD VSS sg13g2_fill_2
XFILLER_54_961 VDD VSS sg13g2_decap_8
X_11780_ _11780_/Y _11910_/A _11912_/A VDD VSS sg13g2_xnor2_1
XFILLER_57_1436 VDD VSS sg13g2_fill_2
XFILLER_82_58 VDD VSS sg13g2_decap_8
XFILLER_18_1409 VDD VSS sg13g2_decap_8
XFILLER_14_847 VDD VSS sg13g2_decap_8
X_10731_ _14910_/D _10999_/B1 _10995_/B _10730_/Y VDD VSS sg13g2_o21ai_1
XFILLER_53_482 VDD VSS sg13g2_decap_8
XFILLER_25_173 VDD VSS sg13g2_decap_8
XFILLER_183_1466 VDD VSS sg13g2_decap_8
XFILLER_0_1191 VDD VSS sg13g2_decap_8
XFILLER_183_1477 VDD VSS sg13g2_fill_2
XFILLER_15_63 VDD VSS sg13g2_decap_8
XFILLER_13_357 VDD VSS sg13g2_decap_8
XFILLER_16_1111 VDD VSS sg13g2_decap_8
X_13450_ _13455_/B _15172_/Q _15173_/Q VDD VSS sg13g2_nand2b_1
X_10662_ _10664_/C _14892_/Q _10666_/D _14893_/Q VDD VSS sg13g2_a21oi_1
XFILLER_185_126 VDD VSS sg13g2_decap_8
XFILLER_55_1182 VDD VSS sg13g2_decap_4
XFILLER_181_1190 VDD VSS sg13g2_decap_8
X_12401_ _12401_/Y _15122_/Q _12348_/A _12442_/A2 _13690_/Q _13282_/A1 VDD VSS sg13g2_a221oi_1
XFILLER_51_1024 VDD VSS sg13g2_decap_8
XFILLER_90_1084 VDD VSS sg13g2_decap_8
XFILLER_142_1163 VDD VSS sg13g2_decap_8
X_13381_ _13382_/B _13401_/C _13396_/C VDD VSS sg13g2_nor2_1
XFILLER_127_705 VDD VSS sg13g2_fill_1
XFILLER_12_1008 VDD VSS sg13g2_decap_8
XFILLER_139_565 VDD VSS sg13g2_decap_8
X_10593_ _10595_/C _14874_/Q _10597_/D _14875_/Q VDD VSS sg13g2_a21oi_1
XFILLER_103_1136 VDD VSS sg13g2_decap_8
XFILLER_127_727 VDD VSS sg13g2_fill_1
XFILLER_16_1188 VDD VSS sg13g2_decap_8
X_15120_ _15120_/Q clkload81/A _15120_/D _15120_/RESET_B VDD VSS sg13g2_dfrbpq_1
X_12332_ _12332_/Y _12308_/Y _12310_/Y _11224_/A VDD VSS sg13g2_a21oi_1
XFILLER_103_1158 VDD VSS sg13g2_fill_1
XFILLER_126_215 VDD VSS sg13g2_decap_8
XFILLER_110_0 VDD VSS sg13g2_decap_8
XFILLER_182_866 VDD VSS sg13g2_decap_8
XFILLER_181_343 VDD VSS sg13g2_decap_8
X_15051_ _15051_/Q clkload81/A _15051_/D _15051_/RESET_B VDD VSS sg13g2_dfrbpq_1
X_12263_ _12263_/Y _12261_/Y _12263_/B _12263_/C VDD VSS sg13g2_nand3b_1
XFILLER_31_95 VDD VSS sg13g2_decap_8
XFILLER_5_567 VDD VSS sg13g2_decap_8
X_14002_ _14002_/Q _14674_/CLK _14002_/D _14002_/RESET_B VDD VSS sg13g2_dfrbpq_1
XFILLER_123_922 VDD VSS sg13g2_decap_8
X_11214_ _11216_/A _11894_/B _11211_/X _11213_/X VDD VSS sg13g2_a21oi_1
XFILLER_122_421 VDD VSS sg13g2_decap_8
X_12194_ _12194_/X _14921_/Q _12294_/A2 _12193_/Y VDD VSS sg13g2_a21o_1
Xoutput40 mem_axi_araddr[11] output40/A VDD VSS sg13g2_buf_1
Xoutput51 mem_axi_araddr[22] _13713_/Q VDD VSS sg13g2_buf_1
XFILLER_150_752 VDD VSS sg13g2_decap_8
Xoutput62 mem_axi_araddr[3] _16856_/A VDD VSS sg13g2_buf_1
Xoutput73 mem_axi_awaddr[12] _16865_/X VDD VSS sg13g2_buf_1
X_11145_ _11150_/B _11172_/A _11164_/B VDD VSS sg13g2_xnor2_1
Xoutput84 mem_axi_awaddr[23] _16876_/X VDD VSS sg13g2_buf_1
Xoutput95 mem_axi_awaddr[4] _16857_/X VDD VSS sg13g2_buf_1
XFILLER_27_1251 VDD VSS sg13g2_decap_8
XFILLER_1_784 VDD VSS sg13g2_decap_8
XFILLER_7_1323 VDD VSS sg13g2_decap_8
X_11076_ _11077_/B _11088_/A _11118_/A _11058_/Y VDD VSS sg13g2_a21oi_1
XFILLER_0_294 VDD VSS sg13g2_decap_8
XFILLER_62_1175 VDD VSS sg13g2_decap_8
XFILLER_49_755 VDD VSS sg13g2_decap_4
XFILLER_48_232 VDD VSS sg13g2_decap_4
X_14904_ _14904_/Q _15226_/CLK _14904_/D _14904_/RESET_B VDD VSS sg13g2_dfrbpq_1
X_10027_ _14609_/D _10093_/A0 _14609_/Q _10027_/S VDD VSS sg13g2_mux2_1
XFILLER_23_1148 VDD VSS sg13g2_decap_8
XFILLER_114_1265 VDD VSS sg13g2_decap_8
XFILLER_40_1440 VDD VSS sg13g2_decap_4
XFILLER_91_522 VDD VSS sg13g2_fill_2
X_14835_ _14835_/Q clkload83/A _14835_/D _14835_/RESET_B VDD VSS sg13g2_dfrbpq_1
XFILLER_17_630 VDD VSS sg13g2_decap_4
XFILLER_45_950 VDD VSS sg13g2_decap_8
XFILLER_63_257 VDD VSS sg13g2_decap_8
X_14757__3052 _14757_/RESET_B VDD VSS sg13g2_tiehi
XFILLER_16_140 VDD VSS sg13g2_decap_8
XFILLER_91_577 VDD VSS sg13g2_decap_8
X_14766_ _14766_/Q clkload88/A _14766_/D _14766_/RESET_B VDD VSS sg13g2_dfrbpq_1
X_11978_ _11978_/Y _11977_/X _11664_/A _11980_/A VDD VSS sg13g2_a21oi_1
XFILLER_44_482 VDD VSS sg13g2_decap_8
X_13717_ _16879_/A clkload70/A _13717_/D _13717_/RESET_B VDD VSS sg13g2_dfrbpq_1
X_10929_ _10929_/Y _10929_/A _11021_/B VDD VSS sg13g2_nand2_1
X_14697_ _14697_/Q _14729_/CLK _14697_/D _14697_/RESET_B VDD VSS sg13g2_dfrbpq_1
XFILLER_32_644 VDD VSS sg13g2_decap_8
XFILLER_177_616 VDD VSS sg13g2_decap_8
X_14196__2076 _14196_/RESET_B VDD VSS sg13g2_tiehi
XFILLER_38_1380 VDD VSS sg13g2_decap_8
XFILLER_176_126 VDD VSS sg13g2_decap_8
X_13648_ _14760_/D _15188_/D _14760_/Q _13652_/S VDD VSS sg13g2_mux2_1
XFILLER_160_1230 VDD VSS sg13g2_decap_4
XFILLER_31_176 VDD VSS sg13g2_decap_8
XFILLER_9_840 VDD VSS sg13g2_decap_8
X_13579_ _15158_/D _13581_/B _13577_/Y _13578_/Y VDD VSS sg13g2_a21oi_1
XFILLER_118_727 VDD VSS sg13g2_decap_8
XFILLER_145_502 VDD VSS sg13g2_decap_8
XFILLER_8_350 VDD VSS sg13g2_decap_8
XFILLER_173_822 VDD VSS sg13g2_decap_8
XFILLER_172_310 VDD VSS sg13g2_decap_8
XFILLER_185_693 VDD VSS sg13g2_decap_8
XFILLER_184_170 VDD VSS sg13g2_fill_1
X_14970__2710 _14970_/RESET_B VDD VSS sg13g2_tiehi
XFILLER_68_2 VDD VSS sg13g2_fill_1
XFILLER_145_557 VDD VSS sg13g2_fill_1
XFILLER_173_888 VDD VSS sg13g2_fill_2
X_15249_ _15249_/Q _15249_/CLK _15249_/D _15249_/RESET_B VDD VSS sg13g2_dfrbpq_1
XFILLER_172_387 VDD VSS sg13g2_decap_8
XFILLER_114_933 VDD VSS sg13g2_decap_8
XFILLER_132_229 VDD VSS sg13g2_decap_8
XFILLER_99_622 VDD VSS sg13g2_fill_1
Xfanout307 _10147_/A1 _10047_/A0 VDD VSS sg13g2_buf_1
X_09810_ _14398_/D _09909_/A1 _14398_/Q _09838_/S VDD VSS sg13g2_mux2_1
XFILLER_87_806 VDD VSS sg13g2_decap_8
XFILLER_59_508 VDD VSS sg13g2_decap_8
Xfanout318 _10141_/A1 _09744_/A1 VDD VSS sg13g2_buf_1
XFILLER_98_154 VDD VSS sg13g2_fill_2
Xfanout329 _10168_/S _10163_/S VDD VSS sg13g2_buf_1
XFILLER_99_699 VDD VSS sg13g2_decap_8
XFILLER_87_839 VDD VSS sg13g2_fill_1
XFILLER_115_1029 VDD VSS sg13g2_decap_8
XFILLER_140_273 VDD VSS sg13g2_decap_4
X_09741_ _14331_/D _14331_/Q _09906_/A1 _09766_/S VDD VSS sg13g2_mux2_1
XFILLER_80_1242 VDD VSS sg13g2_decap_8
XFILLER_80_1253 VDD VSS sg13g2_fill_1
XFILLER_80_1264 VDD VSS sg13g2_fill_1
XFILLER_67_552 VDD VSS sg13g2_decap_8
X_09672_ _14265_/D _09936_/A1 _14265_/Q _09672_/S VDD VSS sg13g2_mux2_1
XFILLER_67_563 VDD VSS sg13g2_fill_2
XFILLER_41_1248 VDD VSS sg13g2_decap_8
XFILLER_28_917 VDD VSS sg13g2_decap_8
XFILLER_132_1376 VDD VSS sg13g2_decap_8
X_08623_ _08623_/Y _07849_/X _08623_/A2 _08654_/B VDD VSS sg13g2_o21ai_1
XFILLER_82_522 VDD VSS sg13g2_decap_8
XFILLER_67_596 VDD VSS sg13g2_decap_8
XFILLER_27_449 VDD VSS sg13g2_decap_8
X_14862__2913 _14862_/RESET_B VDD VSS sg13g2_tiehi
X_08554_ _08554_/Y _08577_/A _08550_/Y _08553_/A VDD VSS sg13g2_o21ai_1
XFILLER_78_1160 VDD VSS sg13g2_decap_8
XFILLER_36_983 VDD VSS sg13g2_decap_8
XFILLER_35_460 VDD VSS sg13g2_decap_8
XFILLER_126_1103 VDD VSS sg13g2_decap_4
XFILLER_39_1155 VDD VSS sg13g2_decap_8
X_08485_ _08485_/Y _07822_/B _08623_/A2 _08654_/B VDD VSS sg13g2_o21ai_1
XFILLER_51_953 VDD VSS sg13g2_decap_8
XFILLER_161_1016 VDD VSS sg13g2_decap_8
X_14026__2246 _14026_/RESET_B VDD VSS sg13g2_tiehi
XFILLER_52_39 VDD VSS sg13g2_fill_2
X_13861__2411 _13861_/RESET_B VDD VSS sg13g2_tiehi
XFILLER_167_126 VDD VSS sg13g2_decap_8
XFILLER_168_28 VDD VSS sg13g2_decap_8
XFILLER_168_649 VDD VSS sg13g2_decap_8
XFILLER_22_154 VDD VSS sg13g2_decap_8
XFILLER_91_1382 VDD VSS sg13g2_fill_1
XFILLER_50_485 VDD VSS sg13g2_decap_8
XFILLER_104_1401 VDD VSS sg13g2_decap_8
XFILLER_17_1453 VDD VSS sg13g2_decap_8
X_14895__2847 _14895_/RESET_B VDD VSS sg13g2_tiehi
Xwire719 wire719/X wire719/A VDD VSS sg13g2_buf_2
XFILLER_148_340 VDD VSS sg13g2_fill_2
X_09106_ _13777_/D _13777_/Q _10093_/A0 _09106_/S VDD VSS sg13g2_mux2_1
X_14241__2031 _14241_/RESET_B VDD VSS sg13g2_tiehi
X_09037_ _09037_/X _09057_/A _09034_/X _09036_/Y VDD VSS sg13g2_a21o_1
XFILLER_117_760 VDD VSS sg13g2_decap_8
XFILLER_151_505 VDD VSS sg13g2_decap_4
XFILLER_184_49 VDD VSS sg13g2_decap_8
X_13894__2378 _13894_/RESET_B VDD VSS sg13g2_tiehi
XFILLER_2_504 VDD VSS sg13g2_decap_8
XFILLER_11_1085 VDD VSS sg13g2_decap_8
XFILLER_151_549 VDD VSS sg13g2_decap_8
XFILLER_85_1153 VDD VSS sg13g2_fill_2
XFILLER_105_955 VDD VSS sg13g2_decap_8
XFILLER_132_741 VDD VSS sg13g2_decap_8
XFILLER_176_1281 VDD VSS sg13g2_decap_8
XFILLER_89_121 VDD VSS sg13g2_decap_8
XFILLER_132_752 VDD VSS sg13g2_fill_2
XFILLER_77_14 VDD VSS sg13g2_decap_8
XFILLER_104_454 VDD VSS sg13g2_decap_8
XFILLER_131_240 VDD VSS sg13g2_decap_8
XFILLER_137_1276 VDD VSS sg13g2_decap_8
XFILLER_120_936 VDD VSS sg13g2_decap_4
Xfanout830 _10647_/D _15250_/Q VDD VSS sg13g2_buf_1
XFILLER_77_316 VDD VSS sg13g2_decap_8
XFILLER_120_947 VDD VSS sg13g2_decap_8
Xfanout841 _12692_/S _12747_/S0 VDD VSS sg13g2_buf_1
XFILLER_63_1451 VDD VSS sg13g2_decap_8
Xfanout852 wire853/A _12761_/S0 VDD VSS sg13g2_buf_1
XFILLER_89_198 VDD VSS sg13g2_decap_8
X_09939_ _14523_/D _14523_/Q _09939_/A1 _09958_/S VDD VSS sg13g2_mux2_1
Xfanout863 _12691_/S1 _12760_/S0 VDD VSS sg13g2_buf_1
Xfanout874 _12633_/S1 _12674_/S1 VDD VSS sg13g2_buf_1
XFILLER_24_1435 VDD VSS sg13g2_decap_8
Xfanout885 _12618_/S1 _12382_/S1 VDD VSS sg13g2_buf_1
XFILLER_133_42 VDD VSS sg13g2_decap_8
X_12950_ _12950_/Y _12947_/Y _12948_/Y _12949_/Y VDD VSS sg13g2_a21oi_1
Xfanout896 _12710_/S1 fanout899/X VDD VSS sg13g2_buf_1
XFILLER_18_427 VDD VSS sg13g2_decap_8
X_11901_ _11902_/A _11898_/Y _11900_/Y _11901_/B1 VDD VSS sg13g2_a21oi_1
XFILLER_93_35 VDD VSS sg13g2_decap_8
X_12881_ _12881_/Y _14772_/Q _13275_/A2 _13140_/B2 VDD VSS sg13g2_o21ai_1
XFILLER_22_1170 VDD VSS sg13g2_decap_8
X_15088__2906 _15088_/RESET_B VDD VSS sg13g2_tiehi
XFILLER_73_566 VDD VSS sg13g2_fill_1
XFILLER_2_1253 VDD VSS sg13g2_decap_8
X_14620_ _14620_/Q _14620_/CLK _14620_/D _14620_/RESET_B VDD VSS sg13g2_dfrbpq_1
X_11832_ _11832_/Y _11830_/Y _11832_/B _11832_/C VDD VSS sg13g2_nand3b_1
XFILLER_73_588 VDD VSS sg13g2_decap_8
XFILLER_96_1282 VDD VSS sg13g2_decap_8
X_14551_ _14551_/Q _15019_/CLK _14551_/D _14551_/RESET_B VDD VSS sg13g2_dfrbpq_1
XFILLER_57_1244 VDD VSS sg13g2_fill_1
XFILLER_26_84 VDD VSS sg13g2_decap_8
XFILLER_158_0 VDD VSS sg13g2_decap_8
XFILLER_18_1206 VDD VSS sg13g2_decap_8
X_11763_ _11763_/Y _11763_/A _11763_/B VDD VSS sg13g2_nand2_1
XFILLER_14_644 VDD VSS sg13g2_decap_8
XFILLER_92_1146 VDD VSS sg13g2_fill_2
XFILLER_53_290 VDD VSS sg13g2_decap_8
XFILLER_53_1108 VDD VSS sg13g2_decap_8
XFILLER_148_1394 VDD VSS sg13g2_fill_2
XFILLER_183_1285 VDD VSS sg13g2_decap_4
X_13502_ _13504_/A _13502_/A _13502_/B _15175_/D _13502_/D VDD VSS sg13g2_or4_1
X_10714_ _10714_/Y _14906_/Q _11196_/B VDD VSS sg13g2_nand2_1
XFILLER_13_154 VDD VSS sg13g2_decap_8
X_14482_ _14482_/Q _14674_/CLK _14482_/D _14482_/RESET_B VDD VSS sg13g2_dfrbpq_1
X_14451__1821 _14451_/RESET_B VDD VSS sg13g2_tiehi
X_11694_ _11694_/Y _11694_/A _11694_/B _12237_/C VDD VSS sg13g2_nand3_1
XFILLER_109_1389 VDD VSS sg13g2_decap_8
XFILLER_70_1433 VDD VSS sg13g2_decap_8
X_13433_ _13433_/Y _13433_/A _13435_/B _13444_/C VDD VSS sg13g2_nor3_1
X_10645_ _14889_/D _14889_/Q _10643_/C _10644_/Y VDD VSS sg13g2_a21oi_1
XFILLER_9_147 VDD VSS sg13g2_decap_8
XFILLER_107_1080 VDD VSS sg13g2_decap_8
XFILLER_127_502 VDD VSS sg13g2_decap_8
XFILLER_139_362 VDD VSS sg13g2_fill_2
XFILLER_31_1417 VDD VSS sg13g2_decap_4
XFILLER_10_861 VDD VSS sg13g2_decap_8
XFILLER_154_310 VDD VSS sg13g2_decap_8
X_13364_ _13435_/A _13396_/C _13364_/B VDD VSS sg13g2_nand2_1
XFILLER_154_321 VDD VSS sg13g2_fill_1
XFILLER_177_1001 VDD VSS sg13g2_decap_8
XFILLER_182_630 VDD VSS sg13g2_decap_8
X_10576_ _10584_/C _14870_/Q _10647_/C _10576_/C _10576_/D VDD VSS sg13g2_and4_1
XFILLER_155_866 VDD VSS sg13g2_decap_8
XFILLER_115_708 VDD VSS sg13g2_decap_8
XFILLER_155_877 VDD VSS sg13g2_fill_2
X_15103_ _15103_/Q _15216_/CLK _15103_/D _15103_/RESET_B VDD VSS sg13g2_dfrbpq_1
X_12315_ _12315_/Y _12311_/Y _12312_/Y _12314_/Y _12313_/Y _12317_/B VDD VSS sg13g2_a221oi_1
XFILLER_6_854 VDD VSS sg13g2_decap_8
XFILLER_181_140 VDD VSS sg13g2_decap_8
X_13295_ _13295_/Y _07672_/X _15053_/Q _13294_/Y VDD VSS sg13g2_a21oi_1
XFILLER_154_376 VDD VSS sg13g2_decap_8
X_13724__2548 _13724_/RESET_B VDD VSS sg13g2_tiehi
XFILLER_5_364 VDD VSS sg13g2_decap_8
XFILLER_177_1078 VDD VSS sg13g2_fill_2
X_14484__1788 _14484_/RESET_B VDD VSS sg13g2_tiehi
X_15034_ _15034_/Q _15237_/CLK _15034_/D _15034_/RESET_B VDD VSS sg13g2_dfrbpq_1
XFILLER_68_1351 VDD VSS sg13g2_fill_1
X_12246_ _12246_/X _12246_/A _12246_/B VDD VSS sg13g2_and2_1
XFILLER_155_1321 VDD VSS sg13g2_decap_8
XFILLER_47_7 VDD VSS sg13g2_decap_8
XFILLER_9_1407 VDD VSS sg13g2_decap_8
X_12177_ _12177_/Y _12243_/A1 _14486_/Q VDD VSS sg13g2_nand2b_1
XFILLER_155_1365 VDD VSS sg13g2_decap_4
XFILLER_96_614 VDD VSS sg13g2_decap_8
XFILLER_111_936 VDD VSS sg13g2_decap_8
XFILLER_151_1207 VDD VSS sg13g2_fill_2
XFILLER_155_1387 VDD VSS sg13g2_fill_2
X_11128_ _11128_/Y _11128_/A _11128_/B VDD VSS sg13g2_nand2_1
XFILLER_7_1120 VDD VSS sg13g2_decap_8
XFILLER_1_581 VDD VSS sg13g2_decap_8
XFILLER_68_349 VDD VSS sg13g2_decap_8
XFILLER_3_77 VDD VSS sg13g2_decap_8
XFILLER_95_146 VDD VSS sg13g2_decap_8
X_14104__2168 _14104_/RESET_B VDD VSS sg13g2_tiehi
XFILLER_49_552 VDD VSS sg13g2_decap_8
XFILLER_110_479 VDD VSS sg13g2_decap_8
X_11059_ _11118_/A _11202_/A _11078_/B VDD VSS sg13g2_xnor2_1
XFILLER_67_80 VDD VSS sg13g2_fill_1
XFILLER_114_1062 VDD VSS sg13g2_decap_8
XFILLER_77_883 VDD VSS sg13g2_decap_4
XFILLER_7_1197 VDD VSS sg13g2_decap_8
XFILLER_49_596 VDD VSS sg13g2_decap_8
XFILLER_149_1114 VDD VSS sg13g2_fill_1
XFILLER_64_555 VDD VSS sg13g2_fill_2
XFILLER_58_1008 VDD VSS sg13g2_decap_8
XFILLER_37_769 VDD VSS sg13g2_decap_8
XFILLER_25_909 VDD VSS sg13g2_fill_1
XFILLER_40_1281 VDD VSS sg13g2_decap_8
XFILLER_184_1027 VDD VSS sg13g2_fill_2
X_14818_ _14818_/Q _14886_/CLK _14818_/D _14818_/RESET_B VDD VSS sg13g2_dfrbpq_1
XFILLER_91_363 VDD VSS sg13g2_decap_8
XFILLER_36_268 VDD VSS sg13g2_decap_8
XFILLER_51_216 VDD VSS sg13g2_decap_8
XFILLER_162_1303 VDD VSS sg13g2_fill_2
XFILLER_178_914 VDD VSS sg13g2_decap_8
X_14749_ _14749_/Q clkload90/A _14749_/D _14749_/RESET_B VDD VSS sg13g2_dfrbpq_1
XFILLER_162_1325 VDD VSS sg13g2_fill_2
XFILLER_75_1377 VDD VSS sg13g2_decap_8
XFILLER_177_413 VDD VSS sg13g2_decap_8
XFILLER_60_761 VDD VSS sg13g2_decap_8
XFILLER_36_1339 VDD VSS sg13g2_fill_2
XFILLER_32_452 VDD VSS sg13g2_decap_8
X_08270_ _08270_/Y _08270_/A _08270_/B _08270_/C VDD VSS sg13g2_nand3_1
XFILLER_162_1347 VDD VSS sg13g2_fill_2
XFILLER_33_997 VDD VSS sg13g2_decap_8
X_15056__2600 _15056_/RESET_B VDD VSS sg13g2_tiehi
XFILLER_20_647 VDD VSS sg13g2_decap_8
XFILLER_34_1052 VDD VSS sg13g2_decap_8
XFILLER_34_1063 VDD VSS sg13g2_decap_8
XFILLER_158_682 VDD VSS sg13g2_decap_8
XFILLER_73_0 VDD VSS sg13g2_decap_4
XFILLER_185_490 VDD VSS sg13g2_decap_8
XFILLER_69_1115 VDD VSS sg13g2_decap_8
XFILLER_146_866 VDD VSS sg13g2_decap_8
XFILLER_69_1126 VDD VSS sg13g2_fill_1
XFILLER_106_719 VDD VSS sg13g2_decap_8
XFILLER_172_140 VDD VSS sg13g2_decap_8
XFILLER_173_674 VDD VSS sg13g2_decap_8
XFILLER_12_1372 VDD VSS sg13g2_decap_8
XFILLER_161_825 VDD VSS sg13g2_fill_2
XFILLER_145_376 VDD VSS sg13g2_decap_8
XFILLER_156_1107 VDD VSS sg13g2_fill_1
XFILLER_133_527 VDD VSS sg13g2_decap_8
XFILLER_160_313 VDD VSS sg13g2_decap_8
XFILLER_161_836 VDD VSS sg13g2_fill_2
X_14314__1958 _14314_/RESET_B VDD VSS sg13g2_tiehi
XFILLER_86_1451 VDD VSS sg13g2_fill_2
XFILLER_126_590 VDD VSS sg13g2_decap_8
XFILLER_82_1304 VDD VSS sg13g2_decap_8
XFILLER_47_1435 VDD VSS sg13g2_decap_8
XFILLER_114_763 VDD VSS sg13g2_decap_8
XFILLER_113_240 VDD VSS sg13g2_decap_8
XFILLER_99_463 VDD VSS sg13g2_decap_8
XFILLER_141_571 VDD VSS sg13g2_fill_2
XFILLER_59_327 VDD VSS sg13g2_decap_8
Xfanout148 _10168_/A1 fanout152/X VDD VSS sg13g2_buf_1
Xfanout159 _10166_/A1 fanout162/X VDD VSS sg13g2_buf_1
X_07985_ _13290_/B _07985_/A _07985_/B _07985_/C _07985_/D VDD VSS sg13g2_nand4_1
XFILLER_47_28 VDD VSS sg13g2_decap_4
X_09724_ _14315_/D _09724_/A0 _14315_/Q _09731_/S VDD VSS sg13g2_mux2_1
XFILLER_110_991 VDD VSS sg13g2_decap_8
XFILLER_41_1056 VDD VSS sg13g2_decap_8
XFILLER_132_1184 VDD VSS sg13g2_fill_1
XFILLER_95_691 VDD VSS sg13g2_decap_8
XFILLER_67_382 VDD VSS sg13g2_decap_8
XFILLER_27_213 VDD VSS sg13g2_decap_8
X_09655_ _14248_/D _10151_/A1 _14248_/Q _09671_/S VDD VSS sg13g2_mux2_1
XFILLER_132_1195 VDD VSS sg13g2_fill_1
XFILLER_55_544 VDD VSS sg13g2_decap_8
XFILLER_55_555 VDD VSS sg13g2_fill_1
XFILLER_82_341 VDD VSS sg13g2_decap_8
X_08606_ _08606_/Y _08282_/Y wire681/X _08605_/X VDD VSS sg13g2_o21ai_1
XFILLER_83_875 VDD VSS sg13g2_decap_8
X_09586_ _14183_/D _14183_/Q _09619_/A0 _09596_/S VDD VSS sg13g2_mux2_1
XFILLER_93_1411 VDD VSS sg13g2_fill_2
XFILLER_43_739 VDD VSS sg13g2_decap_8
XFILLER_167_1269 VDD VSS sg13g2_fill_2
X_14259__2013 _14259_/RESET_B VDD VSS sg13g2_tiehi
X_08537_ _08537_/X _08598_/A3 _07812_/B _07818_/B _07821_/B _08686_/S0 _08598_/S1
+ VDD VSS sg13g2_mux4_1
XFILLER_151_7 VDD VSS sg13g2_decap_8
XFILLER_70_558 VDD VSS sg13g2_fill_1
XFILLER_35_290 VDD VSS sg13g2_fill_1
XFILLER_179_49 VDD VSS sg13g2_decap_8
XFILLER_168_435 VDD VSS sg13g2_decap_8
XFILLER_180_1447 VDD VSS sg13g2_fill_2
X_08468_ _08469_/B _08617_/A _08301_/X _08034_/Y VDD VSS sg13g2_o21ai_1
XFILLER_156_608 VDD VSS sg13g2_decap_8
XFILLER_17_1250 VDD VSS sg13g2_decap_8
XFILLER_11_658 VDD VSS sg13g2_decap_8
XFILLER_156_619 VDD VSS sg13g2_fill_1
X_08399_ _08410_/C _08201_/A _08016_/Y _08688_/C VDD VSS sg13g2_o21ai_1
XFILLER_177_980 VDD VSS sg13g2_decap_8
XFILLER_104_1231 VDD VSS sg13g2_decap_8
XFILLER_149_682 VDD VSS sg13g2_decap_8
XFILLER_183_427 VDD VSS sg13g2_decap_8
XFILLER_10_168 VDD VSS sg13g2_decap_8
X_10430_ _14832_/D _10434_/C _10577_/B _10430_/C VDD VSS sg13g2_nor3_1
XFILLER_148_170 VDD VSS sg13g2_decap_8
XFILLER_12_42 VDD VSS sg13g2_decap_8
XFILLER_100_1117 VDD VSS sg13g2_fill_1
XFILLER_137_877 VDD VSS sg13g2_decap_4
XFILLER_13_1169 VDD VSS sg13g2_decap_8
XFILLER_87_1226 VDD VSS sg13g2_decap_8
XFILLER_139_1305 VDD VSS sg13g2_decap_8
X_10361_ _10361_/Y _14812_/Q _10359_/Y _10365_/C VDD VSS sg13g2_o21ai_1
XFILLER_164_696 VDD VSS sg13g2_decap_4
XFILLER_178_1376 VDD VSS sg13g2_decap_8
X_12100_ _12101_/A _13748_/Q _14100_/Q _14452_/Q _14548_/Q _12100_/S0 _12236_/C VDD
+ VSS sg13g2_mux4_1
XFILLER_139_1338 VDD VSS sg13g2_decap_8
XFILLER_152_847 VDD VSS sg13g2_decap_4
XFILLER_2_301 VDD VSS sg13g2_decap_8
XFILLER_151_324 VDD VSS sg13g2_decap_8
XFILLER_152_858 VDD VSS sg13g2_decap_8
XFILLER_174_1229 VDD VSS sg13g2_fill_2
X_13080_ _13080_/Y _13067_/C _13076_/Y _13079_/Y VDD VSS sg13g2_a21oi_1
XFILLER_88_35 VDD VSS sg13g2_decap_8
X_10292_ _14791_/D _10667_/A _10292_/B _10292_/C VDD VSS sg13g2_nor3_1
XFILLER_3_868 VDD VSS sg13g2_decap_8
X_12031_ _12031_/Y _12033_/A1 _14418_/Q _12236_/C VDD VSS sg13g2_a21oi_1
XFILLER_120_700 VDD VSS sg13g2_decap_8
XFILLER_151_379 VDD VSS sg13g2_decap_8
XFILLER_105_785 VDD VSS sg13g2_decap_8
XFILLER_2_378 VDD VSS sg13g2_decap_8
XFILLER_137_1073 VDD VSS sg13g2_decap_8
XFILLER_77_102 VDD VSS sg13g2_fill_1
XFILLER_104_273 VDD VSS sg13g2_decap_8
XFILLER_78_669 VDD VSS sg13g2_decap_8
Xfanout660 _10675_/A _08838_/Y VDD VSS sg13g2_buf_1
Xfanout671 _08850_/S _08895_/S VDD VSS sg13g2_buf_1
XFILLER_24_1232 VDD VSS sg13g2_decap_8
XFILLER_120_777 VDD VSS sg13g2_decap_4
XFILLER_144_96 VDD VSS sg13g2_decap_8
XFILLER_150_1240 VDD VSS sg13g2_decap_8
X_14469__1803 _14469_/RESET_B VDD VSS sg13g2_tiehi
XFILLER_65_308 VDD VSS sg13g2_decap_8
XFILLER_19_714 VDD VSS sg13g2_decap_8
Xfanout682 _08674_/B1 _07998_/X VDD VSS sg13g2_buf_1
X_13982_ _13982_/Q clkload48/A _13982_/D _13982_/RESET_B VDD VSS sg13g2_dfrbpq_1
Xfanout693 _08001_/A _08623_/A2 VDD VSS sg13g2_buf_1
XFILLER_93_639 VDD VSS sg13g2_decap_8
XFILLER_4_1337 VDD VSS sg13g2_decap_8
XFILLER_150_1273 VDD VSS sg13g2_decap_8
XFILLER_19_736 VDD VSS sg13g2_decap_8
XFILLER_18_224 VDD VSS sg13g2_decap_8
X_12933_ _12933_/Y _12933_/A _15062_/Q VDD VSS sg13g2_nand2_1
XFILLER_98_1366 VDD VSS sg13g2_decap_8
XFILLER_74_875 VDD VSS sg13g2_decap_8
XFILLER_59_1339 VDD VSS sg13g2_decap_8
XFILLER_2_1050 VDD VSS sg13g2_decap_8
XFILLER_46_588 VDD VSS sg13g2_decap_8
XFILLER_34_728 VDD VSS sg13g2_fill_1
XFILLER_160_84 VDD VSS sg13g2_decap_8
X_12864_ _12864_/Y _14771_/Q _13275_/A2 _13140_/B2 VDD VSS sg13g2_o21ai_1
XFILLER_73_374 VDD VSS sg13g2_decap_8
XFILLER_15_920 VDD VSS sg13g2_decap_8
XFILLER_185_1358 VDD VSS sg13g2_decap_8
X_14603_ _14603_/Q clkload9/A _14603_/D _14603_/RESET_B VDD VSS sg13g2_dfrbpq_1
X_11815_ _11815_/X _11815_/A _12317_/B VDD VSS sg13g2_and2_1
XFILLER_57_1041 VDD VSS sg13g2_decap_8
X_12795_ _12795_/Y _12997_/B _12936_/B _12997_/A VDD VSS sg13g2_o21ai_1
XFILLER_14_441 VDD VSS sg13g2_decap_8
XFILLER_109_1131 VDD VSS sg13g2_decap_8
XFILLER_57_1074 VDD VSS sg13g2_decap_4
XFILLER_186_210 VDD VSS sg13g2_decap_8
X_14534_ _14534_/Q _14662_/CLK _14534_/D _14534_/RESET_B VDD VSS sg13g2_dfrbpq_1
X_11746_ _11747_/B _11743_/Y _11745_/Y _11625_/C VDD VSS sg13g2_a21oi_1
XFILLER_15_997 VDD VSS sg13g2_decap_8
XFILLER_186_221 VDD VSS sg13g2_decap_8
XFILLER_42_783 VDD VSS sg13g2_decap_8
XFILLER_30_934 VDD VSS sg13g2_decap_8
XFILLER_41_282 VDD VSS sg13g2_fill_2
XFILLER_128_800 VDD VSS sg13g2_decap_8
X_14465_ _14465_/Q clkload31/A _14465_/D _14465_/RESET_B VDD VSS sg13g2_dfrbpq_1
X_11677_ _11677_/Y _11673_/Y _11674_/Y _11676_/Y _11675_/Y _12101_/B VDD VSS sg13g2_a221oi_1
XFILLER_30_967 VDD VSS sg13g2_decap_8
XFILLER_144_1099 VDD VSS sg13g2_decap_8
XFILLER_168_980 VDD VSS sg13g2_decap_8
XFILLER_175_939 VDD VSS sg13g2_decap_8
XFILLER_70_1263 VDD VSS sg13g2_decap_4
XFILLER_127_310 VDD VSS sg13g2_decap_8
XFILLER_161_1391 VDD VSS sg13g2_fill_2
X_13416_ _13416_/Y _13493_/A1 _13493_/A2 _15093_/Q VDD VSS sg13g2_o21ai_1
X_10628_ _10629_/D _14884_/Q _14883_/Q _14882_/Q _10651_/D VDD VSS sg13g2_and4_1
X_14396_ _14396_/Q _14716_/CLK _14396_/D _14396_/RESET_B VDD VSS sg13g2_dfrbpq_1
XFILLER_139_192 VDD VSS sg13g2_fill_2
X_13957__2315 _13957_/RESET_B VDD VSS sg13g2_tiehi
X_13347_ _13351_/C _13347_/A _15174_/D _15175_/D VDD VSS sg13g2_nand3_1
XFILLER_6_651 VDD VSS sg13g2_decap_8
XFILLER_122_1397 VDD VSS sg13g2_decap_8
XFILLER_154_151 VDD VSS sg13g2_decap_8
X_10559_ _10561_/C _10566_/D _14861_/Q _14860_/Q _14855_/Q VDD VSS sg13g2_nand4_1
XFILLER_185_70 VDD VSS sg13g2_decap_8
Xmax_cap849 _12790_/S _12371_/S VDD VSS sg13g2_buf_8
XFILLER_5_161 VDD VSS sg13g2_decap_8
XFILLER_154_184 VDD VSS sg13g2_decap_8
X_13278_ _15052_/D _13271_/Y _13277_/Y _13021_/A VDD VSS sg13g2_a21oi_1
X_15017_ _15017_/Q _15017_/CLK _15017_/D _15017_/RESET_B VDD VSS sg13g2_dfrbpq_1
X_12229_ _12231_/A _12229_/A _13664_/Q VDD VSS sg13g2_xor2_1
XFILLER_9_1204 VDD VSS sg13g2_decap_8
XFILLER_155_1151 VDD VSS sg13g2_decap_8
XFILLER_116_1135 VDD VSS sg13g2_fill_1
XFILLER_64_1067 VDD VSS sg13g2_decap_8
XFILLER_29_1187 VDD VSS sg13g2_decap_4
XFILLER_97_967 VDD VSS sg13g2_decap_8
XFILLER_64_1078 VDD VSS sg13g2_fill_1
XFILLER_111_755 VDD VSS sg13g2_fill_1
XFILLER_150_390 VDD VSS sg13g2_decap_8
XFILLER_97_978 VDD VSS sg13g2_fill_2
XFILLER_68_146 VDD VSS sg13g2_decap_8
XFILLER_111_766 VDD VSS sg13g2_fill_1
XFILLER_97_989 VDD VSS sg13g2_decap_8
XFILLER_42_1321 VDD VSS sg13g2_decap_8
XFILLER_116_1179 VDD VSS sg13g2_fill_1
XFILLER_110_265 VDD VSS sg13g2_decap_8
XFILLER_133_1460 VDD VSS sg13g2_decap_8
X_07770_ _08315_/A _08258_/C _14998_/Q VDD VSS sg13g2_nor2_1
XFILLER_56_319 VDD VSS sg13g2_fill_2
XFILLER_83_127 VDD VSS sg13g2_fill_1
XFILLER_42_1365 VDD VSS sg13g2_fill_1
XFILLER_65_853 VDD VSS sg13g2_decap_8
XFILLER_92_650 VDD VSS sg13g2_fill_1
X_09440_ _14042_/D _09638_/A0 _14042_/Q _09440_/S VDD VSS sg13g2_mux2_1
XFILLER_92_694 VDD VSS sg13g2_decap_8
X_09371_ _13975_/D _10066_/A0 _13975_/Q _09371_/S VDD VSS sg13g2_mux2_1
XFILLER_36_1103 VDD VSS sg13g2_fill_1
X_08322_ _08322_/Y _08369_/B _08366_/D _08321_/Y VDD VSS sg13g2_o21ai_1
XFILLER_177_210 VDD VSS sg13g2_decap_8
XFILLER_75_1174 VDD VSS sg13g2_decap_4
XFILLER_36_1136 VDD VSS sg13g2_decap_8
XFILLER_162_1144 VDD VSS sg13g2_decap_8
XFILLER_75_1196 VDD VSS sg13g2_decap_8
XFILLER_36_1147 VDD VSS sg13g2_decap_8
XFILLER_166_906 VDD VSS sg13g2_decap_8
X_08253_ _08253_/X _11483_/A _11503_/A1 _08867_/A1 _08863_/A1 _08253_/S0 _08079_/S
+ VDD VSS sg13g2_mux4_1
XFILLER_159_980 VDD VSS sg13g2_fill_1
XFILLER_177_287 VDD VSS sg13g2_decap_8
XFILLER_20_477 VDD VSS sg13g2_decap_8
XFILLER_119_844 VDD VSS sg13g2_decap_8
X_08184_ _08184_/Y _13427_/C _07920_/Y _08183_/Y VDD VSS sg13g2_a21oi_1
XFILLER_14_1456 VDD VSS sg13g2_decap_8
XFILLER_10_1309 VDD VSS sg13g2_decap_8
XFILLER_140_1475 VDD VSS sg13g2_decap_4
XFILLER_146_652 VDD VSS sg13g2_decap_8
X_14547__1725 _14547_/RESET_B VDD VSS sg13g2_tiehi
XFILLER_101_1459 VDD VSS sg13g2_decap_8
XFILLER_145_162 VDD VSS sg13g2_fill_1
XFILLER_173_471 VDD VSS sg13g2_decap_8
XFILLER_106_549 VDD VSS sg13g2_fill_1
XFILLER_82_1101 VDD VSS sg13g2_decap_8
XFILLER_47_1221 VDD VSS sg13g2_decap_8
XFILLER_160_154 VDD VSS sg13g2_decap_8
XFILLER_161_677 VDD VSS sg13g2_fill_2
XFILLER_58_16 VDD VSS sg13g2_fill_1
XFILLER_0_827 VDD VSS sg13g2_decap_8
XFILLER_47_1254 VDD VSS sg13g2_decap_8
XFILLER_88_945 VDD VSS sg13g2_decap_4
XFILLER_87_422 VDD VSS sg13g2_decap_4
XFILLER_181_28 VDD VSS sg13g2_decap_8
XFILLER_101_243 VDD VSS sg13g2_fill_2
XFILLER_134_1279 VDD VSS sg13g2_decap_8
X_07968_ _07969_/D _08641_/A _07966_/Y _07967_/Y VDD VSS sg13g2_a21oi_1
XFILLER_60_1465 VDD VSS sg13g2_decap_8
X_14191__2081 _14191_/RESET_B VDD VSS sg13g2_tiehi
X_09707_ _09739_/S _09740_/B _09707_/B _09707_/C VDD VSS sg13g2_or3_1
XFILLER_74_138 VDD VSS sg13g2_decap_8
XFILLER_114_77 VDD VSS sg13g2_fill_1
XFILLER_21_1438 VDD VSS sg13g2_decap_8
X_07899_ _08073_/B _07903_/B _08063_/A VDD VSS sg13g2_nor2_1
XFILLER_74_37 VDD VSS sg13g2_decap_8
XFILLER_74_59 VDD VSS sg13g2_fill_1
XFILLER_55_352 VDD VSS sg13g2_decap_4
XFILLER_28_566 VDD VSS sg13g2_decap_8
XFILLER_71_812 VDD VSS sg13g2_decap_8
XFILLER_167_1033 VDD VSS sg13g2_fill_2
XFILLER_16_728 VDD VSS sg13g2_decap_8
X_09638_ _14234_/D _09638_/A0 _14234_/Q _09638_/S VDD VSS sg13g2_mux2_1
XFILLER_70_311 VDD VSS sg13g2_fill_2
XFILLER_15_238 VDD VSS sg13g2_decap_8
XFILLER_19_1301 VDD VSS sg13g2_decap_8
X_09569_ _14167_/D _10099_/A0 _14167_/Q _09571_/S VDD VSS sg13g2_mux2_1
XFILLER_31_709 VDD VSS sg13g2_fill_1
XFILLER_90_14 VDD VSS sg13g2_decap_8
X_11600_ _11601_/A _13958_/Q _13990_/Q _14022_/Q _14054_/Q _11597_/A _11598_/C VDD
+ VSS sg13g2_mux4_1
XFILLER_24_772 VDD VSS sg13g2_fill_2
X_12580_ _12580_/X _12572_/X _12576_/X _12571_/X _12575_/X _12663_/S0 _12663_/S1 VDD
+ VSS sg13g2_mux4_1
XFILLER_145_1353 VDD VSS sg13g2_decap_8
XFILLER_168_221 VDD VSS sg13g2_fill_1
XFILLER_24_783 VDD VSS sg13g2_fill_1
XFILLER_23_260 VDD VSS sg13g2_decap_8
XFILLER_93_1296 VDD VSS sg13g2_fill_1
XFILLER_12_945 VDD VSS sg13g2_decap_8
XFILLER_19_1378 VDD VSS sg13g2_decap_8
XFILLER_180_1266 VDD VSS sg13g2_decap_8
X_11531_ _11532_/B _11531_/A _14212_/Q VDD VSS sg13g2_nand2_1
XFILLER_169_788 VDD VSS sg13g2_decap_4
XFILLER_180_1277 VDD VSS sg13g2_fill_2
XFILLER_11_455 VDD VSS sg13g2_decap_8
Xwire324 wire324/X wire324/A VDD VSS sg13g2_buf_2
XFILLER_8_938 VDD VSS sg13g2_decap_8
XFILLER_23_63 VDD VSS sg13g2_decap_8
XFILLER_183_224 VDD VSS sg13g2_decap_8
X_14250_ _14250_/Q clkload16/A _14250_/D _14250_/RESET_B VDD VSS sg13g2_dfrbpq_1
X_11462_ _11463_/C _11452_/A _13688_/Q _11430_/B _11430_/A _11427_/X VDD VSS sg13g2_a221oi_1
XFILLER_139_63 VDD VSS sg13g2_decap_8
XFILLER_104_1050 VDD VSS sg13g2_decap_8
XFILLER_7_448 VDD VSS sg13g2_decap_8
X_13201_ _13202_/B _14919_/Q _13668_/Q _13189_/X VDD VSS sg13g2_a21oi_1
X_10413_ _10422_/D _14827_/Q _10413_/B _10414_/D VDD VSS sg13g2_and3_1
X_14181_ _14181_/Q clkload8/A _14181_/D _14181_/RESET_B VDD VSS sg13g2_dfrbpq_1
X_11393_ _11393_/X _11388_/Y _11389_/Y _11422_/B VDD VSS sg13g2_a21o_1
XFILLER_125_825 VDD VSS sg13g2_fill_2
XFILLER_137_685 VDD VSS sg13g2_decap_8
XFILLER_152_633 VDD VSS sg13g2_decap_8
XFILLER_174_1004 VDD VSS sg13g2_fill_2
X_13132_ _13146_/B _13132_/A _13133_/C VDD VSS sg13g2_nand2_1
XFILLER_125_858 VDD VSS sg13g2_decap_4
X_10344_ _10347_/C _14808_/Q _10343_/B VDD VSS sg13g2_nor2b_1
XFILLER_174_1026 VDD VSS sg13g2_fill_1
XFILLER_178_1195 VDD VSS sg13g2_decap_4
XFILLER_98_709 VDD VSS sg13g2_decap_8
XFILLER_152_666 VDD VSS sg13g2_decap_8
XFILLER_139_1168 VDD VSS sg13g2_decap_8
XFILLER_65_1321 VDD VSS sg13g2_decap_8
XFILLER_3_0 VDD VSS sg13g2_decap_8
X_13063_ _13078_/A _13066_/C _13063_/B VDD VSS sg13g2_nand2b_1
XFILLER_3_665 VDD VSS sg13g2_decap_8
X_10275_ _14786_/D _14786_/Q _10305_/A _10274_/Y VDD VSS sg13g2_a21oi_1
XFILLER_65_1343 VDD VSS sg13g2_decap_4
XFILLER_155_84 VDD VSS sg13g2_decap_8
XFILLER_117_1433 VDD VSS sg13g2_decap_8
Xfanout1400 fanout1400/X fanout1410/X VDD VSS sg13g2_buf_1
X_12014_ _12014_/X _13842_/Q _13874_/Q _12232_/S VDD VSS sg13g2_mux2_1
XFILLER_65_1365 VDD VSS sg13g2_decap_8
XFILLER_2_175 VDD VSS sg13g2_decap_8
XFILLER_152_1324 VDD VSS sg13g2_fill_1
Xfanout1411 _11415_/S _11412_/S0 VDD VSS sg13g2_buf_1
XFILLER_26_1327 VDD VSS sg13g2_decap_8
Xfanout1422 _11328_/S0 _11320_/S0 VDD VSS sg13g2_buf_1
XFILLER_94_904 VDD VSS sg13g2_decap_8
Xfanout1433 _12330_/S0 _12098_/A1 VDD VSS sg13g2_buf_1
Xfanout1444 _12138_/S0 fanout1445/X VDD VSS sg13g2_buf_1
XFILLER_66_606 VDD VSS sg13g2_decap_8
Xfanout1455 _12286_/S0 _12288_/S0 VDD VSS sg13g2_buf_1
XFILLER_38_308 VDD VSS sg13g2_fill_2
XFILLER_120_574 VDD VSS sg13g2_decap_8
Xfanout1466 _10580_/B fanout1476/X VDD VSS sg13g2_buf_1
Xfanout1477 _13211_/A _13266_/A VDD VSS sg13g2_buf_1
XFILLER_94_948 VDD VSS sg13g2_decap_8
XFILLER_78_499 VDD VSS sg13g2_decap_4
Xfanout490 _09563_/S _09570_/S VDD VSS sg13g2_buf_1
XFILLER_8_1281 VDD VSS sg13g2_decap_8
XFILLER_19_522 VDD VSS sg13g2_decap_8
Xfanout1488 _10350_/C _10365_/C VDD VSS sg13g2_buf_1
XFILLER_59_691 VDD VSS sg13g2_decap_8
Xfanout1499 _12956_/B fanout1507/X VDD VSS sg13g2_buf_1
XFILLER_4_1134 VDD VSS sg13g2_decap_8
X_14021__2251 _14021_/RESET_B VDD VSS sg13g2_tiehi
X_13965_ _13965_/Q clkload18/A _13965_/D _13965_/RESET_B VDD VSS sg13g2_dfrbpq_1
XFILLER_58_190 VDD VSS sg13g2_decap_8
XFILLER_98_1152 VDD VSS sg13g2_decap_8
XFILLER_0_1009 VDD VSS sg13g2_decap_8
XFILLER_0_56 VDD VSS sg13g2_decap_8
X_12916_ _12916_/Y _14838_/Q _07728_/B _12895_/B _14870_/Q VDD VSS sg13g2_a22oi_1
XFILLER_73_160 VDD VSS sg13g2_decap_8
XFILLER_111_1087 VDD VSS sg13g2_fill_2
X_13896_ _13896_/Q _14664_/CLK _13896_/D _13896_/RESET_B VDD VSS sg13g2_dfrbpq_1
XFILLER_98_1196 VDD VSS sg13g2_decap_8
X_14625__1647 _14625_/RESET_B VDD VSS sg13g2_tiehi
XFILLER_181_1008 VDD VSS sg13g2_fill_1
X_12847_ _12847_/X _14897_/Q _13690_/Q VDD VSS sg13g2_and2_1
X_14907__2823 _14907_/RESET_B VDD VSS sg13g2_tiehi
XFILLER_9_21 VDD VSS sg13g2_decap_8
XFILLER_72_1325 VDD VSS sg13g2_decap_8
XFILLER_163_1442 VDD VSS sg13g2_decap_8
X_13689__2587 _13689_/RESET_B VDD VSS sg13g2_tiehi
X_12778_ _15019_/D _12778_/A _12778_/B VDD VSS sg13g2_nor2_1
XFILLER_30_731 VDD VSS sg13g2_decap_8
X_14517_ _14517_/Q clkload32/A _14517_/D _14517_/RESET_B VDD VSS sg13g2_dfrbpq_1
XFILLER_159_265 VDD VSS sg13g2_fill_2
X_11729_ _11729_/Y _11236_/A _13289_/C _11728_/Y VDD VSS sg13g2_o21ai_1
XFILLER_147_416 VDD VSS sg13g2_fill_1
XFILLER_124_1459 VDD VSS sg13g2_decap_8
XFILLER_9_98 VDD VSS sg13g2_decap_8
XFILLER_147_449 VDD VSS sg13g2_decap_8
XFILLER_174_224 VDD VSS sg13g2_decap_8
X_14448_ _14448_/Q clkload14/A _14448_/D _14448_/RESET_B VDD VSS sg13g2_dfrbpq_1
XFILLER_128_641 VDD VSS sg13g2_decap_8
XFILLER_163_909 VDD VSS sg13g2_decap_8
XFILLER_128_652 VDD VSS sg13g2_fill_2
XFILLER_116_814 VDD VSS sg13g2_decap_8
XFILLER_122_1183 VDD VSS sg13g2_decap_8
XFILLER_143_600 VDD VSS sg13g2_decap_8
XFILLER_155_460 VDD VSS sg13g2_decap_8
XFILLER_156_983 VDD VSS sg13g2_decap_8
X_14379_ _14379_/Q _14733_/CLK _14379_/D _14379_/RESET_B VDD VSS sg13g2_dfrbpq_1
XFILLER_183_780 VDD VSS sg13g2_decap_8
XFILLER_66_1129 VDD VSS sg13g2_decap_8
XFILLER_143_677 VDD VSS sg13g2_decap_8
XFILLER_170_463 VDD VSS sg13g2_fill_1
XFILLER_157_1279 VDD VSS sg13g2_decap_8
X_08940_ _08940_/X _08939_/X _12203_/A _08940_/S VDD VSS sg13g2_mux2_1
XFILLER_9_1001 VDD VSS sg13g2_decap_8
XFILLER_83_1443 VDD VSS sg13g2_decap_8
XFILLER_44_1416 VDD VSS sg13g2_fill_1
XFILLER_36_0 VDD VSS sg13g2_decap_8
X_08871_ _08871_/X _08870_/X _14967_/Q _08940_/S VDD VSS sg13g2_mux2_1
XFILLER_44_1427 VDD VSS sg13g2_decap_8
XFILLER_97_753 VDD VSS sg13g2_decap_8
X_07822_ _08527_/B _07822_/A _07822_/B VDD VSS sg13g2_nor2_1
XFILLER_9_1078 VDD VSS sg13g2_decap_8
XFILLER_69_477 VDD VSS sg13g2_fill_1
XFILLER_131_1419 VDD VSS sg13g2_decap_4
XFILLER_170_1468 VDD VSS sg13g2_fill_2
XFILLER_57_628 VDD VSS sg13g2_fill_2
XFILLER_85_948 VDD VSS sg13g2_decap_8
XFILLER_84_425 VDD VSS sg13g2_decap_8
X_15118__2816 _15118_/RESET_B VDD VSS sg13g2_tiehi
XFILLER_85_959 VDD VSS sg13g2_fill_2
X_07753_ _15206_/D _10797_/C _07753_/B _07754_/B _10869_/A VDD VSS sg13g2_and4_1
XFILLER_42_1173 VDD VSS sg13g2_decap_8
XFILLER_133_1290 VDD VSS sg13g2_decap_8
XFILLER_72_609 VDD VSS sg13g2_fill_1
XFILLER_42_1184 VDD VSS sg13g2_fill_2
XFILLER_168_1320 VDD VSS sg13g2_decap_8
XFILLER_25_503 VDD VSS sg13g2_decap_8
X_07684_ _07684_/Y _11241_/A _07684_/B _11241_/C VDD VSS sg13g2_nand3_1
XFILLER_93_992 VDD VSS sg13g2_decap_8
XFILLER_65_683 VDD VSS sg13g2_decap_4
XFILLER_64_160 VDD VSS sg13g2_decap_8
XFILLER_80_620 VDD VSS sg13g2_decap_8
XFILLER_64_171 VDD VSS sg13g2_fill_1
X_09423_ _14025_/D _09621_/A0 _14025_/Q _09429_/S VDD VSS sg13g2_mux2_1
XFILLER_129_1337 VDD VSS sg13g2_fill_2
XFILLER_25_558 VDD VSS sg13g2_fill_2
XFILLER_129_1348 VDD VSS sg13g2_decap_8
XFILLER_53_878 VDD VSS sg13g2_fill_1
X_09354_ _13958_/D _09618_/A0 _13958_/Q _09362_/S VDD VSS sg13g2_mux2_1
XFILLER_80_686 VDD VSS sg13g2_fill_2
XFILLER_52_377 VDD VSS sg13g2_decap_8
XFILLER_90_1436 VDD VSS sg13g2_decap_8
XFILLER_139_906 VDD VSS sg13g2_fill_2
X_08305_ _08305_/Y _07994_/X _08304_/Y _08404_/B1 VDD VSS sg13g2_a21oi_1
XFILLER_178_574 VDD VSS sg13g2_decap_8
X_09285_ _13893_/D _13893_/Q _09883_/A0 _09298_/S VDD VSS sg13g2_mux2_1
XFILLER_100_68 VDD VSS sg13g2_decap_8
XFILLER_60_28 VDD VSS sg13g2_decap_8
XFILLER_20_252 VDD VSS sg13g2_decap_8
X_08236_ _08236_/X _08151_/X _08235_/X _08236_/S VDD VSS sg13g2_mux2_1
XFILLER_176_28 VDD VSS sg13g2_decap_8
XFILLER_140_1250 VDD VSS sg13g2_decap_8
XFILLER_14_1253 VDD VSS sg13g2_decap_8
XFILLER_10_1106 VDD VSS sg13g2_decap_8
XFILLER_119_674 VDD VSS sg13g2_fill_1
XFILLER_181_728 VDD VSS sg13g2_decap_8
X_08167_ _08167_/X _08428_/S _08167_/B VDD VSS sg13g2_or2_1
XFILLER_114_7 VDD VSS sg13g2_decap_4
XFILLER_147_994 VDD VSS sg13g2_fill_2
X_14063__2209 _14063_/RESET_B VDD VSS sg13g2_tiehi
XFILLER_134_611 VDD VSS sg13g2_fill_2
XFILLER_162_920 VDD VSS sg13g2_decap_8
XFILLER_175_1302 VDD VSS sg13g2_decap_8
XFILLER_106_313 VDD VSS sg13g2_decap_8
XFILLER_180_238 VDD VSS sg13g2_decap_8
X_08098_ _08098_/Y _08154_/A _08098_/B VDD VSS sg13g2_nand2_1
XFILLER_109_88 VDD VSS sg13g2_decap_8
XFILLER_69_37 VDD VSS sg13g2_decap_8
XFILLER_106_357 VDD VSS sg13g2_decap_8
XFILLER_162_975 VDD VSS sg13g2_decap_4
XFILLER_133_154 VDD VSS sg13g2_decap_4
XFILLER_0_602 VDD VSS sg13g2_decap_8
XFILLER_47_1051 VDD VSS sg13g2_decap_8
XFILLER_121_338 VDD VSS sg13g2_decap_8
XFILLER_125_21 VDD VSS sg13g2_decap_4
XFILLER_134_1010 VDD VSS sg13g2_decap_8
X_14703__1569 _14703_/RESET_B VDD VSS sg13g2_tiehi
XFILLER_47_1062 VDD VSS sg13g2_fill_1
X_10060_ _14641_/D _10093_/A0 _14641_/Q _10060_/S VDD VSS sg13g2_mux2_1
XFILLER_138_1190 VDD VSS sg13g2_fill_2
XFILLER_0_679 VDD VSS sg13g2_decap_8
XFILLER_130_872 VDD VSS sg13g2_decap_8
XFILLER_87_252 VDD VSS sg13g2_decap_8
XFILLER_130_883 VDD VSS sg13g2_fill_2
XFILLER_5_1421 VDD VSS sg13g2_decap_8
XFILLER_48_639 VDD VSS sg13g2_decap_8
XFILLER_102_596 VDD VSS sg13g2_decap_8
XFILLER_25_1371 VDD VSS sg13g2_decap_8
XFILLER_47_149 VDD VSS sg13g2_fill_2
XFILLER_21_1235 VDD VSS sg13g2_decap_8
XFILLER_169_1139 VDD VSS sg13g2_decap_4
XFILLER_18_63 VDD VSS sg13g2_decap_8
XFILLER_29_875 VDD VSS sg13g2_decap_8
X_13750_ _13750_/Q clkload41/A _13750_/D _13750_/RESET_B VDD VSS sg13g2_dfrbpq_1
X_10962_ _11004_/B _14759_/Q _11015_/C VDD VSS sg13g2_xor2_1
XFILLER_16_525 VDD VSS sg13g2_decap_8
XFILLER_55_160 VDD VSS sg13g2_fill_2
X_12701_ _12701_/X _13844_/Q _13876_/Q _13908_/Q _13940_/Q _12702_/S0 _12702_/S1 VDD
+ VSS sg13g2_mux4_1
XFILLER_95_1358 VDD VSS sg13g2_decap_8
XFILLER_56_1309 VDD VSS sg13g2_fill_2
XFILLER_182_1317 VDD VSS sg13g2_decap_8
XFILLER_71_653 VDD VSS sg13g2_decap_8
X_13681_ _13681_/Q clkload73/A _13681_/D _13681_/RESET_B VDD VSS sg13g2_dfrbpq_1
X_10893_ _10893_/X _10893_/A _10893_/B VDD VSS sg13g2_and2_1
XFILLER_43_366 VDD VSS sg13g2_decap_8
XFILLER_71_686 VDD VSS sg13g2_decap_8
XFILLER_31_517 VDD VSS sg13g2_decap_8
X_12632_ _12632_/X _13839_/Q _13871_/Q _13903_/Q _13935_/Q _12633_/S0 _12633_/S1 VDD
+ VSS sg13g2_mux4_1
XFILLER_93_1071 VDD VSS sg13g2_decap_8
XFILLER_58_1191 VDD VSS sg13g2_decap_8
XFILLER_140_0 VDD VSS sg13g2_decap_8
XFILLER_12_742 VDD VSS sg13g2_decap_8
XFILLER_157_703 VDD VSS sg13g2_fill_1
XFILLER_19_1175 VDD VSS sg13g2_decap_8
X_12563_ _12563_/X _14122_/Q _14154_/Q _14186_/Q _14218_/Q _12754_/S0 _12754_/S1 VDD
+ VSS sg13g2_mux4_1
XFILLER_106_1134 VDD VSS sg13g2_fill_1
XFILLER_169_585 VDD VSS sg13g2_decap_8
XFILLER_11_252 VDD VSS sg13g2_decap_8
XFILLER_15_1039 VDD VSS sg13g2_decap_8
X_14302_ _14302_/Q clkload49/A _14302_/D _14302_/RESET_B VDD VSS sg13g2_dfrbpq_1
X_11514_ _11514_/X _13955_/Q _13987_/Q _14019_/Q _14051_/Q _12140_/S0 _12140_/S1 VDD
+ VSS sg13g2_mux4_1
XFILLER_8_735 VDD VSS sg13g2_decap_8
XFILLER_106_1167 VDD VSS sg13g2_decap_8
XFILLER_157_758 VDD VSS sg13g2_decap_8
XFILLER_106_1178 VDD VSS sg13g2_decap_8
XFILLER_141_1058 VDD VSS sg13g2_decap_8
X_12494_ _12494_/X _13957_/Q _13989_/Q _14021_/Q _14053_/Q _12654_/S0 _12654_/S1 VDD
+ VSS sg13g2_mux4_1
XFILLER_7_245 VDD VSS sg13g2_decap_8
X_14233_ _14233_/Q clkload38/A _14233_/D _14233_/RESET_B VDD VSS sg13g2_dfrbpq_1
X_11445_ _11448_/C _11445_/A _11446_/A _11445_/C VDD VSS sg13g2_nand3_1
XFILLER_153_920 VDD VSS sg13g2_decap_8
XFILLER_125_622 VDD VSS sg13g2_decap_8
XFILLER_153_931 VDD VSS sg13g2_fill_1
X_14039__2233 _14039_/RESET_B VDD VSS sg13g2_tiehi
XFILLER_50_94 VDD VSS sg13g2_decap_8
XFILLER_109_184 VDD VSS sg13g2_decap_4
X_14164_ _14164_/Q clkload55/A _14164_/D _14164_/RESET_B VDD VSS sg13g2_dfrbpq_1
X_11376_ _11376_/X _13950_/Q _13982_/Q _14014_/Q _14046_/Q _11418_/A _11419_/C VDD
+ VSS sg13g2_mux4_1
XFILLER_67_1427 VDD VSS sg13g2_decap_8
XFILLER_4_952 VDD VSS sg13g2_decap_8
XFILLER_125_666 VDD VSS sg13g2_decap_8
XFILLER_98_506 VDD VSS sg13g2_decap_8
XFILLER_152_463 VDD VSS sg13g2_decap_8
X_13115_ _13116_/C _14913_/Q _13674_/Q _13088_/X VDD VSS sg13g2_o21ai_1
X_10327_ _10336_/D _14798_/Q _10327_/B _10327_/C _10345_/C VDD VSS sg13g2_and4_1
X_14095_ _14095_/Q _14607_/CLK _14095_/D _14095_/RESET_B VDD VSS sg13g2_dfrbpq_1
XFILLER_3_462 VDD VSS sg13g2_decap_8
XFILLER_112_327 VDD VSS sg13g2_fill_2
XFILLER_124_198 VDD VSS sg13g2_decap_8
X_13046_ _13046_/Y _13050_/C _15061_/Q VDD VSS sg13g2_nor2b_1
X_10258_ _10262_/B _14779_/Q _14780_/Q _14781_/Q _10258_/D VDD VSS sg13g2_nand4_1
XFILLER_26_1124 VDD VSS sg13g2_decap_8
Xfanout1230 _08843_/A _11384_/A VDD VSS sg13g2_buf_1
XFILLER_6_1218 VDD VSS sg13g2_decap_8
XFILLER_67_915 VDD VSS sg13g2_fill_2
Xfanout1241 _13602_/A _14958_/Q VDD VSS sg13g2_buf_1
XFILLER_120_360 VDD VSS sg13g2_fill_1
XFILLER_113_1127 VDD VSS sg13g2_decap_8
XFILLER_121_894 VDD VSS sg13g2_decap_8
Xfanout1252 _13064_/A _14910_/Q VDD VSS sg13g2_buf_1
X_10189_ _15195_/D hold3173/X _15195_/Q _13479_/S VDD VSS sg13g2_mux2_1
Xfanout1263 _10558_/B _14858_/Q VDD VSS sg13g2_buf_1
XFILLER_66_425 VDD VSS sg13g2_decap_8
Xfanout1274 _11202_/A _11171_/B VDD VSS sg13g2_buf_1
XFILLER_78_296 VDD VSS sg13g2_decap_8
XFILLER_120_393 VDD VSS sg13g2_decap_8
XFILLER_82_907 VDD VSS sg13g2_decap_8
XFILLER_66_458 VDD VSS sg13g2_decap_8
X_14997_ _14997_/Q _15019_/CLK _14997_/D _14997_/RESET_B VDD VSS sg13g2_dfrbpq_1
XFILLER_93_255 VDD VSS sg13g2_decap_4
XFILLER_47_661 VDD VSS sg13g2_decap_8
XFILLER_130_1463 VDD VSS sg13g2_decap_8
XFILLER_75_80 VDD VSS sg13g2_decap_8
X_13948_ _13948_/Q _14620_/CLK _13948_/D _13948_/RESET_B VDD VSS sg13g2_dfrbpq_1
XFILLER_19_385 VDD VSS sg13g2_decap_8
XFILLER_90_962 VDD VSS sg13g2_fill_1
X_13879_ _13879_/Q _15017_/CLK _13879_/D _13879_/RESET_B VDD VSS sg13g2_dfrbpq_1
XFILLER_61_163 VDD VSS sg13g2_decap_4
XFILLER_72_1133 VDD VSS sg13g2_decap_8
XFILLER_61_196 VDD VSS sg13g2_fill_2
XFILLER_50_859 VDD VSS sg13g2_decap_8
XFILLER_37_1253 VDD VSS sg13g2_fill_1
XFILLER_163_1261 VDD VSS sg13g2_decap_8
XFILLER_148_714 VDD VSS sg13g2_decap_8
XFILLER_37_1275 VDD VSS sg13g2_decap_8
XFILLER_33_1117 VDD VSS sg13g2_decap_8
XFILLER_30_550 VDD VSS sg13g2_decap_8
XFILLER_163_1294 VDD VSS sg13g2_decap_8
X_15147__2756 _15147_/RESET_B VDD VSS sg13g2_tiehi
XFILLER_124_1256 VDD VSS sg13g2_decap_4
XFILLER_175_533 VDD VSS sg13g2_decap_8
X_09070_ _09070_/Y _09090_/A _09066_/Y _09069_/X VDD VSS sg13g2_o21ai_1
XFILLER_147_235 VDD VSS sg13g2_decap_4
XFILLER_30_583 VDD VSS sg13g2_decap_8
XFILLER_50_1442 VDD VSS sg13g2_fill_1
X_08021_ _08021_/Y _08021_/A _08154_/A VDD VSS sg13g2_nand2_1
XFILLER_50_1453 VDD VSS sg13g2_fill_2
XFILLER_163_728 VDD VSS sg13g2_decap_8
XFILLER_128_471 VDD VSS sg13g2_decap_8
XFILLER_115_110 VDD VSS sg13g2_decap_8
XFILLER_116_633 VDD VSS sg13g2_decap_8
XFILLER_155_290 VDD VSS sg13g2_decap_8
XFILLER_104_806 VDD VSS sg13g2_fill_1
XFILLER_89_506 VDD VSS sg13g2_decap_4
XFILLER_171_783 VDD VSS sg13g2_decap_8
XFILLER_131_625 VDD VSS sg13g2_fill_2
X_09972_ _14555_/D _10071_/A0 _14555_/Q _09997_/S VDD VSS sg13g2_mux2_1
XFILLER_118_1038 VDD VSS sg13g2_decap_8
XFILLER_143_496 VDD VSS sg13g2_decap_4
XFILLER_170_282 VDD VSS sg13g2_decap_4
XFILLER_48_1360 VDD VSS sg13g2_decap_8
XFILLER_157_1098 VDD VSS sg13g2_decap_8
XFILLER_83_1251 VDD VSS sg13g2_decap_8
X_08923_ _13713_/D _16875_/A _08922_/X _08932_/S VDD VSS sg13g2_mux2_1
XFILLER_44_1224 VDD VSS sg13g2_decap_8
XFILLER_69_252 VDD VSS sg13g2_decap_8
XFILLER_58_915 VDD VSS sg13g2_decap_8
XFILLER_112_872 VDD VSS sg13g2_fill_1
XFILLER_130_179 VDD VSS sg13g2_decap_4
XFILLER_131_1205 VDD VSS sg13g2_decap_8
X_08854_ _08854_/X _08853_/X _11454_/A _08895_/S VDD VSS sg13g2_mux2_1
XFILLER_57_436 VDD VSS sg13g2_decap_8
XFILLER_170_1287 VDD VSS sg13g2_decap_8
X_13737__2535 _13737_/RESET_B VDD VSS sg13g2_tiehi
X_14497__1775 _14497_/RESET_B VDD VSS sg13g2_tiehi
X_07805_ _08476_/A _07949_/C _07805_/B VDD VSS sg13g2_nand2b_1
XFILLER_84_233 VDD VSS sg13g2_decap_8
XFILLER_79_1309 VDD VSS sg13g2_decap_8
X_08785_ _08785_/Y _08788_/A1 _14758_/Q _10201_/A1 _07719_/X VDD VSS sg13g2_a22oi_1
XFILLER_55_28 VDD VSS sg13g2_decap_8
XFILLER_26_801 VDD VSS sg13g2_decap_8
XFILLER_72_417 VDD VSS sg13g2_fill_2
X_07736_ _13284_/B _07744_/B _15124_/Q VDD VSS sg13g2_nand2_1
XFILLER_72_428 VDD VSS sg13g2_decap_8
XFILLER_37_160 VDD VSS sg13g2_decap_8
XFILLER_25_311 VDD VSS sg13g2_decap_8
XFILLER_53_642 VDD VSS sg13g2_decap_8
X_07667_ _07667_/Y _13293_/A _15055_/Q _13283_/A VDD VSS sg13g2_nor3_1
XFILLER_81_962 VDD VSS sg13g2_decap_8
XFILLER_26_878 VDD VSS sg13g2_decap_8
XFILLER_111_45 VDD VSS sg13g2_decap_8
XFILLER_129_1145 VDD VSS sg13g2_fill_1
XFILLER_0_1373 VDD VSS sg13g2_decap_8
X_14117__2155 _14117_/RESET_B VDD VSS sg13g2_tiehi
X_13952__2320 _13952_/RESET_B VDD VSS sg13g2_tiehi
X_09406_ _14009_/D _09472_/A0 _14009_/Q _09406_/S VDD VSS sg13g2_mux2_1
XFILLER_129_1167 VDD VSS sg13g2_decap_8
XFILLER_40_314 VDD VSS sg13g2_fill_2
XFILLER_111_78 VDD VSS sg13g2_decap_8
XFILLER_13_539 VDD VSS sg13g2_decap_8
XFILLER_94_1391 VDD VSS sg13g2_decap_8
XFILLER_80_494 VDD VSS sg13g2_fill_1
XFILLER_181_1350 VDD VSS sg13g2_fill_1
XFILLER_185_308 VDD VSS sg13g2_decap_8
XFILLER_71_49 VDD VSS sg13g2_decap_4
XFILLER_139_703 VDD VSS sg13g2_decap_8
XFILLER_40_347 VDD VSS sg13g2_decap_8
X_09337_ _13944_/D _10067_/A0 _13944_/Q _09337_/S VDD VSS sg13g2_mux2_1
XFILLER_178_371 VDD VSS sg13g2_decap_8
X_09268_ _13877_/D _13877_/Q _10164_/A1 _09272_/S VDD VSS sg13g2_mux2_1
XFILLER_166_566 VDD VSS sg13g2_decap_4
XFILLER_14_1050 VDD VSS sg13g2_decap_8
X_08219_ _08247_/B _08219_/A _13545_/A VDD VSS sg13g2_and2_1
XFILLER_126_419 VDD VSS sg13g2_fill_2
XFILLER_181_525 VDD VSS sg13g2_decap_8
X_09199_ _13815_/D _13815_/Q _10166_/A1 wire415/X VDD VSS sg13g2_mux2_1
XFILLER_147_780 VDD VSS sg13g2_fill_2
XFILLER_135_931 VDD VSS sg13g2_fill_2
X_13985__2287 _13985_/RESET_B VDD VSS sg13g2_tiehi
XFILLER_107_633 VDD VSS sg13g2_decap_8
XFILLER_140_1091 VDD VSS sg13g2_decap_8
X_11230_ _11230_/X _11228_/X _11229_/X _11898_/C VDD VSS sg13g2_mux2_1
XFILLER_5_749 VDD VSS sg13g2_decap_8
XFILLER_88_1162 VDD VSS sg13g2_decap_8
XFILLER_101_1064 VDD VSS sg13g2_fill_2
XFILLER_175_1121 VDD VSS sg13g2_fill_1
XFILLER_20_42 VDD VSS sg13g2_decap_8
XFILLER_88_1184 VDD VSS sg13g2_fill_2
XFILLER_4_259 VDD VSS sg13g2_decap_8
XFILLER_150_912 VDD VSS sg13g2_decap_4
XFILLER_134_474 VDD VSS sg13g2_decap_8
X_11161_ _11161_/X _11161_/A _11191_/A VDD VSS sg13g2_and2_1
XFILLER_84_1037 VDD VSS sg13g2_fill_1
XFILLER_136_1116 VDD VSS sg13g2_decap_8
XFILLER_162_794 VDD VSS sg13g2_decap_8
XFILLER_121_113 VDD VSS sg13g2_decap_8
XFILLER_150_956 VDD VSS sg13g2_decap_8
X_10112_ _14690_/D _10145_/A1 _14690_/Q _10135_/S VDD VSS sg13g2_mux2_1
XFILLER_161_293 VDD VSS sg13g2_decap_8
XFILLER_110_809 VDD VSS sg13g2_decap_8
X_11092_ _11095_/A _11092_/A _11118_/C VDD VSS sg13g2_nor2b_1
XFILLER_27_1433 VDD VSS sg13g2_decap_8
XFILLER_1_966 VDD VSS sg13g2_decap_8
XFILLER_114_1403 VDD VSS sg13g2_decap_8
X_14924__2789 _14924_/RESET_B VDD VSS sg13g2_tiehi
XFILLER_103_872 VDD VSS sg13g2_decap_8
XFILLER_153_1463 VDD VSS sg13g2_decap_8
X_14920_ _14920_/Q clkload70/A _14920_/D _14920_/RESET_B VDD VSS sg13g2_dfrbpq_1
X_10043_ _14624_/D _10043_/A0 _14624_/Q _10064_/S VDD VSS sg13g2_mux2_1
XFILLER_0_476 VDD VSS sg13g2_decap_8
XFILLER_114_1436 VDD VSS sg13g2_fill_2
XFILLER_76_734 VDD VSS sg13g2_decap_8
XFILLER_75_222 VDD VSS sg13g2_fill_2
XFILLER_114_1469 VDD VSS sg13g2_fill_1
X_14327__1945 _14327_/RESET_B VDD VSS sg13g2_tiehi
X_14851_ _14851_/Q _14876_/CLK _14851_/D _14851_/RESET_B VDD VSS sg13g2_dfrbpq_1
XFILLER_91_704 VDD VSS sg13g2_decap_8
XFILLER_29_650 VDD VSS sg13g2_decap_4
XFILLER_112_1160 VDD VSS sg13g2_fill_1
X_13802_ _13802_/Q clkload16/A _13802_/D _13802_/RESET_B VDD VSS sg13g2_dfrbpq_1
XFILLER_63_417 VDD VSS sg13g2_decap_8
XFILLER_75_288 VDD VSS sg13g2_fill_1
X_14782_ _14782_/Q clkload62/A _14782_/D _14782_/RESET_B VDD VSS sg13g2_dfrbpq_1
XFILLER_5_1295 VDD VSS sg13g2_decap_8
X_11994_ _11994_/X _14705_/Q _14737_/Q _13777_/Q _13809_/Q _11997_/S0 _11997_/S1 VDD
+ VSS sg13g2_mux4_1
XFILLER_56_480 VDD VSS sg13g2_decap_8
XFILLER_29_694 VDD VSS sg13g2_decap_8
XFILLER_16_322 VDD VSS sg13g2_decap_8
XFILLER_1_1148 VDD VSS sg13g2_decap_8
XFILLER_44_631 VDD VSS sg13g2_decap_8
X_13733_ _13733_/Q _14725_/CLK _13733_/D _13733_/RESET_B VDD VSS sg13g2_dfrbpq_1
XFILLER_186_1272 VDD VSS sg13g2_decap_8
X_10945_ _10945_/Y _10945_/A _10945_/B VDD VSS sg13g2_nor2_1
XFILLER_17_889 VDD VSS sg13g2_decap_8
XFILLER_186_1283 VDD VSS sg13g2_decap_8
XFILLER_147_1245 VDD VSS sg13g2_decap_8
XFILLER_95_1177 VDD VSS sg13g2_decap_8
XFILLER_31_303 VDD VSS sg13g2_decap_8
XFILLER_16_399 VDD VSS sg13g2_decap_8
X_13664_ _13664_/Q _15212_/CLK _13664_/D _13664_/RESET_B VDD VSS sg13g2_dfrbpq_1
X_14542__1730 _14542_/RESET_B VDD VSS sg13g2_tiehi
X_10876_ _10923_/D _10876_/A _10897_/B _10897_/A _10876_/D VDD VSS sg13g2_or4_1
XFILLER_176_308 VDD VSS sg13g2_decap_8
X_12615_ _12615_/X _14382_/Q _14414_/Q _14478_/Q _14510_/Q wire940/X _12620_/S1 VDD
+ VSS sg13g2_mux4_1
XFILLER_160_1423 VDD VSS sg13g2_decap_8
X_13595_ _13595_/Y _13600_/A _08834_/B hold3264/X VDD VSS sg13g2_a21oi_1
XFILLER_129_224 VDD VSS sg13g2_fill_1
XFILLER_40_881 VDD VSS sg13g2_decap_8
XFILLER_34_1459 VDD VSS sg13g2_decap_8
XFILLER_118_909 VDD VSS sg13g2_decap_4
X_12546_ _12546_/X _14249_/Q _14281_/Q _14313_/Q _14345_/Q _12769_/S0 _12769_/S1 VDD
+ VSS sg13g2_mux4_1
XFILLER_8_532 VDD VSS sg13g2_decap_8
XFILLER_61_71 VDD VSS sg13g2_decap_4
XFILLER_77_7 VDD VSS sg13g2_decap_8
XFILLER_184_363 VDD VSS sg13g2_decap_8
XFILLER_172_514 VDD VSS sg13g2_decap_8
XFILLER_184_374 VDD VSS sg13g2_decap_8
XFILLER_138_780 VDD VSS sg13g2_decap_8
XFILLER_157_599 VDD VSS sg13g2_decap_8
X_12477_ _12477_/X _14564_/Q _14596_/Q _14628_/Q _14660_/Q _12689_/S0 _12689_/S1 VDD
+ VSS sg13g2_mux4_1
XFILLER_126_931 VDD VSS sg13g2_decap_8
XANTENNA_4 _09573_/X VDD VSS sg13g2_antennanp
X_13815__2457 _13815_/RESET_B VDD VSS sg13g2_tiehi
X_14216_ _14216_/Q clkload27/A _14216_/D _14216_/RESET_B VDD VSS sg13g2_dfrbpq_1
X_14575__1697 _14575_/RESET_B VDD VSS sg13g2_tiehi
X_11428_ _11430_/A _11428_/A _13689_/Q VDD VSS sg13g2_xor2_1
X_15196_ _15196_/Q clkload80/A _15196_/D _15196_/RESET_B VDD VSS sg13g2_dfrbpq_1
XFILLER_6_77 VDD VSS sg13g2_decap_8
XFILLER_10_1470 VDD VSS sg13g2_decap_8
XFILLER_158_1374 VDD VSS sg13g2_decap_8
X_14147_ _14147_/Q clkload29/A _14147_/D _14147_/RESET_B VDD VSS sg13g2_dfrbpq_1
X_11359_ _11359_/Y _11359_/A _11422_/B VDD VSS sg13g2_nand2_1
XFILLER_98_325 VDD VSS sg13g2_decap_8
XFILLER_140_433 VDD VSS sg13g2_decap_8
X_14078_ _14078_/Q clkload48/A _14078_/D _14078_/RESET_B VDD VSS sg13g2_dfrbpq_1
XFILLER_67_712 VDD VSS sg13g2_decap_4
XFILLER_117_1060 VDD VSS sg13g2_fill_2
X_13029_ _13029_/Y _14813_/Q _13250_/A2 _07727_/B _14845_/Q _13082_/B VDD VSS sg13g2_a221oi_1
XFILLER_6_1015 VDD VSS sg13g2_decap_8
XFILLER_121_680 VDD VSS sg13g2_decap_8
XFILLER_67_734 VDD VSS sg13g2_decap_8
Xfanout1060 _09872_/B _09938_/B VDD VSS sg13g2_buf_1
Xfanout1071 _10781_/C _15060_/Q VDD VSS sg13g2_buf_1
Xfanout1082 _10697_/B _10781_/B VDD VSS sg13g2_buf_1
Xfanout1093 _07805_/B _15007_/Q VDD VSS sg13g2_buf_1
XFILLER_130_1260 VDD VSS sg13g2_decap_8
X_08570_ _08570_/Y _08494_/Y _08574_/D _08569_/Y VDD VSS sg13g2_a21oi_1
XFILLER_94_597 VDD VSS sg13g2_fill_2
XFILLER_19_182 VDD VSS sg13g2_decap_8
XFILLER_165_1345 VDD VSS sg13g2_decap_4
XFILLER_90_770 VDD VSS sg13g2_fill_2
XFILLER_74_1228 VDD VSS sg13g2_fill_1
XFILLER_126_1318 VDD VSS sg13g2_decap_8
XFILLER_165_1378 VDD VSS sg13g2_decap_8
XFILLER_167_308 VDD VSS sg13g2_decap_8
XFILLER_179_168 VDD VSS sg13g2_decap_8
Xclkbuf_leaf_111_clk_i clkload60/A clkbuf_leaf_99_clk_i/A VDD VSS sg13g2_buf_8
XFILLER_124_1031 VDD VSS sg13g2_decap_8
X_09122_ _09125_/B _14919_/Q _09117_/C VDD VSS sg13g2_nor2b_1
XFILLER_175_341 VDD VSS sg13g2_decap_8
X_09053_ _09053_/Y _15233_/Q _09053_/B VDD VSS sg13g2_nand2b_1
XFILLER_135_205 VDD VSS sg13g2_fill_1
X_15250__2794 _15250_/RESET_B VDD VSS sg13g2_tiehi
Xclkbuf_leaf_126_clk_i _14662_/CLK clkload1/A VDD VSS sg13g2_buf_8
X_08004_ _08004_/Y _08104_/B _08174_/A VDD VSS sg13g2_nor2b_1
XFILLER_159_1138 VDD VSS sg13g2_decap_8
XFILLER_50_1294 VDD VSS sg13g2_decap_8
XFILLER_117_953 VDD VSS sg13g2_fill_1
X_14405__1867 _14405_/RESET_B VDD VSS sg13g2_tiehi
XFILLER_116_441 VDD VSS sg13g2_decap_8
XFILLER_11_1267 VDD VSS sg13g2_decap_8
XFILLER_85_1324 VDD VSS sg13g2_decap_8
XFILLER_144_761 VDD VSS sg13g2_decap_8
XFILLER_132_923 VDD VSS sg13g2_decap_8
XFILLER_137_1414 VDD VSS sg13g2_decap_8
XFILLER_144_794 VDD VSS sg13g2_fill_2
XFILLER_85_1357 VDD VSS sg13g2_decap_8
XFILLER_137_1436 VDD VSS sg13g2_decap_8
XFILLER_143_271 VDD VSS sg13g2_decap_8
XFILLER_172_1316 VDD VSS sg13g2_decap_4
XFILLER_89_347 VDD VSS sg13g2_decap_4
XFILLER_89_358 VDD VSS sg13g2_fill_1
X_09955_ _14539_/D _14539_/Q _10087_/A0 _09961_/S VDD VSS sg13g2_mux2_1
XFILLER_48_1190 VDD VSS sg13g2_decap_8
XFILLER_44_1032 VDD VSS sg13g2_decap_8
X_08906_ _08906_/Y _10793_/A _10793_/B _15040_/Q VDD VSS sg13g2_nand3_1
X_14620__1652 _14620_/RESET_B VDD VSS sg13g2_tiehi
X_09886_ _14472_/D _09919_/A1 _14472_/Q _09896_/S VDD VSS sg13g2_mux2_1
XFILLER_100_831 VDD VSS sg13g2_decap_8
XFILLER_131_1024 VDD VSS sg13g2_fill_1
XFILLER_58_756 VDD VSS sg13g2_fill_2
XFILLER_131_1046 VDD VSS sg13g2_decap_8
X_08837_ _08837_/X _10781_/C _10697_/B VDD VSS sg13g2_and2_1
XFILLER_57_244 VDD VSS sg13g2_decap_8
XFILLER_181_7 VDD VSS sg13g2_decap_8
XFILLER_58_778 VDD VSS sg13g2_fill_1
XFILLER_79_1128 VDD VSS sg13g2_decap_8
XFILLER_61_1390 VDD VSS sg13g2_decap_8
XFILLER_22_1352 VDD VSS sg13g2_decap_8
XFILLER_17_119 VDD VSS sg13g2_decap_8
XFILLER_45_428 VDD VSS sg13g2_fill_1
XFILLER_2_1435 VDD VSS sg13g2_decap_8
X_08768_ _13674_/D _08728_/Y _08767_/Y _08766_/Y VDD VSS sg13g2_a21oi_1
XFILLER_72_236 VDD VSS sg13g2_decap_8
XFILLER_26_631 VDD VSS sg13g2_decap_8
X_07719_ _07719_/X _07719_/A _11288_/A VDD VSS sg13g2_or2_1
XFILLER_82_37 VDD VSS sg13g2_decap_8
X_08699_ _08699_/Y _08698_/X _08697_/Y _08696_/Y _08695_/Y VDD VSS sg13g2_a22oi_1
XFILLER_92_1317 VDD VSS sg13g2_decap_8
XFILLER_14_826 VDD VSS sg13g2_decap_8
XFILLER_25_152 VDD VSS sg13g2_decap_8
XFILLER_183_1445 VDD VSS sg13g2_decap_8
XFILLER_26_686 VDD VSS sg13g2_decap_8
XFILLER_0_1170 VDD VSS sg13g2_decap_8
X_10730_ _10730_/Y _13064_/A _11048_/B VDD VSS sg13g2_nand2_1
XFILLER_57_1459 VDD VSS sg13g2_decap_8
XFILLER_13_336 VDD VSS sg13g2_decap_8
XFILLER_15_42 VDD VSS sg13g2_decap_8
XFILLER_186_606 VDD VSS sg13g2_decap_8
XFILLER_40_111 VDD VSS sg13g2_fill_1
XFILLER_186_617 VDD VSS sg13g2_decap_8
XFILLER_41_656 VDD VSS sg13g2_decap_8
XFILLER_185_105 VDD VSS sg13g2_decap_8
X_10661_ _14892_/D _10667_/A _10661_/B _10661_/C VDD VSS sg13g2_nor3_1
XFILLER_9_329 VDD VSS sg13g2_decap_8
XFILLER_90_1052 VDD VSS sg13g2_fill_1
XFILLER_51_1003 VDD VSS sg13g2_decap_8
XFILLER_90_1063 VDD VSS sg13g2_decap_8
X_12400_ _12400_/Y _12400_/A _12400_/B VDD VSS sg13g2_nand2_1
XFILLER_107_1262 VDD VSS sg13g2_decap_8
X_13380_ _13380_/Y _13493_/A1 _13307_/B _15080_/Q VDD VSS sg13g2_o21ai_1
XFILLER_40_188 VDD VSS sg13g2_decap_8
XFILLER_107_1273 VDD VSS sg13g2_fill_1
X_10592_ _14874_/D _10608_/B _10592_/B _10607_/C VDD VSS sg13g2_nor3_1
XFILLER_167_875 VDD VSS sg13g2_decap_8
XFILLER_16_1167 VDD VSS sg13g2_decap_8
XFILLER_127_717 VDD VSS sg13g2_fill_1
X_12331_ _12331_/X _12094_/B _12330_/X _12329_/Y VDD VSS sg13g2_a21o_1
XFILLER_154_536 VDD VSS sg13g2_fill_1
XFILLER_181_322 VDD VSS sg13g2_decap_8
XFILLER_182_845 VDD VSS sg13g2_decap_8
XFILLER_31_63 VDD VSS sg13g2_decap_8
X_15050_ _15050_/Q clkload70/A _15050_/D _15050_/RESET_B VDD VSS sg13g2_dfrbpq_1
X_15070__2958 _15070_/RESET_B VDD VSS sg13g2_tiehi
X_12262_ _12263_/B _12251_/Y _12253_/X _12046_/C VDD VSS sg13g2_o21ai_1
XFILLER_5_546 VDD VSS sg13g2_decap_8
XFILLER_154_569 VDD VSS sg13g2_decap_8
XFILLER_103_0 VDD VSS sg13g2_decap_8
XFILLER_135_772 VDD VSS sg13g2_decap_8
XFILLER_141_208 VDD VSS sg13g2_decap_8
X_14001_ _14001_/Q clkload6/A _14001_/D _14001_/RESET_B VDD VSS sg13g2_dfrbpq_1
X_11213_ _11213_/X _11212_/X _11366_/C _11875_/B VDD VSS sg13g2_a21o_1
XFILLER_181_399 VDD VSS sg13g2_decap_8
X_12193_ _12193_/Y _12192_/Y _12182_/Y _12174_/Y _12164_/Y _12266_/B1 VDD VSS sg13g2_a221oi_1
Xclkbuf_leaf_90_clk_i clkload66/A clkbuf_leaf_93_clk_i/A VDD VSS sg13g2_buf_8
XFILLER_150_731 VDD VSS sg13g2_decap_8
Xoutput41 mem_axi_araddr[12] output41/A VDD VSS sg13g2_buf_1
X_15131__2788 _15131_/RESET_B VDD VSS sg13g2_tiehi
Xoutput52 mem_axi_araddr[23] _13714_/Q VDD VSS sg13g2_buf_1
X_11144_ _11144_/Y _11172_/A _11164_/B VDD VSS sg13g2_nor2_1
Xoutput63 mem_axi_araddr[4] output63/A VDD VSS sg13g2_buf_1
Xoutput74 mem_axi_awaddr[13] _16866_/X VDD VSS sg13g2_buf_1
XFILLER_110_606 VDD VSS sg13g2_fill_1
XFILLER_1_763 VDD VSS sg13g2_decap_8
Xoutput85 mem_axi_awaddr[24] _16877_/X VDD VSS sg13g2_buf_1
XFILLER_95_306 VDD VSS sg13g2_decap_8
XFILLER_7_1302 VDD VSS sg13g2_decap_8
XFILLER_27_1230 VDD VSS sg13g2_decap_8
Xoutput96 mem_axi_awaddr[5] _16858_/X VDD VSS sg13g2_buf_1
XFILLER_89_870 VDD VSS sg13g2_decap_8
XFILLER_66_1290 VDD VSS sg13g2_decap_8
XFILLER_89_881 VDD VSS sg13g2_fill_2
XFILLER_110_639 VDD VSS sg13g2_decap_8
X_11075_ _11118_/B _11125_/A _11097_/A VDD VSS sg13g2_xnor2_1
XFILLER_89_892 VDD VSS sg13g2_decap_8
XFILLER_0_273 VDD VSS sg13g2_decap_8
XFILLER_122_499 VDD VSS sg13g2_decap_8
XFILLER_62_1154 VDD VSS sg13g2_decap_8
XFILLER_49_734 VDD VSS sg13g2_decap_8
Xhold3190 _13616_/A _13724_/Q VDD VSS sg13g2_dlygate4sd3_1
X_14903_ _14903_/Q clkload73/A _14903_/D _14903_/RESET_B VDD VSS sg13g2_dfrbpq_1
X_10026_ _14608_/D _10026_/A0 _14608_/Q _10027_/S VDD VSS sg13g2_mux2_1
XFILLER_76_542 VDD VSS sg13g2_decap_8
XFILLER_23_1127 VDD VSS sg13g2_decap_8
XFILLER_7_1379 VDD VSS sg13g2_decap_8
XFILLER_64_715 VDD VSS sg13g2_decap_8
XFILLER_110_1119 VDD VSS sg13g2_decap_8
X_14834_ _14834_/Q clkload83/A _14834_/D _14834_/RESET_B VDD VSS sg13g2_dfrbpq_1
XFILLER_48_299 VDD VSS sg13g2_decap_8
XFILLER_56_82 VDD VSS sg13g2_decap_8
XFILLER_63_236 VDD VSS sg13g2_decap_8
XFILLER_5_1092 VDD VSS sg13g2_decap_8
XFILLER_91_556 VDD VSS sg13g2_decap_8
X_14765_ _14765_/Q clkload90/A _14765_/D _14765_/RESET_B VDD VSS sg13g2_dfrbpq_1
X_11977_ _11977_/X _14915_/Q _12122_/A2 wire244/X VDD VSS sg13g2_a21o_1
XFILLER_17_686 VDD VSS sg13g2_decap_8
XFILLER_147_1042 VDD VSS sg13g2_fill_1
X_13716_ _13716_/Q clkload53/A _13716_/D _13716_/RESET_B VDD VSS sg13g2_dfrbpq_1
XFILLER_32_623 VDD VSS sg13g2_decap_8
X_10928_ _14936_/D _10927_/Y _10926_/X _10914_/Y VDD VSS sg13g2_o21ai_1
XFILLER_147_1064 VDD VSS sg13g2_fill_1
X_14696_ _14696_/Q clkload23/A _14696_/D _14696_/RESET_B VDD VSS sg13g2_dfrbpq_1
XFILLER_108_1026 VDD VSS sg13g2_decap_8
XFILLER_16_196 VDD VSS sg13g2_decap_8
XFILLER_60_965 VDD VSS sg13g2_decap_8
XFILLER_176_105 VDD VSS sg13g2_decap_8
XFILLER_147_1097 VDD VSS sg13g2_decap_8
X_13647_ _14750_/D _15193_/D _14750_/Q _13647_/S VDD VSS sg13g2_mux2_1
XFILLER_73_1250 VDD VSS sg13g2_decap_8
X_10859_ _10859_/Y _10843_/C _10857_/Y _10858_/Y VDD VSS sg13g2_a21oi_1
XFILLER_158_853 VDD VSS sg13g2_decap_8
XFILLER_34_1245 VDD VSS sg13g2_decap_8
Xclkbuf_leaf_43_clk_i clkload46/A clkbuf_leaf_46_clk_i/A VDD VSS sg13g2_buf_8
X_13578_ _13578_/Y _13578_/A _13581_/B VDD VSS sg13g2_nor2_1
XFILLER_173_801 VDD VSS sg13g2_decap_8
XFILLER_185_672 VDD VSS sg13g2_decap_8
XFILLER_30_1109 VDD VSS sg13g2_decap_8
X_12529_ _12529_/X _14120_/Q _14152_/Q _14184_/Q _14216_/Q _12668_/S0 _12668_/S1 VDD
+ VSS sg13g2_mux4_1
XFILLER_9_896 VDD VSS sg13g2_decap_8
XFILLER_145_536 VDD VSS sg13g2_decap_8
XFILLER_184_182 VDD VSS sg13g2_decap_4
XFILLER_173_867 VDD VSS sg13g2_decap_8
X_15248_ _15248_/Q _15249_/CLK _15248_/D _15248_/RESET_B VDD VSS sg13g2_dfrbpq_1
XFILLER_114_901 VDD VSS sg13g2_decap_8
XFILLER_172_366 VDD VSS sg13g2_decap_8
XFILLER_114_912 VDD VSS sg13g2_decap_8
XFILLER_132_208 VDD VSS sg13g2_decap_8
XFILLER_67_1032 VDD VSS sg13g2_decap_4
Xclkbuf_leaf_58_clk_i clkload77/A clkbuf_leaf_59_clk_i/A VDD VSS sg13g2_buf_8
X_15179_ _15179_/Q _15182_/CLK _15179_/D _15179_/RESET_B VDD VSS sg13g2_dfrbpq_1
XFILLER_119_1133 VDD VSS sg13g2_decap_4
XFILLER_125_293 VDD VSS sg13g2_decap_8
Xfanout308 _10047_/A0 _09019_/Y VDD VSS sg13g2_buf_1
XFILLER_98_144 VDD VSS sg13g2_decap_4
Xfanout319 _09909_/A1 _09744_/A1 VDD VSS sg13g2_buf_1
XFILLER_87_818 VDD VSS sg13g2_decap_8
XFILLER_80_1221 VDD VSS sg13g2_decap_8
XFILLER_45_1341 VDD VSS sg13g2_decap_4
X_09740_ _09772_/S _09938_/D _09740_/B VDD VSS sg13g2_nor2_1
.ends
