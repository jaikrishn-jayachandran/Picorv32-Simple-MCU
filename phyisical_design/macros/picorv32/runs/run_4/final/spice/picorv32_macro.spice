* NGSPICE file created from picorv32_macro.ext - technology: ihp-sg13g2

* Black-box entry subcircuit for sg13g2_mux2_1 abstract view
.subckt sg13g2_mux2_1 X A0 A1 S VDD VSS
.ends

* Black-box entry subcircuit for sg13g2_decap_4 abstract view
.subckt sg13g2_decap_4 VDD VSS
.ends

* Black-box entry subcircuit for sg13g2_decap_8 abstract view
.subckt sg13g2_decap_8 VDD VSS
.ends

* Black-box entry subcircuit for sg13g2_tiehi abstract view
.subckt sg13g2_tiehi L_HI VDD VSS
.ends

* Black-box entry subcircuit for sg13g2_nor3_1 abstract view
.subckt sg13g2_nor3_1 Y A B C VDD VSS
.ends

* Black-box entry subcircuit for sg13g2_nor2_1 abstract view
.subckt sg13g2_nor2_1 Y A B VDD VSS
.ends

* Black-box entry subcircuit for sg13g2_fill_1 abstract view
.subckt sg13g2_fill_1 VDD VSS
.ends

* Black-box entry subcircuit for sg13g2_fill_2 abstract view
.subckt sg13g2_fill_2 VDD VSS
.ends

* Black-box entry subcircuit for sg13g2_o21ai_1 abstract view
.subckt sg13g2_o21ai_1 Y A1 A2 B1 VDD VSS
.ends

* Black-box entry subcircuit for sg13g2_a21oi_1 abstract view
.subckt sg13g2_a21oi_1 Y A1 A2 B1 VDD VSS
.ends

* Black-box entry subcircuit for sg13g2_buf_1 abstract view
.subckt sg13g2_buf_1 X A VDD VSS
.ends

* Black-box entry subcircuit for sg13g2_nor4_1 abstract view
.subckt sg13g2_nor4_1 Y A B C D VDD VSS
.ends

* Black-box entry subcircuit for sg13g2_nand2_1 abstract view
.subckt sg13g2_nand2_1 Y A B VDD VSS
.ends

* Black-box entry subcircuit for sg13g2_a221oi_1 abstract view
.subckt sg13g2_a221oi_1 Y A1 A2 B1 B2 C1 VDD VSS
.ends

* Black-box entry subcircuit for sg13g2_dfrbpq_1 abstract view
.subckt sg13g2_dfrbpq_1 Q CLK D RESET_B VDD VSS
.ends

* Black-box entry subcircuit for sg13g2_mux4_1 abstract view
.subckt sg13g2_mux4_1 X A0 A1 A2 A3 S0 S1 VDD VSS
.ends

* Black-box entry subcircuit for sg13g2_inv_1 abstract view
.subckt sg13g2_inv_1 Y A VDD VSS
.ends

* Black-box entry subcircuit for sg13g2_nand3_1 abstract view
.subckt sg13g2_nand3_1 Y A B C VDD VSS
.ends

* Black-box entry subcircuit for sg13g2_a21o_1 abstract view
.subckt sg13g2_a21o_1 X A1 A2 B1 VDD VSS
.ends

* Black-box entry subcircuit for sg13g2_and4_1 abstract view
.subckt sg13g2_and4_1 X A B C D VDD VSS
.ends

* Black-box entry subcircuit for sg13g2_nand3b_1 abstract view
.subckt sg13g2_nand3b_1 Y A_N B C VDD VSS
.ends

* Black-box entry subcircuit for sg13g2_a22oi_1 abstract view
.subckt sg13g2_a22oi_1 Y A1 A2 B1 B2 VDD VSS
.ends

* Black-box entry subcircuit for sg13g2_and2_1 abstract view
.subckt sg13g2_and2_1 X A B VDD VSS
.ends

* Black-box entry subcircuit for sg13g2_buf_16 abstract view
.subckt sg13g2_buf_16 X A VDD VSS
.ends

* Black-box entry subcircuit for sg13g2_nand2b_1 abstract view
.subckt sg13g2_nand2b_1 Y A_N B VDD VSS
.ends

* Black-box entry subcircuit for sg13g2_or2_1 abstract view
.subckt sg13g2_or2_1 X A B VDD VSS
.ends

* Black-box entry subcircuit for sg13g2_nand4_1 abstract view
.subckt sg13g2_nand4_1 Y A B C D VDD VSS
.ends

* Black-box entry subcircuit for sg13g2_xnor2_1 abstract view
.subckt sg13g2_xnor2_1 Y A B VDD VSS
.ends

* Black-box entry subcircuit for sg13g2_and3_1 abstract view
.subckt sg13g2_and3_1 X A B C VDD VSS
.ends

* Black-box entry subcircuit for sg13g2_dlygate4sd3_1 abstract view
.subckt sg13g2_dlygate4sd3_1 X A VDD VSS
.ends

* Black-box entry subcircuit for sg13g2_or4_1 abstract view
.subckt sg13g2_or4_1 X A B C D VDD VSS
.ends

* Black-box entry subcircuit for sg13g2_antennanp abstract view
.subckt sg13g2_antennanp A VDD VSS
.ends

* Black-box entry subcircuit for sg13g2_buf_8 abstract view
.subckt sg13g2_buf_8 X A VDD VSS
.ends

* Black-box entry subcircuit for sg13g2_nor2b_1 abstract view
.subckt sg13g2_nor2b_1 Y A B_N VDD VSS
.ends

* Black-box entry subcircuit for sg13g2_buf_2 abstract view
.subckt sg13g2_buf_2 X A VDD VSS
.ends

* Black-box entry subcircuit for sg13g2_xor2_1 abstract view
.subckt sg13g2_xor2_1 X A B VDD VSS
.ends

* Black-box entry subcircuit for sg13g2_inv_4 abstract view
.subckt sg13g2_inv_4 Y A VDD VSS
.ends

* Black-box entry subcircuit for sg13g2_or3_1 abstract view
.subckt sg13g2_or3_1 X A B C VDD VSS
.ends

* Black-box entry subcircuit for sg13g2_buf_4 abstract view
.subckt sg13g2_buf_4 X A VDD VSS
.ends

* Black-box entry subcircuit for sg13g2_inv_2 abstract view
.subckt sg13g2_inv_2 Y A VDD VSS
.ends

* Black-box entry subcircuit for sg13g2_tielo abstract view
.subckt sg13g2_tielo L_LO VDD VSS
.ends

.subckt picorv32_macro VDD VSS clk_i mem_axi_araddr[0] mem_axi_araddr[10] mem_axi_araddr[11]
+ mem_axi_araddr[12] mem_axi_araddr[13] mem_axi_araddr[14] mem_axi_araddr[15] mem_axi_araddr[16]
+ mem_axi_araddr[17] mem_axi_araddr[18] mem_axi_araddr[19] mem_axi_araddr[1] mem_axi_araddr[20]
+ mem_axi_araddr[21] mem_axi_araddr[22] mem_axi_araddr[23] mem_axi_araddr[24] mem_axi_araddr[25]
+ mem_axi_araddr[26] mem_axi_araddr[27] mem_axi_araddr[28] mem_axi_araddr[29] mem_axi_araddr[2]
+ mem_axi_araddr[30] mem_axi_araddr[31] mem_axi_araddr[3] mem_axi_araddr[4] mem_axi_araddr[5]
+ mem_axi_araddr[6] mem_axi_araddr[7] mem_axi_araddr[8] mem_axi_araddr[9] mem_axi_arprot[0]
+ mem_axi_arprot[1] mem_axi_arprot[2] mem_axi_arready mem_axi_arvalid mem_axi_awaddr[0]
+ mem_axi_awaddr[10] mem_axi_awaddr[11] mem_axi_awaddr[12] mem_axi_awaddr[13] mem_axi_awaddr[14]
+ mem_axi_awaddr[15] mem_axi_awaddr[16] mem_axi_awaddr[17] mem_axi_awaddr[18] mem_axi_awaddr[19]
+ mem_axi_awaddr[1] mem_axi_awaddr[20] mem_axi_awaddr[21] mem_axi_awaddr[22] mem_axi_awaddr[23]
+ mem_axi_awaddr[24] mem_axi_awaddr[25] mem_axi_awaddr[26] mem_axi_awaddr[27] mem_axi_awaddr[28]
+ mem_axi_awaddr[29] mem_axi_awaddr[2] mem_axi_awaddr[30] mem_axi_awaddr[31] mem_axi_awaddr[3]
+ mem_axi_awaddr[4] mem_axi_awaddr[5] mem_axi_awaddr[6] mem_axi_awaddr[7] mem_axi_awaddr[8]
+ mem_axi_awaddr[9] mem_axi_awprot[0] mem_axi_awprot[1] mem_axi_awprot[2] mem_axi_awready
+ mem_axi_awvalid mem_axi_bready mem_axi_bvalid mem_axi_rdata[0] mem_axi_rdata[10]
+ mem_axi_rdata[11] mem_axi_rdata[12] mem_axi_rdata[13] mem_axi_rdata[14] mem_axi_rdata[15]
+ mem_axi_rdata[16] mem_axi_rdata[17] mem_axi_rdata[18] mem_axi_rdata[19] mem_axi_rdata[1]
+ mem_axi_rdata[20] mem_axi_rdata[21] mem_axi_rdata[22] mem_axi_rdata[23] mem_axi_rdata[24]
+ mem_axi_rdata[25] mem_axi_rdata[26] mem_axi_rdata[27] mem_axi_rdata[28] mem_axi_rdata[29]
+ mem_axi_rdata[2] mem_axi_rdata[30] mem_axi_rdata[31] mem_axi_rdata[3] mem_axi_rdata[4]
+ mem_axi_rdata[5] mem_axi_rdata[6] mem_axi_rdata[7] mem_axi_rdata[8] mem_axi_rdata[9]
+ mem_axi_rready mem_axi_rvalid mem_axi_wdata[0] mem_axi_wdata[10] mem_axi_wdata[11]
+ mem_axi_wdata[12] mem_axi_wdata[13] mem_axi_wdata[14] mem_axi_wdata[15] mem_axi_wdata[16]
+ mem_axi_wdata[17] mem_axi_wdata[18] mem_axi_wdata[19] mem_axi_wdata[1] mem_axi_wdata[20]
+ mem_axi_wdata[21] mem_axi_wdata[22] mem_axi_wdata[23] mem_axi_wdata[24] mem_axi_wdata[25]
+ mem_axi_wdata[26] mem_axi_wdata[27] mem_axi_wdata[28] mem_axi_wdata[29] mem_axi_wdata[2]
+ mem_axi_wdata[30] mem_axi_wdata[31] mem_axi_wdata[3] mem_axi_wdata[4] mem_axi_wdata[5]
+ mem_axi_wdata[6] mem_axi_wdata[7] mem_axi_wdata[8] mem_axi_wdata[9] mem_axi_wready
+ mem_axi_wstrb[0] mem_axi_wstrb[1] mem_axi_wstrb[2] mem_axi_wstrb[3] mem_axi_wvalid
+ rst_ni trap
X_09671_ _14264_/D _09935_/A1 _14264_/Q _09673_/S VDD VSS sg13g2_mux2_1
XFILLER_132_1366 VDD VSS sg13g2_decap_4
XFILLER_80_1298 VDD VSS sg13g2_decap_8
XFILLER_39_255 VDD VSS sg13g2_decap_8
X_15217__2985 _15217_/RESET_B VDD VSS sg13g2_tiehi
X_08622_ _08622_/Y _08622_/A _08622_/B _08622_/C VDD VSS sg13g2_nor3_1
XFILLER_27_428 VDD VSS sg13g2_decap_8
XFILLER_39_299 VDD VSS sg13g2_decap_8
XFILLER_54_258 VDD VSS sg13g2_decap_8
X_14449__1730 _14449_/RESET_B VDD VSS sg13g2_tiehi
X_08553_ _08553_/Y _08553_/A _08553_/B VDD VSS sg13g2_nor2_1
XFILLER_82_589 VDD VSS sg13g2_fill_1
XFILLER_74_1003 VDD VSS sg13g2_decap_8
XFILLER_23_601 VDD VSS sg13g2_decap_8
X_08484_ _08484_/Y _08625_/A _08560_/A _08484_/C VDD VSS sg13g2_nor3_1
XFILLER_126_1104 VDD VSS sg13g2_fill_2
XFILLER_22_133 VDD VSS sg13g2_decap_8
XFILLER_167_105 VDD VSS sg13g2_decap_8
XFILLER_52_1301 VDD VSS sg13g2_decap_8
XFILLER_126_1159 VDD VSS sg13g2_decap_8
XFILLER_91_1372 VDD VSS sg13g2_decap_8
XFILLER_91_1383 VDD VSS sg13g2_fill_1
XFILLER_52_1334 VDD VSS sg13g2_decap_8
XFILLER_149_864 VDD VSS sg13g2_decap_8
XFILLER_52_1367 VDD VSS sg13g2_decap_8
X_09105_ _09105_/Y _09111_/A1 _10752_/B _09104_/X VDD VSS sg13g2_o21ai_1
XFILLER_148_385 VDD VSS sg13g2_decap_8
XFILLER_163_322 VDD VSS sg13g2_decap_8
X_09036_ _09036_/Y _14906_/Q _09031_/C _09035_/Y VDD VSS sg13g2_a21oi_1
XFILLER_11_1064 VDD VSS sg13g2_decap_8
XFILLER_163_399 VDD VSS sg13g2_decap_8
XFILLER_137_1222 VDD VSS sg13g2_fill_2
XFILLER_144_591 VDD VSS sg13g2_decap_4
X_14551__1628 _14551_/RESET_B VDD VSS sg13g2_tiehi
XFILLER_7_7 VDD VSS sg13g2_decap_8
X_13937__2242 _13937_/RESET_B VDD VSS sg13g2_tiehi
X_14697__1482 _14697_/RESET_B VDD VSS sg13g2_tiehi
XFILLER_132_764 VDD VSS sg13g2_decap_4
XFILLER_81_1029 VDD VSS sg13g2_decap_8
Xfanout820 _12396_/S1 _12352_/S1 VDD VSS sg13g2_buf_1
XFILLER_78_829 VDD VSS sg13g2_decap_8
XFILLER_120_926 VDD VSS sg13g2_decap_8
Xfanout831 _12716_/S1 _12717_/S1 VDD VSS sg13g2_buf_1
XFILLER_120_948 VDD VSS sg13g2_fill_1
Xfanout842 _12452_/S1 _12437_/S1 VDD VSS sg13g2_buf_1
X_09938_ wire320/A _09938_/A _09938_/B _09938_/C _09938_/D VDD VSS sg13g2_nor4_1
Xfanout853 _12606_/S0 _12507_/S0 VDD VSS sg13g2_buf_1
Xfanout864 fanout864/X fanout897/X VDD VSS sg13g2_buf_1
XFILLER_86_840 VDD VSS sg13g2_decap_8
XFILLER_133_21 VDD VSS sg13g2_decap_8
Xfanout875 _12783_/S0 _12782_/S0 VDD VSS sg13g2_buf_1
Xfanout886 _12546_/S0 _12773_/S0 VDD VSS sg13g2_buf_1
XFILLER_100_650 VDD VSS sg13g2_fill_2
Xfanout897 fanout897/X _15210_/Q VDD VSS sg13g2_buf_1
X_09869_ _14456_/D _14456_/Q _10167_/A1 _09870_/S VDD VSS sg13g2_mux2_1
XFILLER_58_564 VDD VSS sg13g2_decap_8
XFILLER_73_501 VDD VSS sg13g2_decap_4
XFILLER_18_406 VDD VSS sg13g2_decap_8
XFILLER_100_672 VDD VSS sg13g2_decap_8
XFILLER_93_14 VDD VSS sg13g2_decap_8
X_11900_ _11900_/Y _11900_/A _11900_/B VDD VSS sg13g2_nand2_1
XFILLER_58_597 VDD VSS sg13g2_decap_8
X_12880_ _12880_/Y _14804_/Q _12851_/B _12895_/B _14868_/Q _12917_/B1 VDD VSS sg13g2_a221oi_1
XFILLER_2_1232 VDD VSS sg13g2_decap_8
XFILLER_45_247 VDD VSS sg13g2_decap_8
X_14848__2848 _14848_/RESET_B VDD VSS sg13g2_tiehi
X_11831_ _11832_/B _11820_/Y _11822_/X _11224_/A VDD VSS sg13g2_o21ai_1
XFILLER_73_567 VDD VSS sg13g2_decap_8
XFILLER_60_206 VDD VSS sg13g2_decap_8
XFILLER_57_1223 VDD VSS sg13g2_decap_8
XFILLER_26_63 VDD VSS sg13g2_decap_8
XFILLER_148_1351 VDD VSS sg13g2_fill_2
XFILLER_42_921 VDD VSS sg13g2_decap_8
XFILLER_14_623 VDD VSS sg13g2_decap_8
X_14550_ _14550_/Q clkload24/A _14550_/D _14550_/RESET_B VDD VSS sg13g2_dfrbpq_1
XFILLER_148_1362 VDD VSS sg13g2_fill_1
X_11762_ _11763_/A _14698_/Q _14730_/Q _13770_/Q _13802_/Q _11759_/A _11762_/S1 VDD
+ VSS sg13g2_mux4_1
XFILLER_159_617 VDD VSS sg13g2_decap_8
XFILLER_18_1218 VDD VSS sg13g2_decap_8
XFILLER_13_133 VDD VSS sg13g2_decap_8
X_13501_ _13501_/Y _13655_/S _15129_/Q VDD VSS sg13g2_nand2_1
XFILLER_158_105 VDD VSS sg13g2_decap_8
X_10713_ _10936_/B _10954_/B VDD VSS sg13g2_inv_1
XFILLER_144_1248 VDD VSS sg13g2_decap_8
XFILLER_159_639 VDD VSS sg13g2_fill_1
X_14481_ _14481_/Q _14667_/CLK _14481_/D _14481_/RESET_B VDD VSS sg13g2_dfrbpq_1
X_11693_ _11694_/B _11693_/A _11693_/B _12026_/C VDD VSS sg13g2_nand3_1
XFILLER_144_1259 VDD VSS sg13g2_fill_2
XFILLER_9_126 VDD VSS sg13g2_decap_8
X_13432_ _15098_/D _15098_/Q _13470_/A2 _13431_/Y VDD VSS sg13g2_a21o_1
X_10644_ _10644_/Y _14889_/Q _10643_/C _10392_/B VDD VSS sg13g2_o21ai_1
XFILLER_10_840 VDD VSS sg13g2_decap_8
XFILLER_42_84 VDD VSS sg13g2_decap_8
X_14751__2965 _14751_/RESET_B VDD VSS sg13g2_tiehi
XFILLER_173_119 VDD VSS sg13g2_decap_8
XFILLER_167_694 VDD VSS sg13g2_fill_1
X_13363_ _13363_/Y _13407_/A _13398_/B _15074_/Q VDD VSS sg13g2_nand3_1
X_10575_ _10586_/D _14870_/Q _10647_/C _10575_/C _10653_/A VDD VSS sg13g2_and4_1
XFILLER_42_95 VDD VSS sg13g2_decap_8
XFILLER_158_84 VDD VSS sg13g2_decap_8
XFILLER_166_182 VDD VSS sg13g2_decap_8
XFILLER_6_833 VDD VSS sg13g2_decap_8
XFILLER_155_856 VDD VSS sg13g2_decap_8
X_15102_ _15102_/Q clkload61/A _15102_/D _15102_/RESET_B VDD VSS sg13g2_dfrbpq_1
XFILLER_127_558 VDD VSS sg13g2_decap_8
X_12314_ _12314_/Y _12321_/A1 _14682_/Q _12328_/B1 VDD VSS sg13g2_a21oi_1
XFILLER_155_878 VDD VSS sg13g2_decap_8
XFILLER_154_355 VDD VSS sg13g2_decap_8
X_13294_ _13294_/Y _15204_/Q _13294_/B _13294_/C VDD VSS sg13g2_nand3b_1
XFILLER_5_343 VDD VSS sg13g2_decap_8
X_14190__1989 _14190_/RESET_B VDD VSS sg13g2_tiehi
XFILLER_120_1281 VDD VSS sg13g2_decap_4
X_15033_ _15033_/Q clkload57/A _15033_/D _15033_/RESET_B VDD VSS sg13g2_dfrbpq_1
XFILLER_120_1292 VDD VSS sg13g2_fill_1
X_12245_ _12246_/A _13752_/Q _14104_/Q _14456_/Q _14552_/Q _12017_/A _12169_/C VDD
+ VSS sg13g2_mux4_1
XFILLER_29_1303 VDD VSS sg13g2_decap_8
XFILLER_170_859 VDD VSS sg13g2_decap_8
XFILLER_111_904 VDD VSS sg13g2_decap_8
XFILLER_122_230 VDD VSS sg13g2_decap_8
X_14527__1652 _14527_/RESET_B VDD VSS sg13g2_tiehi
X_12176_ _12176_/Y _12257_/A1 _14422_/Q _12212_/S1 VDD VSS sg13g2_a21oi_1
XFILLER_174_72 VDD VSS sg13g2_decap_8
XFILLER_174_83 VDD VSS sg13g2_decap_8
XFILLER_116_1328 VDD VSS sg13g2_fill_1
XFILLER_123_797 VDD VSS sg13g2_decap_8
XFILLER_1_560 VDD VSS sg13g2_decap_8
X_11127_ _11127_/Y _11127_/A _11127_/B _11146_/A VDD VSS sg13g2_nand3_1
XFILLER_3_56 VDD VSS sg13g2_decap_8
XFILLER_96_659 VDD VSS sg13g2_fill_2
XFILLER_110_458 VDD VSS sg13g2_decap_4
XFILLER_114_1030 VDD VSS sg13g2_fill_2
XFILLER_77_851 VDD VSS sg13g2_decap_8
XFILLER_27_1082 VDD VSS sg13g2_decap_8
X_11058_ _11058_/Y _11145_/A _11078_/B VDD VSS sg13g2_nor2_1
XFILLER_67_70 VDD VSS sg13g2_decap_8
XFILLER_95_169 VDD VSS sg13g2_decap_4
XFILLER_7_1176 VDD VSS sg13g2_decap_8
XFILLER_37_715 VDD VSS sg13g2_decap_8
XFILLER_92_810 VDD VSS sg13g2_decap_8
X_10009_ _14591_/D _10109_/A0 _14591_/Q _10027_/S VDD VSS sg13g2_mux2_1
XFILLER_64_512 VDD VSS sg13g2_decap_4
XFILLER_3_1029 VDD VSS sg13g2_decap_8
XFILLER_91_320 VDD VSS sg13g2_fill_1
XFILLER_40_1260 VDD VSS sg13g2_decap_8
XFILLER_91_342 VDD VSS sg13g2_decap_8
X_14817_ _14817_/Q _14886_/CLK _14817_/D _14817_/RESET_B VDD VSS sg13g2_dfrbpq_1
XFILLER_75_1301 VDD VSS sg13g2_decap_8
XFILLER_18_973 VDD VSS sg13g2_decap_8
XFILLER_64_589 VDD VSS sg13g2_decap_8
XFILLER_17_483 VDD VSS sg13g2_decap_8
X_14748_ _14748_/Q _15214_/CLK _14748_/D _14748_/RESET_B VDD VSS sg13g2_dfrbpq_1
XFILLER_75_1367 VDD VSS sg13g2_decap_8
XFILLER_162_1337 VDD VSS sg13g2_decap_8
X_14679_ _14679_/Q clkload33/A _14679_/D _14679_/RESET_B VDD VSS sg13g2_dfrbpq_1
XFILLER_32_464 VDD VSS sg13g2_decap_8
XFILLER_20_637 VDD VSS sg13g2_decap_8
XFILLER_158_650 VDD VSS sg13g2_decap_8
XFILLER_164_119 VDD VSS sg13g2_decap_8
XFILLER_158_694 VDD VSS sg13g2_fill_1
XFILLER_9_693 VDD VSS sg13g2_decap_8
XFILLER_69_1105 VDD VSS sg13g2_decap_8
XFILLER_69_1116 VDD VSS sg13g2_fill_2
XFILLER_66_0 VDD VSS sg13g2_decap_8
XFILLER_12_1351 VDD VSS sg13g2_decap_8
XFILLER_121_1078 VDD VSS sg13g2_decap_8
XFILLER_145_366 VDD VSS sg13g2_fill_2
X_14952__2640 _14952_/RESET_B VDD VSS sg13g2_tiehi
XFILLER_172_196 VDD VSS sg13g2_decap_8
XFILLER_99_431 VDD VSS sg13g2_decap_8
XFILLER_160_358 VDD VSS sg13g2_decap_8
XFILLER_114_775 VDD VSS sg13g2_decap_8
XFILLER_114_786 VDD VSS sg13g2_fill_2
XFILLER_59_317 VDD VSS sg13g2_decap_8
XFILLER_99_497 VDD VSS sg13g2_fill_1
Xfanout149 _10068_/A0 _10101_/A0 VDD VSS sg13g2_buf_1
X_07984_ _07985_/D _07908_/A _15073_/Q _15215_/Q _07977_/Y VDD VSS sg13g2_a22oi_1
XFILLER_86_136 VDD VSS sg13g2_decap_8
XFILLER_80_1051 VDD VSS sg13g2_decap_8
X_09723_ _14314_/D _09921_/A1 _14314_/Q _09733_/S VDD VSS sg13g2_mux2_1
XFILLER_74_309 VDD VSS sg13g2_fill_1
XFILLER_171_1190 VDD VSS sg13g2_decap_8
XFILLER_68_895 VDD VSS sg13g2_decap_4
XFILLER_27_203 VDD VSS sg13g2_decap_8
XFILLER_132_1174 VDD VSS sg13g2_decap_8
X_09654_ _14247_/D _09720_/A0 _14247_/Q _09670_/S VDD VSS sg13g2_mux2_1
XFILLER_83_865 VDD VSS sg13g2_decap_8
X_08605_ _08605_/X _08605_/A _08605_/B VDD VSS sg13g2_and2_1
XFILLER_167_1237 VDD VSS sg13g2_decap_8
XFILLER_43_718 VDD VSS sg13g2_decap_8
X_09585_ _14182_/D _14182_/Q _09884_/A0 _09596_/S VDD VSS sg13g2_mux2_1
XFILLER_63_28 VDD VSS sg13g2_decap_8
XFILLER_24_910 VDD VSS sg13g2_fill_1
X_08536_ _08545_/A _13533_/A _08214_/X _08688_/C VDD VSS sg13g2_o21ai_1
XFILLER_35_280 VDD VSS sg13g2_decap_8
XFILLER_23_420 VDD VSS sg13g2_decap_8
XFILLER_169_926 VDD VSS sg13g2_fill_2
XFILLER_35_291 VDD VSS sg13g2_fill_2
X_15242__3010 _15242_/RESET_B VDD VSS sg13g2_tiehi
XFILLER_144_7 VDD VSS sg13g2_decap_8
X_08467_ _08469_/A _13529_/A _08617_/B VDD VSS sg13g2_nor2_1
XFILLER_51_773 VDD VSS sg13g2_decap_4
XFILLER_11_637 VDD VSS sg13g2_decap_8
X_14605__1574 _14605_/RESET_B VDD VSS sg13g2_tiehi
XFILLER_23_497 VDD VSS sg13g2_decap_8
XFILLER_168_469 VDD VSS sg13g2_decap_8
X_08398_ _08398_/Y _07911_/A wire660/X _08242_/A VDD VSS sg13g2_o21ai_1
XFILLER_52_1153 VDD VSS sg13g2_decap_8
XFILLER_10_147 VDD VSS sg13g2_decap_8
XFILLER_155_119 VDD VSS sg13g2_decap_8
XFILLER_52_1164 VDD VSS sg13g2_fill_1
XFILLER_12_21 VDD VSS sg13g2_decap_8
Xclkbuf_5_6__f_clk_i clkbuf_5_6__f_clk_i/X clkbuf_4_3_0_clk_i/X VDD VSS sg13g2_buf_16
XFILLER_17_1295 VDD VSS sg13g2_decap_8
XFILLER_136_322 VDD VSS sg13g2_decap_4
XFILLER_104_1265 VDD VSS sg13g2_decap_8
XFILLER_13_1148 VDD VSS sg13g2_decap_8
XFILLER_87_1205 VDD VSS sg13g2_fill_2
XFILLER_128_21 VDD VSS sg13g2_decap_8
X_10360_ _14811_/D _10364_/C _10599_/A _10360_/C VDD VSS sg13g2_nor3_1
XFILLER_136_355 VDD VSS sg13g2_decap_8
XFILLER_104_1298 VDD VSS sg13g2_decap_8
XFILLER_12_98 VDD VSS sg13g2_decap_8
XFILLER_88_14 VDD VSS sg13g2_decap_8
XFILLER_174_1208 VDD VSS sg13g2_fill_2
XFILLER_152_837 VDD VSS sg13g2_fill_1
X_09019_ _09019_/Y _09019_/A _09019_/B VDD VSS sg13g2_nand2_1
X_10291_ _10292_/C _14791_/Q _10294_/C VDD VSS sg13g2_and2_1
XFILLER_3_847 VDD VSS sg13g2_decap_8
XFILLER_163_196 VDD VSS sg13g2_decap_8
X_12030_ _12030_/Y _12235_/A _14386_/Q VDD VSS sg13g2_nand2b_1
XFILLER_137_1030 VDD VSS sg13g2_decap_4
XFILLER_2_357 VDD VSS sg13g2_decap_8
XFILLER_104_252 VDD VSS sg13g2_fill_1
XFILLER_144_42 VDD VSS sg13g2_decap_8
XFILLER_120_734 VDD VSS sg13g2_decap_8
XFILLER_137_1096 VDD VSS sg13g2_decap_8
XFILLER_104_296 VDD VSS sg13g2_fill_1
XFILLER_24_1211 VDD VSS sg13g2_decap_8
Xfanout650 _13152_/A2 _13208_/A2 VDD VSS sg13g2_buf_1
Xfanout661 _09204_/C _11207_/B1 VDD VSS sg13g2_buf_1
Xfanout672 _12123_/A1 _11868_/A VDD VSS sg13g2_buf_1
X_13981_ _13981_/Q clkload38/A _13981_/D _13981_/RESET_B VDD VSS sg13g2_dfrbpq_1
Xfanout683 _11458_/A _07682_/Y VDD VSS sg13g2_buf_1
XFILLER_98_1301 VDD VSS sg13g2_fill_2
XFILLER_4_1316 VDD VSS sg13g2_decap_8
Xfanout694 _12335_/B1 _07656_/Y VDD VSS sg13g2_buf_1
XFILLER_115_1383 VDD VSS sg13g2_fill_1
XFILLER_18_203 VDD VSS sg13g2_decap_8
X_12932_ _12932_/Y _12929_/Y _12930_/Y _12931_/Y VDD VSS sg13g2_a21oi_1
XFILLER_98_1334 VDD VSS sg13g2_decap_8
XFILLER_74_832 VDD VSS sg13g2_decap_8
XFILLER_100_480 VDD VSS sg13g2_fill_2
XFILLER_24_1288 VDD VSS sg13g2_decap_8
XFILLER_170_0 VDD VSS sg13g2_decap_8
XFILLER_94_1209 VDD VSS sg13g2_decap_8
XFILLER_37_84 VDD VSS sg13g2_decap_8
XFILLER_160_63 VDD VSS sg13g2_decap_8
X_12863_ _12863_/Y _14803_/Q _12851_/B _07728_/B _14835_/Q _12917_/B1 VDD VSS sg13g2_a221oi_1
XFILLER_61_504 VDD VSS sg13g2_decap_8
XFILLER_15_910 VDD VSS sg13g2_decap_8
XFILLER_46_589 VDD VSS sg13g2_fill_2
X_14602_ _14602_/Q _14730_/CLK _14602_/D _14602_/RESET_B VDD VSS sg13g2_dfrbpq_1
X_11814_ _11815_/A _13740_/Q _14092_/Q _14444_/Q _14540_/Q _11814_/S0 _11805_/C VDD
+ VSS sg13g2_mux4_1
XFILLER_61_537 VDD VSS sg13g2_decap_8
XFILLER_14_420 VDD VSS sg13g2_decap_8
X_12794_ _13600_/B _12997_/B _12936_/B VDD VSS sg13g2_or2_1
XFILLER_96_1091 VDD VSS sg13g2_decap_8
XFILLER_18_1015 VDD VSS sg13g2_decap_8
X_14533_ _14533_/Q clkload5/A _14533_/D _14533_/RESET_B VDD VSS sg13g2_dfrbpq_1
XFILLER_15_987 VDD VSS sg13g2_decap_8
X_11745_ _11745_/Y _11745_/A _11745_/B VDD VSS sg13g2_nand2_1
XFILLER_57_1075 VDD VSS sg13g2_decap_8
XFILLER_30_924 VDD VSS sg13g2_decap_4
XFILLER_144_1045 VDD VSS sg13g2_decap_8
XFILLER_14_497 VDD VSS sg13g2_decap_8
X_14464_ _14464_/Q clkload27/A _14464_/D _14464_/RESET_B VDD VSS sg13g2_dfrbpq_1
X_11676_ _11676_/Y _11676_/A1 _14664_/Q _11690_/B VDD VSS sg13g2_a21oi_1
XFILLER_168_970 VDD VSS sg13g2_decap_4
XFILLER_128_812 VDD VSS sg13g2_fill_1
XFILLER_31_1204 VDD VSS sg13g2_decap_8
XFILLER_161_1381 VDD VSS sg13g2_fill_2
X_13415_ _15092_/D _15129_/Q _13414_/Y _13409_/Y VDD VSS sg13g2_a21o_1
XFILLER_122_1343 VDD VSS sg13g2_fill_2
XFILLER_139_160 VDD VSS sg13g2_fill_1
X_10627_ _10630_/A _14883_/Q _10632_/D _14884_/Q VDD VSS sg13g2_a21o_1
XFILLER_155_620 VDD VSS sg13g2_decap_8
X_14395_ _14395_/Q _14885_/CLK _14395_/D _14395_/RESET_B VDD VSS sg13g2_dfrbpq_1
XFILLER_127_322 VDD VSS sg13g2_fill_2
XFILLER_6_630 VDD VSS sg13g2_decap_8
X_13346_ _13347_/A _13346_/A _15173_/D VDD VSS sg13g2_nor2_1
XFILLER_115_506 VDD VSS sg13g2_decap_8
X_15216__2984 _15216_/RESET_B VDD VSS sg13g2_tiehi
X_10558_ _10561_/B _14859_/Q _10558_/B _10558_/C _14856_/Q VDD VSS sg13g2_nand4_1
XFILLER_5_140 VDD VSS sg13g2_decap_8
XFILLER_154_163 VDD VSS sg13g2_fill_1
XFILLER_142_314 VDD VSS sg13g2_fill_2
XFILLER_170_623 VDD VSS sg13g2_decap_8
XFILLER_154_185 VDD VSS sg13g2_decap_8
X_13277_ _13277_/Y _13048_/X _13272_/X _13276_/Y VDD VSS sg13g2_a21oi_1
X_10489_ _10498_/D _14850_/Q _14849_/Q _10489_/C _10489_/D VDD VSS sg13g2_and4_1
X_15016_ _15016_/Q clkload33/A _15016_/D _15016_/RESET_B VDD VSS sg13g2_dfrbpq_1
XFILLER_170_678 VDD VSS sg13g2_fill_2
X_13678__2516 _13678_/RESET_B VDD VSS sg13g2_tiehi
X_12228_ _12274_/B _12229_/A _13664_/Q VDD VSS sg13g2_nor2_1
XFILLER_69_604 VDD VSS sg13g2_decap_8
XFILLER_111_701 VDD VSS sg13g2_decap_8
XFILLER_155_1152 VDD VSS sg13g2_fill_2
X_14043__2136 _14043_/RESET_B VDD VSS sg13g2_tiehi
XFILLER_111_712 VDD VSS sg13g2_fill_1
XFILLER_97_935 VDD VSS sg13g2_decap_8
XFILLER_97_946 VDD VSS sg13g2_fill_2
XFILLER_69_637 VDD VSS sg13g2_decap_8
XFILLER_29_1177 VDD VSS sg13g2_decap_8
XFILLER_123_594 VDD VSS sg13g2_fill_1
XFILLER_151_1016 VDD VSS sg13g2_fill_1
X_12159_ _12159_/Y _12168_/A _14198_/Q VDD VSS sg13g2_nand2b_1
XFILLER_110_222 VDD VSS sg13g2_fill_2
XFILLER_68_158 VDD VSS sg13g2_fill_1
XFILLER_83_106 VDD VSS sg13g2_decap_8
XFILLER_77_670 VDD VSS sg13g2_fill_2
XFILLER_42_1355 VDD VSS sg13g2_decap_8
XFILLER_110_299 VDD VSS sg13g2_decap_8
XFILLER_37_545 VDD VSS sg13g2_decap_8
XFILLER_37_589 VDD VSS sg13g2_decap_8
XFILLER_18_770 VDD VSS sg13g2_decap_8
XFILLER_24_217 VDD VSS sg13g2_decap_8
X_09370_ _13974_/D _10098_/A0 _13974_/Q _09370_/S VDD VSS sg13g2_mux2_1
XFILLER_80_857 VDD VSS sg13g2_decap_4
XFILLER_17_280 VDD VSS sg13g2_decap_8
XFILLER_127_1210 VDD VSS sg13g2_decap_8
XFILLER_75_1142 VDD VSS sg13g2_fill_1
XFILLER_127_1232 VDD VSS sg13g2_decap_4
X_08321_ _08321_/Y _08369_/B _08350_/B VDD VSS sg13g2_nand2_1
XFILLER_75_1175 VDD VSS sg13g2_decap_8
XFILLER_21_924 VDD VSS sg13g2_decap_8
XFILLER_33_795 VDD VSS sg13g2_fill_2
X_14996__2591 _14996_/RESET_B VDD VSS sg13g2_tiehi
X_08252_ _08252_/Y _08241_/A _08057_/Y _08241_/Y VDD VSS sg13g2_o21ai_1
XFILLER_127_1287 VDD VSS sg13g2_decap_8
XFILLER_166_918 VDD VSS sg13g2_fill_1
XFILLER_20_434 VDD VSS sg13g2_decap_8
XFILLER_165_406 VDD VSS sg13g2_decap_8
X_08183_ _08183_/Y _13427_/C _08183_/B _08183_/C VDD VSS sg13g2_nor3_1
X_14253__1926 _14253_/RESET_B VDD VSS sg13g2_tiehi
XFILLER_9_490 VDD VSS sg13g2_decap_8
X_14399__1780 _14399_/RESET_B VDD VSS sg13g2_tiehi
XFILLER_161_601 VDD VSS sg13g2_decap_8
XFILLER_146_686 VDD VSS sg13g2_decap_8
XFILLER_173_494 VDD VSS sg13g2_decap_8
XFILLER_160_133 VDD VSS sg13g2_decap_8
XFILLER_88_902 VDD VSS sg13g2_fill_2
XFILLER_114_550 VDD VSS sg13g2_decap_8
XFILLER_86_1293 VDD VSS sg13g2_decap_8
XFILLER_0_828 VDD VSS sg13g2_decap_8
XFILLER_134_1214 VDD VSS sg13g2_decap_8
XFILLER_142_881 VDD VSS sg13g2_fill_2
XFILLER_58_28 VDD VSS sg13g2_decap_8
XFILLER_138_1383 VDD VSS sg13g2_fill_1
X_14019__2160 _14019_/RESET_B VDD VSS sg13g2_tiehi
XFILLER_99_283 VDD VSS sg13g2_decap_8
XFILLER_88_946 VDD VSS sg13g2_decap_8
XFILLER_173_1274 VDD VSS sg13g2_decap_8
XFILLER_134_1236 VDD VSS sg13g2_decap_4
XFILLER_88_968 VDD VSS sg13g2_fill_1
XFILLER_87_467 VDD VSS sg13g2_decap_8
XFILLER_75_607 VDD VSS sg13g2_fill_1
XFILLER_134_1269 VDD VSS sg13g2_fill_1
X_07967_ _07967_/Y _07964_/Y _07856_/Y _07965_/Y VDD VSS sg13g2_o21ai_1
XFILLER_75_629 VDD VSS sg13g2_fill_1
XFILLER_68_681 VDD VSS sg13g2_decap_8
X_09706_ _14298_/D _09772_/A1 _14298_/Q _09706_/S VDD VSS sg13g2_mux2_1
XFILLER_28_534 VDD VSS sg13g2_decap_8
X_07898_ _07905_/B _08183_/B _08188_/A _07879_/Y VDD VSS sg13g2_o21ai_1
XFILLER_55_331 VDD VSS sg13g2_decap_8
XFILLER_16_707 VDD VSS sg13g2_decap_8
X_09637_ _14233_/D _10068_/A0 _14233_/Q _09637_/S VDD VSS sg13g2_mux2_1
XFILLER_28_578 VDD VSS sg13g2_fill_1
X_13741__2438 _13741_/RESET_B VDD VSS sg13g2_tiehi
XFILLER_15_217 VDD VSS sg13g2_decap_8
XFILLER_167_1045 VDD VSS sg13g2_decap_8
X_13887__2292 _13887_/RESET_B VDD VSS sg13g2_tiehi
XFILLER_55_386 VDD VSS sg13g2_decap_8
XFILLER_110_1280 VDD VSS sg13g2_fill_1
XFILLER_82_183 VDD VSS sg13g2_decap_8
XFILLER_70_323 VDD VSS sg13g2_decap_8
XFILLER_110_1291 VDD VSS sg13g2_decap_8
X_09568_ _14166_/D _09900_/A0 _14166_/Q _09571_/S VDD VSS sg13g2_mux2_1
XFILLER_19_1302 VDD VSS sg13g2_decap_8
XFILLER_169_712 VDD VSS sg13g2_fill_1
X_08519_ _08597_/C _08591_/A3 _08559_/A3 _08519_/A2 _08471_/B _13509_/A1 _13510_/A1
+ VDD VSS sg13g2_mux4_1
XFILLER_12_924 VDD VSS sg13g2_decap_8
XFILLER_169_745 VDD VSS sg13g2_decap_8
X_09499_ _14099_/D _10095_/A0 _14099_/Q _09502_/S VDD VSS sg13g2_mux2_1
XFILLER_54_1237 VDD VSS sg13g2_fill_1
XFILLER_106_1316 VDD VSS sg13g2_fill_1
XFILLER_93_1297 VDD VSS sg13g2_fill_2
XFILLER_54_1248 VDD VSS sg13g2_decap_8
X_11530_ _11532_/A _12014_/S _14180_/Q VDD VSS sg13g2_nand2b_1
XFILLER_19_1379 VDD VSS sg13g2_fill_1
XFILLER_11_434 VDD VSS sg13g2_decap_8
XFILLER_23_294 VDD VSS sg13g2_decap_8
XFILLER_106_1349 VDD VSS sg13g2_decap_8
XFILLER_168_266 VDD VSS sg13g2_decap_8
X_14121__2058 _14121_/RESET_B VDD VSS sg13g2_tiehi
XFILLER_8_917 VDD VSS sg13g2_decap_8
XFILLER_23_42 VDD VSS sg13g2_decap_8
XFILLER_139_42 VDD VSS sg13g2_decap_8
X_11461_ _11463_/B _11461_/A _13687_/Q VDD VSS sg13g2_xnor2_1
XFILLER_7_427 VDD VSS sg13g2_decap_8
XFILLER_17_1092 VDD VSS sg13g2_decap_8
XFILLER_104_1051 VDD VSS sg13g2_decap_4
X_13200_ _13224_/A _13200_/A _13667_/Q VDD VSS sg13g2_xnor2_1
X_10412_ _10415_/C _10413_/B _10414_/D _14827_/Q VDD VSS sg13g2_a21oi_1
XFILLER_125_804 VDD VSS sg13g2_decap_4
X_14180_ _14180_/Q clkload23/A _14180_/D _14180_/RESET_B VDD VSS sg13g2_dfrbpq_1
X_14229__1950 _14229_/RESET_B VDD VSS sg13g2_tiehi
X_11392_ _11392_/Y _11814_/S0 _13919_/Q _11391_/Y VDD VSS sg13g2_a21oi_1
XFILLER_139_97 VDD VSS sg13g2_decap_4
XFILLER_124_303 VDD VSS sg13g2_decap_4
XFILLER_136_174 VDD VSS sg13g2_fill_1
XFILLER_164_483 VDD VSS sg13g2_decap_8
X_13131_ _13131_/Y _14914_/Q _13673_/Q _13132_/A VDD VSS sg13g2_a21oi_1
X_10343_ _14807_/D _10343_/A _10343_/B _10353_/C VDD VSS sg13g2_and3_1
XFILLER_136_196 VDD VSS sg13g2_decap_8
XFILLER_65_1300 VDD VSS sg13g2_fill_1
XFILLER_124_347 VDD VSS sg13g2_fill_1
XFILLER_3_644 VDD VSS sg13g2_decap_8
XFILLER_139_1158 VDD VSS sg13g2_fill_1
X_13062_ _13066_/A _13063_/B VDD VSS sg13g2_inv_1
X_10274_ _10274_/Y _14786_/Q _10305_/A _10423_/C VDD VSS sg13g2_o21ai_1
XFILLER_174_1049 VDD VSS sg13g2_fill_2
XFILLER_155_63 VDD VSS sg13g2_decap_8
XFILLER_2_154 VDD VSS sg13g2_decap_8
X_12013_ _12013_/Y _11988_/Y _12012_/X _12296_/A1 VDD VSS sg13g2_a21oi_1
XFILLER_151_199 VDD VSS sg13g2_fill_2
Xfanout1401 _12765_/A1 _12956_/B VDD VSS sg13g2_buf_1
XFILLER_79_957 VDD VSS sg13g2_fill_2
XFILLER_152_1325 VDD VSS sg13g2_decap_4
Xfanout1412 _13398_/B fanout1413/X VDD VSS sg13g2_buf_1
XFILLER_79_968 VDD VSS sg13g2_fill_1
XFILLER_78_467 VDD VSS sg13g2_decap_8
XFILLER_8_1260 VDD VSS sg13g2_decap_8
XFILLER_59_670 VDD VSS sg13g2_fill_1
Xfanout480 _09877_/A0 _09910_/A1 VDD VSS sg13g2_buf_1
XFILLER_4_1113 VDD VSS sg13g2_decap_8
Xfanout491 _08395_/A _08424_/A1 VDD VSS sg13g2_buf_1
XFILLER_93_437 VDD VSS sg13g2_decap_8
X_13964_ _13964_/Q clkload14/A _13964_/D _13964_/RESET_B VDD VSS sg13g2_dfrbpq_1
XFILLER_65_139 VDD VSS sg13g2_decap_8
XFILLER_47_843 VDD VSS sg13g2_decap_8
XFILLER_24_1085 VDD VSS sg13g2_decap_8
XFILLER_171_84 VDD VSS sg13g2_decap_8
XFILLER_0_35 VDD VSS sg13g2_decap_8
XFILLER_98_1153 VDD VSS sg13g2_decap_8
X_12915_ _12933_/A input33/X _12841_/B _12914_/Y VDD VSS sg13g2_a21o_1
XFILLER_98_1164 VDD VSS sg13g2_fill_1
XFILLER_74_662 VDD VSS sg13g2_fill_1
XFILLER_19_567 VDD VSS sg13g2_decap_8
XFILLER_80_109 VDD VSS sg13g2_fill_2
X_13895_ _13895_/Q _14727_/CLK _13895_/D _13895_/RESET_B VDD VSS sg13g2_dfrbpq_1
X_14331__1848 _14331_/RESET_B VDD VSS sg13g2_tiehi
XFILLER_59_1137 VDD VSS sg13g2_fill_1
X_13717__2462 _13717_/RESET_B VDD VSS sg13g2_tiehi
XFILLER_61_312 VDD VSS sg13g2_fill_2
XFILLER_59_1159 VDD VSS sg13g2_decap_8
X_12846_ _12846_/Y _12821_/Y _12834_/Y _12833_/Y VDD VSS sg13g2_o21ai_1
XFILLER_61_356 VDD VSS sg13g2_decap_8
XFILLER_159_200 VDD VSS sg13g2_fill_1
XFILLER_61_367 VDD VSS sg13g2_fill_1
X_12777_ _12778_/B _13663_/Q _12777_/A2 _12776_/X _12400_/A _12777_/C1 VDD VSS sg13g2_a221oi_1
XFILLER_15_784 VDD VSS sg13g2_decap_8
XFILLER_42_570 VDD VSS sg13g2_decap_8
XFILLER_70_890 VDD VSS sg13g2_decap_8
X_14516_ _14516_/Q _14516_/CLK _14516_/D _14516_/RESET_B VDD VSS sg13g2_dfrbpq_1
X_11728_ _11728_/Y _11773_/D _11728_/B VDD VSS sg13g2_xnor2_1
XFILLER_14_294 VDD VSS sg13g2_decap_8
XFILLER_159_266 VDD VSS sg13g2_decap_8
XFILLER_9_77 VDD VSS sg13g2_decap_8
XFILLER_147_439 VDD VSS sg13g2_decap_4
X_14447_ _14447_/Q _14607_/CLK _14447_/D _14447_/RESET_B VDD VSS sg13g2_dfrbpq_1
XFILLER_30_787 VDD VSS sg13g2_decap_8
X_11659_ _11702_/A _11661_/A _11724_/B VDD VSS sg13g2_nor2_1
XFILLER_35_1181 VDD VSS sg13g2_fill_2
XFILLER_128_631 VDD VSS sg13g2_fill_1
XFILLER_122_1162 VDD VSS sg13g2_decap_8
XFILLER_116_804 VDD VSS sg13g2_decap_8
XFILLER_155_450 VDD VSS sg13g2_decap_8
X_14378_ _14378_/Q _14666_/CLK _14378_/D _14378_/RESET_B VDD VSS sg13g2_dfrbpq_1
XFILLER_143_601 VDD VSS sg13g2_fill_2
XFILLER_143_612 VDD VSS sg13g2_fill_1
XFILLER_171_921 VDD VSS sg13g2_decap_8
XFILLER_115_314 VDD VSS sg13g2_decap_8
XFILLER_7_994 VDD VSS sg13g2_decap_8
X_13329_ _13329_/Y _15173_/Q _13336_/S VDD VSS sg13g2_nand2b_1
XFILLER_170_420 VDD VSS sg13g2_decap_8
XFILLER_66_1119 VDD VSS sg13g2_decap_8
XFILLER_171_954 VDD VSS sg13g2_fill_2
XFILLER_131_807 VDD VSS sg13g2_decap_8
XFILLER_157_1258 VDD VSS sg13g2_fill_1
XFILLER_103_509 VDD VSS sg13g2_decap_8
Xhold3019 hold3019/X _10214_/Y VDD VSS sg13g2_dlygate4sd3_1
XFILLER_170_497 VDD VSS sg13g2_decap_8
XFILLER_142_199 VDD VSS sg13g2_fill_2
X_08870_ _08870_/X _15031_/Q _10788_/S _08869_/Y VDD VSS sg13g2_a21o_1
XFILLER_123_391 VDD VSS sg13g2_decap_8
XFILLER_69_445 VDD VSS sg13g2_decap_8
XFILLER_9_1057 VDD VSS sg13g2_decap_8
XFILLER_69_456 VDD VSS sg13g2_fill_2
X_07821_ _07822_/B _15009_/Q _07821_/B VDD VSS sg13g2_and2_1
XFILLER_29_0 VDD VSS sg13g2_decap_8
XFILLER_38_821 VDD VSS sg13g2_decap_8
X_07752_ _07752_/Y _10869_/A _10797_/C _13304_/B _13302_/C VDD VSS sg13g2_nand4_1
XFILLER_84_459 VDD VSS sg13g2_decap_4
XFILLER_93_960 VDD VSS sg13g2_decap_8
XFILLER_38_876 VDD VSS sg13g2_decap_8
XFILLER_37_364 VDD VSS sg13g2_decap_8
XFILLER_25_504 VDD VSS sg13g2_decap_8
X_07683_ _07683_/X _07683_/A _13289_/C VDD VSS sg13g2_or2_1
XFILLER_25_515 VDD VSS sg13g2_fill_2
XFILLER_168_1365 VDD VSS sg13g2_decap_8
X_09422_ _14024_/D _09853_/A1 _14024_/Q _09431_/S VDD VSS sg13g2_mux2_1
X_14307__1872 _14307_/RESET_B VDD VSS sg13g2_tiehi
XFILLER_77_1259 VDD VSS sg13g2_decap_8
X_09353_ _13957_/D _09949_/A1 _13957_/Q _09365_/S VDD VSS sg13g2_mux2_1
XFILLER_40_518 VDD VSS sg13g2_decap_8
XFILLER_100_14 VDD VSS sg13g2_decap_8
XFILLER_33_570 VDD VSS sg13g2_decap_8
XFILLER_21_721 VDD VSS sg13g2_decap_8
X_08304_ _08304_/Y _08306_/C _08306_/B VDD VSS sg13g2_nand2_1
X_09284_ _13892_/D _13892_/Q _09750_/A1 _09301_/S VDD VSS sg13g2_mux2_1
XFILLER_166_715 VDD VSS sg13g2_decap_8
Xclkbuf_5_24__f_clk_i clkbuf_leaf_75_clk_i/A clkbuf_4_12_0_clk_i/X VDD VSS sg13g2_buf_16
XFILLER_20_231 VDD VSS sg13g2_decap_8
XFILLER_127_1095 VDD VSS sg13g2_decap_8
XFILLER_165_203 VDD VSS sg13g2_decap_8
XFILLER_138_439 VDD VSS sg13g2_decap_8
X_08235_ _08235_/X _11483_/A _11454_/A _11502_/A _11461_/A _08235_/S0 _13550_/A1 VDD
+ VSS sg13g2_mux4_1
XFILLER_14_1232 VDD VSS sg13g2_decap_8
XFILLER_21_798 VDD VSS sg13g2_decap_8
XFILLER_107_804 VDD VSS sg13g2_fill_2
XFILLER_109_23 VDD VSS sg13g2_decap_8
X_08166_ _15222_/D _08166_/A _08166_/B _08166_/C VDD VSS sg13g2_nand3_1
XFILLER_162_910 VDD VSS sg13g2_decap_8
XFILLER_88_1344 VDD VSS sg13g2_decap_8
XFILLER_107_837 VDD VSS sg13g2_decap_8
XFILLER_88_1355 VDD VSS sg13g2_fill_1
XFILLER_133_100 VDD VSS sg13g2_decap_4
X_08097_ _08098_/B _08338_/B _08094_/X _08096_/X VDD VSS sg13g2_a21oi_1
XFILLER_173_280 VDD VSS sg13g2_decap_8
XFILLER_107_7 VDD VSS sg13g2_decap_8
XFILLER_122_807 VDD VSS sg13g2_decap_8
XFILLER_115_870 VDD VSS sg13g2_decap_8
XFILLER_47_1030 VDD VSS sg13g2_decap_8
XFILLER_161_486 VDD VSS sg13g2_decap_8
XFILLER_88_721 VDD VSS sg13g2_decap_4
XFILLER_102_520 VDD VSS sg13g2_fill_1
XFILLER_0_658 VDD VSS sg13g2_decap_8
XFILLER_134_1033 VDD VSS sg13g2_fill_2
XFILLER_87_242 VDD VSS sg13g2_decap_8
XFILLER_125_66 VDD VSS sg13g2_fill_1
XFILLER_134_1055 VDD VSS sg13g2_decap_8
XFILLER_48_618 VDD VSS sg13g2_decap_8
X_08999_ _08999_/Y _14900_/Q _08993_/X _09024_/A VDD VSS sg13g2_o21ai_1
XFILLER_88_798 VDD VSS sg13g2_decap_8
XFILLER_75_415 VDD VSS sg13g2_fill_2
XFILLER_60_1252 VDD VSS sg13g2_decap_4
XFILLER_47_139 VDD VSS sg13g2_decap_8
XFILLER_25_1372 VDD VSS sg13g2_decap_8
X_13974__2205 _13974_/RESET_B VDD VSS sg13g2_tiehi
XFILLER_60_1263 VDD VSS sg13g2_decap_8
XFILLER_25_1383 VDD VSS sg13g2_fill_1
XFILLER_112_1342 VDD VSS sg13g2_decap_8
XFILLER_28_331 VDD VSS sg13g2_decap_4
XFILLER_21_1225 VDD VSS sg13g2_decap_8
XFILLER_18_42 VDD VSS sg13g2_decap_8
XFILLER_141_21 VDD VSS sg13g2_decap_8
XFILLER_91_919 VDD VSS sg13g2_decap_4
XFILLER_84_960 VDD VSS sg13g2_fill_1
XFILLER_16_504 VDD VSS sg13g2_decap_8
X_13662__2548 _13662_/RESET_B VDD VSS sg13g2_tiehi
X_10961_ _11009_/A _14759_/Q _10965_/B VDD VSS sg13g2_nand2b_1
XFILLER_95_1315 VDD VSS sg13g2_fill_1
X_15215__2983 _15215_/RESET_B VDD VSS sg13g2_tiehi
XFILLER_84_993 VDD VSS sg13g2_fill_2
XFILLER_56_684 VDD VSS sg13g2_fill_2
XFILLER_43_312 VDD VSS sg13g2_decap_8
X_12700_ _12700_/X _14708_/Q _14740_/Q _13780_/Q _13812_/Q _12703_/S0 _12703_/S1 VDD
+ VSS sg13g2_mux4_1
X_13680_ _13680_/Q clkload56/A _13680_/D _13680_/RESET_B VDD VSS sg13g2_dfrbpq_1
XFILLER_3_1190 VDD VSS sg13g2_decap_8
X_10892_ _10893_/B _10879_/Y _10863_/X _10880_/Y VDD VSS sg13g2_a21oi_1
XFILLER_44_879 VDD VSS sg13g2_fill_2
X_12631_ _12631_/X _13743_/Q _14095_/Q _14447_/Q _14543_/Q _12633_/S0 _12633_/S1 VDD
+ VSS sg13g2_mux4_1
XFILLER_54_1012 VDD VSS sg13g2_decap_8
XFILLER_70_175 VDD VSS sg13g2_decap_8
X_14913__2718 _14913_/RESET_B VDD VSS sg13g2_tiehi
XFILLER_34_63 VDD VSS sg13g2_decap_8
XFILLER_12_721 VDD VSS sg13g2_decap_8
XFILLER_145_1151 VDD VSS sg13g2_decap_8
XFILLER_145_1162 VDD VSS sg13g2_fill_2
XFILLER_169_553 VDD VSS sg13g2_decap_8
X_12562_ _12562_/X _13738_/Q _14090_/Q _14442_/Q _14538_/Q _12562_/S0 _12562_/S1 VDD
+ VSS sg13g2_mux4_1
XFILLER_19_1176 VDD VSS sg13g2_decap_8
XFILLER_11_231 VDD VSS sg13g2_decap_8
XFILLER_106_1146 VDD VSS sg13g2_decap_4
XFILLER_133_0 VDD VSS sg13g2_decap_8
XFILLER_15_1029 VDD VSS sg13g2_decap_8
X_14301_ _14301_/Q clkload47/A _14301_/D _14301_/RESET_B VDD VSS sg13g2_dfrbpq_1
XFILLER_8_714 VDD VSS sg13g2_decap_8
XFILLER_106_1157 VDD VSS sg13g2_decap_8
X_11513_ _11513_/X _14115_/Q _14147_/Q _14179_/Q _14211_/Q _12140_/S0 _12140_/S1 VDD
+ VSS sg13g2_mux4_1
XFILLER_12_798 VDD VSS sg13g2_decap_8
X_12493_ _12493_/X _14117_/Q _14149_/Q _14181_/Q _14213_/Q _12655_/S0 _12655_/S1 VDD
+ VSS sg13g2_mux4_1
XFILLER_7_224 VDD VSS sg13g2_decap_8
X_14232_ _14232_/Q _14728_/CLK _14232_/D _14232_/RESET_B VDD VSS sg13g2_dfrbpq_1
X_11444_ _11444_/X _14688_/Q _14720_/Q _13760_/Q _13792_/Q _12215_/S0 _12213_/S1 VDD
+ VSS sg13g2_mux4_1
XFILLER_32_1365 VDD VSS sg13g2_decap_8
XFILLER_32_1376 VDD VSS sg13g2_fill_1
XFILLER_171_217 VDD VSS sg13g2_decap_8
XFILLER_109_174 VDD VSS sg13g2_fill_2
XFILLER_171_228 VDD VSS sg13g2_fill_2
X_14163_ _14163_/Q clkload25/A _14163_/D _14163_/RESET_B VDD VSS sg13g2_dfrbpq_1
XFILLER_4_931 VDD VSS sg13g2_decap_8
XFILLER_164_280 VDD VSS sg13g2_decap_8
X_11375_ _11375_/Y _11370_/Y _11371_/Y _11875_/B VDD VSS sg13g2_a21oi_1
XFILLER_166_84 VDD VSS sg13g2_decap_8
X_13114_ _13116_/B _13092_/C _13172_/C VDD VSS sg13g2_nand2b_1
XFILLER_3_441 VDD VSS sg13g2_decap_8
XFILLER_113_818 VDD VSS sg13g2_decap_8
X_10326_ _10345_/C _14799_/Q _14800_/Q _14801_/Q _14802_/Q VDD VSS sg13g2_and4_1
XFILLER_98_518 VDD VSS sg13g2_decap_8
XFILLER_113_829 VDD VSS sg13g2_fill_2
X_14094_ _14094_/Q clkload37/A _14094_/D _14094_/RESET_B VDD VSS sg13g2_dfrbpq_1
XFILLER_140_648 VDD VSS sg13g2_decap_4
X_13045_ _13050_/C _13045_/A1 _13044_/Y _12914_/C VDD VSS sg13g2_a21oi_1
XFILLER_156_1280 VDD VSS sg13g2_decap_8
X_10257_ _10268_/D _14779_/Q _14780_/Q _14781_/Q _10258_/D VDD VSS sg13g2_and4_1
XFILLER_117_1242 VDD VSS sg13g2_fill_2
XFILLER_65_1174 VDD VSS sg13g2_decap_8
XFILLER_61_1005 VDD VSS sg13g2_decap_8
Xfanout1220 _11974_/B1 _12048_/A1 VDD VSS sg13g2_buf_1
XFILLER_26_1147 VDD VSS sg13g2_decap_8
Xfanout1231 _12221_/B1 _13661_/Q VDD VSS sg13g2_buf_1
XFILLER_22_7 VDD VSS sg13g2_decap_8
XFILLER_120_350 VDD VSS sg13g2_decap_8
Xfanout1242 _12092_/C _12308_/C VDD VSS sg13g2_buf_1
X_10188_ _14751_/D _15194_/D _14751_/Q _10194_/S VDD VSS sg13g2_mux2_1
XFILLER_113_1117 VDD VSS sg13g2_decap_8
Xfanout1253 _11760_/C _11762_/S1 VDD VSS sg13g2_buf_1
XFILLER_38_106 VDD VSS sg13g2_decap_8
XFILLER_113_1128 VDD VSS sg13g2_fill_2
Xfanout1264 _11897_/C _11899_/S1 VDD VSS sg13g2_buf_1
Xfanout1275 _11651_/S1 _12137_/S1 VDD VSS sg13g2_buf_1
Xfanout1286 _12288_/S1 fanout1291/X VDD VSS sg13g2_buf_1
X_14996_ _14996_/Q clkload32/A _14996_/D _14996_/RESET_B VDD VSS sg13g2_dfrbpq_1
Xfanout1297 _11852_/S0 fanout1316/X VDD VSS sg13g2_buf_1
X_14564__1615 _14564_/RESET_B VDD VSS sg13g2_tiehi
XFILLER_47_662 VDD VSS sg13g2_fill_1
X_13947_ _13947_/Q clkload40/A _13947_/D _13947_/RESET_B VDD VSS sg13g2_dfrbpq_1
XFILLER_19_364 VDD VSS sg13g2_decap_8
XFILLER_75_92 VDD VSS sg13g2_decap_8
X_13878_ _13878_/Q clkload27/A _13878_/D _13878_/RESET_B VDD VSS sg13g2_dfrbpq_1
XFILLER_35_879 VDD VSS sg13g2_decap_4
X_12829_ _12829_/Y _14865_/Q _12895_/B VDD VSS sg13g2_nand2_1
XFILLER_76_1270 VDD VSS sg13g2_fill_2
XFILLER_22_518 VDD VSS sg13g2_decap_8
XFILLER_34_389 VDD VSS sg13g2_decap_8
XFILLER_61_175 VDD VSS sg13g2_decap_8
XFILLER_15_581 VDD VSS sg13g2_decap_8
XFILLER_163_1262 VDD VSS sg13g2_decap_4
XFILLER_33_1118 VDD VSS sg13g2_decap_8
X_08020_ _08021_/A _08338_/B _08018_/X _08019_/X VDD VSS sg13g2_a21oi_1
XFILLER_162_217 VDD VSS sg13g2_decap_8
XFILLER_157_1000 VDD VSS sg13g2_fill_2
XFILLER_128_494 VDD VSS sg13g2_decap_4
XFILLER_7_791 VDD VSS sg13g2_decap_8
XFILLER_116_645 VDD VSS sg13g2_decap_8
XFILLER_116_689 VDD VSS sg13g2_decap_4
X_09971_ _09971_/Y _10037_/A _10105_/B _10070_/C VDD VSS sg13g2_nand3_1
XFILLER_115_166 VDD VSS sg13g2_decap_4
XFILLER_118_1028 VDD VSS sg13g2_fill_2
XFILLER_83_1230 VDD VSS sg13g2_decap_8
XFILLER_48_1361 VDD VSS sg13g2_decap_8
XFILLER_103_339 VDD VSS sg13g2_fill_2
X_08922_ _08922_/X _08921_/X _11983_/A _08931_/S VDD VSS sg13g2_mux2_1
XFILLER_170_294 VDD VSS sg13g2_decap_8
XFILLER_170_1244 VDD VSS sg13g2_fill_2
XFILLER_83_1296 VDD VSS sg13g2_fill_1
XFILLER_112_873 VDD VSS sg13g2_decap_8
X_08853_ _08853_/X _15026_/Q _10691_/S _08852_/Y VDD VSS sg13g2_a21o_1
XFILLER_97_584 VDD VSS sg13g2_decap_4
XFILLER_111_372 VDD VSS sg13g2_decap_8
XFILLER_131_1239 VDD VSS sg13g2_decap_8
X_07804_ _07807_/C _07805_/B _07949_/C VDD VSS sg13g2_nand2b_1
X_08784_ _08784_/Y _13680_/Q _08818_/B VDD VSS sg13g2_nor2_1
XFILLER_38_640 VDD VSS sg13g2_decap_8
X_07735_ _07744_/B _15217_/D _07735_/B _07735_/C _07735_/D VDD VSS sg13g2_or4_1
XFILLER_84_278 VDD VSS sg13g2_decap_8
XFILLER_38_673 VDD VSS sg13g2_decap_8
XFILLER_164_1004 VDD VSS sg13g2_fill_1
X_07666_ _07708_/A _13293_/A _15055_/Q VDD VSS sg13g2_nor2_1
XFILLER_129_1124 VDD VSS sg13g2_fill_2
XFILLER_111_35 VDD VSS sg13g2_decap_8
X_09405_ _14008_/D _09636_/A0 _14008_/Q _09407_/S VDD VSS sg13g2_mux2_1
XFILLER_52_153 VDD VSS sg13g2_decap_8
XFILLER_0_1374 VDD VSS sg13g2_decap_8
XFILLER_13_518 VDD VSS sg13g2_decap_8
XFILLER_53_687 VDD VSS sg13g2_decap_8
XFILLER_41_838 VDD VSS sg13g2_decap_8
XFILLER_55_1343 VDD VSS sg13g2_decap_8
XFILLER_52_197 VDD VSS sg13g2_fill_2
X_09336_ _13943_/D _09703_/A0 _13943_/Q _09338_/S VDD VSS sg13g2_mux2_1
XFILLER_90_1234 VDD VSS sg13g2_decap_8
XFILLER_16_1316 VDD VSS sg13g2_decap_8
XFILLER_90_1245 VDD VSS sg13g2_fill_1
XFILLER_139_737 VDD VSS sg13g2_decap_8
XFILLER_139_748 VDD VSS sg13g2_fill_2
XFILLER_103_1308 VDD VSS sg13g2_fill_1
X_09267_ _13876_/D _13876_/Q _09931_/A1 _09267_/S VDD VSS sg13g2_mux2_1
XFILLER_21_595 VDD VSS sg13g2_decap_8
XFILLER_154_707 VDD VSS sg13g2_decap_8
XFILLER_166_567 VDD VSS sg13g2_decap_8
X_08218_ _08319_/A _08219_/A _13545_/A VDD VSS sg13g2_nor2_1
X_09198_ _13814_/D _13814_/Q _09768_/A1 _09200_/S VDD VSS sg13g2_mux2_1
XFILLER_5_728 VDD VSS sg13g2_decap_8
XFILLER_140_1092 VDD VSS sg13g2_decap_8
XFILLER_107_634 VDD VSS sg13g2_decap_8
X_08149_ _08149_/Y _08014_/B _08011_/X _08688_/A VDD VSS sg13g2_o21ai_1
XFILLER_20_21 VDD VSS sg13g2_decap_8
XFILLER_107_645 VDD VSS sg13g2_fill_1
XFILLER_4_238 VDD VSS sg13g2_decap_8
XFILLER_135_965 VDD VSS sg13g2_decap_8
X_14642__1537 _14642_/RESET_B VDD VSS sg13g2_tiehi
XFILLER_136_21 VDD VSS sg13g2_decap_8
X_11160_ _11161_/A _11150_/B _11150_/A _11159_/Y VDD VSS sg13g2_o21ai_1
XFILLER_134_486 VDD VSS sg13g2_decap_8
XFILLER_161_261 VDD VSS sg13g2_fill_1
XFILLER_162_795 VDD VSS sg13g2_decap_8
XFILLER_96_14 VDD VSS sg13g2_decap_8
XFILLER_20_98 VDD VSS sg13g2_decap_8
XFILLER_136_1139 VDD VSS sg13g2_fill_1
X_10111_ _14689_/D _10144_/A1 _14689_/Q _10135_/S VDD VSS sg13g2_mux2_1
X_11091_ _11094_/B _11091_/A _11091_/B VDD VSS sg13g2_nand2_1
XFILLER_1_945 VDD VSS sg13g2_decap_8
XFILLER_0_455 VDD VSS sg13g2_decap_8
X_10042_ _14623_/D _10109_/A0 _14623_/Q _10060_/S VDD VSS sg13g2_mux2_1
XFILLER_62_1347 VDD VSS sg13g2_decap_8
XFILLER_49_938 VDD VSS sg13g2_decap_8
XFILLER_102_361 VDD VSS sg13g2_fill_1
X_15190__2785 _15190_/RESET_B VDD VSS sg13g2_tiehi
XFILLER_88_595 VDD VSS sg13g2_decap_8
XFILLER_48_426 VDD VSS sg13g2_decap_8
XFILLER_29_63 VDD VSS sg13g2_decap_8
XFILLER_102_394 VDD VSS sg13g2_decap_4
XFILLER_152_42 VDD VSS sg13g2_decap_8
X_14850_ _14850_/Q _14854_/CLK _14850_/D _14850_/RESET_B VDD VSS sg13g2_dfrbpq_1
XFILLER_76_768 VDD VSS sg13g2_decap_8
XFILLER_21_1022 VDD VSS sg13g2_decap_8
X_13801_ _13801_/Q clkload20/A _13801_/D _13801_/RESET_B VDD VSS sg13g2_dfrbpq_1
X_15010__2577 _15010_/RESET_B VDD VSS sg13g2_tiehi
XFILLER_5_1274 VDD VSS sg13g2_decap_8
XFILLER_57_971 VDD VSS sg13g2_decap_8
X_14781_ _14781_/Q _14894_/CLK _14781_/D _14781_/RESET_B VDD VSS sg13g2_dfrbpq_1
XFILLER_112_1172 VDD VSS sg13g2_decap_8
XFILLER_16_301 VDD VSS sg13g2_decap_8
X_11993_ _11993_/X _14257_/Q _14289_/Q _14321_/Q _14353_/Q _11993_/S0 _11995_/S1 VDD
+ VSS sg13g2_mux4_1
XFILLER_56_470 VDD VSS sg13g2_decap_8
XFILLER_1_1127 VDD VSS sg13g2_decap_8
X_13732_ _13732_/Q clkload17/A _13732_/D _13732_/RESET_B VDD VSS sg13g2_dfrbpq_1
X_10944_ _10944_/Y _10948_/C _10948_/D VDD VSS sg13g2_nor2_1
XFILLER_95_1156 VDD VSS sg13g2_fill_1
XFILLER_21_1099 VDD VSS sg13g2_decap_8
XFILLER_17_868 VDD VSS sg13g2_decap_8
XFILLER_32_816 VDD VSS sg13g2_decap_8
XFILLER_56_1129 VDD VSS sg13g2_fill_1
XFILLER_45_84 VDD VSS sg13g2_decap_4
XFILLER_16_378 VDD VSS sg13g2_decap_8
X_13663_ _13663_/Q clkload64/A _13663_/D _13663_/RESET_B VDD VSS sg13g2_dfrbpq_1
XFILLER_44_687 VDD VSS sg13g2_decap_8
XFILLER_108_1219 VDD VSS sg13g2_fill_1
X_10875_ _10875_/Y _10875_/A _10941_/B VDD VSS sg13g2_nand2_1
X_12614_ _12614_/X _13966_/Q _13998_/Q _14030_/Q _14062_/Q _12614_/S0 _12614_/S1 VDD
+ VSS sg13g2_mux4_1
XFILLER_43_197 VDD VSS sg13g2_fill_1
XFILLER_169_350 VDD VSS sg13g2_decap_8
X_13594_ _15163_/D _13593_/B _13592_/Y _13593_/Y VDD VSS sg13g2_a21oi_1
XFILLER_8_511 VDD VSS sg13g2_decap_8
XFILLER_40_871 VDD VSS sg13g2_fill_2
X_12545_ _12545_/X _14377_/Q _14409_/Q _14473_/Q _14505_/Q _12546_/S0 _12546_/S1 VDD
+ VSS sg13g2_mux4_1
XFILLER_12_595 VDD VSS sg13g2_decap_8
XFILLER_126_910 VDD VSS sg13g2_decap_8
X_12476_ _12476_/X _14244_/Q _14276_/Q _14308_/Q _14340_/Q _12716_/S0 _12716_/S1 VDD
+ VSS sg13g2_mux4_1
XFILLER_172_526 VDD VSS sg13g2_decap_8
X_14281__1898 _14281_/RESET_B VDD VSS sg13g2_tiehi
XFILLER_8_588 VDD VSS sg13g2_decap_8
X_14215_ _14215_/Q _14735_/CLK _14215_/D _14215_/RESET_B VDD VSS sg13g2_dfrbpq_1
X_14857__2830 _14857_/RESET_B VDD VSS sg13g2_tiehi
XANTENNA_5 _09342_/Y VDD VSS sg13g2_antennanp
X_11427_ _11427_/X _11428_/A _13689_/Q VDD VSS sg13g2_and2_1
XFILLER_67_1203 VDD VSS sg13g2_fill_1
X_15195_ _15195_/Q clkload55/A _15195_/D _15195_/RESET_B VDD VSS sg13g2_dfrbpq_1
XFILLER_6_56 VDD VSS sg13g2_decap_8
XFILLER_172_559 VDD VSS sg13g2_decap_8
XFILLER_67_1225 VDD VSS sg13g2_decap_8
XFILLER_141_902 VDD VSS sg13g2_decap_8
XFILLER_153_762 VDD VSS sg13g2_decap_8
XFILLER_153_773 VDD VSS sg13g2_fill_2
X_14146_ _14146_/Q _14722_/CLK _14146_/D _14146_/RESET_B VDD VSS sg13g2_dfrbpq_1
X_14618__1561 _14618_/RESET_B VDD VSS sg13g2_tiehi
XFILLER_113_615 VDD VSS sg13g2_decap_8
XFILLER_126_998 VDD VSS sg13g2_fill_2
XFILLER_158_1364 VDD VSS sg13g2_fill_1
X_11358_ _11359_/A _13726_/Q _14078_/Q _14430_/Q _14526_/Q _11358_/S0 _11374_/C VDD
+ VSS sg13g2_mux4_1
XFILLER_152_261 VDD VSS sg13g2_fill_1
XFILLER_98_315 VDD VSS sg13g2_fill_2
XFILLER_99_849 VDD VSS sg13g2_fill_2
X_10309_ _10312_/B _14796_/Q _10327_/B _14797_/Q VDD VSS sg13g2_a21oi_1
X_14077_ _14077_/Q _14653_/CLK _14077_/D _14077_/RESET_B VDD VSS sg13g2_dfrbpq_1
X_11289_ _11289_/Y _14895_/Q _12338_/A2 _07684_/B VDD VSS sg13g2_a21oi_1
XFILLER_140_467 VDD VSS sg13g2_decap_8
XFILLER_117_1050 VDD VSS sg13g2_fill_1
X_13028_ _13028_/Y _14877_/Q _13028_/B VDD VSS sg13g2_nand2_1
XFILLER_66_201 VDD VSS sg13g2_fill_1
XFILLER_121_681 VDD VSS sg13g2_decap_8
Xfanout1050 _08103_/A _08154_/A VDD VSS sg13g2_buf_1
Xfanout1061 _08669_/B1 _08686_/S1 VDD VSS sg13g2_buf_1
Xfanout1072 _08635_/S0 _08686_/S0 VDD VSS sg13g2_buf_1
Xfanout1083 _08137_/S0 _14989_/Q VDD VSS sg13g2_buf_1
Xfanout1094 _12203_/A _14985_/Q VDD VSS sg13g2_buf_1
X_14979_ _14979_/Q _14979_/CLK _14979_/D _14979_/RESET_B VDD VSS sg13g2_dfrbpq_1
XFILLER_82_749 VDD VSS sg13g2_decap_8
XFILLER_78_1332 VDD VSS sg13g2_decap_8
XFILLER_19_161 VDD VSS sg13g2_decap_8
XFILLER_165_1324 VDD VSS sg13g2_fill_1
XFILLER_34_131 VDD VSS sg13g2_fill_2
XFILLER_165_1335 VDD VSS sg13g2_fill_1
XFILLER_74_1218 VDD VSS sg13g2_decap_4
XFILLER_63_974 VDD VSS sg13g2_decap_8
XFILLER_22_315 VDD VSS sg13g2_decap_8
X_14720__1459 _14720_/RESET_B VDD VSS sg13g2_tiehi
XFILLER_96_0 VDD VSS sg13g2_decap_8
XFILLER_163_1081 VDD VSS sg13g2_decap_8
X_09121_ _10767_/B _09140_/S _15046_/Q _09120_/Y VDD VSS sg13g2_o21ai_1
XFILLER_124_1043 VDD VSS sg13g2_decap_8
XFILLER_163_504 VDD VSS sg13g2_decap_8
X_09052_ _13769_/D _13769_/Q _09953_/A1 _09160_/S VDD VSS sg13g2_mux2_1
XFILLER_50_1251 VDD VSS sg13g2_decap_8
XFILLER_159_1106 VDD VSS sg13g2_decap_4
XFILLER_117_921 VDD VSS sg13g2_decap_4
XFILLER_102_1341 VDD VSS sg13g2_decap_4
XFILLER_129_792 VDD VSS sg13g2_decap_8
X_08003_ _08003_/Y _13290_/B _15131_/Q _13290_/A VDD VSS sg13g2_nand3_1
XFILLER_135_239 VDD VSS sg13g2_fill_1
XFILLER_159_1139 VDD VSS sg13g2_decap_8
XFILLER_11_1246 VDD VSS sg13g2_decap_8
XFILLER_102_1374 VDD VSS sg13g2_fill_1
XFILLER_144_762 VDD VSS sg13g2_decap_8
X_15214__2982 _15214_/RESET_B VDD VSS sg13g2_tiehi
XFILLER_85_1336 VDD VSS sg13g2_fill_2
XFILLER_89_304 VDD VSS sg13g2_decap_4
XFILLER_46_1309 VDD VSS sg13g2_fill_2
XFILLER_131_412 VDD VSS sg13g2_fill_2
XFILLER_143_272 VDD VSS sg13g2_decap_8
X_09954_ _14538_/D _14538_/Q _10086_/A0 _09961_/S VDD VSS sg13g2_mux2_1
XFILLER_89_348 VDD VSS sg13g2_decap_8
XFILLER_106_35 VDD VSS sg13g2_decap_8
X_08905_ _13709_/D _16871_/A _08904_/X _08941_/S VDD VSS sg13g2_mux2_1
XFILLER_48_1191 VDD VSS sg13g2_decap_8
XFILLER_83_1082 VDD VSS sg13g2_decap_8
X_09885_ _14471_/D _09918_/A1 _14471_/Q _09899_/S VDD VSS sg13g2_mux2_1
XFILLER_170_1063 VDD VSS sg13g2_fill_2
XFILLER_66_28 VDD VSS sg13g2_decap_8
XFILLER_112_692 VDD VSS sg13g2_fill_2
X_08836_ _08836_/Y _11335_/A _08860_/S VDD VSS sg13g2_nand2_1
XFILLER_85_543 VDD VSS sg13g2_decap_8
XFILLER_131_1036 VDD VSS sg13g2_decap_8
XFILLER_58_768 VDD VSS sg13g2_fill_2
XFILLER_170_1096 VDD VSS sg13g2_decap_8
XFILLER_100_876 VDD VSS sg13g2_decap_8
XFILLER_22_1331 VDD VSS sg13g2_decap_8
XFILLER_100_887 VDD VSS sg13g2_fill_1
X_08767_ _08767_/Y _07720_/C _14760_/Q _15188_/Q _07719_/X VDD VSS sg13g2_a22oi_1
X_14056__2123 _14056_/RESET_B VDD VSS sg13g2_tiehi
XFILLER_122_67 VDD VSS sg13g2_decap_8
X_07718_ _08027_/B _15102_/Q _15101_/Q _15094_/Q _15093_/Q VDD VSS sg13g2_or4_1
X_08698_ _08698_/X _08698_/A _08698_/B VDD VSS sg13g2_and2_1
XFILLER_14_805 VDD VSS sg13g2_decap_8
XFILLER_92_1318 VDD VSS sg13g2_fill_1
XFILLER_15_21 VDD VSS sg13g2_decap_8
X_07649_ _07649_/Y _13345_/B VDD VSS sg13g2_inv_1
XFILLER_0_1171 VDD VSS sg13g2_decap_8
XFILLER_13_315 VDD VSS sg13g2_decap_8
XFILLER_25_175 VDD VSS sg13g2_decap_8
XFILLER_41_635 VDD VSS sg13g2_decap_4
X_10660_ _10661_/C _14892_/Q _14891_/Q _10663_/D VDD VSS sg13g2_and3_1
XFILLER_16_1113 VDD VSS sg13g2_decap_8
XFILLER_9_308 VDD VSS sg13g2_decap_8
XFILLER_40_145 VDD VSS sg13g2_fill_2
XFILLER_15_98 VDD VSS sg13g2_decap_8
X_09319_ _13926_/D _09917_/A1 _13926_/Q _09330_/S VDD VSS sg13g2_mux2_1
XFILLER_55_1184 VDD VSS sg13g2_decap_8
XFILLER_142_1143 VDD VSS sg13g2_fill_1
X_14804__2909 _14804_/RESET_B VDD VSS sg13g2_tiehi
X_10591_ _10607_/C _14874_/Q _10649_/B _10591_/C _10591_/D VDD VSS sg13g2_and4_1
XFILLER_139_556 VDD VSS sg13g2_decap_8
XFILLER_103_1116 VDD VSS sg13g2_decap_8
XFILLER_167_876 VDD VSS sg13g2_decap_4
XFILLER_127_718 VDD VSS sg13g2_decap_8
XFILLER_142_1176 VDD VSS sg13g2_decap_4
XFILLER_167_887 VDD VSS sg13g2_fill_2
X_12330_ _12330_/X _14714_/Q _14746_/Q _13786_/Q _13818_/Q _12330_/S0 _11262_/B VDD
+ VSS sg13g2_mux4_1
XFILLER_21_392 VDD VSS sg13g2_decap_8
XFILLER_166_364 VDD VSS sg13g2_decap_8
XFILLER_31_42 VDD VSS sg13g2_decap_8
XFILLER_154_526 VDD VSS sg13g2_decap_8
XFILLER_5_525 VDD VSS sg13g2_decap_8
XFILLER_147_42 VDD VSS sg13g2_decap_8
X_12261_ _12261_/Y _12237_/Y _12239_/Y _12174_/A VDD VSS sg13g2_a21oi_1
X_15028__2559 _15028_/RESET_B VDD VSS sg13g2_tiehi
X_14000_ _14000_/Q clkload7/A _14000_/D _14000_/RESET_B VDD VSS sg13g2_dfrbpq_1
X_11212_ _11212_/X _14171_/Q _14203_/Q _11212_/S VDD VSS sg13g2_mux2_1
XFILLER_135_773 VDD VSS sg13g2_decap_8
XFILLER_147_86 VDD VSS sg13g2_decap_8
X_12192_ _12192_/Y _12192_/A _12192_/B VDD VSS sg13g2_nor2_1
XFILLER_123_935 VDD VSS sg13g2_fill_2
Xoutput42 mem_axi_araddr[13] _16866_/A VDD VSS sg13g2_buf_1
Xoutput53 mem_axi_araddr[24] _16877_/A VDD VSS sg13g2_buf_1
X_11143_ _11143_/Y _14952_/Q _11170_/B VDD VSS sg13g2_nand2_1
XFILLER_150_754 VDD VSS sg13g2_fill_2
Xoutput64 mem_axi_araddr[5] _16858_/A VDD VSS sg13g2_buf_1
XFILLER_122_456 VDD VSS sg13g2_decap_8
XFILLER_1_742 VDD VSS sg13g2_decap_8
Xoutput75 mem_axi_awaddr[14] _16867_/X VDD VSS sg13g2_buf_1
XFILLER_66_1280 VDD VSS sg13g2_decap_8
X_14266__1913 _14266_/RESET_B VDD VSS sg13g2_tiehi
Xoutput86 mem_axi_awaddr[25] _16878_/X VDD VSS sg13g2_buf_1
XFILLER_89_871 VDD VSS sg13g2_fill_1
XFILLER_49_702 VDD VSS sg13g2_decap_8
Xoutput97 mem_axi_awaddr[6] _16859_/X VDD VSS sg13g2_buf_1
XFILLER_0_252 VDD VSS sg13g2_decap_8
XFILLER_163_63 VDD VSS sg13g2_decap_8
X_11074_ _11074_/Y _14947_/Q _11196_/B VDD VSS sg13g2_nand2_1
XFILLER_88_370 VDD VSS sg13g2_decap_8
XFILLER_27_1264 VDD VSS sg13g2_decap_8
XFILLER_153_1272 VDD VSS sg13g2_fill_1
XFILLER_76_532 VDD VSS sg13g2_decap_8
X_14902_ _14902_/Q _15226_/CLK _14902_/D _14902_/RESET_B VDD VSS sg13g2_dfrbpq_1
X_10025_ _14607_/D _10091_/A0 _14607_/Q _10027_/S VDD VSS sg13g2_mux2_1
XFILLER_7_1358 VDD VSS sg13g2_decap_8
XFILLER_37_908 VDD VSS sg13g2_decap_8
XFILLER_23_1139 VDD VSS sg13g2_decap_8
XFILLER_97_1207 VDD VSS sg13g2_decap_8
XFILLER_64_705 VDD VSS sg13g2_decap_8
XFILLER_48_256 VDD VSS sg13g2_decap_8
XFILLER_114_1289 VDD VSS sg13g2_decap_4
X_14833_ _14833_/Q _14867_/CLK _14833_/D _14833_/RESET_B VDD VSS sg13g2_dfrbpq_1
XFILLER_5_1071 VDD VSS sg13g2_decap_8
XFILLER_57_790 VDD VSS sg13g2_decap_8
X_14764_ _14764_/Q clkload32/A _14764_/D _14764_/RESET_B VDD VSS sg13g2_dfrbpq_1
X_11976_ _11976_/Y _11975_/Y _11965_/Y _11957_/Y _11947_/Y _12001_/A VDD VSS sg13g2_a221oi_1
XFILLER_17_665 VDD VSS sg13g2_decap_8
XFILLER_44_451 VDD VSS sg13g2_fill_2
X_13715_ _16877_/A clkload41/A _13715_/D _13715_/RESET_B VDD VSS sg13g2_dfrbpq_1
XFILLER_32_602 VDD VSS sg13g2_decap_8
X_10927_ _10927_/Y _10956_/C _10936_/C _11183_/B1 VDD VSS sg13g2_o21ai_1
XFILLER_16_175 VDD VSS sg13g2_decap_8
X_14695_ _14695_/Q _14727_/CLK _14695_/D _14695_/RESET_B VDD VSS sg13g2_dfrbpq_1
XFILLER_71_281 VDD VSS sg13g2_decap_8
XFILLER_60_955 VDD VSS sg13g2_decap_4
XFILLER_31_112 VDD VSS sg13g2_fill_1
XFILLER_108_1027 VDD VSS sg13g2_fill_1
X_13646_ _13754_/D _13646_/A VDD VSS sg13g2_buf_1
X_10858_ _10858_/Y _10898_/B1 _10852_/X _10873_/A1 VDD VSS sg13g2_o21ai_1
XFILLER_73_1251 VDD VSS sg13g2_decap_4
XFILLER_60_977 VDD VSS sg13g2_decap_8
XFILLER_20_819 VDD VSS sg13g2_decap_8
XFILLER_38_1382 VDD VSS sg13g2_fill_2
XFILLER_13_882 VDD VSS sg13g2_decap_8
X_13577_ _13577_/Y _14999_/Q _13566_/B _13569_/S _15015_/Q _13525_/X VDD VSS sg13g2_a221oi_1
XFILLER_34_1246 VDD VSS sg13g2_decap_8
XFILLER_31_189 VDD VSS sg13g2_decap_8
XFILLER_125_1374 VDD VSS sg13g2_fill_1
X_13754__2425 _13754_/RESET_B VDD VSS sg13g2_tiehi
X_10789_ _11185_/B _10720_/A _09155_/Y _08949_/Y VDD VSS sg13g2_o21ai_1
XFILLER_12_392 VDD VSS sg13g2_decap_8
X_12528_ _12541_/A _12765_/A1 _12542_/A2 _15002_/Q VDD VSS sg13g2_a21oi_1
XFILLER_9_875 VDD VSS sg13g2_decap_8
XFILLER_173_824 VDD VSS sg13g2_fill_1
XFILLER_117_217 VDD VSS sg13g2_decap_8
XFILLER_121_1249 VDD VSS sg13g2_fill_1
XFILLER_69_1309 VDD VSS sg13g2_decap_8
XFILLER_8_385 VDD VSS sg13g2_decap_8
X_15247_ _15247_/Q _15247_/CLK _15247_/D _15247_/RESET_B VDD VSS sg13g2_dfrbpq_1
XFILLER_145_559 VDD VSS sg13g2_decap_8
X_12459_ _12459_/X _13827_/Q _13859_/Q _13891_/Q _13923_/Q _12546_/S0 _12546_/S1 VDD
+ VSS sg13g2_mux4_1
X_15178_ _15178_/Q clkload65/A _15178_/D _15178_/RESET_B VDD VSS sg13g2_dfrbpq_1
XFILLER_114_935 VDD VSS sg13g2_decap_4
X_14134__2045 _14134_/RESET_B VDD VSS sg13g2_tiehi
XFILLER_154_1014 VDD VSS sg13g2_decap_8
XFILLER_99_646 VDD VSS sg13g2_fill_2
X_14129_ _14129_/Q _14667_/CLK _14129_/D _14129_/RESET_B VDD VSS sg13g2_dfrbpq_1
XFILLER_140_220 VDD VSS sg13g2_decap_8
Xfanout309 _10163_/S _10169_/S VDD VSS sg13g2_buf_1
XFILLER_80_1200 VDD VSS sg13g2_fill_2
XFILLER_113_467 VDD VSS sg13g2_fill_2
XFILLER_98_189 VDD VSS sg13g2_decap_8
XFILLER_39_212 VDD VSS sg13g2_decap_8
X_09670_ _14263_/D _09934_/A1 _14263_/Q _09670_/S VDD VSS sg13g2_mux2_1
XFILLER_95_852 VDD VSS sg13g2_decap_8
XFILLER_80_1277 VDD VSS sg13g2_decap_8
XFILLER_11_0 VDD VSS sg13g2_decap_8
X_08621_ _08622_/B _08621_/A _13525_/A _08621_/C VDD VSS sg13g2_nor3_1
XFILLER_94_362 VDD VSS sg13g2_decap_8
XFILLER_94_384 VDD VSS sg13g2_decap_8
XFILLER_55_738 VDD VSS sg13g2_decap_8
XFILLER_48_790 VDD VSS sg13g2_decap_8
XFILLER_82_546 VDD VSS sg13g2_fill_2
XFILLER_54_237 VDD VSS sg13g2_decap_8
XFILLER_36_941 VDD VSS sg13g2_decap_8
XFILLER_130_1080 VDD VSS sg13g2_decap_8
X_08552_ _08553_/B _08369_/B _08551_/X _08547_/Y _08546_/Y VDD VSS sg13g2_a22oi_1
XFILLER_36_963 VDD VSS sg13g2_fill_2
XFILLER_51_900 VDD VSS sg13g2_decap_4
XFILLER_165_1121 VDD VSS sg13g2_decap_8
Xclkbuf_4_12_0_clk_i clkbuf_4_12_0_clk_i/X clkbuf_0_clk_i/X VDD VSS sg13g2_buf_8
X_08483_ _08501_/A _08600_/A _08150_/X _08676_/B2 VDD VSS sg13g2_o21ai_1
XFILLER_39_1157 VDD VSS sg13g2_fill_1
XFILLER_22_112 VDD VSS sg13g2_decap_8
XFILLER_161_1007 VDD VSS sg13g2_fill_1
XFILLER_126_1138 VDD VSS sg13g2_decap_8
XFILLER_165_1187 VDD VSS sg13g2_decap_4
XFILLER_11_819 VDD VSS sg13g2_decap_8
XFILLER_91_1351 VDD VSS sg13g2_decap_8
XFILLER_50_454 VDD VSS sg13g2_decap_8
XFILLER_51_999 VDD VSS sg13g2_fill_2
XFILLER_10_329 VDD VSS sg13g2_decap_8
XFILLER_50_498 VDD VSS sg13g2_decap_8
XFILLER_22_189 VDD VSS sg13g2_decap_8
X_14344__1835 _14344_/RESET_B VDD VSS sg13g2_tiehi
X_09104_ _09104_/X _13142_/A _09136_/B _09102_/Y VDD VSS sg13g2_a21o_1
XFILLER_148_364 VDD VSS sg13g2_decap_8
XFILLER_149_887 VDD VSS sg13g2_decap_8
XFILLER_163_301 VDD VSS sg13g2_decap_8
XFILLER_15_1190 VDD VSS sg13g2_decap_8
XFILLER_164_857 VDD VSS sg13g2_fill_1
X_09035_ _09035_/Y _14906_/Q _09031_/C _09024_/A VDD VSS sg13g2_o21ai_1
XFILLER_11_1043 VDD VSS sg13g2_decap_8
XFILLER_123_209 VDD VSS sg13g2_fill_2
XFILLER_163_378 VDD VSS sg13g2_decap_8
XFILLER_102_1193 VDD VSS sg13g2_decap_8
XFILLER_116_283 VDD VSS sg13g2_decap_8
XFILLER_2_539 VDD VSS sg13g2_decap_8
XFILLER_46_1117 VDD VSS sg13g2_decap_8
XFILLER_85_1188 VDD VSS sg13g2_fill_2
XFILLER_104_467 VDD VSS sg13g2_decap_4
XFILLER_117_89 VDD VSS sg13g2_decap_8
Xfanout810 _12633_/S1 fanout812/X VDD VSS sg13g2_buf_1
Xfanout821 _12382_/S1 _12352_/S1 VDD VSS sg13g2_buf_1
XFILLER_77_49 VDD VSS sg13g2_decap_4
XFILLER_77_307 VDD VSS sg13g2_decap_8
Xfanout832 _12715_/S1 _12717_/S1 VDD VSS sg13g2_buf_1
X_09937_ _14522_/D _14522_/Q _09937_/A1 _09937_/S VDD VSS sg13g2_mux2_1
XFILLER_77_318 VDD VSS sg13g2_fill_2
XFILLER_104_489 VDD VSS sg13g2_decap_8
Xfanout843 _12450_/S1 _12437_/S1 VDD VSS sg13g2_buf_1
Xfanout854 _12507_/S0 fanout864/X VDD VSS sg13g2_buf_1
Xfanout865 _12590_/S0 _12614_/S0 VDD VSS sg13g2_buf_1
X_14841__2862 _14841_/RESET_B VDD VSS sg13g2_tiehi
Xfanout876 _12787_/S0 _12782_/S0 VDD VSS sg13g2_buf_1
XFILLER_58_543 VDD VSS sg13g2_decap_8
XFILLER_100_640 VDD VSS sg13g2_decap_4
Xfanout887 _12767_/S0 _12773_/S0 VDD VSS sg13g2_buf_1
X_09868_ _14455_/D _14455_/Q _09967_/A1 _09870_/S VDD VSS sg13g2_mux2_1
Xfanout898 _07683_/A _12870_/A2 VDD VSS sg13g2_buf_1
XFILLER_85_340 VDD VSS sg13g2_decap_8
XFILLER_86_874 VDD VSS sg13g2_decap_8
X_08819_ _13690_/D _08817_/Y _08816_/Y _08818_/Y VDD VSS sg13g2_a21oi_1
XFILLER_86_896 VDD VSS sg13g2_fill_1
XFILLER_45_215 VDD VSS sg13g2_decap_4
XFILLER_2_1211 VDD VSS sg13g2_decap_8
X_13832__2347 _13832_/RESET_B VDD VSS sg13g2_tiehi
X_09799_ _14388_/D _09898_/A0 _14388_/Q _09799_/S VDD VSS sg13g2_mux2_1
XFILLER_46_749 VDD VSS sg13g2_decap_8
X_14592__1587 _14592_/RESET_B VDD VSS sg13g2_tiehi
X_11830_ _11830_/Y _11806_/Y _11808_/Y _11224_/A VDD VSS sg13g2_a21oi_1
XFILLER_26_42 VDD VSS sg13g2_decap_8
XFILLER_14_602 VDD VSS sg13g2_decap_8
XFILLER_26_462 VDD VSS sg13g2_decap_8
X_14874__2796 _14874_/RESET_B VDD VSS sg13g2_tiehi
XFILLER_2_1288 VDD VSS sg13g2_decap_8
X_11761_ _11761_/Y _11761_/A _11761_/B _12237_/C VDD VSS sg13g2_nand3_1
XFILLER_96_1284 VDD VSS sg13g2_decap_8
XFILLER_54_793 VDD VSS sg13g2_decap_4
XFILLER_109_1325 VDD VSS sg13g2_decap_8
XFILLER_13_112 VDD VSS sg13g2_decap_8
XFILLER_144_1205 VDD VSS sg13g2_decap_8
XFILLER_57_1257 VDD VSS sg13g2_decap_8
X_13500_ _15128_/D _13351_/C _13502_/D _13499_/Y VDD VSS sg13g2_o21ai_1
XFILLER_41_432 VDD VSS sg13g2_decap_8
X_10712_ _10954_/B _09034_/X _10788_/S _08877_/Y VDD VSS sg13g2_a21oi_1
X_14480_ _14480_/Q _14512_/CLK _14480_/D _14480_/RESET_B VDD VSS sg13g2_dfrbpq_1
X_11692_ _11693_/B _11692_/A _14216_/Q VDD VSS sg13g2_nand2_1
XFILLER_14_679 VDD VSS sg13g2_decap_8
XFILLER_9_105 VDD VSS sg13g2_decap_8
XFILLER_42_999 VDD VSS sg13g2_decap_8
X_13431_ _13431_/Y _13455_/A _13435_/B _13444_/C VDD VSS sg13g2_nor3_1
X_10643_ _14888_/D _10643_/A _10643_/B _10643_/C VDD VSS sg13g2_nor3_1
XFILLER_13_189 VDD VSS sg13g2_decap_8
XFILLER_167_651 VDD VSS sg13g2_decap_4
XFILLER_42_63 VDD VSS sg13g2_decap_8
XFILLER_139_364 VDD VSS sg13g2_decap_8
X_13362_ _15073_/D _15073_/Q _13470_/A2 _13361_/Y VDD VSS sg13g2_a21o_1
XFILLER_139_375 VDD VSS sg13g2_fill_1
XFILLER_158_63 VDD VSS sg13g2_decap_8
XFILLER_166_161 VDD VSS sg13g2_decap_8
X_10574_ _10583_/D _14870_/Q _10647_/C VDD VSS sg13g2_and2_1
XFILLER_6_812 VDD VSS sg13g2_decap_8
X_15101_ _15101_/Q clkload61/A _15101_/D _15101_/RESET_B VDD VSS sg13g2_dfrbpq_1
X_12313_ _12313_/Y _12250_/A1 _14650_/Q VDD VSS sg13g2_nand2b_1
XFILLER_10_896 VDD VSS sg13g2_decap_8
XFILLER_154_334 VDD VSS sg13g2_decap_8
XFILLER_5_322 VDD VSS sg13g2_decap_8
X_13293_ _13294_/C _13293_/A _13300_/A _13293_/C _13293_/D VDD VSS sg13g2_nor4_1
XFILLER_108_751 VDD VSS sg13g2_decap_8
X_15032_ _15032_/Q clkload56/A _15032_/D _15032_/RESET_B VDD VSS sg13g2_dfrbpq_1
X_12244_ _12244_/Y _12240_/Y _12241_/Y _12243_/Y _12242_/Y _12246_/B VDD VSS sg13g2_a221oi_1
XFILLER_6_889 VDD VSS sg13g2_decap_8
XFILLER_135_570 VDD VSS sg13g2_decap_8
XFILLER_170_838 VDD VSS sg13g2_decap_8
XFILLER_108_795 VDD VSS sg13g2_decap_8
XFILLER_135_581 VDD VSS sg13g2_fill_1
XFILLER_5_399 VDD VSS sg13g2_decap_8
XFILLER_123_754 VDD VSS sg13g2_fill_1
X_12175_ _12175_/Y _12257_/A1 _14390_/Q VDD VSS sg13g2_nand2b_1
XFILLER_116_1307 VDD VSS sg13g2_decap_4
XFILLER_96_605 VDD VSS sg13g2_decap_8
XFILLER_29_1359 VDD VSS sg13g2_decap_8
XFILLER_3_35 VDD VSS sg13g2_decap_8
X_11126_ _11146_/A _11145_/A _11147_/A VDD VSS sg13g2_xnor2_1
Xclkbuf_leaf_110_clk_i _14979_/CLK clkbuf_5_18__f_clk_i/X VDD VSS sg13g2_buf_8
X_11057_ _14945_/D _11056_/Y _11055_/Y _11048_/Y VDD VSS sg13g2_o21ai_1
XFILLER_7_1155 VDD VSS sg13g2_decap_8
XFILLER_76_340 VDD VSS sg13g2_decap_8
XFILLER_3_1008 VDD VSS sg13g2_decap_8
XFILLER_77_885 VDD VSS sg13g2_decap_4
X_10008_ _14590_/D _10074_/A0 _14590_/Q _10030_/S VDD VSS sg13g2_mux2_1
XFILLER_114_1086 VDD VSS sg13g2_decap_4
XFILLER_76_395 VDD VSS sg13g2_fill_1
X_14422__1757 _14422_/RESET_B VDD VSS sg13g2_tiehi
XFILLER_64_546 VDD VSS sg13g2_decap_8
X_13808__2371 _13808_/RESET_B VDD VSS sg13g2_tiehi
X_14816_ _14816_/Q clkload45/A _14816_/D _14816_/RESET_B VDD VSS sg13g2_dfrbpq_1
Xclkbuf_leaf_125_clk_i clkload3/A clkbuf_leaf_3_clk_i/A VDD VSS sg13g2_buf_8
XFILLER_18_952 VDD VSS sg13g2_decap_8
XFILLER_17_462 VDD VSS sg13g2_decap_8
X_15213__2981 _15213_/RESET_B VDD VSS sg13g2_tiehi
X_14747_ _14747_/Q _15214_/CLK _14747_/D _14747_/RESET_B VDD VSS sg13g2_dfrbpq_1
X_11959_ _11959_/Y _11969_/A _14416_/Q _12038_/B1 VDD VSS sg13g2_a21oi_1
XFILLER_33_933 VDD VSS sg13g2_fill_1
XFILLER_83_92 VDD VSS sg13g2_decap_8
XFILLER_162_1316 VDD VSS sg13g2_decap_8
XFILLER_33_966 VDD VSS sg13g2_decap_4
XFILLER_32_443 VDD VSS sg13g2_decap_8
XFILLER_149_106 VDD VSS sg13g2_fill_2
X_14678_ _14678_/Q clkload26/A _14678_/D _14678_/RESET_B VDD VSS sg13g2_dfrbpq_1
XFILLER_60_763 VDD VSS sg13g2_fill_1
XFILLER_20_616 VDD VSS sg13g2_decap_8
X_13629_ _13737_/D _13629_/A VDD VSS sg13g2_buf_1
XFILLER_32_487 VDD VSS sg13g2_fill_1
XFILLER_121_1035 VDD VSS sg13g2_decap_8
XFILLER_9_672 VDD VSS sg13g2_decap_8
XFILLER_118_537 VDD VSS sg13g2_decap_8
XFILLER_145_323 VDD VSS sg13g2_decap_8
XFILLER_12_1330 VDD VSS sg13g2_decap_8
XFILLER_8_182 VDD VSS sg13g2_decap_8
XFILLER_173_654 VDD VSS sg13g2_decap_4
XFILLER_59_0 VDD VSS sg13g2_decap_8
XFILLER_161_838 VDD VSS sg13g2_decap_8
XFILLER_172_175 VDD VSS sg13g2_decap_8
XFILLER_161_849 VDD VSS sg13g2_fill_2
X_13910__2269 _13910_/RESET_B VDD VSS sg13g2_tiehi
XFILLER_160_337 VDD VSS sg13g2_decap_8
XFILLER_102_905 VDD VSS sg13g2_fill_2
XFILLER_82_1328 VDD VSS sg13g2_decap_8
XFILLER_82_1339 VDD VSS sg13g2_fill_2
XFILLER_99_476 VDD VSS sg13g2_decap_8
X_15192__2777 _15192_/RESET_B VDD VSS sg13g2_tiehi
X_14959__2628 _14959_/RESET_B VDD VSS sg13g2_tiehi
X_07983_ _07985_/C _07978_/Y _15077_/Q _07908_/B VDD VSS sg13g2_a21oi_1
XFILLER_45_1161 VDD VSS sg13g2_decap_8
X_09722_ _14313_/D _09920_/A1 _14313_/Q _09738_/S VDD VSS sg13g2_mux2_1
XFILLER_68_841 VDD VSS sg13g2_decap_8
X_09653_ _14246_/D _09884_/A0 _14246_/Q _09664_/S VDD VSS sg13g2_mux2_1
XFILLER_103_14 VDD VSS sg13g2_decap_4
XFILLER_167_1216 VDD VSS sg13g2_decap_8
X_08604_ _08605_/B _08672_/A _07855_/B _08674_/A2 _08643_/D VDD VSS sg13g2_a22oi_1
X_09584_ _14181_/D _14181_/Q _10048_/A0 _09596_/S VDD VSS sg13g2_mux2_1
XFILLER_27_259 VDD VSS sg13g2_decap_8
XFILLER_82_365 VDD VSS sg13g2_fill_1
X_08535_ _15240_/D _08535_/A _08535_/B VDD VSS sg13g2_nand2_1
XFILLER_82_387 VDD VSS sg13g2_decap_8
XFILLER_70_527 VDD VSS sg13g2_decap_4
XFILLER_169_905 VDD VSS sg13g2_decap_8
X_08466_ _08617_/B _08376_/X _08465_/X _08597_/B VDD VSS sg13g2_mux2_1
XFILLER_11_616 VDD VSS sg13g2_decap_8
X_14577__1602 _14577_/RESET_B VDD VSS sg13g2_tiehi
XFILLER_50_262 VDD VSS sg13g2_decap_4
XFILLER_23_476 VDD VSS sg13g2_decap_8
XFILLER_168_448 VDD VSS sg13g2_decap_8
X_08397_ _08397_/Y _08397_/A _08397_/B VDD VSS sg13g2_nor2_1
XFILLER_52_1132 VDD VSS sg13g2_decap_8
XFILLER_10_126 VDD VSS sg13g2_decap_8
XFILLER_137_7 VDD VSS sg13g2_decap_8
XFILLER_7_609 VDD VSS sg13g2_decap_8
XFILLER_109_504 VDD VSS sg13g2_fill_1
XFILLER_137_813 VDD VSS sg13g2_decap_8
XFILLER_17_1274 VDD VSS sg13g2_decap_8
XFILLER_137_824 VDD VSS sg13g2_fill_2
XFILLER_13_1127 VDD VSS sg13g2_decap_8
XFILLER_6_119 VDD VSS sg13g2_decap_8
XFILLER_12_77 VDD VSS sg13g2_decap_8
XFILLER_87_1239 VDD VSS sg13g2_decap_8
XFILLER_136_378 VDD VSS sg13g2_fill_1
X_09018_ _09019_/B _10702_/A _09030_/D _09017_/Y VDD VSS sg13g2_o21ai_1
XFILLER_128_77 VDD VSS sg13g2_decap_8
XFILLER_163_175 VDD VSS sg13g2_decap_8
X_10290_ _10292_/B _10281_/D _10298_/D _14791_/Q VDD VSS sg13g2_a21oi_1
XFILLER_3_826 VDD VSS sg13g2_decap_8
XFILLER_105_721 VDD VSS sg13g2_decap_8
XFILLER_128_88 VDD VSS sg13g2_fill_1
XFILLER_88_37 VDD VSS sg13g2_decap_8
X_14500__1679 _14500_/RESET_B VDD VSS sg13g2_tiehi
XFILLER_2_336 VDD VSS sg13g2_decap_8
XFILLER_132_551 VDD VSS sg13g2_decap_8
XFILLER_160_871 VDD VSS sg13g2_decap_4
XFILLER_144_21 VDD VSS sg13g2_decap_8
XFILLER_137_1075 VDD VSS sg13g2_decap_8
Xfanout640 _08623_/A2 _07993_/Y VDD VSS sg13g2_buf_1
Xfanout651 _13208_/A2 _13236_/A2 VDD VSS sg13g2_buf_1
XFILLER_115_1340 VDD VSS sg13g2_decap_8
Xfanout662 _11207_/B1 _11045_/B1 VDD VSS sg13g2_buf_1
XFILLER_77_148 VDD VSS sg13g2_decap_8
X_13980_ _13980_/Q clkload44/A _13980_/D _13980_/RESET_B VDD VSS sg13g2_dfrbpq_1
XFILLER_115_1351 VDD VSS sg13g2_fill_1
XFILLER_120_779 VDD VSS sg13g2_decap_8
Xfanout673 _11868_/A _12339_/A1 VDD VSS sg13g2_buf_1
XFILLER_58_340 VDD VSS sg13g2_decap_8
Xfanout684 _10203_/S _08721_/S VDD VSS sg13g2_buf_1
Xclkbuf_leaf_42_clk_i clkload34/A clkbuf_leaf_43_clk_i/A VDD VSS sg13g2_buf_8
Xfanout695 _11964_/B _11973_/B VDD VSS sg13g2_buf_1
XFILLER_74_811 VDD VSS sg13g2_decap_8
X_12931_ _12931_/Y _14775_/Q _13275_/A2 _13236_/B1 VDD VSS sg13g2_o21ai_1
XFILLER_59_896 VDD VSS sg13g2_decap_8
XFILLER_24_1267 VDD VSS sg13g2_decap_8
XFILLER_101_993 VDD VSS sg13g2_decap_4
XFILLER_150_1275 VDD VSS sg13g2_decap_8
XFILLER_92_129 VDD VSS sg13g2_decap_8
XFILLER_19_749 VDD VSS sg13g2_decap_8
XFILLER_111_1248 VDD VSS sg13g2_decap_8
XFILLER_46_546 VDD VSS sg13g2_decap_4
XFILLER_37_63 VDD VSS sg13g2_decap_8
XFILLER_160_42 VDD VSS sg13g2_decap_8
XFILLER_46_557 VDD VSS sg13g2_fill_1
X_12862_ _12862_/Y _14867_/Q _12895_/B VDD VSS sg13g2_nand2_1
XFILLER_98_1379 VDD VSS sg13g2_fill_1
XFILLER_18_259 VDD VSS sg13g2_decap_8
XFILLER_163_0 VDD VSS sg13g2_decap_8
X_14601_ _14601_/Q clkload21/A _14601_/D _14601_/RESET_B VDD VSS sg13g2_dfrbpq_1
X_11813_ _11813_/Y _11809_/Y _11810_/Y _11812_/Y _11811_/Y _11815_/B VDD VSS sg13g2_a221oi_1
XFILLER_96_1070 VDD VSS sg13g2_decap_8
XFILLER_2_1085 VDD VSS sg13g2_decap_8
X_12793_ _12793_/Y _12997_/B _12936_/B VDD VSS sg13g2_nor2_1
XFILLER_27_793 VDD VSS sg13g2_decap_8
Xclkbuf_leaf_57_clk_i _15159_/CLK clkbuf_leaf_62_clk_i/A VDD VSS sg13g2_buf_8
XFILLER_54_590 VDD VSS sg13g2_decap_8
XFILLER_57_1043 VDD VSS sg13g2_fill_1
XFILLER_15_966 VDD VSS sg13g2_decap_8
X_14532_ _14532_/Q _14660_/CLK _14532_/D _14532_/RESET_B VDD VSS sg13g2_dfrbpq_1
X_11744_ _11745_/A _13738_/Q _14090_/Q _14442_/Q _14538_/Q _11741_/A _11760_/C VDD
+ VSS sg13g2_mux4_1
XFILLER_41_251 VDD VSS sg13g2_decap_8
XFILLER_14_476 VDD VSS sg13g2_decap_8
XFILLER_42_785 VDD VSS sg13g2_decap_4
X_14463_ _14463_/Q clkload14/A _14463_/D _14463_/RESET_B VDD VSS sg13g2_dfrbpq_1
XFILLER_30_947 VDD VSS sg13g2_decap_8
X_11675_ _11675_/Y _11676_/A1 _14632_/Q VDD VSS sg13g2_nand2b_1
XFILLER_70_1221 VDD VSS sg13g2_decap_8
XFILLER_169_84 VDD VSS sg13g2_decap_8
XFILLER_174_407 VDD VSS sg13g2_decap_8
X_13414_ _13414_/Y _13429_/A _13494_/B _13435_/B VDD VSS sg13g2_nor3_1
XFILLER_122_1322 VDD VSS sg13g2_decap_8
X_10626_ _14883_/D _10626_/A _10630_/C _10626_/C VDD VSS sg13g2_and3_1
XFILLER_127_301 VDD VSS sg13g2_decap_8
XFILLER_128_824 VDD VSS sg13g2_decap_8
XFILLER_168_993 VDD VSS sg13g2_decap_8
X_14394_ _14394_/Q clkload49/A _14394_/D _14394_/RESET_B VDD VSS sg13g2_dfrbpq_1
XFILLER_128_868 VDD VSS sg13g2_fill_2
X_13345_ _13345_/Y _13499_/A _13345_/B VDD VSS sg13g2_nand2_1
XFILLER_10_693 VDD VSS sg13g2_decap_8
X_13671__2530 _13671_/RESET_B VDD VSS sg13g2_tiehi
X_10557_ _14867_/D _10557_/A _10557_/B _10557_/C VDD VSS sg13g2_and3_1
XFILLER_170_602 VDD VSS sg13g2_decap_8
X_13276_ _13276_/Y _13273_/Y _13274_/Y _13275_/Y VDD VSS sg13g2_a21oi_1
XFILLER_6_686 VDD VSS sg13g2_decap_8
XFILLER_52_7 VDD VSS sg13g2_decap_8
X_10488_ _10490_/B _10492_/C _10508_/C _14850_/Q VDD VSS sg13g2_a21oi_1
X_15015_ _15015_/Q _15015_/CLK _15015_/D _15015_/RESET_B VDD VSS sg13g2_dfrbpq_1
XFILLER_170_657 VDD VSS sg13g2_decap_8
X_12227_ _12270_/A _12229_/A _12298_/B VDD VSS sg13g2_nor2_1
XFILLER_5_196 VDD VSS sg13g2_decap_8
XFILLER_123_540 VDD VSS sg13g2_fill_1
X_14922__2700 _14922_/RESET_B VDD VSS sg13g2_tiehi
XFILLER_64_1025 VDD VSS sg13g2_decap_8
XFILLER_151_871 VDD VSS sg13g2_decap_8
XFILLER_69_616 VDD VSS sg13g2_decap_8
XFILLER_29_1156 VDD VSS sg13g2_decap_8
XFILLER_123_573 VDD VSS sg13g2_decap_8
XFILLER_111_724 VDD VSS sg13g2_decap_8
X_12158_ _12158_/Y _12168_/A _14166_/Q _12018_/C VDD VSS sg13g2_a21oi_1
XFILLER_9_1239 VDD VSS sg13g2_decap_8
XFILLER_78_70 VDD VSS sg13g2_decap_8
XFILLER_78_81 VDD VSS sg13g2_fill_2
XFILLER_64_1069 VDD VSS sg13g2_fill_1
X_11109_ _11109_/Y _11109_/A _11109_/B VDD VSS sg13g2_nand2_1
XFILLER_84_608 VDD VSS sg13g2_decap_8
X_12089_ _12091_/A _12090_/A _14196_/Q VDD VSS sg13g2_nand2b_1
XFILLER_42_1334 VDD VSS sg13g2_decap_8
X_14655__1524 _14655_/RESET_B VDD VSS sg13g2_tiehi
XFILLER_77_682 VDD VSS sg13g2_decap_8
XFILLER_49_373 VDD VSS sg13g2_decap_4
XFILLER_77_693 VDD VSS sg13g2_decap_8
X_14955__2634 _14955_/RESET_B VDD VSS sg13g2_tiehi
XFILLER_94_80 VDD VSS sg13g2_decap_8
XFILLER_64_343 VDD VSS sg13g2_fill_1
X_14084__2095 _14084_/RESET_B VDD VSS sg13g2_tiehi
XFILLER_91_151 VDD VSS sg13g2_fill_2
XFILLER_80_825 VDD VSS sg13g2_decap_8
XFILLER_75_1121 VDD VSS sg13g2_decap_8
X_08320_ _08366_/D _08420_/A _08418_/A VDD VSS sg13g2_nor2b_1
XFILLER_21_903 VDD VSS sg13g2_decap_8
XFILLER_166_1293 VDD VSS sg13g2_decap_8
XFILLER_36_1138 VDD VSS sg13g2_fill_2
X_15023__2564 _15023_/RESET_B VDD VSS sg13g2_tiehi
XFILLER_127_1266 VDD VSS sg13g2_decap_8
X_08251_ _15226_/D _08039_/A _08250_/X _08246_/Y VDD VSS sg13g2_o21ai_1
XFILLER_20_413 VDD VSS sg13g2_decap_8
XFILLER_123_1119 VDD VSS sg13g2_decap_8
XFILLER_119_802 VDD VSS sg13g2_fill_2
XFILLER_162_1179 VDD VSS sg13g2_decap_8
X_08182_ _08188_/C _08183_/B _08182_/B _08182_/C VDD VSS sg13g2_nor3_1
XFILLER_119_846 VDD VSS sg13g2_decap_8
XFILLER_158_492 VDD VSS sg13g2_decap_8
XFILLER_146_665 VDD VSS sg13g2_decap_8
XFILLER_173_440 VDD VSS sg13g2_decap_8
XFILLER_173_451 VDD VSS sg13g2_decap_8
XFILLER_133_304 VDD VSS sg13g2_decap_4
XFILLER_160_112 VDD VSS sg13g2_decap_8
XFILLER_86_1250 VDD VSS sg13g2_decap_8
XFILLER_161_668 VDD VSS sg13g2_decap_8
XFILLER_0_807 VDD VSS sg13g2_decap_8
XFILLER_99_240 VDD VSS sg13g2_decap_8
XFILLER_88_914 VDD VSS sg13g2_fill_2
XFILLER_173_1253 VDD VSS sg13g2_fill_2
XFILLER_160_189 VDD VSS sg13g2_decap_8
X_14294__1885 _14294_/RESET_B VDD VSS sg13g2_tiehi
XFILLER_87_446 VDD VSS sg13g2_decap_8
X_07966_ _07966_/Y _15015_/Q _07853_/B VDD VSS sg13g2_nor2b_1
XFILLER_114_35 VDD VSS sg13g2_fill_2
XFILLER_68_660 VDD VSS sg13g2_decap_8
X_09705_ _14297_/D _09936_/A1 _14297_/Q _09705_/S VDD VSS sg13g2_mux2_1
XFILLER_28_513 VDD VSS sg13g2_decap_8
X_07897_ _08037_/B _07900_/B _07903_/B VDD VSS sg13g2_nand2_1
XFILLER_74_28 VDD VSS sg13g2_decap_8
X_15063__1423 _15063_/RESET_B VDD VSS sg13g2_tiehi
X_09636_ _14232_/D _09636_/A0 _14232_/Q _09638_/S VDD VSS sg13g2_mux2_1
XFILLER_56_866 VDD VSS sg13g2_fill_2
XFILLER_83_663 VDD VSS sg13g2_decap_8
XFILLER_167_1024 VDD VSS sg13g2_decap_8
XFILLER_82_140 VDD VSS sg13g2_decap_8
XFILLER_43_505 VDD VSS sg13g2_decap_4
XFILLER_3_1372 VDD VSS sg13g2_decap_8
XFILLER_83_696 VDD VSS sg13g2_fill_1
XFILLER_3_1383 VDD VSS sg13g2_fill_1
X_09567_ _14165_/D _10097_/A0 _14165_/Q _09567_/S VDD VSS sg13g2_mux2_1
XFILLER_71_858 VDD VSS sg13g2_decap_8
XFILLER_93_1232 VDD VSS sg13g2_decap_8
XFILLER_36_590 VDD VSS sg13g2_decap_8
X_08518_ _08526_/C _13533_/A _08197_/X _08688_/C VDD VSS sg13g2_o21ai_1
XFILLER_12_903 VDD VSS sg13g2_decap_8
XFILLER_169_724 VDD VSS sg13g2_decap_8
XFILLER_24_763 VDD VSS sg13g2_decap_8
X_09498_ _14098_/D _10161_/A1 _14098_/Q _09504_/S VDD VSS sg13g2_mux2_1
XFILLER_145_1344 VDD VSS sg13g2_fill_1
XFILLER_90_49 VDD VSS sg13g2_decap_4
XFILLER_19_1358 VDD VSS sg13g2_decap_8
XFILLER_11_413 VDD VSS sg13g2_decap_8
XFILLER_23_273 VDD VSS sg13g2_decap_8
XFILLER_157_908 VDD VSS sg13g2_decap_8
XFILLER_168_245 VDD VSS sg13g2_decap_8
X_08449_ _08449_/Y _08448_/Y _07948_/A _08667_/A1 VDD VSS sg13g2_a21oi_1
XFILLER_23_21 VDD VSS sg13g2_decap_8
XFILLER_106_1328 VDD VSS sg13g2_fill_1
XFILLER_128_109 VDD VSS sg13g2_fill_1
XFILLER_139_21 VDD VSS sg13g2_decap_8
XFILLER_7_406 VDD VSS sg13g2_decap_8
X_11460_ _14962_/D _07909_/B _11248_/B _11459_/Y VDD VSS sg13g2_a21oi_1
XFILLER_17_1071 VDD VSS sg13g2_decap_8
X_13782__2397 _13782_/RESET_B VDD VSS sg13g2_tiehi
XFILLER_149_492 VDD VSS sg13g2_decap_4
XFILLER_20_980 VDD VSS sg13g2_decap_8
X_10411_ _14826_/D _10413_/B _10414_/D _10407_/Y _07648_/Y _10661_/A VDD VSS sg13g2_a221oi_1
XFILLER_99_14 VDD VSS sg13g2_decap_8
XFILLER_23_98 VDD VSS sg13g2_decap_8
XFILLER_139_76 VDD VSS sg13g2_decap_8
X_11391_ _11391_/Y _11391_/A _11419_/C VDD VSS sg13g2_nand2_1
XFILLER_109_356 VDD VSS sg13g2_fill_2
XFILLER_152_602 VDD VSS sg13g2_fill_1
XFILLER_164_462 VDD VSS sg13g2_decap_8
X_14733__1446 _14733_/RESET_B VDD VSS sg13g2_tiehi
XFILLER_125_827 VDD VSS sg13g2_decap_8
X_13130_ _13170_/B _14915_/Q _13672_/Q VDD VSS sg13g2_xnor2_1
XFILLER_87_1036 VDD VSS sg13g2_decap_4
XFILLER_125_838 VDD VSS sg13g2_fill_1
X_10342_ _10343_/B _10342_/A _14807_/Q _10342_/C _10357_/D VDD VSS sg13g2_nand4_1
XFILLER_152_624 VDD VSS sg13g2_decap_8
XFILLER_3_623 VDD VSS sg13g2_decap_8
XFILLER_30_1282 VDD VSS sg13g2_decap_8
XFILLER_174_1028 VDD VSS sg13g2_decap_4
XFILLER_124_359 VDD VSS sg13g2_decap_8
XFILLER_151_134 VDD VSS sg13g2_decap_8
XFILLER_155_42 VDD VSS sg13g2_decap_8
X_13061_ _13063_/B _13026_/A _13058_/B _13060_/Y VDD VSS sg13g2_a21oi_1
X_15212__2980 _15212_/RESET_B VDD VSS sg13g2_tiehi
X_10273_ _14785_/D _10299_/A _10299_/B _10271_/Y VDD VSS sg13g2_a21oi_1
XFILLER_2_133 VDD VSS sg13g2_decap_8
XFILLER_79_914 VDD VSS sg13g2_fill_2
XFILLER_79_925 VDD VSS sg13g2_decap_8
X_12012_ _12012_/X _12012_/A _12055_/D VDD VSS sg13g2_and2_1
XFILLER_120_510 VDD VSS sg13g2_decap_8
Xfanout1402 _10213_/A _12653_/A1 VDD VSS sg13g2_buf_1
XFILLER_78_424 VDD VSS sg13g2_decap_8
Xfanout1413 fanout1413/X _13005_/C VDD VSS sg13g2_buf_1
XFILLER_26_1329 VDD VSS sg13g2_decap_8
XFILLER_120_565 VDD VSS sg13g2_fill_2
Xfanout470 _09374_/S _09342_/Y VDD VSS sg13g2_buf_1
Xfanout481 _09910_/A1 _10142_/A1 VDD VSS sg13g2_buf_1
XFILLER_93_416 VDD VSS sg13g2_decap_8
XFILLER_111_1001 VDD VSS sg13g2_fill_1
Xfanout492 _08039_/A _08424_/A1 VDD VSS sg13g2_buf_1
XFILLER_47_833 VDD VSS sg13g2_decap_4
XFILLER_171_63 VDD VSS sg13g2_decap_8
X_13963_ _13963_/Q clkload1/A _13963_/D _13963_/RESET_B VDD VSS sg13g2_dfrbpq_1
XFILLER_24_1064 VDD VSS sg13g2_decap_8
XFILLER_0_14 VDD VSS sg13g2_decap_8
XFILLER_74_630 VDD VSS sg13g2_decap_4
XFILLER_19_546 VDD VSS sg13g2_decap_8
X_12914_ _12914_/Y _12914_/A _12914_/B _12914_/C VDD VSS sg13g2_nor3_1
XFILLER_4_1169 VDD VSS sg13g2_decap_8
X_13894_ _13894_/Q clkload11/A _13894_/D _13894_/RESET_B VDD VSS sg13g2_dfrbpq_1
XFILLER_47_888 VDD VSS sg13g2_decap_8
XFILLER_46_365 VDD VSS sg13g2_fill_1
XFILLER_62_836 VDD VSS sg13g2_decap_8
XFILLER_46_387 VDD VSS sg13g2_fill_2
X_12845_ _12845_/Y _12845_/A _12845_/B _12845_/C _12845_/D VDD VSS sg13g2_nand4_1
XFILLER_27_590 VDD VSS sg13g2_decap_8
XFILLER_72_1305 VDD VSS sg13g2_fill_1
XFILLER_15_763 VDD VSS sg13g2_decap_8
X_12776_ _12776_/X _12774_/X _12775_/X _12776_/S VDD VSS sg13g2_mux2_1
XFILLER_14_273 VDD VSS sg13g2_decap_8
X_14515_ _14515_/Q clkload24/A _14515_/D _14515_/RESET_B VDD VSS sg13g2_dfrbpq_1
X_11727_ _11728_/B _11707_/A _11773_/C _11705_/Y VDD VSS sg13g2_o21ai_1
XFILLER_159_245 VDD VSS sg13g2_decap_8
XFILLER_9_56 VDD VSS sg13g2_decap_8
X_14069__2110 _14069_/RESET_B VDD VSS sg13g2_tiehi
XFILLER_119_109 VDD VSS sg13g2_decap_8
XFILLER_128_610 VDD VSS sg13g2_decap_8
X_14446_ _14446_/Q clkload37/A _14446_/D _14446_/RESET_B VDD VSS sg13g2_dfrbpq_1
X_11658_ _14969_/D _11635_/A _12271_/A _11657_/Y VDD VSS sg13g2_a21o_1
XFILLER_11_980 VDD VSS sg13g2_decap_8
X_10609_ _10611_/C _14879_/Q _10614_/A VDD VSS sg13g2_nand2b_1
XFILLER_127_131 VDD VSS sg13g2_fill_2
X_14377_ _14377_/Q _14505_/CLK _14377_/D _14377_/RESET_B VDD VSS sg13g2_dfrbpq_1
XFILLER_156_974 VDD VSS sg13g2_decap_4
X_11589_ _11632_/A _11591_/A _11724_/B VDD VSS sg13g2_nor2_1
XFILLER_10_490 VDD VSS sg13g2_decap_8
XFILLER_156_985 VDD VSS sg13g2_fill_2
XFILLER_31_1068 VDD VSS sg13g2_fill_2
XFILLER_156_996 VDD VSS sg13g2_decap_4
XFILLER_7_973 VDD VSS sg13g2_decap_8
X_13328_ _15067_/D _13328_/A _13328_/B VDD VSS sg13g2_nor2_1
X_14709__1470 _14709_/RESET_B VDD VSS sg13g2_tiehi
XFILLER_171_944 VDD VSS sg13g2_fill_1
XFILLER_6_483 VDD VSS sg13g2_decap_8
XFILLER_143_668 VDD VSS sg13g2_decap_4
X_13259_ _13259_/Y _13259_/A _13259_/B VDD VSS sg13g2_xnor2_1
XFILLER_89_91 VDD VSS sg13g2_decap_8
XFILLER_170_476 VDD VSS sg13g2_decap_8
XFILLER_142_178 VDD VSS sg13g2_decap_8
XFILLER_97_722 VDD VSS sg13g2_decap_8
XFILLER_69_413 VDD VSS sg13g2_decap_8
XFILLER_130_329 VDD VSS sg13g2_decap_4
XFILLER_123_370 VDD VSS sg13g2_decap_8
XFILLER_9_1036 VDD VSS sg13g2_decap_8
XFILLER_97_755 VDD VSS sg13g2_decap_8
X_07820_ _07820_/X _15009_/Q _07821_/B VDD VSS sg13g2_or2_1
XFILLER_111_554 VDD VSS sg13g2_decap_8
XFILLER_97_777 VDD VSS sg13g2_fill_1
XFILLER_85_917 VDD VSS sg13g2_decap_4
X_15162__2633 _15162_/RESET_B VDD VSS sg13g2_tiehi
XFILLER_42_1120 VDD VSS sg13g2_fill_2
XFILLER_78_980 VDD VSS sg13g2_fill_1
X_14171__2008 _14171_/RESET_B VDD VSS sg13g2_tiehi
X_07751_ _07751_/Y _10869_/A _10797_/C VDD VSS sg13g2_nand2_1
XFILLER_133_1292 VDD VSS sg13g2_decap_8
XFILLER_42_1197 VDD VSS sg13g2_fill_2
X_07682_ _07682_/Y _07682_/A _11243_/C VDD VSS sg13g2_nor2_1
XFILLER_168_1344 VDD VSS sg13g2_decap_8
X_14279__1900 _14279_/RESET_B VDD VSS sg13g2_tiehi
X_09421_ _14023_/D _09984_/A0 _14023_/Q _09436_/S VDD VSS sg13g2_mux2_1
XFILLER_80_611 VDD VSS sg13g2_decap_8
XFILLER_77_1238 VDD VSS sg13g2_decap_8
X_09352_ _13956_/D _10147_/A1 _13956_/Q _09370_/S VDD VSS sg13g2_mux2_1
XFILLER_80_688 VDD VSS sg13g2_decap_8
XFILLER_21_700 VDD VSS sg13g2_decap_8
XFILLER_80_699 VDD VSS sg13g2_fill_1
X_08303_ _08303_/Y _08306_/C _08306_/B VDD VSS sg13g2_nor2_1
X_09283_ _13891_/D _13891_/Q _09316_/A0 _09301_/S VDD VSS sg13g2_mux2_1
XFILLER_20_210 VDD VSS sg13g2_decap_8
XFILLER_139_919 VDD VSS sg13g2_decap_4
XFILLER_166_705 VDD VSS sg13g2_fill_1
XFILLER_138_418 VDD VSS sg13g2_decap_8
X_08234_ _08234_/Y _08338_/B _08431_/C VDD VSS sg13g2_nor2_1
XFILLER_14_1211 VDD VSS sg13g2_decap_8
XFILLER_21_777 VDD VSS sg13g2_decap_8
X_14202__1977 _14202_/RESET_B VDD VSS sg13g2_tiehi
XFILLER_53_1293 VDD VSS sg13g2_decap_8
XFILLER_147_952 VDD VSS sg13g2_decap_4
XFILLER_20_287 VDD VSS sg13g2_decap_8
XFILLER_165_259 VDD VSS sg13g2_decap_8
X_08165_ _08166_/A _07871_/X _08163_/Y _08164_/Y VDD VSS sg13g2_o21ai_1
XFILLER_118_153 VDD VSS sg13g2_fill_2
XFILLER_134_602 VDD VSS sg13g2_decap_8
XFILLER_14_1288 VDD VSS sg13g2_decap_8
XFILLER_174_771 VDD VSS sg13g2_decap_8
XFILLER_106_304 VDD VSS sg13g2_fill_1
XFILLER_119_687 VDD VSS sg13g2_fill_2
XFILLER_134_613 VDD VSS sg13g2_fill_2
XFILLER_146_484 VDD VSS sg13g2_fill_1
XFILLER_106_326 VDD VSS sg13g2_decap_8
X_08096_ _08096_/X _08199_/C _08452_/D VDD VSS sg13g2_and2_1
XFILLER_101_1269 VDD VSS sg13g2_fill_1
XFILLER_49_1329 VDD VSS sg13g2_decap_8
XFILLER_69_28 VDD VSS sg13g2_decap_4
XFILLER_161_443 VDD VSS sg13g2_decap_8
XFILLER_133_145 VDD VSS sg13g2_fill_2
XFILLER_134_668 VDD VSS sg13g2_decap_8
XFILLER_161_454 VDD VSS sg13g2_fill_2
XFILLER_162_977 VDD VSS sg13g2_decap_8
XFILLER_161_465 VDD VSS sg13g2_decap_8
XFILLER_162_999 VDD VSS sg13g2_decap_8
X_13767__2412 _13767_/RESET_B VDD VSS sg13g2_tiehi
XFILLER_115_893 VDD VSS sg13g2_decap_4
XFILLER_138_1170 VDD VSS sg13g2_decap_8
XFILLER_0_637 VDD VSS sg13g2_decap_8
XFILLER_134_1012 VDD VSS sg13g2_decap_8
XFILLER_88_777 VDD VSS sg13g2_decap_8
X_08998_ _08998_/X _15027_/Q _15224_/Q _09009_/S VDD VSS sg13g2_mux2_1
XFILLER_25_1351 VDD VSS sg13g2_decap_8
XFILLER_102_598 VDD VSS sg13g2_decap_8
XFILLER_47_118 VDD VSS sg13g2_decap_8
X_07949_ _07950_/C _07805_/B _07949_/B _07949_/C VDD VSS sg13g2_nand3b_1
XFILLER_21_1204 VDD VSS sg13g2_decap_8
XFILLER_18_21 VDD VSS sg13g2_decap_8
X_14147__2032 _14147_/RESET_B VDD VSS sg13g2_tiehi
XFILLER_84_950 VDD VSS sg13g2_fill_1
XFILLER_1_1309 VDD VSS sg13g2_decap_8
X_10960_ _10978_/A _14759_/Q _11015_/C VDD VSS sg13g2_nor2_1
XFILLER_84_972 VDD VSS sg13g2_decap_8
XFILLER_18_98 VDD VSS sg13g2_decap_8
X_09619_ _14215_/D _10150_/A1 _14215_/Q _09634_/S VDD VSS sg13g2_mux2_1
XFILLER_55_184 VDD VSS sg13g2_decap_8
X_10891_ _10893_/A _10865_/Y _10841_/Y _10890_/Y VDD VSS sg13g2_o21ai_1
X_12630_ _12630_/X _14575_/Q _14607_/Q _14639_/Q _14671_/Q _12633_/S0 _12633_/S1 VDD
+ VSS sg13g2_mux4_1
XFILLER_12_700 VDD VSS sg13g2_decap_8
XFILLER_34_42 VDD VSS sg13g2_decap_8
XFILLER_169_532 VDD VSS sg13g2_decap_8
XFILLER_52_880 VDD VSS sg13g2_decap_8
X_12561_ _12561_/X _14570_/Q _14602_/Q _14634_/Q _14666_/Q _12562_/S0 _12562_/S1 VDD
+ VSS sg13g2_mux4_1
XFILLER_19_1155 VDD VSS sg13g2_decap_8
XFILLER_11_210 VDD VSS sg13g2_decap_8
XFILLER_15_1008 VDD VSS sg13g2_decap_8
XFILLER_106_1136 VDD VSS sg13g2_fill_1
X_14300_ _14300_/Q clkload46/A _14300_/D _14300_/RESET_B VDD VSS sg13g2_dfrbpq_1
X_11512_ _11512_/X _13731_/Q _14083_/Q _14435_/Q _14531_/Q _11715_/S0 _11715_/S1 VDD
+ VSS sg13g2_mux4_1
XFILLER_54_1079 VDD VSS sg13g2_decap_4
XFILLER_12_777 VDD VSS sg13g2_decap_8
X_12492_ _12492_/X _13733_/Q _14085_/Q _14437_/Q _14533_/Q _12655_/S0 _12655_/S1 VDD
+ VSS sg13g2_mux4_1
XFILLER_7_203 VDD VSS sg13g2_decap_8
XFILLER_11_287 VDD VSS sg13g2_decap_8
XFILLER_126_0 VDD VSS sg13g2_decap_8
X_14231_ _14231_/Q clkload33/A _14231_/D _14231_/RESET_B VDD VSS sg13g2_dfrbpq_1
XFILLER_32_1344 VDD VSS sg13g2_decap_8
XFILLER_138_963 VDD VSS sg13g2_decap_8
X_11443_ _11446_/B _11443_/A _11443_/B VDD VSS sg13g2_nor2_1
XFILLER_137_440 VDD VSS sg13g2_fill_2
XFILLER_109_153 VDD VSS sg13g2_decap_8
XFILLER_50_63 VDD VSS sg13g2_fill_2
X_14162_ _14162_/Q _14512_/CLK _14162_/D _14162_/RESET_B VDD VSS sg13g2_dfrbpq_1
XFILLER_4_910 VDD VSS sg13g2_decap_8
XFILLER_166_63 VDD VSS sg13g2_decap_8
X_11374_ _11374_/Y _11374_/A _11374_/B _11374_/C VDD VSS sg13g2_nand3_1
XFILLER_125_635 VDD VSS sg13g2_decap_8
X_13113_ _13113_/X _13172_/A _13172_/B _13172_/C VDD VSS sg13g2_and3_1
XFILLER_3_420 VDD VSS sg13g2_decap_8
X_10325_ _14801_/D _10325_/A _10325_/B _10334_/C VDD VSS sg13g2_and3_1
XFILLER_153_988 VDD VSS sg13g2_decap_8
X_14093_ _14093_/Q clkload3/A _14093_/D _14093_/RESET_B VDD VSS sg13g2_dfrbpq_1
X_15194__2769 _15194_/RESET_B VDD VSS sg13g2_tiehi
XFILLER_4_987 VDD VSS sg13g2_decap_8
XFILLER_140_627 VDD VSS sg13g2_decap_8
X_14357__1822 _14357_/RESET_B VDD VSS sg13g2_tiehi
XFILLER_106_882 VDD VSS sg13g2_decap_8
X_13044_ _13044_/Y input28/X _13609_/A _12997_/B VDD VSS sg13g2_o21ai_1
XFILLER_117_1221 VDD VSS sg13g2_decap_8
X_10256_ _14780_/D _10256_/A _10265_/D _10295_/C VDD VSS sg13g2_and3_1
XFILLER_79_733 VDD VSS sg13g2_decap_8
XFILLER_65_1153 VDD VSS sg13g2_decap_8
XFILLER_79_744 VDD VSS sg13g2_fill_2
XFILLER_3_497 VDD VSS sg13g2_decap_8
Xfanout1210 _11061_/A2 _14761_/Q VDD VSS sg13g2_buf_1
XFILLER_26_1126 VDD VSS sg13g2_decap_8
Xfanout1221 _11625_/C _12048_/A1 VDD VSS sg13g2_buf_1
Xfanout1232 _12000_/A _11747_/A VDD VSS sg13g2_buf_1
XFILLER_94_703 VDD VSS sg13g2_decap_8
X_10187_ _10187_/X hold3056/X _15194_/Q _10187_/S VDD VSS sg13g2_mux2_1
Xfanout1243 _12188_/C _12219_/S VDD VSS sg13g2_buf_1
XFILLER_79_799 VDD VSS sg13g2_decap_8
Xfanout1254 _11997_/S1 _11972_/S1 VDD VSS sg13g2_buf_1
XFILLER_66_416 VDD VSS sg13g2_fill_2
XFILLER_152_1178 VDD VSS sg13g2_decap_4
Xfanout1265 _11366_/C _11229_/S1 VDD VSS sg13g2_buf_1
Xfanout1276 _12138_/S1 _12137_/S1 VDD VSS sg13g2_buf_1
XFILLER_15_7 VDD VSS sg13g2_decap_8
Xfanout1287 _11489_/S1 _11469_/S1 VDD VSS sg13g2_buf_1
XFILLER_94_758 VDD VSS sg13g2_fill_1
X_14995_ _14995_/Q clkload60/A _14995_/D _14995_/RESET_B VDD VSS sg13g2_dfrbpq_1
Xfanout1298 _11418_/A _11854_/S0 VDD VSS sg13g2_buf_1
XFILLER_19_343 VDD VSS sg13g2_decap_8
X_13946_ _13946_/Q clkload49/A _13946_/D _13946_/RESET_B VDD VSS sg13g2_dfrbpq_1
XFILLER_34_324 VDD VSS sg13g2_decap_8
X_13877_ _13877_/Q clkload18/A _13877_/D _13877_/RESET_B VDD VSS sg13g2_dfrbpq_1
XFILLER_90_964 VDD VSS sg13g2_decap_8
XFILLER_50_806 VDD VSS sg13g2_decap_4
XFILLER_37_1200 VDD VSS sg13g2_decap_8
X_12828_ _12828_/Y _12828_/A _12828_/B VDD VSS sg13g2_nand2_1
XFILLER_37_1211 VDD VSS sg13g2_fill_2
XFILLER_15_560 VDD VSS sg13g2_decap_8
XFILLER_90_997 VDD VSS sg13g2_fill_1
XFILLER_72_1102 VDD VSS sg13g2_fill_2
XFILLER_128_1383 VDD VSS sg13g2_fill_1
XFILLER_148_705 VDD VSS sg13g2_decap_8
X_12759_ _12759_/X _13976_/Q _14008_/Q _14040_/Q _14072_/Q _12759_/S0 _12759_/S1 VDD
+ VSS sg13g2_mux4_1
X_13845__2334 _13845_/RESET_B VDD VSS sg13g2_tiehi
XFILLER_147_204 VDD VSS sg13g2_fill_1
XFILLER_72_1179 VDD VSS sg13g2_decap_8
XFILLER_124_1258 VDD VSS sg13g2_decap_4
XFILLER_129_941 VDD VSS sg13g2_decap_8
XFILLER_147_237 VDD VSS sg13g2_decap_8
XFILLER_147_248 VDD VSS sg13g2_fill_2
X_14429_ _14429_/Q _14653_/CLK _14429_/D _14429_/RESET_B VDD VSS sg13g2_dfrbpq_1
XFILLER_156_771 VDD VSS sg13g2_decap_8
XFILLER_128_473 VDD VSS sg13g2_decap_8
XFILLER_7_770 VDD VSS sg13g2_decap_8
XFILLER_115_101 VDD VSS sg13g2_fill_2
Xmax_cap412 _12791_/B2 _12348_/Y VDD VSS sg13g2_buf_2
XFILLER_6_280 VDD VSS sg13g2_decap_8
XFILLER_115_145 VDD VSS sg13g2_decap_8
X_09970_ _14554_/D _14554_/Q _09970_/A1 _09970_/S VDD VSS sg13g2_mux2_1
XFILLER_171_763 VDD VSS sg13g2_fill_1
XFILLER_118_1007 VDD VSS sg13g2_decap_8
XFILLER_143_465 VDD VSS sg13g2_decap_8
XFILLER_171_774 VDD VSS sg13g2_fill_2
XFILLER_41_0 VDD VSS sg13g2_decap_8
XFILLER_170_273 VDD VSS sg13g2_decap_8
X_08921_ _08921_/X _15043_/Q _14947_/Q _10757_/A VDD VSS sg13g2_mux2_1
XFILLER_171_796 VDD VSS sg13g2_decap_8
XFILLER_103_329 VDD VSS sg13g2_decap_4
XFILLER_115_189 VDD VSS sg13g2_fill_2
XFILLER_157_1089 VDD VSS sg13g2_fill_2
XFILLER_170_1201 VDD VSS sg13g2_decap_8
XFILLER_44_1215 VDD VSS sg13g2_decap_8
XFILLER_170_1223 VDD VSS sg13g2_decap_8
XFILLER_83_1275 VDD VSS sg13g2_decap_8
X_08852_ _08852_/Y _10691_/S _14930_/Q VDD VSS sg13g2_nor2b_1
XFILLER_58_928 VDD VSS sg13g2_decap_4
XFILLER_112_885 VDD VSS sg13g2_fill_1
XFILLER_29_107 VDD VSS sg13g2_fill_1
X_07803_ _08481_/A _07950_/A _07949_/B VDD VSS sg13g2_and2_1
XFILLER_85_736 VDD VSS sg13g2_decap_8
XFILLER_170_1289 VDD VSS sg13g2_decap_8
X_08783_ _13679_/D _08728_/Y _08782_/Y _08781_/Y VDD VSS sg13g2_a21oi_1
X_07734_ _07735_/D wire649/X _07734_/B _07734_/C VDD VSS sg13g2_nand3_1
XFILLER_77_1002 VDD VSS sg13g2_decap_8
XFILLER_65_471 VDD VSS sg13g2_decap_8
XFILLER_37_173 VDD VSS sg13g2_decap_4
X_07665_ _07665_/X _13508_/B _08721_/S VDD VSS sg13g2_or2_1
XFILLER_111_14 VDD VSS sg13g2_decap_8
XFILLER_53_644 VDD VSS sg13g2_decap_8
XFILLER_26_869 VDD VSS sg13g2_decap_8
XFILLER_0_1353 VDD VSS sg13g2_decap_8
X_09404_ _14007_/D _10166_/A1 _14007_/Q _09406_/S VDD VSS sg13g2_mux2_1
XFILLER_38_1019 VDD VSS sg13g2_decap_8
XFILLER_20_1281 VDD VSS sg13g2_decap_8
XFILLER_164_1038 VDD VSS sg13g2_fill_1
XFILLER_81_997 VDD VSS sg13g2_decap_8
X_09335_ _13942_/D _09768_/A1 _13942_/Q _09338_/S VDD VSS sg13g2_mux2_1
XFILLER_139_705 VDD VSS sg13g2_fill_1
X_14435__1744 _14435_/RESET_B VDD VSS sg13g2_tiehi
XFILLER_51_1208 VDD VSS sg13g2_decap_4
XFILLER_142_1336 VDD VSS sg13g2_fill_2
X_09266_ _13875_/D _13875_/Q _09332_/A0 _09271_/S VDD VSS sg13g2_mux2_1
XFILLER_142_1358 VDD VSS sg13g2_decap_8
XFILLER_21_574 VDD VSS sg13g2_decap_8
XFILLER_166_546 VDD VSS sg13g2_decap_8
XFILLER_138_248 VDD VSS sg13g2_fill_2
X_08217_ _08217_/X _08544_/A _08452_/C VDD VSS sg13g2_and2_1
X_09197_ _13813_/D _13813_/Q _10164_/A1 _09201_/S VDD VSS sg13g2_mux2_1
XFILLER_5_707 VDD VSS sg13g2_decap_8
XFILLER_105_1191 VDD VSS sg13g2_decap_8
XFILLER_107_613 VDD VSS sg13g2_decap_8
XFILLER_135_922 VDD VSS sg13g2_decap_8
XFILLER_14_1085 VDD VSS sg13g2_decap_8
XFILLER_153_229 VDD VSS sg13g2_decap_8
X_08148_ _08688_/A _08242_/A _08194_/B VDD VSS sg13g2_nand2_1
XFILLER_88_1142 VDD VSS sg13g2_decap_8
XFILLER_4_217 VDD VSS sg13g2_decap_8
XFILLER_88_1153 VDD VSS sg13g2_fill_2
XFILLER_162_730 VDD VSS sg13g2_fill_1
XFILLER_101_1077 VDD VSS sg13g2_decap_8
XFILLER_134_454 VDD VSS sg13g2_decap_8
XFILLER_162_763 VDD VSS sg13g2_decap_8
XFILLER_135_988 VDD VSS sg13g2_decap_8
X_08079_ _08079_/X _08397_/B _08009_/X _08079_/S VDD VSS sg13g2_mux2_1
XFILLER_20_77 VDD VSS sg13g2_decap_8
X_10110_ _14688_/D _10143_/A1 _14688_/Q _10135_/S VDD VSS sg13g2_mux2_1
XFILLER_1_924 VDD VSS sg13g2_decap_8
XFILLER_106_189 VDD VSS sg13g2_fill_2
XFILLER_171_1009 VDD VSS sg13g2_fill_2
XFILLER_136_77 VDD VSS sg13g2_decap_8
X_11090_ _11092_/A _11125_/A _10754_/X _11088_/A _11087_/X _11058_/Y VDD VSS sg13g2_a221oi_1
XFILLER_115_690 VDD VSS sg13g2_decap_8
XFILLER_136_88 VDD VSS sg13g2_fill_1
XFILLER_150_969 VDD VSS sg13g2_decap_8
XFILLER_0_434 VDD VSS sg13g2_decap_8
XFILLER_62_1326 VDD VSS sg13g2_decap_8
X_10041_ _14622_/D _10074_/A0 _14622_/Q _10063_/S VDD VSS sg13g2_mux2_1
XFILLER_96_59 VDD VSS sg13g2_decap_8
XFILLER_130_660 VDD VSS sg13g2_decap_8
XFILLER_48_405 VDD VSS sg13g2_decap_8
XFILLER_29_42 VDD VSS sg13g2_decap_8
XFILLER_102_373 VDD VSS sg13g2_decap_8
XFILLER_152_21 VDD VSS sg13g2_decap_8
XFILLER_75_202 VDD VSS sg13g2_fill_1
X_13923__2256 _13923_/RESET_B VDD VSS sg13g2_tiehi
X_14683__1496 _14683_/RESET_B VDD VSS sg13g2_tiehi
XFILLER_21_1001 VDD VSS sg13g2_decap_8
XFILLER_5_1253 VDD VSS sg13g2_decap_8
XFILLER_57_950 VDD VSS sg13g2_decap_8
X_13800_ _13800_/Q _14644_/CLK _13800_/D _13800_/RESET_B VDD VSS sg13g2_dfrbpq_1
X_14780_ _14780_/Q clkload51/A _14780_/D _14780_/RESET_B VDD VSS sg13g2_dfrbpq_1
X_11992_ _11992_/X _14385_/Q _14417_/Q _14481_/Q _14513_/Q _11993_/S0 _11995_/S1 VDD
+ VSS sg13g2_mux4_1
XFILLER_28_140 VDD VSS sg13g2_fill_2
XFILLER_1_1106 VDD VSS sg13g2_decap_8
X_13731_ _13731_/Q clkload19/A _13731_/D _13731_/RESET_B VDD VSS sg13g2_dfrbpq_1
X_10943_ _11004_/A _14758_/Q _10954_/C VDD VSS sg13g2_xnor2_1
XFILLER_90_238 VDD VSS sg13g2_decap_4
XFILLER_21_1078 VDD VSS sg13g2_decap_8
XFILLER_17_847 VDD VSS sg13g2_decap_8
XFILLER_45_63 VDD VSS sg13g2_decap_8
XFILLER_16_357 VDD VSS sg13g2_decap_8
XFILLER_44_666 VDD VSS sg13g2_decap_8
XFILLER_32_806 VDD VSS sg13g2_decap_4
X_13662_ _13662_/Q _15213_/CLK _13662_/D _13662_/RESET_B VDD VSS sg13g2_dfrbpq_1
X_10874_ _14932_/D _10873_/Y _10872_/Y _10862_/Y VDD VSS sg13g2_o21ai_1
XFILLER_72_997 VDD VSS sg13g2_decap_8
XFILLER_71_474 VDD VSS sg13g2_decap_4
XFILLER_71_496 VDD VSS sg13g2_decap_8
X_12613_ _12613_/X _14126_/Q _14158_/Q _14190_/Q _14222_/Q _12614_/S0 _12614_/S1 VDD
+ VSS sg13g2_mux4_1
X_13593_ _13593_/Y _13593_/A _13593_/B VDD VSS sg13g2_nor2_1
XFILLER_31_349 VDD VSS sg13g2_decap_8
XFILLER_24_390 VDD VSS sg13g2_decap_8
XFILLER_40_850 VDD VSS sg13g2_decap_8
XFILLER_129_204 VDD VSS sg13g2_fill_2
X_12544_ _12544_/X _14697_/Q _14729_/Q _13769_/Q _13801_/Q _12546_/S0 _12546_/S1 VDD
+ VSS sg13g2_mux4_1
XFILLER_12_574 VDD VSS sg13g2_decap_8
XFILLER_157_546 VDD VSS sg13g2_decap_4
XFILLER_61_84 VDD VSS sg13g2_decap_8
XFILLER_157_579 VDD VSS sg13g2_decap_8
X_12475_ _12475_/X _14372_/Q _14404_/Q _14468_/Q _14500_/Q _12727_/S0 _12727_/S1 VDD
+ VSS sg13g2_mux4_1
XFILLER_8_567 VDD VSS sg13g2_decap_8
XFILLER_32_1152 VDD VSS sg13g2_decap_8
XFILLER_172_505 VDD VSS sg13g2_decap_8
XFILLER_138_782 VDD VSS sg13g2_decap_8
X_14214_ _14214_/Q clkload11/A _14214_/D _14214_/RESET_B VDD VSS sg13g2_dfrbpq_1
X_11426_ _11426_/Y _12859_/A _12338_/A2 _07684_/B VDD VSS sg13g2_a21oi_1
XFILLER_6_35 VDD VSS sg13g2_decap_8
XANTENNA_6 _09408_/Y VDD VSS sg13g2_antennanp
X_15194_ _15194_/Q clkload65/A _15194_/D _15194_/RESET_B VDD VSS sg13g2_dfrbpq_1
XFILLER_126_977 VDD VSS sg13g2_decap_8
X_14145_ _14145_/Q _14681_/CLK _14145_/D _14145_/RESET_B VDD VSS sg13g2_dfrbpq_1
X_11357_ _11357_/Y _11374_/C _11353_/X _11356_/Y VDD VSS sg13g2_o21ai_1
XFILLER_99_817 VDD VSS sg13g2_decap_4
XFILLER_152_251 VDD VSS sg13g2_decap_4
XFILLER_141_936 VDD VSS sg13g2_decap_8
XFILLER_152_273 VDD VSS sg13g2_fill_2
X_10308_ _14796_/D _14796_/Q _10327_/B _10307_/Y VDD VSS sg13g2_a21oi_1
XFILLER_4_784 VDD VSS sg13g2_decap_8
XFILLER_119_1349 VDD VSS sg13g2_fill_2
XFILLER_141_958 VDD VSS sg13g2_fill_2
X_14076_ _14076_/Q clkload44/A _14076_/D _14076_/RESET_B VDD VSS sg13g2_dfrbpq_1
X_11288_ _11288_/Y _11288_/A _15217_/Q VDD VSS sg13g2_nor2b_1
XFILLER_79_541 VDD VSS sg13g2_decap_8
XFILLER_3_294 VDD VSS sg13g2_decap_8
X_13027_ _13027_/Y _13026_/Y _13271_/C _13042_/B VDD VSS sg13g2_nand3b_1
X_10239_ _14774_/D _10237_/B _10234_/Y _10238_/Y VDD VSS sg13g2_a21oi_1
XFILLER_121_660 VDD VSS sg13g2_decap_8
Xfanout1040 _08668_/A _14993_/Q VDD VSS sg13g2_buf_1
Xfanout1051 _08154_/A _08161_/A2 VDD VSS sg13g2_buf_1
Xfanout1062 _08124_/S1 _08686_/S1 VDD VSS sg13g2_buf_1
XFILLER_39_438 VDD VSS sg13g2_decap_4
Xfanout1073 _08054_/B _08083_/S0 VDD VSS sg13g2_buf_1
X_14513__1666 _14513_/RESET_B VDD VSS sg13g2_tiehi
Xfanout1084 _08692_/B _08048_/B VDD VSS sg13g2_buf_1
Xfanout1095 _08012_/B _12152_/A VDD VSS sg13g2_buf_1
XFILLER_130_1240 VDD VSS sg13g2_decap_8
XFILLER_82_717 VDD VSS sg13g2_decap_8
XFILLER_19_140 VDD VSS sg13g2_decap_8
X_14978_ _14978_/Q _14979_/CLK _14978_/D _14978_/RESET_B VDD VSS sg13g2_dfrbpq_1
XFILLER_48_983 VDD VSS sg13g2_decap_8
XFILLER_63_920 VDD VSS sg13g2_decap_8
XFILLER_130_1284 VDD VSS sg13g2_decap_8
XFILLER_81_238 VDD VSS sg13g2_decap_8
XFILLER_130_1295 VDD VSS sg13g2_fill_1
X_13929_ _13929_/Q _14745_/CLK _13929_/D _13929_/RESET_B VDD VSS sg13g2_dfrbpq_1
X_14767__2946 _14767_/RESET_B VDD VSS sg13g2_tiehi
XFILLER_50_614 VDD VSS sg13g2_decap_8
X_09120_ _09120_/Y _15243_/Q _09154_/B VDD VSS sg13g2_nand2b_1
XFILLER_124_1022 VDD VSS sg13g2_decap_4
XFILLER_148_524 VDD VSS sg13g2_decap_4
XFILLER_89_0 VDD VSS sg13g2_decap_8
XFILLER_37_1085 VDD VSS sg13g2_decap_4
X_15094__2793 _15094_/RESET_B VDD VSS sg13g2_tiehi
XFILLER_31_894 VDD VSS sg13g2_fill_2
X_09051_ _09051_/Y _09051_/A1 _10720_/B _09050_/X VDD VSS sg13g2_o21ai_1
XFILLER_15_1372 VDD VSS sg13g2_decap_8
X_08002_ _08002_/Y _08037_/A _08037_/B _08039_/A VDD VSS sg13g2_a21oi_1
XFILLER_11_1225 VDD VSS sg13g2_decap_8
XFILLER_159_1118 VDD VSS sg13g2_decap_8
XFILLER_50_1285 VDD VSS sg13g2_fill_2
XFILLER_117_944 VDD VSS sg13g2_fill_2
XFILLER_144_741 VDD VSS sg13g2_decap_8
XFILLER_128_292 VDD VSS sg13g2_decap_8
XFILLER_143_251 VDD VSS sg13g2_decap_8
XFILLER_172_1329 VDD VSS sg13g2_decap_8
XFILLER_171_593 VDD VSS sg13g2_decap_8
X_09953_ _14537_/D _14537_/Q _09953_/A1 _09969_/S VDD VSS sg13g2_mux2_1
XFILLER_106_14 VDD VSS sg13g2_decap_8
X_08904_ _08904_/X _08903_/X _11843_/A _08904_/S VDD VSS sg13g2_mux2_1
XFILLER_58_703 VDD VSS sg13g2_decap_8
X_09884_ _14470_/D _09884_/A0 _14470_/Q _09895_/S VDD VSS sg13g2_mux2_1
XFILLER_112_671 VDD VSS sg13g2_decap_8
XFILLER_97_382 VDD VSS sg13g2_fill_2
X_08835_ _08842_/S _13600_/A _08835_/B VDD VSS sg13g2_nand2_1
XFILLER_22_1310 VDD VSS sg13g2_decap_8
XFILLER_111_192 VDD VSS sg13g2_decap_8
XFILLER_79_1119 VDD VSS sg13g2_decap_4
XFILLER_73_717 VDD VSS sg13g2_decap_8
XFILLER_61_1381 VDD VSS sg13g2_fill_2
X_08766_ _08766_/Y _13674_/Q _08775_/B VDD VSS sg13g2_nor2_1
XFILLER_73_728 VDD VSS sg13g2_fill_1
XFILLER_39_983 VDD VSS sg13g2_decap_8
XFILLER_122_35 VDD VSS sg13g2_decap_4
XFILLER_85_599 VDD VSS sg13g2_decap_8
X_07717_ wire660/A _15102_/Q _15101_/Q _15094_/Q _15093_/Q VDD VSS sg13g2_nor4_1
XFILLER_72_238 VDD VSS sg13g2_decap_8
XFILLER_26_633 VDD VSS sg13g2_decap_8
X_08697_ _08697_/Y _08697_/A _08697_/B VDD VSS sg13g2_nand2_1
XFILLER_167_7 VDD VSS sg13g2_decap_8
XFILLER_82_28 VDD VSS sg13g2_decap_4
XFILLER_0_1150 VDD VSS sg13g2_decap_8
X_07648_ _07648_/Y _14826_/Q VDD VSS sg13g2_inv_1
XFILLER_25_154 VDD VSS sg13g2_decap_8
XFILLER_26_688 VDD VSS sg13g2_decap_8
X_14668__1511 _14668_/RESET_B VDD VSS sg13g2_tiehi
XFILLER_139_502 VDD VSS sg13g2_decap_4
XFILLER_15_77 VDD VSS sg13g2_decap_8
XFILLER_55_1163 VDD VSS sg13g2_decap_8
XFILLER_142_1122 VDD VSS sg13g2_fill_2
X_09318_ _13925_/D _09318_/A0 _13925_/Q _09330_/S VDD VSS sg13g2_mux2_1
XFILLER_139_535 VDD VSS sg13g2_decap_8
X_10590_ _10606_/B _14874_/Q _10649_/B VDD VSS sg13g2_nand2_1
X_14097__2082 _14097_/RESET_B VDD VSS sg13g2_tiehi
XFILLER_21_371 VDD VSS sg13g2_decap_8
XFILLER_166_343 VDD VSS sg13g2_decap_8
XFILLER_16_1169 VDD VSS sg13g2_decap_8
X_14812__2901 _14812_/RESET_B VDD VSS sg13g2_tiehi
XFILLER_51_1049 VDD VSS sg13g2_fill_2
X_09249_ _13858_/D _13858_/Q _10145_/A1 _09272_/S VDD VSS sg13g2_mux2_1
XFILLER_31_21 VDD VSS sg13g2_decap_8
XFILLER_142_1199 VDD VSS sg13g2_decap_8
XFILLER_5_504 VDD VSS sg13g2_decap_8
XFILLER_147_21 VDD VSS sg13g2_decap_8
X_12260_ _12260_/X _12246_/B _12259_/X _12258_/Y VDD VSS sg13g2_a21o_1
X_15036__2551 _15036_/RESET_B VDD VSS sg13g2_tiehi
X_11211_ _11211_/X _14107_/Q _14139_/Q _11212_/S VDD VSS sg13g2_mux2_1
XFILLER_31_98 VDD VSS sg13g2_decap_8
X_12191_ _12192_/B _12188_/Y _12190_/Y _12265_/B1 VDD VSS sg13g2_a21oi_1
XFILLER_150_722 VDD VSS sg13g2_decap_8
XFILLER_123_947 VDD VSS sg13g2_decap_8
XFILLER_150_733 VDD VSS sg13g2_fill_2
Xoutput43 mem_axi_araddr[14] _16867_/A VDD VSS sg13g2_buf_1
X_11142_ _14951_/D _11141_/X _11140_/Y _11133_/Y VDD VSS sg13g2_o21ai_1
XFILLER_122_435 VDD VSS sg13g2_decap_8
XFILLER_123_958 VDD VSS sg13g2_fill_1
XFILLER_1_721 VDD VSS sg13g2_decap_8
XFILLER_123_969 VDD VSS sg13g2_decap_8
Xoutput54 mem_axi_araddr[25] _16878_/A VDD VSS sg13g2_buf_1
Xoutput65 mem_axi_araddr[6] _16859_/A VDD VSS sg13g2_buf_1
XFILLER_62_1101 VDD VSS sg13g2_fill_2
Xoutput76 mem_axi_awaddr[15] _16868_/X VDD VSS sg13g2_buf_1
XFILLER_0_231 VDD VSS sg13g2_decap_8
XFILLER_163_42 VDD VSS sg13g2_decap_8
Xoutput87 mem_axi_awaddr[26] _16879_/X VDD VSS sg13g2_buf_1
XFILLER_150_788 VDD VSS sg13g2_decap_8
X_11073_ _14946_/D _14946_/Q _11048_/B _11072_/Y VDD VSS sg13g2_a21o_1
XFILLER_27_1243 VDD VSS sg13g2_decap_8
XFILLER_103_660 VDD VSS sg13g2_decap_8
Xoutput98 mem_axi_awaddr[7] _16860_/X VDD VSS sg13g2_buf_1
XFILLER_62_1134 VDD VSS sg13g2_fill_2
Xhold3170 hold3170/X _15166_/Q VDD VSS sg13g2_dlygate4sd3_1
XFILLER_7_1337 VDD VSS sg13g2_decap_8
XFILLER_1_798 VDD VSS sg13g2_decap_8
X_14901_ _14901_/Q clkload56/A _14901_/D _14901_/RESET_B VDD VSS sg13g2_dfrbpq_1
X_10024_ _14606_/D _10090_/A0 _14606_/Q _10030_/S VDD VSS sg13g2_mux2_1
XFILLER_102_170 VDD VSS sg13g2_decap_8
XFILLER_23_1118 VDD VSS sg13g2_decap_8
X_14832_ _14832_/Q _15064_/CLK _14832_/D _14832_/RESET_B VDD VSS sg13g2_dfrbpq_1
XFILLER_5_1050 VDD VSS sg13g2_decap_8
XFILLER_56_51 VDD VSS sg13g2_fill_1
XFILLER_45_931 VDD VSS sg13g2_fill_1
X_14763_ _14763_/Q clkload71/A _14763_/D _14763_/RESET_B VDD VSS sg13g2_dfrbpq_1
XFILLER_17_644 VDD VSS sg13g2_decap_8
X_11975_ _11975_/Y _11975_/A _11975_/B VDD VSS sg13g2_nor2_1
XFILLER_16_154 VDD VSS sg13g2_decap_8
X_13714_ _16876_/A clkload41/A _13714_/D _13714_/RESET_B VDD VSS sg13g2_dfrbpq_1
X_10926_ _10926_/X _10926_/A _10926_/B _10956_/C VDD VSS sg13g2_and3_1
XFILLER_60_923 VDD VSS sg13g2_fill_1
X_14694_ _14694_/Q clkload11/A _14694_/D _14694_/RESET_B VDD VSS sg13g2_dfrbpq_1
X_13645_ _13753_/D _13645_/A VDD VSS sg13g2_buf_1
X_10857_ _10857_/Y _10857_/A _10857_/B VDD VSS sg13g2_xnor2_1
XFILLER_38_1361 VDD VSS sg13g2_decap_8
X_14763__2952 _14763_/RESET_B VDD VSS sg13g2_tiehi
XFILLER_13_861 VDD VSS sg13g2_decap_8
XFILLER_31_168 VDD VSS sg13g2_decap_8
XFILLER_82_7 VDD VSS sg13g2_decap_8
X_13576_ _15157_/D _13584_/B _13574_/Y _13575_/Y VDD VSS sg13g2_a21oi_1
X_10788_ _11199_/B _07614_/Y _09155_/Y _10788_/S VDD VSS sg13g2_mux2_1
XFILLER_12_371 VDD VSS sg13g2_decap_8
XFILLER_121_1206 VDD VSS sg13g2_fill_1
XFILLER_9_854 VDD VSS sg13g2_decap_8
X_12527_ _15001_/D _12527_/A _12527_/B VDD VSS sg13g2_nor2_1
XFILLER_160_1288 VDD VSS sg13g2_fill_1
XFILLER_145_516 VDD VSS sg13g2_decap_8
XFILLER_157_376 VDD VSS sg13g2_decap_8
XFILLER_8_364 VDD VSS sg13g2_decap_8
X_15246_ _15246_/Q _15247_/CLK _15246_/D _15246_/RESET_B VDD VSS sg13g2_dfrbpq_1
X_12458_ _12471_/A _10213_/A _07737_/B _08263_/B VDD VSS sg13g2_a21oi_1
XFILLER_172_368 VDD VSS sg13g2_decap_8
X_11409_ _11409_/Y _11804_/A _14463_/Q VDD VSS sg13g2_nand2b_1
X_15177_ _15177_/Q clkload66/A _15177_/D _15177_/RESET_B VDD VSS sg13g2_dfrbpq_1
X_12389_ _12389_/X _14686_/Q _14718_/Q _13758_/Q _13790_/Q _12396_/S0 _12396_/S1 VDD
+ VSS sg13g2_mux4_1
XFILLER_172_379 VDD VSS sg13g2_decap_8
XFILLER_119_1135 VDD VSS sg13g2_decap_8
X_14128_ _14128_/Q clkload7/A _14128_/D _14128_/RESET_B VDD VSS sg13g2_dfrbpq_1
XFILLER_4_581 VDD VSS sg13g2_decap_8
XFILLER_114_969 VDD VSS sg13g2_fill_1
XFILLER_119_1157 VDD VSS sg13g2_decap_8
XFILLER_141_755 VDD VSS sg13g2_decap_4
X_13795__2384 _13795_/RESET_B VDD VSS sg13g2_tiehi
XFILLER_101_619 VDD VSS sg13g2_fill_2
XFILLER_119_1179 VDD VSS sg13g2_fill_2
XFILLER_98_168 VDD VSS sg13g2_decap_8
X_14059_ _14059_/Q clkload1/A _14059_/D _14059_/RESET_B VDD VSS sg13g2_dfrbpq_1
X_14746__1433 _14746_/RESET_B VDD VSS sg13g2_tiehi
XFILLER_79_371 VDD VSS sg13g2_decap_8
XFILLER_171_1362 VDD VSS sg13g2_decap_8
XFILLER_79_382 VDD VSS sg13g2_fill_1
XFILLER_171_1373 VDD VSS sg13g2_fill_2
XFILLER_67_544 VDD VSS sg13g2_decap_8
XFILLER_94_341 VDD VSS sg13g2_decap_8
X_08620_ _08621_/C _08635_/A1 _08620_/A1 _08620_/A2 _08620_/A3 _08686_/S0 _08686_/S1
+ VDD VSS sg13g2_mux4_1
XFILLER_67_577 VDD VSS sg13g2_decap_8
XFILLER_55_717 VDD VSS sg13g2_decap_8
XFILLER_95_897 VDD VSS sg13g2_decap_8
XFILLER_54_216 VDD VSS sg13g2_decap_8
X_08551_ _08551_/X _08567_/B _08531_/B _07956_/Y VDD VSS sg13g2_a21o_1
XFILLER_82_558 VDD VSS sg13g2_decap_8
XFILLER_39_1125 VDD VSS sg13g2_fill_1
XFILLER_36_986 VDD VSS sg13g2_decap_8
X_08482_ _15237_/D _08039_/A _08481_/X _08475_/Y VDD VSS sg13g2_o21ai_1
XFILLER_36_997 VDD VSS sg13g2_fill_2
XFILLER_126_1117 VDD VSS sg13g2_decap_8
XFILLER_165_1166 VDD VSS sg13g2_decap_8
XFILLER_74_1049 VDD VSS sg13g2_decap_8
XFILLER_91_1330 VDD VSS sg13g2_decap_8
XFILLER_50_433 VDD VSS sg13g2_decap_8
XFILLER_10_308 VDD VSS sg13g2_decap_8
XFILLER_50_477 VDD VSS sg13g2_decap_8
XFILLER_22_168 VDD VSS sg13g2_decap_8
X_09103_ _09150_/B _13142_/A _14915_/Q _09103_/C _09103_/D VDD VSS sg13g2_and4_1
XFILLER_13_1309 VDD VSS sg13g2_decap_8
XFILLER_148_343 VDD VSS sg13g2_decap_8
XFILLER_164_814 VDD VSS sg13g2_decap_8
XFILLER_30_190 VDD VSS sg13g2_fill_1
XFILLER_164_836 VDD VSS sg13g2_decap_8
X_09034_ _09034_/X _15033_/Q _15230_/Q _09100_/B VDD VSS sg13g2_mux2_1
XFILLER_11_1022 VDD VSS sg13g2_decap_8
XFILLER_163_357 VDD VSS sg13g2_decap_8
XFILLER_102_1172 VDD VSS sg13g2_decap_8
XFILLER_89_1270 VDD VSS sg13g2_fill_1
XFILLER_105_903 VDD VSS sg13g2_fill_1
XFILLER_116_240 VDD VSS sg13g2_decap_8
XFILLER_85_1123 VDD VSS sg13g2_decap_8
XFILLER_2_518 VDD VSS sg13g2_decap_8
XFILLER_116_262 VDD VSS sg13g2_decap_8
XFILLER_105_947 VDD VSS sg13g2_fill_2
XFILLER_117_35 VDD VSS sg13g2_decap_8
XFILLER_11_1099 VDD VSS sg13g2_decap_8
XFILLER_137_1224 VDD VSS sg13g2_fill_1
XFILLER_132_744 VDD VSS sg13g2_decap_8
XFILLER_85_1167 VDD VSS sg13g2_decap_8
XFILLER_132_755 VDD VSS sg13g2_fill_1
XFILLER_78_809 VDD VSS sg13g2_decap_8
XFILLER_171_390 VDD VSS sg13g2_decap_8
Xfanout800 _12705_/S0 _12789_/S0 VDD VSS sg13g2_buf_1
XFILLER_89_146 VDD VSS sg13g2_decap_8
XFILLER_77_28 VDD VSS sg13g2_decap_8
X_14385__1794 _14385_/RESET_B VDD VSS sg13g2_tiehi
Xfanout811 _12645_/S1 fanout812/X VDD VSS sg13g2_buf_1
Xfanout822 _12617_/S1 _12352_/S1 VDD VSS sg13g2_buf_1
X_09936_ _14521_/D _14521_/Q _09936_/A1 _09936_/S VDD VSS sg13g2_mux2_1
Xfanout833 _12717_/S1 fanout846/X VDD VSS sg13g2_buf_1
Xfanout844 _12742_/S1 _12437_/S1 VDD VSS sg13g2_buf_1
Xfanout855 _12562_/S0 fanout864/X VDD VSS sg13g2_buf_1
Xfanout866 _12592_/S0 _12614_/S0 VDD VSS sg13g2_buf_1
Xfanout877 _12782_/S0 fanout897/X VDD VSS sg13g2_buf_1
X_09867_ _14454_/D _14454_/Q _10165_/A1 _09867_/S VDD VSS sg13g2_mux2_1
XFILLER_97_190 VDD VSS sg13g2_decap_8
Xfanout888 _12771_/S0 _12773_/S0 VDD VSS sg13g2_buf_1
XFILLER_100_652 VDD VSS sg13g2_fill_1
Xfanout899 _13048_/B _12870_/A2 VDD VSS sg13g2_buf_1
XFILLER_46_717 VDD VSS sg13g2_decap_4
X_08818_ _08818_/Y _13690_/Q _08818_/B VDD VSS sg13g2_nor2_1
X_14005__2174 _14005_/RESET_B VDD VSS sg13g2_tiehi
X_09798_ _14387_/D _10162_/A1 _14387_/Q _09800_/S VDD VSS sg13g2_mux2_1
XFILLER_85_385 VDD VSS sg13g2_fill_2
XFILLER_26_21 VDD VSS sg13g2_decap_8
X_08749_ _08749_/Y _13668_/Q _08775_/B VDD VSS sg13g2_nor2_1
XFILLER_22_1184 VDD VSS sg13g2_decap_8
XFILLER_27_964 VDD VSS sg13g2_decap_8
XFILLER_54_750 VDD VSS sg13g2_decap_4
XFILLER_2_1267 VDD VSS sg13g2_decap_8
X_11760_ _11761_/B _11760_/A _11760_/B _11760_/C VDD VSS sg13g2_nand3_1
XFILLER_27_986 VDD VSS sg13g2_fill_1
XFILLER_148_1353 VDD VSS sg13g2_fill_1
XFILLER_53_260 VDD VSS sg13g2_fill_2
X_10711_ _14905_/D _10999_/B1 _10954_/A _10708_/Y VDD VSS sg13g2_o21ai_1
XFILLER_26_98 VDD VSS sg13g2_decap_8
XFILLER_14_658 VDD VSS sg13g2_decap_8
X_11691_ _11693_/A _11692_/A _14184_/Q VDD VSS sg13g2_nand2b_1
XFILLER_42_978 VDD VSS sg13g2_decap_8
XFILLER_139_310 VDD VSS sg13g2_decap_8
XFILLER_13_168 VDD VSS sg13g2_decap_8
X_13430_ _15097_/D _15097_/Q _13470_/A2 _13429_/Y VDD VSS sg13g2_a21o_1
X_10642_ _10643_/C _14888_/Q _14887_/Q _10642_/C VDD VSS sg13g2_and3_1
XFILLER_42_42 VDD VSS sg13g2_decap_8
XFILLER_158_42 VDD VSS sg13g2_decap_8
XFILLER_166_140 VDD VSS sg13g2_decap_8
X_13361_ _13361_/Y _13494_/B _13429_/A _13361_/C VDD VSS sg13g2_nor3_1
X_10573_ _10577_/C _10647_/C _10591_/C _14870_/Q VDD VSS sg13g2_a21oi_1
XFILLER_10_875 VDD VSS sg13g2_decap_8
X_15100_ _15100_/Q clkload68/A _15100_/D _15100_/RESET_B VDD VSS sg13g2_dfrbpq_1
XFILLER_5_301 VDD VSS sg13g2_decap_8
X_12312_ _12312_/Y _12321_/A1 _14618_/Q _12312_/B1 VDD VSS sg13g2_a21oi_1
X_13292_ _15055_/D _15055_/Q _07710_/Y _07694_/Y VDD VSS sg13g2_a21o_1
XFILLER_108_730 VDD VSS sg13g2_decap_8
XFILLER_6_868 VDD VSS sg13g2_decap_8
XFILLER_170_817 VDD VSS sg13g2_decap_8
X_15031_ _15031_/Q clkload56/A _15031_/D _15031_/RESET_B VDD VSS sg13g2_dfrbpq_1
X_12243_ _12243_/Y _12257_/A1 _14680_/Q _12015_/B VDD VSS sg13g2_a21oi_1
XFILLER_123_700 VDD VSS sg13g2_decap_4
XFILLER_68_1343 VDD VSS sg13g2_decap_8
XFILLER_107_262 VDD VSS sg13g2_decap_4
XFILLER_5_378 VDD VSS sg13g2_decap_8
XFILLER_123_722 VDD VSS sg13g2_decap_8
XFILLER_68_1365 VDD VSS sg13g2_decap_8
XFILLER_123_733 VDD VSS sg13g2_fill_2
X_12174_ _12174_/Y _12174_/A _12174_/B VDD VSS sg13g2_nor2_1
XFILLER_162_390 VDD VSS sg13g2_decap_8
XFILLER_29_1338 VDD VSS sg13g2_decap_8
XFILLER_123_766 VDD VSS sg13g2_decap_8
XFILLER_3_14 VDD VSS sg13g2_decap_8
XFILLER_122_254 VDD VSS sg13g2_decap_8
X_14215__1964 _14215_/RESET_B VDD VSS sg13g2_tiehi
X_11125_ _11128_/B _11125_/A _11147_/A VDD VSS sg13g2_xnor2_1
XFILLER_122_265 VDD VSS sg13g2_fill_1
XFILLER_95_105 VDD VSS sg13g2_fill_2
XFILLER_68_319 VDD VSS sg13g2_decap_8
XFILLER_122_276 VDD VSS sg13g2_decap_8
XFILLER_27_1040 VDD VSS sg13g2_decap_8
XFILLER_89_691 VDD VSS sg13g2_fill_1
XFILLER_7_1134 VDD VSS sg13g2_decap_8
X_11056_ _11056_/Y _11044_/C _11068_/C _11056_/B1 VDD VSS sg13g2_o21ai_1
XFILLER_1_595 VDD VSS sg13g2_decap_8
XFILLER_77_864 VDD VSS sg13g2_decap_8
XFILLER_49_555 VDD VSS sg13g2_decap_8
XFILLER_153_1092 VDD VSS sg13g2_decap_8
X_10007_ _14589_/D _10107_/A0 _14589_/Q _10030_/S VDD VSS sg13g2_mux2_1
XFILLER_92_801 VDD VSS sg13g2_fill_2
XFILLER_77_875 VDD VSS sg13g2_fill_2
XFILLER_92_823 VDD VSS sg13g2_decap_8
XFILLER_40_1240 VDD VSS sg13g2_fill_1
XFILLER_97_1038 VDD VSS sg13g2_decap_8
XFILLER_18_931 VDD VSS sg13g2_decap_8
X_14815_ _14815_/Q _14886_/CLK _14815_/D _14815_/RESET_B VDD VSS sg13g2_dfrbpq_1
XFILLER_92_856 VDD VSS sg13g2_decap_8
XFILLER_149_1128 VDD VSS sg13g2_decap_8
XFILLER_40_1284 VDD VSS sg13g2_decap_8
XFILLER_17_441 VDD VSS sg13g2_decap_8
XFILLER_33_912 VDD VSS sg13g2_decap_8
X_14746_ _14746_/Q _14746_/CLK _14746_/D _14746_/RESET_B VDD VSS sg13g2_dfrbpq_1
X_11958_ _11958_/Y _11969_/A _14384_/Q VDD VSS sg13g2_nand2b_1
XFILLER_44_260 VDD VSS sg13g2_fill_2
XFILLER_32_422 VDD VSS sg13g2_decap_8
X_10909_ _10954_/D _10936_/A _10936_/D VDD VSS sg13g2_nand2_1
X_14677_ _14677_/Q _14677_/CLK _14677_/D _14677_/RESET_B VDD VSS sg13g2_dfrbpq_1
X_11889_ _11889_/Y _11885_/Y _11886_/Y _11888_/Y _11887_/Y _11900_/B VDD VSS sg13g2_a221oi_1
XFILLER_149_129 VDD VSS sg13g2_decap_8
X_13628_ _13736_/D _13628_/A VDD VSS sg13g2_buf_1
XFILLER_158_630 VDD VSS sg13g2_fill_1
XFILLER_38_1191 VDD VSS sg13g2_decap_8
XFILLER_160_1030 VDD VSS sg13g2_decap_8
X_13703__2476 _13703_/RESET_B VDD VSS sg13g2_tiehi
XFILLER_160_1041 VDD VSS sg13g2_fill_2
XFILLER_146_814 VDD VSS sg13g2_fill_1
XFILLER_157_140 VDD VSS sg13g2_decap_8
XFILLER_9_651 VDD VSS sg13g2_decap_8
XFILLER_160_1063 VDD VSS sg13g2_fill_2
X_13559_ _13559_/Y _08110_/C _13567_/A2 _13558_/Y VDD VSS sg13g2_a21oi_1
XFILLER_158_685 VDD VSS sg13g2_decap_4
XFILLER_8_161 VDD VSS sg13g2_decap_8
XFILLER_173_633 VDD VSS sg13g2_decap_8
XFILLER_121_1058 VDD VSS sg13g2_decap_4
XFILLER_161_817 VDD VSS sg13g2_fill_2
X_15229_ _15229_/Q clkload58/A _15229_/D _15229_/RESET_B VDD VSS sg13g2_dfrbpq_1
XFILLER_172_154 VDD VSS sg13g2_decap_8
XFILLER_160_316 VDD VSS sg13g2_decap_8
XFILLER_82_1307 VDD VSS sg13g2_decap_8
X_07982_ _07985_/B _07834_/B _07980_/Y _15216_/Q VDD VSS sg13g2_o21ai_1
XFILLER_102_939 VDD VSS sg13g2_decap_8
XFILLER_114_799 VDD VSS sg13g2_decap_8
XFILLER_113_287 VDD VSS sg13g2_fill_2
XFILLER_68_820 VDD VSS sg13g2_decap_8
X_14967__2620 _14967_/RESET_B VDD VSS sg13g2_tiehi
X_09721_ _14312_/D _10151_/A1 _14312_/Q _09730_/S VDD VSS sg13g2_mux2_1
XFILLER_41_1004 VDD VSS sg13g2_fill_2
XFILLER_80_1064 VDD VSS sg13g2_decap_8
XFILLER_45_1184 VDD VSS sg13g2_decap_8
X_09652_ _14245_/D _09916_/A1 _14245_/Q _09664_/S VDD VSS sg13g2_mux2_1
XFILLER_83_823 VDD VSS sg13g2_decap_8
XFILLER_95_694 VDD VSS sg13g2_fill_2
XFILLER_83_834 VDD VSS sg13g2_fill_2
XFILLER_67_385 VDD VSS sg13g2_fill_2
XFILLER_55_525 VDD VSS sg13g2_decap_8
Xclkbuf_5_18__f_clk_i clkbuf_5_18__f_clk_i/X clkbuf_4_9_0_clk_i/X VDD VSS sg13g2_buf_16
X_08603_ _08603_/Y _08600_/A _08603_/B VDD VSS sg13g2_nand2b_1
XFILLER_27_238 VDD VSS sg13g2_decap_8
X_09583_ _14180_/D _14180_/Q _10047_/A0 _09601_/S VDD VSS sg13g2_mux2_1
XFILLER_82_344 VDD VSS sg13g2_decap_8
XFILLER_36_761 VDD VSS sg13g2_fill_1
X_08534_ _08535_/A _08567_/B _08532_/Y _08533_/Y VDD VSS sg13g2_o21ai_1
XFILLER_63_591 VDD VSS sg13g2_decap_8
XFILLER_169_928 VDD VSS sg13g2_fill_1
X_08465_ _08465_/X _08471_/B _07949_/C _07945_/B _07946_/B _13509_/A1 _13510_/A1 VDD
+ VSS sg13g2_mux4_1
X_14844__2856 _14844_/RESET_B VDD VSS sg13g2_tiehi
XFILLER_23_455 VDD VSS sg13g2_decap_8
XFILLER_168_427 VDD VSS sg13g2_decap_8
XFILLER_10_105 VDD VSS sg13g2_decap_8
X_08396_ _15233_/D _08395_/Y _08393_/Y _08388_/Y VDD VSS sg13g2_a21o_1
XFILLER_56_1291 VDD VSS sg13g2_decap_4
XFILLER_17_1253 VDD VSS sg13g2_decap_8
XFILLER_104_1212 VDD VSS sg13g2_fill_1
XFILLER_108_1381 VDD VSS sg13g2_fill_2
XFILLER_143_1261 VDD VSS sg13g2_fill_1
XFILLER_13_1106 VDD VSS sg13g2_decap_8
XFILLER_104_1256 VDD VSS sg13g2_decap_4
XFILLER_137_847 VDD VSS sg13g2_decap_8
XFILLER_148_173 VDD VSS sg13g2_fill_2
XFILLER_52_1188 VDD VSS sg13g2_decap_4
XFILLER_12_56 VDD VSS sg13g2_decap_8
XFILLER_139_1308 VDD VSS sg13g2_fill_1
XFILLER_152_817 VDD VSS sg13g2_decap_8
X_09017_ _09017_/Y _09141_/A _09016_/C _10702_/A _09030_/D VDD VSS sg13g2_a22oi_1
XFILLER_128_56 VDD VSS sg13g2_decap_8
XFILLER_163_154 VDD VSS sg13g2_decap_8
XFILLER_3_805 VDD VSS sg13g2_decap_8
XFILLER_124_519 VDD VSS sg13g2_fill_1
X_14472__1707 _14472_/RESET_B VDD VSS sg13g2_tiehi
X_13858__2321 _13858_/RESET_B VDD VSS sg13g2_tiehi
XFILLER_2_315 VDD VSS sg13g2_decap_8
XFILLER_105_744 VDD VSS sg13g2_decap_8
XFILLER_160_850 VDD VSS sg13g2_decap_8
XFILLER_104_243 VDD VSS sg13g2_decap_8
XFILLER_137_1054 VDD VSS sg13g2_decap_8
XFILLER_78_628 VDD VSS sg13g2_decap_8
XFILLER_78_639 VDD VSS sg13g2_fill_1
Xfanout630 _08654_/B _07997_/Y VDD VSS sg13g2_buf_1
Xfanout641 _12707_/C1 _12624_/C1 VDD VSS sg13g2_buf_1
XFILLER_28_1371 VDD VSS sg13g2_decap_8
Xfanout652 _13236_/A2 _12918_/A2 VDD VSS sg13g2_buf_1
X_09919_ _14504_/D _14504_/Q _09919_/A1 _09928_/S VDD VSS sg13g2_mux2_1
XFILLER_28_1382 VDD VSS sg13g2_fill_2
Xfanout663 _11193_/B1 _11045_/B1 VDD VSS sg13g2_buf_1
XFILLER_101_950 VDD VSS sg13g2_decap_8
Xfanout674 _12156_/A _12294_/B1 VDD VSS sg13g2_buf_1
XFILLER_150_1243 VDD VSS sg13g2_decap_8
Xfanout685 _13336_/S _08721_/S VDD VSS sg13g2_buf_1
XFILLER_24_1246 VDD VSS sg13g2_decap_8
XFILLER_111_1205 VDD VSS sg13g2_decap_8
X_12930_ _12930_/Y _14807_/Q _13014_/A2 _13234_/B _14839_/Q _13248_/B VDD VSS sg13g2_a221oi_1
Xfanout696 _11973_/B fanout706/X VDD VSS sg13g2_buf_1
XFILLER_19_728 VDD VSS sg13g2_decap_8
XFILLER_46_525 VDD VSS sg13g2_decap_8
XFILLER_37_42 VDD VSS sg13g2_decap_8
XFILLER_100_482 VDD VSS sg13g2_fill_1
XFILLER_160_21 VDD VSS sg13g2_decap_8
XFILLER_18_238 VDD VSS sg13g2_decap_8
X_12861_ _12861_/X _12861_/A _12861_/B VDD VSS sg13g2_xor2_1
X_14600_ _14600_/Q _14728_/CLK _14600_/D _14600_/RESET_B VDD VSS sg13g2_dfrbpq_1
XFILLER_2_1064 VDD VSS sg13g2_decap_8
X_11812_ _11812_/Y _11814_/S0 _14668_/Q _11802_/B VDD VSS sg13g2_a21oi_1
XFILLER_73_377 VDD VSS sg13g2_decap_8
XFILLER_27_772 VDD VSS sg13g2_decap_8
XFILLER_160_98 VDD VSS sg13g2_decap_8
XFILLER_33_219 VDD VSS sg13g2_decap_8
X_12792_ _15020_/D _12792_/A _12792_/B VDD VSS sg13g2_nor2_1
XFILLER_15_945 VDD VSS sg13g2_decap_8
XFILLER_109_1112 VDD VSS sg13g2_decap_8
XFILLER_156_0 VDD VSS sg13g2_decap_8
X_13960__2219 _13960_/RESET_B VDD VSS sg13g2_tiehi
X_14531_ _14531_/Q clkload19/A _14531_/D _14531_/RESET_B VDD VSS sg13g2_dfrbpq_1
XFILLER_109_1123 VDD VSS sg13g2_fill_1
X_11743_ _11743_/Y _11743_/A _11743_/B _11743_/C VDD VSS sg13g2_nand3_1
XFILLER_14_455 VDD VSS sg13g2_decap_8
XFILLER_42_764 VDD VSS sg13g2_decap_8
XFILLER_148_1194 VDD VSS sg13g2_decap_8
XFILLER_159_427 VDD VSS sg13g2_decap_8
X_14462_ _14462_/Q clkload38/A _14462_/D _14462_/RESET_B VDD VSS sg13g2_dfrbpq_1
XFILLER_109_1178 VDD VSS sg13g2_fill_2
XFILLER_169_63 VDD VSS sg13g2_decap_8
X_11674_ _11674_/Y _11676_/A1 _14600_/Q _12038_/B1 VDD VSS sg13g2_a21oi_1
XFILLER_161_1350 VDD VSS sg13g2_fill_2
X_13413_ _13444_/B _15198_/Q _15199_/Q _13490_/B _13490_/C VDD VSS sg13g2_or4_1
XFILLER_35_1364 VDD VSS sg13g2_decap_8
X_10625_ _10626_/A _14883_/Q _14882_/Q _10651_/D _10625_/D VDD VSS sg13g2_nand4_1
XFILLER_70_1255 VDD VSS sg13g2_decap_8
XFILLER_161_1383 VDD VSS sg13g2_fill_1
X_14393_ _14393_/Q _14505_/CLK _14393_/D _14393_/RESET_B VDD VSS sg13g2_dfrbpq_1
XFILLER_122_1345 VDD VSS sg13g2_fill_1
XFILLER_10_672 VDD VSS sg13g2_decap_8
XFILLER_127_324 VDD VSS sg13g2_fill_1
XFILLER_128_847 VDD VSS sg13g2_decap_8
XFILLER_31_1239 VDD VSS sg13g2_decap_8
XFILLER_139_195 VDD VSS sg13g2_fill_2
X_13344_ _15069_/D _13341_/A _15174_/D _13343_/Y VDD VSS sg13g2_o21ai_1
X_10556_ _10557_/B _14867_/Q _14866_/Q _14865_/Q _10556_/D VDD VSS sg13g2_nand4_1
XFILLER_143_806 VDD VSS sg13g2_decap_8
XFILLER_155_666 VDD VSS sg13g2_decap_8
XFILLER_6_665 VDD VSS sg13g2_decap_8
X_13275_ _13275_/Y _10342_/A _13275_/A2 _13275_/B1 VDD VSS sg13g2_o21ai_1
X_10487_ _14849_/D _10633_/A _10487_/B _10495_/D VDD VSS sg13g2_nor3_1
XFILLER_5_175 VDD VSS sg13g2_decap_8
X_14448__1731 _14448_/RESET_B VDD VSS sg13g2_tiehi
X_15014_ _15014_/Q _15015_/CLK _15014_/D _15014_/RESET_B VDD VSS sg13g2_dfrbpq_1
X_12226_ _14985_/D _12203_/A _12271_/A _12225_/Y VDD VSS sg13g2_a21o_1
XFILLER_45_7 VDD VSS sg13g2_decap_8
XFILLER_151_850 VDD VSS sg13g2_decap_8
XFILLER_29_1135 VDD VSS sg13g2_decap_8
XFILLER_123_552 VDD VSS sg13g2_decap_8
XFILLER_9_1218 VDD VSS sg13g2_decap_8
X_12157_ _12157_/Y _12168_/A _14134_/Q VDD VSS sg13g2_nand2b_1
XFILLER_64_1048 VDD VSS sg13g2_decap_8
XFILLER_2_882 VDD VSS sg13g2_decap_8
XFILLER_110_213 VDD VSS sg13g2_decap_4
XFILLER_155_1187 VDD VSS sg13g2_decap_8
XFILLER_110_224 VDD VSS sg13g2_fill_1
X_11108_ _11109_/A _10764_/X _11097_/Y _11107_/Y VDD VSS sg13g2_o21ai_1
XFILLER_78_93 VDD VSS sg13g2_fill_2
XFILLER_42_1313 VDD VSS sg13g2_decap_8
X_12088_ _12092_/A _12087_/X _12304_/B VDD VSS sg13g2_nand2b_1
XFILLER_68_149 VDD VSS sg13g2_decap_4
XFILLER_1_392 VDD VSS sg13g2_decap_8
XFILLER_110_246 VDD VSS sg13g2_decap_8
XFILLER_81_1373 VDD VSS sg13g2_decap_4
XFILLER_110_257 VDD VSS sg13g2_fill_1
XFILLER_77_650 VDD VSS sg13g2_decap_4
X_11039_ _11043_/B _11040_/A _11052_/D _11052_/B VDD VSS sg13g2_o21ai_1
XFILLER_92_631 VDD VSS sg13g2_decap_8
XFILLER_64_322 VDD VSS sg13g2_decap_8
XFILLER_76_193 VDD VSS sg13g2_decap_8
XFILLER_91_130 VDD VSS sg13g2_decap_8
XFILLER_25_709 VDD VSS sg13g2_fill_2
XFILLER_65_889 VDD VSS sg13g2_decap_8
XFILLER_64_355 VDD VSS sg13g2_decap_8
XFILLER_92_675 VDD VSS sg13g2_fill_2
XFILLER_64_366 VDD VSS sg13g2_fill_1
XFILLER_91_163 VDD VSS sg13g2_decap_8
XFILLER_92_697 VDD VSS sg13g2_decap_8
XFILLER_64_399 VDD VSS sg13g2_fill_2
XFILLER_91_185 VDD VSS sg13g2_decap_8
X_15177__2859 _15177_/RESET_B VDD VSS sg13g2_tiehi
XFILLER_166_1272 VDD VSS sg13g2_decap_8
X_14729_ _14729_/Q clkload20/A _14729_/D _14729_/RESET_B VDD VSS sg13g2_dfrbpq_1
X_14550__1629 _14550_/RESET_B VDD VSS sg13g2_tiehi
X_13936__2243 _13936_/RESET_B VDD VSS sg13g2_tiehi
XFILLER_60_550 VDD VSS sg13g2_decap_8
X_14696__1483 _14696_/RESET_B VDD VSS sg13g2_tiehi
X_08250_ _08250_/X _08318_/A _08250_/B VDD VSS sg13g2_xor2_1
XFILLER_21_959 VDD VSS sg13g2_decap_8
X_08181_ _08183_/C _14961_/Q _07911_/A _08162_/Y VDD VSS sg13g2_a21oi_1
XFILLER_146_611 VDD VSS sg13g2_decap_4
XFILLER_20_469 VDD VSS sg13g2_decap_8
XFILLER_71_0 VDD VSS sg13g2_decap_8
XFILLER_174_931 VDD VSS sg13g2_fill_1
XFILLER_146_633 VDD VSS sg13g2_fill_2
XFILLER_174_953 VDD VSS sg13g2_fill_1
XFILLER_118_379 VDD VSS sg13g2_decap_8
XFILLER_127_880 VDD VSS sg13g2_fill_2
XFILLER_145_176 VDD VSS sg13g2_decap_4
XFILLER_127_891 VDD VSS sg13g2_fill_1
XFILLER_12_1183 VDD VSS sg13g2_decap_8
XFILLER_161_636 VDD VSS sg13g2_decap_4
XFILLER_160_168 VDD VSS sg13g2_decap_8
XFILLER_88_926 VDD VSS sg13g2_decap_4
XFILLER_142_883 VDD VSS sg13g2_fill_1
XFILLER_59_105 VDD VSS sg13g2_fill_1
XFILLER_102_725 VDD VSS sg13g2_decap_4
XFILLER_87_425 VDD VSS sg13g2_decap_8
XFILLER_102_747 VDD VSS sg13g2_decap_8
XFILLER_102_758 VDD VSS sg13g2_fill_1
XFILLER_114_14 VDD VSS sg13g2_decap_8
X_07965_ _07965_/Y _15016_/Q _08012_/B VDD VSS sg13g2_nand2b_1
X_09704_ _14296_/D _09935_/A1 _14296_/Q _09706_/S VDD VSS sg13g2_mux2_1
X_07896_ _07896_/X _07900_/B _07903_/B VDD VSS sg13g2_and2_1
XFILLER_83_620 VDD VSS sg13g2_fill_2
X_14750__2966 _14750_/RESET_B VDD VSS sg13g2_tiehi
XFILLER_167_1003 VDD VSS sg13g2_decap_8
X_09635_ _14231_/D _09967_/A1 _14231_/Q _09637_/S VDD VSS sg13g2_mux2_1
XFILLER_28_569 VDD VSS sg13g2_decap_8
XFILLER_3_1351 VDD VSS sg13g2_decap_8
X_09566_ _14164_/D _09632_/A0 _14164_/Q _09566_/S VDD VSS sg13g2_mux2_1
XFILLER_93_1211 VDD VSS sg13g2_decap_8
XFILLER_130_35 VDD VSS sg13g2_fill_2
XFILLER_70_347 VDD VSS sg13g2_decap_8
X_08517_ _15239_/D _08517_/A _08517_/B _08517_/C _08517_/D VDD VSS sg13g2_nand4_1
X_09497_ _14097_/D _10127_/A0 _14097_/Q _09497_/S VDD VSS sg13g2_mux2_1
XFILLER_90_28 VDD VSS sg13g2_decap_8
XFILLER_19_1337 VDD VSS sg13g2_decap_8
XFILLER_93_1277 VDD VSS sg13g2_decap_4
XFILLER_54_1228 VDD VSS sg13g2_decap_8
X_14526__1653 _14526_/RESET_B VDD VSS sg13g2_tiehi
XFILLER_23_252 VDD VSS sg13g2_decap_8
XFILLER_168_224 VDD VSS sg13g2_decap_8
X_08448_ _08448_/Y _08663_/B _08443_/Y _08447_/X VDD VSS sg13g2_a21oi_1
XFILLER_93_1299 VDD VSS sg13g2_fill_1
XFILLER_12_959 VDD VSS sg13g2_decap_8
XFILLER_17_1050 VDD VSS sg13g2_decap_8
X_08379_ _08379_/Y _08621_/A _08544_/A VDD VSS sg13g2_nand2_1
XFILLER_11_469 VDD VSS sg13g2_decap_8
XFILLER_149_471 VDD VSS sg13g2_decap_8
XFILLER_109_313 VDD VSS sg13g2_fill_1
XFILLER_23_77 VDD VSS sg13g2_decap_8
X_15066__2877 _15066_/RESET_B VDD VSS sg13g2_tiehi
X_10410_ _10414_/D _14823_/Q _14824_/Q _14825_/Q _14826_/Q VDD VSS sg13g2_and4_1
X_11390_ _11391_/A _11814_/S0 _13887_/Q VDD VSS sg13g2_nand2b_1
XFILLER_164_441 VDD VSS sg13g2_decap_8
XFILLER_165_964 VDD VSS sg13g2_decap_4
XFILLER_137_666 VDD VSS sg13g2_decap_8
XFILLER_109_368 VDD VSS sg13g2_decap_8
XFILLER_136_154 VDD VSS sg13g2_fill_1
X_10341_ _10343_/A _10313_/X _10357_/D _14807_/Q VDD VSS sg13g2_a21o_1
XFILLER_99_59 VDD VSS sg13g2_decap_8
XFILLER_136_165 VDD VSS sg13g2_decap_8
XFILLER_3_602 VDD VSS sg13g2_decap_8
XFILLER_30_1261 VDD VSS sg13g2_decap_8
XFILLER_137_699 VDD VSS sg13g2_decap_4
XFILLER_139_1116 VDD VSS sg13g2_decap_8
XFILLER_139_1127 VDD VSS sg13g2_fill_2
Xclkbuf_leaf_124_clk_i clkload2/A clkbuf_leaf_3_clk_i/A VDD VSS sg13g2_buf_8
XFILLER_155_21 VDD VSS sg13g2_decap_8
XFILLER_124_338 VDD VSS sg13g2_decap_8
X_13060_ _13060_/Y _13042_/A _13037_/Y _13057_/C VDD VSS sg13g2_o21ai_1
XFILLER_2_112 VDD VSS sg13g2_decap_8
X_10272_ _10281_/D _10299_/A _10299_/B VDD VSS sg13g2_nor2_1
X_12011_ _12011_/X _12012_/A _11988_/Y _12055_/D VDD VSS sg13g2_a21o_1
XFILLER_3_679 VDD VSS sg13g2_decap_8
XFILLER_26_1308 VDD VSS sg13g2_decap_8
XFILLER_155_98 VDD VSS sg13g2_decap_8
XFILLER_160_680 VDD VSS sg13g2_fill_1
Xfanout1403 _12653_/A1 _12751_/A1 VDD VSS sg13g2_buf_1
XFILLER_132_382 VDD VSS sg13g2_fill_1
Xfanout1414 _13005_/C input38/X VDD VSS sg13g2_buf_1
XFILLER_2_189 VDD VSS sg13g2_decap_8
XFILLER_152_1349 VDD VSS sg13g2_decap_4
X_13674__2524 _13674_/RESET_B VDD VSS sg13g2_tiehi
Xfanout460 _09469_/S _09472_/S VDD VSS sg13g2_buf_1
XFILLER_48_63 VDD VSS sg13g2_decap_8
XFILLER_47_801 VDD VSS sg13g2_fill_1
Xfanout471 _09370_/S _09373_/S VDD VSS sg13g2_buf_1
XFILLER_59_661 VDD VSS sg13g2_decap_8
XFILLER_171_42 VDD VSS sg13g2_decap_8
XFILLER_115_1160 VDD VSS sg13g2_fill_1
Xfanout482 _10142_/A1 _08989_/X VDD VSS sg13g2_buf_1
XFILLER_63_1092 VDD VSS sg13g2_decap_8
XFILLER_47_812 VDD VSS sg13g2_decap_8
XFILLER_24_1043 VDD VSS sg13g2_decap_8
X_13962_ _13962_/Q _14730_/CLK _13962_/D _13962_/RESET_B VDD VSS sg13g2_dfrbpq_1
Xfanout493 _08424_/A1 _08001_/Y VDD VSS sg13g2_buf_1
XFILLER_58_160 VDD VSS sg13g2_fill_2
XFILLER_115_1182 VDD VSS sg13g2_decap_8
XFILLER_8_1295 VDD VSS sg13g2_decap_8
XFILLER_19_525 VDD VSS sg13g2_decap_8
XFILLER_111_1024 VDD VSS sg13g2_decap_8
XFILLER_4_1148 VDD VSS sg13g2_decap_8
XFILLER_150_1084 VDD VSS sg13g2_decap_8
X_12913_ _12914_/C _13045_/A1 _12867_/C input10/X VDD VSS sg13g2_a21oi_1
XFILLER_74_653 VDD VSS sg13g2_decap_8
X_13893_ _13893_/Q _14725_/CLK _13893_/D _13893_/RESET_B VDD VSS sg13g2_dfrbpq_1
XFILLER_47_878 VDD VSS sg13g2_fill_2
XFILLER_46_355 VDD VSS sg13g2_decap_4
XFILLER_74_675 VDD VSS sg13g2_fill_2
XFILLER_62_815 VDD VSS sg13g2_decap_8
XFILLER_34_517 VDD VSS sg13g2_decap_4
X_12844_ _12845_/D _12883_/A _12867_/C _12844_/C input23/X VDD VSS sg13g2_nand4_1
XFILLER_98_1199 VDD VSS sg13g2_decap_8
XFILLER_61_314 VDD VSS sg13g2_fill_1
XFILLER_64_62 VDD VSS sg13g2_fill_1
XFILLER_15_742 VDD VSS sg13g2_decap_8
X_12775_ _12775_/X _12769_/X _12773_/X _12768_/X _12772_/X _12553_/S _12775_/S1 VDD
+ VSS sg13g2_mux4_1
XFILLER_14_252 VDD VSS sg13g2_decap_8
XFILLER_159_224 VDD VSS sg13g2_decap_8
X_14514_ _14514_/Q _14632_/CLK _14514_/D _14514_/RESET_B VDD VSS sg13g2_dfrbpq_1
XFILLER_9_35 VDD VSS sg13g2_decap_8
X_11726_ _11773_/D _11726_/A _13678_/Q VDD VSS sg13g2_xnor2_1
XFILLER_120_90 VDD VSS sg13g2_decap_4
X_14445_ _14445_/Q clkload3/A _14445_/D _14445_/RESET_B VDD VSS sg13g2_dfrbpq_1
X_11657_ _11657_/Y _11656_/Y _11655_/Y _11643_/Y _12294_/B1 _12271_/A VDD VSS sg13g2_a221oi_1
XFILLER_174_216 VDD VSS sg13g2_decap_8
XFILLER_122_1120 VDD VSS sg13g2_decap_8
XFILLER_122_1131 VDD VSS sg13g2_fill_2
XFILLER_174_227 VDD VSS sg13g2_decap_8
XFILLER_127_110 VDD VSS sg13g2_decap_8
X_10608_ _14878_/D _10629_/C _10643_/A _10608_/C VDD VSS sg13g2_nor3_1
X_14376_ _14376_/Q _14644_/CLK _14376_/D _14376_/RESET_B VDD VSS sg13g2_dfrbpq_1
XFILLER_31_1047 VDD VSS sg13g2_decap_8
X_11588_ _14967_/D _11570_/A _12295_/B1 _11587_/Y VDD VSS sg13g2_a21o_1
XFILLER_7_952 VDD VSS sg13g2_decap_8
XFILLER_31_1058 VDD VSS sg13g2_fill_1
XFILLER_143_603 VDD VSS sg13g2_fill_1
XFILLER_122_1197 VDD VSS sg13g2_decap_8
X_13327_ _13328_/B _15114_/Q _13306_/B _13309_/Y _09640_/C VDD VSS sg13g2_a22oi_1
X_10539_ _14861_/D _10543_/C _10543_/D _10535_/B _07622_/Y _13141_/A VDD VSS sg13g2_a221oi_1
XFILLER_6_462 VDD VSS sg13g2_decap_8
XFILLER_171_934 VDD VSS sg13g2_fill_2
XFILLER_155_485 VDD VSS sg13g2_decap_8
XFILLER_157_1216 VDD VSS sg13g2_decap_8
XFILLER_143_647 VDD VSS sg13g2_decap_8
XFILLER_171_956 VDD VSS sg13g2_fill_1
XFILLER_115_349 VDD VSS sg13g2_decap_4
XFILLER_157_1249 VDD VSS sg13g2_decap_8
XFILLER_89_70 VDD VSS sg13g2_decap_8
X_13258_ _13259_/B _14924_/Q _13663_/Q VDD VSS sg13g2_xnor2_1
XFILLER_170_455 VDD VSS sg13g2_decap_8
X_12209_ _12210_/B _14711_/Q _14743_/Q _13783_/Q _13815_/Q _12212_/S0 _12212_/S1 VDD
+ VSS sg13g2_mux4_1
XFILLER_9_1015 VDD VSS sg13g2_decap_8
XFILLER_124_894 VDD VSS sg13g2_fill_1
XFILLER_151_680 VDD VSS sg13g2_decap_4
X_13189_ _13189_/X _13189_/A _13190_/B _13225_/B VDD VSS sg13g2_and3_1
XFILLER_111_522 VDD VSS sg13g2_decap_8
X_14604__1575 _14604_/RESET_B VDD VSS sg13g2_tiehi
X_07750_ _15207_/D _07750_/A _07750_/B VDD VSS sg13g2_or2_1
XFILLER_49_160 VDD VSS sg13g2_fill_1
XFILLER_42_1154 VDD VSS sg13g2_decap_8
XFILLER_93_940 VDD VSS sg13g2_decap_8
XFILLER_38_856 VDD VSS sg13g2_fill_1
X_07681_ _07687_/A _07677_/Y _07680_/Y _08831_/B _11241_/A VDD VSS sg13g2_a22oi_1
X_16879_ _16879_/X _16879_/A VDD VSS sg13g2_buf_1
XFILLER_77_1217 VDD VSS sg13g2_decap_8
X_09420_ _14022_/D _09950_/A1 _14022_/Q _09431_/S VDD VSS sg13g2_mux2_1
XFILLER_92_472 VDD VSS sg13g2_decap_8
XFILLER_53_826 VDD VSS sg13g2_fill_1
XFILLER_37_399 VDD VSS sg13g2_fill_2
X_09351_ _13955_/D _09615_/A0 _13955_/Q _09373_/S VDD VSS sg13g2_mux2_1
XFILLER_80_667 VDD VSS sg13g2_decap_8
XFILLER_52_369 VDD VSS sg13g2_decap_8
X_08302_ _08625_/B _08138_/A _08234_/Y _08452_/C _08301_/X VDD VSS sg13g2_a22oi_1
X_09282_ _13890_/D _13890_/Q _10145_/A1 _09301_/S VDD VSS sg13g2_mux2_1
XFILLER_100_49 VDD VSS sg13g2_decap_8
XFILLER_127_1064 VDD VSS sg13g2_decap_8
X_08233_ _15225_/D _08232_/Y _08233_/B _08233_/C VDD VSS sg13g2_nand3b_1
XFILLER_21_756 VDD VSS sg13g2_decap_8
XFILLER_105_1340 VDD VSS sg13g2_fill_2
XFILLER_53_1272 VDD VSS sg13g2_decap_8
XFILLER_20_266 VDD VSS sg13g2_decap_8
XFILLER_119_633 VDD VSS sg13g2_decap_8
XFILLER_147_942 VDD VSS sg13g2_decap_4
XFILLER_165_238 VDD VSS sg13g2_decap_8
X_08164_ _08164_/Y _08163_/Y _07871_/X _08039_/A VDD VSS sg13g2_a21oi_1
XFILLER_105_1373 VDD VSS sg13g2_fill_2
XFILLER_118_121 VDD VSS sg13g2_fill_1
Xclkbuf_leaf_41_clk_i clkload33/A clkbuf_leaf_43_clk_i/A VDD VSS sg13g2_buf_8
XFILLER_109_14 VDD VSS sg13g2_decap_4
XFILLER_118_132 VDD VSS sg13g2_decap_8
XFILLER_14_1267 VDD VSS sg13g2_decap_8
XFILLER_140_1275 VDD VSS sg13g2_fill_1
X_08095_ _08199_/C _08300_/A1 _07775_/A _07786_/A _07782_/A _08253_/S0 _08402_/A VDD
+ VSS sg13g2_mux4_1
XFILLER_119_699 VDD VSS sg13g2_decap_8
XFILLER_161_422 VDD VSS sg13g2_decap_8
XFILLER_118_198 VDD VSS sg13g2_decap_8
XFILLER_162_956 VDD VSS sg13g2_decap_8
Xclkload70 clkload70/Y clkload70/A VDD VSS sg13g2_inv_1
XFILLER_133_124 VDD VSS sg13g2_decap_8
XFILLER_121_319 VDD VSS sg13g2_decap_8
Xclkbuf_leaf_56_clk_i clkload68/A clkbuf_leaf_62_clk_i/A VDD VSS sg13g2_buf_8
XFILLER_88_712 VDD VSS sg13g2_decap_4
XFILLER_86_1081 VDD VSS sg13g2_decap_8
XFILLER_0_616 VDD VSS sg13g2_decap_8
XFILLER_114_382 VDD VSS sg13g2_decap_8
XFILLER_125_35 VDD VSS sg13g2_decap_8
XFILLER_87_222 VDD VSS sg13g2_fill_2
XFILLER_88_756 VDD VSS sg13g2_decap_8
XFILLER_130_853 VDD VSS sg13g2_decap_8
XFILLER_134_1035 VDD VSS sg13g2_fill_1
X_08997_ _13760_/D _13760_/Q _10143_/A1 _09160_/S VDD VSS sg13g2_mux2_1
XFILLER_25_1330 VDD VSS sg13g2_decap_8
XFILLER_87_288 VDD VSS sg13g2_decap_8
X_07948_ _07950_/B _07948_/A _08443_/A _07950_/A _07949_/B VDD VSS sg13g2_nand4_1
XFILLER_28_300 VDD VSS sg13g2_decap_8
X_07879_ _07879_/Y _07879_/A _08103_/B VDD VSS sg13g2_xnor2_1
XFILLER_18_77 VDD VSS sg13g2_decap_8
X_09618_ _14214_/D _09884_/A0 _14214_/Q _09629_/S VDD VSS sg13g2_mux2_1
XFILLER_28_388 VDD VSS sg13g2_fill_2
XFILLER_16_539 VDD VSS sg13g2_decap_8
X_10890_ _10890_/Y _10890_/A _10890_/B _10890_/C VDD VSS sg13g2_nor3_1
XFILLER_70_111 VDD VSS sg13g2_decap_4
XFILLER_43_347 VDD VSS sg13g2_decap_8
XFILLER_70_133 VDD VSS sg13g2_decap_8
XFILLER_43_358 VDD VSS sg13g2_fill_1
X_09549_ _14147_/D _09615_/A0 _14147_/Q _09567_/S VDD VSS sg13g2_mux2_1
XFILLER_34_21 VDD VSS sg13g2_decap_8
XFILLER_169_511 VDD VSS sg13g2_decap_8
XFILLER_19_1134 VDD VSS sg13g2_decap_8
X_12560_ _12560_/X _14250_/Q _14282_/Q _14314_/Q _14346_/Q _12614_/S0 _12614_/S1 VDD
+ VSS sg13g2_mux4_1
X_14042__2137 _14042_/RESET_B VDD VSS sg13g2_tiehi
XFILLER_24_594 VDD VSS sg13g2_decap_8
XFILLER_106_1115 VDD VSS sg13g2_fill_2
XFILLER_12_756 VDD VSS sg13g2_decap_8
XFILLER_157_717 VDD VSS sg13g2_decap_8
XFILLER_54_1058 VDD VSS sg13g2_decap_8
XFILLER_34_98 VDD VSS sg13g2_decap_4
X_11511_ _11511_/X _14563_/Q _14595_/Q _14627_/Q _14659_/Q _11715_/S0 _11715_/S1 VDD
+ VSS sg13g2_mux4_1
XFILLER_169_588 VDD VSS sg13g2_decap_8
XFILLER_138_920 VDD VSS sg13g2_decap_8
X_12491_ _12491_/X _14565_/Q _14597_/Q _14629_/Q _14661_/Q _12633_/S0 _12633_/S1 VDD
+ VSS sg13g2_mux4_1
XFILLER_11_266 VDD VSS sg13g2_decap_8
XFILLER_32_1323 VDD VSS sg13g2_decap_8
XFILLER_8_749 VDD VSS sg13g2_decap_8
X_14230_ _14230_/Q clkload26/A _14230_/D _14230_/RESET_B VDD VSS sg13g2_dfrbpq_1
XFILLER_156_249 VDD VSS sg13g2_fill_2
X_11442_ _11443_/B _13824_/Q _13856_/Q _13888_/Q _13920_/Q _11489_/S0 _11489_/S1 VDD
+ VSS sg13g2_mux4_1
XFILLER_50_42 VDD VSS sg13g2_decap_8
XFILLER_7_259 VDD VSS sg13g2_decap_8
XFILLER_119_0 VDD VSS sg13g2_decap_8
XFILLER_153_923 VDD VSS sg13g2_decap_8
XFILLER_166_42 VDD VSS sg13g2_decap_8
X_14161_ _14161_/Q clkload0/A _14161_/D _14161_/RESET_B VDD VSS sg13g2_dfrbpq_1
X_11373_ _11374_/B _11373_/A _14206_/Q VDD VSS sg13g2_nand2_1
XFILLER_109_176 VDD VSS sg13g2_fill_1
XFILLER_50_86 VDD VSS sg13g2_decap_8
XFILLER_50_97 VDD VSS sg13g2_fill_2
X_13112_ _13172_/C _13112_/A _13104_/A VDD VSS sg13g2_nor2b_1
X_10324_ _10325_/B _14799_/Q _14800_/Q _14801_/Q _10414_/B VDD VSS sg13g2_nand4_1
X_14092_ _14092_/Q clkload13/A _14092_/D _14092_/RESET_B VDD VSS sg13g2_dfrbpq_1
XFILLER_4_966 VDD VSS sg13g2_decap_8
XFILLER_65_1121 VDD VSS sg13g2_fill_1
XFILLER_79_712 VDD VSS sg13g2_decap_8
XFILLER_1_0 VDD VSS sg13g2_decap_8
XFILLER_117_1200 VDD VSS sg13g2_decap_8
XFILLER_124_179 VDD VSS sg13g2_decap_8
X_13043_ _13043_/Y _13041_/Y _13043_/B _13271_/C VDD VSS sg13g2_nand3b_1
X_10255_ _10265_/D _14778_/Q _14779_/Q _14780_/Q _10255_/D VDD VSS sg13g2_nand4_1
XFILLER_3_476 VDD VSS sg13g2_decap_8
XFILLER_26_1105 VDD VSS sg13g2_decap_8
XFILLER_121_831 VDD VSS sg13g2_decap_4
XFILLER_152_1113 VDD VSS sg13g2_decap_8
Xfanout1200 _10513_/D _14851_/Q VDD VSS sg13g2_buf_1
Xfanout1211 _12347_/B _14750_/Q VDD VSS sg13g2_buf_1
XFILLER_117_1255 VDD VSS sg13g2_decap_4
XFILLER_121_864 VDD VSS sg13g2_decap_8
Xfanout1222 _12048_/A1 _13661_/Q VDD VSS sg13g2_buf_1
X_10186_ _14749_/D _10185_/Y _14749_/Q _08855_/S VDD VSS sg13g2_a21o_1
XFILLER_61_1029 VDD VSS sg13g2_decap_8
Xfanout1233 _11747_/A _11957_/A VDD VSS sg13g2_buf_1
X_14995__2592 _14995_/RESET_B VDD VSS sg13g2_tiehi
Xfanout1244 _12214_/B _12219_/S VDD VSS sg13g2_buf_1
XFILLER_152_1168 VDD VSS sg13g2_fill_2
Xfanout1255 _11970_/C _11972_/S1 VDD VSS sg13g2_buf_1
XFILLER_78_277 VDD VSS sg13g2_decap_8
XFILLER_94_737 VDD VSS sg13g2_decap_8
Xfanout1266 _11328_/S1 _11229_/S1 VDD VSS sg13g2_buf_1
XFILLER_93_214 VDD VSS sg13g2_decap_4
X_14994_ _14994_/Q clkload67/A _14994_/D _14994_/RESET_B VDD VSS sg13g2_dfrbpq_1
Xfanout1277 _12140_/S1 _12137_/S1 VDD VSS sg13g2_buf_1
XFILLER_66_439 VDD VSS sg13g2_decap_8
XFILLER_59_480 VDD VSS sg13g2_decap_8
Xfanout290 _10080_/A0 _09019_/Y VDD VSS sg13g2_buf_1
Xfanout1288 _11493_/S1 _11469_/S1 VDD VSS sg13g2_buf_1
XFILLER_8_1092 VDD VSS sg13g2_decap_8
XFILLER_19_322 VDD VSS sg13g2_decap_8
Xfanout1299 _11400_/A _11854_/S0 VDD VSS sg13g2_buf_1
X_13945_ _13945_/Q _14745_/CLK _13945_/D _13945_/RESET_B VDD VSS sg13g2_dfrbpq_1
X_14252__1927 _14252_/RESET_B VDD VSS sg13g2_tiehi
XFILLER_93_269 VDD VSS sg13g2_decap_8
X_14398__1781 _14398_/RESET_B VDD VSS sg13g2_tiehi
XFILLER_90_910 VDD VSS sg13g2_decap_8
XFILLER_90_921 VDD VSS sg13g2_fill_1
XFILLER_62_612 VDD VSS sg13g2_fill_1
XFILLER_46_163 VDD VSS sg13g2_decap_8
X_13876_ _13876_/Q _14516_/CLK _13876_/D _13876_/RESET_B VDD VSS sg13g2_dfrbpq_1
XFILLER_90_943 VDD VSS sg13g2_decap_8
XFILLER_19_399 VDD VSS sg13g2_decap_8
X_12827_ _12828_/A input26/X _12841_/B _12803_/X input5/X _12826_/X VDD VSS sg13g2_a221oi_1
XFILLER_61_144 VDD VSS sg13g2_fill_2
XFILLER_62_678 VDD VSS sg13g2_fill_1
XFILLER_76_1294 VDD VSS sg13g2_decap_8
X_12758_ _12758_/X _14136_/Q _14168_/Q _14200_/Q _14232_/Q _12758_/S0 _12758_/S1 VDD
+ VSS sg13g2_mux4_1
X_14018__2161 _14018_/RESET_B VDD VSS sg13g2_tiehi
XFILLER_72_1158 VDD VSS sg13g2_decap_8
X_11709_ _11709_/X _13737_/Q _14089_/Q _14441_/Q _14537_/Q _12282_/S0 _12282_/S1 VDD
+ VSS sg13g2_mux4_1
X_12689_ _12689_/X _14259_/Q _14291_/Q _14323_/Q _14355_/Q _12689_/S0 _12689_/S1 VDD
+ VSS sg13g2_mux4_1
X_14428_ _14428_/Q clkload44/A _14428_/D _14428_/RESET_B VDD VSS sg13g2_dfrbpq_1
XFILLER_129_964 VDD VSS sg13g2_decap_8
XFILLER_128_452 VDD VSS sg13g2_decap_8
XFILLER_129_986 VDD VSS sg13g2_fill_2
X_14359_ _14359_/Q _15015_/CLK _14359_/D _14359_/RESET_B VDD VSS sg13g2_dfrbpq_1
XFILLER_157_1024 VDD VSS sg13g2_fill_1
X_13740__2439 _13740_/RESET_B VDD VSS sg13g2_tiehi
X_13886__2293 _13886_/RESET_B VDD VSS sg13g2_tiehi
XFILLER_170_252 VDD VSS sg13g2_decap_8
XFILLER_157_1068 VDD VSS sg13g2_decap_8
X_08920_ _13712_/D _16874_/A _08919_/X _08932_/S VDD VSS sg13g2_mux2_1
XFILLER_69_200 VDD VSS sg13g2_decap_8
XFILLER_69_211 VDD VSS sg13g2_fill_2
XFILLER_124_691 VDD VSS sg13g2_decap_8
XFILLER_34_0 VDD VSS sg13g2_decap_8
X_08851_ _13695_/D _16857_/A _08850_/X _08855_/S VDD VSS sg13g2_mux2_1
XFILLER_97_553 VDD VSS sg13g2_decap_8
XFILLER_85_715 VDD VSS sg13g2_decap_8
XFILLER_44_1249 VDD VSS sg13g2_fill_2
XFILLER_131_1208 VDD VSS sg13g2_decap_8
XFILLER_170_1257 VDD VSS sg13g2_decap_8
X_07802_ _07949_/B _08471_/B _15008_/Q VDD VSS sg13g2_nand2b_1
XFILLER_84_203 VDD VSS sg13g2_fill_1
X_14120__2059 _14120_/RESET_B VDD VSS sg13g2_tiehi
X_08782_ _08782_/Y _07720_/C _14759_/Q _15183_/Q _07719_/X VDD VSS sg13g2_a22oi_1
X_07733_ _07734_/C _15097_/Q _15077_/Q _15075_/Q _15092_/Q VDD VSS sg13g2_nor4_1
XFILLER_26_815 VDD VSS sg13g2_fill_2
XFILLER_37_152 VDD VSS sg13g2_decap_8
X_14228__1951 _14228_/RESET_B VDD VSS sg13g2_tiehi
XFILLER_1_91 VDD VSS sg13g2_decap_8
X_07664_ _13508_/B _13613_/B _13613_/C VDD VSS sg13g2_nor2_1
XFILLER_26_848 VDD VSS sg13g2_decap_8
XFILLER_0_1332 VDD VSS sg13g2_decap_8
XFILLER_20_1260 VDD VSS sg13g2_decap_8
X_09403_ _14006_/D _10098_/A0 _14006_/Q _09403_/S VDD VSS sg13g2_mux2_1
XFILLER_81_976 VDD VSS sg13g2_decap_8
XFILLER_111_59 VDD VSS sg13g2_decap_8
X_09334_ _13941_/D _10164_/A1 _13941_/Q _09334_/S VDD VSS sg13g2_mux2_1
XFILLER_94_1383 VDD VSS sg13g2_fill_1
XFILLER_33_391 VDD VSS sg13g2_decap_8
X_09265_ _13874_/D _13874_/Q _10128_/A0 _09271_/S VDD VSS sg13g2_mux2_1
XFILLER_21_553 VDD VSS sg13g2_decap_8
XFILLER_166_525 VDD VSS sg13g2_decap_8
X_08216_ _08544_/A _08138_/A _08215_/X _08452_/D VDD VSS sg13g2_mux2_1
X_09196_ _13812_/D _13812_/Q _09632_/A0 _09202_/S VDD VSS sg13g2_mux2_1
XFILLER_119_441 VDD VSS sg13g2_decap_4
XFILLER_105_1170 VDD VSS sg13g2_decap_4
XFILLER_88_1110 VDD VSS sg13g2_fill_2
XFILLER_14_1064 VDD VSS sg13g2_decap_8
XFILLER_153_208 VDD VSS sg13g2_decap_8
XFILLER_112_7 VDD VSS sg13g2_decap_8
X_08147_ _08147_/Y _08014_/B _08013_/X _08146_/X VDD VSS sg13g2_a21oi_1
XFILLER_101_1045 VDD VSS sg13g2_decap_8
XFILLER_134_433 VDD VSS sg13g2_decap_8
XFILLER_162_742 VDD VSS sg13g2_decap_8
X_08078_ _15219_/D _08068_/Y _08078_/B _08078_/C VDD VSS sg13g2_nand3b_1
XFILLER_20_56 VDD VSS sg13g2_decap_8
X_14330__1849 _14330_/RESET_B VDD VSS sg13g2_tiehi
X_13716__2463 _13716_/RESET_B VDD VSS sg13g2_tiehi
XFILLER_88_1198 VDD VSS sg13g2_fill_2
XFILLER_1_903 VDD VSS sg13g2_decap_8
XFILLER_106_168 VDD VSS sg13g2_decap_8
XFILLER_122_617 VDD VSS sg13g2_fill_2
XFILLER_150_926 VDD VSS sg13g2_decap_8
XFILLER_161_252 VDD VSS sg13g2_decap_8
XFILLER_136_56 VDD VSS sg13g2_decap_8
XFILLER_0_413 VDD VSS sg13g2_decap_8
XFILLER_122_639 VDD VSS sg13g2_decap_8
XFILLER_161_296 VDD VSS sg13g2_decap_8
XFILLER_96_27 VDD VSS sg13g2_decap_4
XFILLER_62_1305 VDD VSS sg13g2_decap_8
X_10040_ _14621_/D _10107_/A0 _14621_/Q _10063_/S VDD VSS sg13g2_mux2_1
XFILLER_102_341 VDD VSS sg13g2_fill_1
XFILLER_49_918 VDD VSS sg13g2_decap_4
XFILLER_29_21 VDD VSS sg13g2_decap_8
XFILLER_76_726 VDD VSS sg13g2_decap_4
XFILLER_75_214 VDD VSS sg13g2_decap_8
XFILLER_60_1051 VDD VSS sg13g2_fill_1
XFILLER_5_1232 VDD VSS sg13g2_decap_8
XFILLER_29_98 VDD VSS sg13g2_decap_8
XFILLER_152_77 VDD VSS sg13g2_decap_8
X_11991_ _11991_/X _13969_/Q _14001_/Q _14033_/Q _14065_/Q _11996_/S0 _11996_/S1 VDD
+ VSS sg13g2_mux4_1
XFILLER_95_1103 VDD VSS sg13g2_fill_2
XFILLER_21_1057 VDD VSS sg13g2_decap_8
XFILLER_17_826 VDD VSS sg13g2_decap_8
X_13730_ _13730_/Q clkload30/A _13730_/D _13730_/RESET_B VDD VSS sg13g2_dfrbpq_1
X_10942_ _10942_/Y _10954_/C _14758_/Q VDD VSS sg13g2_nor2b_1
XFILLER_112_1196 VDD VSS sg13g2_decap_8
XFILLER_83_280 VDD VSS sg13g2_decap_8
XFILLER_45_42 VDD VSS sg13g2_decap_8
XFILLER_16_336 VDD VSS sg13g2_decap_8
XFILLER_44_645 VDD VSS sg13g2_decap_8
X_13661_ _13661_/Q _15188_/CLK _13661_/D _13661_/RESET_B VDD VSS sg13g2_dfrbpq_1
X_15120__2719 _15120_/RESET_B VDD VSS sg13g2_tiehi
X_10873_ _10873_/Y _10873_/A1 _10871_/A _07753_/B VDD VSS sg13g2_o21ai_1
X_12612_ _12625_/A _12709_/A1 _12765_/A2 _15008_/Q VDD VSS sg13g2_a21oi_1
XFILLER_43_188 VDD VSS sg13g2_decap_8
XFILLER_25_892 VDD VSS sg13g2_decap_8
X_13592_ _13592_/Y _15004_/Q _13552_/B _13561_/S _15020_/Q _13545_/X VDD VSS sg13g2_a221oi_1
XFILLER_40_840 VDD VSS sg13g2_decap_4
XFILLER_12_553 VDD VSS sg13g2_decap_8
X_12543_ _12543_/X _13833_/Q _13865_/Q _13897_/Q _13929_/Q _12546_/S0 _12546_/S1 VDD
+ VSS sg13g2_mux4_1
XFILLER_169_385 VDD VSS sg13g2_decap_8
XFILLER_61_63 VDD VSS sg13g2_decap_8
XFILLER_8_546 VDD VSS sg13g2_decap_8
XFILLER_32_1131 VDD VSS sg13g2_decap_8
X_12474_ _12474_/X _13956_/Q _13988_/Q _14020_/Q _14052_/Q _12522_/S0 _12522_/S1 VDD
+ VSS sg13g2_mux4_1
XFILLER_71_1191 VDD VSS sg13g2_fill_1
XFILLER_6_14 VDD VSS sg13g2_decap_8
XFILLER_123_1281 VDD VSS sg13g2_fill_2
X_14213_ _14213_/Q _14725_/CLK _14213_/D _14213_/RESET_B VDD VSS sg13g2_dfrbpq_1
X_11425_ _11425_/Y _11425_/A wire523/X _11425_/C VDD VSS sg13g2_nand3_1
X_15193_ _15193_/Q _15214_/CLK _15193_/D _15193_/RESET_B VDD VSS sg13g2_dfrbpq_1
XFILLER_32_1186 VDD VSS sg13g2_fill_2
XANTENNA_7 _09702_/S VDD VSS sg13g2_antennanp
XFILLER_158_1311 VDD VSS sg13g2_decap_8
XFILLER_152_230 VDD VSS sg13g2_decap_8
X_14144_ _14144_/Q clkload30/A _14144_/D _14144_/RESET_B VDD VSS sg13g2_dfrbpq_1
X_11356_ _11356_/Y _11355_/Y _11354_/Y _11875_/B VDD VSS sg13g2_a21oi_1
XFILLER_141_915 VDD VSS sg13g2_decap_8
XFILLER_4_763 VDD VSS sg13g2_decap_8
X_14306__1873 _14306_/RESET_B VDD VSS sg13g2_tiehi
X_10307_ _10307_/Y _14796_/Q _10327_/B _10334_/C VDD VSS sg13g2_o21ai_1
X_14075_ _14075_/Q clkload40/A _14075_/D _14075_/RESET_B VDD VSS sg13g2_dfrbpq_1
XFILLER_98_339 VDD VSS sg13g2_decap_8
XFILLER_106_680 VDD VSS sg13g2_decap_8
X_11287_ _11287_/Y _11287_/A _11287_/B wire523/A VDD VSS sg13g2_nand3_1
XFILLER_3_273 VDD VSS sg13g2_decap_8
X_13026_ _13026_/Y _13026_/A _13057_/A _13026_/C VDD VSS sg13g2_nor3_1
X_10238_ _10238_/Y _10237_/B _10234_/Y _13499_/B VDD VSS sg13g2_o21ai_1
XFILLER_79_564 VDD VSS sg13g2_fill_1
Xfanout1030 _08306_/B _15000_/Q VDD VSS sg13g2_buf_1
XFILLER_67_726 VDD VSS sg13g2_decap_4
Xfanout1041 _08560_/A _08599_/A VDD VSS sg13g2_buf_1
XFILLER_6_1029 VDD VSS sg13g2_decap_8
Xfanout1052 _08161_/A2 _14992_/Q VDD VSS sg13g2_buf_1
X_10169_ _14746_/D _14746_/Q _10169_/A1 _10169_/S VDD VSS sg13g2_mux2_1
Xfanout1063 _08686_/S1 _13521_/A VDD VSS sg13g2_buf_1
Xfanout1074 _08046_/B _08083_/S0 VDD VSS sg13g2_buf_1
XFILLER_94_556 VDD VSS sg13g2_fill_2
Xfanout1085 _08048_/B _12300_/A VDD VSS sg13g2_buf_1
Xfanout1096 _08635_/A1 _12152_/A VDD VSS sg13g2_buf_1
X_14977_ _14977_/Q _14979_/CLK _14977_/D _14977_/RESET_B VDD VSS sg13g2_dfrbpq_1
XFILLER_94_589 VDD VSS sg13g2_fill_2
X_13928_ _13928_/Q _14644_/CLK _13928_/D _13928_/RESET_B VDD VSS sg13g2_dfrbpq_1
XFILLER_165_1315 VDD VSS sg13g2_decap_8
XFILLER_19_196 VDD VSS sg13g2_decap_8
XFILLER_78_1378 VDD VSS sg13g2_fill_2
X_13859_ _13859_/Q _14505_/CLK _13859_/D _13859_/RESET_B VDD VSS sg13g2_dfrbpq_1
XFILLER_23_818 VDD VSS sg13g2_fill_2
XFILLER_34_199 VDD VSS sg13g2_decap_8
XFILLER_128_1192 VDD VSS sg13g2_decap_8
X_15068__2869 _15068_/RESET_B VDD VSS sg13g2_tiehi
XFILLER_31_873 VDD VSS sg13g2_decap_8
X_09050_ _09050_/X _14908_/Q _09056_/C _09049_/Y VDD VSS sg13g2_a21o_1
XFILLER_30_372 VDD VSS sg13g2_fill_2
XFILLER_124_1078 VDD VSS sg13g2_decap_8
XFILLER_15_1351 VDD VSS sg13g2_decap_8
XFILLER_11_1204 VDD VSS sg13g2_decap_8
X_08001_ _08001_/Y _08001_/A _08275_/B _08001_/C _08001_/D VDD VSS sg13g2_nand4_1
X_13973__2206 _13973_/RESET_B VDD VSS sg13g2_tiehi
X_15129__2699 _15129_/RESET_B VDD VSS sg13g2_tiehi
XFILLER_163_539 VDD VSS sg13g2_decap_8
XFILLER_128_271 VDD VSS sg13g2_decap_8
XFILLER_117_967 VDD VSS sg13g2_decap_8
XFILLER_117_978 VDD VSS sg13g2_fill_1
XFILLER_132_904 VDD VSS sg13g2_fill_1
XFILLER_143_230 VDD VSS sg13g2_decap_8
XFILLER_85_1327 VDD VSS sg13g2_decap_4
XFILLER_85_1349 VDD VSS sg13g2_fill_1
XFILLER_171_572 VDD VSS sg13g2_decap_8
XFILLER_116_488 VDD VSS sg13g2_decap_8
XFILLER_131_414 VDD VSS sg13g2_fill_1
XFILLER_172_1308 VDD VSS sg13g2_decap_8
X_09952_ _14536_/D _14536_/Q _10084_/A0 _09961_/S VDD VSS sg13g2_mux2_1
XFILLER_48_1171 VDD VSS sg13g2_fill_2
XFILLER_44_1002 VDD VSS sg13g2_decap_4
X_08903_ _08903_/X _15039_/Q _14943_/Q _10735_/A VDD VSS sg13g2_mux2_1
XFILLER_112_650 VDD VSS sg13g2_decap_8
X_09883_ _14469_/D _09916_/A1 _14469_/Q _09895_/S VDD VSS sg13g2_mux2_1
XFILLER_98_895 VDD VSS sg13g2_decap_4
X_08834_ _08834_/X _13600_/A _13508_/C VDD VSS sg13g2_and2_1
XFILLER_135_1185 VDD VSS sg13g2_decap_8
XFILLER_85_567 VDD VSS sg13g2_fill_2
XFILLER_122_14 VDD VSS sg13g2_decap_8
X_08765_ _13673_/D _08765_/A1 _08763_/Y _08764_/Y VDD VSS sg13g2_a21oi_1
XFILLER_72_217 VDD VSS sg13g2_fill_2
XFILLER_66_781 VDD VSS sg13g2_decap_8
XFILLER_26_612 VDD VSS sg13g2_decap_8
XFILLER_22_1366 VDD VSS sg13g2_decap_8
X_07716_ _08049_/A _15102_/Q _15094_/Q VDD VSS sg13g2_nor2_1
X_08696_ _08696_/Y _15019_/Q _08673_/B _08698_/B VDD VSS sg13g2_a21oi_1
XFILLER_25_133 VDD VSS sg13g2_decap_8
XFILLER_26_667 VDD VSS sg13g2_decap_8
X_07647_ _07647_/Y _14806_/Q VDD VSS sg13g2_inv_1
XFILLER_81_773 VDD VSS sg13g2_fill_2
XFILLER_54_998 VDD VSS sg13g2_decap_8
XFILLER_81_795 VDD VSS sg13g2_fill_1
XFILLER_107_1210 VDD VSS sg13g2_decap_4
XFILLER_15_56 VDD VSS sg13g2_decap_8
XFILLER_167_801 VDD VSS sg13g2_decap_4
XFILLER_107_1232 VDD VSS sg13g2_fill_2
X_09317_ _13924_/D _09750_/A1 _13924_/Q _09334_/S VDD VSS sg13g2_mux2_1
XFILLER_90_1044 VDD VSS sg13g2_decap_8
XFILLER_21_350 VDD VSS sg13g2_decap_8
XFILLER_166_322 VDD VSS sg13g2_decap_8
XFILLER_16_1148 VDD VSS sg13g2_decap_8
XFILLER_107_1265 VDD VSS sg13g2_decap_8
X_09248_ _13857_/D _13857_/Q _09780_/A0 _09271_/S VDD VSS sg13g2_mux2_1
XFILLER_154_506 VDD VSS sg13g2_decap_8
XFILLER_167_889 VDD VSS sg13g2_fill_1
XFILLER_166_399 VDD VSS sg13g2_decap_8
X_14563__1616 _14563_/RESET_B VDD VSS sg13g2_tiehi
X_09179_ _13795_/D _13795_/Q _10146_/A1 _09201_/S VDD VSS sg13g2_mux2_1
XFILLER_107_422 VDD VSS sg13g2_decap_8
X_13949__2230 _13949_/RESET_B VDD VSS sg13g2_tiehi
XFILLER_31_77 VDD VSS sg13g2_decap_8
XFILLER_108_956 VDD VSS sg13g2_decap_8
X_11210_ _11210_/X _13947_/Q _13979_/Q _14011_/Q _14043_/Q _11212_/S _11878_/B1 VDD
+ VSS sg13g2_mux4_1
X_12190_ _12190_/Y _12190_/A _12190_/B VDD VSS sg13g2_nand2_1
XFILLER_134_241 VDD VSS sg13g2_decap_8
XFILLER_150_701 VDD VSS sg13g2_decap_8
XFILLER_162_572 VDD VSS sg13g2_decap_4
XFILLER_1_700 VDD VSS sg13g2_decap_8
XFILLER_134_274 VDD VSS sg13g2_decap_8
X_11141_ _11141_/X _11163_/A _11207_/A2 _11207_/B1 VDD VSS sg13g2_a21o_1
XFILLER_107_499 VDD VSS sg13g2_fill_2
Xoutput44 mem_axi_araddr[15] _16868_/A VDD VSS sg13g2_buf_1
Xoutput55 mem_axi_araddr[26] _16879_/A VDD VSS sg13g2_buf_1
XFILLER_0_210 VDD VSS sg13g2_decap_8
XFILLER_163_21 VDD VSS sg13g2_decap_8
Xoutput66 mem_axi_araddr[7] _16860_/A VDD VSS sg13g2_buf_1
XFILLER_27_1222 VDD VSS sg13g2_decap_8
XFILLER_150_767 VDD VSS sg13g2_decap_8
Xoutput77 mem_axi_awaddr[16] _16869_/X VDD VSS sg13g2_buf_1
X_11072_ _11072_/Y _11029_/C _11070_/Y _11071_/Y VDD VSS sg13g2_a21oi_1
XFILLER_62_1113 VDD VSS sg13g2_decap_8
XFILLER_110_609 VDD VSS sg13g2_decap_8
Xoutput88 mem_axi_awaddr[27] _16880_/X VDD VSS sg13g2_buf_1
Xoutput99 mem_axi_awaddr[8] _16861_/X VDD VSS sg13g2_buf_1
XFILLER_7_1316 VDD VSS sg13g2_decap_8
XFILLER_1_777 VDD VSS sg13g2_decap_8
Xhold3160 _13584_/A _15160_/Q VDD VSS sg13g2_dlygate4sd3_1
X_14900_ _14900_/Q clkload56/A _14900_/D _14900_/RESET_B VDD VSS sg13g2_dfrbpq_1
Xhold3171 hold3171/X _14777_/Q VDD VSS sg13g2_dlygate4sd3_1
X_10023_ _14605_/D _10056_/A0 _14605_/Q _10027_/S VDD VSS sg13g2_mux2_1
XFILLER_62_1146 VDD VSS sg13g2_decap_8
XFILLER_114_1225 VDD VSS sg13g2_decap_4
XFILLER_0_287 VDD VSS sg13g2_decap_8
XFILLER_163_98 VDD VSS sg13g2_decap_8
XFILLER_49_759 VDD VSS sg13g2_decap_8
XFILLER_48_225 VDD VSS sg13g2_fill_2
XFILLER_27_1299 VDD VSS sg13g2_decap_8
X_14831_ _14831_/Q clkload50/A _14831_/D _14831_/RESET_B VDD VSS sg13g2_dfrbpq_1
X_14886__2772 _14886_/RESET_B VDD VSS sg13g2_tiehi
XFILLER_29_450 VDD VSS sg13g2_fill_2
X_14762_ _14762_/Q clkload32/A _14762_/D _14762_/RESET_B VDD VSS sg13g2_dfrbpq_1
XFILLER_17_623 VDD VSS sg13g2_decap_8
X_11974_ _11975_/B _11971_/Y _11973_/Y _11974_/B1 VDD VSS sg13g2_a21oi_1
XFILLER_91_548 VDD VSS sg13g2_decap_8
XFILLER_99_1091 VDD VSS sg13g2_fill_2
XFILLER_91_559 VDD VSS sg13g2_fill_1
XFILLER_16_133 VDD VSS sg13g2_decap_8
X_13713_ _16875_/A _14682_/CLK _13713_/D _13713_/RESET_B VDD VSS sg13g2_dfrbpq_1
XFILLER_44_442 VDD VSS sg13g2_decap_4
X_10925_ _10926_/B _10954_/A _10954_/D _10924_/Y VDD VSS sg13g2_o21ai_1
XFILLER_44_453 VDD VSS sg13g2_fill_1
X_14693_ _14693_/Q clkload6/A _14693_/D _14693_/RESET_B VDD VSS sg13g2_dfrbpq_1
XFILLER_44_486 VDD VSS sg13g2_decap_8
XFILLER_32_637 VDD VSS sg13g2_decap_4
XFILLER_147_1067 VDD VSS sg13g2_decap_8
X_13644_ _13752_/D _13644_/A VDD VSS sg13g2_buf_1
XFILLER_73_1220 VDD VSS sg13g2_decap_8
XFILLER_38_1340 VDD VSS sg13g2_decap_8
X_10856_ _10857_/B _14752_/Q _10870_/A VDD VSS sg13g2_xnor2_1
XFILLER_13_840 VDD VSS sg13g2_decap_8
XFILLER_32_659 VDD VSS sg13g2_decap_8
XFILLER_72_84 VDD VSS sg13g2_decap_8
XFILLER_12_350 VDD VSS sg13g2_decap_8
X_13575_ _13575_/Y _13575_/A _13584_/B VDD VSS sg13g2_nor2_1
XFILLER_73_1275 VDD VSS sg13g2_decap_4
X_10787_ _14923_/D _10787_/A VDD VSS sg13g2_inv_1
XFILLER_9_833 VDD VSS sg13g2_decap_8
XFILLER_125_1365 VDD VSS sg13g2_decap_8
XFILLER_169_182 VDD VSS sg13g2_decap_8
XFILLER_158_867 VDD VSS sg13g2_fill_2
X_12526_ _12527_/B _13681_/Q _12721_/A2 _12525_/X _12721_/B2 _12624_/C1 VDD VSS sg13g2_a221oi_1
XFILLER_121_1218 VDD VSS sg13g2_fill_1
XFILLER_8_343 VDD VSS sg13g2_decap_8
XFILLER_75_7 VDD VSS sg13g2_decap_8
XFILLER_173_815 VDD VSS sg13g2_decap_8
X_15245_ _15245_/Q _15247_/CLK _15245_/D _15245_/RESET_B VDD VSS sg13g2_dfrbpq_1
XFILLER_172_314 VDD VSS sg13g2_decap_8
X_12457_ _14996_/D _12457_/A _12457_/B VDD VSS sg13g2_nor2_1
XFILLER_172_325 VDD VSS sg13g2_decap_8
X_14539__1640 _14539_/RESET_B VDD VSS sg13g2_tiehi
X_11408_ _11408_/Y _11804_/A _14399_/Q _11805_/C VDD VSS sg13g2_a21oi_1
X_15176_ _15176_/Q clkload66/A _15176_/D _15176_/RESET_B VDD VSS sg13g2_dfrbpq_1
XFILLER_126_775 VDD VSS sg13g2_decap_4
XFILLER_158_1141 VDD VSS sg13g2_decap_8
X_12388_ _14991_/D _08431_/D _12443_/A2 _12387_/Y _12386_/Y VDD VSS sg13g2_a22oi_1
XFILLER_158_1152 VDD VSS sg13g2_fill_2
XFILLER_113_403 VDD VSS sg13g2_decap_8
XFILLER_119_1114 VDD VSS sg13g2_fill_1
XFILLER_153_572 VDD VSS sg13g2_decap_8
XFILLER_4_560 VDD VSS sg13g2_decap_8
X_14127_ _14127_/Q clkload6/A _14127_/D _14127_/RESET_B VDD VSS sg13g2_dfrbpq_1
XFILLER_28_1008 VDD VSS sg13g2_decap_8
XFILLER_10_1281 VDD VSS sg13g2_decap_8
XFILLER_141_734 VDD VSS sg13g2_decap_8
X_11339_ _11339_/Y _11339_/A _11339_/B VDD VSS sg13g2_xnor2_1
XFILLER_98_147 VDD VSS sg13g2_decap_8
XFILLER_45_1311 VDD VSS sg13g2_fill_2
XFILLER_84_1371 VDD VSS sg13g2_decap_8
XFILLER_80_1202 VDD VSS sg13g2_fill_1
X_14058_ _14058_/Q _14666_/CLK _14058_/D _14058_/RESET_B VDD VSS sg13g2_dfrbpq_1
XFILLER_141_789 VDD VSS sg13g2_decap_4
XFILLER_171_1341 VDD VSS sg13g2_decap_8
XFILLER_79_361 VDD VSS sg13g2_decap_4
X_13009_ _13009_/Y _13009_/A _13010_/A _13010_/B VDD VSS sg13g2_nand3_1
XFILLER_95_876 VDD VSS sg13g2_decap_8
XFILLER_82_504 VDD VSS sg13g2_fill_2
XFILLER_39_269 VDD VSS sg13g2_decap_8
XFILLER_43_1090 VDD VSS sg13g2_decap_8
X_08550_ _08550_/Y _08567_/B _08531_/B _07956_/Y VDD VSS sg13g2_a21oi_1
XFILLER_36_965 VDD VSS sg13g2_fill_1
XFILLER_78_1153 VDD VSS sg13g2_decap_8
XFILLER_39_1104 VDD VSS sg13g2_decap_8
X_14641__1538 _14641_/RESET_B VDD VSS sg13g2_tiehi
X_08481_ _08481_/X _08481_/A _08481_/B VDD VSS sg13g2_xor2_1
XFILLER_74_1017 VDD VSS sg13g2_fill_2
XFILLER_23_615 VDD VSS sg13g2_decap_4
XFILLER_50_412 VDD VSS sg13g2_fill_2
XFILLER_62_283 VDD VSS sg13g2_fill_2
XFILLER_168_609 VDD VSS sg13g2_decap_8
XFILLER_22_147 VDD VSS sg13g2_decap_8
XFILLER_167_119 VDD VSS sg13g2_decap_8
XFILLER_148_333 VDD VSS sg13g2_fill_2
X_09102_ _09102_/Y _13142_/A _09136_/B _09111_/A1 VDD VSS sg13g2_o21ai_1
XFILLER_52_1348 VDD VSS sg13g2_fill_2
XFILLER_31_681 VDD VSS sg13g2_decap_8
XFILLER_31_692 VDD VSS sg13g2_fill_1
XFILLER_108_219 VDD VSS sg13g2_decap_8
XFILLER_11_1001 VDD VSS sg13g2_decap_8
X_09033_ _13766_/D _13766_/Q _09950_/A1 _09106_/S VDD VSS sg13g2_mux2_1
XFILLER_163_336 VDD VSS sg13g2_decap_8
XFILLER_102_1151 VDD VSS sg13g2_decap_8
XFILLER_117_753 VDD VSS sg13g2_fill_2
XFILLER_117_764 VDD VSS sg13g2_fill_1
XFILLER_117_14 VDD VSS sg13g2_decap_8
XFILLER_11_1078 VDD VSS sg13g2_decap_8
XFILLER_137_1203 VDD VSS sg13g2_decap_8
XFILLER_117_797 VDD VSS sg13g2_decap_8
XFILLER_104_425 VDD VSS sg13g2_decap_8
Xfanout801 _12789_/S0 _15212_/Q VDD VSS sg13g2_buf_1
Xfanout812 fanout812/X fanout816/X VDD VSS sg13g2_buf_1
X_09935_ _14520_/D _14520_/Q _09935_/A1 _09935_/S VDD VSS sg13g2_mux2_1
Xfanout823 _12352_/S1 _12618_/S1 VDD VSS sg13g2_buf_1
Xfanout834 _12727_/S1 _12731_/S1 VDD VSS sg13g2_buf_1
Xfanout845 _12437_/S1 fanout846/X VDD VSS sg13g2_buf_1
XFILLER_113_992 VDD VSS sg13g2_fill_1
Xfanout856 _12655_/S0 fanout860/X VDD VSS sg13g2_buf_1
Xfanout867 _12614_/S0 _12618_/S0 VDD VSS sg13g2_buf_1
X_09866_ _14453_/D _14453_/Q _10031_/A0 _09867_/S VDD VSS sg13g2_mux2_1
Xfanout878 _12522_/S0 _12717_/S0 VDD VSS sg13g2_buf_1
XFILLER_133_35 VDD VSS sg13g2_decap_8
Xfanout889 _12773_/S0 fanout894/X VDD VSS sg13g2_buf_1
X_08817_ _08817_/Y _13279_/B _15122_/Q _13482_/A _15192_/Q _08825_/C1 VDD VSS sg13g2_a221oi_1
Xclkbuf_4_6_0_clk_i clkbuf_4_6_0_clk_i/X clkbuf_0_clk_i/X VDD VSS sg13g2_buf_8
XFILLER_58_578 VDD VSS sg13g2_decap_8
X_09797_ _14386_/D _10061_/A0 _14386_/Q _09804_/S VDD VSS sg13g2_mux2_1
XFILLER_100_686 VDD VSS sg13g2_decap_8
XFILLER_93_28 VDD VSS sg13g2_decap_8
XFILLER_100_697 VDD VSS sg13g2_fill_1
XFILLER_22_1163 VDD VSS sg13g2_decap_8
X_08748_ _08748_/Y _07720_/A _11288_/A _15194_/Q VDD VSS sg13g2_o21ai_1
XFILLER_27_943 VDD VSS sg13g2_decap_8
X_14280__1899 _14280_/RESET_B VDD VSS sg13g2_tiehi
XFILLER_2_1246 VDD VSS sg13g2_decap_8
XFILLER_26_431 VDD VSS sg13g2_decap_8
X_08679_ _08679_/Y _08642_/Y _08645_/X _08678_/Y VDD VSS sg13g2_a21oi_1
XFILLER_27_998 VDD VSS sg13g2_decap_8
XFILLER_109_1305 VDD VSS sg13g2_decap_8
XFILLER_92_1117 VDD VSS sg13g2_fill_2
XFILLER_57_1237 VDD VSS sg13g2_decap_8
XFILLER_26_77 VDD VSS sg13g2_decap_8
X_14617__1562 _14617_/RESET_B VDD VSS sg13g2_tiehi
XFILLER_42_935 VDD VSS sg13g2_decap_8
XFILLER_14_637 VDD VSS sg13g2_decap_8
X_10710_ _10936_/C _09027_/X _10743_/S _08873_/Y VDD VSS sg13g2_a21o_1
XFILLER_42_957 VDD VSS sg13g2_decap_8
X_11690_ _11694_/A _11689_/X _11690_/B VDD VSS sg13g2_nand2b_1
XFILLER_144_1229 VDD VSS sg13g2_fill_1
XFILLER_13_147 VDD VSS sg13g2_decap_8
XFILLER_41_456 VDD VSS sg13g2_decap_4
XFILLER_158_119 VDD VSS sg13g2_decap_8
X_10641_ _10643_/B _14887_/Q _10642_/C _14888_/Q VDD VSS sg13g2_a21oi_1
XFILLER_42_21 VDD VSS sg13g2_decap_8
XFILLER_158_21 VDD VSS sg13g2_decap_8
XFILLER_155_804 VDD VSS sg13g2_decap_8
X_13360_ _13494_/B _13389_/B _13389_/A VDD VSS sg13g2_nand2b_1
X_10572_ _14869_/D _10572_/A _10572_/B _10572_/C VDD VSS sg13g2_nor3_1
XFILLER_10_854 VDD VSS sg13g2_decap_8
XFILLER_155_837 VDD VSS sg13g2_fill_1
X_12311_ _12311_/Y _12250_/A1 _14586_/Q VDD VSS sg13g2_nand2b_1
X_13291_ _15054_/D _13291_/A _13291_/B _13291_/C VDD VSS sg13g2_nand3_1
XFILLER_158_98 VDD VSS sg13g2_decap_8
XFILLER_166_196 VDD VSS sg13g2_decap_8
XFILLER_6_847 VDD VSS sg13g2_decap_8
XFILLER_120_1251 VDD VSS sg13g2_decap_8
X_15030_ _15030_/Q _15226_/CLK _15030_/D _15030_/RESET_B VDD VSS sg13g2_dfrbpq_1
X_12242_ _12242_/Y _12242_/A_N _14648_/Q VDD VSS sg13g2_nand2b_1
XFILLER_68_1322 VDD VSS sg13g2_decap_8
XFILLER_154_369 VDD VSS sg13g2_decap_8
XFILLER_5_357 VDD VSS sg13g2_decap_8
XFILLER_101_0 VDD VSS sg13g2_decap_8
XFILLER_29_1317 VDD VSS sg13g2_decap_8
XFILLER_174_42 VDD VSS sg13g2_fill_1
XFILLER_122_211 VDD VSS sg13g2_decap_8
X_12173_ _12174_/B _12170_/Y _12172_/Y _12265_/B1 VDD VSS sg13g2_a21oi_1
XFILLER_64_1219 VDD VSS sg13g2_decap_8
XFILLER_111_918 VDD VSS sg13g2_decap_8
XFILLER_122_244 VDD VSS sg13g2_decap_4
X_11124_ _11128_/A _11127_/A _11127_/B VDD VSS sg13g2_nand2_1
XFILLER_150_564 VDD VSS sg13g2_decap_8
XFILLER_155_1369 VDD VSS sg13g2_fill_2
XFILLER_49_501 VDD VSS sg13g2_decap_8
XFILLER_89_681 VDD VSS sg13g2_fill_2
XFILLER_7_1113 VDD VSS sg13g2_decap_8
XFILLER_1_574 VDD VSS sg13g2_decap_8
X_11055_ _11055_/Y _11206_/A1 _11051_/Y _11054_/Y VDD VSS sg13g2_a21oi_1
XFILLER_103_480 VDD VSS sg13g2_decap_8
XFILLER_153_1082 VDD VSS sg13g2_decap_4
XFILLER_27_1096 VDD VSS sg13g2_decap_8
X_10006_ _14588_/D _10072_/A0 _14588_/Q _10030_/S VDD VSS sg13g2_mux2_1
XFILLER_67_84 VDD VSS sg13g2_decap_8
XFILLER_37_729 VDD VSS sg13g2_decap_8
XFILLER_97_1017 VDD VSS sg13g2_fill_2
XFILLER_91_301 VDD VSS sg13g2_fill_2
XFILLER_18_910 VDD VSS sg13g2_decap_8
XFILLER_76_386 VDD VSS sg13g2_decap_8
X_14814_ _14814_/Q clkload48/A _14814_/D _14814_/RESET_B VDD VSS sg13g2_dfrbpq_1
XFILLER_17_420 VDD VSS sg13g2_decap_8
XFILLER_29_291 VDD VSS sg13g2_decap_8
XFILLER_92_879 VDD VSS sg13g2_decap_8
XFILLER_91_356 VDD VSS sg13g2_decap_4
X_14745_ _14745_/Q _14745_/CLK _14745_/D _14745_/RESET_B VDD VSS sg13g2_dfrbpq_1
XFILLER_75_1315 VDD VSS sg13g2_fill_2
XFILLER_18_987 VDD VSS sg13g2_decap_8
X_11957_ _11957_/Y _11957_/A _11957_/B VDD VSS sg13g2_nor2_1
XFILLER_32_401 VDD VSS sg13g2_decap_8
XFILLER_44_272 VDD VSS sg13g2_decap_8
X_10908_ _10908_/Y _10923_/A _10923_/D _10923_/B VDD VSS sg13g2_o21ai_1
XFILLER_17_497 VDD VSS sg13g2_decap_8
X_14676_ _14676_/Q clkload15/A _14676_/D _14676_/RESET_B VDD VSS sg13g2_dfrbpq_1
X_11888_ _11888_/Y _11217_/S _14510_/Q _12304_/B VDD VSS sg13g2_a21oi_1
XFILLER_60_754 VDD VSS sg13g2_decap_8
X_13627_ _13735_/D _13627_/A VDD VSS sg13g2_buf_1
XFILLER_38_1170 VDD VSS sg13g2_decap_8
X_10839_ _10841_/B _14751_/Q _10876_/A VDD VSS sg13g2_xor2_1
XFILLER_32_478 VDD VSS sg13g2_decap_8
XFILLER_9_630 VDD VSS sg13g2_decap_8
XFILLER_125_1162 VDD VSS sg13g2_decap_8
XFILLER_158_664 VDD VSS sg13g2_decap_8
XFILLER_160_1053 VDD VSS sg13g2_fill_1
X_13558_ _13558_/Y _15008_/Q _13563_/B _13563_/C VDD VSS sg13g2_nor3_1
XFILLER_34_1056 VDD VSS sg13g2_decap_8
XFILLER_8_140 VDD VSS sg13g2_decap_8
XFILLER_173_612 VDD VSS sg13g2_decap_8
X_12509_ _12509_/X _12508_/X _12507_/X _12501_/X _12502_/X _12608_/S1 _12539_/S VDD
+ VSS sg13g2_mux4_1
XFILLER_146_848 VDD VSS sg13g2_decap_8
X_13489_ _15124_/D _15124_/Q _13655_/S _13488_/Y VDD VSS sg13g2_a21o_1
XFILLER_172_133 VDD VSS sg13g2_decap_8
X_15228_ _15228_/Q _15228_/CLK _15228_/D _15228_/RESET_B VDD VSS sg13g2_dfrbpq_1
XFILLER_12_1365 VDD VSS sg13g2_decap_8
X_14055__2124 _14055_/RESET_B VDD VSS sg13g2_tiehi
X_15159_ _15159_/Q _15159_/CLK _15159_/D _15159_/RESET_B VDD VSS sg13g2_dfrbpq_1
XFILLER_99_445 VDD VSS sg13g2_decap_8
XFILLER_113_233 VDD VSS sg13g2_decap_8
XFILLER_99_456 VDD VSS sg13g2_fill_2
XFILLER_102_918 VDD VSS sg13g2_decap_8
X_07981_ _07985_/A _07980_/Y _15075_/Q _07981_/C VDD VSS sg13g2_nand3b_1
XFILLER_101_428 VDD VSS sg13g2_fill_2
X_09720_ _14311_/D _09720_/A0 _14311_/Q _09738_/S VDD VSS sg13g2_mux2_1
XFILLER_136_1280 VDD VSS sg13g2_fill_1
XFILLER_132_1144 VDD VSS sg13g2_decap_8
XFILLER_28_707 VDD VSS sg13g2_decap_8
X_09651_ _14244_/D _09750_/A1 _14244_/Q _09670_/S VDD VSS sg13g2_mux2_1
XFILLER_55_504 VDD VSS sg13g2_decap_8
XFILLER_27_217 VDD VSS sg13g2_decap_8
X_08602_ _08615_/A _15015_/Q _07853_/B _08674_/B1 VDD VSS sg13g2_o21ai_1
X_09582_ _14179_/D _14179_/Q _09615_/A0 _09601_/S VDD VSS sg13g2_mux2_1
XFILLER_36_740 VDD VSS sg13g2_decap_8
X_08533_ _08533_/Y _08567_/B _08532_/Y _08667_/A1 VDD VSS sg13g2_a21oi_1
XFILLER_35_272 VDD VSS sg13g2_decap_4
X_08464_ _08475_/D _08027_/Y _08242_/A _08463_/Y VDD VSS sg13g2_a21oi_1
XFILLER_23_434 VDD VSS sg13g2_decap_8
XFILLER_168_406 VDD VSS sg13g2_decap_8
XFILLER_24_979 VDD VSS sg13g2_fill_2
XFILLER_52_1101 VDD VSS sg13g2_fill_1
X_08395_ _08395_/Y _08395_/A _08395_/B VDD VSS sg13g2_nor2_1
XFILLER_17_1232 VDD VSS sg13g2_decap_8
X_14265__1914 _14265_/RESET_B VDD VSS sg13g2_tiehi
XFILLER_149_642 VDD VSS sg13g2_decap_8
XFILLER_32_990 VDD VSS sg13g2_decap_8
XFILLER_149_664 VDD VSS sg13g2_decap_8
XFILLER_109_517 VDD VSS sg13g2_decap_8
XFILLER_12_35 VDD VSS sg13g2_decap_8
XFILLER_109_539 VDD VSS sg13g2_decap_8
XFILLER_164_634 VDD VSS sg13g2_decap_8
XFILLER_104_1279 VDD VSS sg13g2_decap_4
XFILLER_128_35 VDD VSS sg13g2_decap_8
XFILLER_163_133 VDD VSS sg13g2_decap_8
X_09016_ _09019_/A _09141_/A _09016_/B _09016_/C VDD VSS sg13g2_nand3_1
XFILLER_145_881 VDD VSS sg13g2_fill_2
XFILLER_88_28 VDD VSS sg13g2_decap_4
XFILLER_151_328 VDD VSS sg13g2_fill_1
XFILLER_5_7 VDD VSS sg13g2_decap_8
XFILLER_77_106 VDD VSS sg13g2_decap_8
Xfanout620 _13611_/A2 _08828_/Y VDD VSS sg13g2_buf_1
XFILLER_28_1350 VDD VSS sg13g2_decap_8
XFILLER_144_56 VDD VSS sg13g2_decap_8
Xfanout631 _08238_/B _07997_/Y VDD VSS sg13g2_buf_1
XFILLER_99_990 VDD VSS sg13g2_decap_8
XFILLER_77_117 VDD VSS sg13g2_fill_2
XFILLER_120_748 VDD VSS sg13g2_fill_2
Xfanout642 _12763_/C1 _12624_/C1 VDD VSS sg13g2_buf_1
X_09918_ _14503_/D _14503_/Q _09918_/A1 _09936_/S VDD VSS sg13g2_mux2_1
Xfanout653 _13275_/A2 _12918_/A2 VDD VSS sg13g2_buf_1
XFILLER_144_78 VDD VSS sg13g2_decap_4
XFILLER_24_1225 VDD VSS sg13g2_decap_8
Xfanout664 _11045_/B1 _10999_/B1 VDD VSS sg13g2_buf_1
Xfanout675 _12294_/B1 _12339_/A1 VDD VSS sg13g2_buf_1
Xfanout686 _13477_/S _13479_/S VDD VSS sg13g2_buf_1
XFILLER_19_707 VDD VSS sg13g2_decap_8
X_13753__2426 _13753_/RESET_B VDD VSS sg13g2_tiehi
Xfanout697 _11745_/B _11763_/B VDD VSS sg13g2_buf_1
X_09849_ _14436_/D _14436_/Q _10047_/A0 _09867_/S VDD VSS sg13g2_mux2_1
XFILLER_37_21 VDD VSS sg13g2_decap_8
X_13899__2280 _13899_/RESET_B VDD VSS sg13g2_tiehi
XFILLER_85_172 VDD VSS sg13g2_decap_4
XFILLER_18_217 VDD VSS sg13g2_decap_8
XFILLER_98_1348 VDD VSS sg13g2_decap_4
XFILLER_74_846 VDD VSS sg13g2_decap_8
X_12860_ _12876_/A _12861_/B _12861_/A VDD VSS sg13g2_nor2_1
XFILLER_6_1190 VDD VSS sg13g2_decap_8
XFILLER_2_1043 VDD VSS sg13g2_decap_8
X_11811_ _11811_/Y _11814_/S0 _14636_/Q VDD VSS sg13g2_nand2b_1
XFILLER_37_98 VDD VSS sg13g2_decap_8
XFILLER_160_77 VDD VSS sg13g2_decap_8
XFILLER_61_518 VDD VSS sg13g2_decap_8
X_12791_ _12792_/B _13662_/Q _12358_/Y _12790_/X _12791_/B2 _12791_/C1 VDD VSS sg13g2_a221oi_1
XFILLER_15_924 VDD VSS sg13g2_decap_8
XFILLER_82_890 VDD VSS sg13g2_decap_4
XFILLER_42_721 VDD VSS sg13g2_decap_8
X_14530_ _14530_/Q clkload30/A _14530_/D _14530_/RESET_B VDD VSS sg13g2_dfrbpq_1
XFILLER_148_1162 VDD VSS sg13g2_decap_4
X_14133__2046 _14133_/RESET_B VDD VSS sg13g2_tiehi
X_11742_ _11743_/B _11742_/A _11742_/B _11760_/C VDD VSS sg13g2_nand3_1
XFILLER_148_1173 VDD VSS sg13g2_fill_2
XFILLER_14_434 VDD VSS sg13g2_decap_8
XFILLER_159_406 VDD VSS sg13g2_decap_8
XFILLER_53_42 VDD VSS sg13g2_decap_8
XFILLER_42_743 VDD VSS sg13g2_decap_8
XFILLER_18_1029 VDD VSS sg13g2_decap_8
XFILLER_149_0 VDD VSS sg13g2_decap_8
XFILLER_169_42 VDD VSS sg13g2_decap_8
X_14461_ _14461_/Q clkload45/A _14461_/D _14461_/RESET_B VDD VSS sg13g2_dfrbpq_1
XFILLER_57_1089 VDD VSS sg13g2_decap_8
X_11673_ _11673_/Y _11676_/A1 _14568_/Q VDD VSS sg13g2_nand2b_1
XFILLER_144_1059 VDD VSS sg13g2_decap_8
XFILLER_35_1343 VDD VSS sg13g2_decap_8
XFILLER_122_1302 VDD VSS sg13g2_fill_1
X_13412_ _13448_/C _15198_/Q _13412_/B _13412_/C VDD VSS sg13g2_nor3_1
X_10624_ _10626_/C _14883_/Q _10636_/A VDD VSS sg13g2_nand2b_1
X_14392_ _14392_/Q _14744_/CLK _14392_/D _14392_/RESET_B VDD VSS sg13g2_dfrbpq_1
XFILLER_10_651 VDD VSS sg13g2_decap_8
XFILLER_31_1218 VDD VSS sg13g2_decap_8
XFILLER_167_483 VDD VSS sg13g2_decap_8
X_13343_ _13343_/Y _13346_/A _15069_/Q VDD VSS sg13g2_nand2_1
XFILLER_70_1289 VDD VSS sg13g2_decap_8
XFILLER_155_634 VDD VSS sg13g2_decap_8
X_10555_ _10557_/A _14867_/Q _10555_/B VDD VSS sg13g2_nand2b_1
XFILLER_122_1368 VDD VSS sg13g2_decap_8
XFILLER_154_133 VDD VSS sg13g2_fill_1
XFILLER_6_644 VDD VSS sg13g2_decap_8
X_13274_ _13274_/Y _14830_/Q _13206_/B _13249_/B _14894_/Q _13274_/C1 VDD VSS sg13g2_a221oi_1
X_10486_ _10512_/B _14849_/Q _10489_/C _14847_/Q _10486_/D VDD VSS sg13g2_nand4_1
XFILLER_5_154 VDD VSS sg13g2_decap_8
X_15013_ _15013_/Q _15015_/CLK _15013_/D _15013_/RESET_B VDD VSS sg13g2_dfrbpq_1
XFILLER_155_1100 VDD VSS sg13g2_decap_8
X_12225_ _12225_/Y _12224_/Y _12223_/X _12204_/Y _12294_/B1 _12271_/A VDD VSS sg13g2_a221oi_1
XFILLER_154_199 VDD VSS sg13g2_decap_8
XFILLER_29_1114 VDD VSS sg13g2_decap_8
XFILLER_159_1280 VDD VSS sg13g2_decap_4
XFILLER_68_1174 VDD VSS sg13g2_decap_8
X_12156_ _12156_/Y _12156_/A _12156_/B _12156_/C VDD VSS sg13g2_nand3_1
XFILLER_2_861 VDD VSS sg13g2_decap_8
XFILLER_38_7 VDD VSS sg13g2_decap_8
XFILLER_151_1008 VDD VSS sg13g2_fill_2
X_11107_ _11107_/Y _11097_/Y _10764_/X _11139_/B1 VDD VSS sg13g2_a21oi_1
XFILLER_1_371 VDD VSS sg13g2_decap_8
X_12087_ _12087_/X _14132_/Q _14164_/Q _12090_/A VDD VSS sg13g2_mux2_1
X_11038_ _11044_/A _11064_/C _11036_/Y _11037_/Y VDD VSS sg13g2_o21ai_1
X_14343__1836 _14343_/RESET_B VDD VSS sg13g2_tiehi
XFILLER_92_610 VDD VSS sg13g2_decap_8
XFILLER_64_301 VDD VSS sg13g2_decap_8
XFILLER_42_1369 VDD VSS sg13g2_decap_8
X_13729__2450 _13729_/RESET_B VDD VSS sg13g2_tiehi
X_14489__1690 _14489_/RESET_B VDD VSS sg13g2_tiehi
XFILLER_76_172 VDD VSS sg13g2_decap_8
XFILLER_94_60 VDD VSS sg13g2_fill_2
XFILLER_92_654 VDD VSS sg13g2_decap_8
XFILLER_37_559 VDD VSS sg13g2_decap_4
XFILLER_40_1082 VDD VSS sg13g2_decap_8
XFILLER_64_378 VDD VSS sg13g2_decap_8
X_12989_ _12993_/B _12943_/A _12989_/B _12989_/C VDD VSS sg13g2_nand3b_1
XFILLER_18_784 VDD VSS sg13g2_decap_8
XFILLER_45_592 VDD VSS sg13g2_fill_2
X_14728_ _14728_/Q _14728_/CLK _14728_/D _14728_/RESET_B VDD VSS sg13g2_dfrbpq_1
XFILLER_17_294 VDD VSS sg13g2_decap_8
XFILLER_33_754 VDD VSS sg13g2_decap_8
X_14109__2070 _14109_/RESET_B VDD VSS sg13g2_tiehi
XFILLER_75_1189 VDD VSS sg13g2_decap_8
XFILLER_127_1257 VDD VSS sg13g2_fill_2
X_14659_ _14659_/Q _14659_/CLK _14659_/D _14659_/RESET_B VDD VSS sg13g2_dfrbpq_1
XFILLER_32_264 VDD VSS sg13g2_fill_2
XFILLER_21_938 VDD VSS sg13g2_decap_8
XFILLER_119_804 VDD VSS sg13g2_fill_1
X_08180_ _08187_/B _08246_/A1 _08170_/X _08397_/A _08179_/Y VDD VSS sg13g2_a22oi_1
XFILLER_20_448 VDD VSS sg13g2_decap_8
XFILLER_158_483 VDD VSS sg13g2_decap_4
XFILLER_64_0 VDD VSS sg13g2_decap_8
X_13831__2348 _13831_/RESET_B VDD VSS sg13g2_tiehi
XFILLER_12_1162 VDD VSS sg13g2_decap_8
XFILLER_161_615 VDD VSS sg13g2_decap_8
X_14591__1588 _14591_/RESET_B VDD VSS sg13g2_tiehi
XFILLER_103_1290 VDD VSS sg13g2_decap_8
XFILLER_138_1342 VDD VSS sg13g2_fill_2
XFILLER_160_147 VDD VSS sg13g2_decap_8
XFILLER_88_916 VDD VSS sg13g2_fill_1
XFILLER_99_297 VDD VSS sg13g2_decap_8
XFILLER_173_1288 VDD VSS sg13g2_decap_8
X_07964_ _07964_/Y _08641_/C _07963_/Y _07962_/Y VDD VSS sg13g2_a21oi_1
XFILLER_4_91 VDD VSS sg13g2_decap_8
X_09703_ _14295_/D _09703_/A0 _14295_/Q _09703_/S VDD VSS sg13g2_mux2_1
XFILLER_114_37 VDD VSS sg13g2_fill_1
XFILLER_96_982 VDD VSS sg13g2_decap_8
XFILLER_110_770 VDD VSS sg13g2_fill_1
X_07895_ _08037_/A _07900_/B _07903_/B VDD VSS sg13g2_or2_1
XFILLER_114_59 VDD VSS sg13g2_decap_4
XFILLER_68_695 VDD VSS sg13g2_decap_8
X_14319__1860 _14319_/RESET_B VDD VSS sg13g2_tiehi
X_09634_ _14230_/D _09900_/A0 _14230_/Q _09634_/S VDD VSS sg13g2_mux2_1
XFILLER_3_1330 VDD VSS sg13g2_decap_8
XFILLER_28_548 VDD VSS sg13g2_decap_8
XFILLER_55_345 VDD VSS sg13g2_decap_8
XFILLER_55_367 VDD VSS sg13g2_decap_8
X_09565_ _14163_/D _10095_/A0 _14163_/Q _09567_/S VDD VSS sg13g2_mux2_1
XFILLER_83_687 VDD VSS sg13g2_fill_2
XFILLER_130_14 VDD VSS sg13g2_decap_8
XFILLER_167_1059 VDD VSS sg13g2_decap_8
XFILLER_58_1343 VDD VSS sg13g2_decap_8
X_08516_ _08517_/D _07816_/X _08541_/A _08515_/Y _07815_/X _08514_/Y VDD VSS sg13g2_a221oi_1
XFILLER_82_197 VDD VSS sg13g2_decap_8
XFILLER_70_337 VDD VSS sg13g2_decap_4
XFILLER_58_1354 VDD VSS sg13g2_fill_1
X_09496_ _14096_/D _10159_/A1 _14096_/Q _09504_/S VDD VSS sg13g2_mux2_1
XFILLER_19_1316 VDD VSS sg13g2_decap_8
XFILLER_93_1256 VDD VSS sg13g2_decap_8
XFILLER_58_1376 VDD VSS sg13g2_decap_8
XFILLER_54_1207 VDD VSS sg13g2_fill_1
XFILLER_23_231 VDD VSS sg13g2_decap_8
XFILLER_168_203 VDD VSS sg13g2_decap_8
X_08447_ _08447_/X _08649_/S _08447_/B VDD VSS sg13g2_and2_1
XFILLER_12_938 VDD VSS sg13g2_decap_8
XFILLER_142_7 VDD VSS sg13g2_decap_8
XFILLER_169_759 VDD VSS sg13g2_fill_2
XFILLER_11_448 VDD VSS sg13g2_decap_8
X_08378_ _08378_/Y _13525_/A _08376_/X _08377_/Y VDD VSS sg13g2_o21ai_1
XFILLER_23_56 VDD VSS sg13g2_decap_8
XFILLER_139_56 VDD VSS sg13g2_decap_8
XFILLER_164_420 VDD VSS sg13g2_decap_8
XFILLER_99_38 VDD VSS sg13g2_decap_8
XFILLER_109_358 VDD VSS sg13g2_fill_1
XFILLER_30_1240 VDD VSS sg13g2_decap_8
X_10340_ _14806_/D _10414_/B _10357_/D _10337_/B _07647_/Y _13328_/A VDD VSS sg13g2_a221oi_1
XFILLER_104_1098 VDD VSS sg13g2_decap_4
X_14421__1758 _14421_/RESET_B VDD VSS sg13g2_tiehi
X_13807__2372 _13807_/RESET_B VDD VSS sg13g2_tiehi
XFILLER_164_497 VDD VSS sg13g2_decap_8
XFILLER_174_1019 VDD VSS sg13g2_decap_4
XFILLER_152_659 VDD VSS sg13g2_fill_2
X_10271_ _10271_/Y _10305_/A _10295_/C VDD VSS sg13g2_nand2b_1
XFILLER_3_658 VDD VSS sg13g2_decap_8
X_12010_ _12055_/D _12008_/Y _12010_/B VDD VSS sg13g2_nand2b_1
XFILLER_155_77 VDD VSS sg13g2_decap_8
XFILLER_133_884 VDD VSS sg13g2_fill_1
XFILLER_152_1306 VDD VSS sg13g2_fill_2
XFILLER_2_168 VDD VSS sg13g2_decap_8
Xfanout1404 _12751_/A1 _12956_/B VDD VSS sg13g2_buf_1
Xfanout450 _09567_/S _09571_/S VDD VSS sg13g2_buf_1
XFILLER_48_42 VDD VSS sg13g2_decap_8
Xfanout461 _09472_/S wire462/X VDD VSS sg13g2_buf_1
XFILLER_171_21 VDD VSS sg13g2_decap_8
Xfanout472 _09373_/S _09342_/Y VDD VSS sg13g2_buf_1
X_13961_ _13961_/Q clkload20/A _13961_/D _13961_/RESET_B VDD VSS sg13g2_dfrbpq_1
XFILLER_8_1274 VDD VSS sg13g2_decap_8
XFILLER_19_504 VDD VSS sg13g2_decap_8
Xfanout483 _08932_/S _08941_/S VDD VSS sg13g2_buf_1
XFILLER_98_1101 VDD VSS sg13g2_fill_1
Xfanout494 _08588_/B _08000_/X VDD VSS sg13g2_buf_1
XFILLER_98_1112 VDD VSS sg13g2_decap_4
XFILLER_4_1127 VDD VSS sg13g2_decap_8
XFILLER_150_1063 VDD VSS sg13g2_decap_8
XFILLER_48_97 VDD VSS sg13g2_decap_8
X_12912_ _12914_/B _12911_/Y _12799_/X input19/X _12801_/Y VDD VSS sg13g2_a22oi_1
XFILLER_58_183 VDD VSS sg13g2_decap_8
XFILLER_47_857 VDD VSS sg13g2_decap_8
X_13892_ _13892_/Q _14703_/CLK _13892_/D _13892_/RESET_B VDD VSS sg13g2_dfrbpq_1
XFILLER_24_1099 VDD VSS sg13g2_decap_8
XFILLER_171_98 VDD VSS sg13g2_decap_8
XFILLER_0_49 VDD VSS sg13g2_decap_8
X_12843_ _12845_/C _13609_/A _12899_/C input6/X _12883_/A VDD VSS sg13g2_nand4_1
XFILLER_46_389 VDD VSS sg13g2_fill_1
XFILLER_15_721 VDD VSS sg13g2_decap_8
X_14951__2642 _14951_/RESET_B VDD VSS sg13g2_tiehi
X_12774_ _12774_/X _12767_/X _12771_/X _12766_/X _12770_/X _12553_/S _12775_/S1 VDD
+ VSS sg13g2_mux4_1
XFILLER_14_231 VDD VSS sg13g2_decap_8
X_14513_ _14513_/Q _14667_/CLK _14513_/D _14513_/RESET_B VDD VSS sg13g2_dfrbpq_1
XFILLER_9_14 VDD VSS sg13g2_decap_8
X_11725_ _11725_/Y _11726_/A _13678_/Q VDD VSS sg13g2_nor2_1
XFILLER_15_798 VDD VSS sg13g2_decap_8
XFILLER_42_584 VDD VSS sg13g2_decap_8
X_14444_ _14444_/Q clkload13/A _14444_/D _14444_/RESET_B VDD VSS sg13g2_dfrbpq_1
X_14958__2629 _14958_/RESET_B VDD VSS sg13g2_tiehi
XFILLER_80_51 VDD VSS sg13g2_decap_4
XFILLER_35_1140 VDD VSS sg13g2_decap_4
X_11656_ _11656_/Y wire523/X _11654_/X _12156_/A VDD VSS sg13g2_a21oi_1
XFILLER_35_1151 VDD VSS sg13g2_fill_1
XFILLER_70_1053 VDD VSS sg13g2_decap_8
XFILLER_126_1290 VDD VSS sg13g2_decap_8
XFILLER_156_932 VDD VSS sg13g2_decap_8
XFILLER_80_84 VDD VSS sg13g2_fill_2
X_10607_ _10614_/A _14878_/Q _14877_/Q _10607_/C _10607_/D VDD VSS sg13g2_nand4_1
XFILLER_167_280 VDD VSS sg13g2_decap_8
X_14375_ _14375_/Q _14703_/CLK _14375_/D _14375_/RESET_B VDD VSS sg13g2_dfrbpq_1
XFILLER_7_931 VDD VSS sg13g2_decap_8
XFILLER_35_1195 VDD VSS sg13g2_fill_2
XFILLER_155_431 VDD VSS sg13g2_decap_8
X_11587_ _11587_/Y _11586_/Y _11585_/Y _11572_/X _11722_/B2 _12271_/A VDD VSS sg13g2_a221oi_1
XFILLER_127_133 VDD VSS sg13g2_fill_1
XFILLER_122_1176 VDD VSS sg13g2_decap_8
XFILLER_156_987 VDD VSS sg13g2_fill_1
X_13326_ _15066_/D _13328_/A _13326_/B VDD VSS sg13g2_nor2_1
XFILLER_6_441 VDD VSS sg13g2_decap_8
XFILLER_155_464 VDD VSS sg13g2_decap_8
X_10538_ _10547_/D _10538_/A _10538_/B _10567_/A _10567_/B VDD VSS sg13g2_nor4_1
XFILLER_115_328 VDD VSS sg13g2_decap_8
XFILLER_170_434 VDD VSS sg13g2_decap_8
X_13257_ _13270_/A _14924_/Q _13663_/Q VDD VSS sg13g2_nand2_1
X_10469_ _10472_/C _10500_/A _10473_/D _14845_/Q VDD VSS sg13g2_a21oi_1
X_12208_ _12208_/Y _12207_/X _12219_/S VDD VSS sg13g2_nand2b_1
X_13188_ _13202_/A _13188_/A _13225_/B _13225_/A VDD VSS sg13g2_nand3_1
XFILLER_96_223 VDD VSS sg13g2_fill_2
X_12139_ _12139_/X _14133_/Q _14165_/Q _14197_/Q _14229_/Q _12140_/S0 _12140_/S1 VDD
+ VSS sg13g2_mux4_1
XFILLER_42_1100 VDD VSS sg13g2_decap_8
X_14576__1603 _14576_/RESET_B VDD VSS sg13g2_tiehi
XFILLER_111_567 VDD VSS sg13g2_decap_8
XFILLER_78_971 VDD VSS sg13g2_fill_2
XFILLER_42_1122 VDD VSS sg13g2_fill_1
XFILLER_111_589 VDD VSS sg13g2_fill_1
XFILLER_84_429 VDD VSS sg13g2_fill_2
XFILLER_38_835 VDD VSS sg13g2_decap_8
XFILLER_168_1302 VDD VSS sg13g2_decap_8
X_07680_ _07680_/Y _13293_/A _11243_/C _07679_/Y VDD VSS sg13g2_a21oi_1
XFILLER_37_334 VDD VSS sg13g2_decap_8
X_16878_ _16878_/X _16878_/A VDD VSS sg13g2_buf_1
XFILLER_53_805 VDD VSS sg13g2_decap_8
XFILLER_65_676 VDD VSS sg13g2_decap_8
XFILLER_64_164 VDD VSS sg13g2_fill_2
XFILLER_37_378 VDD VSS sg13g2_decap_8
XFILLER_52_315 VDD VSS sg13g2_fill_2
XFILLER_53_849 VDD VSS sg13g2_decap_8
XFILLER_168_1379 VDD VSS sg13g2_fill_1
XFILLER_80_646 VDD VSS sg13g2_decap_8
XFILLER_18_581 VDD VSS sg13g2_decap_8
X_09350_ _13954_/D _10078_/A0 _13954_/Q _09370_/S VDD VSS sg13g2_mux2_1
XFILLER_64_197 VDD VSS sg13g2_decap_8
XFILLER_166_1070 VDD VSS sg13g2_decap_8
X_08301_ _08301_/X _08215_/X _08300_/X _08452_/D VDD VSS sg13g2_mux2_1
XFILLER_100_28 VDD VSS sg13g2_decap_8
XFILLER_127_1043 VDD VSS sg13g2_decap_8
X_09281_ _13889_/D _13889_/Q _09780_/A0 _09301_/S VDD VSS sg13g2_mux2_1
XFILLER_33_584 VDD VSS sg13g2_decap_8
XFILLER_21_735 VDD VSS sg13g2_decap_8
X_08232_ _08232_/Y _07924_/C _08230_/Y _08231_/Y VDD VSS sg13g2_a21oi_1
XFILLER_147_910 VDD VSS sg13g2_fill_1
XFILLER_166_729 VDD VSS sg13g2_decap_4
XFILLER_53_1251 VDD VSS sg13g2_decap_8
XFILLER_20_245 VDD VSS sg13g2_decap_8
XFILLER_119_612 VDD VSS sg13g2_fill_1
XFILLER_165_217 VDD VSS sg13g2_decap_8
XFILLER_118_100 VDD VSS sg13g2_decap_8
XFILLER_140_1232 VDD VSS sg13g2_decap_8
X_08163_ _08163_/Y _08160_/A _08162_/Y _08160_/Y VDD VSS sg13g2_a21oi_1
XFILLER_14_1246 VDD VSS sg13g2_decap_8
XFILLER_101_1205 VDD VSS sg13g2_fill_2
XFILLER_158_291 VDD VSS sg13g2_decap_8
XFILLER_118_155 VDD VSS sg13g2_fill_1
XFILLER_119_689 VDD VSS sg13g2_fill_1
XFILLER_162_924 VDD VSS sg13g2_decap_8
X_08094_ _08094_/X _08384_/A1 _07945_/B _07790_/A _07826_/B _08402_/A _08063_/A VDD
+ VSS sg13g2_mux4_1
XFILLER_134_626 VDD VSS sg13g2_decap_8
XFILLER_161_401 VDD VSS sg13g2_decap_8
XFILLER_109_59 VDD VSS sg13g2_decap_4
XFILLER_118_177 VDD VSS sg13g2_decap_8
XFILLER_174_795 VDD VSS sg13g2_decap_4
Xclkload60 clkload60/Y clkload60/A VDD VSS sg13g2_inv_4
Xclkload71 clkload71/X clkload71/A VDD VSS sg13g2_buf_8
XFILLER_173_294 VDD VSS sg13g2_decap_8
XFILLER_115_851 VDD VSS sg13g2_fill_1
XFILLER_114_350 VDD VSS sg13g2_fill_1
XFILLER_115_884 VDD VSS sg13g2_decap_4
XFILLER_125_14 VDD VSS sg13g2_decap_8
XFILLER_87_201 VDD VSS sg13g2_decap_8
XFILLER_142_692 VDD VSS sg13g2_decap_8
XFILLER_47_1088 VDD VSS sg13g2_decap_8
XFILLER_141_191 VDD VSS sg13g2_decap_8
X_08996_ _08996_/Y _08993_/X _08995_/Y _08992_/Y VDD VSS sg13g2_o21ai_1
XFILLER_47_1099 VDD VSS sg13g2_fill_2
XFILLER_102_556 VDD VSS sg13g2_fill_2
XFILLER_85_18 VDD VSS sg13g2_fill_2
XFILLER_130_887 VDD VSS sg13g2_decap_8
XFILLER_87_267 VDD VSS sg13g2_decap_8
X_07947_ _08443_/A _08435_/A _08574_/A _07945_/Y VDD VSS sg13g2_o21ai_1
XFILLER_151_1383 VDD VSS sg13g2_fill_1
X_15138__2681 _15138_/RESET_B VDD VSS sg13g2_tiehi
XFILLER_60_1277 VDD VSS sg13g2_decap_8
X_07878_ _07878_/Y _08105_/A _08338_/B VDD VSS sg13g2_nand2_1
XFILLER_21_1239 VDD VSS sg13g2_decap_8
XFILLER_18_56 VDD VSS sg13g2_decap_8
XFILLER_141_35 VDD VSS sg13g2_decap_8
XFILLER_83_451 VDD VSS sg13g2_decap_8
X_09617_ _14213_/D _10048_/A0 _14213_/Q _09629_/S VDD VSS sg13g2_mux2_1
XFILLER_55_153 VDD VSS sg13g2_decap_8
XFILLER_16_518 VDD VSS sg13g2_decap_8
XFILLER_55_164 VDD VSS sg13g2_fill_2
XFILLER_43_326 VDD VSS sg13g2_decap_8
X_09548_ _14146_/D _10012_/A0 _14146_/Q _09567_/S VDD VSS sg13g2_mux2_1
XFILLER_58_1140 VDD VSS sg13g2_decap_8
XFILLER_19_1113 VDD VSS sg13g2_decap_8
X_13677__2518 _13677_/RESET_B VDD VSS sg13g2_tiehi
XFILLER_58_1184 VDD VSS sg13g2_decap_8
X_09479_ _14079_/D _10109_/A0 _14079_/Q _09497_/S VDD VSS sg13g2_mux2_1
XFILLER_70_189 VDD VSS sg13g2_decap_8
XFILLER_54_1026 VDD VSS sg13g2_decap_8
XFILLER_106_1105 VDD VSS sg13g2_fill_1
XFILLER_51_370 VDD VSS sg13g2_decap_8
XFILLER_34_77 VDD VSS sg13g2_decap_8
XFILLER_12_735 VDD VSS sg13g2_decap_8
XFILLER_169_567 VDD VSS sg13g2_decap_8
X_11510_ _11510_/X _14243_/Q _14275_/Q _14307_/Q _14339_/Q _12140_/S0 _12140_/S1 VDD
+ VSS sg13g2_mux4_1
X_12490_ _12490_/X _14245_/Q _14277_/Q _14309_/Q _14341_/Q _12655_/S0 _12655_/S1 VDD
+ VSS sg13g2_mux4_1
XFILLER_11_245 VDD VSS sg13g2_decap_8
XFILLER_138_910 VDD VSS sg13g2_fill_1
XFILLER_32_1302 VDD VSS sg13g2_decap_8
XFILLER_8_728 VDD VSS sg13g2_decap_8
X_11441_ _11441_/X _13728_/Q _14080_/Q _14432_/Q _14528_/Q _12215_/S0 _12213_/S1 VDD
+ VSS sg13g2_mux4_1
XFILLER_50_21 VDD VSS sg13g2_decap_8
XFILLER_165_740 VDD VSS sg13g2_fill_1
X_14654__1525 _14654_/RESET_B VDD VSS sg13g2_tiehi
XFILLER_7_238 VDD VSS sg13g2_decap_8
XFILLER_137_442 VDD VSS sg13g2_fill_1
XFILLER_165_762 VDD VSS sg13g2_fill_2
XFILLER_166_21 VDD VSS sg13g2_decap_8
X_14160_ _14160_/Q clkload7/A _14160_/D _14160_/RESET_B VDD VSS sg13g2_dfrbpq_1
X_11372_ _11374_/A _11373_/A _14174_/Q VDD VSS sg13g2_nand2b_1
XFILLER_165_784 VDD VSS sg13g2_decap_8
XFILLER_124_103 VDD VSS sg13g2_decap_4
X_13111_ _15040_/D _13141_/A _13111_/B VDD VSS sg13g2_nor2_1
X_10323_ _10325_/A _14801_/Q _10323_/B VDD VSS sg13g2_nand2b_1
XFILLER_164_294 VDD VSS sg13g2_decap_8
X_14083__2096 _14083_/RESET_B VDD VSS sg13g2_tiehi
X_14091_ _14091_/Q clkload0/A _14091_/D _14091_/RESET_B VDD VSS sg13g2_dfrbpq_1
XFILLER_4_945 VDD VSS sg13g2_decap_8
XFILLER_124_136 VDD VSS sg13g2_decap_8
XFILLER_166_98 VDD VSS sg13g2_decap_8
XFILLER_153_979 VDD VSS sg13g2_decap_4
X_13042_ _13043_/B _13042_/A _13042_/B _13042_/C VDD VSS sg13g2_nand3_1
XFILLER_3_455 VDD VSS sg13g2_decap_8
X_10254_ _10256_/A _14779_/Q _10258_/D _14780_/Q VDD VSS sg13g2_a21o_1
XFILLER_65_1133 VDD VSS sg13g2_decap_8
Xfanout1201 _10489_/C _14848_/Q VDD VSS sg13g2_buf_1
XFILLER_105_394 VDD VSS sg13g2_fill_2
XFILLER_156_1294 VDD VSS sg13g2_fill_2
Xfanout1212 _13613_/C _14748_/Q VDD VSS sg13g2_buf_1
XFILLER_120_331 VDD VSS sg13g2_decap_8
Xfanout1223 _11559_/C fanout1227/X VDD VSS sg13g2_buf_1
X_10185_ _10185_/Y _10185_/A _10185_/B _10185_/C VDD VSS sg13g2_nand3_1
XFILLER_65_1188 VDD VSS sg13g2_decap_8
XFILLER_61_1019 VDD VSS sg13g2_decap_4
XFILLER_152_1147 VDD VSS sg13g2_decap_8
X_15022__2565 _15022_/RESET_B VDD VSS sg13g2_tiehi
Xfanout1234 _12332_/B1 _11957_/A VDD VSS sg13g2_buf_1
Xfanout1245 _12219_/S _12308_/C VDD VSS sg13g2_buf_1
XFILLER_120_364 VDD VSS sg13g2_decap_8
Xfanout1256 _11925_/S1 _11972_/S1 VDD VSS sg13g2_buf_1
XFILLER_121_898 VDD VSS sg13g2_decap_4
Xfanout1267 _11878_/B1 _11229_/S1 VDD VSS sg13g2_buf_1
XFILLER_8_1071 VDD VSS sg13g2_decap_8
X_14993_ _14993_/Q _15247_/CLK _14993_/D _14993_/RESET_B VDD VSS sg13g2_dfrbpq_1
Xfanout280 _09949_/A1 _10048_/A0 VDD VSS sg13g2_buf_1
Xfanout1278 _12137_/S1 fanout1291/X VDD VSS sg13g2_buf_1
XFILLER_19_301 VDD VSS sg13g2_decap_8
XFILLER_115_80 VDD VSS sg13g2_decap_8
Xfanout291 _09780_/A0 _09912_/A1 VDD VSS sg13g2_buf_1
Xfanout1289 _12213_/S1 _11469_/S1 VDD VSS sg13g2_buf_1
XFILLER_93_248 VDD VSS sg13g2_decap_4
XFILLER_75_952 VDD VSS sg13g2_decap_8
X_13944_ _13944_/Q _14984_/CLK _13944_/D _13944_/RESET_B VDD VSS sg13g2_dfrbpq_1
XFILLER_74_451 VDD VSS sg13g2_fill_1
XFILLER_75_985 VDD VSS sg13g2_decap_8
XFILLER_19_378 VDD VSS sg13g2_decap_8
X_13875_ _13875_/Q clkload24/A _13875_/D _13875_/RESET_B VDD VSS sg13g2_dfrbpq_1
XFILLER_61_123 VDD VSS sg13g2_decap_8
X_12826_ _12826_/X _12900_/A _12900_/B _12884_/C input13/X VDD VSS sg13g2_and4_1
XFILLER_62_657 VDD VSS sg13g2_decap_8
XFILLER_163_1221 VDD VSS sg13g2_decap_4
XFILLER_72_1104 VDD VSS sg13g2_fill_1
X_12757_ _12757_/X _13752_/Q _14104_/Q _14456_/Q _14552_/Q _12757_/S0 _12757_/S1 VDD
+ VSS sg13g2_mux4_1
XFILLER_61_189 VDD VSS sg13g2_decap_4
XFILLER_43_893 VDD VSS sg13g2_fill_2
XFILLER_15_595 VDD VSS sg13g2_decap_8
X_11708_ _11708_/X _14569_/Q _14601_/Q _14633_/Q _14665_/Q _12282_/S0 _12282_/S1 VDD
+ VSS sg13g2_mux4_1
XFILLER_37_1279 VDD VSS sg13g2_decap_4
XFILLER_148_729 VDD VSS sg13g2_fill_2
XFILLER_163_1287 VDD VSS sg13g2_fill_2
X_12688_ _12688_/X _14387_/Q _14419_/Q _14483_/Q _14515_/Q _12689_/S0 _12689_/S1 VDD
+ VSS sg13g2_mux4_1
X_14293__1886 _14293_/RESET_B VDD VSS sg13g2_tiehi
X_14427_ _14427_/Q clkload40/A _14427_/D _14427_/RESET_B VDD VSS sg13g2_dfrbpq_1
X_11639_ _11639_/Y _11570_/A _13683_/Q _13682_/Q _11591_/A VDD VSS sg13g2_a22oi_1
XFILLER_128_431 VDD VSS sg13g2_decap_8
XFILLER_144_902 VDD VSS sg13g2_fill_2
X_14358_ _14358_/Q clkload28/A _14358_/D _14358_/RESET_B VDD VSS sg13g2_dfrbpq_1
XFILLER_129_998 VDD VSS sg13g2_decap_4
XFILLER_115_103 VDD VSS sg13g2_fill_1
XFILLER_143_412 VDD VSS sg13g2_fill_2
XFILLER_143_423 VDD VSS sg13g2_fill_2
X_13309_ _13309_/Y _13499_/C _13303_/A _13306_/B VDD VSS sg13g2_a21oi_1
XFILLER_171_743 VDD VSS sg13g2_decap_4
XFILLER_116_659 VDD VSS sg13g2_decap_8
XFILLER_170_231 VDD VSS sg13g2_decap_8
X_14289_ _14289_/Q _14667_/CLK _14289_/D _14289_/RESET_B VDD VSS sg13g2_dfrbpq_1
XFILLER_131_607 VDD VSS sg13g2_fill_2
XFILLER_48_1342 VDD VSS sg13g2_decap_8
XFILLER_112_810 VDD VSS sg13g2_decap_8
XFILLER_174_1350 VDD VSS sg13g2_decap_4
XFILLER_83_1244 VDD VSS sg13g2_decap_8
XFILLER_48_1375 VDD VSS sg13g2_decap_8
XFILLER_97_532 VDD VSS sg13g2_decap_8
X_08850_ _08850_/X _08849_/X _07912_/B _08860_/S VDD VSS sg13g2_mux2_1
XFILLER_174_1383 VDD VSS sg13g2_fill_1
XFILLER_123_191 VDD VSS sg13g2_decap_8
X_07801_ _07950_/A _15008_/Q _08471_/B VDD VSS sg13g2_nand2b_1
XFILLER_27_0 VDD VSS sg13g2_decap_8
XFILLER_69_278 VDD VSS sg13g2_decap_4
X_08781_ _08781_/Y _13679_/Q _08781_/B VDD VSS sg13g2_nor2_1
XFILLER_111_386 VDD VSS sg13g2_fill_1
X_13781__2398 _13781_/RESET_B VDD VSS sg13g2_tiehi
X_07732_ _08429_/B _15097_/Q _15092_/Q VDD VSS sg13g2_nor2_1
XFILLER_38_654 VDD VSS sg13g2_decap_8
XFILLER_93_760 VDD VSS sg13g2_fill_2
XFILLER_37_142 VDD VSS sg13g2_fill_2
XFILLER_168_1121 VDD VSS sg13g2_decap_8
XFILLER_53_602 VDD VSS sg13g2_fill_2
XFILLER_38_687 VDD VSS sg13g2_decap_8
XFILLER_26_827 VDD VSS sg13g2_decap_8
XFILLER_1_70 VDD VSS sg13g2_decap_8
X_07663_ _10187_/S input36/X input3/X _14749_/Q VDD VSS sg13g2_o21ai_1
XFILLER_81_922 VDD VSS sg13g2_decap_4
XFILLER_25_304 VDD VSS sg13g2_fill_1
XFILLER_0_1311 VDD VSS sg13g2_decap_8
XFILLER_168_1143 VDD VSS sg13g2_decap_8
X_14732__1447 _14732_/RESET_B VDD VSS sg13g2_tiehi
XFILLER_92_270 VDD VSS sg13g2_decap_4
XFILLER_168_1154 VDD VSS sg13g2_fill_2
XFILLER_52_112 VDD VSS sg13g2_decap_8
X_09402_ _14005_/D _10031_/A0 _14005_/Q _09403_/S VDD VSS sg13g2_mux2_1
XFILLER_81_955 VDD VSS sg13g2_decap_8
Xclkbuf_leaf_123_clk_i clkload11/A clkbuf_5_4__f_clk_i/X VDD VSS sg13g2_buf_8
XFILLER_94_1351 VDD VSS sg13g2_decap_4
X_09333_ _13940_/D _09931_/A1 _13940_/Q _09339_/S VDD VSS sg13g2_mux2_1
XFILLER_52_167 VDD VSS sg13g2_decap_4
XFILLER_90_1226 VDD VSS sg13g2_fill_1
XFILLER_33_370 VDD VSS sg13g2_decap_8
XFILLER_142_1305 VDD VSS sg13g2_decap_4
XFILLER_55_1368 VDD VSS sg13g2_decap_8
XFILLER_21_532 VDD VSS sg13g2_decap_8
XFILLER_166_504 VDD VSS sg13g2_decap_8
X_09264_ _13873_/D _13873_/Q _10160_/A1 _09264_/S VDD VSS sg13g2_mux2_1
XFILLER_55_1379 VDD VSS sg13g2_fill_1
X_08215_ _08215_/X _08219_/A _14963_/Q _14962_/Q _14961_/Q _13517_/A _13521_/A VDD
+ VSS sg13g2_mux4_1
XFILLER_53_1070 VDD VSS sg13g2_fill_1
XFILLER_18_1190 VDD VSS sg13g2_decap_8
X_09195_ _13811_/D _13811_/Q _09930_/A1 _09200_/S VDD VSS sg13g2_mux2_1
XFILLER_14_1043 VDD VSS sg13g2_decap_8
X_08146_ _08146_/X _08146_/A _08177_/S VDD VSS sg13g2_and2_1
XFILLER_101_1024 VDD VSS sg13g2_decap_8
XFILLER_134_412 VDD VSS sg13g2_decap_8
XFILLER_88_1166 VDD VSS sg13g2_fill_2
XFILLER_20_35 VDD VSS sg13g2_decap_8
X_08077_ _08078_/C _08588_/B _08076_/Y _08246_/A1 _08058_/X VDD VSS sg13g2_a22oi_1
XFILLER_88_1177 VDD VSS sg13g2_decap_8
XFILLER_105_7 VDD VSS sg13g2_decap_8
XFILLER_161_231 VDD VSS sg13g2_decap_8
XFILLER_84_1019 VDD VSS sg13g2_decap_8
XFILLER_136_35 VDD VSS sg13g2_decap_8
XFILLER_121_139 VDD VSS sg13g2_fill_1
XFILLER_1_959 VDD VSS sg13g2_decap_8
XFILLER_88_543 VDD VSS sg13g2_fill_1
XFILLER_130_640 VDD VSS sg13g2_fill_2
XFILLER_0_469 VDD VSS sg13g2_decap_8
XFILLER_103_887 VDD VSS sg13g2_decap_8
X_14068__2111 _14068_/RESET_B VDD VSS sg13g2_tiehi
X_08979_ _13757_/D _13757_/Q _09908_/A1 _09167_/S VDD VSS sg13g2_mux2_1
XFILLER_5_1211 VDD VSS sg13g2_decap_8
XFILLER_29_77 VDD VSS sg13g2_decap_8
XFILLER_112_1120 VDD VSS sg13g2_decap_8
XFILLER_152_56 VDD VSS sg13g2_decap_8
XFILLER_25_1183 VDD VSS sg13g2_decap_8
X_11990_ _11990_/X _14129_/Q _14161_/Q _14193_/Q _14225_/Q _11996_/S0 _11996_/S1 VDD
+ VSS sg13g2_mux4_1
XFILLER_91_708 VDD VSS sg13g2_decap_8
XFILLER_99_1251 VDD VSS sg13g2_fill_2
XFILLER_91_719 VDD VSS sg13g2_fill_2
XFILLER_60_1085 VDD VSS sg13g2_decap_8
XFILLER_21_1036 VDD VSS sg13g2_decap_8
XFILLER_17_805 VDD VSS sg13g2_decap_8
XFILLER_28_142 VDD VSS sg13g2_fill_1
XFILLER_5_1288 VDD VSS sg13g2_decap_8
XFILLER_57_985 VDD VSS sg13g2_decap_8
XFILLER_56_462 VDD VSS sg13g2_decap_4
X_10941_ _10941_/X _14938_/Q _10941_/B VDD VSS sg13g2_and2_1
XFILLER_45_21 VDD VSS sg13g2_decap_8
XFILLER_16_315 VDD VSS sg13g2_decap_8
XFILLER_72_933 VDD VSS sg13g2_fill_2
XFILLER_56_484 VDD VSS sg13g2_decap_8
XFILLER_43_112 VDD VSS sg13g2_decap_8
X_14708__1471 _14708_/RESET_B VDD VSS sg13g2_tiehi
XFILLER_43_123 VDD VSS sg13g2_fill_2
X_13660_ _13660_/Q _15188_/CLK _13660_/D _13660_/RESET_B VDD VSS sg13g2_dfrbpq_1
XFILLER_147_1238 VDD VSS sg13g2_decap_8
X_10872_ _10872_/Y _10871_/Y _07649_/Y _10869_/Y _10867_/Y _13307_/B VDD VSS sg13g2_a221oi_1
X_12611_ _15007_/D _12611_/A _12611_/B VDD VSS sg13g2_nor2_1
XFILLER_43_167 VDD VSS sg13g2_decap_8
X_13591_ _15162_/D _13593_/B _13589_/Y _13590_/Y VDD VSS sg13g2_a21oi_1
XFILLER_12_532 VDD VSS sg13g2_decap_8
XFILLER_169_364 VDD VSS sg13g2_decap_8
X_12542_ _12555_/A _12653_/A1 _12542_/A2 _15003_/Q VDD VSS sg13g2_a21oi_1
XFILLER_101_93 VDD VSS sg13g2_decap_8
XFILLER_61_42 VDD VSS sg13g2_decap_8
XFILLER_131_0 VDD VSS sg13g2_decap_8
XFILLER_8_525 VDD VSS sg13g2_decap_8
XFILLER_32_1110 VDD VSS sg13g2_decap_8
X_12473_ _12473_/X _14116_/Q _14148_/Q _14180_/Q _14212_/Q _12727_/S0 _12727_/S1 VDD
+ VSS sg13g2_mux4_1
X_14170__2009 _14170_/RESET_B VDD VSS sg13g2_tiehi
X_14212_ _14212_/Q clkload23/A _14212_/D _14212_/RESET_B VDD VSS sg13g2_dfrbpq_1
X_11424_ _11425_/A _11423_/Y _12118_/C _11424_/C VDD VSS sg13g2_nand3b_1
XFILLER_32_1165 VDD VSS sg13g2_decap_8
XFILLER_126_924 VDD VSS sg13g2_fill_1
X_15192_ _15192_/Q clkload63/A _15192_/D _15192_/RESET_B VDD VSS sg13g2_dfrbpq_1
XFILLER_125_412 VDD VSS sg13g2_decap_4
XFILLER_165_581 VDD VSS sg13g2_decap_8
XANTENNA_8 _09702_/S VDD VSS sg13g2_antennanp
X_14143_ _14143_/Q clkload9/A _14143_/D _14143_/RESET_B VDD VSS sg13g2_dfrbpq_1
X_11355_ _11355_/Y _11353_/S _14654_/Q _11894_/B VDD VSS sg13g2_a21oi_1
XFILLER_4_742 VDD VSS sg13g2_decap_8
X_14278__1901 _14278_/RESET_B VDD VSS sg13g2_tiehi
XFILLER_67_1239 VDD VSS sg13g2_decap_4
XFILLER_98_307 VDD VSS sg13g2_fill_2
X_10306_ _14795_/D _10327_/B _10306_/B _10306_/C VDD VSS sg13g2_nor3_1
XFILLER_113_629 VDD VSS sg13g2_decap_8
X_14074_ _14074_/Q _14734_/CLK _14074_/D _14074_/RESET_B VDD VSS sg13g2_dfrbpq_1
XFILLER_3_252 VDD VSS sg13g2_decap_8
XFILLER_152_275 VDD VSS sg13g2_fill_1
X_11286_ _11287_/B _11378_/S _11276_/Y _11285_/Y VDD VSS sg13g2_o21ai_1
XFILLER_140_437 VDD VSS sg13g2_fill_2
XFILLER_112_139 VDD VSS sg13g2_decap_8
X_13025_ _13042_/B _13026_/A _13026_/C _13057_/A VDD VSS sg13g2_o21ai_1
X_10237_ wire525/A _10237_/A _10237_/B _10237_/C _10237_/D VDD VSS sg13g2_nor4_1
XFILLER_67_705 VDD VSS sg13g2_fill_1
Xfanout1020 _13293_/A _15056_/Q VDD VSS sg13g2_buf_1
XFILLER_6_1008 VDD VSS sg13g2_decap_8
Xfanout1031 _08276_/B _14999_/Q VDD VSS sg13g2_buf_1
XFILLER_94_502 VDD VSS sg13g2_fill_1
Xfanout1042 _08599_/A _08361_/A1 VDD VSS sg13g2_buf_1
XFILLER_20_7 VDD VSS sg13g2_decap_8
XFILLER_117_1086 VDD VSS sg13g2_fill_2
Xfanout1053 _08014_/B _08599_/B VDD VSS sg13g2_buf_1
X_10168_ _14745_/D _14745_/Q _10168_/A1 _10168_/S VDD VSS sg13g2_mux2_1
XFILLER_79_598 VDD VSS sg13g2_fill_1
XFILLER_121_695 VDD VSS sg13g2_decap_8
XFILLER_86_72 VDD VSS sg13g2_decap_8
XFILLER_117_1097 VDD VSS sg13g2_decap_8
Xfanout1064 _13510_/A1 _13521_/A VDD VSS sg13g2_buf_1
Xfanout1075 _08009_/S _08083_/S0 VDD VSS sg13g2_buf_1
XFILLER_66_237 VDD VSS sg13g2_fill_2
Xfanout1086 _12300_/A _14988_/Q VDD VSS sg13g2_buf_1
XFILLER_48_952 VDD VSS sg13g2_decap_8
Xfanout1097 _12152_/A _14984_/Q VDD VSS sg13g2_buf_1
XFILLER_43_1283 VDD VSS sg13g2_decap_8
X_14201__1978 _14201_/RESET_B VDD VSS sg13g2_tiehi
X_14976_ _14976_/Q clkload41/A _14976_/D _14976_/RESET_B VDD VSS sg13g2_dfrbpq_1
X_10099_ _14679_/D _10099_/A0 _14679_/Q _10102_/S VDD VSS sg13g2_mux2_1
Xclkbuf_leaf_40_clk_i clkload32/A clkbuf_leaf_43_clk_i/A VDD VSS sg13g2_buf_8
XFILLER_81_207 VDD VSS sg13g2_decap_8
XFILLER_47_462 VDD VSS sg13g2_decap_8
XFILLER_130_1264 VDD VSS sg13g2_fill_1
XFILLER_47_473 VDD VSS sg13g2_fill_1
X_13927_ _13927_/Q clkload18/A _13927_/D _13927_/RESET_B VDD VSS sg13g2_dfrbpq_1
XFILLER_78_1346 VDD VSS sg13g2_decap_4
XFILLER_19_175 VDD VSS sg13g2_decap_8
XFILLER_78_1357 VDD VSS sg13g2_decap_8
XFILLER_90_752 VDD VSS sg13g2_decap_8
X_13858_ _13858_/Q _14722_/CLK _13858_/D _13858_/RESET_B VDD VSS sg13g2_dfrbpq_1
XFILLER_90_763 VDD VSS sg13g2_fill_1
XFILLER_63_988 VDD VSS sg13g2_fill_2
XFILLER_16_882 VDD VSS sg13g2_decap_8
X_12809_ _12809_/Y _14767_/Q _13275_/A2 _13275_/B1 VDD VSS sg13g2_o21ai_1
X_13766__2413 _13766_/RESET_B VDD VSS sg13g2_tiehi
XFILLER_22_329 VDD VSS sg13g2_decap_8
X_13789_ _13789_/Q clkload47/A _13789_/D _13789_/RESET_B VDD VSS sg13g2_dfrbpq_1
Xclkbuf_leaf_55_clk_i clkload67/A clkbuf_leaf_62_clk_i/A VDD VSS sg13g2_buf_8
XFILLER_76_1092 VDD VSS sg13g2_decap_8
XFILLER_15_392 VDD VSS sg13g2_decap_8
XFILLER_163_1062 VDD VSS sg13g2_decap_8
XFILLER_31_852 VDD VSS sg13g2_decap_8
XFILLER_163_1095 VDD VSS sg13g2_fill_2
XFILLER_15_1330 VDD VSS sg13g2_decap_8
XFILLER_50_1221 VDD VSS sg13g2_decap_8
X_08000_ _08000_/X _08001_/A _08275_/B _08001_/C _08001_/D VDD VSS sg13g2_and4_1
XFILLER_163_518 VDD VSS sg13g2_decap_8
XFILLER_128_250 VDD VSS sg13g2_decap_8
XFILLER_50_1265 VDD VSS sg13g2_fill_2
XFILLER_144_710 VDD VSS sg13g2_fill_2
X_14146__2033 _14146_/RESET_B VDD VSS sg13g2_tiehi
XFILLER_102_1355 VDD VSS sg13g2_fill_2
XFILLER_104_607 VDD VSS sg13g2_decap_8
XFILLER_116_467 VDD VSS sg13g2_decap_8
XFILLER_144_776 VDD VSS sg13g2_decap_8
XFILLER_171_551 VDD VSS sg13g2_decap_8
XFILLER_132_927 VDD VSS sg13g2_decap_8
XFILLER_144_787 VDD VSS sg13g2_fill_2
X_09951_ _14535_/D _14535_/Q _09984_/A0 _09966_/S VDD VSS sg13g2_mux2_1
XFILLER_132_938 VDD VSS sg13g2_fill_1
XFILLER_143_286 VDD VSS sg13g2_decap_4
X_08902_ _13708_/D _08932_/S _08900_/Y _08901_/Y VDD VSS sg13g2_a21oi_1
XFILLER_98_852 VDD VSS sg13g2_decap_4
XFILLER_170_1011 VDD VSS sg13g2_decap_8
X_09882_ _14468_/D _09915_/A1 _14468_/Q _09899_/S VDD VSS sg13g2_mux2_1
XFILLER_135_1142 VDD VSS sg13g2_decap_8
XFILLER_106_49 VDD VSS sg13g2_decap_8
XFILLER_44_1036 VDD VSS sg13g2_decap_8
XFILLER_100_802 VDD VSS sg13g2_decap_8
XFILLER_100_813 VDD VSS sg13g2_fill_2
X_08833_ _08833_/Y _14747_/Q _13613_/C _08833_/C VDD VSS sg13g2_nor3_1
XFILLER_100_824 VDD VSS sg13g2_decap_8
X_08764_ _08764_/Y _13673_/Q _08775_/B VDD VSS sg13g2_nor2_1
XFILLER_61_1383 VDD VSS sg13g2_fill_1
XFILLER_22_1345 VDD VSS sg13g2_decap_8
X_07715_ _07721_/B _15099_/Q _15098_/Q _15088_/Q _15087_/Q VDD VSS sg13g2_nor4_1
X_08695_ _08695_/Y _08681_/B _08679_/Y _08673_/X VDD VSS sg13g2_o21ai_1
XFILLER_54_933 VDD VSS sg13g2_decap_8
XFILLER_54_944 VDD VSS sg13g2_fill_2
XFILLER_25_112 VDD VSS sg13g2_decap_8
XFILLER_65_292 VDD VSS sg13g2_decap_8
X_07646_ _07646_/Y _14802_/Q VDD VSS sg13g2_inv_1
XFILLER_14_819 VDD VSS sg13g2_decap_8
XFILLER_41_605 VDD VSS sg13g2_decap_8
XFILLER_80_251 VDD VSS sg13g2_fill_1
XFILLER_15_35 VDD VSS sg13g2_decap_8
XFILLER_0_1185 VDD VSS sg13g2_decap_8
XFILLER_13_329 VDD VSS sg13g2_decap_8
XFILLER_25_189 VDD VSS sg13g2_decap_8
X_14356__1823 _14356_/RESET_B VDD VSS sg13g2_tiehi
XFILLER_55_1132 VDD VSS sg13g2_decap_4
XFILLER_34_690 VDD VSS sg13g2_decap_8
XFILLER_107_1222 VDD VSS sg13g2_decap_4
XFILLER_142_1102 VDD VSS sg13g2_fill_2
X_09316_ _13923_/D _09316_/A0 _13923_/Q _09334_/S VDD VSS sg13g2_mux2_1
XFILLER_22_841 VDD VSS sg13g2_decap_8
XFILLER_166_301 VDD VSS sg13g2_decap_8
XFILLER_16_1127 VDD VSS sg13g2_decap_8
XFILLER_55_1198 VDD VSS sg13g2_decap_8
XFILLER_22_885 VDD VSS sg13g2_fill_2
XFILLER_107_1277 VDD VSS sg13g2_decap_8
XFILLER_142_1157 VDD VSS sg13g2_fill_2
X_09247_ _13856_/D _13856_/Q _10143_/A1 _09271_/S VDD VSS sg13g2_mux2_1
XFILLER_90_1089 VDD VSS sg13g2_decap_8
Xclkbuf_4_2_0_clk_i clkbuf_4_2_0_clk_i/X clkbuf_0_clk_i/X VDD VSS sg13g2_buf_8
XFILLER_166_378 VDD VSS sg13g2_decap_8
X_09178_ _13794_/D _13794_/Q _09913_/A1 _09201_/S VDD VSS sg13g2_mux2_1
XFILLER_31_56 VDD VSS sg13g2_decap_8
XFILLER_108_935 VDD VSS sg13g2_decap_8
Xclkbuf_5_9__f_clk_i clkbuf_5_9__f_clk_i/X clkbuf_4_4_0_clk_i/X VDD VSS sg13g2_buf_16
XFILLER_5_539 VDD VSS sg13g2_decap_8
XFILLER_134_220 VDD VSS sg13g2_fill_2
XFILLER_147_56 VDD VSS sg13g2_decap_8
X_08129_ _08129_/X _07775_/A _07786_/A _07782_/A _14971_/Q _13518_/A1 _08207_/S1 VDD
+ VSS sg13g2_mux4_1
XFILLER_162_551 VDD VSS sg13g2_decap_8
XFILLER_134_253 VDD VSS sg13g2_decap_8
X_11140_ _11140_/Y _11139_/Y _11138_/Y _11136_/Y _11206_/A1 _11207_/A2 VDD VSS sg13g2_a221oi_1
Xoutput45 mem_axi_araddr[16] _16869_/A VDD VSS sg13g2_buf_1
XFILLER_27_1201 VDD VSS sg13g2_decap_8
Xoutput56 mem_axi_araddr[27] _16880_/A VDD VSS sg13g2_buf_1
Xoutput67 mem_axi_araddr[8] _16861_/A VDD VSS sg13g2_buf_1
XFILLER_89_841 VDD VSS sg13g2_fill_1
Xoutput78 mem_axi_awaddr[17] _16870_/X VDD VSS sg13g2_buf_1
X_11071_ _11071_/Y _11029_/C _11068_/B _11154_/B1 VDD VSS sg13g2_o21ai_1
XFILLER_62_1103 VDD VSS sg13g2_fill_1
XFILLER_118_1351 VDD VSS sg13g2_fill_2
XFILLER_1_756 VDD VSS sg13g2_decap_8
Xoutput89 mem_axi_awaddr[28] _16881_/X VDD VSS sg13g2_buf_1
XFILLER_66_1294 VDD VSS sg13g2_decap_4
Xhold3150 _13578_/A _15158_/Q VDD VSS sg13g2_dlygate4sd3_1
XFILLER_49_716 VDD VSS sg13g2_decap_8
Xhold3161 _10973_/A _14940_/Q VDD VSS sg13g2_dlygate4sd3_1
X_10022_ _14604_/D _10088_/A0 _14604_/Q _10030_/S VDD VSS sg13g2_mux2_1
XFILLER_76_502 VDD VSS sg13g2_fill_2
XFILLER_0_266 VDD VSS sg13g2_decap_8
XFILLER_153_1264 VDD VSS sg13g2_fill_1
XFILLER_163_77 VDD VSS sg13g2_decap_8
X_13844__2335 _13844_/RESET_B VDD VSS sg13g2_tiehi
XFILLER_48_204 VDD VSS sg13g2_decap_8
XFILLER_131_993 VDD VSS sg13g2_decap_8
XFILLER_88_384 VDD VSS sg13g2_decap_8
XFILLER_49_738 VDD VSS sg13g2_decap_8
XFILLER_27_1278 VDD VSS sg13g2_decap_8
XFILLER_114_1259 VDD VSS sg13g2_fill_2
X_14830_ _14830_/Q _14890_/CLK _14830_/D _14830_/RESET_B VDD VSS sg13g2_dfrbpq_1
XFILLER_64_719 VDD VSS sg13g2_decap_8
XFILLER_56_42 VDD VSS sg13g2_decap_8
XFILLER_17_602 VDD VSS sg13g2_decap_8
X_14761_ _14761_/Q clkload63/A _14761_/D _14761_/RESET_B VDD VSS sg13g2_dfrbpq_1
X_11973_ _11973_/Y _11973_/A _11973_/B VDD VSS sg13g2_nand2_1
XFILLER_63_229 VDD VSS sg13g2_decap_8
XFILLER_5_1085 VDD VSS sg13g2_decap_8
XFILLER_56_86 VDD VSS sg13g2_decap_8
XFILLER_16_112 VDD VSS sg13g2_decap_8
XFILLER_84_590 VDD VSS sg13g2_fill_2
XFILLER_147_1002 VDD VSS sg13g2_decap_8
X_13712_ _16874_/A _14746_/CLK _13712_/D _13712_/RESET_B VDD VSS sg13g2_dfrbpq_1
X_10924_ _10924_/Y _10954_/D _10954_/A _10983_/A1 VDD VSS sg13g2_a21oi_1
XFILLER_147_1013 VDD VSS sg13g2_fill_1
X_14692_ _14692_/Q clkload17/A _14692_/D _14692_/RESET_B VDD VSS sg13g2_dfrbpq_1
XFILLER_72_763 VDD VSS sg13g2_decap_8
XFILLER_17_679 VDD VSS sg13g2_decap_8
XFILLER_44_465 VDD VSS sg13g2_decap_8
XFILLER_32_616 VDD VSS sg13g2_decap_8
XFILLER_16_189 VDD VSS sg13g2_decap_8
X_13643_ _13751_/D _13643_/A VDD VSS sg13g2_buf_1
X_10855_ _10890_/A _14752_/Q _10870_/A VDD VSS sg13g2_nor2_1
XFILLER_72_63 VDD VSS sg13g2_decap_8
XFILLER_71_295 VDD VSS sg13g2_decap_8
X_13574_ _13574_/Y _14998_/Q _13566_/B _13569_/S _15014_/Q _13521_/X VDD VSS sg13g2_a221oi_1
XFILLER_158_835 VDD VSS sg13g2_decap_8
XFILLER_160_1224 VDD VSS sg13g2_fill_2
XFILLER_169_161 VDD VSS sg13g2_decap_8
X_10786_ _10787_/A _14923_/Q _11196_/B _11154_/B1 _11181_/A VDD VSS sg13g2_a22oi_1
XFILLER_9_812 VDD VSS sg13g2_decap_8
XFILLER_13_896 VDD VSS sg13g2_decap_8
X_12525_ _12525_/X _12524_/X _12523_/X _12692_/S VDD VSS sg13g2_mux2_1
XFILLER_157_345 VDD VSS sg13g2_decap_8
XFILLER_8_322 VDD VSS sg13g2_decap_8
XFILLER_160_1279 VDD VSS sg13g2_decap_8
XFILLER_9_889 VDD VSS sg13g2_decap_8
X_15244_ _15244_/Q _15247_/CLK _15244_/D _15244_/RESET_B VDD VSS sg13g2_dfrbpq_1
X_12456_ _12457_/B _13686_/Q _12763_/A2 _12455_/X _12415_/A _12777_/C1 VDD VSS sg13g2_a221oi_1
XFILLER_126_710 VDD VSS sg13g2_decap_8
XFILLER_123_1090 VDD VSS sg13g2_fill_2
XFILLER_138_581 VDD VSS sg13g2_fill_1
XFILLER_68_7 VDD VSS sg13g2_decap_8
XFILLER_8_399 VDD VSS sg13g2_decap_8
X_11407_ _11407_/Y _11804_/A _14367_/Q VDD VSS sg13g2_nand2b_1
X_15175_ _15175_/Q _15183_/CLK _15175_/D _15175_/RESET_B VDD VSS sg13g2_dfrbpq_1
XFILLER_67_1003 VDD VSS sg13g2_fill_2
X_12387_ _12387_/Y _15121_/Q _12348_/A _12777_/A2 _13691_/Q _13282_/A1 VDD VSS sg13g2_a221oi_1
XFILLER_153_551 VDD VSS sg13g2_decap_8
XFILLER_99_616 VDD VSS sg13g2_fill_2
XFILLER_10_1260 VDD VSS sg13g2_decap_8
XFILLER_141_713 VDD VSS sg13g2_decap_8
X_14126_ _14126_/Q clkload36/A _14126_/D _14126_/RESET_B VDD VSS sg13g2_dfrbpq_1
X_11338_ _11339_/B _11338_/A _11338_/B VDD VSS sg13g2_nor2_1
XFILLER_141_724 VDD VSS sg13g2_fill_2
XFILLER_153_584 VDD VSS sg13g2_decap_8
XFILLER_98_126 VDD VSS sg13g2_decap_8
XFILLER_154_1028 VDD VSS sg13g2_decap_8
XFILLER_84_1350 VDD VSS sg13g2_decap_4
X_14057_ _14057_/Q clkload20/A _14057_/D _14057_/RESET_B VDD VSS sg13g2_dfrbpq_1
X_11269_ _11287_/A _12332_/B1 _11258_/Y _11268_/Y VDD VSS sg13g2_o21ai_1
XFILLER_171_1320 VDD VSS sg13g2_decap_8
XFILLER_79_340 VDD VSS sg13g2_decap_8
X_13008_ _13010_/B _13058_/A _13058_/C VDD VSS sg13g2_nand2_1
XFILLER_95_811 VDD VSS sg13g2_fill_1
X_14434__1745 _14434_/RESET_B VDD VSS sg13g2_tiehi
XFILLER_45_1378 VDD VSS sg13g2_decap_4
XFILLER_132_1337 VDD VSS sg13g2_fill_1
XFILLER_39_226 VDD VSS sg13g2_fill_1
XFILLER_39_248 VDD VSS sg13g2_decap_8
XFILLER_94_398 VDD VSS sg13g2_decap_8
X_14959_ _14959_/Q clkload62/A _14959_/D _14959_/RESET_B VDD VSS sg13g2_dfrbpq_1
XFILLER_36_955 VDD VSS sg13g2_fill_2
XFILLER_130_1094 VDD VSS sg13g2_decap_8
X_08480_ _08481_/B _08478_/Y _08479_/Y _08477_/Y VDD VSS sg13g2_a21oi_1
XFILLER_90_582 VDD VSS sg13g2_decap_8
XFILLER_22_126 VDD VSS sg13g2_decap_8
XFILLER_94_0 VDD VSS sg13g2_decap_8
XFILLER_91_1365 VDD VSS sg13g2_decap_8
XFILLER_148_312 VDD VSS sg13g2_decap_8
X_09101_ _10752_/B _09140_/S _15043_/Q _09100_/Y VDD VSS sg13g2_o21ai_1
XFILLER_149_857 VDD VSS sg13g2_decap_8
XFILLER_149_879 VDD VSS sg13g2_decap_4
XFILLER_148_378 VDD VSS sg13g2_decap_8
X_09032_ _09032_/X _09057_/A _09027_/X _09031_/Y VDD VSS sg13g2_a21o_1
X_13922__2257 _13922_/RESET_B VDD VSS sg13g2_tiehi
XFILLER_163_315 VDD VSS sg13g2_decap_8
X_14682__1497 _14682_/RESET_B VDD VSS sg13g2_tiehi
XFILLER_102_1130 VDD VSS sg13g2_decap_8
XFILLER_117_732 VDD VSS sg13g2_decap_8
XFILLER_7_91 VDD VSS sg13g2_decap_8
XFILLER_11_1057 VDD VSS sg13g2_decap_8
XFILLER_137_1215 VDD VSS sg13g2_decap_8
XFILLER_144_584 VDD VSS sg13g2_decap_8
XFILLER_105_949 VDD VSS sg13g2_fill_1
XFILLER_144_595 VDD VSS sg13g2_fill_2
Xfanout802 _12601_/S1 _12660_/S1 VDD VSS sg13g2_buf_1
XFILLER_172_1139 VDD VSS sg13g2_fill_2
XFILLER_132_768 VDD VSS sg13g2_fill_1
X_09934_ _14519_/D _14519_/Q _09934_/A1 _09935_/S VDD VSS sg13g2_mux2_1
Xfanout813 _12674_/S1 _12759_/S1 VDD VSS sg13g2_buf_1
Xfanout824 _12618_/S1 fanout849/X VDD VSS sg13g2_buf_1
Xfanout835 _12757_/S1 _12731_/S1 VDD VSS sg13g2_buf_1
XFILLER_86_811 VDD VSS sg13g2_fill_2
Xfanout846 fanout846/X _12745_/S1 VDD VSS sg13g2_buf_1
Xfanout857 _12658_/S0 fanout860/X VDD VSS sg13g2_buf_1
X_09865_ _14452_/D _14452_/Q _10096_/A0 _09871_/S VDD VSS sg13g2_mux2_1
XFILLER_133_14 VDD VSS sg13g2_decap_8
Xfanout868 _12396_/S0 _12352_/S0 VDD VSS sg13g2_buf_1
Xfanout879 _12716_/S0 _12717_/S0 VDD VSS sg13g2_buf_1
XFILLER_58_557 VDD VSS sg13g2_decap_8
X_08816_ _08816_/Y _13499_/C _13481_/A _15179_/Q VDD VSS sg13g2_o21ai_1
XFILLER_100_665 VDD VSS sg13g2_decap_8
X_09796_ _14385_/D _09928_/A1 _14385_/Q _09796_/S VDD VSS sg13g2_mux2_1
XFILLER_86_888 VDD VSS sg13g2_fill_2
XFILLER_73_505 VDD VSS sg13g2_fill_2
XFILLER_6_1372 VDD VSS sg13g2_decap_8
XFILLER_6_1383 VDD VSS sg13g2_fill_1
XFILLER_22_1142 VDD VSS sg13g2_decap_8
X_08747_ _13667_/D _08765_/A1 _08745_/Y _08746_/Y VDD VSS sg13g2_a21oi_1
XFILLER_2_1225 VDD VSS sg13g2_decap_8
XFILLER_27_922 VDD VSS sg13g2_decap_8
XFILLER_26_410 VDD VSS sg13g2_decap_8
XFILLER_172_7 VDD VSS sg13g2_decap_8
X_14856__2832 _14856_/RESET_B VDD VSS sg13g2_tiehi
XFILLER_148_1322 VDD VSS sg13g2_decap_8
X_08678_ _08678_/Y _08678_/A _08678_/B _08678_/C VDD VSS sg13g2_nand3_1
XFILLER_57_1216 VDD VSS sg13g2_decap_8
XFILLER_26_56 VDD VSS sg13g2_decap_8
XFILLER_54_774 VDD VSS sg13g2_decap_8
XFILLER_42_914 VDD VSS sg13g2_decap_8
XFILLER_14_616 VDD VSS sg13g2_decap_8
X_07629_ _07629_/Y _08154_/A VDD VSS sg13g2_inv_1
XFILLER_96_1298 VDD VSS sg13g2_decap_8
XFILLER_109_1339 VDD VSS sg13g2_fill_1
XFILLER_13_126 VDD VSS sg13g2_decap_8
XFILLER_144_1219 VDD VSS sg13g2_fill_1
X_10640_ _14887_/D _10640_/A _10639_/Y VDD VSS sg13g2_nor2b_1
XFILLER_9_119 VDD VSS sg13g2_decap_8
X_14889__2766 _14889_/RESET_B VDD VSS sg13g2_tiehi
XFILLER_22_671 VDD VSS sg13g2_decap_8
XFILLER_10_833 VDD VSS sg13g2_decap_8
X_10571_ _10572_/A _10647_/C _10579_/B _10579_/C VDD VSS sg13g2_and3_1
XFILLER_42_77 VDD VSS sg13g2_decap_8
X_12310_ _12310_/Y _12310_/A _12324_/B VDD VSS sg13g2_nand2_1
XFILLER_167_687 VDD VSS sg13g2_decap_8
XFILLER_33_1260 VDD VSS sg13g2_fill_1
XFILLER_158_77 VDD VSS sg13g2_decap_8
XFILLER_166_175 VDD VSS sg13g2_decap_8
X_13290_ _13291_/C _13290_/A _13290_/B _13294_/B _13290_/D VDD VSS sg13g2_nand4_1
XFILLER_6_826 VDD VSS sg13g2_decap_8
XFILLER_155_849 VDD VSS sg13g2_decap_8
X_14512__1667 _14512_/RESET_B VDD VSS sg13g2_tiehi
XFILLER_154_348 VDD VSS sg13g2_decap_8
X_12241_ _12241_/Y _12257_/A1 _14616_/Q _12169_/C VDD VSS sg13g2_a21oi_1
XFILLER_5_336 VDD VSS sg13g2_decap_8
XFILLER_108_765 VDD VSS sg13g2_fill_2
XFILLER_120_1285 VDD VSS sg13g2_fill_2
XFILLER_163_882 VDD VSS sg13g2_decap_8
X_14766__2947 _14766_/RESET_B VDD VSS sg13g2_tiehi
X_12172_ _12172_/Y _12172_/A _12246_/B VDD VSS sg13g2_nand2_1
XFILLER_64_1209 VDD VSS sg13g2_decap_4
XFILLER_174_54 VDD VSS sg13g2_decap_8
XFILLER_174_65 VDD VSS sg13g2_decap_8
X_11123_ _11127_/B _11123_/A _11123_/B VDD VSS sg13g2_nor2_1
XFILLER_77_800 VDD VSS sg13g2_decap_8
XFILLER_1_553 VDD VSS sg13g2_decap_8
XFILLER_95_118 VDD VSS sg13g2_fill_2
XFILLER_77_811 VDD VSS sg13g2_fill_2
XFILLER_3_49 VDD VSS sg13g2_decap_8
X_11054_ _11054_/Y _11069_/B _11053_/Y _11029_/C VDD VSS sg13g2_o21ai_1
XFILLER_153_1061 VDD VSS sg13g2_decap_8
XFILLER_153_1072 VDD VSS sg13g2_fill_1
XFILLER_77_844 VDD VSS sg13g2_decap_8
XFILLER_118_1192 VDD VSS sg13g2_decap_8
XFILLER_76_321 VDD VSS sg13g2_decap_4
XFILLER_67_63 VDD VSS sg13g2_decap_8
X_10005_ _14587_/D _10104_/A0 _14587_/Q _10030_/S VDD VSS sg13g2_mux2_1
XFILLER_7_1169 VDD VSS sg13g2_decap_8
XFILLER_76_354 VDD VSS sg13g2_decap_4
XFILLER_37_708 VDD VSS sg13g2_decap_8
XFILLER_64_516 VDD VSS sg13g2_fill_2
X_14813_ _14813_/Q clkload48/A _14813_/D _14813_/RESET_B VDD VSS sg13g2_dfrbpq_1
XFILLER_40_1253 VDD VSS sg13g2_decap_8
XFILLER_123_91 VDD VSS sg13g2_decap_8
XFILLER_18_966 VDD VSS sg13g2_decap_8
X_14744_ _14744_/Q _14744_/CLK _14744_/D _14744_/RESET_B VDD VSS sg13g2_dfrbpq_1
XFILLER_83_51 VDD VSS sg13g2_decap_8
X_11956_ _11957_/B _11953_/Y _11955_/Y _11974_/B1 VDD VSS sg13g2_a21oi_1
XFILLER_75_1327 VDD VSS sg13g2_fill_2
XFILLER_17_476 VDD VSS sg13g2_decap_8
X_10907_ _10907_/Y _10907_/A _10948_/B VDD VSS sg13g2_xnor2_1
X_14675_ _14675_/Q clkload22/A _14675_/D _14675_/RESET_B VDD VSS sg13g2_dfrbpq_1
X_14749__1428 _14749_/RESET_B VDD VSS sg13g2_tiehi
X_11887_ _11887_/Y _11217_/S _14478_/Q VDD VSS sg13g2_nand2b_1
XFILLER_32_457 VDD VSS sg13g2_decap_8
X_13626_ _13734_/D _13626_/A VDD VSS sg13g2_buf_1
X_10838_ _10865_/A _10851_/C _14751_/Q VDD VSS sg13g2_nand2_1
XFILLER_158_621 VDD VSS sg13g2_decap_8
XFILLER_13_693 VDD VSS sg13g2_decap_8
X_13557_ _15150_/D _15150_/Q _13556_/Y _13565_/S VDD VSS sg13g2_mux2_1
X_10769_ _10769_/X _14950_/Q _10767_/A _10767_/Y VDD VSS sg13g2_a21o_1
X_12508_ _12508_/X _13958_/Q _13990_/Q _14022_/Q _14054_/Q _12660_/S0 _12660_/S1 VDD
+ VSS sg13g2_mux4_1
XFILLER_121_1049 VDD VSS sg13g2_fill_2
X_13488_ _13488_/Y _15174_/D _13487_/Y VDD VSS sg13g2_nor2b_1
XFILLER_9_686 VDD VSS sg13g2_decap_8
XFILLER_172_112 VDD VSS sg13g2_decap_8
XFILLER_12_1344 VDD VSS sg13g2_decap_8
X_15227_ _15227_/Q _15228_/CLK _15227_/D _15227_/RESET_B VDD VSS sg13g2_dfrbpq_1
X_12439_ _12439_/X _12432_/X _12436_/X _12431_/X _12435_/X _12553_/S _12719_/S0 VDD
+ VSS sg13g2_mux4_1
XFILLER_8_196 VDD VSS sg13g2_decap_8
XFILLER_154_893 VDD VSS sg13g2_decap_8
X_15158_ _15158_/Q clkload68/A _15158_/D _15158_/RESET_B VDD VSS sg13g2_dfrbpq_1
XFILLER_172_189 VDD VSS sg13g2_decap_8
XFILLER_114_735 VDD VSS sg13g2_decap_8
XFILLER_153_392 VDD VSS sg13g2_decap_8
XFILLER_114_768 VDD VSS sg13g2_decap_8
X_14109_ _14109_/Q clkload47/A _14109_/D _14109_/RESET_B VDD VSS sg13g2_dfrbpq_1
X_15089_ _15089_/Q _15159_/CLK _15089_/D _15089_/RESET_B VDD VSS sg13g2_dfrbpq_1
X_07980_ _07980_/Y _08577_/B _07866_/Y _07979_/Y VDD VSS sg13g2_a21oi_1
X_14667__1512 _14667_/RESET_B VDD VSS sg13g2_tiehi
XFILLER_84_1180 VDD VSS sg13g2_decap_8
XFILLER_80_1011 VDD VSS sg13g2_decap_4
XFILLER_84_1191 VDD VSS sg13g2_fill_1
X_15174__2879 _15174_/RESET_B VDD VSS sg13g2_tiehi
XFILLER_80_1044 VDD VSS sg13g2_decap_8
XFILLER_136_1292 VDD VSS sg13g2_decap_8
XFILLER_95_630 VDD VSS sg13g2_fill_1
XFILLER_45_1175 VDD VSS sg13g2_decap_4
XFILLER_41_1006 VDD VSS sg13g2_fill_1
XFILLER_171_1183 VDD VSS sg13g2_decap_8
X_09650_ _14243_/D _09914_/A1 _14243_/Q _09672_/S VDD VSS sg13g2_mux2_1
X_14096__2083 _14096_/RESET_B VDD VSS sg13g2_tiehi
XFILLER_68_888 VDD VSS sg13g2_decap_8
X_14811__2902 _14811_/RESET_B VDD VSS sg13g2_tiehi
X_08601_ _08605_/A _08617_/A _08458_/X _08600_/Y VDD VSS sg13g2_o21ai_1
XFILLER_68_899 VDD VSS sg13g2_fill_2
XFILLER_95_696 VDD VSS sg13g2_fill_1
XFILLER_82_313 VDD VSS sg13g2_fill_2
XFILLER_67_387 VDD VSS sg13g2_fill_1
X_09581_ _14178_/D _14178_/Q _10012_/A0 _09601_/S VDD VSS sg13g2_mux2_1
XFILLER_48_590 VDD VSS sg13g2_decap_8
X_08532_ _08532_/Y _08548_/A _08529_/Y _08531_/Y VDD VSS sg13g2_a21oi_1
XFILLER_24_903 VDD VSS sg13g2_decap_8
X_15035__2552 _15035_/RESET_B VDD VSS sg13g2_tiehi
XFILLER_23_413 VDD VSS sg13g2_decap_8
X_08463_ _08463_/Y _13533_/A _08463_/B VDD VSS sg13g2_nor2_1
XFILLER_91_891 VDD VSS sg13g2_decap_8
XFILLER_169_919 VDD VSS sg13g2_decap_8
XFILLER_17_1211 VDD VSS sg13g2_decap_8
X_08394_ _08395_/B _08414_/C _08394_/B _08394_/C VDD VSS sg13g2_nor3_1
XFILLER_91_1151 VDD VSS sg13g2_decap_8
XFILLER_51_777 VDD VSS sg13g2_fill_2
XFILLER_149_621 VDD VSS sg13g2_decap_8
XFILLER_52_1146 VDD VSS sg13g2_decap_8
XFILLER_108_1383 VDD VSS sg13g2_fill_1
XFILLER_164_602 VDD VSS sg13g2_fill_1
XFILLER_12_14 VDD VSS sg13g2_decap_8
XFILLER_149_687 VDD VSS sg13g2_decap_4
XFILLER_17_1288 VDD VSS sg13g2_decap_8
Xclkbuf_5_27__f_clk_i clkbuf_leaf_72_clk_i/A clkbuf_4_13_0_clk_i/X VDD VSS sg13g2_buf_16
XFILLER_136_315 VDD VSS sg13g2_decap_8
XFILLER_128_14 VDD VSS sg13g2_decap_8
XFILLER_136_326 VDD VSS sg13g2_fill_2
XFILLER_163_112 VDD VSS sg13g2_decap_8
X_09015_ _09016_/B _15030_/Q _15227_/Q _09107_/B VDD VSS sg13g2_mux2_1
XFILLER_145_860 VDD VSS sg13g2_fill_2
XFILLER_144_370 VDD VSS sg13g2_decap_4
XFILLER_163_189 VDD VSS sg13g2_decap_8
XFILLER_137_1012 VDD VSS sg13g2_fill_1
XFILLER_137_1023 VDD VSS sg13g2_decap_8
XFILLER_144_392 VDD VSS sg13g2_decap_8
XFILLER_137_1034 VDD VSS sg13g2_fill_2
Xfanout610 _10684_/A2 _10694_/S VDD VSS sg13g2_buf_1
XFILLER_144_35 VDD VSS sg13g2_decap_8
Xfanout621 _08835_/B _08828_/Y VDD VSS sg13g2_buf_1
XFILLER_104_289 VDD VSS sg13g2_decap_8
XFILLER_137_1089 VDD VSS sg13g2_decap_8
Xfanout632 _08672_/A _08541_/A VDD VSS sg13g2_buf_1
X_09917_ _14502_/D _14502_/Q _09917_/A1 _09928_/S VDD VSS sg13g2_mux2_1
XFILLER_150_1201 VDD VSS sg13g2_fill_1
Xfanout643 _12624_/C1 _12777_/C1 VDD VSS sg13g2_buf_1
XFILLER_63_1253 VDD VSS sg13g2_fill_2
XFILLER_24_1204 VDD VSS sg13g2_decap_8
XFILLER_113_790 VDD VSS sg13g2_decap_8
Xfanout654 _12918_/A2 _07728_/X VDD VSS sg13g2_buf_1
XFILLER_101_941 VDD VSS sg13g2_fill_1
Xfanout665 _10999_/B1 _07703_/Y VDD VSS sg13g2_buf_1
Xfanout676 _11722_/B2 _12339_/A1 VDD VSS sg13g2_buf_1
XFILLER_63_1297 VDD VSS sg13g2_decap_8
XFILLER_4_1309 VDD VSS sg13g2_decap_8
Xfanout687 _13479_/S _08721_/S VDD VSS sg13g2_buf_1
X_09848_ _14435_/D _14435_/Q _10079_/A0 _09870_/S VDD VSS sg13g2_mux2_1
XFILLER_86_663 VDD VSS sg13g2_decap_8
Xfanout698 _11763_/B fanout706/X VDD VSS sg13g2_buf_1
X_09779_ _14368_/D _09911_/A1 _14368_/Q _09804_/S VDD VSS sg13g2_mux2_1
XFILLER_2_1022 VDD VSS sg13g2_decap_8
XFILLER_37_77 VDD VSS sg13g2_decap_8
XFILLER_27_741 VDD VSS sg13g2_decap_4
XFILLER_160_56 VDD VSS sg13g2_decap_8
XFILLER_73_357 VDD VSS sg13g2_fill_2
X_11810_ _11810_/Y _11814_/S0 _14604_/Q _11805_/C VDD VSS sg13g2_a21oi_1
XFILLER_15_903 VDD VSS sg13g2_decap_8
X_12790_ _12790_/X _12789_/X _12788_/X _12790_/S VDD VSS sg13g2_mux2_1
XFILLER_148_1141 VDD VSS sg13g2_decap_8
XFILLER_14_413 VDD VSS sg13g2_decap_8
X_11741_ _11742_/B _11741_/A _14666_/Q VDD VSS sg13g2_nand2_1
XFILLER_96_1084 VDD VSS sg13g2_decap_8
XFILLER_2_1099 VDD VSS sg13g2_decap_8
XFILLER_26_273 VDD VSS sg13g2_fill_1
XFILLER_53_21 VDD VSS sg13g2_decap_8
XFILLER_18_1008 VDD VSS sg13g2_decap_8
XFILLER_169_21 VDD VSS sg13g2_decap_8
X_13794__2385 _13794_/RESET_B VDD VSS sg13g2_tiehi
XFILLER_144_1038 VDD VSS sg13g2_decap_8
X_14460_ _14460_/Q _14854_/CLK _14460_/D _14460_/RESET_B VDD VSS sg13g2_dfrbpq_1
X_15096__2787 _15096_/RESET_B VDD VSS sg13g2_tiehi
X_11672_ _11672_/Y _11669_/Y _11671_/X _11747_/A VDD VSS sg13g2_o21ai_1
XFILLER_30_917 VDD VSS sg13g2_decap_8
XFILLER_41_265 VDD VSS sg13g2_fill_2
XFILLER_35_1322 VDD VSS sg13g2_decap_8
XFILLER_30_928 VDD VSS sg13g2_fill_1
XFILLER_109_1169 VDD VSS sg13g2_fill_2
X_13411_ _13490_/C _13448_/B _13421_/B VDD VSS sg13g2_nand2b_1
X_10623_ _14882_/D _10633_/A _10623_/B _10632_/D VDD VSS sg13g2_nor3_1
XFILLER_168_963 VDD VSS sg13g2_decap_8
X_14391_ _14391_/Q clkload27/A _14391_/D _14391_/RESET_B VDD VSS sg13g2_dfrbpq_1
XFILLER_168_974 VDD VSS sg13g2_fill_1
X_14745__1434 _14745_/RESET_B VDD VSS sg13g2_tiehi
XFILLER_10_630 VDD VSS sg13g2_decap_8
XFILLER_169_98 VDD VSS sg13g2_decap_8
XFILLER_22_490 VDD VSS sg13g2_decap_8
XFILLER_139_153 VDD VSS sg13g2_decap_8
XFILLER_167_462 VDD VSS sg13g2_decap_8
XFILLER_122_1336 VDD VSS sg13g2_fill_2
X_13342_ _15068_/D _13342_/A1 _13346_/A _13341_/Y VDD VSS sg13g2_a21o_1
XFILLER_127_315 VDD VSS sg13g2_decap_8
XFILLER_128_838 VDD VSS sg13g2_decap_4
X_10554_ _14866_/D _10554_/A _10555_/B _10557_/C VDD VSS sg13g2_and3_1
XFILLER_154_112 VDD VSS sg13g2_decap_8
XFILLER_6_623 VDD VSS sg13g2_decap_8
XFILLER_139_197 VDD VSS sg13g2_fill_1
XFILLER_33_1090 VDD VSS sg13g2_decap_8
X_13273_ _13273_/Y _14862_/Q _13273_/B VDD VSS sg13g2_nand2_1
X_10485_ _10508_/C _14849_/Q _10489_/C _14847_/Q _10486_/D VDD VSS sg13g2_and4_1
XFILLER_5_133 VDD VSS sg13g2_decap_8
XFILLER_142_307 VDD VSS sg13g2_decap_8
XFILLER_170_616 VDD VSS sg13g2_decap_8
XFILLER_108_573 VDD VSS sg13g2_fill_1
X_15012_ _15012_/Q clkload32/A _15012_/D _15012_/RESET_B VDD VSS sg13g2_dfrbpq_1
X_12224_ _12224_/Y _13245_/A _11655_/B _12294_/B1 VDD VSS sg13g2_a21oi_1
XFILLER_120_1093 VDD VSS sg13g2_decap_8
XFILLER_123_510 VDD VSS sg13g2_decap_8
XFILLER_135_370 VDD VSS sg13g2_decap_4
X_13686__2500 _13686_/RESET_B VDD VSS sg13g2_tiehi
X_12155_ _12156_/C _12155_/A _12155_/B _12198_/D VDD VSS sg13g2_nand3_1
XFILLER_2_840 VDD VSS sg13g2_decap_8
XFILLER_155_1145 VDD VSS sg13g2_decap_8
XFILLER_116_1107 VDD VSS sg13g2_fill_2
XFILLER_97_928 VDD VSS sg13g2_fill_2
XFILLER_123_587 VDD VSS sg13g2_decap_8
X_11106_ _11106_/Y _11093_/Y _11105_/Y _11151_/A VDD VSS sg13g2_a21oi_1
XFILLER_1_350 VDD VSS sg13g2_decap_8
X_12086_ _12086_/X _12197_/B _12086_/B VDD VSS sg13g2_xor2_1
XFILLER_78_95 VDD VSS sg13g2_fill_1
X_11037_ _11037_/Y _11036_/Y _11064_/C _11043_/A VDD VSS sg13g2_a21oi_1
XFILLER_42_1348 VDD VSS sg13g2_decap_8
XFILLER_37_516 VDD VSS sg13g2_fill_1
XFILLER_37_538 VDD VSS sg13g2_decap_8
XFILLER_94_94 VDD VSS sg13g2_fill_2
XFILLER_52_508 VDD VSS sg13g2_fill_2
XFILLER_18_763 VDD VSS sg13g2_decap_8
X_12988_ _12989_/C _12988_/A _12988_/B _12988_/C _12988_/D VDD VSS sg13g2_nor4_1
XFILLER_80_839 VDD VSS sg13g2_fill_1
XFILLER_33_722 VDD VSS sg13g2_decap_4
XFILLER_17_273 VDD VSS sg13g2_decap_8
XFILLER_127_1203 VDD VSS sg13g2_decap_8
X_14727_ _14727_/Q _14727_/CLK _14727_/D _14727_/RESET_B VDD VSS sg13g2_dfrbpq_1
X_11939_ _11939_/Y _12055_/B _11937_/Y _11938_/Y VDD VSS sg13g2_o21ai_1
XFILLER_32_221 VDD VSS sg13g2_decap_8
XFILLER_127_1225 VDD VSS sg13g2_decap_8
XFILLER_21_917 VDD VSS sg13g2_decap_8
X_14658_ _14658_/Q clkload29/A _14658_/D _14658_/RESET_B VDD VSS sg13g2_dfrbpq_1
XFILLER_33_788 VDD VSS sg13g2_decap_8
X_14384__1795 _14384_/RESET_B VDD VSS sg13g2_tiehi
XFILLER_14_980 VDD VSS sg13g2_decap_8
XFILLER_20_427 VDD VSS sg13g2_decap_8
X_13609_ _13609_/Y _13609_/A _13609_/B VDD VSS sg13g2_nor2_1
XFILLER_13_490 VDD VSS sg13g2_decap_8
X_14589_ _14589_/Q _14653_/CLK _14589_/D _14589_/RESET_B VDD VSS sg13g2_dfrbpq_1
XFILLER_174_911 VDD VSS sg13g2_decap_8
XFILLER_159_996 VDD VSS sg13g2_decap_8
X_14840__2864 _14840_/RESET_B VDD VSS sg13g2_tiehi
XFILLER_9_483 VDD VSS sg13g2_decap_8
XFILLER_12_1141 VDD VSS sg13g2_decap_8
XFILLER_146_679 VDD VSS sg13g2_decap_8
X_14004__2175 _14004_/RESET_B VDD VSS sg13g2_tiehi
XFILLER_173_476 VDD VSS sg13g2_decap_8
XFILLER_173_487 VDD VSS sg13g2_decap_8
XFILLER_57_0 VDD VSS sg13g2_decap_8
XFILLER_114_510 VDD VSS sg13g2_fill_2
XFILLER_160_126 VDD VSS sg13g2_decap_8
XFILLER_173_1201 VDD VSS sg13g2_fill_2
XFILLER_86_1264 VDD VSS sg13g2_decap_4
X_14873__2798 _14873_/RESET_B VDD VSS sg13g2_tiehi
XFILLER_86_1286 VDD VSS sg13g2_decap_8
XFILLER_142_863 VDD VSS sg13g2_fill_1
XFILLER_88_939 VDD VSS sg13g2_decap_8
XFILLER_82_1139 VDD VSS sg13g2_fill_1
XFILLER_99_276 VDD VSS sg13g2_decap_8
XFILLER_173_1267 VDD VSS sg13g2_decap_8
XFILLER_134_1229 VDD VSS sg13g2_decap_8
XFILLER_4_70 VDD VSS sg13g2_decap_8
X_07963_ _07963_/Y _15013_/Q _07861_/B VDD VSS sg13g2_nor2b_1
XFILLER_68_641 VDD VSS sg13g2_decap_8
X_09702_ _14294_/D _09768_/A1 _14294_/Q _09702_/S VDD VSS sg13g2_mux2_1
X_07894_ _07904_/B _07917_/B _08160_/B VDD VSS sg13g2_nor2_1
XFILLER_28_505 VDD VSS sg13g2_decap_4
XFILLER_68_674 VDD VSS sg13g2_decap_8
XFILLER_83_622 VDD VSS sg13g2_fill_1
XFILLER_28_527 VDD VSS sg13g2_decap_8
X_09633_ _14229_/D _10097_/A0 _14229_/Q _09634_/S VDD VSS sg13g2_mux2_1
XFILLER_67_195 VDD VSS sg13g2_fill_2
X_09564_ _14162_/D _09630_/A0 _14162_/Q _09572_/S VDD VSS sg13g2_mux2_1
XFILLER_167_1038 VDD VSS sg13g2_fill_2
XFILLER_82_154 VDD VSS sg13g2_fill_2
XFILLER_70_305 VDD VSS sg13g2_fill_2
XFILLER_58_1322 VDD VSS sg13g2_decap_8
XFILLER_55_379 VDD VSS sg13g2_decap_8
XFILLER_36_560 VDD VSS sg13g2_decap_8
XFILLER_70_316 VDD VSS sg13g2_decap_8
X_08515_ _08515_/Y _07816_/X _08623_/A2 _08654_/B VDD VSS sg13g2_o21ai_1
XFILLER_130_37 VDD VSS sg13g2_fill_1
XFILLER_64_891 VDD VSS sg13g2_decap_4
X_09495_ _14095_/D _10091_/A0 _14095_/Q _09504_/S VDD VSS sg13g2_mux2_1
XFILLER_23_210 VDD VSS sg13g2_decap_8
XFILLER_93_1246 VDD VSS sg13g2_fill_2
XFILLER_12_917 VDD VSS sg13g2_decap_8
XFILLER_169_738 VDD VSS sg13g2_decap_8
X_08446_ _08447_/B _08421_/Y _08444_/Y _08445_/Y VDD VSS sg13g2_o21ai_1
X_14214__1965 _14214_/RESET_B VDD VSS sg13g2_tiehi
XFILLER_11_427 VDD VSS sg13g2_decap_8
XFILLER_23_287 VDD VSS sg13g2_decap_8
XFILLER_168_259 VDD VSS sg13g2_decap_8
XFILLER_23_35 VDD VSS sg13g2_decap_8
X_08377_ _08377_/Y _08300_/X _08377_/B VDD VSS sg13g2_nand2b_1
XFILLER_135_7 VDD VSS sg13g2_decap_8
XFILLER_149_451 VDD VSS sg13g2_decap_8
XFILLER_165_900 VDD VSS sg13g2_decap_4
XFILLER_139_35 VDD VSS sg13g2_decap_8
XFILLER_17_1085 VDD VSS sg13g2_decap_8
XFILLER_104_1044 VDD VSS sg13g2_decap_8
XFILLER_104_1055 VDD VSS sg13g2_fill_1
XFILLER_20_994 VDD VSS sg13g2_decap_8
XFILLER_99_28 VDD VSS sg13g2_decap_4
X_13779__2400 _13779_/RESET_B VDD VSS sg13g2_tiehi
XFILLER_124_307 VDD VSS sg13g2_fill_2
XFILLER_164_476 VDD VSS sg13g2_decap_8
XFILLER_174_1009 VDD VSS sg13g2_decap_4
XFILLER_105_510 VDD VSS sg13g2_fill_2
XFILLER_152_638 VDD VSS sg13g2_decap_4
X_10270_ _10305_/A _14784_/Q _14785_/Q _10278_/C VDD VSS sg13g2_and3_1
XFILLER_3_637 VDD VSS sg13g2_decap_8
XFILLER_30_1296 VDD VSS sg13g2_decap_8
XFILLER_133_841 VDD VSS sg13g2_decap_8
XFILLER_105_543 VDD VSS sg13g2_fill_2
XFILLER_155_56 VDD VSS sg13g2_decap_8
XFILLER_2_147 VDD VSS sg13g2_decap_8
Xfanout1405 _12956_/B _13005_/C VDD VSS sg13g2_buf_1
XFILLER_120_524 VDD VSS sg13g2_decap_8
XFILLER_152_1329 VDD VSS sg13g2_fill_1
XFILLER_160_693 VDD VSS sg13g2_decap_8
XFILLER_78_438 VDD VSS sg13g2_fill_1
X_14159__2020 _14159_/RESET_B VDD VSS sg13g2_tiehi
XFILLER_48_21 VDD VSS sg13g2_decap_8
Xfanout440 _09799_/S _09805_/S VDD VSS sg13g2_buf_1
Xfanout451 _09571_/S _09540_/Y VDD VSS sg13g2_buf_1
XFILLER_8_1253 VDD VSS sg13g2_decap_8
X_13702__2477 _13702_/RESET_B VDD VSS sg13g2_tiehi
X_13960_ _13960_/Q _14310_/CLK _13960_/D _13960_/RESET_B VDD VSS sg13g2_dfrbpq_1
Xfanout473 _09230_/S _09226_/S VDD VSS sg13g2_buf_1
XFILLER_4_1106 VDD VSS sg13g2_decap_8
Xfanout484 _08941_/S _08956_/S VDD VSS sg13g2_buf_1
Xfanout495 _13652_/S _13656_/S VDD VSS sg13g2_buf_1
XFILLER_101_793 VDD VSS sg13g2_decap_8
X_12911_ _12911_/Y input28/X _13602_/A VDD VSS sg13g2_nand2b_1
XFILLER_86_482 VDD VSS sg13g2_decap_8
XFILLER_171_77 VDD VSS sg13g2_decap_8
XFILLER_24_1078 VDD VSS sg13g2_decap_8
XFILLER_0_28 VDD VSS sg13g2_decap_8
X_13891_ _13891_/Q _14505_/CLK _13891_/D _13891_/RESET_B VDD VSS sg13g2_dfrbpq_1
XFILLER_111_1048 VDD VSS sg13g2_fill_1
XFILLER_104_82 VDD VSS sg13g2_decap_8
X_12842_ _12845_/B _12900_/A _12900_/B _12867_/C input14/X VDD VSS sg13g2_nand4_1
XFILLER_74_677 VDD VSS sg13g2_fill_1
XFILLER_15_700 VDD VSS sg13g2_decap_8
XFILLER_74_699 VDD VSS sg13g2_decap_8
XFILLER_161_0 VDD VSS sg13g2_decap_8
XFILLER_27_571 VDD VSS sg13g2_decap_8
XFILLER_14_210 VDD VSS sg13g2_decap_8
X_12773_ _12773_/X _14265_/Q _14297_/Q _14329_/Q _14361_/Q _12773_/S0 _12773_/S1 VDD
+ VSS sg13g2_mux4_1
X_14512_ _14512_/Q _14512_/CLK _14512_/D _14512_/RESET_B VDD VSS sg13g2_dfrbpq_1
XFILLER_15_777 VDD VSS sg13g2_decap_8
X_11724_ _11724_/Y _11726_/A _11724_/B VDD VSS sg13g2_nor2_1
XFILLER_42_563 VDD VSS sg13g2_decap_8
XFILLER_70_883 VDD VSS sg13g2_decap_8
XFILLER_14_287 VDD VSS sg13g2_decap_8
XFILLER_70_1010 VDD VSS sg13g2_fill_1
XFILLER_159_259 VDD VSS sg13g2_decap_8
X_14443_ _14443_/Q clkload0/A _14443_/D _14443_/RESET_B VDD VSS sg13g2_dfrbpq_1
X_11655_ _11655_/Y _14906_/Q _11655_/B VDD VSS sg13g2_nand2_1
X_14966__2621 _14966_/RESET_B VDD VSS sg13g2_tiehi
XFILLER_156_911 VDD VSS sg13g2_decap_8
XFILLER_7_910 VDD VSS sg13g2_decap_8
XFILLER_128_624 VDD VSS sg13g2_fill_2
XFILLER_155_410 VDD VSS sg13g2_decap_8
X_10606_ _10629_/C _10606_/A _10606_/B _10652_/A VDD VSS sg13g2_nor3_1
X_14374_ _14374_/Q clkload11/A _14374_/D _14374_/RESET_B VDD VSS sg13g2_dfrbpq_1
X_11586_ _11586_/Y _12957_/A _11655_/B _12156_/A VDD VSS sg13g2_a21oi_1
XFILLER_11_994 VDD VSS sg13g2_decap_8
XFILLER_6_420 VDD VSS sg13g2_decap_8
X_13325_ _13326_/B _15113_/Q _13306_/B _13309_/Y _09640_/B VDD VSS sg13g2_a22oi_1
X_10537_ _10567_/B _14861_/Q _14860_/Q _14859_/Q _10558_/B VDD VSS sg13g2_nand4_1
XFILLER_171_914 VDD VSS sg13g2_decap_8
XFILLER_115_307 VDD VSS sg13g2_decap_8
X_14369__1810 _14369_/RESET_B VDD VSS sg13g2_tiehi
XFILLER_7_987 VDD VSS sg13g2_decap_8
XFILLER_170_413 VDD VSS sg13g2_decap_8
XFILLER_50_7 VDD VSS sg13g2_decap_8
X_13256_ _13259_/A _13243_/Y _13232_/A _13255_/Y VDD VSS sg13g2_o21ai_1
X_10468_ _14844_/D _10633_/A _10468_/B _10468_/C VDD VSS sg13g2_nor3_1
XFILLER_124_830 VDD VSS sg13g2_decap_8
XFILLER_6_497 VDD VSS sg13g2_decap_8
XFILLER_142_137 VDD VSS sg13g2_fill_2
X_14999__2588 _14999_/RESET_B VDD VSS sg13g2_tiehi
X_12207_ _12207_/X _13847_/Q _13879_/Q _13911_/Q _13943_/Q _12212_/S0 _12212_/S1 VDD
+ VSS sg13g2_mux4_1
X_13187_ _13191_/A _13188_/A _13225_/A _13186_/X VDD VSS sg13g2_a21o_1
X_10399_ _10414_/C _10400_/B _10400_/C _10400_/D VDD VSS sg13g2_nor3_1
X_12138_ _12138_/X _14389_/Q _14421_/Q _14485_/Q _14517_/Q _12138_/S0 _12138_/S1 VDD
+ VSS sg13g2_mux4_1
XFILLER_123_384 VDD VSS sg13g2_decap_8
XFILLER_97_769 VDD VSS sg13g2_decap_4
XFILLER_78_950 VDD VSS sg13g2_decap_8
XFILLER_46_1281 VDD VSS sg13g2_decap_8
X_12069_ _12069_/X _14259_/Q _14291_/Q _14323_/Q _14355_/Q _12073_/S0 _12073_/S1 VDD
+ VSS sg13g2_mux4_1
XFILLER_46_1292 VDD VSS sg13g2_fill_2
XFILLER_133_1262 VDD VSS sg13g2_fill_2
XFILLER_93_920 VDD VSS sg13g2_fill_1
XFILLER_77_482 VDD VSS sg13g2_decap_8
X_16877_ _16877_/X _16877_/A VDD VSS sg13g2_buf_1
XFILLER_93_953 VDD VSS sg13g2_decap_8
XFILLER_168_1358 VDD VSS sg13g2_decap_8
XFILLER_18_560 VDD VSS sg13g2_decap_8
XFILLER_80_625 VDD VSS sg13g2_decap_4
X_14471__1708 _14471_/RESET_B VDD VSS sg13g2_tiehi
X_13857__2322 _13857_/RESET_B VDD VSS sg13g2_tiehi
XFILLER_45_390 VDD VSS sg13g2_decap_8
X_08300_ _08300_/X _07775_/A _08300_/A1 _08867_/A1 _08300_/A3 _13517_/A _13521_/A
+ VDD VSS sg13g2_mux4_1
X_09280_ _13888_/D _13888_/Q _10143_/A1 _09305_/S VDD VSS sg13g2_mux2_1
XFILLER_33_563 VDD VSS sg13g2_decap_8
XFILLER_21_714 VDD VSS sg13g2_decap_8
X_08231_ _08231_/Y _07924_/C _08230_/Y _08000_/X VDD VSS sg13g2_o21ai_1
XFILLER_53_1230 VDD VSS sg13g2_decap_8
XFILLER_20_224 VDD VSS sg13g2_decap_8
XFILLER_127_1088 VDD VSS sg13g2_decap_8
XFILLER_92_1290 VDD VSS sg13g2_decap_8
XFILLER_18_1372 VDD VSS sg13g2_decap_8
XFILLER_18_1383 VDD VSS sg13g2_fill_1
XFILLER_14_1225 VDD VSS sg13g2_decap_8
X_08162_ _08162_/Y _08182_/B _08115_/B _08140_/Y VDD VSS sg13g2_o21ai_1
XFILLER_158_270 VDD VSS sg13g2_decap_8
XFILLER_9_280 VDD VSS sg13g2_decap_8
XFILLER_162_903 VDD VSS sg13g2_decap_8
X_08093_ _08093_/Y _07879_/Y _08091_/Y _08092_/Y VDD VSS sg13g2_a21oi_1
XFILLER_88_1337 VDD VSS sg13g2_decap_8
XFILLER_174_785 VDD VSS sg13g2_decap_4
XFILLER_133_104 VDD VSS sg13g2_fill_2
Xclkload50 clkload50/X clkload50/A VDD VSS sg13g2_buf_8
XFILLER_173_273 VDD VSS sg13g2_decap_8
Xclkload61 clkload61/Y clkload61/A VDD VSS sg13g2_inv_1
Xclkload72 clkload72/Y clkload72/A VDD VSS sg13g2_inv_4
XFILLER_47_1012 VDD VSS sg13g2_decap_8
XFILLER_115_863 VDD VSS sg13g2_decap_8
XFILLER_47_1023 VDD VSS sg13g2_decap_8
XFILLER_161_479 VDD VSS sg13g2_decap_8
XFILLER_142_682 VDD VSS sg13g2_decap_4
XFILLER_141_170 VDD VSS sg13g2_decap_8
X_15077__2841 _15077_/RESET_B VDD VSS sg13g2_tiehi
XFILLER_134_1026 VDD VSS sg13g2_decap_8
XFILLER_138_1195 VDD VSS sg13g2_decap_8
XFILLER_87_235 VDD VSS sg13g2_decap_8
X_08995_ _08995_/Y _14899_/Q _08988_/C _09024_/A VDD VSS sg13g2_o21ai_1
XFILLER_130_866 VDD VSS sg13g2_fill_2
XFILLER_134_1048 VDD VSS sg13g2_fill_2
XFILLER_69_961 VDD VSS sg13g2_decap_4
XFILLER_75_408 VDD VSS sg13g2_decap_8
X_07946_ _08435_/A _15005_/Q _07946_/B VDD VSS sg13g2_nand2b_1
XFILLER_25_1365 VDD VSS sg13g2_decap_8
XFILLER_60_1256 VDD VSS sg13g2_fill_2
XFILLER_112_1335 VDD VSS sg13g2_decap_8
XFILLER_21_1218 VDD VSS sg13g2_decap_8
XFILLER_18_35 VDD VSS sg13g2_decap_8
XFILLER_141_14 VDD VSS sg13g2_decap_8
X_07877_ _07917_/A _07879_/A _08138_/B VDD VSS sg13g2_nor2_1
XFILLER_28_335 VDD VSS sg13g2_fill_1
X_13670__2532 _13670_/RESET_B VDD VSS sg13g2_tiehi
X_09616_ _14212_/D _10047_/A0 _14212_/Q _09634_/S VDD VSS sg13g2_mux2_1
XFILLER_84_986 VDD VSS sg13g2_decap_8
XFILLER_141_69 VDD VSS sg13g2_decap_4
XFILLER_43_305 VDD VSS sg13g2_decap_8
XFILLER_3_1183 VDD VSS sg13g2_decap_8
XFILLER_110_1070 VDD VSS sg13g2_decap_8
X_09547_ _14145_/D _10077_/A0 _14145_/Q _09567_/S VDD VSS sg13g2_mux2_1
XFILLER_110_1092 VDD VSS sg13g2_fill_1
XFILLER_145_1100 VDD VSS sg13g2_fill_2
X_14447__1732 _14447_/RESET_B VDD VSS sg13g2_tiehi
XFILLER_71_669 VDD VSS sg13g2_fill_1
XFILLER_145_1111 VDD VSS sg13g2_fill_1
XFILLER_149_1291 VDD VSS sg13g2_fill_1
XFILLER_54_1005 VDD VSS sg13g2_decap_8
XFILLER_93_1065 VDD VSS sg13g2_fill_2
XFILLER_70_168 VDD VSS sg13g2_decap_8
XFILLER_12_714 VDD VSS sg13g2_decap_8
XFILLER_145_1144 VDD VSS sg13g2_decap_8
X_14921__2702 _14921_/RESET_B VDD VSS sg13g2_tiehi
X_09478_ _14078_/D _10074_/A0 _14078_/Q _09494_/S VDD VSS sg13g2_mux2_1
XFILLER_34_56 VDD VSS sg13g2_decap_8
XFILLER_169_546 VDD VSS sg13g2_decap_8
XFILLER_52_894 VDD VSS sg13g2_decap_8
XFILLER_19_1169 VDD VSS sg13g2_decap_8
XFILLER_11_224 VDD VSS sg13g2_decap_8
X_08429_ _08429_/Y _08659_/A _08429_/B _08429_/C VDD VSS sg13g2_nor3_1
XFILLER_8_707 VDD VSS sg13g2_decap_8
Xclkload0 clkload0/Y clkload0/A VDD VSS sg13g2_inv_1
X_11440_ _11440_/X _14560_/Q _14592_/Q _14624_/Q _14656_/Q _12215_/S0 _12213_/S1 VDD
+ VSS sg13g2_mux4_1
XFILLER_7_217 VDD VSS sg13g2_decap_8
XFILLER_32_1358 VDD VSS sg13g2_decap_8
XFILLER_20_791 VDD VSS sg13g2_decap_8
X_11371_ _11371_/Y _11821_/S0 _14142_/Q _11374_/C VDD VSS sg13g2_a21oi_1
X_14954__2636 _14954_/RESET_B VDD VSS sg13g2_tiehi
XFILLER_109_167 VDD VSS sg13g2_decap_8
XFILLER_164_273 VDD VSS sg13g2_decap_8
X_13110_ _13111_/B _13166_/A1 _13105_/X _13104_/Y _13160_/B _13109_/Y VDD VSS sg13g2_a221oi_1
X_10322_ _14800_/D _10322_/A _10323_/B _10334_/C VDD VSS sg13g2_and3_1
XFILLER_4_924 VDD VSS sg13g2_decap_8
X_14090_ _14090_/Q _14730_/CLK _14090_/D _14090_/RESET_B VDD VSS sg13g2_dfrbpq_1
XFILLER_125_649 VDD VSS sg13g2_decap_4
XFILLER_166_77 VDD VSS sg13g2_decap_8
XFILLER_3_434 VDD VSS sg13g2_decap_8
XFILLER_106_852 VDD VSS sg13g2_decap_4
X_13041_ _13041_/Y _13042_/A _13042_/B _13042_/C VDD VSS sg13g2_a21oi_1
X_10253_ _14779_/D _14779_/Q _10258_/D _10252_/Y VDD VSS sg13g2_a21oi_1
XFILLER_161_980 VDD VSS sg13g2_decap_4
XFILLER_106_896 VDD VSS sg13g2_decap_8
XFILLER_156_1273 VDD VSS sg13g2_decap_8
XFILLER_117_1235 VDD VSS sg13g2_decap_8
XFILLER_120_310 VDD VSS sg13g2_decap_8
XFILLER_65_1167 VDD VSS sg13g2_decap_8
X_13935__2244 _13935_/RESET_B VDD VSS sg13g2_tiehi
Xfanout1202 _10486_/D _14846_/Q VDD VSS sg13g2_buf_1
X_10184_ _10184_/X input36/X input3/X _10184_/C VDD VSS sg13g2_or3_1
X_14695__1484 _14695_/RESET_B VDD VSS sg13g2_tiehi
Xfanout1213 _13613_/B _14747_/Q VDD VSS sg13g2_buf_1
Xfanout1224 _12290_/S1 fanout1227/X VDD VSS sg13g2_buf_1
Xfanout1235 _11224_/A _11957_/A VDD VSS sg13g2_buf_1
Xfanout1246 _12308_/C _13659_/Q VDD VSS sg13g2_buf_1
XFILLER_94_717 VDD VSS sg13g2_decap_4
XFILLER_8_1050 VDD VSS sg13g2_decap_8
X_14992_ _14992_/Q _15228_/CLK _14992_/D _14992_/RESET_B VDD VSS sg13g2_dfrbpq_1
Xfanout1257 _11972_/S1 _11762_/S1 VDD VSS sg13g2_buf_1
Xfanout270 _09603_/S _09605_/S VDD VSS sg13g2_buf_1
Xfanout1268 _11229_/S1 _11899_/S1 VDD VSS sg13g2_buf_1
Xfanout281 _10048_/A0 _10148_/A1 VDD VSS sg13g2_buf_1
Xfanout1279 _12018_/C _12187_/C VDD VSS sg13g2_buf_1
Xfanout292 _09912_/A1 _09001_/X VDD VSS sg13g2_buf_1
X_13943_ _13943_/Q clkload34/A _13943_/D _13943_/RESET_B VDD VSS sg13g2_dfrbpq_1
XFILLER_46_121 VDD VSS sg13g2_decap_8
XFILLER_47_655 VDD VSS sg13g2_decap_8
XFILLER_19_357 VDD VSS sg13g2_decap_8
X_13874_ _13874_/Q clkload23/A _13874_/D _13874_/RESET_B VDD VSS sg13g2_dfrbpq_1
X_12825_ _12828_/B _13601_/A _12867_/C _12844_/C input22/X VDD VSS sg13g2_nand4_1
XFILLER_163_1200 VDD VSS sg13g2_decap_8
XFILLER_90_978 VDD VSS sg13g2_fill_1
XFILLER_61_146 VDD VSS sg13g2_fill_1
XFILLER_76_1263 VDD VSS sg13g2_decap_8
XFILLER_61_168 VDD VSS sg13g2_decap_8
XFILLER_15_574 VDD VSS sg13g2_decap_8
X_12756_ _12756_/X _14584_/Q _14616_/Q _14648_/Q _14680_/Q _12757_/S0 _12757_/S1 VDD
+ VSS sg13g2_mux4_1
XFILLER_98_7 VDD VSS sg13g2_decap_8
XFILLER_42_382 VDD VSS sg13g2_decap_8
XFILLER_163_1266 VDD VSS sg13g2_fill_2
X_11707_ _11707_/Y _11707_/A _11773_/C VDD VSS sg13g2_xnor2_1
XFILLER_91_95 VDD VSS sg13g2_decap_8
XFILLER_148_719 VDD VSS sg13g2_decap_4
XFILLER_129_911 VDD VSS sg13g2_fill_1
X_12687_ _12687_/X _14707_/Q _14739_/Q _13779_/Q _13811_/Q _12689_/S0 _12689_/S1 VDD
+ VSS sg13g2_mux4_1
XFILLER_128_410 VDD VSS sg13g2_decap_8
X_14426_ _14426_/Q clkload49/A _14426_/D _14426_/RESET_B VDD VSS sg13g2_dfrbpq_1
X_11638_ _11638_/X _11638_/A _11638_/B _11638_/C VDD VSS sg13g2_or3_1
XFILLER_11_791 VDD VSS sg13g2_decap_8
XFILLER_156_752 VDD VSS sg13g2_decap_8
X_14357_ _14357_/Q clkload16/A _14357_/D _14357_/RESET_B VDD VSS sg13g2_dfrbpq_1
Xwire660 wire660/X wire660/A VDD VSS sg13g2_buf_2
X_11569_ _11572_/A _11638_/A _11571_/C VDD VSS sg13g2_nor2_1
XFILLER_156_785 VDD VSS sg13g2_fill_2
XFILLER_128_487 VDD VSS sg13g2_decap_8
XFILLER_156_796 VDD VSS sg13g2_decap_8
XFILLER_7_784 VDD VSS sg13g2_decap_8
XFILLER_116_638 VDD VSS sg13g2_decap_8
XFILLER_157_1015 VDD VSS sg13g2_fill_2
X_13308_ _13308_/Y _13308_/A _15205_/Q VDD VSS sg13g2_nor2_1
XFILLER_144_958 VDD VSS sg13g2_decap_4
XFILLER_170_210 VDD VSS sg13g2_decap_8
X_14288_ _14288_/Q _14662_/CLK _14288_/D _14288_/RESET_B VDD VSS sg13g2_dfrbpq_1
XFILLER_6_294 VDD VSS sg13g2_decap_8
XFILLER_48_1321 VDD VSS sg13g2_decap_8
XFILLER_115_159 VDD VSS sg13g2_decap_8
XFILLER_143_479 VDD VSS sg13g2_fill_2
X_13239_ _15049_/D _13239_/A _13239_/B VDD VSS sg13g2_nor2_1
XFILLER_83_1223 VDD VSS sg13g2_decap_8
XFILLER_152_991 VDD VSS sg13g2_decap_4
XFILLER_170_287 VDD VSS sg13g2_decap_8
XFILLER_170_1215 VDD VSS sg13g2_decap_4
XFILLER_83_1267 VDD VSS sg13g2_decap_4
XFILLER_111_332 VDD VSS sg13g2_decap_8
X_14525__1654 _14525_/RESET_B VDD VSS sg13g2_tiehi
XFILLER_111_343 VDD VSS sg13g2_fill_2
XFILLER_170_1237 VDD VSS sg13g2_decap_8
XFILLER_83_1289 VDD VSS sg13g2_decap_8
X_07800_ _08574_/A _15006_/Q _07945_/B VDD VSS sg13g2_xor2_1
XFILLER_69_257 VDD VSS sg13g2_decap_4
X_08780_ _13678_/D _08728_/Y _08779_/Y _08778_/Y VDD VSS sg13g2_a21oi_1
XFILLER_97_588 VDD VSS sg13g2_fill_1
X_07731_ _07907_/D _15077_/Q _15075_/Q VDD VSS sg13g2_or2_1
XFILLER_133_1070 VDD VSS sg13g2_decap_4
XFILLER_38_633 VDD VSS sg13g2_decap_8
X_14779__2934 _14779_/RESET_B VDD VSS sg13g2_tiehi
XFILLER_168_1100 VDD VSS sg13g2_fill_2
XFILLER_81_901 VDD VSS sg13g2_decap_8
XFILLER_38_666 VDD VSS sg13g2_decap_8
X_07662_ _07662_/Y _14764_/Q _07766_/B VDD VSS sg13g2_nor2_1
XFILLER_77_1016 VDD VSS sg13g2_fill_1
X_09401_ _14004_/D _09632_/A0 _14004_/Q _09401_/S VDD VSS sg13g2_mux2_1
XFILLER_111_28 VDD VSS sg13g2_decap_8
XFILLER_92_293 VDD VSS sg13g2_decap_8
XFILLER_53_658 VDD VSS sg13g2_decap_4
XFILLER_0_1367 VDD VSS sg13g2_decap_8
X_15098__2779 _15098_/RESET_B VDD VSS sg13g2_tiehi
XFILLER_20_1295 VDD VSS sg13g2_decap_8
X_09332_ _13939_/D _09332_/A0 _13939_/Q _09338_/S VDD VSS sg13g2_mux2_1
XFILLER_90_1205 VDD VSS sg13g2_decap_8
XFILLER_55_1336 VDD VSS sg13g2_decap_8
XFILLER_21_511 VDD VSS sg13g2_decap_8
XFILLER_16_1309 VDD VSS sg13g2_decap_8
X_09263_ _13872_/D _13872_/Q _10159_/A1 _09264_/S VDD VSS sg13g2_mux2_1
XFILLER_90_1249 VDD VSS sg13g2_decap_4
X_08214_ _08214_/X _08374_/B _08617_/A _08212_/X VDD VSS sg13g2_a21o_1
XFILLER_14_1022 VDD VSS sg13g2_decap_8
X_09194_ _13810_/D _13810_/Q _10128_/A0 _09200_/S VDD VSS sg13g2_mux2_1
XFILLER_21_588 VDD VSS sg13g2_decap_8
XFILLER_53_1082 VDD VSS sg13g2_fill_1
X_08145_ _15221_/D _08145_/A _08145_/B _08145_/C VDD VSS sg13g2_nand3_1
XFILLER_105_1183 VDD VSS sg13g2_decap_4
XFILLER_140_1063 VDD VSS sg13g2_decap_4
XFILLER_146_240 VDD VSS sg13g2_fill_1
XFILLER_140_1074 VDD VSS sg13g2_fill_2
XFILLER_107_627 VDD VSS sg13g2_decap_8
XFILLER_135_936 VDD VSS sg13g2_fill_1
XFILLER_140_1085 VDD VSS sg13g2_fill_2
XFILLER_20_14 VDD VSS sg13g2_decap_8
XFILLER_14_1099 VDD VSS sg13g2_decap_8
XFILLER_135_958 VDD VSS sg13g2_decap_8
XFILLER_161_210 VDD VSS sg13g2_decap_8
X_08076_ _08076_/Y _08137_/S0 _08074_/X _08075_/Y VDD VSS sg13g2_a21oi_1
XFILLER_49_1118 VDD VSS sg13g2_fill_1
XFILLER_136_14 VDD VSS sg13g2_decap_8
XFILLER_134_468 VDD VSS sg13g2_fill_1
XFILLER_162_777 VDD VSS sg13g2_decap_8
XFILLER_122_619 VDD VSS sg13g2_fill_1
XFILLER_134_479 VDD VSS sg13g2_decap_8
XFILLER_162_788 VDD VSS sg13g2_decap_8
XFILLER_1_938 VDD VSS sg13g2_decap_8
XFILLER_0_448 VDD VSS sg13g2_decap_8
XFILLER_130_674 VDD VSS sg13g2_decap_4
XFILLER_88_588 VDD VSS sg13g2_decap_8
XFILLER_48_419 VDD VSS sg13g2_decap_8
X_08978_ wire398/A _10674_/A _08972_/S _08977_/Y VDD VSS sg13g2_o21ai_1
XFILLER_29_56 VDD VSS sg13g2_decap_8
XFILLER_102_387 VDD VSS sg13g2_decap_8
XFILLER_152_35 VDD VSS sg13g2_decap_8
XFILLER_60_1042 VDD VSS sg13g2_decap_8
XFILLER_25_1162 VDD VSS sg13g2_decap_8
XFILLER_102_398 VDD VSS sg13g2_fill_1
X_07929_ _07930_/A _08263_/B _07929_/B VDD VSS sg13g2_nand2b_1
XFILLER_99_1230 VDD VSS sg13g2_decap_8
XFILLER_21_1015 VDD VSS sg13g2_decap_8
XFILLER_84_750 VDD VSS sg13g2_fill_1
XFILLER_5_1267 VDD VSS sg13g2_decap_8
XFILLER_57_964 VDD VSS sg13g2_decap_8
XFILLER_112_1165 VDD VSS sg13g2_decap_8
X_10940_ _14937_/D _10939_/Y _10938_/Y _10929_/Y VDD VSS sg13g2_o21ai_1
XFILLER_95_1116 VDD VSS sg13g2_decap_8
XFILLER_84_783 VDD VSS sg13g2_decap_4
XFILLER_112_1187 VDD VSS sg13g2_fill_1
XFILLER_147_1206 VDD VSS sg13g2_fill_1
XFILLER_71_422 VDD VSS sg13g2_decap_8
X_10871_ _10871_/Y _10871_/A _10871_/B VDD VSS sg13g2_xnor2_1
XFILLER_71_444 VDD VSS sg13g2_decap_4
XFILLER_43_135 VDD VSS sg13g2_decap_4
XFILLER_45_77 VDD VSS sg13g2_decap_8
XFILLER_45_88 VDD VSS sg13g2_fill_1
X_12610_ _12611_/B _13675_/Q _12707_/A2 _12609_/X _12679_/B2 _12707_/C1 VDD VSS sg13g2_a221oi_1
X_13590_ _13590_/Y _13590_/A _13593_/B VDD VSS sg13g2_nor2_1
XFILLER_12_511 VDD VSS sg13g2_decap_8
XFILLER_169_343 VDD VSS sg13g2_decap_8
X_12541_ _15002_/D _12541_/A _12541_/B VDD VSS sg13g2_nor2_1
XFILLER_61_21 VDD VSS sg13g2_decap_8
XFILLER_8_504 VDD VSS sg13g2_decap_8
XFILLER_40_864 VDD VSS sg13g2_fill_2
XFILLER_157_538 VDD VSS sg13g2_decap_4
XFILLER_12_588 VDD VSS sg13g2_decap_8
X_12472_ _12485_/A _10213_/A _07737_/B _14998_/Q VDD VSS sg13g2_a21oi_1
X_14603__1576 _14603_/RESET_B VDD VSS sg13g2_tiehi
X_15161__2635 _15161_/RESET_B VDD VSS sg13g2_tiehi
XFILLER_71_1182 VDD VSS sg13g2_decap_8
XFILLER_61_98 VDD VSS sg13g2_decap_8
XFILLER_123_1261 VDD VSS sg13g2_decap_4
XFILLER_124_0 VDD VSS sg13g2_decap_8
X_14211_ _14211_/Q _14659_/CLK _14211_/D _14211_/RESET_B VDD VSS sg13g2_dfrbpq_1
XFILLER_138_763 VDD VSS sg13g2_fill_2
X_11423_ _11423_/Y _11420_/Y _11422_/Y _12000_/A VDD VSS sg13g2_a21oi_1
XFILLER_123_1283 VDD VSS sg13g2_fill_1
XFILLER_153_700 VDD VSS sg13g2_decap_8
XFILLER_165_560 VDD VSS sg13g2_decap_8
X_15191_ _15191_/Q clkload65/A _15191_/D _15191_/RESET_B VDD VSS sg13g2_dfrbpq_1
XFILLER_172_519 VDD VSS sg13g2_decap_8
XFILLER_138_796 VDD VSS sg13g2_decap_8
XANTENNA_9 _09702_/S VDD VSS sg13g2_antennanp
XFILLER_137_273 VDD VSS sg13g2_decap_4
XFILLER_6_49 VDD VSS sg13g2_decap_8
X_14142_ _14142_/Q clkload35/A _14142_/D _14142_/RESET_B VDD VSS sg13g2_dfrbpq_1
X_11354_ _11354_/Y _11353_/S _14622_/Q VDD VSS sg13g2_nand2b_1
XFILLER_4_721 VDD VSS sg13g2_decap_8
XFILLER_67_1218 VDD VSS sg13g2_decap_8
XFILLER_153_755 VDD VSS sg13g2_fill_2
XFILLER_113_608 VDD VSS sg13g2_decap_8
XFILLER_158_1357 VDD VSS sg13g2_decap_8
X_10305_ _10327_/B _10305_/A _10305_/B _10311_/B _10311_/C VDD VSS sg13g2_and4_1
XFILLER_3_231 VDD VSS sg13g2_decap_8
X_14073_ _14073_/Q _14649_/CLK _14073_/D _14073_/RESET_B VDD VSS sg13g2_dfrbpq_1
X_11285_ _11285_/Y _11285_/A _12334_/C VDD VSS sg13g2_nor2b_1
XFILLER_152_287 VDD VSS sg13g2_fill_2
XFILLER_4_798 VDD VSS sg13g2_decap_8
X_13024_ _13026_/A _13009_/A _13010_/B _13058_/C VDD VSS sg13g2_o21ai_1
X_10236_ _14773_/D _07638_/Y _10232_/B _10235_/Y VDD VSS sg13g2_a21oi_1
XFILLER_105_170 VDD VSS sg13g2_decap_4
XFILLER_10_91 VDD VSS sg13g2_decap_8
XFILLER_156_1092 VDD VSS sg13g2_fill_1
Xfanout1010 _09107_/B _09161_/S VDD VSS sg13g2_buf_1
Xfanout1021 _13613_/A _15056_/Q VDD VSS sg13g2_buf_1
XFILLER_121_674 VDD VSS sg13g2_decap_8
Xfanout1032 _08263_/B _14997_/Q VDD VSS sg13g2_buf_1
X_10167_ _14744_/D _14744_/Q _10167_/A1 _10167_/S VDD VSS sg13g2_mux2_1
Xfanout1043 _08241_/A _08270_/B VDD VSS sg13g2_buf_1
XFILLER_94_514 VDD VSS sg13g2_decap_4
XFILLER_0_982 VDD VSS sg13g2_decap_8
XFILLER_120_162 VDD VSS sg13g2_decap_4
Xfanout1054 _08194_/B _08599_/B VDD VSS sg13g2_buf_1
Xfanout1065 _13522_/A1 _13521_/A VDD VSS sg13g2_buf_1
XFILLER_48_931 VDD VSS sg13g2_decap_8
XFILLER_13_7 VDD VSS sg13g2_decap_8
Xfanout1076 _08083_/S0 _08686_/S0 VDD VSS sg13g2_buf_1
X_14975_ _14975_/Q clkload41/A _14975_/D _14975_/RESET_B VDD VSS sg13g2_dfrbpq_1
Xfanout1087 _08673_/B _12278_/A VDD VSS sg13g2_buf_1
X_10098_ _14678_/D _10098_/A0 _14678_/Q _10098_/S VDD VSS sg13g2_mux2_1
XFILLER_94_558 VDD VSS sg13g2_fill_1
Xfanout1098 _07853_/B _12128_/A VDD VSS sg13g2_buf_1
X_13926_ _13926_/Q _14310_/CLK _13926_/D _13926_/RESET_B VDD VSS sg13g2_dfrbpq_1
XFILLER_75_772 VDD VSS sg13g2_fill_2
XFILLER_35_603 VDD VSS sg13g2_fill_2
XFILLER_19_154 VDD VSS sg13g2_decap_8
XFILLER_78_1325 VDD VSS sg13g2_decap_8
XFILLER_34_102 VDD VSS sg13g2_fill_2
XFILLER_165_1306 VDD VSS sg13g2_fill_1
XFILLER_90_731 VDD VSS sg13g2_decap_8
X_13857_ _13857_/Q clkload25/A _13857_/D _13857_/RESET_B VDD VSS sg13g2_dfrbpq_1
XFILLER_16_861 VDD VSS sg13g2_decap_8
X_12808_ _12808_/Y _13300_/A _13312_/A VDD VSS sg13g2_nor2_1
XFILLER_22_308 VDD VSS sg13g2_decap_8
XFILLER_62_488 VDD VSS sg13g2_fill_2
XFILLER_50_628 VDD VSS sg13g2_fill_2
X_13788_ _13788_/Q _14746_/CLK _13788_/D _13788_/RESET_B VDD VSS sg13g2_dfrbpq_1
XFILLER_37_1033 VDD VSS sg13g2_decap_4
XFILLER_15_371 VDD VSS sg13g2_decap_8
XFILLER_163_1041 VDD VSS sg13g2_fill_1
XFILLER_31_831 VDD VSS sg13g2_decap_8
X_12739_ _12739_/X _13751_/Q _14103_/Q _14455_/Q _14551_/Q _12752_/S0 _12752_/S1 VDD
+ VSS sg13g2_mux4_1
XFILLER_163_1074 VDD VSS sg13g2_decap_8
XFILLER_124_1036 VDD VSS sg13g2_decap_8
XFILLER_129_730 VDD VSS sg13g2_fill_1
XFILLER_50_1211 VDD VSS sg13g2_decap_4
X_14409_ _14409_/Q _14505_/CLK _14409_/D _14409_/RESET_B VDD VSS sg13g2_dfrbpq_1
XFILLER_117_914 VDD VSS sg13g2_decap_8
XFILLER_141_1372 VDD VSS sg13g2_fill_2
XFILLER_102_1334 VDD VSS sg13g2_decap_8
XFILLER_117_925 VDD VSS sg13g2_fill_2
XFILLER_11_1239 VDD VSS sg13g2_decap_8
XFILLER_7_581 VDD VSS sg13g2_decap_8
XFILLER_171_530 VDD VSS sg13g2_decap_8
XFILLER_144_755 VDD VSS sg13g2_decap_8
XFILLER_89_308 VDD VSS sg13g2_fill_2
X_09950_ _14534_/D _14534_/Q _09950_/A1 _09961_/S VDD VSS sg13g2_mux2_1
XFILLER_143_265 VDD VSS sg13g2_decap_8
XFILLER_103_129 VDD VSS sg13g2_fill_2
X_08901_ _08901_/Y _13608_/A1 _08835_/B _16870_/A VDD VSS sg13g2_a21oi_1
XFILLER_98_831 VDD VSS sg13g2_decap_8
XFILLER_106_28 VDD VSS sg13g2_decap_8
XFILLER_112_630 VDD VSS sg13g2_fill_2
XFILLER_135_1121 VDD VSS sg13g2_decap_8
XFILLER_139_1290 VDD VSS sg13g2_decap_8
X_09881_ _14467_/D _09914_/A1 _14467_/Q _09899_/S VDD VSS sg13g2_mux2_1
XFILLER_174_1170 VDD VSS sg13g2_decap_8
XFILLER_48_1184 VDD VSS sg13g2_decap_8
XFILLER_174_1181 VDD VSS sg13g2_decap_8
XFILLER_83_1075 VDD VSS sg13g2_decap_8
X_14041__2138 _14041_/RESET_B VDD VSS sg13g2_tiehi
XFILLER_135_1165 VDD VSS sg13g2_fill_1
X_08832_ _08833_/C _13293_/A _15055_/Q _13283_/A _11241_/C VDD VSS sg13g2_nor4_1
XFILLER_112_685 VDD VSS sg13g2_decap_8
XFILLER_131_1018 VDD VSS sg13g2_decap_4
X_15229__2997 _15229_/RESET_B VDD VSS sg13g2_tiehi
XFILLER_131_1029 VDD VSS sg13g2_decap_8
XFILLER_85_536 VDD VSS sg13g2_decap_8
X_08763_ _08763_/Y _07720_/A _11288_/A _15189_/Q VDD VSS sg13g2_o21ai_1
XFILLER_22_1324 VDD VSS sg13g2_decap_8
XFILLER_100_869 VDD VSS sg13g2_decap_8
XFILLER_54_901 VDD VSS sg13g2_fill_2
X_07714_ _07714_/Y _07740_/A _13293_/D VDD VSS sg13g2_nand2_1
X_08694_ _08694_/Y _08380_/Y _08544_/B _08687_/X _08110_/D _08693_/Y VDD VSS sg13g2_a221oi_1
XFILLER_26_647 VDD VSS sg13g2_fill_2
X_07645_ _10297_/B _14793_/Q VDD VSS sg13g2_inv_1
XFILLER_80_241 VDD VSS sg13g2_decap_4
XFILLER_15_14 VDD VSS sg13g2_decap_8
XFILLER_20_1092 VDD VSS sg13g2_decap_8
XFILLER_0_1164 VDD VSS sg13g2_decap_8
XFILLER_13_308 VDD VSS sg13g2_decap_8
XFILLER_25_168 VDD VSS sg13g2_decap_8
XFILLER_41_628 VDD VSS sg13g2_decap_8
XFILLER_41_639 VDD VSS sg13g2_fill_1
X_09315_ _13922_/D _10145_/A1 _13922_/Q _09334_/S VDD VSS sg13g2_mux2_1
XFILLER_16_1106 VDD VSS sg13g2_decap_8
XFILLER_55_1177 VDD VSS sg13g2_decap_8
XFILLER_142_1136 VDD VSS sg13g2_decap_8
XFILLER_167_836 VDD VSS sg13g2_decap_4
XFILLER_139_549 VDD VSS sg13g2_decap_8
X_09246_ _13855_/D _13855_/Q _09910_/A1 _09264_/S VDD VSS sg13g2_mux2_1
XFILLER_167_869 VDD VSS sg13g2_decap_8
X_14994__2593 _14994_/RESET_B VDD VSS sg13g2_tiehi
XFILLER_142_1169 VDD VSS sg13g2_decap_8
XFILLER_21_385 VDD VSS sg13g2_decap_8
XFILLER_166_357 VDD VSS sg13g2_decap_8
XFILLER_31_35 VDD VSS sg13g2_decap_8
XFILLER_119_240 VDD VSS sg13g2_fill_2
XFILLER_154_519 VDD VSS sg13g2_decap_8
X_09177_ _13793_/D _13793_/Q _10144_/A1 _09200_/S VDD VSS sg13g2_mux2_1
XFILLER_135_711 VDD VSS sg13g2_decap_8
XFILLER_5_518 VDD VSS sg13g2_decap_8
XFILLER_147_35 VDD VSS sg13g2_decap_8
XFILLER_147_582 VDD VSS sg13g2_fill_2
X_08128_ _08128_/X _08384_/A1 _08487_/A3 _07826_/B _08493_/B2 _13522_/A1 _13517_/A
+ VDD VSS sg13g2_mux4_1
X_14251__1928 _14251_/RESET_B VDD VSS sg13g2_tiehi
XFILLER_135_744 VDD VSS sg13g2_fill_1
XFILLER_162_530 VDD VSS sg13g2_decap_8
X_14397__1782 _14397_/RESET_B VDD VSS sg13g2_tiehi
XFILLER_135_766 VDD VSS sg13g2_decap_8
XFILLER_147_79 VDD VSS sg13g2_decap_8
XFILLER_123_917 VDD VSS sg13g2_decap_8
XFILLER_123_928 VDD VSS sg13g2_decap_8
X_08059_ _08059_/X _11706_/A _07826_/B _11661_/A _11726_/A _08669_/B1 _08048_/A VDD
+ VSS sg13g2_mux4_1
XFILLER_162_585 VDD VSS sg13g2_decap_8
Xoutput46 mem_axi_araddr[17] _16870_/A VDD VSS sg13g2_buf_1
XFILLER_150_747 VDD VSS sg13g2_decap_8
Xoutput57 mem_axi_araddr[28] _16881_/A VDD VSS sg13g2_buf_1
X_11070_ _11070_/Y _11151_/A _11069_/Y _11067_/Y VDD VSS sg13g2_a21oi_1
XFILLER_1_735 VDD VSS sg13g2_decap_8
XFILLER_122_449 VDD VSS sg13g2_decap_8
Xoutput68 mem_axi_araddr[9] _16862_/A VDD VSS sg13g2_buf_1
Xoutput79 mem_axi_awaddr[18] _16871_/X VDD VSS sg13g2_buf_1
Xhold3140 _13535_/A _15144_/Q VDD VSS sg13g2_dlygate4sd3_1
XFILLER_0_245 VDD VSS sg13g2_decap_8
XFILLER_163_56 VDD VSS sg13g2_decap_8
Xhold3151 _13423_/C _15095_/Q VDD VSS sg13g2_dlygate4sd3_1
X_10021_ _14603_/D _10121_/A0 _14603_/Q _10027_/S VDD VSS sg13g2_mux2_1
Xhold3162 _13523_/A _15141_/Q VDD VSS sg13g2_dlygate4sd3_1
XFILLER_88_363 VDD VSS sg13g2_decap_8
XFILLER_27_1257 VDD VSS sg13g2_decap_8
XFILLER_103_674 VDD VSS sg13g2_decap_4
X_14017__2162 _14017_/RESET_B VDD VSS sg13g2_tiehi
XFILLER_48_227 VDD VSS sg13g2_fill_1
XFILLER_56_21 VDD VSS sg13g2_decap_8
XFILLER_48_249 VDD VSS sg13g2_decap_8
XFILLER_5_1064 VDD VSS sg13g2_decap_8
X_14760_ _14760_/Q _15188_/CLK _14760_/D _14760_/RESET_B VDD VSS sg13g2_dfrbpq_1
X_11972_ _11973_/A _14704_/Q _14736_/Q _13776_/Q _13808_/Q _11966_/S _11972_/S1 VDD
+ VSS sg13g2_mux4_1
XFILLER_57_783 VDD VSS sg13g2_decap_8
XFILLER_72_731 VDD VSS sg13g2_fill_1
XFILLER_29_496 VDD VSS sg13g2_decap_4
X_13711_ _16873_/A clkload42/A _13711_/D _13711_/RESET_B VDD VSS sg13g2_dfrbpq_1
XFILLER_99_1093 VDD VSS sg13g2_fill_1
X_10923_ _10937_/B _10923_/A _10923_/B _10954_/A _10923_/D VDD VSS sg13g2_nor4_1
XFILLER_72_742 VDD VSS sg13g2_decap_8
XFILLER_17_658 VDD VSS sg13g2_decap_8
X_14691_ _14691_/Q clkload19/A _14691_/D _14691_/RESET_B VDD VSS sg13g2_dfrbpq_1
XFILLER_147_1025 VDD VSS sg13g2_fill_1
XFILLER_71_241 VDD VSS sg13g2_fill_2
XFILLER_16_168 VDD VSS sg13g2_decap_8
X_13642_ _13750_/D _13642_/A VDD VSS sg13g2_buf_1
X_13885__2294 _13885_/RESET_B VDD VSS sg13g2_tiehi
X_10854_ _10865_/B _10870_/A _14752_/Q VDD VSS sg13g2_nand2_1
XFILLER_71_274 VDD VSS sg13g2_decap_8
XFILLER_31_105 VDD VSS sg13g2_decap_8
XFILLER_60_959 VDD VSS sg13g2_fill_2
XFILLER_158_803 VDD VSS sg13g2_decap_4
XFILLER_169_140 VDD VSS sg13g2_decap_8
X_13573_ _15156_/D _13570_/S _13571_/Y _13572_/Y VDD VSS sg13g2_a21oi_1
XFILLER_38_1375 VDD VSS sg13g2_decap_8
X_10785_ _10785_/Y _08943_/A _09148_/Y _08943_/Y VDD VSS sg13g2_o21ai_1
XFILLER_73_1266 VDD VSS sg13g2_decap_4
XFILLER_13_875 VDD VSS sg13g2_decap_8
XFILLER_8_301 VDD VSS sg13g2_decap_8
XFILLER_34_1239 VDD VSS sg13g2_decap_8
X_12524_ _12524_/X _12520_/X _12519_/X _12516_/X _12515_/X _12719_/S0 _12720_/S VDD
+ VSS sg13g2_mux4_1
XFILLER_12_385 VDD VSS sg13g2_decap_8
XFILLER_9_868 VDD VSS sg13g2_decap_8
X_15243_ _15243_/Q _15247_/CLK _15243_/D _15243_/RESET_B VDD VSS sg13g2_dfrbpq_1
X_12455_ _12455_/X _12454_/X _12453_/X _12776_/S VDD VSS sg13g2_mux2_1
XFILLER_8_378 VDD VSS sg13g2_decap_8
XFILLER_125_210 VDD VSS sg13g2_fill_1
XFILLER_158_1110 VDD VSS sg13g2_decap_8
X_11406_ _11425_/C _12000_/A _11404_/Y _11405_/Y VDD VSS sg13g2_o21ai_1
XFILLER_153_530 VDD VSS sg13g2_decap_8
X_15174_ _15174_/Q _15183_/CLK _15174_/D _15174_/RESET_B VDD VSS sg13g2_dfrbpq_1
XFILLER_158_1121 VDD VSS sg13g2_fill_2
X_12386_ _12386_/Y _12400_/A _12386_/B VDD VSS sg13g2_nand2_1
X_14227__1952 _14227_/RESET_B VDD VSS sg13g2_tiehi
X_14125_ _14125_/Q clkload3/A _14125_/D _14125_/RESET_B VDD VSS sg13g2_dfrbpq_1
X_11337_ _11338_/B _11249_/A _15123_/Q _12836_/B _11291_/A VDD VSS sg13g2_a22oi_1
XFILLER_154_1007 VDD VSS sg13g2_decap_8
Xclkbuf_leaf_122_clk_i _14733_/CLK clkbuf_5_4__f_clk_i/X VDD VSS sg13g2_buf_8
XFILLER_99_639 VDD VSS sg13g2_decap_8
XFILLER_107_980 VDD VSS sg13g2_decap_8
XFILLER_4_595 VDD VSS sg13g2_decap_8
X_14056_ _14056_/Q _14728_/CLK _14056_/D _14056_/RESET_B VDD VSS sg13g2_dfrbpq_1
XFILLER_45_1313 VDD VSS sg13g2_fill_1
XFILLER_106_490 VDD VSS sg13g2_decap_8
X_11268_ _11268_/Y _11267_/Y _12332_/B1 _11231_/S VDD VSS sg13g2_a21oi_1
XFILLER_122_950 VDD VSS sg13g2_fill_1
XFILLER_122_972 VDD VSS sg13g2_decap_4
X_13007_ _13058_/C _14907_/Q _13680_/Q VDD VSS sg13g2_nand2_1
XFILLER_97_94 VDD VSS sg13g2_fill_2
X_10219_ _10219_/X _14767_/Q _14768_/Q VDD VSS sg13g2_and2_1
XFILLER_80_1237 VDD VSS sg13g2_fill_1
X_11199_ _11199_/Y _11181_/A _11199_/B VDD VSS sg13g2_nand2b_1
XFILLER_95_845 VDD VSS sg13g2_decap_8
XFILLER_67_558 VDD VSS sg13g2_fill_1
XFILLER_94_355 VDD VSS sg13g2_decap_8
XFILLER_82_506 VDD VSS sg13g2_fill_1
XFILLER_94_377 VDD VSS sg13g2_decap_8
XFILLER_36_912 VDD VSS sg13g2_decap_8
X_14958_ _14958_/Q clkload62/A _14958_/D _14958_/RESET_B VDD VSS sg13g2_dfrbpq_1
XFILLER_82_528 VDD VSS sg13g2_decap_4
XFILLER_48_783 VDD VSS sg13g2_decap_8
XFILLER_36_923 VDD VSS sg13g2_fill_1
XFILLER_82_539 VDD VSS sg13g2_decap_8
XFILLER_78_1122 VDD VSS sg13g2_decap_8
XFILLER_36_934 VDD VSS sg13g2_decap_8
XFILLER_130_1073 VDD VSS sg13g2_decap_8
XFILLER_78_1133 VDD VSS sg13g2_fill_1
XFILLER_47_271 VDD VSS sg13g2_decap_8
XFILLER_75_591 VDD VSS sg13g2_fill_2
X_13909_ _13909_/Q clkload16/A _13909_/D _13909_/RESET_B VDD VSS sg13g2_dfrbpq_1
XFILLER_63_742 VDD VSS sg13g2_decap_8
X_14889_ _14889_/Q clkload48/A _14889_/D _14889_/RESET_B VDD VSS sg13g2_dfrbpq_1
XFILLER_90_561 VDD VSS sg13g2_decap_8
XFILLER_74_1019 VDD VSS sg13g2_fill_1
X_13715__2464 _13715_/RESET_B VDD VSS sg13g2_tiehi
XFILLER_50_414 VDD VSS sg13g2_fill_1
XFILLER_22_105 VDD VSS sg13g2_decap_8
XFILLER_35_499 VDD VSS sg13g2_fill_2
XFILLER_91_1344 VDD VSS sg13g2_decap_8
XFILLER_50_447 VDD VSS sg13g2_decap_8
X_09100_ _09100_/Y _15240_/Q _09100_/B VDD VSS sg13g2_nand2b_1
XFILLER_87_0 VDD VSS sg13g2_decap_8
XFILLER_31_672 VDD VSS sg13g2_decap_4
XFILLER_30_171 VDD VSS sg13g2_decap_8
XFILLER_148_357 VDD VSS sg13g2_decap_8
X_09031_ _09031_/Y _09057_/A _09031_/B _09031_/C VDD VSS sg13g2_nor3_1
XFILLER_164_828 VDD VSS sg13g2_decap_4
XFILLER_15_1183 VDD VSS sg13g2_decap_8
XFILLER_7_70 VDD VSS sg13g2_decap_8
XFILLER_11_1036 VDD VSS sg13g2_decap_8
XFILLER_144_552 VDD VSS sg13g2_decap_8
XFILLER_102_1186 VDD VSS sg13g2_decap_8
XFILLER_116_254 VDD VSS sg13g2_decap_4
XFILLER_104_405 VDD VSS sg13g2_fill_2
XFILLER_105_928 VDD VSS sg13g2_fill_2
XFILLER_85_1137 VDD VSS sg13g2_fill_1
XFILLER_89_105 VDD VSS sg13g2_decap_4
XFILLER_116_276 VDD VSS sg13g2_decap_8
X_09933_ _14518_/D _14518_/Q _09138_/X _09935_/S VDD VSS sg13g2_mux2_1
Xfanout803 _12661_/S1 _12660_/S1 VDD VSS sg13g2_buf_1
Xfanout814 _12758_/S1 _12759_/S1 VDD VSS sg13g2_buf_1
Xfanout825 _12703_/S1 _12785_/S1 VDD VSS sg13g2_buf_1
Xfanout836 _12689_/S1 _12731_/S1 VDD VSS sg13g2_buf_1
XFILLER_98_672 VDD VSS sg13g2_fill_2
XFILLER_112_460 VDD VSS sg13g2_fill_2
Xfanout847 _12752_/S1 _12745_/S1 VDD VSS sg13g2_buf_1
X_09864_ _14451_/D _14451_/Q _10095_/A0 _09867_/S VDD VSS sg13g2_mux2_1
Xfanout858 _12633_/S0 fanout860/X VDD VSS sg13g2_buf_1
Xfanout869 _12382_/S0 _12352_/S0 VDD VSS sg13g2_buf_1
X_08815_ _13689_/D _08813_/Y _08812_/Y _08814_/Y VDD VSS sg13g2_a21oi_1
XFILLER_85_333 VDD VSS sg13g2_decap_8
XFILLER_100_644 VDD VSS sg13g2_fill_2
XFILLER_86_867 VDD VSS sg13g2_decap_8
X_09795_ _14384_/D _09828_/A0 _14384_/Q _09796_/S VDD VSS sg13g2_mux2_1
XFILLER_6_1351 VDD VSS sg13g2_decap_8
XFILLER_133_59 VDD VSS sg13g2_fill_2
XFILLER_22_1121 VDD VSS sg13g2_decap_8
X_15039__2547 _15039_/RESET_B VDD VSS sg13g2_tiehi
XFILLER_2_1204 VDD VSS sg13g2_decap_8
XFILLER_45_208 VDD VSS sg13g2_decap_8
X_08746_ _08746_/Y _13667_/Q _08781_/B VDD VSS sg13g2_nor2_1
XFILLER_45_219 VDD VSS sg13g2_fill_1
XFILLER_113_1271 VDD VSS sg13g2_decap_8
XFILLER_39_794 VDD VSS sg13g2_decap_4
XFILLER_26_35 VDD VSS sg13g2_decap_8
XFILLER_22_1198 VDD VSS sg13g2_decap_8
X_08677_ _08697_/A _08662_/B _07847_/Y _07974_/C VDD VSS sg13g2_a21oi_1
XFILLER_165_7 VDD VSS sg13g2_decap_8
X_14882__2780 _14882_/RESET_B VDD VSS sg13g2_tiehi
XFILLER_96_1277 VDD VSS sg13g2_fill_2
XFILLER_54_786 VDD VSS sg13g2_decap_8
XFILLER_13_105 VDD VSS sg13g2_decap_8
X_07628_ _13609_/A _13602_/A VDD VSS sg13g2_inv_1
XFILLER_54_797 VDD VSS sg13g2_fill_1
X_14305__1874 _14305_/RESET_B VDD VSS sg13g2_tiehi
XFILLER_41_425 VDD VSS sg13g2_decap_8
XFILLER_107_1031 VDD VSS sg13g2_fill_1
XFILLER_10_812 VDD VSS sg13g2_decap_8
XFILLER_107_1053 VDD VSS sg13g2_decap_4
XFILLER_167_644 VDD VSS sg13g2_decap_8
X_10570_ _10572_/C _10579_/B _10579_/C _10647_/C VDD VSS sg13g2_a21oi_1
XFILLER_50_981 VDD VSS sg13g2_decap_8
XFILLER_50_992 VDD VSS sg13g2_fill_1
XFILLER_42_56 VDD VSS sg13g2_decap_8
XFILLER_167_655 VDD VSS sg13g2_fill_1
XFILLER_139_357 VDD VSS sg13g2_decap_8
XFILLER_127_508 VDD VSS sg13g2_decap_4
XFILLER_166_154 VDD VSS sg13g2_decap_8
XFILLER_6_805 VDD VSS sg13g2_decap_8
XFILLER_21_182 VDD VSS sg13g2_decap_8
XFILLER_158_56 VDD VSS sg13g2_decap_8
X_09229_ _13840_/D _10159_/A1 _13840_/Q _09230_/S VDD VSS sg13g2_mux2_1
XFILLER_108_700 VDD VSS sg13g2_decap_4
XFILLER_10_889 VDD VSS sg13g2_decap_8
XFILLER_5_315 VDD VSS sg13g2_decap_8
XFILLER_120_1242 VDD VSS sg13g2_decap_4
X_12240_ _12240_/Y _12017_/A _14584_/Q VDD VSS sg13g2_nand2b_1
XFILLER_108_744 VDD VSS sg13g2_decap_8
XFILLER_135_552 VDD VSS sg13g2_fill_2
XFILLER_174_11 VDD VSS sg13g2_decap_8
XFILLER_108_788 VDD VSS sg13g2_decap_8
XFILLER_135_563 VDD VSS sg13g2_decap_8
X_12171_ _12172_/A _13750_/Q _14102_/Q _14454_/Q _14550_/Q _12186_/A _12187_/C VDD
+ VSS sg13g2_mux4_1
XFILLER_68_1357 VDD VSS sg13g2_decap_4
XFILLER_123_747 VDD VSS sg13g2_decap_8
XFILLER_150_533 VDD VSS sg13g2_decap_4
X_11122_ _11123_/B _11119_/B _11063_/Y _11091_/B VDD VSS sg13g2_o21ai_1
XFILLER_1_532 VDD VSS sg13g2_decap_8
XFILLER_3_28 VDD VSS sg13g2_decap_8
Xclkbuf_leaf_54_clk_i clkload61/A clkbuf_leaf_72_clk_i/A VDD VSS sg13g2_buf_8
X_11053_ _11053_/Y _11068_/C _11068_/A _11151_/A VDD VSS sg13g2_o21ai_1
XFILLER_104_994 VDD VSS sg13g2_decap_8
XFILLER_118_1171 VDD VSS sg13g2_decap_8
XFILLER_89_683 VDD VSS sg13g2_fill_1
XFILLER_76_300 VDD VSS sg13g2_decap_8
XFILLER_27_1054 VDD VSS sg13g2_fill_1
XFILLER_67_42 VDD VSS sg13g2_decap_8
X_10004_ _10004_/Y _10037_/A _10004_/B _10004_/C _10070_/C VDD VSS sg13g2_nand4_1
XFILLER_7_1148 VDD VSS sg13g2_decap_8
XFILLER_76_333 VDD VSS sg13g2_decap_8
X_15093__2795 _15093_/RESET_B VDD VSS sg13g2_tiehi
XFILLER_88_193 VDD VSS sg13g2_fill_1
XFILLER_114_1057 VDD VSS sg13g2_decap_4
XFILLER_77_889 VDD VSS sg13g2_fill_2
XFILLER_114_1079 VDD VSS sg13g2_decap_8
X_14812_ _14812_/Q _14890_/CLK _14812_/D _14812_/RESET_B VDD VSS sg13g2_dfrbpq_1
XFILLER_92_837 VDD VSS sg13g2_fill_1
XFILLER_64_539 VDD VSS sg13g2_decap_8
XFILLER_123_70 VDD VSS sg13g2_decap_8
X_13972__2207 _13972_/RESET_B VDD VSS sg13g2_tiehi
Xclkbuf_leaf_69_clk_i clkload64/A clkbuf_leaf_82_clk_i/A VDD VSS sg13g2_buf_8
XFILLER_18_945 VDD VSS sg13g2_decap_8
X_14743_ _14743_/Q clkload34/A _14743_/D _14743_/RESET_B VDD VSS sg13g2_dfrbpq_1
X_11955_ _11955_/Y _11955_/A _11964_/B VDD VSS sg13g2_nand2_1
XFILLER_40_1298 VDD VSS sg13g2_decap_8
XFILLER_17_455 VDD VSS sg13g2_decap_8
X_10906_ _10948_/B _14756_/Q _10923_/B VDD VSS sg13g2_xor2_1
X_14674_ _14674_/Q _14706_/CLK _14674_/D _14674_/RESET_B VDD VSS sg13g2_dfrbpq_1
XFILLER_162_1309 VDD VSS sg13g2_decap_8
X_11886_ _11886_/Y _11217_/S _14414_/Q _11897_/C VDD VSS sg13g2_a21oi_1
XFILLER_32_436 VDD VSS sg13g2_decap_8
X_13625_ _13733_/D _13625_/A VDD VSS sg13g2_buf_1
XFILLER_158_600 VDD VSS sg13g2_decap_8
X_10837_ _10849_/A _10837_/A _10837_/B VDD VSS sg13g2_nand2_1
XFILLER_20_609 VDD VSS sg13g2_decap_8
XFILLER_125_1142 VDD VSS sg13g2_fill_2
XFILLER_13_672 VDD VSS sg13g2_decap_8
X_13556_ _13556_/Y _08138_/B _13567_/A2 _13555_/Y VDD VSS sg13g2_a21oi_1
XFILLER_80_7 VDD VSS sg13g2_decap_8
X_10768_ _11147_/A _14950_/Q _10767_/A _10767_/Y VDD VSS sg13g2_a21oi_1
XFILLER_73_1096 VDD VSS sg13g2_fill_2
XFILLER_121_1006 VDD VSS sg13g2_fill_2
XFILLER_118_508 VDD VSS sg13g2_fill_2
XFILLER_12_182 VDD VSS sg13g2_decap_8
XFILLER_157_154 VDD VSS sg13g2_decap_4
X_15228__2996 _15228_/RESET_B VDD VSS sg13g2_tiehi
X_12507_ _12507_/X _14118_/Q _14150_/Q _14182_/Q _14214_/Q _12507_/S0 _12507_/S1 VDD
+ VSS sg13g2_mux4_1
XFILLER_9_665 VDD VSS sg13g2_decap_8
XFILLER_173_603 VDD VSS sg13g2_decap_4
XFILLER_121_1028 VDD VSS sg13g2_decap_8
XFILLER_145_316 VDD VSS sg13g2_decap_8
X_13487_ _13487_/Y _13502_/A _15173_/D _15175_/D _13502_/D VDD VSS sg13g2_nor4_1
XFILLER_12_1323 VDD VSS sg13g2_decap_8
X_10699_ _10699_/Y _14902_/Q _10941_/B VDD VSS sg13g2_nand2_1
XFILLER_8_175 VDD VSS sg13g2_decap_8
XFILLER_173_647 VDD VSS sg13g2_decap_8
X_15226_ _15226_/Q _15226_/CLK _15226_/D _15226_/RESET_B VDD VSS sg13g2_dfrbpq_1
X_12438_ _12438_/X _14241_/Q _14273_/Q _14305_/Q _14337_/Q _12452_/S0 _12452_/S1 VDD
+ VSS sg13g2_mux4_1
XFILLER_173_658 VDD VSS sg13g2_fill_2
XFILLER_172_168 VDD VSS sg13g2_decap_8
XFILLER_154_883 VDD VSS sg13g2_decap_4
X_15157_ _15157_/Q clkload68/A _15157_/D _15157_/RESET_B VDD VSS sg13g2_dfrbpq_1
X_12369_ _12369_/X _12368_/X _12367_/X _12361_/X _12362_/X _12398_/S0 _12789_/S1 VDD
+ VSS sg13g2_mux4_1
XFILLER_5_882 VDD VSS sg13g2_decap_8
X_14108_ _14108_/Q clkload40/A _14108_/D _14108_/RESET_B VDD VSS sg13g2_dfrbpq_1
X_15088_ _15088_/Q _15159_/CLK _15088_/D _15088_/RESET_B VDD VSS sg13g2_dfrbpq_1
XFILLER_4_392 VDD VSS sg13g2_decap_8
XFILLER_99_469 VDD VSS sg13g2_decap_8
X_14039_ _14039_/Q clkload34/A _14039_/D _14039_/RESET_B VDD VSS sg13g2_dfrbpq_1
XFILLER_68_834 VDD VSS sg13g2_decap_8
XFILLER_110_931 VDD VSS sg13g2_fill_2
XFILLER_67_322 VDD VSS sg13g2_decap_4
XFILLER_67_333 VDD VSS sg13g2_decap_4
XFILLER_95_653 VDD VSS sg13g2_fill_2
XFILLER_80_1078 VDD VSS sg13g2_decap_4
XFILLER_45_1198 VDD VSS sg13g2_decap_8
X_08600_ _08600_/Y _08600_/A _08659_/B _08600_/C _08600_/D VDD VSS sg13g2_nor4_1
XFILLER_94_163 VDD VSS sg13g2_fill_1
XFILLER_103_18 VDD VSS sg13g2_fill_1
X_09580_ _14177_/D _14177_/Q _09945_/A1 _09601_/S VDD VSS sg13g2_mux2_1
XFILLER_55_539 VDD VSS sg13g2_fill_1
X_14562__1617 _14562_/RESET_B VDD VSS sg13g2_tiehi
X_08531_ _08531_/Y _08548_/A _08531_/B VDD VSS sg13g2_nor2_1
X_13948__2231 _13948_/RESET_B VDD VSS sg13g2_tiehi
XFILLER_82_358 VDD VSS sg13g2_decap_8
XFILLER_51_701 VDD VSS sg13g2_fill_1
X_08462_ _15236_/D _08462_/A _08462_/B _08462_/C VDD VSS sg13g2_nand3_1
XFILLER_1_1281 VDD VSS sg13g2_decap_8
XFILLER_50_233 VDD VSS sg13g2_fill_2
X_08393_ _08393_/Y _08394_/B _08394_/C _08414_/C VDD VSS sg13g2_o21ai_1
XFILLER_11_609 VDD VSS sg13g2_decap_8
XFILLER_23_469 VDD VSS sg13g2_decap_8
XFILLER_108_1340 VDD VSS sg13g2_fill_1
XFILLER_52_1114 VDD VSS sg13g2_fill_1
XFILLER_50_266 VDD VSS sg13g2_fill_1
XFILLER_52_1125 VDD VSS sg13g2_decap_8
XFILLER_10_119 VDD VSS sg13g2_decap_8
XFILLER_149_655 VDD VSS sg13g2_decap_4
XFILLER_137_806 VDD VSS sg13g2_decap_8
XFILLER_17_1267 VDD VSS sg13g2_decap_8
X_14859__2826 _14859_/RESET_B VDD VSS sg13g2_tiehi
X_09014_ _13763_/D _13763_/Q _10079_/A0 _09160_/S VDD VSS sg13g2_mux2_1
XFILLER_105_703 VDD VSS sg13g2_decap_4
XFILLER_163_168 VDD VSS sg13g2_decap_8
XFILLER_3_819 VDD VSS sg13g2_decap_8
XFILLER_105_714 VDD VSS sg13g2_fill_2
XFILLER_145_883 VDD VSS sg13g2_fill_1
XFILLER_89_1092 VDD VSS sg13g2_decap_8
XFILLER_132_511 VDD VSS sg13g2_decap_4
XFILLER_2_329 VDD VSS sg13g2_decap_8
XFILLER_144_14 VDD VSS sg13g2_decap_8
XFILLER_160_864 VDD VSS sg13g2_decap_8
XFILLER_160_875 VDD VSS sg13g2_fill_2
Xfanout600 _08943_/A _10720_/A VDD VSS sg13g2_buf_1
XFILLER_137_1068 VDD VSS sg13g2_decap_8
Xfanout611 _10694_/S _08893_/A VDD VSS sg13g2_buf_1
XFILLER_132_588 VDD VSS sg13g2_fill_2
Xfanout622 _13490_/B _08825_/C1 VDD VSS sg13g2_buf_1
X_09916_ _14501_/D _14501_/Q _09916_/A1 _09928_/S VDD VSS sg13g2_mux2_1
XFILLER_63_1232 VDD VSS sg13g2_decap_8
Xfanout633 _08541_/A _08692_/A VDD VSS sg13g2_buf_1
X_14762__2954 _14762_/RESET_B VDD VSS sg13g2_tiehi
Xfanout644 _12777_/C1 _12791_/C1 VDD VSS sg13g2_buf_1
Xfanout655 _13082_/B _13207_/C1 VDD VSS sg13g2_buf_1
XFILLER_86_631 VDD VSS sg13g2_fill_2
Xfanout666 _07705_/B _07703_/Y VDD VSS sg13g2_buf_1
XFILLER_58_333 VDD VSS sg13g2_decap_8
Xfanout677 _11500_/B2 _12339_/A1 VDD VSS sg13g2_buf_1
X_09847_ _14434_/D _14434_/Q _10012_/A0 _09867_/S VDD VSS sg13g2_mux2_1
XFILLER_101_964 VDD VSS sg13g2_decap_4
Xfanout688 _08721_/S _10187_/S VDD VSS sg13g2_buf_1
XFILLER_100_452 VDD VSS sg13g2_fill_1
Xfanout699 _12036_/B _12239_/B VDD VSS sg13g2_buf_1
XFILLER_59_889 VDD VSS sg13g2_decap_8
XFILLER_101_986 VDD VSS sg13g2_decap_8
XFILLER_101_997 VDD VSS sg13g2_fill_1
XFILLER_111_1219 VDD VSS sg13g2_decap_8
XFILLER_150_1268 VDD VSS sg13g2_decap_8
XFILLER_2_1001 VDD VSS sg13g2_decap_8
X_09778_ _14367_/D _09877_/A0 _14367_/Q _09796_/S VDD VSS sg13g2_mux2_1
XFILLER_46_539 VDD VSS sg13g2_decap_8
XFILLER_37_56 VDD VSS sg13g2_decap_8
XFILLER_160_35 VDD VSS sg13g2_decap_8
X_08729_ _08729_/Y _13345_/B _11061_/A2 _08727_/X _13448_/B _13490_/B VDD VSS sg13g2_a221oi_1
XFILLER_148_1120 VDD VSS sg13g2_decap_8
X_14538__1641 _14538_/RESET_B VDD VSS sg13g2_tiehi
XFILLER_57_1003 VDD VSS sg13g2_fill_2
XFILLER_96_1063 VDD VSS sg13g2_decap_8
XFILLER_2_1078 VDD VSS sg13g2_decap_8
XFILLER_26_252 VDD VSS sg13g2_decap_8
XFILLER_27_786 VDD VSS sg13g2_decap_8
X_11740_ _11742_/A _11759_/A _14634_/Q VDD VSS sg13g2_nand2b_1
XFILLER_109_1104 VDD VSS sg13g2_fill_2
XFILLER_15_959 VDD VSS sg13g2_decap_8
XFILLER_144_1006 VDD VSS sg13g2_decap_4
XFILLER_14_469 VDD VSS sg13g2_decap_8
X_11671_ _11671_/X _11671_/A _12036_/B VDD VSS sg13g2_and2_1
XFILLER_74_1350 VDD VSS sg13g2_fill_1
XFILLER_42_778 VDD VSS sg13g2_decap_8
XFILLER_161_1320 VDD VSS sg13g2_decap_4
XFILLER_42_789 VDD VSS sg13g2_fill_1
XFILLER_168_942 VDD VSS sg13g2_decap_8
X_13410_ _13421_/B _15194_/Q _15195_/Q _15196_/Q _15197_/Q VDD VSS sg13g2_nor4_1
XFILLER_74_1383 VDD VSS sg13g2_fill_1
XFILLER_70_1214 VDD VSS sg13g2_decap_8
X_10622_ _10636_/A _14882_/Q _10651_/D _10622_/C VDD VSS sg13g2_nand3_1
XFILLER_169_77 VDD VSS sg13g2_decap_8
X_14390_ _14390_/Q clkload26/A _14390_/D _14390_/RESET_B VDD VSS sg13g2_dfrbpq_1
XFILLER_139_132 VDD VSS sg13g2_decap_8
XFILLER_167_441 VDD VSS sg13g2_decap_8
XFILLER_122_1315 VDD VSS sg13g2_decap_8
XFILLER_128_817 VDD VSS sg13g2_decap_8
XFILLER_168_986 VDD VSS sg13g2_decap_8
XFILLER_35_1378 VDD VSS sg13g2_decap_4
X_13341_ _13341_/Y _13341_/A _15174_/D VDD VSS sg13g2_nor2b_1
X_10553_ _10555_/B _14866_/Q _14865_/Q _10556_/D VDD VSS sg13g2_nand3_1
XFILLER_6_602 VDD VSS sg13g2_decap_8
XFILLER_10_686 VDD VSS sg13g2_decap_8
XFILLER_5_112 VDD VSS sg13g2_decap_8
X_13272_ _13272_/X input28/X _13272_/A2 _13272_/B1 VDD VSS sg13g2_a21o_1
XFILLER_108_541 VDD VSS sg13g2_fill_2
XFILLER_120_1050 VDD VSS sg13g2_decap_8
X_10484_ _10495_/D _14849_/Q _10489_/C _14847_/Q _10484_/D VDD VSS sg13g2_and4_1
XFILLER_108_552 VDD VSS sg13g2_decap_8
XFILLER_68_1110 VDD VSS sg13g2_fill_1
X_15011_ _15011_/Q clkload32/A _15011_/D _15011_/RESET_B VDD VSS sg13g2_dfrbpq_1
XFILLER_6_679 VDD VSS sg13g2_decap_8
XFILLER_120_1072 VDD VSS sg13g2_decap_8
XFILLER_136_872 VDD VSS sg13g2_decap_8
X_12223_ _12223_/X _12223_/A _12223_/B _12223_/C VDD VSS sg13g2_or3_1
XFILLER_136_883 VDD VSS sg13g2_fill_1
XFILLER_136_894 VDD VSS sg13g2_decap_4
XFILLER_68_1154 VDD VSS sg13g2_fill_1
XFILLER_123_522 VDD VSS sg13g2_decap_8
XFILLER_5_189 VDD VSS sg13g2_decap_8
XFILLER_68_1165 VDD VSS sg13g2_decap_4
X_14640__1539 _14640_/RESET_B VDD VSS sg13g2_tiehi
X_12154_ _12156_/B _12155_/A _12155_/B _12198_/D VDD VSS sg13g2_a21o_1
XFILLER_64_1018 VDD VSS sg13g2_decap_8
XFILLER_151_864 VDD VSS sg13g2_decap_8
XFILLER_29_1149 VDD VSS sg13g2_decap_8
XFILLER_123_566 VDD VSS sg13g2_decap_8
XFILLER_81_1310 VDD VSS sg13g2_decap_8
XFILLER_78_63 VDD VSS sg13g2_decap_8
X_11105_ _11105_/Y _11125_/A _10759_/X _11118_/D VDD VSS sg13g2_a21oi_1
X_12085_ _12086_/B _12061_/A _13190_/B _12063_/Y VDD VSS sg13g2_a21oi_1
XFILLER_2_896 VDD VSS sg13g2_decap_8
XFILLER_89_480 VDD VSS sg13g2_decap_8
XFILLER_49_333 VDD VSS sg13g2_decap_4
XFILLER_42_1327 VDD VSS sg13g2_decap_8
X_11036_ _11036_/Y _11023_/A _11040_/A _11034_/Y _11022_/B VDD VSS sg13g2_a22oi_1
XFILLER_76_130 VDD VSS sg13g2_fill_1
XFILLER_49_366 VDD VSS sg13g2_decap_8
XFILLER_134_91 VDD VSS sg13g2_decap_8
XFILLER_65_848 VDD VSS sg13g2_decap_8
XFILLER_94_73 VDD VSS sg13g2_decap_8
XFILLER_64_336 VDD VSS sg13g2_decap_8
XFILLER_18_742 VDD VSS sg13g2_decap_8
XFILLER_91_144 VDD VSS sg13g2_decap_8
XFILLER_80_818 VDD VSS sg13g2_decap_8
X_12987_ _12987_/Y _12988_/C _12988_/D VDD VSS sg13g2_nor2_1
XFILLER_17_252 VDD VSS sg13g2_decap_8
X_14726_ _14726_/Q clkload2/A _14726_/D _14726_/RESET_B VDD VSS sg13g2_dfrbpq_1
X_11938_ _11938_/Y _11937_/Y _12055_/B _12296_/A1 VDD VSS sg13g2_a21oi_1
XFILLER_166_1253 VDD VSS sg13g2_fill_1
XFILLER_166_1286 VDD VSS sg13g2_decap_8
X_14657_ _14657_/Q _14681_/CLK _14657_/D _14657_/RESET_B VDD VSS sg13g2_dfrbpq_1
X_11869_ _11869_/Y _12090_/A _13838_/Q VDD VSS sg13g2_nand2b_1
XFILLER_20_406 VDD VSS sg13g2_decap_8
X_13608_ _13608_/Y _13608_/A1 _13611_/A2 hold3155/X VDD VSS sg13g2_a21oi_1
X_14588_ _14588_/Q _14682_/CLK _14588_/D _14588_/RESET_B VDD VSS sg13g2_dfrbpq_1
XFILLER_174_901 VDD VSS sg13g2_decap_4
X_13539_ _13539_/Y _13539_/A _13543_/B VDD VSS sg13g2_nor2_1
XFILLER_9_462 VDD VSS sg13g2_decap_8
XFILLER_174_923 VDD VSS sg13g2_fill_2
XFILLER_119_839 VDD VSS sg13g2_decap_8
XFILLER_12_1120 VDD VSS sg13g2_decap_8
XFILLER_173_422 VDD VSS sg13g2_decap_8
XFILLER_173_433 VDD VSS sg13g2_decap_8
XFILLER_118_349 VDD VSS sg13g2_fill_2
XFILLER_127_850 VDD VSS sg13g2_decap_8
XFILLER_145_146 VDD VSS sg13g2_fill_2
XFILLER_174_989 VDD VSS sg13g2_fill_2
X_15209_ _15209_/Q _15214_/CLK _15209_/D _15209_/RESET_B VDD VSS sg13g2_dfrbpq_1
XFILLER_138_1300 VDD VSS sg13g2_fill_1
XFILLER_160_105 VDD VSS sg13g2_decap_8
XFILLER_86_1243 VDD VSS sg13g2_decap_8
XFILLER_12_1197 VDD VSS sg13g2_decap_8
XFILLER_99_233 VDD VSS sg13g2_decap_8
XFILLER_142_853 VDD VSS sg13g2_fill_1
XFILLER_88_907 VDD VSS sg13g2_decap_8
XFILLER_153_190 VDD VSS sg13g2_decap_8
XFILLER_82_1118 VDD VSS sg13g2_decap_4
X_14616__1563 _14616_/RESET_B VDD VSS sg13g2_tiehi
XFILLER_47_1249 VDD VSS sg13g2_decap_8
XFILLER_141_374 VDD VSS sg13g2_decap_8
XFILLER_114_599 VDD VSS sg13g2_decap_8
X_07962_ _07962_/Y _15014_/Q _07859_/B VDD VSS sg13g2_nor2b_1
XFILLER_87_439 VDD VSS sg13g2_decap_8
X_09701_ _14293_/D _09932_/A1 _14293_/Q _09705_/S VDD VSS sg13g2_mux2_1
XFILLER_114_28 VDD VSS sg13g2_decap_8
XFILLER_96_962 VDD VSS sg13g2_decap_8
XFILLER_68_653 VDD VSS sg13g2_decap_8
X_07893_ _07893_/Y _08110_/C _08843_/A VDD VSS sg13g2_nand2_1
XFILLER_95_461 VDD VSS sg13g2_fill_2
X_09632_ _14228_/D _09632_/A0 _14228_/Q _09632_/S VDD VSS sg13g2_mux2_1
XFILLER_167_1017 VDD VSS sg13g2_decap_8
XFILLER_83_656 VDD VSS sg13g2_decap_8
XFILLER_82_133 VDD VSS sg13g2_decap_8
X_09563_ _14161_/D _09629_/A0 _14161_/Q _09563_/S VDD VSS sg13g2_mux2_1
XFILLER_23_1293 VDD VSS sg13g2_decap_8
XFILLER_3_1365 VDD VSS sg13g2_decap_8
XFILLER_97_1361 VDD VSS sg13g2_decap_8
XFILLER_64_870 VDD VSS sg13g2_decap_8
X_08514_ _08514_/Y _08514_/A _08625_/A VDD VSS sg13g2_nor2_1
XFILLER_93_1225 VDD VSS sg13g2_decap_8
XFILLER_36_583 VDD VSS sg13g2_decap_8
X_09494_ _14094_/D _09760_/A1 _14094_/Q _09494_/S VDD VSS sg13g2_mux2_1
XFILLER_63_380 VDD VSS sg13g2_decap_8
XFILLER_169_717 VDD VSS sg13g2_fill_2
XFILLER_51_542 VDD VSS sg13g2_decap_8
XFILLER_24_756 VDD VSS sg13g2_decap_8
X_08445_ _08445_/Y _07798_/X _07826_/X _07799_/X VDD VSS sg13g2_a21oi_1
XFILLER_51_564 VDD VSS sg13g2_decap_4
XFILLER_11_406 VDD VSS sg13g2_decap_8
XFILLER_23_266 VDD VSS sg13g2_decap_8
XFILLER_23_14 VDD VSS sg13g2_decap_8
XFILLER_168_238 VDD VSS sg13g2_decap_8
X_08376_ _08376_/X _08383_/A _07790_/A _08405_/A1 _08376_/A3 _13509_/A1 _13510_/A1
+ VDD VSS sg13g2_mux4_1
XFILLER_104_1001 VDD VSS sg13g2_fill_2
XFILLER_139_14 VDD VSS sg13g2_decap_8
XFILLER_17_1064 VDD VSS sg13g2_decap_8
XFILLER_165_912 VDD VSS sg13g2_fill_1
XFILLER_143_1072 VDD VSS sg13g2_fill_2
XFILLER_149_485 VDD VSS sg13g2_decap_8
XFILLER_128_7 VDD VSS sg13g2_decap_8
XFILLER_137_636 VDD VSS sg13g2_fill_2
XFILLER_20_973 VDD VSS sg13g2_decap_8
XFILLER_109_349 VDD VSS sg13g2_decap_8
XFILLER_164_455 VDD VSS sg13g2_decap_8
X_15109__2743 _15109_/RESET_B VDD VSS sg13g2_tiehi
XFILLER_87_1029 VDD VSS sg13g2_decap_8
XFILLER_121_1370 VDD VSS sg13g2_decap_4
XFILLER_152_617 VDD VSS sg13g2_decap_8
XFILLER_118_883 VDD VSS sg13g2_decap_4
XFILLER_3_616 VDD VSS sg13g2_decap_8
XFILLER_30_1275 VDD VSS sg13g2_decap_8
XFILLER_145_691 VDD VSS sg13g2_decap_8
XFILLER_151_127 VDD VSS sg13g2_decap_8
XFILLER_155_35 VDD VSS sg13g2_decap_8
XFILLER_2_126 VDD VSS sg13g2_decap_8
XFILLER_79_907 VDD VSS sg13g2_decap_8
XFILLER_120_503 VDD VSS sg13g2_decap_8
XFILLER_78_417 VDD VSS sg13g2_decap_8
Xfanout1406 _13427_/B _13469_/A VDD VSS sg13g2_buf_1
Xfanout430 _09999_/S _10002_/S VDD VSS sg13g2_buf_1
XFILLER_8_1232 VDD VSS sg13g2_decap_8
Xfanout441 _09805_/S _09773_/Y VDD VSS sg13g2_buf_1
XFILLER_63_1051 VDD VSS sg13g2_decap_4
XFILLER_115_1130 VDD VSS sg13g2_fill_1
XFILLER_120_558 VDD VSS sg13g2_decap_8
XFILLER_150_1010 VDD VSS sg13g2_decap_8
Xfanout452 _09530_/S _09539_/S VDD VSS sg13g2_buf_1
XFILLER_28_1182 VDD VSS sg13g2_decap_8
Xfanout463 _09398_/S _09407_/S VDD VSS sg13g2_buf_1
XFILLER_93_409 VDD VSS sg13g2_decap_8
Xfanout474 _09238_/S _09226_/S VDD VSS sg13g2_buf_1
Xfanout485 _08956_/S _08834_/X VDD VSS sg13g2_buf_1
XFILLER_86_461 VDD VSS sg13g2_decap_8
XFILLER_171_56 VDD VSS sg13g2_decap_8
XFILLER_101_772 VDD VSS sg13g2_decap_8
X_12910_ _12910_/Y _12910_/A _12909_/Y VDD VSS sg13g2_nor2b_1
Xfanout496 _13656_/S _13502_/A VDD VSS sg13g2_buf_1
XFILLER_47_826 VDD VSS sg13g2_decap_8
XFILLER_24_1057 VDD VSS sg13g2_decap_8
X_15227__2995 _15227_/RESET_B VDD VSS sg13g2_tiehi
XFILLER_74_623 VDD VSS sg13g2_decap_8
XFILLER_47_837 VDD VSS sg13g2_fill_2
X_13890_ _13890_/Q _14722_/CLK _13890_/D _13890_/RESET_B VDD VSS sg13g2_dfrbpq_1
XFILLER_74_634 VDD VSS sg13g2_fill_2
XFILLER_19_539 VDD VSS sg13g2_decap_8
XFILLER_111_1038 VDD VSS sg13g2_fill_2
XFILLER_100_282 VDD VSS sg13g2_decap_8
X_12841_ _12845_/A input29/X _12841_/B VDD VSS sg13g2_nand2_1
XFILLER_64_21 VDD VSS sg13g2_decap_8
XFILLER_62_829 VDD VSS sg13g2_decap_8
XFILLER_27_550 VDD VSS sg13g2_decap_8
X_14054__2125 _14054_/RESET_B VDD VSS sg13g2_tiehi
XFILLER_27_583 VDD VSS sg13g2_decap_8
X_12772_ _12772_/X _14393_/Q _14425_/Q _14489_/Q _14521_/Q _12773_/S0 _12773_/S1 VDD
+ VSS sg13g2_mux4_1
XFILLER_73_199 VDD VSS sg13g2_fill_2
XFILLER_42_520 VDD VSS sg13g2_fill_2
XFILLER_154_0 VDD VSS sg13g2_decap_8
XFILLER_15_756 VDD VSS sg13g2_decap_8
X_14511_ _14511_/Q _14672_/CLK _14511_/D _14511_/RESET_B VDD VSS sg13g2_dfrbpq_1
XFILLER_159_205 VDD VSS sg13g2_fill_1
X_11723_ _14971_/D _11706_/A _12295_/B1 _11722_/Y VDD VSS sg13g2_a21o_1
XFILLER_30_704 VDD VSS sg13g2_decap_8
XFILLER_14_266 VDD VSS sg13g2_decap_8
XFILLER_159_238 VDD VSS sg13g2_decap_8
XFILLER_9_49 VDD VSS sg13g2_decap_8
X_14442_ _14442_/Q _14730_/CLK _14442_/D _14442_/RESET_B VDD VSS sg13g2_dfrbpq_1
X_11654_ _11654_/X _11652_/X _11653_/X _12192_/A VDD VSS sg13g2_mux2_1
XFILLER_122_1101 VDD VSS sg13g2_decap_8
XFILLER_128_603 VDD VSS sg13g2_decap_8
XFILLER_156_923 VDD VSS sg13g2_decap_4
X_10605_ _10652_/A _14878_/Q _14877_/Q _14876_/Q _14875_/Q VDD VSS sg13g2_nand4_1
XFILLER_31_1006 VDD VSS sg13g2_decap_8
X_14373_ _14373_/Q clkload7/A _14373_/D _14373_/RESET_B VDD VSS sg13g2_dfrbpq_1
XFILLER_80_86 VDD VSS sg13g2_fill_1
XFILLER_11_973 VDD VSS sg13g2_decap_8
X_11585_ _11585_/Y _11975_/A _11583_/X _11584_/Y VDD VSS sg13g2_o21ai_1
XFILLER_122_1145 VDD VSS sg13g2_decap_4
XFILLER_127_124 VDD VSS sg13g2_decap_8
X_13324_ _15065_/D _13324_/A _13324_/B VDD VSS sg13g2_nor2_1
XFILLER_10_483 VDD VSS sg13g2_decap_8
X_10536_ _10543_/D _14861_/Q _14860_/Q _14859_/Q _10558_/B VDD VSS sg13g2_and4_1
XFILLER_13_91 VDD VSS sg13g2_decap_8
XFILLER_7_966 VDD VSS sg13g2_decap_8
XFILLER_171_904 VDD VSS sg13g2_decap_4
XFILLER_129_91 VDD VSS sg13g2_decap_4
X_13255_ _13255_/Y _14923_/Q _13664_/Q _13245_/X VDD VSS sg13g2_a21oi_1
XFILLER_6_476 VDD VSS sg13g2_decap_8
XFILLER_108_371 VDD VSS sg13g2_decap_8
XFILLER_155_499 VDD VSS sg13g2_decap_4
X_10467_ _10468_/C _10500_/A _10471_/C _10471_/D VDD VSS sg13g2_and3_1
X_12206_ _12206_/X _14391_/Q _14423_/Q _14487_/Q _14519_/Q _12212_/S0 _12212_/S1 VDD
+ VSS sg13g2_mux4_1
XFILLER_89_84 VDD VSS sg13g2_decap_8
XFILLER_135_190 VDD VSS sg13g2_decap_8
XFILLER_170_469 VDD VSS sg13g2_decap_8
X_13186_ _13186_/X _13189_/A _13190_/B _13225_/B VDD VSS sg13g2_a21o_1
XFILLER_43_7 VDD VSS sg13g2_decap_8
X_10398_ _10400_/D _14820_/Q _14821_/Q _14822_/Q _10398_/D VDD VSS sg13g2_nand4_1
XFILLER_97_715 VDD VSS sg13g2_decap_8
XFILLER_69_406 VDD VSS sg13g2_decap_8
XFILLER_123_363 VDD VSS sg13g2_decap_8
XFILLER_9_1029 VDD VSS sg13g2_decap_8
X_12137_ _12137_/X _14261_/Q _14293_/Q _14325_/Q _14357_/Q _12138_/S0 _12137_/S1 VDD
+ VSS sg13g2_mux4_1
XFILLER_97_737 VDD VSS sg13g2_decap_4
XFILLER_151_694 VDD VSS sg13g2_decap_8
X_14843__2858 _14843_/RESET_B VDD VSS sg13g2_tiehi
XFILLER_111_547 VDD VSS sg13g2_decap_8
XFILLER_46_1260 VDD VSS sg13g2_decap_8
XFILLER_2_693 VDD VSS sg13g2_decap_8
X_14264__1915 _14264_/RESET_B VDD VSS sg13g2_tiehi
XFILLER_81_1162 VDD VSS sg13g2_decap_8
XFILLER_42_1113 VDD VSS sg13g2_fill_2
X_12068_ _12068_/X _14387_/Q _14419_/Q _14483_/Q _14515_/Q _12073_/S0 _12073_/S1 VDD
+ VSS sg13g2_mux4_1
XFILLER_38_804 VDD VSS sg13g2_fill_2
XFILLER_78_973 VDD VSS sg13g2_fill_1
XFILLER_77_461 VDD VSS sg13g2_decap_8
X_11019_ _11019_/Y _11044_/C _11042_/D _11056_/B1 VDD VSS sg13g2_o21ai_1
XFILLER_133_1285 VDD VSS sg13g2_fill_2
XFILLER_64_100 VDD VSS sg13g2_fill_2
XFILLER_42_1168 VDD VSS sg13g2_decap_4
X_16876_ _16876_/X _16876_/A VDD VSS sg13g2_buf_1
XFILLER_65_667 VDD VSS sg13g2_decap_4
XFILLER_92_453 VDD VSS sg13g2_decap_8
XFILLER_80_604 VDD VSS sg13g2_decap_8
XFILLER_64_166 VDD VSS sg13g2_fill_1
XFILLER_92_486 VDD VSS sg13g2_decap_8
XFILLER_92_497 VDD VSS sg13g2_decap_8
XFILLER_61_840 VDD VSS sg13g2_decap_8
X_14709_ _14709_/Q clkload18/A _14709_/D _14709_/RESET_B VDD VSS sg13g2_dfrbpq_1
X_14927__2690 _14927_/RESET_B VDD VSS sg13g2_tiehi
X_08230_ _08230_/Y _08248_/A _08227_/Y _08229_/Y VDD VSS sg13g2_o21ai_1
XFILLER_20_203 VDD VSS sg13g2_decap_8
XFILLER_18_1351 VDD VSS sg13g2_decap_8
XFILLER_147_901 VDD VSS sg13g2_decap_8
XFILLER_14_1204 VDD VSS sg13g2_decap_8
X_08161_ _08182_/C _08843_/A _08161_/A2 _14959_/Q _08377_/B _08113_/Y VDD VSS sg13g2_a221oi_1
XFILLER_146_411 VDD VSS sg13g2_fill_2
XFILLER_53_1286 VDD VSS sg13g2_decap_8
XFILLER_147_956 VDD VSS sg13g2_fill_2
X_13752__2427 _13752_/RESET_B VDD VSS sg13g2_tiehi
XFILLER_174_731 VDD VSS sg13g2_fill_1
X_13898__2281 _13898_/RESET_B VDD VSS sg13g2_tiehi
X_08092_ _08092_/Y _07879_/Y _08091_/Y _08588_/B VDD VSS sg13g2_o21ai_1
XFILLER_118_146 VDD VSS sg13g2_decap_8
XFILLER_173_252 VDD VSS sg13g2_decap_8
Xclkload40 clkload40/Y clkload40/A VDD VSS sg13g2_inv_1
Xclkload51 clkload51/Y clkload51/A VDD VSS sg13g2_inv_1
Xclkload62 clkload62/Y clkload62/A VDD VSS sg13g2_inv_4
XFILLER_161_436 VDD VSS sg13g2_decap_8
XFILLER_86_1040 VDD VSS sg13g2_decap_4
XFILLER_115_842 VDD VSS sg13g2_decap_8
XFILLER_133_138 VDD VSS sg13g2_decap_8
XFILLER_130_801 VDD VSS sg13g2_decap_8
X_14132__2047 _14132_/RESET_B VDD VSS sg13g2_tiehi
XFILLER_86_1095 VDD VSS sg13g2_decap_4
XFILLER_134_1005 VDD VSS sg13g2_decap_8
X_08994_ _09011_/D _14899_/Q _12859_/A _10681_/A _10674_/A VDD VSS sg13g2_nand4_1
XFILLER_114_396 VDD VSS sg13g2_fill_1
XFILLER_60_1202 VDD VSS sg13g2_fill_1
XFILLER_69_951 VDD VSS sg13g2_fill_2
X_07945_ _07945_/Y _15006_/Q _07945_/B VDD VSS sg13g2_nand2b_1
XFILLER_25_1344 VDD VSS sg13g2_decap_8
XFILLER_69_995 VDD VSS sg13g2_decap_8
XFILLER_60_1246 VDD VSS sg13g2_fill_1
XFILLER_18_14 VDD VSS sg13g2_decap_8
XFILLER_84_932 VDD VSS sg13g2_fill_2
X_07876_ _07876_/Y _07876_/A _07876_/B VDD VSS sg13g2_nand2_1
XFILLER_84_965 VDD VSS sg13g2_decap_8
XFILLER_55_122 VDD VSS sg13g2_decap_4
X_09615_ _14211_/D _09615_/A0 _14211_/Q _09634_/S VDD VSS sg13g2_mux2_1
XFILLER_3_1162 VDD VSS sg13g2_decap_8
XFILLER_23_1090 VDD VSS sg13g2_decap_8
XFILLER_55_177 VDD VSS sg13g2_decap_8
X_09546_ _14144_/D _10043_/A0 _14144_/Q _09567_/S VDD VSS sg13g2_mux2_1
XFILLER_70_147 VDD VSS sg13g2_decap_4
XFILLER_34_35 VDD VSS sg13g2_decap_8
XFILLER_169_525 VDD VSS sg13g2_decap_8
X_09477_ _14077_/D _10107_/A0 _14077_/Q _09494_/S VDD VSS sg13g2_mux2_1
XFILLER_52_873 VDD VSS sg13g2_decap_8
XFILLER_19_1148 VDD VSS sg13g2_decap_8
XFILLER_11_203 VDD VSS sg13g2_decap_8
X_08428_ _08428_/X _08337_/X _08427_/X _08511_/S VDD VSS sg13g2_mux2_1
XFILLER_93_1099 VDD VSS sg13g2_fill_1
XFILLER_141_1009 VDD VSS sg13g2_fill_1
Xclkload1 clkload1/X clkload1/A VDD VSS sg13g2_buf_8
X_08359_ _08373_/C _08415_/A _08674_/A2 _08668_/B _08381_/A _08358_/Y VDD VSS sg13g2_a221oi_1
XFILLER_32_1337 VDD VSS sg13g2_decap_8
XFILLER_20_770 VDD VSS sg13g2_decap_8
XFILLER_138_956 VDD VSS sg13g2_decap_8
Xclkbuf_5_11__f_clk_i clkbuf_leaf_36_clk_i/A clkbuf_4_5_0_clk_i/X VDD VSS sg13g2_buf_16
XFILLER_109_146 VDD VSS sg13g2_decap_8
XFILLER_165_764 VDD VSS sg13g2_fill_1
X_14342__1837 _14342_/RESET_B VDD VSS sg13g2_tiehi
X_11370_ _11370_/Y _11821_/S0 _14110_/Q VDD VSS sg13g2_nand2b_1
XFILLER_50_56 VDD VSS sg13g2_decap_8
X_13728__2451 _13728_/RESET_B VDD VSS sg13g2_tiehi
XFILLER_164_252 VDD VSS sg13g2_decap_8
X_14488__1691 _14488_/RESET_B VDD VSS sg13g2_tiehi
XFILLER_4_903 VDD VSS sg13g2_decap_8
XFILLER_125_628 VDD VSS sg13g2_decap_8
XFILLER_153_937 VDD VSS sg13g2_fill_2
XFILLER_166_56 VDD VSS sg13g2_decap_8
X_10321_ _10323_/B _14798_/Q _14799_/Q _14800_/Q _10342_/C VDD VSS sg13g2_nand4_1
XFILLER_3_413 VDD VSS sg13g2_decap_8
XFILLER_106_831 VDD VSS sg13g2_decap_8
X_13040_ _13042_/C _13057_/B _13057_/C VDD VSS sg13g2_nand2_1
XFILLER_69_1271 VDD VSS sg13g2_fill_2
XFILLER_156_1230 VDD VSS sg13g2_decap_4
X_10252_ _10252_/Y _14779_/Q _10258_/D _10295_/C VDD VSS sg13g2_o21ai_1
XFILLER_59_21 VDD VSS sg13g2_decap_8
XFILLER_105_352 VDD VSS sg13g2_decap_4
XFILLER_156_1252 VDD VSS sg13g2_decap_8
XFILLER_79_726 VDD VSS sg13g2_decap_8
XFILLER_117_1214 VDD VSS sg13g2_decap_8
X_10183_ _14748_/D _10173_/Y _10181_/Y _10182_/Y VDD VSS sg13g2_o21ai_1
X_14108__2071 _14108_/RESET_B VDD VSS sg13g2_tiehi
Xfanout1203 _10500_/A _14844_/Q VDD VSS sg13g2_buf_1
XFILLER_26_1119 VDD VSS sg13g2_decap_8
XFILLER_105_396 VDD VSS sg13g2_fill_1
Xfanout1214 _12836_/B _13692_/Q VDD VSS sg13g2_buf_1
XFILLER_78_236 VDD VSS sg13g2_fill_2
Xfanout1225 _12265_/B1 fanout1227/X VDD VSS sg13g2_buf_1
Xfanout1236 _11957_/A _11450_/A1 VDD VSS sg13g2_buf_1
X_14991_ _14991_/Q clkload62/A _14991_/D _14991_/RESET_B VDD VSS sg13g2_dfrbpq_1
Xfanout1247 _11851_/S1 _11852_/S1 VDD VSS sg13g2_buf_1
Xfanout260 _10063_/S _10069_/S VDD VSS sg13g2_buf_1
Xfanout1258 _12038_/B1 _12026_/C VDD VSS sg13g2_buf_1
Xfanout271 _09599_/S _09605_/S VDD VSS sg13g2_buf_1
Xfanout1269 _11899_/S1 _12215_/S1 VDD VSS sg13g2_buf_1
XFILLER_75_910 VDD VSS sg13g2_decap_8
Xfanout282 _09916_/A1 _10148_/A1 VDD VSS sg13g2_buf_1
X_13942_ _13942_/Q clkload26/A _13942_/D _13942_/RESET_B VDD VSS sg13g2_dfrbpq_1
XFILLER_93_228 VDD VSS sg13g2_fill_2
Xfanout293 _10077_/A0 _09945_/A1 VDD VSS sg13g2_buf_1
XFILLER_86_291 VDD VSS sg13g2_fill_1
XFILLER_19_336 VDD VSS sg13g2_decap_8
X_13873_ _13873_/Q clkload7/A _13873_/D _13873_/RESET_B VDD VSS sg13g2_dfrbpq_1
XFILLER_62_604 VDD VSS sg13g2_decap_4
XFILLER_35_829 VDD VSS sg13g2_decap_8
X_13830__2349 _13830_/RESET_B VDD VSS sg13g2_tiehi
X_12824_ _15022_/D _13239_/A _12824_/B VDD VSS sg13g2_nor2_1
X_14590__1589 _14590_/RESET_B VDD VSS sg13g2_tiehi
XFILLER_90_957 VDD VSS sg13g2_decap_8
XFILLER_76_1242 VDD VSS sg13g2_decap_8
XFILLER_128_1332 VDD VSS sg13g2_fill_2
XFILLER_15_553 VDD VSS sg13g2_decap_8
X_12755_ _12755_/X _14264_/Q _14296_/Q _14328_/Q _14360_/Q _12758_/S0 _12758_/S1 VDD
+ VSS sg13g2_mux4_1
XFILLER_72_1117 VDD VSS sg13g2_decap_8
XFILLER_37_1248 VDD VSS sg13g2_decap_4
X_11706_ _11773_/C _11706_/A _13679_/Q VDD VSS sg13g2_xnor2_1
X_12686_ _12686_/X _13843_/Q _13875_/Q _13907_/Q _13939_/Q _12689_/S0 _12689_/S1 VDD
+ VSS sg13g2_mux4_1
XFILLER_129_923 VDD VSS sg13g2_fill_1
X_14425_ _14425_/Q _14505_/CLK _14425_/D _14425_/RESET_B VDD VSS sg13g2_dfrbpq_1
X_11637_ _11776_/A _11638_/C _11637_/B VDD VSS sg13g2_nor2_1
XFILLER_11_770 VDD VSS sg13g2_decap_8
XFILLER_156_731 VDD VSS sg13g2_decap_8
XFILLER_129_978 VDD VSS sg13g2_fill_2
X_14356_ _14356_/Q clkload15/A _14356_/D _14356_/RESET_B VDD VSS sg13g2_dfrbpq_1
XFILLER_10_280 VDD VSS sg13g2_decap_8
XFILLER_155_241 VDD VSS sg13g2_decap_4
X_11568_ _11571_/C _11502_/A _13685_/Q _12942_/B _11526_/A _11505_/X VDD VSS sg13g2_a221oi_1
XFILLER_128_466 VDD VSS sg13g2_decap_8
XFILLER_7_763 VDD VSS sg13g2_decap_8
X_14318__1861 _14318_/RESET_B VDD VSS sg13g2_tiehi
X_13307_ _13307_/Y _13308_/A _13307_/B VDD VSS sg13g2_nor2_1
XFILLER_143_414 VDD VSS sg13g2_fill_1
X_10519_ _14855_/D _13141_/A _10519_/B _10519_/C VDD VSS sg13g2_nor3_1
XFILLER_109_680 VDD VSS sg13g2_decap_4
XFILLER_13_1281 VDD VSS sg13g2_decap_8
X_14287_ _14287_/Q clkload6/A _14287_/D _14287_/RESET_B VDD VSS sg13g2_dfrbpq_1
XFILLER_6_273 VDD VSS sg13g2_decap_8
XFILLER_109_691 VDD VSS sg13g2_decap_4
X_11499_ _11499_/Y _14901_/Q _11433_/B _11500_/B2 VDD VSS sg13g2_a21oi_1
XFILLER_83_1202 VDD VSS sg13g2_decap_8
X_13238_ _13239_/B _13253_/B2 _13233_/X _13232_/Y _13238_/B2 _13237_/Y VDD VSS sg13g2_a221oi_1
XFILLER_170_266 VDD VSS sg13g2_decap_8
XFILLER_171_789 VDD VSS sg13g2_decap_8
XFILLER_44_1208 VDD VSS sg13g2_decap_8
XFILLER_3_980 VDD VSS sg13g2_decap_8
X_13169_ _13169_/Y _13170_/C _13170_/D VDD VSS sg13g2_nor2_1
X_15249__2495 _15249_/RESET_B VDD VSS sg13g2_tiehi
XFILLER_174_1374 VDD VSS sg13g2_fill_1
XFILLER_135_1347 VDD VSS sg13g2_decap_4
XFILLER_2_490 VDD VSS sg13g2_decap_8
XFILLER_85_729 VDD VSS sg13g2_decap_8
XFILLER_38_612 VDD VSS sg13g2_decap_8
X_07730_ _07734_/B _15078_/Q _15084_/Q _15085_/Q _15081_/Q VDD VSS sg13g2_nor4_1
XFILLER_65_442 VDD VSS sg13g2_fill_1
XFILLER_37_133 VDD VSS sg13g2_decap_4
XFILLER_66_976 VDD VSS sg13g2_fill_2
X_07661_ _07661_/Y _07766_/B VDD VSS sg13g2_inv_1
XFILLER_93_762 VDD VSS sg13g2_fill_1
X_16859_ _16859_/X _16859_/A VDD VSS sg13g2_buf_1
XFILLER_65_464 VDD VSS sg13g2_decap_8
XFILLER_53_615 VDD VSS sg13g2_fill_2
XFILLER_37_166 VDD VSS sg13g2_decap_8
X_09400_ _14003_/D _09666_/A0 _14003_/Q _09403_/S VDD VSS sg13g2_mux2_1
XFILLER_37_177 VDD VSS sg13g2_fill_1
XFILLER_53_637 VDD VSS sg13g2_decap_8
X_14420__1759 _14420_/RESET_B VDD VSS sg13g2_tiehi
XFILLER_65_497 VDD VSS sg13g2_fill_2
XFILLER_0_1346 VDD VSS sg13g2_decap_8
XFILLER_164_1009 VDD VSS sg13g2_fill_2
X_13806__2373 _13806_/RESET_B VDD VSS sg13g2_tiehi
XFILLER_37_199 VDD VSS sg13g2_decap_8
XFILLER_25_339 VDD VSS sg13g2_decap_8
XFILLER_20_1274 VDD VSS sg13g2_decap_8
X_09331_ _13938_/D _10128_/A0 _13938_/Q _09338_/S VDD VSS sg13g2_mux2_1
XFILLER_80_478 VDD VSS sg13g2_fill_2
XFILLER_61_670 VDD VSS sg13g2_decap_8
X_09262_ _13871_/D _13871_/Q _09926_/A1 _09272_/S VDD VSS sg13g2_mux2_1
XFILLER_142_1329 VDD VSS sg13g2_decap_8
XFILLER_14_1001 VDD VSS sg13g2_decap_8
X_08213_ _08374_/B _08121_/X _08124_/X _13525_/A VDD VSS sg13g2_mux2_1
XFILLER_119_400 VDD VSS sg13g2_decap_4
XFILLER_21_567 VDD VSS sg13g2_decap_8
XFILLER_166_539 VDD VSS sg13g2_decap_8
X_09193_ _13809_/D _13809_/Q _10160_/A1 _09193_/S VDD VSS sg13g2_mux2_1
X_13673__2526 _13673_/RESET_B VDD VSS sg13g2_tiehi
XFILLER_140_1031 VDD VSS sg13g2_fill_2
XFILLER_147_742 VDD VSS sg13g2_decap_8
XFILLER_147_753 VDD VSS sg13g2_fill_2
X_08144_ _08145_/C _08110_/D _08138_/X _08463_/B _08246_/A1 _08143_/Y VDD VSS sg13g2_a221oi_1
XFILLER_107_606 VDD VSS sg13g2_decap_8
XFILLER_135_915 VDD VSS sg13g2_decap_8
X_15226__2994 _15226_/RESET_B VDD VSS sg13g2_tiehi
XFILLER_14_1078 VDD VSS sg13g2_decap_8
XFILLER_88_1135 VDD VSS sg13g2_decap_8
XFILLER_147_797 VDD VSS sg13g2_decap_4
X_08075_ _08075_/Y _08137_/S0 _08160_/A _08074_/C _08074_/B VDD VSS sg13g2_a22oi_1
XFILLER_174_594 VDD VSS sg13g2_decap_8
XFILLER_88_1168 VDD VSS sg13g2_fill_1
XFILLER_106_138 VDD VSS sg13g2_fill_2
XFILLER_134_447 VDD VSS sg13g2_decap_8
XFILLER_162_756 VDD VSS sg13g2_decap_8
XFILLER_150_907 VDD VSS sg13g2_decap_4
XFILLER_1_917 VDD VSS sg13g2_decap_8
XFILLER_143_970 VDD VSS sg13g2_fill_2
XFILLER_115_683 VDD VSS sg13g2_decap_8
XFILLER_0_427 VDD VSS sg13g2_decap_8
XFILLER_103_845 VDD VSS sg13g2_decap_8
XFILLER_62_1319 VDD VSS sg13g2_decap_8
XFILLER_103_856 VDD VSS sg13g2_fill_2
XFILLER_130_642 VDD VSS sg13g2_fill_1
XFILLER_29_35 VDD VSS sg13g2_decap_8
XFILLER_152_14 VDD VSS sg13g2_decap_8
X_08977_ _08977_/Y _09141_/A _08977_/B _10697_/B VDD VSS sg13g2_nand3_1
XFILLER_102_366 VDD VSS sg13g2_decap_8
XFILLER_25_1141 VDD VSS sg13g2_decap_8
X_07928_ _07928_/Y _07923_/Y _07925_/Y _07797_/X VDD VSS sg13g2_a21oi_1
XFILLER_75_228 VDD VSS sg13g2_fill_1
XFILLER_57_943 VDD VSS sg13g2_decap_8
XFILLER_5_1246 VDD VSS sg13g2_decap_8
XFILLER_112_1144 VDD VSS sg13g2_decap_4
XFILLER_28_133 VDD VSS sg13g2_decap_8
X_07859_ _08641_/C _15014_/Q _07859_/B VDD VSS sg13g2_xnor2_1
XFILLER_28_177 VDD VSS sg13g2_fill_2
X_10870_ _10897_/B _10870_/A _10871_/A VDD VSS sg13g2_nand2_1
XFILLER_83_294 VDD VSS sg13g2_fill_2
XFILLER_45_56 VDD VSS sg13g2_decap_8
XFILLER_44_659 VDD VSS sg13g2_decap_8
X_09529_ _14128_/D _09696_/A0 _14128_/Q _09539_/S VDD VSS sg13g2_mux2_1
XFILLER_71_467 VDD VSS sg13g2_fill_2
XFILLER_31_309 VDD VSS sg13g2_decap_4
XFILLER_71_489 VDD VSS sg13g2_decap_8
XFILLER_169_322 VDD VSS sg13g2_decap_8
XFILLER_101_62 VDD VSS sg13g2_fill_2
X_12540_ _12541_/B _13680_/Q _12721_/A2 _12539_/X _12721_/B2 _12777_/C1 VDD VSS sg13g2_a221oi_1
XFILLER_52_692 VDD VSS sg13g2_fill_2
XFILLER_24_383 VDD VSS sg13g2_decap_8
XFILLER_12_567 VDD VSS sg13g2_decap_8
XFILLER_36_1270 VDD VSS sg13g2_fill_1
XFILLER_169_399 VDD VSS sg13g2_decap_8
X_14575__1604 _14575_/RESET_B VDD VSS sg13g2_tiehi
X_12471_ _14997_/D _12471_/A _12471_/B VDD VSS sg13g2_nor2_1
XFILLER_138_720 VDD VSS sg13g2_decap_8
XFILLER_61_77 VDD VSS sg13g2_decap_8
XFILLER_138_742 VDD VSS sg13g2_decap_8
X_14210_ _14210_/Q clkload29/A _14210_/D _14210_/RESET_B VDD VSS sg13g2_dfrbpq_1
X_11422_ _11422_/Y _11422_/A _11745_/B VDD VSS sg13g2_nand2_1
XFILLER_32_1145 VDD VSS sg13g2_decap_8
XFILLER_137_230 VDD VSS sg13g2_decap_4
X_15190_ _15190_/Q clkload72/A _15190_/D _15190_/RESET_B VDD VSS sg13g2_dfrbpq_1
XFILLER_138_775 VDD VSS sg13g2_decap_8
XFILLER_6_28 VDD VSS sg13g2_decap_8
XFILLER_4_700 VDD VSS sg13g2_decap_8
XFILLER_117_0 VDD VSS sg13g2_decap_8
X_14141_ _14141_/Q clkload47/A _14141_/D _14141_/RESET_B VDD VSS sg13g2_dfrbpq_1
X_11353_ _11353_/X _14558_/Q _14590_/Q _11353_/S VDD VSS sg13g2_mux2_1
XFILLER_158_1325 VDD VSS sg13g2_decap_4
XFILLER_3_210 VDD VSS sg13g2_decap_8
XFILLER_152_244 VDD VSS sg13g2_decap_8
X_10304_ _10311_/C _14794_/Q _14795_/Q VDD VSS sg13g2_and2_1
X_14072_ _14072_/Q _14744_/CLK _14072_/D _14072_/RESET_B VDD VSS sg13g2_dfrbpq_1
XFILLER_141_929 VDD VSS sg13g2_decap_8
XFILLER_152_255 VDD VSS sg13g2_fill_2
X_11284_ _11285_/A _11281_/Y _11283_/Y _12332_/B1 VDD VSS sg13g2_a21oi_1
XFILLER_98_309 VDD VSS sg13g2_fill_1
XFILLER_152_266 VDD VSS sg13g2_decap_8
XFILLER_4_777 VDD VSS sg13g2_decap_8
XFILLER_106_672 VDD VSS sg13g2_decap_4
XFILLER_112_108 VDD VSS sg13g2_fill_2
XFILLER_10_70 VDD VSS sg13g2_decap_8
X_13023_ _13057_/A _14908_/Q _13679_/Q VDD VSS sg13g2_xor2_1
XFILLER_79_512 VDD VSS sg13g2_fill_2
X_10235_ _10235_/Y _07638_/Y _10232_/B _10441_/C VDD VSS sg13g2_o21ai_1
XFILLER_106_694 VDD VSS sg13g2_decap_8
XFILLER_3_287 VDD VSS sg13g2_decap_8
Xfanout1000 _10004_/B _09806_/B VDD VSS sg13g2_buf_1
XFILLER_105_193 VDD VSS sg13g2_decap_4
Xfanout1011 _09161_/S _15059_/Q VDD VSS sg13g2_buf_1
Xfanout1022 _13283_/A _15054_/Q VDD VSS sg13g2_buf_1
XFILLER_0_961 VDD VSS sg13g2_decap_8
Xfanout1033 _13545_/A _14996_/Q VDD VSS sg13g2_buf_1
X_10166_ _14743_/D _14743_/Q _10166_/A1 _10167_/S VDD VSS sg13g2_mux2_1
Xfanout1044 _08270_/B _08361_/A1 VDD VSS sg13g2_buf_1
XFILLER_48_910 VDD VSS sg13g2_decap_8
XFILLER_117_1088 VDD VSS sg13g2_fill_1
Xfanout1055 _08599_/B _13525_/A VDD VSS sg13g2_buf_1
Xfanout1066 _08235_/S0 _08207_/S1 VDD VSS sg13g2_buf_1
Xfanout1077 _08686_/S0 _13518_/A1 VDD VSS sg13g2_buf_1
X_14974_ _14974_/Q _14979_/CLK _14974_/D _14974_/RESET_B VDD VSS sg13g2_dfrbpq_1
Xfanout1088 _12278_/A _14987_/Q VDD VSS sg13g2_buf_1
X_10097_ _14677_/D _10097_/A0 _14677_/Q _10101_/S VDD VSS sg13g2_mux2_1
XFILLER_130_1233 VDD VSS sg13g2_decap_8
XFILLER_47_431 VDD VSS sg13g2_fill_2
Xfanout1099 _08620_/A1 _12128_/A VDD VSS sg13g2_buf_1
XFILLER_19_133 VDD VSS sg13g2_decap_8
X_13925_ _13925_/Q clkload7/A _13925_/D _13925_/RESET_B VDD VSS sg13g2_dfrbpq_1
XFILLER_63_913 VDD VSS sg13g2_decap_8
XFILLER_130_1277 VDD VSS sg13g2_decap_8
XFILLER_74_272 VDD VSS sg13g2_fill_2
X_13856_ _13856_/Q _14721_/CLK _13856_/D _13856_/RESET_B VDD VSS sg13g2_dfrbpq_1
XFILLER_16_840 VDD VSS sg13g2_decap_8
X_12807_ _12807_/Y _14799_/Q _12851_/B _07728_/B _14831_/Q _13248_/B VDD VSS sg13g2_a221oi_1
XFILLER_62_467 VDD VSS sg13g2_decap_4
XFILLER_50_607 VDD VSS sg13g2_decap_8
XFILLER_15_350 VDD VSS sg13g2_decap_8
X_13787_ _13787_/Q clkload46/A _13787_/D _13787_/RESET_B VDD VSS sg13g2_dfrbpq_1
XFILLER_37_1012 VDD VSS sg13g2_decap_8
X_10999_ _10999_/X _10995_/B _11045_/A2 _10999_/B1 VDD VSS sg13g2_a21o_1
XFILLER_90_798 VDD VSS sg13g2_decap_8
XFILLER_43_681 VDD VSS sg13g2_decap_8
X_12738_ _12738_/X _14583_/Q _14615_/Q _14647_/Q _14679_/Q _12752_/S0 _12752_/S1 VDD
+ VSS sg13g2_mux4_1
XFILLER_43_692 VDD VSS sg13g2_fill_1
XFILLER_37_1056 VDD VSS sg13g2_decap_8
XFILLER_37_1067 VDD VSS sg13g2_fill_2
XFILLER_30_331 VDD VSS sg13g2_decap_8
XFILLER_124_1026 VDD VSS sg13g2_fill_1
XFILLER_148_517 VDD VSS sg13g2_decap_8
X_15250__2701 _15250_/RESET_B VDD VSS sg13g2_tiehi
XFILLER_148_528 VDD VSS sg13g2_fill_2
XFILLER_37_1089 VDD VSS sg13g2_fill_1
XFILLER_163_1097 VDD VSS sg13g2_fill_1
X_12669_ _12669_/X _14386_/Q _14418_/Q _14482_/Q _14514_/Q _12758_/S0 _12758_/S1 VDD
+ VSS sg13g2_mux4_1
XFILLER_31_887 VDD VSS sg13g2_decap_8
XFILLER_129_742 VDD VSS sg13g2_decap_8
XFILLER_141_1340 VDD VSS sg13g2_fill_1
X_14408_ _14408_/Q _14644_/CLK _14408_/D _14408_/RESET_B VDD VSS sg13g2_dfrbpq_1
XFILLER_117_904 VDD VSS sg13g2_decap_4
XFILLER_15_1365 VDD VSS sg13g2_decap_8
XFILLER_11_1218 VDD VSS sg13g2_decap_8
XFILLER_7_560 VDD VSS sg13g2_decap_8
XFILLER_50_1278 VDD VSS sg13g2_decap_8
XFILLER_102_1357 VDD VSS sg13g2_fill_1
X_14339_ _14339_/Q _14505_/CLK _14339_/D _14339_/RESET_B VDD VSS sg13g2_dfrbpq_1
XFILLER_128_285 VDD VSS sg13g2_decap_8
XFILLER_143_244 VDD VSS sg13g2_decap_8
Xmax_cap268 _09892_/S _09904_/S VDD VSS sg13g2_buf_4
XFILLER_100_1081 VDD VSS sg13g2_decap_8
XFILLER_171_586 VDD VSS sg13g2_decap_8
X_08900_ _08900_/Y _11798_/A _08931_/S _08899_/Y VDD VSS sg13g2_a21oi_1
XFILLER_135_1111 VDD VSS sg13g2_decap_4
XFILLER_143_299 VDD VSS sg13g2_decap_8
X_09880_ _14466_/D _09913_/A1 _14466_/Q _09899_/S VDD VSS sg13g2_mux2_1
XFILLER_83_1043 VDD VSS sg13g2_fill_2
XFILLER_32_0 VDD VSS sg13g2_decap_8
X_08831_ _08831_/Y _13283_/A _08831_/B VDD VSS sg13g2_nor2_1
XFILLER_112_664 VDD VSS sg13g2_decap_8
XFILLER_97_375 VDD VSS sg13g2_decap_8
XFILLER_22_1303 VDD VSS sg13g2_decap_8
X_08762_ _13672_/D _08762_/A1 _08760_/Y _08761_/Y VDD VSS sg13g2_a21oi_1
X_07713_ _07740_/A _07713_/A _07748_/B VDD VSS sg13g2_nor2b_1
XFILLER_39_976 VDD VSS sg13g2_decap_8
X_14653__1526 _14653_/RESET_B VDD VSS sg13g2_tiehi
XFILLER_122_28 VDD VSS sg13g2_decap_8
X_08693_ _08693_/Y _08693_/A _08693_/B _08693_/C VDD VSS sg13g2_nand3_1
XFILLER_54_913 VDD VSS sg13g2_fill_1
XFILLER_53_401 VDD VSS sg13g2_fill_1
XFILLER_26_626 VDD VSS sg13g2_decap_8
XFILLER_65_272 VDD VSS sg13g2_decap_8
XFILLER_38_497 VDD VSS sg13g2_decap_8
X_07644_ _10297_/A _14790_/Q VDD VSS sg13g2_inv_1
XFILLER_80_220 VDD VSS sg13g2_decap_8
XFILLER_0_1143 VDD VSS sg13g2_decap_8
XFILLER_25_147 VDD VSS sg13g2_decap_8
XFILLER_20_1071 VDD VSS sg13g2_decap_8
X_14082__2097 _14082_/RESET_B VDD VSS sg13g2_tiehi
XFILLER_59_1281 VDD VSS sg13g2_decap_8
X_09314_ _13921_/D _09780_/A0 _13921_/Q _09334_/S VDD VSS sg13g2_mux2_1
XFILLER_62_990 VDD VSS sg13g2_decap_8
XFILLER_146_1262 VDD VSS sg13g2_fill_2
XFILLER_142_1104 VDD VSS sg13g2_fill_1
XFILLER_55_1156 VDD VSS sg13g2_decap_8
XFILLER_139_506 VDD VSS sg13g2_fill_1
XFILLER_142_1115 VDD VSS sg13g2_decap_8
XFILLER_107_1246 VDD VSS sg13g2_fill_2
XFILLER_139_528 VDD VSS sg13g2_decap_8
XFILLER_90_1058 VDD VSS sg13g2_decap_4
X_09245_ _13854_/D _13854_/Q _10141_/A1 _09267_/S VDD VSS sg13g2_mux2_1
X_15021__2566 _15021_/RESET_B VDD VSS sg13g2_tiehi
XFILLER_21_364 VDD VSS sg13g2_decap_8
XFILLER_142_1159 VDD VSS sg13g2_fill_1
XFILLER_166_336 VDD VSS sg13g2_decap_8
XFILLER_31_14 VDD VSS sg13g2_decap_8
X_09176_ _13792_/D _13792_/Q _10143_/A1 _09201_/S VDD VSS sg13g2_mux2_1
XFILLER_147_14 VDD VSS sg13g2_decap_8
X_08127_ _08463_/B _13529_/A _08122_/Y _08126_/Y VDD VSS sg13g2_o21ai_1
XFILLER_110_7 VDD VSS sg13g2_decap_8
X_08058_ _08058_/X _08044_/X _08052_/Y _08042_/X _08167_/B _08241_/A _08177_/S VDD
+ VSS sg13g2_mux4_1
XFILLER_122_406 VDD VSS sg13g2_fill_2
XFILLER_150_715 VDD VSS sg13g2_decap_8
XFILLER_66_1241 VDD VSS sg13g2_decap_8
XFILLER_1_714 VDD VSS sg13g2_decap_8
Xoutput47 mem_axi_araddr[18] _16871_/A VDD VSS sg13g2_buf_1
XFILLER_118_1320 VDD VSS sg13g2_decap_8
Xoutput58 mem_axi_araddr[29] _16882_/A VDD VSS sg13g2_buf_1
Xoutput69 mem_axi_arprot[2] _16854_/X VDD VSS sg13g2_buf_1
XFILLER_0_224 VDD VSS sg13g2_decap_8
XFILLER_153_1222 VDD VSS sg13g2_decap_8
XFILLER_163_35 VDD VSS sg13g2_decap_8
Xhold3130 _10800_/A _14927_/Q VDD VSS sg13g2_dlygate4sd3_1
XFILLER_27_1236 VDD VSS sg13g2_decap_8
XFILLER_103_653 VDD VSS sg13g2_decap_8
Xhold3141 _10862_/A _14932_/Q VDD VSS sg13g2_dlygate4sd3_1
X_10020_ _14602_/D _10086_/A0 _14602_/Q _10030_/S VDD VSS sg13g2_mux2_1
XFILLER_62_1127 VDD VSS sg13g2_decap_8
Xhold3152 _13581_/A _15159_/Q VDD VSS sg13g2_dlygate4sd3_1
XFILLER_118_1375 VDD VSS sg13g2_decap_4
XFILLER_153_1255 VDD VSS sg13g2_decap_4
Xhold3163 _11048_/A _14945_/Q VDD VSS sg13g2_dlygate4sd3_1
XFILLER_89_887 VDD VSS sg13g2_fill_2
XFILLER_76_504 VDD VSS sg13g2_fill_1
XFILLER_102_163 VDD VSS sg13g2_decap_8
XFILLER_130_472 VDD VSS sg13g2_decap_8
X_14292__1887 _14292_/RESET_B VDD VSS sg13g2_tiehi
XFILLER_9_1190 VDD VSS sg13g2_decap_8
XFILLER_5_1043 VDD VSS sg13g2_decap_8
X_11971_ _11971_/Y _11971_/A _11971_/B _12237_/C VDD VSS sg13g2_nand3_1
X_14629__1550 _14629_/RESET_B VDD VSS sg13g2_tiehi
XFILLER_99_1072 VDD VSS sg13g2_decap_8
X_13710_ _16872_/A clkload53/A _13710_/D _13710_/RESET_B VDD VSS sg13g2_dfrbpq_1
X_10922_ _10926_/A _10920_/A _10920_/B _10921_/Y VDD VSS sg13g2_a21o_1
XFILLER_17_637 VDD VSS sg13g2_decap_8
X_14690_ _14690_/Q _14722_/CLK _14690_/D _14690_/RESET_B VDD VSS sg13g2_dfrbpq_1
XFILLER_71_220 VDD VSS sg13g2_decap_8
XFILLER_16_147 VDD VSS sg13g2_decap_8
X_13641_ _13749_/D _13641_/A VDD VSS sg13g2_buf_1
XFILLER_72_776 VDD VSS sg13g2_fill_2
XFILLER_72_21 VDD VSS sg13g2_decap_8
XFILLER_60_916 VDD VSS sg13g2_decap_8
X_10853_ _10857_/A _14751_/Q _10851_/C _10841_/Y VDD VSS sg13g2_a21o_1
XFILLER_73_1201 VDD VSS sg13g2_decap_4
XFILLER_73_1212 VDD VSS sg13g2_decap_4
XFILLER_31_117 VDD VSS sg13g2_fill_1
XFILLER_125_1302 VDD VSS sg13g2_decap_8
XFILLER_38_1354 VDD VSS sg13g2_decap_8
XFILLER_164_1362 VDD VSS sg13g2_decap_8
X_13572_ _13572_/Y _15156_/Q _13584_/B VDD VSS sg13g2_nor2_1
XFILLER_31_139 VDD VSS sg13g2_fill_1
XFILLER_13_854 VDD VSS sg13g2_decap_8
XFILLER_164_1373 VDD VSS sg13g2_fill_2
X_10784_ _14922_/D _11193_/B1 _11164_/C _10783_/Y VDD VSS sg13g2_o21ai_1
XFILLER_125_1335 VDD VSS sg13g2_fill_2
XFILLER_72_98 VDD VSS sg13g2_decap_4
X_12523_ _12523_/X _12522_/X _12521_/X _12518_/X _12517_/X _12719_/S0 _12720_/S VDD
+ VSS sg13g2_mux4_1
XFILLER_158_848 VDD VSS sg13g2_fill_2
XFILLER_12_364 VDD VSS sg13g2_decap_8
XFILLER_9_847 VDD VSS sg13g2_decap_8
XFILLER_169_196 VDD VSS sg13g2_decap_8
X_15242_ _15242_/Q _15247_/CLK _15242_/D _15242_/RESET_B VDD VSS sg13g2_dfrbpq_1
XFILLER_145_509 VDD VSS sg13g2_fill_2
X_12454_ _12454_/X _12446_/X _12450_/X _12445_/X _12449_/X _12762_/S _12454_/S1 VDD
+ VSS sg13g2_mux4_1
XFILLER_8_357 VDD VSS sg13g2_decap_8
XFILLER_173_829 VDD VSS sg13g2_decap_4
XFILLER_166_881 VDD VSS sg13g2_fill_1
X_13780__2399 _13780_/RESET_B VDD VSS sg13g2_tiehi
X_11405_ _11405_/Y _11396_/Y _12000_/A _11625_/C VDD VSS sg13g2_a21oi_1
X_15173_ _15173_/Q _15183_/CLK _15173_/D _15173_/RESET_B VDD VSS sg13g2_dfrbpq_1
X_12385_ _12386_/B _12383_/X _12384_/X _12706_/S VDD VSS sg13g2_mux2_1
X_14124_ _14124_/Q clkload14/A _14124_/D _14124_/RESET_B VDD VSS sg13g2_dfrbpq_1
X_14731__1448 _14731_/RESET_B VDD VSS sg13g2_tiehi
X_11336_ _11339_/A _11336_/A _11335_/X VDD VSS sg13g2_nor2b_1
XFILLER_21_91 VDD VSS sg13g2_decap_8
XFILLER_119_1128 VDD VSS sg13g2_decap_8
XFILLER_4_574 VDD VSS sg13g2_decap_8
XFILLER_10_1295 VDD VSS sg13g2_decap_8
XFILLER_141_748 VDD VSS sg13g2_decap_8
XFILLER_158_1188 VDD VSS sg13g2_decap_4
X_14055_ _14055_/Q _14607_/CLK _14055_/D _14055_/RESET_B VDD VSS sg13g2_dfrbpq_1
XFILLER_141_759 VDD VSS sg13g2_fill_2
X_11267_ _11267_/Y _11263_/Y _11264_/X _11266_/Y VDD VSS sg13g2_o21ai_1
XFILLER_79_320 VDD VSS sg13g2_fill_1
XFILLER_140_258 VDD VSS sg13g2_fill_2
X_13006_ _13058_/A _14907_/Q _13680_/Q VDD VSS sg13g2_or2_1
X_10218_ _14767_/D _14767_/Q _13324_/A VDD VSS sg13g2_nor2_1
X_11198_ _11201_/A _11177_/B _11177_/C _11197_/X VDD VSS sg13g2_o21ai_1
XFILLER_171_1355 VDD VSS sg13g2_decap_8
X_10149_ _14726_/D _14726_/Q _10149_/A1 _10160_/S VDD VSS sg13g2_mux2_1
XFILLER_48_762 VDD VSS sg13g2_decap_8
XFILLER_78_1101 VDD VSS sg13g2_decap_8
XFILLER_54_209 VDD VSS sg13g2_decap_8
X_14957_ _14957_/Q clkload56/A _14957_/D _14957_/RESET_B VDD VSS sg13g2_dfrbpq_1
XFILLER_75_570 VDD VSS sg13g2_decap_8
XFILLER_169_1240 VDD VSS sg13g2_fill_1
X_15225__2993 _15225_/RESET_B VDD VSS sg13g2_tiehi
XFILLER_63_721 VDD VSS sg13g2_decap_8
X_13908_ _13908_/Q _14516_/CLK _13908_/D _13908_/RESET_B VDD VSS sg13g2_dfrbpq_1
XFILLER_36_957 VDD VSS sg13g2_fill_1
X_14888_ _14888_/Q _14890_/CLK _14888_/D _14888_/RESET_B VDD VSS sg13g2_dfrbpq_1
XFILLER_78_1167 VDD VSS sg13g2_decap_4
XFILLER_39_1118 VDD VSS sg13g2_decap_8
XFILLER_36_979 VDD VSS sg13g2_decap_8
XFILLER_63_787 VDD VSS sg13g2_fill_2
X_13839_ _13839_/Q _14735_/CLK _13839_/D _13839_/RESET_B VDD VSS sg13g2_dfrbpq_1
XFILLER_165_1159 VDD VSS sg13g2_decap_8
XFILLER_91_1323 VDD VSS sg13g2_decap_8
XFILLER_50_426 VDD VSS sg13g2_decap_8
XFILLER_149_837 VDD VSS sg13g2_decap_4
X_09030_ _09043_/A _14905_/Q _12957_/A _10702_/A _09030_/D VDD VSS sg13g2_nand4_1
X_14067__2112 _14067_/RESET_B VDD VSS sg13g2_tiehi
XFILLER_50_1042 VDD VSS sg13g2_fill_2
XFILLER_129_561 VDD VSS sg13g2_decap_8
XFILLER_15_1162 VDD VSS sg13g2_decap_8
XFILLER_11_1015 VDD VSS sg13g2_decap_8
XFILLER_144_531 VDD VSS sg13g2_decap_8
XFILLER_89_1263 VDD VSS sg13g2_decap_8
XFILLER_102_1165 VDD VSS sg13g2_decap_8
XFILLER_116_233 VDD VSS sg13g2_decap_8
XFILLER_85_1116 VDD VSS sg13g2_decap_8
XFILLER_117_778 VDD VSS sg13g2_fill_2
XFILLER_117_28 VDD VSS sg13g2_decap_8
X_14707__1472 _14707_/RESET_B VDD VSS sg13g2_tiehi
X_09932_ _14517_/D _14517_/Q _09932_/A1 _09936_/S VDD VSS sg13g2_mux2_1
XFILLER_171_383 VDD VSS sg13g2_decap_8
XFILLER_131_247 VDD VSS sg13g2_fill_1
Xfanout804 _12660_/S1 fanout816/X VDD VSS sg13g2_buf_1
Xfanout815 _12759_/S1 fanout816/X VDD VSS sg13g2_buf_1
Xfanout826 _12785_/S1 _12782_/S1 VDD VSS sg13g2_buf_1
Xfanout837 _12731_/S1 fanout846/X VDD VSS sg13g2_buf_1
X_09863_ _14450_/D _14450_/Q _10161_/A1 _09863_/S VDD VSS sg13g2_mux2_1
Xfanout848 _12745_/S1 fanout849/X VDD VSS sg13g2_buf_1
XFILLER_100_612 VDD VSS sg13g2_fill_1
XFILLER_140_781 VDD VSS sg13g2_fill_2
Xfanout859 _12645_/S0 fanout860/X VDD VSS sg13g2_buf_1
X_08814_ _08814_/Y _13689_/Q _08826_/B VDD VSS sg13g2_nor2_1
XFILLER_97_183 VDD VSS sg13g2_decap_8
XFILLER_6_1330 VDD VSS sg13g2_decap_8
X_09794_ _14383_/D _09926_/A1 _14383_/Q _09800_/S VDD VSS sg13g2_mux2_1
XFILLER_22_1100 VDD VSS sg13g2_decap_8
XFILLER_26_1280 VDD VSS sg13g2_decap_8
XFILLER_27_902 VDD VSS sg13g2_fill_1
X_08745_ _08745_/Y _08760_/A1 _08754_/A2 _15195_/Q VDD VSS sg13g2_o21ai_1
XFILLER_38_250 VDD VSS sg13g2_decap_8
XFILLER_26_14 VDD VSS sg13g2_decap_8
XFILLER_22_1177 VDD VSS sg13g2_decap_8
XFILLER_27_957 VDD VSS sg13g2_decap_8
X_08676_ _08676_/Y _08363_/X _08544_/B _08668_/X _08676_/B2 _08675_/Y VDD VSS sg13g2_a221oi_1
XFILLER_54_743 VDD VSS sg13g2_decap_8
XFILLER_53_220 VDD VSS sg13g2_decap_8
XFILLER_26_445 VDD VSS sg13g2_fill_2
XFILLER_54_765 VDD VSS sg13g2_decap_4
XFILLER_53_242 VDD VSS sg13g2_decap_8
X_07627_ _07627_/Y _07884_/A VDD VSS sg13g2_inv_1
X_14277__1902 _14277_/RESET_B VDD VSS sg13g2_tiehi
XFILLER_81_573 VDD VSS sg13g2_decap_8
XFILLER_148_1379 VDD VSS sg13g2_fill_1
XFILLER_158_7 VDD VSS sg13g2_decap_8
XFILLER_107_1010 VDD VSS sg13g2_decap_8
XFILLER_139_303 VDD VSS sg13g2_decap_8
XFILLER_42_35 VDD VSS sg13g2_decap_8
XFILLER_167_634 VDD VSS sg13g2_fill_2
XFILLER_21_161 VDD VSS sg13g2_decap_8
XFILLER_158_35 VDD VSS sg13g2_decap_8
XFILLER_166_133 VDD VSS sg13g2_decap_8
X_09228_ _13839_/D _10125_/A0 _13839_/Q _09238_/S VDD VSS sg13g2_mux2_1
XFILLER_155_818 VDD VSS sg13g2_fill_2
XFILLER_10_868 VDD VSS sg13g2_decap_8
XFILLER_154_306 VDD VSS sg13g2_decap_8
XFILLER_107_200 VDD VSS sg13g2_fill_2
XFILLER_108_723 VDD VSS sg13g2_decap_8
X_14200__1979 _14200_/RESET_B VDD VSS sg13g2_tiehi
X_09159_ _09159_/Y _09024_/A _09155_/Y _09158_/Y VDD VSS sg13g2_o21ai_1
XFILLER_33_1295 VDD VSS sg13g2_decap_8
XFILLER_135_531 VDD VSS sg13g2_decap_8
XFILLER_120_1265 VDD VSS sg13g2_decap_8
XFILLER_108_767 VDD VSS sg13g2_fill_1
XFILLER_68_1336 VDD VSS sg13g2_decap_8
XFILLER_107_255 VDD VSS sg13g2_decap_8
XFILLER_123_704 VDD VSS sg13g2_fill_2
X_12170_ _12170_/Y _12170_/A _12170_/B _12188_/C VDD VSS sg13g2_nand3_1
XFILLER_107_266 VDD VSS sg13g2_fill_1
XFILLER_120_1298 VDD VSS sg13g2_fill_1
XFILLER_155_1306 VDD VSS sg13g2_fill_2
XFILLER_150_512 VDD VSS sg13g2_decap_8
XFILLER_162_383 VDD VSS sg13g2_decap_8
X_11121_ _11123_/A _11115_/A _11115_/B _11145_/A VDD VSS sg13g2_a21oi_1
XFILLER_1_511 VDD VSS sg13g2_decap_8
XFILLER_122_225 VDD VSS sg13g2_fill_1
XFILLER_123_759 VDD VSS sg13g2_decap_8
XFILLER_66_1060 VDD VSS sg13g2_fill_1
X_13765__2414 _13765_/RESET_B VDD VSS sg13g2_tiehi
X_11052_ _11069_/B _11052_/A _11052_/B _11078_/A _11052_/D VDD VSS sg13g2_nor4_1
XFILLER_27_1033 VDD VSS sg13g2_decap_8
XFILLER_103_450 VDD VSS sg13g2_decap_4
XFILLER_67_21 VDD VSS sg13g2_decap_8
XFILLER_114_1003 VDD VSS sg13g2_fill_2
XFILLER_49_515 VDD VSS sg13g2_fill_1
XFILLER_114_1014 VDD VSS sg13g2_decap_4
XFILLER_7_1127 VDD VSS sg13g2_decap_8
XFILLER_1_588 VDD VSS sg13g2_decap_8
X_10003_ _14586_/D _10102_/A0 _14586_/Q _10003_/S VDD VSS sg13g2_mux2_1
XFILLER_103_494 VDD VSS sg13g2_fill_2
XFILLER_49_548 VDD VSS sg13g2_decap_8
XFILLER_67_98 VDD VSS sg13g2_decap_8
X_14811_ _14811_/Q clkload48/A _14811_/D _14811_/RESET_B VDD VSS sg13g2_dfrbpq_1
XFILLER_40_1233 VDD VSS sg13g2_fill_2
XFILLER_131_1350 VDD VSS sg13g2_fill_1
XFILLER_18_924 VDD VSS sg13g2_decap_8
XFILLER_131_1372 VDD VSS sg13g2_decap_8
XFILLER_92_849 VDD VSS sg13g2_decap_8
XFILLER_57_581 VDD VSS sg13g2_fill_2
X_14145__2034 _14145_/RESET_B VDD VSS sg13g2_tiehi
X_14742_ _14742_/Q clkload27/A _14742_/D _14742_/RESET_B VDD VSS sg13g2_dfrbpq_1
X_11954_ _11955_/A _13744_/Q _14096_/Q _14448_/Q _14544_/Q _11966_/S _11972_/S1 VDD
+ VSS sg13g2_mux4_1
XFILLER_17_434 VDD VSS sg13g2_decap_8
XFILLER_33_905 VDD VSS sg13g2_decap_8
XFILLER_44_242 VDD VSS sg13g2_decap_8
X_10905_ _10945_/A _14756_/Q _10936_/D VDD VSS sg13g2_nor2_1
XFILLER_75_1329 VDD VSS sg13g2_fill_1
X_14673_ _14673_/Q _14737_/CLK _14673_/D _14673_/RESET_B VDD VSS sg13g2_dfrbpq_1
XFILLER_45_787 VDD VSS sg13g2_fill_2
X_11885_ _11885_/Y _11893_/S _14382_/Q VDD VSS sg13g2_nand2b_1
XFILLER_32_415 VDD VSS sg13g2_decap_8
XFILLER_44_286 VDD VSS sg13g2_fill_2
X_13624_ _13732_/D _13624_/A VDD VSS sg13g2_buf_1
X_10836_ _14929_/D _14929_/Q _10837_/B _10835_/Y VDD VSS sg13g2_a21o_1
XFILLER_16_91 VDD VSS sg13g2_decap_8
XFILLER_13_651 VDD VSS sg13g2_decap_8
XFILLER_164_1170 VDD VSS sg13g2_fill_2
XFILLER_73_1053 VDD VSS sg13g2_decap_4
XFILLER_41_960 VDD VSS sg13g2_fill_1
XFILLER_38_1184 VDD VSS sg13g2_decap_8
X_13555_ _13555_/Y _15007_/Q _13563_/B _13563_/C VDD VSS sg13g2_nor3_1
X_10767_ _10767_/Y _10767_/A _10767_/B VDD VSS sg13g2_nor2_1
XFILLER_12_161 VDD VSS sg13g2_decap_8
XFILLER_157_133 VDD VSS sg13g2_decap_8
XFILLER_9_644 VDD VSS sg13g2_decap_8
XFILLER_146_807 VDD VSS sg13g2_decap_8
X_12506_ _12506_/X _13734_/Q _14086_/Q _14438_/Q _14534_/Q _12661_/S0 _12661_/S1 VDD
+ VSS sg13g2_mux4_1
XFILLER_158_678 VDD VSS sg13g2_decap_8
XFILLER_12_1302 VDD VSS sg13g2_decap_8
XFILLER_158_689 VDD VSS sg13g2_fill_1
X_13486_ _13502_/D _13486_/A _15170_/D _15169_/D VDD VSS sg13g2_nand3_1
XFILLER_73_7 VDD VSS sg13g2_decap_8
X_10698_ _10897_/A _14933_/Q _10675_/A _10697_/X VDD VSS sg13g2_a21oi_1
XFILLER_8_154 VDD VSS sg13g2_decap_8
XFILLER_173_626 VDD VSS sg13g2_decap_8
X_15225_ _15225_/Q _15226_/CLK _15225_/D _15225_/RESET_B VDD VSS sg13g2_dfrbpq_1
XFILLER_51_1373 VDD VSS sg13g2_decap_8
X_12437_ _12437_/X _14369_/Q _14401_/Q _14465_/Q _14497_/Q _12437_/S0 _12437_/S1 VDD
+ VSS sg13g2_mux4_1
XFILLER_126_520 VDD VSS sg13g2_fill_2
XFILLER_138_380 VDD VSS sg13g2_fill_2
XFILLER_172_147 VDD VSS sg13g2_decap_8
XFILLER_154_862 VDD VSS sg13g2_decap_8
XFILLER_12_1379 VDD VSS sg13g2_fill_1
XFILLER_160_309 VDD VSS sg13g2_decap_8
X_15156_ _15156_/Q clkload68/A _15156_/D _15156_/RESET_B VDD VSS sg13g2_dfrbpq_1
X_12368_ _12368_/X _14684_/Q _14716_/Q _13756_/Q _13788_/Q _12787_/S0 _12787_/S1 VDD
+ VSS sg13g2_mux4_1
XFILLER_5_861 VDD VSS sg13g2_decap_8
XFILLER_141_501 VDD VSS sg13g2_decap_4
X_14107_ _14107_/Q _14653_/CLK _14107_/D _14107_/RESET_B VDD VSS sg13g2_dfrbpq_1
XFILLER_153_383 VDD VSS sg13g2_decap_4
X_11319_ _11319_/Y _11314_/Y _11315_/Y _11329_/B1 VDD VSS sg13g2_a21oi_1
XFILLER_4_371 VDD VSS sg13g2_decap_8
X_15087_ _15087_/Q _15159_/CLK _15087_/D _15087_/RESET_B VDD VSS sg13g2_dfrbpq_1
XFILLER_10_1092 VDD VSS sg13g2_decap_8
X_12299_ _12299_/Y _12280_/A _12279_/B _12277_/X VDD VSS sg13g2_a21oi_1
XFILLER_45_1100 VDD VSS sg13g2_fill_2
XFILLER_113_247 VDD VSS sg13g2_fill_2
XFILLER_84_1171 VDD VSS sg13g2_fill_1
X_14038_ _14038_/Q clkload26/A _14038_/D _14038_/RESET_B VDD VSS sg13g2_dfrbpq_1
X_14355__1824 _14355_/RESET_B VDD VSS sg13g2_tiehi
XFILLER_68_813 VDD VSS sg13g2_decap_8
XFILLER_110_910 VDD VSS sg13g2_decap_8
XFILLER_122_781 VDD VSS sg13g2_decap_8
XFILLER_67_301 VDD VSS sg13g2_decap_8
XFILLER_171_1163 VDD VSS sg13g2_fill_2
XFILLER_122_792 VDD VSS sg13g2_decap_8
XFILLER_110_965 VDD VSS sg13g2_fill_2
XFILLER_132_1158 VDD VSS sg13g2_decap_8
XFILLER_83_816 VDD VSS sg13g2_decap_8
XFILLER_55_518 VDD VSS sg13g2_decap_8
X_08530_ _08531_/B _07823_/Y _08497_/B _07954_/C VDD VSS sg13g2_o21ai_1
XFILLER_36_754 VDD VSS sg13g2_decap_8
XFILLER_91_871 VDD VSS sg13g2_fill_1
X_08461_ _08462_/C _08461_/A _08461_/B _08461_/C _08461_/D VDD VSS sg13g2_and4_1
XFILLER_1_1260 VDD VSS sg13g2_decap_8
XFILLER_169_1092 VDD VSS sg13g2_decap_8
XFILLER_63_584 VDD VSS sg13g2_decap_8
XFILLER_50_212 VDD VSS sg13g2_decap_8
XFILLER_23_448 VDD VSS sg13g2_decap_8
X_14852__2840 _14852_/RESET_B VDD VSS sg13g2_tiehi
X_08392_ _08394_/C _08367_/Y _08391_/Y _08390_/Y VDD VSS sg13g2_a21oi_1
XFILLER_149_601 VDD VSS sg13g2_fill_2
XFILLER_108_1330 VDD VSS sg13g2_fill_1
XFILLER_148_100 VDD VSS sg13g2_decap_4
XFILLER_56_1284 VDD VSS sg13g2_decap_8
XFILLER_91_1175 VDD VSS sg13g2_decap_4
XFILLER_17_1246 VDD VSS sg13g2_decap_8
XFILLER_104_1205 VDD VSS sg13g2_decap_8
XFILLER_148_133 VDD VSS sg13g2_decap_4
X_13843__2336 _13843_/RESET_B VDD VSS sg13g2_tiehi
XFILLER_109_509 VDD VSS sg13g2_fill_2
X_13989__2190 _13989_/RESET_B VDD VSS sg13g2_tiehi
XFILLER_12_49 VDD VSS sg13g2_decap_8
X_09013_ _09013_/Y _09030_/D _09012_/Y _09010_/Y VDD VSS sg13g2_o21ai_1
X_14885__2774 _14885_/RESET_B VDD VSS sg13g2_tiehi
XFILLER_128_49 VDD VSS sg13g2_decap_8
XFILLER_163_147 VDD VSS sg13g2_decap_8
XFILLER_145_862 VDD VSS sg13g2_fill_1
XFILLER_89_1071 VDD VSS sg13g2_decap_8
XFILLER_2_308 VDD VSS sg13g2_decap_8
XFILLER_160_843 VDD VSS sg13g2_decap_8
XFILLER_104_236 VDD VSS sg13g2_decap_8
XFILLER_137_1047 VDD VSS sg13g2_decap_8
XFILLER_63_1200 VDD VSS sg13g2_decap_4
Xfanout601 _10720_/A _10794_/A2 VDD VSS sg13g2_buf_1
Xfanout612 _08893_/A _08837_/X VDD VSS sg13g2_buf_1
X_09915_ _14500_/D _14500_/Q _09915_/A1 _09936_/S VDD VSS sg13g2_mux2_1
Xfanout623 _08825_/C1 _08724_/Y VDD VSS sg13g2_buf_1
Xfanout634 _08142_/A _08692_/A VDD VSS sg13g2_buf_1
XFILLER_28_1364 VDD VSS sg13g2_decap_8
XFILLER_113_781 VDD VSS sg13g2_fill_2
Xfanout645 _12443_/A2 _12791_/C1 VDD VSS sg13g2_buf_1
XFILLER_86_621 VDD VSS sg13g2_fill_2
XFILLER_63_1255 VDD VSS sg13g2_fill_1
Xfanout656 _13274_/C1 _13207_/C1 VDD VSS sg13g2_buf_1
Xfanout667 _13279_/D _07703_/Y VDD VSS sg13g2_buf_1
X_09846_ _14433_/D _14433_/Q _10077_/A0 _09867_/S VDD VSS sg13g2_mux2_1
XFILLER_24_1239 VDD VSS sg13g2_decap_8
XFILLER_112_291 VDD VSS sg13g2_decap_4
XFILLER_150_1236 VDD VSS sg13g2_decap_8
Xfanout678 _12339_/A1 _11340_/A1 VDD VSS sg13g2_buf_1
Xfanout689 _11378_/S _12335_/B1 VDD VSS sg13g2_buf_1
XFILLER_46_518 VDD VSS sg13g2_decap_8
XFILLER_37_35 VDD VSS sg13g2_decap_8
XFILLER_160_14 VDD VSS sg13g2_decap_8
X_09777_ _14366_/D _09909_/A1 _14366_/Q _09799_/S VDD VSS sg13g2_mux2_1
X_08728_ _08728_/Y _08727_/X _13448_/B _13490_/B VDD VSS sg13g2_a21oi_1
XFILLER_73_359 VDD VSS sg13g2_fill_1
XFILLER_26_231 VDD VSS sg13g2_decap_8
XFILLER_96_1042 VDD VSS sg13g2_decap_8
XFILLER_2_1057 VDD VSS sg13g2_decap_8
XFILLER_57_1015 VDD VSS sg13g2_fill_1
X_08659_ _08661_/C _08659_/A _08659_/B _08659_/C VDD VSS sg13g2_or3_1
XFILLER_15_938 VDD VSS sg13g2_decap_8
XFILLER_41_201 VDD VSS sg13g2_decap_8
XFILLER_42_735 VDD VSS sg13g2_decap_4
XFILLER_41_212 VDD VSS sg13g2_fill_2
Xclkbuf_leaf_121_clk_i clkload10/A clkbuf_5_4__f_clk_i/X VDD VSS sg13g2_buf_8
XFILLER_81_392 VDD VSS sg13g2_decap_8
XFILLER_144_1018 VDD VSS sg13g2_fill_2
XFILLER_148_1187 VDD VSS sg13g2_decap_8
XFILLER_14_448 VDD VSS sg13g2_decap_8
X_11670_ _11671_/A _14696_/Q _14728_/Q _13768_/Q _13800_/Q _11692_/A _12038_/B1 VDD
+ VSS sg13g2_mux4_1
XFILLER_42_757 VDD VSS sg13g2_decap_8
XFILLER_168_921 VDD VSS sg13g2_decap_8
XFILLER_169_56 VDD VSS sg13g2_decap_8
X_10621_ _10632_/D _14882_/Q _10651_/D _10625_/D VDD VSS sg13g2_and3_1
XFILLER_23_971 VDD VSS sg13g2_decap_8
XFILLER_167_420 VDD VSS sg13g2_decap_8
XFILLER_35_1357 VDD VSS sg13g2_decap_8
XFILLER_70_1248 VDD VSS sg13g2_decap_8
X_13340_ _15174_/D hold3059/X _15174_/Q _13477_/S VDD VSS sg13g2_mux2_1
X_14433__1746 _14433_/RESET_B VDD VSS sg13g2_tiehi
X_10552_ _10554_/A _14865_/Q _10556_/D _14866_/Q VDD VSS sg13g2_a21o_1
X_13819__2360 _13819_/RESET_B VDD VSS sg13g2_tiehi
XFILLER_10_665 VDD VSS sg13g2_decap_8
XFILLER_139_188 VDD VSS sg13g2_fill_2
XFILLER_167_497 VDD VSS sg13g2_decap_8
X_13271_ _13271_/Y _13269_/Y _13271_/B _13271_/C VDD VSS sg13g2_nand3b_1
X_10483_ _10487_/B _10489_/C _10489_/D _14849_/Q VDD VSS sg13g2_a21oi_1
X_15010_ _15010_/Q _15015_/CLK _15010_/D _15010_/RESET_B VDD VSS sg13g2_dfrbpq_1
XFILLER_6_658 VDD VSS sg13g2_decap_8
X_15224__2992 _15224_/RESET_B VDD VSS sg13g2_tiehi
X_12222_ _12223_/C _12291_/A _12219_/X _12221_/Y VDD VSS sg13g2_a21oi_1
XFILLER_5_168 VDD VSS sg13g2_decap_8
XFILLER_155_1114 VDD VSS sg13g2_decap_4
XFILLER_151_843 VDD VSS sg13g2_fill_2
X_12153_ _12198_/D _12151_/Y _12153_/B VDD VSS sg13g2_nand2b_1
XFILLER_29_1128 VDD VSS sg13g2_decap_8
XFILLER_123_545 VDD VSS sg13g2_decap_8
XFILLER_118_93 VDD VSS sg13g2_decap_8
XFILLER_78_42 VDD VSS sg13g2_decap_8
X_11104_ _11104_/Y _11085_/Y _11095_/A _11118_/D VDD VSS sg13g2_o21ai_1
XFILLER_111_718 VDD VSS sg13g2_fill_1
XFILLER_150_364 VDD VSS sg13g2_fill_2
XFILLER_2_875 VDD VSS sg13g2_decap_8
XFILLER_110_206 VDD VSS sg13g2_decap_8
X_12084_ _12197_/B _12084_/A _13668_/Q VDD VSS sg13g2_xnor2_1
XFILLER_110_217 VDD VSS sg13g2_fill_1
XFILLER_49_312 VDD VSS sg13g2_decap_8
XFILLER_150_397 VDD VSS sg13g2_decap_8
XFILLER_42_1306 VDD VSS sg13g2_decap_8
X_11035_ _11035_/Y _11023_/A _11040_/A _11034_/Y VDD VSS sg13g2_a21oi_1
XFILLER_81_1366 VDD VSS sg13g2_decap_8
XFILLER_1_385 VDD VSS sg13g2_decap_8
XFILLER_77_654 VDD VSS sg13g2_fill_1
XFILLER_65_816 VDD VSS sg13g2_fill_1
XFILLER_92_624 VDD VSS sg13g2_decap_8
XFILLER_64_315 VDD VSS sg13g2_decap_8
X_13921__2258 _13921_/RESET_B VDD VSS sg13g2_tiehi
XFILLER_76_186 VDD VSS sg13g2_decap_8
XFILLER_58_890 VDD VSS sg13g2_decap_8
XFILLER_18_721 VDD VSS sg13g2_decap_8
X_14681__1498 _14681_/RESET_B VDD VSS sg13g2_tiehi
XFILLER_91_123 VDD VSS sg13g2_decap_8
XFILLER_64_348 VDD VSS sg13g2_decap_8
X_12986_ _13058_/D _14906_/Q _13681_/Q VDD VSS sg13g2_xor2_1
XFILLER_92_668 VDD VSS sg13g2_decap_8
XFILLER_40_1074 VDD VSS sg13g2_decap_4
XFILLER_17_231 VDD VSS sg13g2_decap_8
XFILLER_73_860 VDD VSS sg13g2_fill_1
XFILLER_40_1096 VDD VSS sg13g2_decap_8
XFILLER_73_871 VDD VSS sg13g2_decap_8
X_14725_ _14725_/Q _14725_/CLK _14725_/D _14725_/RESET_B VDD VSS sg13g2_dfrbpq_1
XFILLER_91_178 VDD VSS sg13g2_decap_8
X_11937_ _11937_/Y _11914_/A _13673_/Q _11916_/Y VDD VSS sg13g2_a21oi_1
XFILLER_18_798 VDD VSS sg13g2_decap_8
X_14656_ _14656_/Q _14721_/CLK _14656_/D _14656_/RESET_B VDD VSS sg13g2_dfrbpq_1
X_11868_ _11868_/Y _11868_/A _11868_/B _11868_/C VDD VSS sg13g2_nand3_1
XFILLER_158_420 VDD VSS sg13g2_decap_8
X_13607_ _15166_/D _13606_/Y _13611_/A2 _13605_/Y VDD VSS sg13g2_a21oi_1
X_10819_ _10821_/B _10844_/B _15122_/Q VDD VSS sg13g2_nand2_1
X_14587_ _14587_/Q clkload40/A _14587_/D _14587_/RESET_B VDD VSS sg13g2_dfrbpq_1
X_11799_ _11800_/B _11770_/A _13064_/B _11779_/Y VDD VSS sg13g2_a21oi_1
XFILLER_146_604 VDD VSS sg13g2_decap_8
XFILLER_9_441 VDD VSS sg13g2_decap_8
X_13538_ _13538_/Y _14994_/Q _13566_/C _15002_/Q _13546_/B2 VDD VSS sg13g2_a22oi_1
XFILLER_145_103 VDD VSS sg13g2_fill_1
X_14409__1770 _14409_/RESET_B VDD VSS sg13g2_tiehi
X_13469_ _13469_/X _13469_/A _13507_/B _13469_/C wire513/X VDD VSS sg13g2_and4_1
XFILLER_127_862 VDD VSS sg13g2_decap_8
XFILLER_86_1211 VDD VSS sg13g2_decap_8
XFILLER_145_169 VDD VSS sg13g2_decap_8
X_15208_ _15208_/Q clkload71/A _15208_/D _15208_/RESET_B VDD VSS sg13g2_dfrbpq_1
XFILLER_126_350 VDD VSS sg13g2_fill_2
XFILLER_12_1176 VDD VSS sg13g2_decap_8
XFILLER_161_629 VDD VSS sg13g2_decap_8
XFILLER_114_523 VDD VSS sg13g2_fill_2
X_15139_ _15139_/Q clkload59/A _15139_/D _15139_/RESET_B VDD VSS sg13g2_dfrbpq_1
XFILLER_47_1228 VDD VSS sg13g2_decap_4
XFILLER_102_718 VDD VSS sg13g2_decap_8
X_07961_ _08577_/B _07961_/A _07961_/B VDD VSS sg13g2_nand2_1
XFILLER_87_418 VDD VSS sg13g2_decap_8
X_09700_ _14292_/D _09898_/A0 _14292_/Q _09700_/S VDD VSS sg13g2_mux2_1
XFILLER_96_952 VDD VSS sg13g2_decap_4
X_07892_ _08160_/B _08154_/A _08843_/A VDD VSS sg13g2_nor2b_1
XFILLER_67_131 VDD VSS sg13g2_decap_8
XFILLER_67_142 VDD VSS sg13g2_fill_1
X_09631_ _14227_/D _09666_/A0 _14227_/Q _09634_/S VDD VSS sg13g2_mux2_1
XFILLER_96_996 VDD VSS sg13g2_decap_4
XFILLER_83_613 VDD VSS sg13g2_decap_8
XFILLER_67_164 VDD VSS sg13g2_decap_4
XFILLER_82_101 VDD VSS sg13g2_decap_8
XFILLER_23_1272 VDD VSS sg13g2_decap_8
X_14511__1668 _14511_/RESET_B VDD VSS sg13g2_tiehi
X_09562_ _14160_/D _09828_/A0 _14160_/Q _09572_/S VDD VSS sg13g2_mux2_1
XFILLER_3_1344 VDD VSS sg13g2_decap_8
XFILLER_71_819 VDD VSS sg13g2_fill_1
X_08513_ _08517_/C _08599_/A _08511_/X _08512_/Y VDD VSS sg13g2_o21ai_1
XFILLER_93_1204 VDD VSS sg13g2_decap_8
XFILLER_24_702 VDD VSS sg13g2_decap_4
XFILLER_130_28 VDD VSS sg13g2_decap_8
X_09493_ _14093_/D _10056_/A0 _14093_/Q _09497_/S VDD VSS sg13g2_mux2_1
XFILLER_51_510 VDD VSS sg13g2_fill_1
XFILLER_51_521 VDD VSS sg13g2_decap_8
X_14765__2948 _14765_/RESET_B VDD VSS sg13g2_tiehi
X_08444_ _08444_/Y _08574_/A _08574_/B VDD VSS sg13g2_nand2_1
XFILLER_51_554 VDD VSS sg13g2_decap_4
XFILLER_23_245 VDD VSS sg13g2_decap_8
XFILLER_145_1349 VDD VSS sg13g2_fill_1
XFILLER_168_217 VDD VSS sg13g2_decap_8
X_08375_ _08375_/Y _13529_/A _08223_/X _08397_/A VDD VSS sg13g2_o21ai_1
Xclkbuf_leaf_53_clk_i clkload60/A clkbuf_leaf_72_clk_i/A VDD VSS sg13g2_buf_8
XFILLER_17_1043 VDD VSS sg13g2_decap_8
XFILLER_108_1171 VDD VSS sg13g2_fill_1
XFILLER_143_1051 VDD VSS sg13g2_decap_8
XFILLER_149_464 VDD VSS sg13g2_decap_8
XFILLER_20_952 VDD VSS sg13g2_decap_8
XFILLER_109_306 VDD VSS sg13g2_decap_8
XFILLER_143_1095 VDD VSS sg13g2_decap_8
XFILLER_165_957 VDD VSS sg13g2_decap_8
XFILLER_164_434 VDD VSS sg13g2_decap_8
XFILLER_165_968 VDD VSS sg13g2_fill_1
XFILLER_118_851 VDD VSS sg13g2_fill_1
XFILLER_136_147 VDD VSS sg13g2_decap_8
XFILLER_139_1109 VDD VSS sg13g2_decap_8
XFILLER_30_1254 VDD VSS sg13g2_decap_8
Xclkbuf_leaf_68_clk_i clkload63/A clkbuf_leaf_82_clk_i/A VDD VSS sg13g2_buf_8
XFILLER_155_14 VDD VSS sg13g2_decap_8
XFILLER_2_105 VDD VSS sg13g2_decap_8
XFILLER_3_7 VDD VSS sg13g2_decap_8
XFILLER_132_342 VDD VSS sg13g2_decap_4
XFILLER_160_662 VDD VSS sg13g2_decap_8
Xfanout1407 _13469_/A _13440_/B VDD VSS sg13g2_buf_1
XFILLER_8_1211 VDD VSS sg13g2_decap_8
Xfanout420 _10136_/S wire421/A VDD VSS sg13g2_buf_1
Xfanout431 _10002_/S _09971_/Y VDD VSS sg13g2_buf_1
XFILLER_28_1161 VDD VSS sg13g2_decap_8
XFILLER_132_397 VDD VSS sg13g2_decap_4
Xfanout442 _09664_/S _09673_/S VDD VSS sg13g2_buf_1
Xfanout453 _09533_/S _09539_/S VDD VSS sg13g2_buf_1
XFILLER_115_1142 VDD VSS sg13g2_decap_8
Xfanout464 _09401_/S _09407_/S VDD VSS sg13g2_buf_1
XFILLER_59_654 VDD VSS sg13g2_decap_8
XFILLER_48_56 VDD VSS sg13g2_decap_8
XFILLER_150_1033 VDD VSS sg13g2_fill_1
Xfanout475 _09237_/S _09226_/S VDD VSS sg13g2_buf_1
XFILLER_171_35 VDD VSS sg13g2_decap_8
XFILLER_101_762 VDD VSS sg13g2_decap_4
Xfanout486 _08892_/S _08834_/X VDD VSS sg13g2_buf_1
XFILLER_8_1288 VDD VSS sg13g2_decap_8
XFILLER_58_153 VDD VSS sg13g2_decap_8
XFILLER_19_518 VDD VSS sg13g2_decap_8
XFILLER_100_250 VDD VSS sg13g2_fill_1
Xfanout497 _13346_/A _13499_/A VDD VSS sg13g2_buf_1
X_09829_ _14417_/D _09928_/A1 _14417_/Q _09829_/S VDD VSS sg13g2_mux2_1
XFILLER_111_1017 VDD VSS sg13g2_decap_8
XFILLER_59_698 VDD VSS sg13g2_decap_8
XFILLER_150_1077 VDD VSS sg13g2_decap_8
XFILLER_74_646 VDD VSS sg13g2_decap_8
X_12840_ _15023_/D _13239_/A _12840_/B VDD VSS sg13g2_nor2_1
XFILLER_62_808 VDD VSS sg13g2_decap_8
XFILLER_74_668 VDD VSS sg13g2_decap_8
XFILLER_46_359 VDD VSS sg13g2_fill_1
X_12771_ _12771_/X _13977_/Q _14009_/Q _14041_/Q _14073_/Q _12771_/S0 _12771_/S1 VDD
+ VSS sg13g2_mux4_1
XFILLER_55_893 VDD VSS sg13g2_fill_2
XFILLER_15_735 VDD VSS sg13g2_decap_8
X_14510_ _14510_/Q clkload39/A _14510_/D _14510_/RESET_B VDD VSS sg13g2_dfrbpq_1
X_11722_ _11722_/Y _11721_/Y _11720_/Y _11707_/Y _11722_/B2 _12295_/B1 VDD VSS sg13g2_a221oi_1
XFILLER_14_245 VDD VSS sg13g2_decap_8
XFILLER_159_217 VDD VSS sg13g2_decap_8
XFILLER_9_28 VDD VSS sg13g2_decap_8
XFILLER_147_0 VDD VSS sg13g2_decap_8
X_14441_ _14441_/Q clkload21/A _14441_/D _14441_/RESET_B VDD VSS sg13g2_dfrbpq_1
X_14666__1513 _14666_/RESET_B VDD VSS sg13g2_tiehi
X_11653_ _11653_/X _11646_/X _11647_/X _11650_/X _11651_/X _11549_/B _11559_/C VDD
+ VSS sg13g2_mux4_1
XFILLER_80_21 VDD VSS sg13g2_decap_8
XFILLER_42_598 VDD VSS sg13g2_decap_8
XFILLER_120_94 VDD VSS sg13g2_fill_2
XFILLER_161_1151 VDD VSS sg13g2_fill_2
X_10604_ _10613_/A _14878_/Q _14877_/Q _10610_/D VDD VSS sg13g2_nand3_1
XFILLER_11_952 VDD VSS sg13g2_decap_8
XFILLER_168_773 VDD VSS sg13g2_fill_2
X_14372_ _14372_/Q _14672_/CLK _14372_/D _14372_/RESET_B VDD VSS sg13g2_dfrbpq_1
XFILLER_70_1045 VDD VSS sg13g2_decap_4
XFILLER_174_209 VDD VSS sg13g2_decap_8
X_11584_ _11584_/Y _12001_/A _11584_/B VDD VSS sg13g2_nor2_1
XFILLER_128_626 VDD VSS sg13g2_fill_1
XFILLER_127_103 VDD VSS sg13g2_decap_8
XFILLER_156_946 VDD VSS sg13g2_decap_8
XFILLER_80_98 VDD VSS sg13g2_fill_2
XFILLER_10_462 VDD VSS sg13g2_decap_8
X_13323_ _13324_/B _15112_/Q _13306_/B _13309_/Y _15065_/Q VDD VSS sg13g2_a22oi_1
X_14095__2084 _14095_/RESET_B VDD VSS sg13g2_tiehi
XFILLER_13_70 VDD VSS sg13g2_decap_8
XFILLER_167_294 VDD VSS sg13g2_decap_8
X_10535_ _14860_/D _10535_/A _10535_/B _10535_/C VDD VSS sg13g2_and3_1
XFILLER_7_945 VDD VSS sg13g2_decap_8
X_14810__2903 _14810_/RESET_B VDD VSS sg13g2_tiehi
XFILLER_129_70 VDD VSS sg13g2_decap_8
XFILLER_6_455 VDD VSS sg13g2_decap_8
XFILLER_155_478 VDD VSS sg13g2_decap_8
XFILLER_157_1209 VDD VSS sg13g2_decap_8
X_13254_ _15050_/D _13247_/Y _13253_/Y _13021_/A VDD VSS sg13g2_a21oi_1
XFILLER_142_106 VDD VSS sg13g2_fill_2
X_10466_ _10509_/B _10500_/A _10511_/D VDD VSS sg13g2_nand2_1
X_12205_ _12205_/X _14263_/Q _14295_/Q _14327_/Q _14359_/Q _12212_/S0 _12212_/S1 VDD
+ VSS sg13g2_mux4_1
XFILLER_89_63 VDD VSS sg13g2_decap_8
XFILLER_142_139 VDD VSS sg13g2_fill_1
XFILLER_170_448 VDD VSS sg13g2_decap_8
X_13185_ _13225_/B _14919_/Q _13668_/Q VDD VSS sg13g2_xor2_1
X_15034__2553 _15034_/RESET_B VDD VSS sg13g2_tiehi
X_10397_ _10413_/B _10400_/A _10397_/B _10397_/C VDD VSS sg13g2_nor3_1
XFILLER_9_1008 VDD VSS sg13g2_decap_8
XFILLER_124_887 VDD VSS sg13g2_decap_8
XFILLER_151_673 VDD VSS sg13g2_decap_8
X_12136_ _12136_/X _14709_/Q _14741_/Q _13781_/Q _13813_/Q _12140_/S0 _12140_/S1 VDD
+ VSS sg13g2_mux4_1
XFILLER_111_515 VDD VSS sg13g2_decap_8
XFILLER_151_684 VDD VSS sg13g2_fill_2
XFILLER_36_7 VDD VSS sg13g2_decap_8
XFILLER_2_672 VDD VSS sg13g2_decap_8
XFILLER_81_1141 VDD VSS sg13g2_decap_8
XFILLER_78_941 VDD VSS sg13g2_fill_1
X_12067_ _12067_/X _13971_/Q _14003_/Q _14035_/Q _14067_/Q _12073_/S0 _12073_/S1 VDD
+ VSS sg13g2_mux4_1
XFILLER_1_182 VDD VSS sg13g2_decap_8
XFILLER_172_1280 VDD VSS sg13g2_decap_8
XFILLER_133_1264 VDD VSS sg13g2_fill_1
X_11018_ _11018_/Y _11022_/B _11014_/Y _11017_/Y VDD VSS sg13g2_a21oi_1
XFILLER_42_1147 VDD VSS sg13g2_decap_8
X_16875_ _16875_/X _16875_/A VDD VSS sg13g2_buf_1
XFILLER_93_933 VDD VSS sg13g2_decap_8
XFILLER_168_1316 VDD VSS sg13g2_fill_1
XFILLER_92_432 VDD VSS sg13g2_decap_8
XFILLER_37_348 VDD VSS sg13g2_decap_4
XFILLER_53_819 VDD VSS sg13g2_decap_8
XFILLER_93_999 VDD VSS sg13g2_decap_8
XFILLER_64_178 VDD VSS sg13g2_fill_2
X_12969_ _12969_/Y _12967_/Y _12968_/Y _12933_/Y VDD VSS sg13g2_o21ai_1
XFILLER_18_595 VDD VSS sg13g2_decap_8
XFILLER_127_1002 VDD VSS sg13g2_fill_2
X_14708_ _14708_/Q clkload15/A _14708_/D _14708_/RESET_B VDD VSS sg13g2_dfrbpq_1
XFILLER_60_362 VDD VSS sg13g2_decap_8
XFILLER_127_1057 VDD VSS sg13g2_decap_8
XFILLER_18_1330 VDD VSS sg13g2_decap_8
X_14639_ _14639_/Q clkload6/A _14639_/D _14639_/RESET_B VDD VSS sg13g2_dfrbpq_1
XFILLER_33_598 VDD VSS sg13g2_decap_8
XFILLER_21_749 VDD VSS sg13g2_decap_8
X_08160_ _08160_/Y _08160_/A _08160_/B _08160_/C VDD VSS sg13g2_nor3_1
XFILLER_53_1265 VDD VSS sg13g2_fill_2
XFILLER_20_259 VDD VSS sg13g2_decap_8
XFILLER_119_626 VDD VSS sg13g2_decap_8
XFILLER_118_114 VDD VSS sg13g2_decap_8
XFILLER_140_1246 VDD VSS sg13g2_fill_2
XFILLER_147_946 VDD VSS sg13g2_fill_2
XFILLER_174_743 VDD VSS sg13g2_fill_2
X_08091_ _08091_/Y _08074_/B _08088_/Y _08090_/Y VDD VSS sg13g2_a21oi_1
XFILLER_101_1219 VDD VSS sg13g2_fill_1
XFILLER_109_18 VDD VSS sg13g2_fill_1
XFILLER_173_231 VDD VSS sg13g2_decap_8
Xclkload30 clkload30/X clkload30/A VDD VSS sg13g2_buf_8
XFILLER_62_0 VDD VSS sg13g2_decap_8
Xclkload41 clkload41/Y clkload41/A VDD VSS sg13g2_inv_2
XFILLER_161_415 VDD VSS sg13g2_decap_8
XFILLER_162_949 VDD VSS sg13g2_decap_8
Xclkload52 clkload52/Y clkload52/A VDD VSS sg13g2_inv_2
XFILLER_133_117 VDD VSS sg13g2_decap_8
Xclkload63 clkload63/Y clkload63/A VDD VSS sg13g2_inv_1
XFILLER_127_692 VDD VSS sg13g2_decap_8
XFILLER_88_705 VDD VSS sg13g2_decap_8
XFILLER_86_1074 VDD VSS sg13g2_decap_8
XFILLER_0_609 VDD VSS sg13g2_decap_8
XFILLER_88_716 VDD VSS sg13g2_fill_1
XFILLER_102_504 VDD VSS sg13g2_fill_2
XFILLER_125_28 VDD VSS sg13g2_decap_8
X_08993_ _08993_/X _14899_/Q _12859_/A _10681_/A _10674_/A VDD VSS sg13g2_and4_1
XFILLER_87_215 VDD VSS sg13g2_decap_8
X_13793__2386 _13793_/RESET_B VDD VSS sg13g2_tiehi
XFILLER_64_1350 VDD VSS sg13g2_fill_1
XFILLER_151_1320 VDD VSS sg13g2_decap_8
X_07944_ _07961_/A _07942_/A _07928_/Y _07906_/B VDD VSS sg13g2_o21ai_1
XFILLER_64_1372 VDD VSS sg13g2_decap_8
XFILLER_25_1323 VDD VSS sg13g2_decap_8
X_14819__2894 _14819_/RESET_B VDD VSS sg13g2_tiehi
XFILLER_64_1383 VDD VSS sg13g2_fill_1
XFILLER_84_900 VDD VSS sg13g2_fill_1
XFILLER_84_911 VDD VSS sg13g2_decap_8
XFILLER_56_602 VDD VSS sg13g2_fill_2
X_14744__1435 _14744_/RESET_B VDD VSS sg13g2_tiehi
XFILLER_96_782 VDD VSS sg13g2_decap_8
X_07875_ _07905_/A _07876_/A _07876_/B VDD VSS sg13g2_and2_1
XFILLER_83_410 VDD VSS sg13g2_fill_2
XFILLER_29_849 VDD VSS sg13g2_fill_2
X_09614_ _14210_/D _10012_/A0 _14210_/Q _09637_/S VDD VSS sg13g2_mux2_1
XFILLER_44_808 VDD VSS sg13g2_decap_4
XFILLER_3_1141 VDD VSS sg13g2_decap_8
XFILLER_83_465 VDD VSS sg13g2_decap_8
XFILLER_110_1050 VDD VSS sg13g2_decap_4
X_09545_ _14143_/D _09611_/A0 _14143_/Q _09563_/S VDD VSS sg13g2_mux2_1
XFILLER_71_627 VDD VSS sg13g2_decap_4
XFILLER_70_104 VDD VSS sg13g2_decap_8
X_15223__2991 _15223_/RESET_B VDD VSS sg13g2_tiehi
XFILLER_70_115 VDD VSS sg13g2_fill_1
XFILLER_93_1023 VDD VSS sg13g2_fill_2
XFILLER_70_126 VDD VSS sg13g2_decap_8
XFILLER_34_14 VDD VSS sg13g2_decap_8
XFILLER_145_1102 VDD VSS sg13g2_fill_1
XFILLER_169_504 VDD VSS sg13g2_decap_8
XFILLER_93_1034 VDD VSS sg13g2_decap_4
XFILLER_58_1154 VDD VSS sg13g2_decap_4
X_09476_ _14076_/D _10072_/A0 _14076_/Q _09494_/S VDD VSS sg13g2_mux2_1
XFILLER_24_554 VDD VSS sg13g2_fill_2
XFILLER_19_1127 VDD VSS sg13g2_decap_8
XFILLER_93_1067 VDD VSS sg13g2_fill_1
X_08427_ _08427_/X _11726_/A _11706_/A _08487_/A3 _07946_/B _08635_/S0 _08079_/S VDD
+ VSS sg13g2_mux4_1
XFILLER_140_7 VDD VSS sg13g2_decap_8
XFILLER_12_749 VDD VSS sg13g2_decap_8
XFILLER_71_1343 VDD VSS sg13g2_decap_4
X_08358_ _08358_/Y _08412_/A _08275_/B _08357_/Y VDD VSS sg13g2_o21ai_1
XFILLER_11_259 VDD VSS sg13g2_decap_8
Xclkload2 clkload2/Y clkload2/A VDD VSS sg13g2_inv_1
XFILLER_32_1316 VDD VSS sg13g2_decap_8
XFILLER_50_35 VDD VSS sg13g2_decap_8
XFILLER_164_231 VDD VSS sg13g2_decap_8
X_08289_ _08289_/Y _08265_/X _08315_/C _08315_/A VDD VSS sg13g2_a21oi_1
XFILLER_153_916 VDD VSS sg13g2_fill_1
XFILLER_166_35 VDD VSS sg13g2_decap_8
X_10320_ _10322_/A _14799_/Q _10414_/B _14800_/Q VDD VSS sg13g2_a21o_1
XFILLER_50_79 VDD VSS sg13g2_decap_8
XFILLER_106_810 VDD VSS sg13g2_decap_4
XFILLER_118_670 VDD VSS sg13g2_fill_1
XFILLER_153_949 VDD VSS sg13g2_fill_2
XFILLER_118_681 VDD VSS sg13g2_decap_8
X_10251_ _14778_/D _10251_/A _10258_/D VDD VSS sg13g2_nor2_1
XFILLER_4_959 VDD VSS sg13g2_decap_8
XFILLER_105_331 VDD VSS sg13g2_decap_8
XFILLER_65_1114 VDD VSS sg13g2_decap_8
XFILLER_156_1242 VDD VSS sg13g2_fill_2
XFILLER_79_705 VDD VSS sg13g2_decap_8
XFILLER_3_469 VDD VSS sg13g2_decap_8
XFILLER_121_824 VDD VSS sg13g2_decap_8
XFILLER_152_1106 VDD VSS sg13g2_decap_8
X_10182_ _10182_/Y _10182_/A _13613_/C VDD VSS sg13g2_nand2_1
XFILLER_121_835 VDD VSS sg13g2_fill_2
Xfanout1204 _10471_/C _10511_/D VDD VSS sg13g2_buf_1
XFILLER_160_492 VDD VSS sg13g2_decap_8
Xfanout1215 _12942_/B _13684_/Q VDD VSS sg13g2_buf_1
XFILLER_117_1259 VDD VSS sg13g2_fill_1
X_14383__1796 _14383_/RESET_B VDD VSS sg13g2_tiehi
Xfanout1226 _11446_/A fanout1227/X VDD VSS sg13g2_buf_1
Xfanout1237 _12174_/A _11450_/A1 VDD VSS sg13g2_buf_1
X_14990_ _14990_/Q clkload62/A _14990_/D _14990_/RESET_B VDD VSS sg13g2_dfrbpq_1
Xfanout250 _10083_/A0 _10150_/A1 VDD VSS sg13g2_buf_1
Xfanout1248 _11996_/S1 _11852_/S1 VDD VSS sg13g2_buf_1
Xfanout261 _10069_/S _10037_/Y VDD VSS sg13g2_buf_1
Xfanout1259 _12026_/C _11762_/S1 VDD VSS sg13g2_buf_1
XFILLER_93_207 VDD VSS sg13g2_decap_8
Xfanout272 _09605_/S _09573_/X VDD VSS sg13g2_buf_1
X_13941_ _13941_/Q clkload16/A _13941_/D _13941_/RESET_B VDD VSS sg13g2_dfrbpq_1
Xfanout283 _09318_/A0 _10148_/A1 VDD VSS sg13g2_buf_1
XFILLER_8_1085 VDD VSS sg13g2_decap_8
XFILLER_87_782 VDD VSS sg13g2_decap_8
XFILLER_75_21 VDD VSS sg13g2_decap_8
XFILLER_47_613 VDD VSS sg13g2_decap_8
Xfanout294 _09945_/A1 _09448_/A0 VDD VSS sg13g2_buf_1
XFILLER_86_270 VDD VSS sg13g2_decap_8
XFILLER_19_315 VDD VSS sg13g2_decap_8
XFILLER_75_966 VDD VSS sg13g2_decap_4
X_13872_ _13872_/Q clkload8/A _13872_/D _13872_/RESET_B VDD VSS sg13g2_dfrbpq_1
XFILLER_90_903 VDD VSS sg13g2_decap_8
XFILLER_46_145 VDD VSS sg13g2_fill_2
XFILLER_46_156 VDD VSS sg13g2_decap_8
XFILLER_75_999 VDD VSS sg13g2_decap_8
X_14003__2176 _14003_/RESET_B VDD VSS sg13g2_tiehi
X_12823_ _12824_/B _12878_/D _12822_/X _12816_/Y _12870_/A2 _12820_/Y VDD VSS sg13g2_a221oi_1
XFILLER_61_137 VDD VSS sg13g2_decap_8
XFILLER_15_532 VDD VSS sg13g2_decap_8
X_12754_ _12754_/X _14392_/Q _14424_/Q _14488_/Q _14520_/Q _12785_/S0 _12785_/S1 VDD
+ VSS sg13g2_mux4_1
XFILLER_91_53 VDD VSS sg13g2_decap_4
XFILLER_128_1355 VDD VSS sg13g2_fill_1
XFILLER_76_1287 VDD VSS sg13g2_decap_8
X_11705_ _11705_/Y _11706_/A _13679_/Q VDD VSS sg13g2_nand2_1
X_12685_ _12685_/X _13971_/Q _14003_/Q _14035_/Q _14067_/Q _12689_/S0 _12689_/S1 VDD
+ VSS sg13g2_mux4_1
XFILLER_30_535 VDD VSS sg13g2_fill_2
X_14424_ _14424_/Q _14979_/CLK _14424_/D _14424_/RESET_B VDD VSS sg13g2_dfrbpq_1
X_11636_ _11637_/B _11636_/A _11636_/B _11636_/C VDD VSS sg13g2_nand3_1
XFILLER_156_710 VDD VSS sg13g2_decap_8
XFILLER_24_91 VDD VSS sg13g2_decap_8
XFILLER_168_581 VDD VSS sg13g2_decap_8
XFILLER_129_957 VDD VSS sg13g2_decap_8
XFILLER_128_445 VDD VSS sg13g2_decap_8
X_14355_ _14355_/Q _14660_/CLK _14355_/D _14355_/RESET_B VDD VSS sg13g2_dfrbpq_1
X_11567_ _11638_/B _11502_/A _13685_/Q _12942_/B _11526_/A VDD VSS sg13g2_a22oi_1
XFILLER_7_742 VDD VSS sg13g2_decap_8
XFILLER_144_916 VDD VSS sg13g2_decap_4
XFILLER_116_618 VDD VSS sg13g2_fill_2
XFILLER_13_1260 VDD VSS sg13g2_decap_8
XFILLER_144_927 VDD VSS sg13g2_decap_4
XFILLER_156_787 VDD VSS sg13g2_fill_1
X_13306_ _15059_/D _13324_/A _13306_/B _13306_/C VDD VSS sg13g2_nor3_1
X_10518_ _10519_/C _14855_/Q _10579_/B VDD VSS sg13g2_and2_1
X_14286_ _14286_/Q clkload37/A _14286_/D _14286_/RESET_B VDD VSS sg13g2_dfrbpq_1
XFILLER_6_252 VDD VSS sg13g2_decap_8
X_11498_ _11498_/Y _11446_/A _11496_/X _11497_/Y VDD VSS sg13g2_o21ai_1
XFILLER_157_1017 VDD VSS sg13g2_fill_1
XFILLER_87_1350 VDD VSS sg13g2_fill_2
XFILLER_157_1039 VDD VSS sg13g2_decap_8
X_13237_ _13237_/Y _13234_/Y _13235_/Y _13236_/Y VDD VSS sg13g2_a21oi_1
XFILLER_170_245 VDD VSS sg13g2_decap_8
X_10449_ _10450_/C _10647_/A _14839_/Q _10510_/B _10514_/A VDD VSS sg13g2_and4_1
XFILLER_152_971 VDD VSS sg13g2_decap_4
XFILLER_100_1296 VDD VSS sg13g2_decap_8
XFILLER_48_1356 VDD VSS sg13g2_fill_1
XFILLER_112_824 VDD VSS sg13g2_fill_2
X_13168_ _13225_/A _13189_/A _13190_/B VDD VSS sg13g2_xor2_1
XFILLER_124_684 VDD VSS sg13g2_decap_8
XFILLER_135_1337 VDD VSS sg13g2_decap_4
XFILLER_97_546 VDD VSS sg13g2_decap_8
X_12119_ _12119_/Y _12099_/Y _12101_/X _11378_/S VDD VSS sg13g2_o21ai_1
X_13099_ _13099_/Y _13166_/A1 _13098_/X _13097_/Y VDD VSS sg13g2_a21oi_1
X_14213__1966 _14213_/RESET_B VDD VSS sg13g2_tiehi
XFILLER_85_708 VDD VSS sg13g2_decap_8
XFILLER_66_933 VDD VSS sg13g2_fill_1
XFILLER_120_890 VDD VSS sg13g2_decap_8
XFILLER_77_281 VDD VSS sg13g2_fill_2
XFILLER_65_421 VDD VSS sg13g2_decap_8
XFILLER_37_112 VDD VSS sg13g2_decap_8
XFILLER_133_1094 VDD VSS sg13g2_fill_1
XFILLER_168_1102 VDD VSS sg13g2_fill_1
X_07660_ _07766_/B _10210_/D _14749_/Q VDD VSS sg13g2_nand2b_1
X_16858_ _16858_/X _16858_/A VDD VSS sg13g2_buf_1
XFILLER_65_454 VDD VSS sg13g2_fill_2
XFILLER_26_808 VDD VSS sg13g2_fill_2
X_13778__2401 _13778_/RESET_B VDD VSS sg13g2_tiehi
XFILLER_93_785 VDD VSS sg13g2_fill_2
XFILLER_1_84 VDD VSS sg13g2_decap_8
XFILLER_20_1253 VDD VSS sg13g2_decap_8
XFILLER_19_882 VDD VSS sg13g2_decap_8
XFILLER_0_1325 VDD VSS sg13g2_decap_8
XFILLER_111_1381 VDD VSS sg13g2_fill_2
XFILLER_81_969 VDD VSS sg13g2_decap_8
XFILLER_80_435 VDD VSS sg13g2_fill_1
XFILLER_52_126 VDD VSS sg13g2_fill_2
X_09330_ _13937_/D _10160_/A1 _13937_/Q _09330_/S VDD VSS sg13g2_mux2_1
XFILLER_18_392 VDD VSS sg13g2_decap_8
XFILLER_55_1327 VDD VSS sg13g2_decap_4
X_09261_ _13870_/D _13870_/Q _10090_/A0 _09267_/S VDD VSS sg13g2_mux2_1
XFILLER_33_384 VDD VSS sg13g2_decap_8
XFILLER_60_181 VDD VSS sg13g2_decap_8
X_08212_ _08212_/X _08621_/A _08688_/D _08688_/A VDD VSS sg13g2_and3_1
XFILLER_21_546 VDD VSS sg13g2_decap_8
XFILLER_166_518 VDD VSS sg13g2_decap_8
X_14158__2021 _14158_/RESET_B VDD VSS sg13g2_tiehi
X_09192_ _13808_/D _13808_/Q _09696_/A0 _09193_/S VDD VSS sg13g2_mux2_1
XFILLER_147_710 VDD VSS sg13g2_decap_8
XFILLER_119_434 VDD VSS sg13g2_decap_8
X_13701__2478 _13701_/RESET_B VDD VSS sg13g2_tiehi
X_08143_ _08143_/Y _08182_/B _08141_/Y _08142_/Y VDD VSS sg13g2_o21ai_1
XFILLER_119_445 VDD VSS sg13g2_fill_1
XFILLER_146_231 VDD VSS sg13g2_fill_1
XFILLER_14_1057 VDD VSS sg13g2_decap_8
XFILLER_174_540 VDD VSS sg13g2_decap_8
XFILLER_174_551 VDD VSS sg13g2_decap_8
XFILLER_140_1076 VDD VSS sg13g2_fill_1
XFILLER_101_1038 VDD VSS sg13g2_decap_8
X_08074_ _08074_/X _08160_/A _08074_/B _08074_/C VDD VSS sg13g2_and3_1
XFILLER_134_426 VDD VSS sg13g2_decap_8
XFILLER_162_735 VDD VSS sg13g2_decap_8
XFILLER_20_49 VDD VSS sg13g2_decap_8
XFILLER_161_245 VDD VSS sg13g2_decap_8
XFILLER_136_49 VDD VSS sg13g2_decap_8
X_14950__2644 _14950_/RESET_B VDD VSS sg13g2_tiehi
XFILLER_0_406 VDD VSS sg13g2_decap_8
XFILLER_88_513 VDD VSS sg13g2_fill_2
XFILLER_143_993 VDD VSS sg13g2_decap_4
XFILLER_161_289 VDD VSS sg13g2_decap_8
XFILLER_29_14 VDD VSS sg13g2_decap_8
XFILLER_102_334 VDD VSS sg13g2_decap_8
XFILLER_103_879 VDD VSS sg13g2_fill_2
X_08976_ _08977_/B _10675_/B _10675_/C VDD VSS sg13g2_nor2_1
XFILLER_25_1120 VDD VSS sg13g2_decap_8
XFILLER_9_1372 VDD VSS sg13g2_decap_8
XFILLER_75_207 VDD VSS sg13g2_decap_8
XFILLER_69_771 VDD VSS sg13g2_fill_2
XFILLER_9_1383 VDD VSS sg13g2_fill_1
X_14965__2622 _14965_/RESET_B VDD VSS sg13g2_tiehi
X_07927_ _07927_/Y _07922_/Y _07904_/A _07926_/X VDD VSS sg13g2_a21oi_1
XFILLER_5_1225 VDD VSS sg13g2_decap_8
XFILLER_151_1161 VDD VSS sg13g2_fill_1
XFILLER_28_112 VDD VSS sg13g2_decap_8
XFILLER_112_1134 VDD VSS sg13g2_decap_4
XFILLER_151_1194 VDD VSS sg13g2_decap_8
XFILLER_25_1197 VDD VSS sg13g2_decap_8
X_07858_ _07858_/X _15014_/Q _07859_/B VDD VSS sg13g2_and2_1
XFILLER_99_1265 VDD VSS sg13g2_decap_4
XFILLER_60_1099 VDD VSS sg13g2_fill_2
XFILLER_17_819 VDD VSS sg13g2_decap_8
XFILLER_57_999 VDD VSS sg13g2_decap_4
XFILLER_99_1298 VDD VSS sg13g2_decap_4
XFILLER_45_35 VDD VSS sg13g2_decap_8
XFILLER_16_329 VDD VSS sg13g2_decap_8
X_14368__1811 _14368_/RESET_B VDD VSS sg13g2_tiehi
XFILLER_83_273 VDD VSS sg13g2_decap_8
XFILLER_44_638 VDD VSS sg13g2_decap_8
X_07789_ _08391_/B _07790_/A _15003_/Q VDD VSS sg13g2_nor2_1
XFILLER_25_830 VDD VSS sg13g2_decap_8
X_09528_ _14127_/D _10091_/A0 _14127_/Q _09530_/S VDD VSS sg13g2_mux2_1
XFILLER_169_301 VDD VSS sg13g2_decap_8
XFILLER_101_41 VDD VSS sg13g2_decap_8
X_14998__2589 _14998_/RESET_B VDD VSS sg13g2_tiehi
X_09459_ _14060_/D _09624_/A0 _14060_/Q _09467_/S VDD VSS sg13g2_mux2_1
XFILLER_40_844 VDD VSS sg13g2_fill_2
XFILLER_12_546 VDD VSS sg13g2_decap_8
XFILLER_169_378 VDD VSS sg13g2_decap_8
X_12470_ _12471_/B _13685_/Q _12763_/A2 _12469_/X _12415_/A _12624_/C1 VDD VSS sg13g2_a221oi_1
XFILLER_36_1260 VDD VSS sg13g2_fill_1
XFILLER_8_539 VDD VSS sg13g2_decap_8
XFILLER_32_1124 VDD VSS sg13g2_decap_8
X_11421_ _11422_/A _13951_/Q _13983_/Q _14015_/Q _14047_/Q _11418_/A _11419_/C VDD
+ VSS sg13g2_mux4_1
XFILLER_123_1274 VDD VSS sg13g2_decap_8
XFILLER_126_905 VDD VSS sg13g2_fill_1
XFILLER_138_765 VDD VSS sg13g2_fill_1
X_14140_ _14140_/Q clkload40/A _14140_/D _14140_/RESET_B VDD VSS sg13g2_dfrbpq_1
XFILLER_32_1179 VDD VSS sg13g2_decap_8
X_11352_ _11361_/B _11346_/Y _11351_/Y _11224_/A VDD VSS sg13g2_o21ai_1
XFILLER_165_595 VDD VSS sg13g2_decap_8
XFILLER_153_757 VDD VSS sg13g2_fill_1
X_10303_ _10306_/C _14794_/Q _10299_/Y hold3167/X VDD VSS sg13g2_a21oi_1
X_14071_ _14071_/Q clkload33/A _14071_/D _14071_/RESET_B VDD VSS sg13g2_dfrbpq_1
X_11283_ _11283_/Y _11283_/A _12324_/B VDD VSS sg13g2_nand2_1
XFILLER_4_756 VDD VSS sg13g2_decap_8
X_14470__1709 _14470_/RESET_B VDD VSS sg13g2_tiehi
X_13022_ _13042_/A _14908_/Q _13679_/Q VDD VSS sg13g2_nand2_1
X_13856__2323 _13856_/RESET_B VDD VSS sg13g2_tiehi
X_10234_ _10234_/Y _14771_/Q _14772_/Q _14773_/Q _10234_/D VDD VSS sg13g2_nand4_1
XFILLER_3_266 VDD VSS sg13g2_decap_8
XFILLER_152_289 VDD VSS sg13g2_fill_1
XFILLER_133_481 VDD VSS sg13g2_fill_2
XFILLER_156_1083 VDD VSS sg13g2_fill_2
Xfanout1001 _09806_/B _09707_/B VDD VSS sg13g2_buf_1
XFILLER_0_940 VDD VSS sg13g2_decap_8
Xfanout1012 _09009_/S _13305_/A VDD VSS sg13g2_buf_1
X_10165_ _14742_/D _14742_/Q _10165_/A1 _10167_/S VDD VSS sg13g2_mux2_1
Xfanout1023 _08831_/B _11241_/C VDD VSS sg13g2_buf_1
XFILLER_117_1067 VDD VSS sg13g2_decap_8
Xfanout1034 _08659_/A _08600_/A VDD VSS sg13g2_buf_1
Xfanout1045 _08361_/A1 _08161_/A2 VDD VSS sg13g2_buf_1
Xfanout1056 _13525_/A _14991_/Q VDD VSS sg13g2_buf_1
XFILLER_130_1201 VDD VSS sg13g2_fill_2
X_14973_ _14973_/Q _14979_/CLK _14973_/D _14973_/RESET_B VDD VSS sg13g2_dfrbpq_1
Xfanout1067 _08402_/A _08207_/S1 VDD VSS sg13g2_buf_1
X_10096_ _14676_/D _10096_/A0 _14676_/Q _10096_/S VDD VSS sg13g2_mux2_1
XFILLER_86_86 VDD VSS sg13g2_fill_2
Xfanout1078 _13509_/A1 _13518_/A1 VDD VSS sg13g2_buf_1
XFILLER_94_549 VDD VSS sg13g2_decap_8
XFILLER_19_112 VDD VSS sg13g2_decap_8
Xfanout1089 _08010_/B _08653_/B VDD VSS sg13g2_buf_1
XFILLER_48_966 VDD VSS sg13g2_decap_8
X_13924_ _13924_/Q _14672_/CLK _13924_/D _13924_/RESET_B VDD VSS sg13g2_dfrbpq_1
XFILLER_43_1297 VDD VSS sg13g2_decap_8
XFILLER_35_605 VDD VSS sg13g2_fill_1
XFILLER_19_91 VDD VSS sg13g2_decap_8
XFILLER_142_92 VDD VSS sg13g2_decap_8
X_13855_ _13855_/Q clkload12/A _13855_/D _13855_/RESET_B VDD VSS sg13g2_dfrbpq_1
XFILLER_63_947 VDD VSS sg13g2_decap_4
XFILLER_19_189 VDD VSS sg13g2_decap_8
X_12806_ _12806_/Y _14863_/Q _12895_/B VDD VSS sg13g2_nand2_1
X_13786_ _13786_/Q _14746_/CLK _13786_/D _13786_/RESET_B VDD VSS sg13g2_dfrbpq_1
X_10998_ _10998_/Y _11027_/B1 _10992_/X _10997_/Y VDD VSS sg13g2_a21oi_1
XFILLER_31_800 VDD VSS sg13g2_fill_2
XFILLER_43_660 VDD VSS sg13g2_fill_2
XFILLER_128_1152 VDD VSS sg13g2_fill_2
XFILLER_16_896 VDD VSS sg13g2_decap_8
X_12737_ _12750_/A _12765_/A1 _12737_/A2 _15017_/Q VDD VSS sg13g2_a21oi_1
XFILLER_128_1185 VDD VSS sg13g2_decap_8
XFILLER_31_866 VDD VSS sg13g2_decap_8
X_12668_ _12668_/X _14258_/Q _14290_/Q _14322_/Q _14354_/Q _12758_/S0 _12758_/S1 VDD
+ VSS sg13g2_mux4_1
XFILLER_50_1202 VDD VSS sg13g2_decap_4
XFILLER_30_365 VDD VSS sg13g2_decap_8
XFILLER_15_1344 VDD VSS sg13g2_decap_8
XFILLER_128_220 VDD VSS sg13g2_fill_2
X_14407_ _14407_/Q _14703_/CLK _14407_/D _14407_/RESET_B VDD VSS sg13g2_dfrbpq_1
XFILLER_50_1235 VDD VSS sg13g2_fill_1
X_11619_ _11619_/Y _11597_/A _13926_/Q _11690_/B VDD VSS sg13g2_a21oi_1
XFILLER_141_1374 VDD VSS sg13g2_fill_1
X_12599_ _12599_/X _14573_/Q _14605_/Q _14637_/Q _14669_/Q _12606_/S0 _12606_/S1 VDD
+ VSS sg13g2_mux4_1
X_15137__2683 _15137_/RESET_B VDD VSS sg13g2_tiehi
XFILLER_128_264 VDD VSS sg13g2_decap_8
XFILLER_156_584 VDD VSS sg13g2_fill_2
X_14338_ _14338_/Q clkload25/A _14338_/D _14338_/RESET_B VDD VSS sg13g2_dfrbpq_1
XFILLER_85_1309 VDD VSS sg13g2_fill_2
XFILLER_143_223 VDD VSS sg13g2_decap_8
X_14269_ _14269_/Q clkload47/A _14269_/D _14269_/RESET_B VDD VSS sg13g2_dfrbpq_1
X_15222__2990 _15222_/RESET_B VDD VSS sg13g2_tiehi
XFILLER_98_800 VDD VSS sg13g2_decap_8
XFILLER_171_565 VDD VSS sg13g2_decap_8
XFILLER_87_1191 VDD VSS sg13g2_decap_8
XFILLER_48_1153 VDD VSS sg13g2_fill_2
X_14446__1733 _14446_/RESET_B VDD VSS sg13g2_tiehi
XFILLER_140_930 VDD VSS sg13g2_decap_8
XFILLER_140_941 VDD VSS sg13g2_decap_8
XFILLER_44_1006 VDD VSS sg13g2_fill_2
XFILLER_112_643 VDD VSS sg13g2_decap_8
XFILLER_170_1025 VDD VSS sg13g2_decap_8
X_08830_ _08830_/X _14747_/Q _13613_/C _08830_/C VDD VSS sg13g2_or3_1
XFILLER_98_899 VDD VSS sg13g2_fill_2
XFILLER_135_1178 VDD VSS sg13g2_decap_8
XFILLER_25_0 VDD VSS sg13g2_decap_8
X_08761_ _08761_/Y _13129_/B _08761_/B VDD VSS sg13g2_nor2_1
XFILLER_78_590 VDD VSS sg13g2_decap_4
XFILLER_38_421 VDD VSS sg13g2_decap_8
X_07712_ _07713_/A _08831_/B _11241_/A VDD VSS sg13g2_nor2_1
X_08692_ _08693_/C _08692_/A _08692_/B _08692_/C VDD VSS sg13g2_nand3_1
XFILLER_66_774 VDD VSS sg13g2_decap_8
XFILLER_22_1359 VDD VSS sg13g2_decap_8
XFILLER_65_251 VDD VSS sg13g2_decap_8
XFILLER_81_711 VDD VSS sg13g2_fill_2
X_07643_ _10299_/A _14785_/Q VDD VSS sg13g2_inv_1
XFILLER_0_1122 VDD VSS sg13g2_decap_8
XFILLER_25_126 VDD VSS sg13g2_decap_8
XFILLER_20_1050 VDD VSS sg13g2_decap_8
XFILLER_59_1260 VDD VSS sg13g2_decap_8
XFILLER_55_1113 VDD VSS sg13g2_decap_4
X_09313_ _13920_/D _10143_/A1 _13920_/Q _09338_/S VDD VSS sg13g2_mux2_1
XFILLER_15_49 VDD VSS sg13g2_decap_8
XFILLER_0_1199 VDD VSS sg13g2_decap_8
XFILLER_107_1203 VDD VSS sg13g2_decap_8
XFILLER_146_1252 VDD VSS sg13g2_fill_1
XFILLER_167_805 VDD VSS sg13g2_fill_1
X_13934__2245 _13934_/RESET_B VDD VSS sg13g2_tiehi
X_14694__1485 _14694_/RESET_B VDD VSS sg13g2_tiehi
X_09244_ _13853_/D _13853_/Q _09310_/A0 _09267_/S VDD VSS sg13g2_mux2_1
XFILLER_21_343 VDD VSS sg13g2_decap_8
XFILLER_166_315 VDD VSS sg13g2_decap_8
X_09175_ _13791_/D _13791_/Q _09877_/A0 _09193_/S VDD VSS sg13g2_mux2_1
XFILLER_107_404 VDD VSS sg13g2_decap_4
X_08126_ _08126_/Y _08621_/A _08126_/B VDD VSS sg13g2_nand2_1
XFILLER_108_949 VDD VSS sg13g2_decap_8
XFILLER_147_584 VDD VSS sg13g2_fill_1
XFILLER_134_234 VDD VSS sg13g2_decap_8
X_08057_ _08057_/Y _08177_/S _08052_/Y _08056_/Y VDD VSS sg13g2_o21ai_1
XFILLER_31_1190 VDD VSS sg13g2_decap_8
XFILLER_103_7 VDD VSS sg13g2_decap_8
XFILLER_162_565 VDD VSS sg13g2_decap_8
XFILLER_134_267 VDD VSS sg13g2_decap_8
XFILLER_162_576 VDD VSS sg13g2_fill_1
XFILLER_116_982 VDD VSS sg13g2_fill_2
XFILLER_122_429 VDD VSS sg13g2_fill_2
XFILLER_89_822 VDD VSS sg13g2_fill_2
XFILLER_0_203 VDD VSS sg13g2_decap_8
Xoutput48 mem_axi_araddr[19] _16872_/A VDD VSS sg13g2_buf_1
XFILLER_163_14 VDD VSS sg13g2_decap_8
Xoutput59 mem_axi_araddr[2] _16855_/A VDD VSS sg13g2_buf_1
XFILLER_27_1215 VDD VSS sg13g2_decap_8
XFILLER_103_632 VDD VSS sg13g2_fill_1
Xhold3120 _13630_/A _13738_/Q VDD VSS sg13g2_dlygate4sd3_1
Xhold3131 _10903_/A _14935_/Q VDD VSS sg13g2_dlygate4sd3_1
Xhold3142 _10959_/A _14939_/Q VDD VSS sg13g2_dlygate4sd3_1
XFILLER_7_1309 VDD VSS sg13g2_decap_8
XFILLER_118_1365 VDD VSS sg13g2_fill_2
Xhold3153 _13587_/A _15161_/Q VDD VSS sg13g2_dlygate4sd3_1
Xhold3164 _13593_/A _15163_/Q VDD VSS sg13g2_dlygate4sd3_1
XFILLER_103_687 VDD VSS sg13g2_fill_2
XFILLER_130_462 VDD VSS sg13g2_fill_1
XFILLER_48_218 VDD VSS sg13g2_decap_8
XFILLER_88_398 VDD VSS sg13g2_decap_8
X_08959_ _09204_/D _10776_/C _10793_/B VDD VSS sg13g2_nor2_1
XFILLER_5_1022 VDD VSS sg13g2_decap_8
XFILLER_29_432 VDD VSS sg13g2_decap_8
XFILLER_99_1040 VDD VSS sg13g2_decap_8
X_11970_ _11971_/B _11970_/A _11970_/B _11970_/C VDD VSS sg13g2_nand3_1
XFILLER_57_763 VDD VSS sg13g2_fill_2
XFILLER_56_251 VDD VSS sg13g2_decap_8
XFILLER_17_616 VDD VSS sg13g2_decap_8
XFILLER_72_722 VDD VSS sg13g2_decap_8
X_10921_ _10921_/Y _10920_/A _10920_/B _11027_/B1 VDD VSS sg13g2_o21ai_1
XFILLER_5_1099 VDD VSS sg13g2_decap_8
XFILLER_71_210 VDD VSS sg13g2_fill_1
XFILLER_16_126 VDD VSS sg13g2_decap_8
XFILLER_44_435 VDD VSS sg13g2_decap_8
XFILLER_45_969 VDD VSS sg13g2_fill_2
XFILLER_60_906 VDD VSS sg13g2_fill_1
XFILLER_38_1300 VDD VSS sg13g2_fill_2
XFILLER_112_62 VDD VSS sg13g2_fill_2
X_13640_ _13748_/D _13640_/A VDD VSS sg13g2_buf_1
X_10852_ _10852_/X _10870_/A _10897_/D VDD VSS sg13g2_xor2_1
XFILLER_44_479 VDD VSS sg13g2_decap_8
XFILLER_38_1333 VDD VSS sg13g2_decap_8
XFILLER_13_833 VDD VSS sg13g2_decap_8
X_13571_ _13571_/Y _14997_/Q _13566_/B _13569_/S _15013_/Q _13517_/X VDD VSS sg13g2_a221oi_1
X_10783_ _10783_/Y _13245_/A _11196_/B VDD VSS sg13g2_nand2_1
XFILLER_72_77 VDD VSS sg13g2_decap_8
XFILLER_34_1208 VDD VSS sg13g2_decap_8
XFILLER_12_343 VDD VSS sg13g2_decap_8
X_12522_ _12522_/X _13959_/Q _13991_/Q _14023_/Q _14055_/Q _12522_/S0 _12522_/S1 VDD
+ VSS sg13g2_mux4_1
XFILLER_169_175 VDD VSS sg13g2_decap_8
X_14524__1655 _14524_/RESET_B VDD VSS sg13g2_tiehi
XFILLER_9_826 VDD VSS sg13g2_decap_8
XFILLER_40_685 VDD VSS sg13g2_fill_2
XFILLER_157_359 VDD VSS sg13g2_fill_1
X_15241_ _15241_/Q _15247_/CLK _15241_/D _15241_/RESET_B VDD VSS sg13g2_dfrbpq_1
XFILLER_8_336 VDD VSS sg13g2_decap_8
X_12453_ _12453_/X _12448_/X _12452_/X _12447_/X _12451_/X _12762_/S _12454_/S1 VDD
+ VSS sg13g2_mux4_1
XFILLER_172_307 VDD VSS sg13g2_decap_8
X_14778__2935 _14778_/RESET_B VDD VSS sg13g2_tiehi
X_11404_ _11404_/Y _11402_/Y _11401_/Y _11745_/B _11403_/X VDD VSS sg13g2_a22oi_1
X_15172_ _15172_/Q _15183_/CLK _15172_/D _15172_/RESET_B VDD VSS sg13g2_dfrbpq_1
X_12384_ _12384_/X _12378_/X _12382_/X _12377_/X _12381_/X _12398_/S1 _12398_/S0 VDD
+ VSS sg13g2_mux4_1
XFILLER_165_392 VDD VSS sg13g2_decap_8
XFILLER_158_1134 VDD VSS sg13g2_fill_2
X_14123_ _14123_/Q clkload0/A _14123_/D _14123_/RESET_B VDD VSS sg13g2_dfrbpq_1
X_11335_ _11335_/X _11335_/A _13691_/Q VDD VSS sg13g2_or2_1
XFILLER_21_70 VDD VSS sg13g2_decap_8
XFILLER_125_245 VDD VSS sg13g2_decap_4
XFILLER_114_919 VDD VSS sg13g2_fill_2
XFILLER_126_779 VDD VSS sg13g2_fill_2
XFILLER_153_565 VDD VSS sg13g2_decap_8
XFILLER_4_553 VDD VSS sg13g2_decap_8
XFILLER_10_1274 VDD VSS sg13g2_decap_8
XFILLER_137_70 VDD VSS sg13g2_fill_1
XFILLER_137_81 VDD VSS sg13g2_decap_8
X_15079__2835 _15079_/RESET_B VDD VSS sg13g2_tiehi
XFILLER_153_598 VDD VSS sg13g2_decap_8
X_14054_ _14054_/Q clkload2/A _14054_/D _14054_/RESET_B VDD VSS sg13g2_dfrbpq_1
X_11266_ _11266_/Y _11266_/A _11266_/B VDD VSS sg13g2_nand2_1
XFILLER_79_310 VDD VSS sg13g2_fill_2
XFILLER_84_1364 VDD VSS sg13g2_decap_8
X_13005_ _15033_/D _13005_/A _13005_/B _13005_/C VDD VSS sg13g2_nand3_1
X_10217_ _10217_/Y _10187_/S _13600_/C _10216_/Y VDD VSS sg13g2_a21oi_1
XFILLER_171_1334 VDD VSS sg13g2_decap_8
X_11197_ _11197_/X _11197_/A _11197_/B VDD VSS sg13g2_and2_1
XFILLER_79_354 VDD VSS sg13g2_decap_8
XFILLER_45_1348 VDD VSS sg13g2_fill_2
XFILLER_79_365 VDD VSS sg13g2_fill_2
XFILLER_94_302 VDD VSS sg13g2_decap_8
XFILLER_121_473 VDD VSS sg13g2_fill_1
X_10148_ _14725_/D _14725_/Q _10148_/A1 _10160_/S VDD VSS sg13g2_mux2_1
XFILLER_121_495 VDD VSS sg13g2_decap_8
XFILLER_95_869 VDD VSS sg13g2_decap_8
XFILLER_153_91 VDD VSS sg13g2_decap_8
X_14956_ _14956_/Q clkload42/A _14956_/D _14956_/RESET_B VDD VSS sg13g2_dfrbpq_1
X_10079_ _14659_/D _10079_/A0 _14659_/Q _10101_/S VDD VSS sg13g2_mux2_1
X_13907_ _13907_/Q clkload24/A _13907_/D _13907_/RESET_B VDD VSS sg13g2_dfrbpq_1
XFILLER_75_593 VDD VSS sg13g2_fill_1
XFILLER_35_424 VDD VSS sg13g2_decap_4
X_14887_ _14887_/Q _14890_/CLK _14887_/D _14887_/RESET_B VDD VSS sg13g2_dfrbpq_1
XFILLER_78_1146 VDD VSS sg13g2_decap_8
X_13838_ _13838_/Q _14734_/CLK _13838_/D _13838_/RESET_B VDD VSS sg13g2_dfrbpq_1
XFILLER_23_608 VDD VSS sg13g2_decap_8
XFILLER_23_619 VDD VSS sg13g2_fill_2
XFILLER_91_1302 VDD VSS sg13g2_decap_8
XFILLER_90_596 VDD VSS sg13g2_decap_8
XFILLER_16_693 VDD VSS sg13g2_decap_8
XFILLER_149_805 VDD VSS sg13g2_decap_8
X_13769_ _13769_/Q clkload20/A _13769_/D _13769_/RESET_B VDD VSS sg13g2_dfrbpq_1
XFILLER_149_816 VDD VSS sg13g2_fill_1
XFILLER_52_1308 VDD VSS sg13g2_fill_2
XFILLER_31_652 VDD VSS sg13g2_decap_8
XFILLER_91_1379 VDD VSS sg13g2_decap_4
XFILLER_148_326 VDD VSS sg13g2_decap_8
XFILLER_15_1141 VDD VSS sg13g2_decap_8
XFILLER_157_871 VDD VSS sg13g2_decap_4
XFILLER_141_1182 VDD VSS sg13g2_decap_8
XFILLER_163_329 VDD VSS sg13g2_decap_8
XFILLER_102_1144 VDD VSS sg13g2_decap_8
XFILLER_116_212 VDD VSS sg13g2_decap_8
XFILLER_117_746 VDD VSS sg13g2_decap_8
X_14679__1500 _14679_/RESET_B VDD VSS sg13g2_tiehi
XFILLER_132_705 VDD VSS sg13g2_decap_8
XFILLER_104_407 VDD VSS sg13g2_fill_1
XFILLER_132_716 VDD VSS sg13g2_fill_1
XFILLER_171_362 VDD VSS sg13g2_decap_8
XFILLER_104_418 VDD VSS sg13g2_decap_8
X_09931_ _14516_/D _14516_/Q _09931_/A1 _09931_/S VDD VSS sg13g2_mux2_1
XFILLER_125_790 VDD VSS sg13g2_decap_8
XFILLER_98_630 VDD VSS sg13g2_decap_8
Xfanout805 _12606_/S1 _12507_/S1 VDD VSS sg13g2_buf_1
Xfanout816 fanout816/X fanout849/X VDD VSS sg13g2_buf_1
XFILLER_113_963 VDD VSS sg13g2_fill_2
Xfanout827 _12783_/S1 _12782_/S1 VDD VSS sg13g2_buf_1
X_09862_ _14449_/D _14449_/Q _10127_/A0 _09862_/S VDD VSS sg13g2_mux2_1
XFILLER_97_140 VDD VSS sg13g2_decap_8
Xfanout838 _12546_/S1 _12773_/S1 VDD VSS sg13g2_buf_1
XFILLER_98_674 VDD VSS sg13g2_fill_1
Xfanout849 fanout849/X _15211_/Q VDD VSS sg13g2_buf_1
XFILLER_97_151 VDD VSS sg13g2_fill_2
X_08813_ _08813_/Y _13279_/B _12347_/B _08727_/D _15180_/Q _08825_/C1 VDD VSS sg13g2_a221oi_1
XFILLER_133_28 VDD VSS sg13g2_decap_8
XFILLER_86_847 VDD VSS sg13g2_fill_2
X_09793_ _14382_/D _09925_/A1 _14382_/Q _09799_/S VDD VSS sg13g2_mux2_1
XFILLER_61_1172 VDD VSS sg13g2_decap_8
X_14602__1577 _14602_/RESET_B VDD VSS sg13g2_tiehi
X_08744_ _13666_/D _08765_/A1 _08742_/Y _08743_/Y VDD VSS sg13g2_a21oi_1
XFILLER_100_679 VDD VSS sg13g2_decap_8
XFILLER_113_1262 VDD VSS sg13g2_decap_4
XFILLER_22_1156 VDD VSS sg13g2_decap_8
XFILLER_2_1239 VDD VSS sg13g2_decap_8
XFILLER_27_936 VDD VSS sg13g2_decap_8
X_08675_ _08675_/Y _08035_/X _08671_/Y _08674_/Y VDD VSS sg13g2_o21ai_1
XFILLER_26_424 VDD VSS sg13g2_decap_8
XFILLER_148_1336 VDD VSS sg13g2_fill_1
XFILLER_81_552 VDD VSS sg13g2_decap_8
X_07626_ _07626_/Y _07900_/B VDD VSS sg13g2_inv_1
XFILLER_42_928 VDD VSS sg13g2_decap_8
XFILLER_148_1358 VDD VSS sg13g2_decap_4
XFILLER_22_630 VDD VSS sg13g2_decap_8
XFILLER_167_602 VDD VSS sg13g2_decap_8
XFILLER_42_14 VDD VSS sg13g2_decap_8
XFILLER_146_1093 VDD VSS sg13g2_decap_8
XFILLER_21_140 VDD VSS sg13g2_decap_8
XFILLER_158_14 VDD VSS sg13g2_decap_8
XFILLER_166_112 VDD VSS sg13g2_decap_8
XFILLER_22_685 VDD VSS sg13g2_fill_2
XFILLER_10_847 VDD VSS sg13g2_decap_8
X_09227_ _13838_/D _09859_/A1 _13838_/Q _09233_/S VDD VSS sg13g2_mux2_1
XFILLER_166_189 VDD VSS sg13g2_decap_8
X_09158_ _09158_/Y _09162_/A _09158_/B _09158_/C VDD VSS sg13g2_nand3_1
XFILLER_147_370 VDD VSS sg13g2_fill_1
XFILLER_135_521 VDD VSS sg13g2_decap_4
XFILLER_147_392 VDD VSS sg13g2_decap_8
XFILLER_163_841 VDD VSS sg13g2_decap_8
XFILLER_68_1315 VDD VSS sg13g2_decap_8
X_08109_ _08452_/A _08207_/S1 _08402_/B _08023_/Y _08101_/Y VDD VSS sg13g2_a22oi_1
XFILLER_135_554 VDD VSS sg13g2_fill_1
X_09089_ _09090_/C _14911_/Q _13064_/A _09089_/C _09103_/D VDD VSS sg13g2_nand4_1
XFILLER_162_362 VDD VSS sg13g2_decap_8
XFILLER_174_35 VDD VSS sg13g2_decap_8
XFILLER_163_896 VDD VSS sg13g2_fill_1
X_11120_ _11127_/A _11012_/B _11012_/C _11119_/Y VDD VSS sg13g2_o21ai_1
XFILLER_122_237 VDD VSS sg13g2_decap_8
XFILLER_122_248 VDD VSS sg13g2_fill_2
XFILLER_27_1012 VDD VSS sg13g2_decap_8
X_11051_ _11051_/Y _11064_/D _11051_/B VDD VSS sg13g2_xnor2_1
XFILLER_7_1106 VDD VSS sg13g2_decap_8
XFILLER_1_567 VDD VSS sg13g2_decap_8
XFILLER_153_1042 VDD VSS sg13g2_fill_2
X_10002_ _14585_/D _10101_/A0 _14585_/Q _10002_/S VDD VSS sg13g2_mux2_1
XFILLER_103_473 VDD VSS sg13g2_decap_8
XFILLER_107_95 VDD VSS sg13g2_fill_2
XFILLER_131_793 VDD VSS sg13g2_decap_8
XFILLER_77_858 VDD VSS sg13g2_fill_2
XFILLER_27_1089 VDD VSS sg13g2_decap_8
XFILLER_130_281 VDD VSS sg13g2_decap_4
XFILLER_67_77 VDD VSS sg13g2_decap_8
X_14810_ _14810_/Q clkload51/A _14810_/D _14810_/RESET_B VDD VSS sg13g2_dfrbpq_1
XFILLER_92_817 VDD VSS sg13g2_fill_1
XFILLER_18_903 VDD VSS sg13g2_decap_8
XFILLER_57_560 VDD VSS sg13g2_decap_8
XFILLER_45_711 VDD VSS sg13g2_decap_8
XFILLER_17_413 VDD VSS sg13g2_decap_8
X_14741_ _14741_/Q clkload18/A _14741_/D _14741_/RESET_B VDD VSS sg13g2_dfrbpq_1
XFILLER_83_21 VDD VSS sg13g2_decap_8
XFILLER_40_1267 VDD VSS sg13g2_fill_2
X_11953_ _11953_/Y _11953_/A _11953_/B _12237_/C VDD VSS sg13g2_nand3_1
XFILLER_91_349 VDD VSS sg13g2_decap_8
XFILLER_29_284 VDD VSS sg13g2_decap_8
XFILLER_75_1308 VDD VSS sg13g2_decap_8
X_10904_ _10907_/A _10888_/Y _10904_/B VDD VSS sg13g2_nand2b_1
XFILLER_83_65 VDD VSS sg13g2_decap_4
X_14672_ _14672_/Q _14672_/CLK _14672_/D _14672_/RESET_B VDD VSS sg13g2_dfrbpq_1
X_11884_ _11884_/Y _11378_/S _11883_/X _12118_/C VDD VSS sg13g2_a21oi_1
XFILLER_60_725 VDD VSS sg13g2_fill_2
XFILLER_16_70 VDD VSS sg13g2_decap_8
X_13623_ _13731_/D _13623_/A VDD VSS sg13g2_buf_1
X_10835_ _10835_/Y _10827_/B _10816_/Y _10834_/Y _10873_/A1 _13279_/D VDD VSS sg13g2_a221oi_1
XFILLER_13_630 VDD VSS sg13g2_decap_8
XFILLER_38_1163 VDD VSS sg13g2_decap_8
XFILLER_12_140 VDD VSS sg13g2_decap_8
X_13554_ _15149_/D _15149_/Q _13553_/Y _13565_/S VDD VSS sg13g2_mux2_1
XFILLER_157_112 VDD VSS sg13g2_decap_8
XFILLER_160_1024 VDD VSS sg13g2_fill_1
X_10766_ _14918_/D _11207_/B1 _11115_/B _10765_/Y VDD VSS sg13g2_o21ai_1
XFILLER_9_623 VDD VSS sg13g2_decap_8
XFILLER_41_983 VDD VSS sg13g2_decap_8
XFILLER_125_1155 VDD VSS sg13g2_decap_8
X_14040__2139 _14040_/RESET_B VDD VSS sg13g2_tiehi
XFILLER_158_657 VDD VSS sg13g2_decap_8
XFILLER_160_1046 VDD VSS sg13g2_decap_8
X_12505_ _12505_/X _14566_/Q _14598_/Q _14630_/Q _14662_/Q _12661_/S0 _12661_/S1 VDD
+ VSS sg13g2_mux4_1
X_15171__1429 _15171_/RESET_B VDD VSS sg13g2_tiehi
XFILLER_8_133 VDD VSS sg13g2_decap_8
X_13485_ _13486_/A _15171_/D _15172_/D VDD VSS sg13g2_nor2_1
X_10697_ _10697_/X _10697_/A _10697_/B _10781_/C VDD VSS sg13g2_and3_1
X_15224_ _15224_/Q clkload67/A _15224_/D _15224_/RESET_B VDD VSS sg13g2_dfrbpq_1
X_12436_ _12436_/X _13953_/Q _13985_/Q _14017_/Q _14049_/Q _12771_/S0 _12771_/S1 VDD
+ VSS sg13g2_mux4_1
XFILLER_66_7 VDD VSS sg13g2_decap_8
XFILLER_32_91 VDD VSS sg13g2_decap_8
XFILLER_172_126 VDD VSS sg13g2_decap_8
XFILLER_12_1358 VDD VSS sg13g2_decap_8
XFILLER_5_840 VDD VSS sg13g2_decap_8
X_15155_ _15155_/Q clkload68/A _15155_/D _15155_/RESET_B VDD VSS sg13g2_dfrbpq_1
XFILLER_126_565 VDD VSS sg13g2_fill_2
X_12367_ _12367_/X _13820_/Q _13852_/Q _13884_/Q _13916_/Q _12787_/S0 _12787_/S1 VDD
+ VSS sg13g2_mux4_1
XFILLER_153_362 VDD VSS sg13g2_decap_8
XFILLER_4_350 VDD VSS sg13g2_decap_8
X_14106_ _14106_/Q _14682_/CLK _14106_/D _14106_/RESET_B VDD VSS sg13g2_dfrbpq_1
XFILLER_10_1071 VDD VSS sg13g2_decap_8
X_11318_ _11318_/Y _11318_/A _11318_/B VDD VSS sg13g2_nand2_1
XFILLER_99_438 VDD VSS sg13g2_decap_8
XFILLER_113_226 VDD VSS sg13g2_decap_8
X_15086_ _15086_/Q _15159_/CLK _15086_/D _15086_/RESET_B VDD VSS sg13g2_dfrbpq_1
X_12298_ _12298_/Y _12300_/A _12298_/B VDD VSS sg13g2_nor2_1
XFILLER_107_790 VDD VSS sg13g2_decap_8
XFILLER_49_1281 VDD VSS sg13g2_fill_2
X_14037_ _14037_/Q _14677_/CLK _14037_/D _14037_/RESET_B VDD VSS sg13g2_dfrbpq_1
X_11249_ _11249_/Y _11249_/A _12298_/B VDD VSS sg13g2_nor2_1
XFILLER_141_579 VDD VSS sg13g2_fill_2
XFILLER_45_1134 VDD VSS sg13g2_decap_4
XFILLER_171_1153 VDD VSS sg13g2_fill_2
XFILLER_80_1058 VDD VSS sg13g2_fill_1
XFILLER_121_292 VDD VSS sg13g2_decap_4
XFILLER_68_869 VDD VSS sg13g2_fill_2
XFILLER_171_1197 VDD VSS sg13g2_fill_2
X_14993__2594 _14993_/RESET_B VDD VSS sg13g2_tiehi
XFILLER_94_154 VDD VSS sg13g2_fill_1
X_14939_ _14939_/Q clkload53/A _14939_/D _14939_/RESET_B VDD VSS sg13g2_dfrbpq_1
X_14250__1929 _14250_/RESET_B VDD VSS sg13g2_tiehi
X_08460_ _08461_/D _08200_/A _08458_/X _08459_/Y VDD VSS sg13g2_o21ai_1
XFILLER_91_861 VDD VSS sg13g2_decap_4
XFILLER_63_552 VDD VSS sg13g2_decap_8
X_14396__1783 _14396_/RESET_B VDD VSS sg13g2_tiehi
XFILLER_35_265 VDD VSS sg13g2_decap_8
XFILLER_23_427 VDD VSS sg13g2_decap_8
XFILLER_17_980 VDD VSS sg13g2_decap_8
X_08391_ _08391_/Y _08391_/A _08391_/B VDD VSS sg13g2_nor2_1
XFILLER_16_490 VDD VSS sg13g2_decap_8
XFILLER_92_0 VDD VSS sg13g2_decap_8
XFILLER_17_1225 VDD VSS sg13g2_decap_8
XFILLER_149_635 VDD VSS sg13g2_decap_8
XFILLER_32_983 VDD VSS sg13g2_decap_8
XFILLER_31_471 VDD VSS sg13g2_fill_1
X_14016__2163 _14016_/RESET_B VDD VSS sg13g2_tiehi
XFILLER_12_28 VDD VSS sg13g2_decap_8
X_09012_ _09012_/Y _14902_/Q _09022_/D _09051_/A1 VDD VSS sg13g2_o21ai_1
XFILLER_128_28 VDD VSS sg13g2_decap_8
XFILLER_163_126 VDD VSS sg13g2_decap_8
XFILLER_129_381 VDD VSS sg13g2_decap_8
XFILLER_144_340 VDD VSS sg13g2_decap_8
XFILLER_145_874 VDD VSS sg13g2_decap_8
XFILLER_105_716 VDD VSS sg13g2_fill_1
XFILLER_172_660 VDD VSS sg13g2_decap_4
XFILLER_117_576 VDD VSS sg13g2_fill_1
XFILLER_104_204 VDD VSS sg13g2_decap_4
X_13661__1424 _13661_/RESET_B VDD VSS sg13g2_tiehi
XFILLER_117_598 VDD VSS sg13g2_fill_2
X_13884__2295 _13884_/RESET_B VDD VSS sg13g2_tiehi
Xfanout602 _10794_/A2 _10735_/A VDD VSS sg13g2_buf_1
X_09914_ _14499_/D _14499_/Q _09914_/A1 _09936_/S VDD VSS sg13g2_mux2_1
Xfanout613 _08931_/S _08955_/S VDD VSS sg13g2_buf_1
XFILLER_28_1343 VDD VSS sg13g2_decap_8
Xfanout624 _13427_/A _13407_/A VDD VSS sg13g2_buf_1
XFILLER_99_983 VDD VSS sg13g2_decap_8
XFILLER_144_49 VDD VSS sg13g2_decap_8
Xfanout635 _08692_/A _07996_/X VDD VSS sg13g2_buf_1
XFILLER_86_611 VDD VSS sg13g2_fill_2
XFILLER_58_302 VDD VSS sg13g2_fill_2
Xfanout646 _13282_/A1 _12791_/C1 VDD VSS sg13g2_buf_1
XFILLER_98_482 VDD VSS sg13g2_decap_8
XFILLER_115_1335 VDD VSS sg13g2_fill_1
Xfanout657 _13207_/C1 _07727_/Y VDD VSS sg13g2_buf_1
X_09845_ _14432_/D _14432_/Q _10043_/A0 _09867_/S VDD VSS sg13g2_mux2_1
XFILLER_24_1218 VDD VSS sg13g2_decap_8
Xfanout668 _11154_/B1 _11183_/B1 VDD VSS sg13g2_buf_1
Xfanout679 _07684_/B _11340_/A1 VDD VSS sg13g2_buf_1
XFILLER_37_14 VDD VSS sg13g2_decap_8
X_09776_ _14365_/D _09908_/A1 _14365_/Q _09799_/S VDD VSS sg13g2_mux2_1
XFILLER_86_688 VDD VSS sg13g2_fill_2
XFILLER_85_165 VDD VSS sg13g2_decap_8
XFILLER_74_839 VDD VSS sg13g2_decap_8
XFILLER_85_176 VDD VSS sg13g2_fill_1
XFILLER_113_1070 VDD VSS sg13g2_decap_8
XFILLER_6_1183 VDD VSS sg13g2_decap_8
X_08727_ _08727_/X _15129_/Q _15124_/Q _15071_/Q _08727_/D VDD VSS sg13g2_or4_1
XFILLER_85_198 VDD VSS sg13g2_fill_2
XFILLER_170_7 VDD VSS sg13g2_decap_8
XFILLER_96_1021 VDD VSS sg13g2_decap_8
XFILLER_2_1036 VDD VSS sg13g2_decap_8
XFILLER_26_210 VDD VSS sg13g2_decap_8
XFILLER_15_917 VDD VSS sg13g2_decap_8
X_14226__1953 _14226_/RESET_B VDD VSS sg13g2_tiehi
X_08658_ _08659_/C _08029_/Y _08591_/X _08511_/X _08599_/A _08657_/Y VDD VSS sg13g2_a221oi_1
XFILLER_42_714 VDD VSS sg13g2_decap_8
XFILLER_81_360 VDD VSS sg13g2_fill_1
XFILLER_109_1106 VDD VSS sg13g2_fill_1
XFILLER_148_1155 VDD VSS sg13g2_decap_8
XFILLER_82_894 VDD VSS sg13g2_fill_1
XFILLER_14_427 VDD VSS sg13g2_decap_8
XFILLER_96_1098 VDD VSS sg13g2_fill_1
XFILLER_53_35 VDD VSS sg13g2_decap_8
XFILLER_168_900 VDD VSS sg13g2_decap_8
X_15201__2969 _15201_/RESET_B VDD VSS sg13g2_tiehi
X_08589_ _08596_/B _08600_/A _08252_/Y _08676_/B2 VDD VSS sg13g2_o21ai_1
XFILLER_169_35 VDD VSS sg13g2_decap_8
X_10620_ _10623_/B _10651_/D _10622_/C _14882_/Q VDD VSS sg13g2_a21oi_1
XFILLER_35_1336 VDD VSS sg13g2_decap_8
XFILLER_161_1366 VDD VSS sg13g2_fill_1
X_10551_ _14865_/D _14865_/Q _10556_/D _10550_/Y VDD VSS sg13g2_a21oi_1
XFILLER_10_644 VDD VSS sg13g2_decap_8
XFILLER_167_476 VDD VSS sg13g2_decap_8
XFILLER_155_627 VDD VSS sg13g2_decap_8
X_13270_ _13271_/B _13270_/A _13270_/B _13270_/C VDD VSS sg13g2_nand3_1
X_10482_ _14848_/D _10482_/A _10481_/Y VDD VSS sg13g2_nor2b_1
XFILLER_154_126 VDD VSS sg13g2_decap_8
XFILLER_6_637 VDD VSS sg13g2_decap_8
XFILLER_108_543 VDD VSS sg13g2_fill_1
XFILLER_136_852 VDD VSS sg13g2_decap_8
X_12221_ _12221_/Y _12291_/A _12220_/Y _12221_/B1 VDD VSS sg13g2_o21ai_1
XFILLER_136_863 VDD VSS sg13g2_decap_4
XFILLER_5_147 VDD VSS sg13g2_decap_8
X_12152_ _12153_/B _12152_/A _13666_/Q VDD VSS sg13g2_nand2_1
XFILLER_29_1107 VDD VSS sg13g2_decap_8
XFILLER_159_1284 VDD VSS sg13g2_fill_1
XFILLER_78_21 VDD VSS sg13g2_decap_8
XFILLER_135_395 VDD VSS sg13g2_decap_8
X_11103_ _11118_/D _11125_/A _11115_/B VDD VSS sg13g2_xnor2_1
XFILLER_111_708 VDD VSS sg13g2_decap_4
X_13714__2465 _13714_/RESET_B VDD VSS sg13g2_tiehi
XFILLER_2_854 VDD VSS sg13g2_decap_8
X_12083_ _12198_/A _12084_/A _13668_/Q VDD VSS sg13g2_nor2_1
XFILLER_77_600 VDD VSS sg13g2_decap_4
XFILLER_1_364 VDD VSS sg13g2_decap_8
X_11034_ _11034_/Y _15117_/Q _11042_/D _11023_/Y VDD VSS sg13g2_a21oi_1
XFILLER_77_633 VDD VSS sg13g2_fill_2
XFILLER_134_60 VDD VSS sg13g2_decap_8
XFILLER_92_603 VDD VSS sg13g2_decap_8
XFILLER_94_42 VDD VSS sg13g2_decap_8
XFILLER_76_165 VDD VSS sg13g2_decap_8
XFILLER_18_700 VDD VSS sg13g2_decap_8
Xclkbuf_5_2__f_clk_i clkbuf_leaf_8_clk_i/A clkbuf_4_1_0_clk_i/X VDD VSS sg13g2_buf_16
XFILLER_91_102 VDD VSS sg13g2_decap_8
XFILLER_92_647 VDD VSS sg13g2_decap_8
XFILLER_131_1181 VDD VSS sg13g2_fill_1
XFILLER_17_210 VDD VSS sg13g2_decap_8
X_12985_ _13009_/A _14906_/Q _13681_/Q VDD VSS sg13g2_nand2_1
XFILLER_45_530 VDD VSS sg13g2_decap_8
X_14724_ _14724_/Q clkload17/A _14724_/D _14724_/RESET_B VDD VSS sg13g2_dfrbpq_1
X_15185__2811 _15185_/RESET_B VDD VSS sg13g2_tiehi
XFILLER_18_777 VDD VSS sg13g2_decap_8
X_11936_ _12055_/B _11936_/A _13129_/B VDD VSS sg13g2_xnor2_1
XFILLER_27_91 VDD VSS sg13g2_decap_8
XFILLER_150_70 VDD VSS sg13g2_fill_2
XFILLER_79_1296 VDD VSS sg13g2_decap_8
XFILLER_17_287 VDD VSS sg13g2_decap_8
XFILLER_127_1217 VDD VSS sg13g2_decap_4
XFILLER_33_747 VDD VSS sg13g2_decap_8
X_14655_ _14655_/Q _14733_/CLK _14655_/D _14655_/RESET_B VDD VSS sg13g2_dfrbpq_1
X_11867_ _11868_/C _11867_/A _11867_/B _11910_/C VDD VSS sg13g2_nand3_1
XFILLER_32_235 VDD VSS sg13g2_fill_2
X_13606_ _13606_/Y _12801_/Y _13600_/Y _08830_/X VDD VSS sg13g2_o21ai_1
X_10818_ _10818_/Y _10818_/A _10818_/B VDD VSS sg13g2_nor2_1
X_14586_ _14586_/Q clkload41/A _14586_/D _14586_/RESET_B VDD VSS sg13g2_dfrbpq_1
XFILLER_14_994 VDD VSS sg13g2_decap_8
X_11798_ _12056_/A _11798_/A _13676_/Q VDD VSS sg13g2_xor2_1
XFILLER_159_966 VDD VSS sg13g2_decap_8
XFILLER_9_420 VDD VSS sg13g2_decap_8
XFILLER_41_780 VDD VSS sg13g2_fill_2
X_13537_ _13537_/X _14994_/Q _13566_/C VDD VSS sg13g2_and2_1
X_10749_ _11068_/B _14946_/Q _10794_/A2 _10747_/Y VDD VSS sg13g2_a21o_1
XFILLER_158_487 VDD VSS sg13g2_fill_1
XFILLER_139_690 VDD VSS sg13g2_fill_2
X_13468_ wire513/A _15173_/Q _15174_/Q _15175_/Q _13468_/D VDD VSS sg13g2_nor4_1
XFILLER_9_497 VDD VSS sg13g2_decap_8
XFILLER_12_1155 VDD VSS sg13g2_decap_8
XFILLER_161_608 VDD VSS sg13g2_decap_8
X_15207_ _15207_/Q clkload71/A _15207_/D _15207_/RESET_B VDD VSS sg13g2_dfrbpq_1
X_12419_ _12419_/X _13952_/Q _13984_/Q _14016_/Q _14048_/Q _12450_/S0 _12450_/S1 VDD
+ VSS sg13g2_mux4_1
XFILLER_103_1283 VDD VSS sg13g2_decap_8
XFILLER_142_811 VDD VSS sg13g2_decap_8
X_13399_ _15087_/D _13455_/A _13396_/D _13398_/Y VDD VSS sg13g2_o21ai_1
XFILLER_126_362 VDD VSS sg13g2_fill_1
X_14855__2834 _14855_/RESET_B VDD VSS sg13g2_tiehi
X_15138_ _15138_/Q clkload60/A _15138_/D _15138_/RESET_B VDD VSS sg13g2_dfrbpq_1
XFILLER_114_557 VDD VSS sg13g2_fill_1
XFILLER_141_343 VDD VSS sg13g2_decap_4
X_14304__1875 _14304_/RESET_B VDD VSS sg13g2_tiehi
X_15069_ _15069_/Q _15183_/CLK _15069_/D _15069_/RESET_B VDD VSS sg13g2_dfrbpq_1
X_07960_ _07960_/Y _08434_/B _07906_/B _07959_/Y VDD VSS sg13g2_a21oi_1
XFILLER_4_84 VDD VSS sg13g2_decap_8
X_07891_ _07917_/B _08142_/C _08452_/C VDD VSS sg13g2_nor2_1
X_14888__2768 _14888_/RESET_B VDD VSS sg13g2_tiehi
X_09630_ _14226_/D _09630_/A0 _14226_/Q _09638_/S VDD VSS sg13g2_mux2_1
XFILLER_68_688 VDD VSS sg13g2_decap_8
XFILLER_3_1323 VDD VSS sg13g2_decap_8
XFILLER_23_1251 VDD VSS sg13g2_decap_8
X_13869__2310 _13869_/RESET_B VDD VSS sg13g2_tiehi
X_09561_ _14159_/D _09959_/A1 _14159_/Q _09563_/S VDD VSS sg13g2_mux2_1
XFILLER_55_338 VDD VSS sg13g2_decap_8
X_08512_ _08512_/Y _08560_/A _08339_/Y _08539_/B1 VDD VSS sg13g2_a21oi_1
X_09492_ _14092_/D _10088_/A0 _14092_/Q _09494_/S VDD VSS sg13g2_mux2_1
XFILLER_58_1336 VDD VSS sg13g2_decap_8
XFILLER_110_1298 VDD VSS sg13g2_decap_4
XFILLER_169_708 VDD VSS sg13g2_decap_4
XFILLER_19_1309 VDD VSS sg13g2_decap_8
X_14773__2940 _14773_/RESET_B VDD VSS sg13g2_tiehi
X_08443_ _08443_/Y _08443_/A _08443_/B VDD VSS sg13g2_nor2_1
XFILLER_58_1369 VDD VSS sg13g2_decap_8
XFILLER_23_224 VDD VSS sg13g2_decap_8
X_08374_ _08374_/Y _08617_/A _08374_/B VDD VSS sg13g2_nor2_1
XFILLER_17_1022 VDD VSS sg13g2_decap_8
XFILLER_23_49 VDD VSS sg13g2_decap_8
XFILLER_20_931 VDD VSS sg13g2_decap_8
XFILLER_104_1025 VDD VSS sg13g2_fill_2
XFILLER_143_1074 VDD VSS sg13g2_fill_1
XFILLER_165_925 VDD VSS sg13g2_decap_4
XFILLER_139_49 VDD VSS sg13g2_decap_8
XFILLER_143_1085 VDD VSS sg13g2_fill_1
XFILLER_164_413 VDD VSS sg13g2_decap_8
XFILLER_17_1099 VDD VSS sg13g2_decap_8
XFILLER_137_638 VDD VSS sg13g2_fill_1
XFILLER_30_1233 VDD VSS sg13g2_decap_8
XFILLER_117_340 VDD VSS sg13g2_decap_8
XFILLER_145_660 VDD VSS sg13g2_decap_8
X_13971__2208 _13971_/RESET_B VDD VSS sg13g2_tiehi
XFILLER_145_671 VDD VSS sg13g2_fill_1
XFILLER_132_321 VDD VSS sg13g2_decap_8
XFILLER_133_855 VDD VSS sg13g2_decap_4
XFILLER_160_652 VDD VSS sg13g2_fill_1
Xfanout410 _12415_/A _12400_/A VDD VSS sg13g2_buf_1
Xfanout1408 _13440_/B fanout1413/X VDD VSS sg13g2_buf_1
XFILLER_28_1140 VDD VSS sg13g2_decap_8
Xfanout432 _09831_/S _09837_/S VDD VSS sg13g2_buf_1
XFILLER_59_622 VDD VSS sg13g2_decap_8
Xfanout443 _09667_/S _09673_/S VDD VSS sg13g2_buf_1
XFILLER_48_35 VDD VSS sg13g2_decap_8
Xfanout454 _09539_/S _09507_/Y VDD VSS sg13g2_buf_1
XFILLER_87_953 VDD VSS sg13g2_fill_2
XFILLER_171_14 VDD VSS sg13g2_decap_8
Xfanout465 _09407_/S _09375_/Y VDD VSS sg13g2_buf_1
XFILLER_8_1267 VDD VSS sg13g2_decap_8
XFILLER_58_132 VDD VSS sg13g2_decap_8
XFILLER_47_806 VDD VSS sg13g2_fill_2
Xfanout476 _09226_/S _09233_/S VDD VSS sg13g2_buf_1
Xfanout487 _08855_/S _08834_/X VDD VSS sg13g2_buf_1
X_09828_ _14416_/D _09828_/A0 _14416_/Q _09829_/S VDD VSS sg13g2_mux2_1
Xfanout498 _13499_/A _13502_/A VDD VSS sg13g2_buf_1
XFILLER_86_496 VDD VSS sg13g2_decap_8
XFILLER_41_1362 VDD VSS sg13g2_decap_8
X_14459__1720 _14459_/RESET_B VDD VSS sg13g2_tiehi
X_09759_ _14349_/D _14349_/Q _09924_/A1 _09763_/S VDD VSS sg13g2_mux2_1
XFILLER_27_530 VDD VSS sg13g2_fill_2
XFILLER_104_96 VDD VSS sg13g2_fill_1
XFILLER_15_714 VDD VSS sg13g2_decap_8
X_12770_ _12770_/X _14137_/Q _14169_/Q _14201_/Q _14233_/Q _12771_/S0 _12771_/S1 VDD
+ VSS sg13g2_mux4_1
XFILLER_14_224 VDD VSS sg13g2_decap_8
X_11721_ _11721_/Y _14908_/Q _11433_/B _11722_/B2 VDD VSS sg13g2_a21oi_1
X_14440_ _14440_/Q _14512_/CLK _14440_/D _14440_/RESET_B VDD VSS sg13g2_dfrbpq_1
XFILLER_42_577 VDD VSS sg13g2_decap_8
X_11652_ _11652_/X _11644_/X _11645_/X _11648_/X _11649_/X _12188_/C _11559_/C VDD
+ VSS sg13g2_mux4_1
XFILLER_126_1250 VDD VSS sg13g2_decap_8
XFILLER_35_1133 VDD VSS sg13g2_decap_8
XFILLER_11_931 VDD VSS sg13g2_decap_8
XFILLER_74_1193 VDD VSS sg13g2_decap_4
XFILLER_35_1144 VDD VSS sg13g2_fill_1
X_10603_ _10608_/C _14877_/Q _10610_/D _14878_/Q VDD VSS sg13g2_a21oi_1
XFILLER_80_55 VDD VSS sg13g2_fill_2
X_14371_ _14371_/Q clkload16/A _14371_/D _14371_/RESET_B VDD VSS sg13g2_dfrbpq_1
XFILLER_126_1283 VDD VSS sg13g2_decap_8
X_11583_ _11583_/X _11575_/X _11576_/X _11579_/X _11580_/X _11964_/B _11999_/S1 VDD
+ VSS sg13g2_mux4_1
XFILLER_35_1166 VDD VSS sg13g2_fill_2
XFILLER_10_441 VDD VSS sg13g2_decap_8
XFILLER_35_1177 VDD VSS sg13g2_decap_4
XFILLER_167_273 VDD VSS sg13g2_decap_8
XFILLER_7_924 VDD VSS sg13g2_decap_8
XFILLER_35_1188 VDD VSS sg13g2_decap_8
XFILLER_155_424 VDD VSS sg13g2_decap_8
X_13322_ _15064_/D _13322_/A _13322_/B VDD VSS sg13g2_nand2_1
X_10534_ _10535_/B _14860_/Q _14859_/Q _10558_/B _10543_/C VDD VSS sg13g2_nand4_1
XFILLER_122_1169 VDD VSS sg13g2_decap_8
XFILLER_6_434 VDD VSS sg13g2_decap_8
XFILLER_155_457 VDD VSS sg13g2_decap_8
XFILLER_143_608 VDD VSS sg13g2_decap_4
X_13253_ _13253_/Y _13297_/A0 _13251_/Y _13252_/X _13253_/B2 VDD VSS sg13g2_a22oi_1
X_10465_ _10468_/B _10471_/C _10471_/D _10500_/A VDD VSS sg13g2_a21oi_1
XFILLER_171_928 VDD VSS sg13g2_fill_1
XFILLER_136_671 VDD VSS sg13g2_fill_1
XFILLER_89_42 VDD VSS sg13g2_decap_8
XFILLER_170_427 VDD VSS sg13g2_decap_8
X_14561__1618 _14561_/RESET_B VDD VSS sg13g2_tiehi
X_13947__2232 _13947_/RESET_B VDD VSS sg13g2_tiehi
X_12204_ _12204_/Y _12204_/A _12272_/A VDD VSS sg13g2_xnor2_1
XFILLER_163_490 VDD VSS sg13g2_decap_8
X_13184_ _15045_/D _13324_/A _13184_/B VDD VSS sg13g2_nor2_1
X_10396_ _10397_/C _14818_/Q _14819_/Q _10396_/C _10396_/D VDD VSS sg13g2_nand4_1
XFILLER_151_641 VDD VSS sg13g2_decap_4
XFILLER_159_1092 VDD VSS sg13g2_decap_8
X_12135_ _12135_/X _13845_/Q _13877_/Q _13909_/Q _13941_/Q _12138_/S0 _12137_/S1 VDD
+ VSS sg13g2_mux4_1
XFILLER_2_651 VDD VSS sg13g2_decap_8
XFILLER_124_899 VDD VSS sg13g2_fill_1
XFILLER_150_173 VDD VSS sg13g2_fill_2
XFILLER_1_161 VDD VSS sg13g2_decap_8
XFILLER_123_398 VDD VSS sg13g2_decap_8
XFILLER_145_92 VDD VSS sg13g2_decap_8
X_12066_ _12066_/X _14131_/Q _14163_/Q _14195_/Q _14227_/Q _12073_/S0 _12073_/S1 VDD
+ VSS sg13g2_mux4_1
XFILLER_42_1115 VDD VSS sg13g2_fill_1
XFILLER_29_7 VDD VSS sg13g2_decap_8
XFILLER_133_1243 VDD VSS sg13g2_decap_8
XFILLER_38_806 VDD VSS sg13g2_fill_1
X_11017_ _11017_/Y _11027_/B1 _11016_/Y _11044_/C VDD VSS sg13g2_o21ai_1
X_16874_ _16874_/X _16874_/A VDD VSS sg13g2_buf_1
XFILLER_38_828 VDD VSS sg13g2_decap_8
XFILLER_133_1287 VDD VSS sg13g2_fill_1
XFILLER_92_411 VDD VSS sg13g2_decap_8
XFILLER_64_102 VDD VSS sg13g2_fill_1
XFILLER_77_496 VDD VSS sg13g2_decap_8
XFILLER_93_967 VDD VSS sg13g2_decap_4
XFILLER_161_91 VDD VSS sg13g2_decap_8
XFILLER_64_157 VDD VSS sg13g2_decap_8
XFILLER_46_861 VDD VSS sg13g2_decap_8
X_12968_ _12968_/Y input22/X _12795_/Y _12937_/Y VDD VSS sg13g2_o21ai_1
XFILLER_33_500 VDD VSS sg13g2_decap_8
XFILLER_18_574 VDD VSS sg13g2_decap_8
XFILLER_33_511 VDD VSS sg13g2_fill_1
X_14707_ _14707_/Q clkload25/A _14707_/D _14707_/RESET_B VDD VSS sg13g2_dfrbpq_1
X_11919_ _11919_/X _13743_/Q _14095_/Q _14447_/Q _14543_/Q _11925_/S0 _11925_/S1 VDD
+ VSS sg13g2_mux4_1
XFILLER_166_1063 VDD VSS sg13g2_decap_8
X_12899_ _12902_/C _13601_/A _12900_/C _12899_/C input27/X VDD VSS sg13g2_nand4_1
XFILLER_33_577 VDD VSS sg13g2_decap_8
X_14638_ _14638_/Q clkload39/A _14638_/D _14638_/RESET_B VDD VSS sg13g2_dfrbpq_1
XFILLER_21_728 VDD VSS sg13g2_decap_8
XFILLER_14_791 VDD VSS sg13g2_decap_8
XFILLER_53_1244 VDD VSS sg13g2_decap_8
XFILLER_140_1203 VDD VSS sg13g2_fill_2
X_14761__2955 _14761_/RESET_B VDD VSS sg13g2_tiehi
XFILLER_20_238 VDD VSS sg13g2_decap_8
X_14569_ _14569_/Q clkload21/A _14569_/D _14569_/RESET_B VDD VSS sg13g2_dfrbpq_1
XFILLER_14_1239 VDD VSS sg13g2_decap_8
XFILLER_146_424 VDD VSS sg13g2_fill_2
XFILLER_158_284 VDD VSS sg13g2_decap_8
X_08090_ _08090_/Y _13427_/C _08090_/B _08090_/C VDD VSS sg13g2_nor3_1
XFILLER_119_649 VDD VSS sg13g2_fill_2
Xclkload20 clkload20/Y clkload20/A VDD VSS sg13g2_inv_2
XFILLER_9_294 VDD VSS sg13g2_decap_8
XFILLER_162_917 VDD VSS sg13g2_decap_8
Xclkload31 clkload31/Y clkload31/A VDD VSS sg13g2_inv_1
Xclkload42 clkload42/Y clkload42/A VDD VSS sg13g2_inv_2
Xclkload53 clkload53/Y clkload53/A VDD VSS sg13g2_inv_2
XFILLER_127_671 VDD VSS sg13g2_decap_8
Xclkload64 clkload64/Y clkload64/A VDD VSS sg13g2_inv_2
XFILLER_55_0 VDD VSS sg13g2_decap_8
XFILLER_173_287 VDD VSS sg13g2_decap_8
X_14537__1642 _14537_/RESET_B VDD VSS sg13g2_tiehi
XFILLER_86_1053 VDD VSS sg13g2_fill_2
XFILLER_114_343 VDD VSS sg13g2_decap_8
XFILLER_142_652 VDD VSS sg13g2_fill_2
XFILLER_170_961 VDD VSS sg13g2_fill_2
XFILLER_115_877 VDD VSS sg13g2_decap_8
X_15105__2751 _15105_/RESET_B VDD VSS sg13g2_tiehi
XFILLER_47_1037 VDD VSS sg13g2_decap_8
XFILLER_142_674 VDD VSS sg13g2_fill_2
XFILLER_102_516 VDD VSS sg13g2_decap_4
Xclkbuf_leaf_120_clk_i clkload9/A clkbuf_5_4__f_clk_i/X VDD VSS sg13g2_buf_8
X_08992_ _08992_/Y _08992_/A _08992_/B _10697_/B VDD VSS sg13g2_nand3_1
XFILLER_64_1340 VDD VSS sg13g2_fill_1
X_15200__2968 _15200_/RESET_B VDD VSS sg13g2_tiehi
XFILLER_25_1302 VDD VSS sg13g2_decap_8
XFILLER_141_184 VDD VSS sg13g2_decap_8
X_07943_ _08434_/B _07797_/X _07927_/Y _07942_/Y VDD VSS sg13g2_o21ai_1
XFILLER_87_249 VDD VSS sg13g2_fill_2
XFILLER_151_1354 VDD VSS sg13g2_fill_2
XFILLER_96_761 VDD VSS sg13g2_decap_8
X_07874_ _07876_/B _07910_/B _14994_/Q VDD VSS sg13g2_nand2_1
XFILLER_84_934 VDD VSS sg13g2_fill_1
XFILLER_25_1379 VDD VSS sg13g2_decap_4
XFILLER_68_496 VDD VSS sg13g2_fill_2
X_09613_ _14209_/D _09945_/A1 _14209_/Q _09634_/S VDD VSS sg13g2_mux2_1
XFILLER_84_956 VDD VSS sg13g2_decap_4
XFILLER_18_49 VDD VSS sg13g2_decap_8
XFILLER_141_28 VDD VSS sg13g2_decap_8
XFILLER_3_1120 VDD VSS sg13g2_decap_8
XFILLER_83_444 VDD VSS sg13g2_decap_8
XFILLER_37_850 VDD VSS sg13g2_fill_1
XFILLER_37_861 VDD VSS sg13g2_fill_1
X_09544_ _14142_/D _09610_/A0 _14142_/Q _09566_/S VDD VSS sg13g2_mux2_1
XFILLER_97_1160 VDD VSS sg13g2_decap_8
XFILLER_43_319 VDD VSS sg13g2_decap_8
XFILLER_83_499 VDD VSS sg13g2_decap_8
XFILLER_37_894 VDD VSS sg13g2_decap_8
XFILLER_58_1133 VDD VSS sg13g2_decap_8
XFILLER_3_1197 VDD VSS sg13g2_decap_8
XFILLER_97_1193 VDD VSS sg13g2_decap_8
XFILLER_24_522 VDD VSS sg13g2_decap_4
XFILLER_19_1106 VDD VSS sg13g2_decap_8
X_09475_ _14075_/D _09574_/A1 _14075_/Q _09494_/S VDD VSS sg13g2_mux2_1
X_13685__2502 _13685_/RESET_B VDD VSS sg13g2_tiehi
XFILLER_54_1019 VDD VSS sg13g2_decap_8
X_08426_ _08429_/C _08426_/A _08426_/B VDD VSS sg13g2_nor2_1
XFILLER_12_728 VDD VSS sg13g2_decap_8
XFILLER_145_1158 VDD VSS sg13g2_decap_4
XFILLER_11_238 VDD VSS sg13g2_decap_8
XFILLER_133_7 VDD VSS sg13g2_decap_8
X_08357_ _08357_/Y _14971_/Q _15003_/Q _08674_/B1 VDD VSS sg13g2_o21ai_1
XFILLER_149_251 VDD VSS sg13g2_fill_1
Xclkload3 clkload3/Y clkload3/A VDD VSS sg13g2_inv_2
XFILLER_50_14 VDD VSS sg13g2_decap_8
XFILLER_164_210 VDD VSS sg13g2_decap_8
XFILLER_165_733 VDD VSS sg13g2_decap_8
XFILLER_166_14 VDD VSS sg13g2_decap_8
X_08288_ _08315_/C _08867_/A1 _14998_/Q _08300_/A3 _08263_/B VDD VSS sg13g2_a22oi_1
XFILLER_165_777 VDD VSS sg13g2_decap_8
XFILLER_30_1041 VDD VSS sg13g2_fill_1
XFILLER_124_107 VDD VSS sg13g2_fill_2
XFILLER_153_939 VDD VSS sg13g2_fill_1
XFILLER_164_287 VDD VSS sg13g2_decap_8
XFILLER_4_938 VDD VSS sg13g2_decap_8
X_10250_ _10258_/D _14776_/Q _14777_/Q _14778_/Q _10250_/D VDD VSS sg13g2_and4_1
XFILLER_145_490 VDD VSS sg13g2_fill_2
XFILLER_3_448 VDD VSS sg13g2_decap_8
XFILLER_69_1295 VDD VSS sg13g2_decap_8
XFILLER_65_1126 VDD VSS sg13g2_decap_8
X_10181_ _10181_/Y _13613_/A _13508_/B _10174_/Y _13613_/B VDD VSS sg13g2_a22oi_1
XFILLER_160_471 VDD VSS sg13g2_decap_8
XFILLER_156_1287 VDD VSS sg13g2_decap_8
Xfanout1205 _10511_/D _14843_/Q VDD VSS sg13g2_buf_1
XFILLER_120_324 VDD VSS sg13g2_fill_2
XFILLER_117_1249 VDD VSS sg13g2_fill_1
Xfanout1216 _13064_/B _13677_/Q VDD VSS sg13g2_buf_1
Xfanout1227 fanout1227/X _13661_/Q VDD VSS sg13g2_buf_1
Xfanout240 _11248_/B _11341_/A2 VDD VSS sg13g2_buf_1
Xfanout1238 _12291_/A _11450_/A1 VDD VSS sg13g2_buf_1
XFILLER_120_357 VDD VSS sg13g2_decap_8
Xfanout251 _09720_/A0 _10150_/A1 VDD VSS sg13g2_buf_1
Xfanout1249 _11995_/S1 _11852_/S1 VDD VSS sg13g2_buf_1
Xfanout262 _10064_/S _10068_/S VDD VSS sg13g2_buf_1
X_13940_ _13940_/Q _14516_/CLK _13940_/D _13940_/RESET_B VDD VSS sg13g2_dfrbpq_1
Xfanout273 _09601_/S _09604_/S VDD VSS sg13g2_buf_1
XFILLER_8_1064 VDD VSS sg13g2_decap_8
XFILLER_115_73 VDD VSS sg13g2_decap_8
Xclkbuf_5_20__f_clk_i clkbuf_leaf_97_clk_i/A clkbuf_4_10_0_clk_i/X VDD VSS sg13g2_buf_16
Xfanout284 _10148_/A1 _09025_/X VDD VSS sg13g2_buf_1
Xfanout295 _09448_/A0 _10144_/A1 VDD VSS sg13g2_buf_1
XFILLER_75_945 VDD VSS sg13g2_decap_8
X_13871_ _13871_/Q _14735_/CLK _13871_/D _13871_/RESET_B VDD VSS sg13g2_dfrbpq_1
XFILLER_46_135 VDD VSS sg13g2_decap_4
XFILLER_41_1181 VDD VSS sg13g2_fill_2
X_12822_ _12822_/X _14895_/Q _12836_/B VDD VSS sg13g2_xor2_1
XFILLER_75_99 VDD VSS sg13g2_decap_8
XFILLER_61_105 VDD VSS sg13g2_fill_1
XFILLER_15_511 VDD VSS sg13g2_decap_8
XFILLER_61_116 VDD VSS sg13g2_decap_8
XFILLER_27_382 VDD VSS sg13g2_decap_8
XFILLER_91_21 VDD VSS sg13g2_decap_8
XFILLER_167_1372 VDD VSS sg13g2_decap_8
X_12753_ _12753_/X _14712_/Q _14744_/Q _13784_/Q _13816_/Q _12757_/S0 _12757_/S1 VDD
+ VSS sg13g2_mux4_1
XFILLER_163_1214 VDD VSS sg13g2_decap_8
XFILLER_128_1334 VDD VSS sg13g2_fill_1
XFILLER_163_1225 VDD VSS sg13g2_fill_1
XFILLER_42_352 VDD VSS sg13g2_decap_8
X_11704_ _11707_/A _11663_/B _11771_/B _11771_/A VDD VSS sg13g2_a21o_1
XFILLER_15_588 VDD VSS sg13g2_decap_8
X_14615__1564 _14615_/RESET_B VDD VSS sg13g2_tiehi
XFILLER_42_363 VDD VSS sg13g2_fill_1
X_12684_ _12684_/X _14131_/Q _14163_/Q _14195_/Q _14227_/Q _12689_/S0 _12689_/S1 VDD
+ VSS sg13g2_mux4_1
XFILLER_42_396 VDD VSS sg13g2_decap_8
X_14423_ _14423_/Q clkload27/A _14423_/D _14423_/RESET_B VDD VSS sg13g2_dfrbpq_1
X_11635_ _11773_/A _11635_/A _13681_/Q VDD VSS sg13g2_xnor2_1
XFILLER_24_70 VDD VSS sg13g2_decap_8
XFILLER_168_560 VDD VSS sg13g2_decap_8
XFILLER_128_424 VDD VSS sg13g2_decap_8
X_14354_ _14354_/Q _14632_/CLK _14354_/D _14354_/RESET_B VDD VSS sg13g2_dfrbpq_1
XFILLER_7_721 VDD VSS sg13g2_decap_8
X_11566_ _14966_/D _11566_/A _11566_/B VDD VSS sg13g2_nor2_1
XFILLER_156_766 VDD VSS sg13g2_fill_1
X_13305_ _13306_/C _13305_/A _13305_/B VDD VSS sg13g2_nor2_1
XFILLER_6_231 VDD VSS sg13g2_decap_8
X_10517_ _10519_/B _10453_/C _10521_/D _14855_/Q VDD VSS sg13g2_a21oi_1
XFILLER_143_405 VDD VSS sg13g2_decap_8
X_14285_ _14285_/Q clkload10/A _14285_/D _14285_/RESET_B VDD VSS sg13g2_dfrbpq_1
X_11497_ _11497_/Y _11446_/A _11495_/Y _12292_/A VDD VSS sg13g2_a21oi_1
XFILLER_7_798 VDD VSS sg13g2_decap_8
XFILLER_171_736 VDD VSS sg13g2_decap_8
XFILLER_171_747 VDD VSS sg13g2_fill_2
XFILLER_170_224 VDD VSS sg13g2_decap_8
X_13236_ _13236_/Y _14795_/Q _13236_/A2 _13236_/B1 VDD VSS sg13g2_o21ai_1
XFILLER_136_490 VDD VSS sg13g2_decap_4
X_10448_ _10450_/B _10453_/C _10514_/A _14839_/Q VDD VSS sg13g2_a21oi_1
XFILLER_48_1335 VDD VSS sg13g2_decap_8
XFILLER_174_1332 VDD VSS sg13g2_decap_8
XFILLER_174_1343 VDD VSS sg13g2_decap_8
XFILLER_156_91 VDD VSS sg13g2_decap_8
XFILLER_97_503 VDD VSS sg13g2_decap_4
XFILLER_83_1237 VDD VSS sg13g2_decap_8
X_13167_ _15044_/D _13160_/Y _13166_/Y _13155_/A VDD VSS sg13g2_a21oi_1
X_10379_ _14817_/D _10379_/A _10633_/A _10379_/C VDD VSS sg13g2_nor3_1
XFILLER_48_1368 VDD VSS sg13g2_decap_8
XFILLER_123_184 VDD VSS sg13g2_decap_8
X_12118_ _12118_/Y _12116_/Y _12118_/B _12118_/C VDD VSS sg13g2_nand3b_1
X_13098_ _13098_/X input13/X _13205_/A2 _13205_/B1 VDD VSS sg13g2_a21o_1
Xclkbuf_leaf_52_clk_i clkload59/A clkbuf_leaf_52_clk_i/A VDD VSS sg13g2_buf_8
XFILLER_111_379 VDD VSS sg13g2_decap_8
X_12049_ _12049_/Y _12048_/Y _12192_/A _12292_/A VDD VSS sg13g2_a21oi_1
XFILLER_77_260 VDD VSS sg13g2_decap_8
XFILLER_93_742 VDD VSS sg13g2_fill_2
XFILLER_38_647 VDD VSS sg13g2_fill_2
XFILLER_77_293 VDD VSS sg13g2_decap_8
X_16857_ _16857_/X _16857_/A VDD VSS sg13g2_buf_1
XFILLER_93_753 VDD VSS sg13g2_decap_8
XFILLER_66_978 VDD VSS sg13g2_fill_1
XFILLER_168_1114 VDD VSS sg13g2_decap_8
XFILLER_1_63 VDD VSS sg13g2_decap_8
XFILLER_81_915 VDD VSS sg13g2_decap_8
XFILLER_20_1232 VDD VSS sg13g2_decap_8
XFILLER_19_861 VDD VSS sg13g2_decap_8
XFILLER_0_1304 VDD VSS sg13g2_decap_8
XFILLER_81_926 VDD VSS sg13g2_fill_1
XFILLER_92_263 VDD VSS sg13g2_decap_8
XFILLER_92_274 VDD VSS sg13g2_fill_1
XFILLER_52_105 VDD VSS sg13g2_decap_8
XFILLER_18_371 VDD VSS sg13g2_decap_8
Xclkbuf_leaf_67_clk_i _15183_/CLK clkbuf_leaf_83_clk_i/A VDD VSS sg13g2_buf_8
XFILLER_94_1344 VDD VSS sg13g2_decap_8
XFILLER_94_1355 VDD VSS sg13g2_fill_1
XFILLER_34_864 VDD VSS sg13g2_fill_2
XFILLER_90_1219 VDD VSS sg13g2_decap_8
X_09260_ _13869_/D _13869_/Q _10156_/A1 _09260_/S VDD VSS sg13g2_mux2_1
XFILLER_33_363 VDD VSS sg13g2_decap_8
XFILLER_21_525 VDD VSS sg13g2_decap_8
X_08211_ _15224_/D _08211_/A _08211_/B _08211_/C _08211_/D VDD VSS sg13g2_nand4_1
XFILLER_53_1030 VDD VSS sg13g2_decap_4
X_09191_ _13807_/D _13807_/Q _10125_/A0 _09193_/S VDD VSS sg13g2_mux2_1
XFILLER_18_1183 VDD VSS sg13g2_decap_8
XFILLER_140_1022 VDD VSS sg13g2_fill_1
XFILLER_144_1191 VDD VSS sg13g2_decap_8
XFILLER_14_1036 VDD VSS sg13g2_decap_8
X_08142_ _08142_/Y _08142_/A _08154_/A _08142_/C VDD VSS sg13g2_nand3_1
XFILLER_105_1164 VDD VSS sg13g2_fill_2
XFILLER_147_766 VDD VSS sg13g2_decap_4
XFILLER_162_703 VDD VSS sg13g2_fill_2
X_08073_ _08074_/C _08073_/A _08073_/B _08073_/C VDD VSS sg13g2_nand3_1
XFILLER_134_405 VDD VSS sg13g2_decap_8
XFILLER_140_1099 VDD VSS sg13g2_decap_8
XFILLER_88_1159 VDD VSS sg13g2_decap_8
XFILLER_31_1372 VDD VSS sg13g2_decap_8
XFILLER_20_28 VDD VSS sg13g2_decap_8
XFILLER_31_1383 VDD VSS sg13g2_fill_1
XFILLER_161_224 VDD VSS sg13g2_decap_8
XFILLER_136_28 VDD VSS sg13g2_decap_8
X_14053__2126 _14053_/RESET_B VDD VSS sg13g2_tiehi
XFILLER_115_652 VDD VSS sg13g2_decap_8
XFILLER_114_162 VDD VSS sg13g2_fill_1
XFILLER_130_633 VDD VSS sg13g2_decap_8
XFILLER_103_858 VDD VSS sg13g2_fill_1
X_08975_ _10675_/C _15220_/Q _13305_/A VDD VSS sg13g2_nor2b_1
XFILLER_9_1351 VDD VSS sg13g2_decap_8
XFILLER_69_750 VDD VSS sg13g2_decap_8
XFILLER_69_761 VDD VSS sg13g2_fill_2
XFILLER_64_1181 VDD VSS sg13g2_fill_1
XFILLER_5_1204 VDD VSS sg13g2_decap_8
XFILLER_116_1260 VDD VSS sg13g2_decap_8
X_07926_ _07926_/X _07926_/A _07926_/B VDD VSS sg13g2_or2_1
XFILLER_116_1271 VDD VSS sg13g2_fill_2
XFILLER_111_880 VDD VSS sg13g2_decap_8
XFILLER_152_49 VDD VSS sg13g2_decap_8
XFILLER_25_1176 VDD VSS sg13g2_decap_8
XFILLER_96_591 VDD VSS sg13g2_decap_8
XFILLER_99_1244 VDD VSS sg13g2_decap_8
X_07857_ _07857_/X _15014_/Q _07859_/B VDD VSS sg13g2_or2_1
XFILLER_60_1078 VDD VSS sg13g2_decap_8
XFILLER_21_1029 VDD VSS sg13g2_decap_8
X_15187__2803 _15187_/RESET_B VDD VSS sg13g2_tiehi
XFILLER_57_978 VDD VSS sg13g2_decap_8
XFILLER_56_455 VDD VSS sg13g2_fill_2
XFILLER_112_1179 VDD VSS sg13g2_decap_4
XFILLER_16_308 VDD VSS sg13g2_decap_8
XFILLER_72_926 VDD VSS sg13g2_decap_8
XFILLER_45_14 VDD VSS sg13g2_decap_8
XFILLER_56_477 VDD VSS sg13g2_decap_8
XFILLER_43_105 VDD VSS sg13g2_decap_8
XFILLER_28_179 VDD VSS sg13g2_fill_1
X_07788_ _07797_/C _08414_/A _08414_/B _08414_/D VDD VSS sg13g2_o21ai_1
XFILLER_71_436 VDD VSS sg13g2_decap_4
XFILLER_37_680 VDD VSS sg13g2_decap_4
XFILLER_83_296 VDD VSS sg13g2_fill_1
X_09527_ _14126_/D _09760_/A1 _14126_/Q _09533_/S VDD VSS sg13g2_mux2_1
XFILLER_71_458 VDD VSS sg13g2_fill_1
XFILLER_71_469 VDD VSS sg13g2_fill_1
XFILLER_24_341 VDD VSS sg13g2_decap_8
X_09458_ _14059_/D _09623_/A0 _14059_/Q _09464_/S VDD VSS sg13g2_mux2_1
XFILLER_101_64 VDD VSS sg13g2_fill_1
XFILLER_12_525 VDD VSS sg13g2_decap_8
XFILLER_169_357 VDD VSS sg13g2_decap_8
XFILLER_52_694 VDD VSS sg13g2_fill_1
XFILLER_101_86 VDD VSS sg13g2_decap_8
X_08409_ _08410_/B _08426_/A _08407_/Y _08408_/Y VDD VSS sg13g2_a21o_1
XFILLER_61_35 VDD VSS sg13g2_decap_8
XFILLER_71_1141 VDD VSS sg13g2_decap_4
X_09389_ _13992_/D _09853_/A1 _13992_/Q _09398_/S VDD VSS sg13g2_mux2_1
XFILLER_8_518 VDD VSS sg13g2_decap_8
XFILLER_32_1103 VDD VSS sg13g2_decap_8
XFILLER_123_1220 VDD VSS sg13g2_fill_1
X_14263__1916 _14263_/RESET_B VDD VSS sg13g2_tiehi
XFILLER_36_1283 VDD VSS sg13g2_fill_1
X_11420_ _11420_/Y _11420_/A _11420_/B _11743_/C VDD VSS sg13g2_nand3_1
XFILLER_126_917 VDD VSS sg13g2_decap_8
XFILLER_125_405 VDD VSS sg13g2_decap_8
XFILLER_165_574 VDD VSS sg13g2_decap_8
X_11351_ _11351_/Y _11347_/Y _11348_/Y _11350_/Y _11349_/Y _12092_/C VDD VSS sg13g2_a221oi_1
XFILLER_125_416 VDD VSS sg13g2_fill_2
X_10302_ _14794_/D _14794_/Q _10299_/Y _10301_/Y VDD VSS sg13g2_a21oi_1
XFILLER_4_735 VDD VSS sg13g2_decap_8
X_14070_ _14070_/Q clkload26/A _14070_/D _14070_/RESET_B VDD VSS sg13g2_dfrbpq_1
XFILLER_141_909 VDD VSS sg13g2_fill_2
XFILLER_153_769 VDD VSS sg13g2_decap_4
X_11282_ _11283_/A _13948_/Q _13980_/Q _14012_/Q _14044_/Q _12303_/S _12307_/C VDD
+ VSS sg13g2_mux4_1
XFILLER_106_652 VDD VSS sg13g2_decap_8
XFILLER_3_245 VDD VSS sg13g2_decap_8
XFILLER_134_972 VDD VSS sg13g2_decap_8
X_13021_ _15034_/D _13021_/A _13021_/B VDD VSS sg13g2_nor2_1
X_14029__2150 _14029_/RESET_B VDD VSS sg13g2_tiehi
X_10233_ _10237_/D _14772_/Q _14773_/Q VDD VSS sg13g2_nand2_1
XFILLER_121_600 VDD VSS sg13g2_decap_8
XFILLER_79_514 VDD VSS sg13g2_fill_1
XFILLER_156_1062 VDD VSS sg13g2_decap_8
Xfanout1002 _09707_/B _15063_/Q VDD VSS sg13g2_buf_1
X_10164_ _14741_/D _14741_/Q _10164_/A1 _10168_/S VDD VSS sg13g2_mux2_1
Xfanout1013 _13305_/A _15059_/Q VDD VSS sg13g2_buf_1
Xfanout1024 _11241_/C _15053_/Q VDD VSS sg13g2_buf_1
Xfanout1035 _08600_/A _08668_/A VDD VSS sg13g2_buf_1
XFILLER_121_688 VDD VSS sg13g2_decap_8
Xfanout1046 _08621_/A _08161_/A2 VDD VSS sg13g2_buf_1
X_14972_ _14972_/Q _15247_/CLK _14972_/D _14972_/RESET_B VDD VSS sg13g2_dfrbpq_1
Xfanout1057 _08338_/B _08377_/B VDD VSS sg13g2_buf_1
X_10095_ _14675_/D _10095_/A0 _14675_/Q _10098_/S VDD VSS sg13g2_mux2_1
XFILLER_0_996 VDD VSS sg13g2_decap_8
XFILLER_102_880 VDD VSS sg13g2_decap_8
Xfanout1068 _08033_/A _07884_/A VDD VSS sg13g2_buf_1
Xfanout1079 _13518_/A1 _14989_/Q VDD VSS sg13g2_buf_1
XFILLER_48_945 VDD VSS sg13g2_decap_8
X_13923_ _13923_/Q _14505_/CLK _13923_/D _13923_/RESET_B VDD VSS sg13g2_dfrbpq_1
XFILLER_19_70 VDD VSS sg13g2_decap_8
X_13751__2428 _13751_/RESET_B VDD VSS sg13g2_tiehi
XFILLER_142_71 VDD VSS sg13g2_decap_8
X_13897__2282 _13897_/RESET_B VDD VSS sg13g2_tiehi
XFILLER_19_168 VDD VSS sg13g2_decap_8
X_13854_ _13854_/Q clkload38/A _13854_/D _13854_/RESET_B VDD VSS sg13g2_dfrbpq_1
XFILLER_90_723 VDD VSS sg13g2_decap_4
XFILLER_78_1339 VDD VSS sg13g2_decap_8
XFILLER_90_745 VDD VSS sg13g2_fill_2
X_12805_ _12805_/Y _12914_/A _12802_/Y _12804_/Y VDD VSS sg13g2_o21ai_1
X_13785_ _13785_/Q _14745_/CLK _13785_/D _13785_/RESET_B VDD VSS sg13g2_dfrbpq_1
XFILLER_76_1041 VDD VSS sg13g2_decap_4
X_10997_ _10997_/Y _10995_/Y _10996_/Y _11044_/C VDD VSS sg13g2_o21ai_1
XFILLER_16_875 VDD VSS sg13g2_decap_8
X_12736_ _15016_/D _12736_/A _12736_/B VDD VSS sg13g2_nor2_1
XFILLER_35_91 VDD VSS sg13g2_decap_4
XFILLER_15_385 VDD VSS sg13g2_decap_8
X_14131__2048 _14131_/RESET_B VDD VSS sg13g2_tiehi
XFILLER_96_7 VDD VSS sg13g2_decap_8
XFILLER_42_171 VDD VSS sg13g2_decap_8
XFILLER_124_1006 VDD VSS sg13g2_decap_8
XFILLER_31_845 VDD VSS sg13g2_decap_8
XFILLER_124_1017 VDD VSS sg13g2_fill_1
XFILLER_163_1088 VDD VSS sg13g2_decap_8
X_12667_ _12680_/A _10213_/A _07737_/B _15012_/Q VDD VSS sg13g2_a21oi_1
XFILLER_15_1323 VDD VSS sg13g2_decap_8
X_14406_ _14406_/Q _14733_/CLK _14406_/D _14406_/RESET_B VDD VSS sg13g2_dfrbpq_1
X_11618_ _11618_/Y _12040_/A1 _13894_/Q VDD VSS sg13g2_nand2b_1
X_14239__1940 _14239_/RESET_B VDD VSS sg13g2_tiehi
X_12598_ _12611_/A _12709_/A1 _12737_/A2 _07805_/B VDD VSS sg13g2_a21oi_1
XFILLER_128_243 VDD VSS sg13g2_decap_8
XFILLER_50_1258 VDD VSS sg13g2_decap_8
XFILLER_144_703 VDD VSS sg13g2_decap_8
X_14337_ _14337_/Q clkload31/A _14337_/D _14337_/RESET_B VDD VSS sg13g2_dfrbpq_1
X_11549_ _11549_/X _11549_/A _11549_/B VDD VSS sg13g2_and2_1
XFILLER_129_799 VDD VSS sg13g2_fill_2
XFILLER_7_595 VDD VSS sg13g2_decap_8
X_14268_ _14268_/Q clkload44/A _14268_/D _14268_/RESET_B VDD VSS sg13g2_dfrbpq_1
XFILLER_171_544 VDD VSS sg13g2_decap_8
XFILLER_144_769 VDD VSS sg13g2_decap_8
X_13219_ _13219_/Y _14826_/Q _13206_/B _13249_/B _14890_/Q _13274_/C1 VDD VSS sg13g2_a221oi_1
XFILLER_48_1132 VDD VSS sg13g2_decap_8
XFILLER_143_279 VDD VSS sg13g2_decap_8
XFILLER_125_994 VDD VSS sg13g2_decap_8
X_14199_ _14199_/Q clkload30/A _14199_/D _14199_/RESET_B VDD VSS sg13g2_dfrbpq_1
XFILLER_83_1045 VDD VSS sg13g2_fill_1
XFILLER_98_845 VDD VSS sg13g2_decap_8
XFILLER_83_1056 VDD VSS sg13g2_fill_2
XFILLER_111_110 VDD VSS sg13g2_decap_8
XFILLER_124_493 VDD VSS sg13g2_decap_8
XFILLER_98_856 VDD VSS sg13g2_fill_1
XFILLER_135_1135 VDD VSS sg13g2_decap_8
X_14920__2704 _14920_/RESET_B VDD VSS sg13g2_tiehi
XFILLER_48_1198 VDD VSS sg13g2_fill_1
XFILLER_44_1029 VDD VSS sg13g2_decap_8
XFILLER_83_1089 VDD VSS sg13g2_decap_4
XFILLER_170_1059 VDD VSS sg13g2_decap_4
X_08760_ _08760_/Y _08760_/A1 _13342_/A1 _15190_/Q VDD VSS sg13g2_o21ai_1
XFILLER_78_580 VDD VSS sg13g2_fill_2
X_07711_ _07748_/B _13302_/C _07754_/B VDD VSS sg13g2_and2_1
XFILLER_18_0 VDD VSS sg13g2_decap_8
XFILLER_22_1338 VDD VSS sg13g2_decap_8
X_08691_ _08693_/B _08692_/C _08048_/B _08690_/X VDD VSS sg13g2_o21ai_1
X_14341__1838 _14341_/RESET_B VDD VSS sg13g2_tiehi
X_13727__2452 _13727_/RESET_B VDD VSS sg13g2_tiehi
XFILLER_54_926 VDD VSS sg13g2_decap_8
XFILLER_38_477 VDD VSS sg13g2_decap_8
XFILLER_0_1101 VDD VSS sg13g2_decap_8
X_14487__1692 _14487_/RESET_B VDD VSS sg13g2_tiehi
X_07642_ _10265_/C _14783_/Q VDD VSS sg13g2_inv_1
X_14953__2638 _14953_/RESET_B VDD VSS sg13g2_tiehi
XFILLER_81_723 VDD VSS sg13g2_decap_4
XFILLER_25_105 VDD VSS sg13g2_decap_8
XFILLER_4_1281 VDD VSS sg13g2_decap_8
XFILLER_59_1250 VDD VSS sg13g2_fill_1
XFILLER_15_28 VDD VSS sg13g2_decap_8
XFILLER_55_1103 VDD VSS sg13g2_decap_4
XFILLER_0_1178 VDD VSS sg13g2_decap_8
XFILLER_146_1231 VDD VSS sg13g2_decap_8
X_09312_ _13919_/D _09910_/A1 _13919_/Q _09330_/S VDD VSS sg13g2_mux2_1
XFILLER_55_1125 VDD VSS sg13g2_decap_8
XFILLER_22_834 VDD VSS sg13g2_decap_8
XFILLER_107_1226 VDD VSS sg13g2_fill_2
XFILLER_21_322 VDD VSS sg13g2_decap_8
X_14107__2072 _14107_/RESET_B VDD VSS sg13g2_tiehi
X_09243_ _13852_/D _13852_/Q _09907_/A1 _09267_/S VDD VSS sg13g2_mux2_1
XFILLER_107_1248 VDD VSS sg13g2_fill_1
XFILLER_107_1259 VDD VSS sg13g2_fill_2
X_09174_ _13790_/D _13790_/Q _10141_/A1 _09202_/S VDD VSS sg13g2_mux2_1
XFILLER_21_399 VDD VSS sg13g2_decap_8
XFILLER_31_49 VDD VSS sg13g2_decap_8
XFILLER_108_928 VDD VSS sg13g2_decap_8
X_08125_ _08126_/B _08688_/D _08124_/X _08279_/B VDD VSS sg13g2_mux2_1
XFILLER_147_49 VDD VSS sg13g2_decap_8
XFILLER_174_371 VDD VSS sg13g2_decap_8
XFILLER_162_544 VDD VSS sg13g2_decap_8
X_08056_ _08056_/Y _08167_/B _08177_/S VDD VSS sg13g2_nand2b_1
XFILLER_89_812 VDD VSS sg13g2_fill_2
Xoutput49 mem_axi_araddr[20] _16873_/A VDD VSS sg13g2_buf_1
XFILLER_103_611 VDD VSS sg13g2_decap_8
XFILLER_153_1202 VDD VSS sg13g2_fill_2
XFILLER_157_1371 VDD VSS sg13g2_decap_8
Xhold3110 _13615_/A _13723_/Q VDD VSS sg13g2_dlygate4sd3_1
XFILLER_143_791 VDD VSS sg13g2_decap_8
XFILLER_157_1382 VDD VSS sg13g2_fill_2
Xhold3121 _13646_/A _13754_/Q VDD VSS sg13g2_dlygate4sd3_1
XFILLER_1_749 VDD VSS sg13g2_decap_8
Xhold3132 _10914_/A _14936_/Q VDD VSS sg13g2_dlygate4sd3_1
Xhold3143 _13531_/A _15143_/Q VDD VSS sg13g2_dlygate4sd3_1
XFILLER_66_1287 VDD VSS sg13g2_decap_8
XFILLER_49_709 VDD VSS sg13g2_decap_8
Xhold3154 _10875_/A _14933_/Q VDD VSS sg13g2_dlygate4sd3_1
XFILLER_66_1298 VDD VSS sg13g2_fill_1
XFILLER_0_259 VDD VSS sg13g2_decap_8
Xhold3165 _13527_/A _15142_/Q VDD VSS sg13g2_dlygate4sd3_1
XFILLER_131_986 VDD VSS sg13g2_decap_8
XFILLER_88_377 VDD VSS sg13g2_decap_8
X_08958_ _10105_/D _09905_/A _09839_/C VDD VSS sg13g2_nor2_1
XFILLER_5_1001 VDD VSS sg13g2_decap_8
XFILLER_76_539 VDD VSS sg13g2_decap_8
XFILLER_69_591 VDD VSS sg13g2_fill_2
X_07909_ _07909_/Y _14994_/Q _07909_/B VDD VSS sg13g2_nor2_1
XFILLER_56_35 VDD VSS sg13g2_decap_8
X_08889_ _13705_/D _08892_/S _08887_/Y _08888_/Y VDD VSS sg13g2_a21oi_1
XFILLER_91_509 VDD VSS sg13g2_fill_1
XFILLER_5_1078 VDD VSS sg13g2_decap_8
X_10920_ _10934_/B _10920_/A _10920_/B VDD VSS sg13g2_nand2_1
XFILLER_56_79 VDD VSS sg13g2_decap_8
XFILLER_16_105 VDD VSS sg13g2_decap_8
XFILLER_84_583 VDD VSS sg13g2_fill_2
XFILLER_57_797 VDD VSS sg13g2_decap_8
X_14317__1862 _14317_/RESET_B VDD VSS sg13g2_tiehi
XFILLER_56_296 VDD VSS sg13g2_fill_2
XFILLER_72_756 VDD VSS sg13g2_decap_8
X_10851_ _10871_/B _10851_/A _10870_/A _10851_/C _10851_/D VDD VSS sg13g2_nand4_1
XFILLER_44_458 VDD VSS sg13g2_decap_8
XFILLER_32_609 VDD VSS sg13g2_decap_8
XFILLER_112_85 VDD VSS sg13g2_decap_4
XFILLER_77_1372 VDD VSS sg13g2_decap_8
XFILLER_13_812 VDD VSS sg13g2_decap_8
XFILLER_77_1383 VDD VSS sg13g2_fill_1
X_13570_ _15155_/D _15155_/Q _13569_/X _13570_/S VDD VSS sg13g2_mux2_1
XFILLER_72_56 VDD VSS sg13g2_decap_8
XFILLER_71_288 VDD VSS sg13g2_decap_8
XFILLER_25_683 VDD VSS sg13g2_decap_4
XFILLER_164_1353 VDD VSS sg13g2_decap_4
X_10782_ _11164_/C _14953_/Q _08943_/A _10781_/X VDD VSS sg13g2_a21oi_1
XFILLER_12_322 VDD VSS sg13g2_decap_8
XFILLER_158_817 VDD VSS sg13g2_decap_8
XFILLER_24_182 VDD VSS sg13g2_decap_8
XFILLER_169_154 VDD VSS sg13g2_decap_8
X_12521_ _12521_/X _14119_/Q _14151_/Q _14183_/Q _14215_/Q _12522_/S0 _12522_/S1 VDD
+ VSS sg13g2_mux4_1
XFILLER_9_805 VDD VSS sg13g2_decap_8
XFILLER_40_642 VDD VSS sg13g2_fill_1
XFILLER_158_828 VDD VSS sg13g2_decap_8
XFILLER_13_889 VDD VSS sg13g2_decap_8
XFILLER_8_315 VDD VSS sg13g2_decap_8
X_15240_ _15240_/Q clkload58/A _15240_/D _15240_/RESET_B VDD VSS sg13g2_dfrbpq_1
X_12452_ _12452_/X _14242_/Q _14274_/Q _14306_/Q _14338_/Q _12452_/S0 _12452_/S1 VDD
+ VSS sg13g2_mux4_1
XFILLER_12_399 VDD VSS sg13g2_decap_8
XFILLER_138_541 VDD VSS sg13g2_fill_1
XFILLER_122_0 VDD VSS sg13g2_decap_8
XFILLER_166_872 VDD VSS sg13g2_fill_2
X_11403_ _11403_/X _13727_/Q _14079_/Q _14431_/Q _14527_/Q _11400_/A _07654_/A VDD
+ VSS sg13g2_mux4_1
X_15171_ _15171_/Q _15183_/CLK _15171_/D _15171_/RESET_B VDD VSS sg13g2_dfrbpq_1
XFILLER_123_1083 VDD VSS sg13g2_decap_8
X_12383_ _12383_/X _12376_/X _12380_/X _12375_/X _12379_/X _12398_/S1 _12398_/S0 VDD
+ VSS sg13g2_mux4_1
XFILLER_165_371 VDD VSS sg13g2_decap_8
X_14122_ _14122_/Q _14666_/CLK _14122_/D _14122_/RESET_B VDD VSS sg13g2_dfrbpq_1
XFILLER_153_544 VDD VSS sg13g2_decap_8
X_11334_ _11336_/A _11335_/A _13691_/Q VDD VSS sg13g2_and2_1
XFILLER_4_532 VDD VSS sg13g2_decap_8
XFILLER_10_1253 VDD VSS sg13g2_decap_8
XFILLER_99_609 VDD VSS sg13g2_decap_8
XFILLER_141_706 VDD VSS sg13g2_decap_8
X_13805__2374 _13805_/RESET_B VDD VSS sg13g2_tiehi
X_14053_ _14053_/Q clkload5/A _14053_/D _14053_/RESET_B VDD VSS sg13g2_dfrbpq_1
X_11265_ _11266_/A _14684_/Q _14716_/Q _13756_/Q _13788_/Q _12326_/A1 _11262_/B VDD
+ VSS sg13g2_mux4_1
XFILLER_98_119 VDD VSS sg13g2_decap_8
XFILLER_84_1343 VDD VSS sg13g2_decap_8
XFILLER_107_994 VDD VSS sg13g2_decap_8
XFILLER_140_227 VDD VSS sg13g2_decap_4
X_13004_ _13005_/B _12999_/Y _13048_/B _13003_/Y VDD VSS sg13g2_a21oi_1
XFILLER_171_1313 VDD VSS sg13g2_decap_8
X_10216_ _10216_/Y _13600_/C _14765_/Q VDD VSS sg13g2_nor2_1
XFILLER_79_333 VDD VSS sg13g2_decap_8
X_11196_ _11209_/A _11196_/A _11196_/B VDD VSS sg13g2_nand2_1
XFILLER_95_804 VDD VSS sg13g2_decap_8
X_10147_ _14724_/D _14724_/Q _10147_/A1 _10168_/S VDD VSS sg13g2_mux2_1
XFILLER_39_219 VDD VSS sg13g2_decap_8
XFILLER_153_70 VDD VSS sg13g2_decap_8
XFILLER_95_859 VDD VSS sg13g2_fill_1
XFILLER_0_793 VDD VSS sg13g2_decap_8
XFILLER_94_336 VDD VSS sg13g2_fill_1
XFILLER_11_7 VDD VSS sg13g2_decap_8
XFILLER_134_1190 VDD VSS sg13g2_decap_4
X_14955_ _14955_/Q clkload53/A _14955_/D _14955_/RESET_B VDD VSS sg13g2_dfrbpq_1
X_10078_ _14658_/D _10078_/A0 _14658_/Q _10101_/S VDD VSS sg13g2_mux2_1
XFILLER_94_369 VDD VSS sg13g2_decap_4
X_13906_ _13906_/Q clkload23/A _13906_/D _13906_/RESET_B VDD VSS sg13g2_dfrbpq_1
XFILLER_48_797 VDD VSS sg13g2_decap_8
X_14886_ _14886_/Q _14886_/CLK _14886_/D _14886_/RESET_B VDD VSS sg13g2_dfrbpq_1
XFILLER_36_948 VDD VSS sg13g2_decap_8
XFILLER_130_1087 VDD VSS sg13g2_decap_8
XFILLER_62_211 VDD VSS sg13g2_decap_8
XFILLER_169_1275 VDD VSS sg13g2_fill_2
X_13837_ _13837_/Q _14733_/CLK _13837_/D _13837_/RESET_B VDD VSS sg13g2_dfrbpq_1
XFILLER_165_1128 VDD VSS sg13g2_fill_2
XFILLER_90_575 VDD VSS sg13g2_decap_8
XFILLER_63_789 VDD VSS sg13g2_fill_1
XFILLER_16_672 VDD VSS sg13g2_decap_8
XFILLER_22_119 VDD VSS sg13g2_decap_8
X_13768_ _13768_/Q _14728_/CLK _13768_/D _13768_/RESET_B VDD VSS sg13g2_dfrbpq_1
XFILLER_15_182 VDD VSS sg13g2_decap_8
XFILLER_43_491 VDD VSS sg13g2_decap_8
XFILLER_31_631 VDD VSS sg13g2_decap_8
XFILLER_91_1358 VDD VSS sg13g2_fill_2
XFILLER_148_305 VDD VSS sg13g2_decap_8
X_12719_ _12719_/X _12710_/X _12711_/X _12717_/X _12716_/X _12719_/S0 _12692_/S VDD
+ VSS sg13g2_mux4_1
X_13699_ _16861_/A _15226_/CLK _13699_/D _13699_/RESET_B VDD VSS sg13g2_dfrbpq_1
XFILLER_15_1120 VDD VSS sg13g2_decap_8
XFILLER_129_541 VDD VSS sg13g2_fill_1
XFILLER_163_308 VDD VSS sg13g2_decap_8
XFILLER_102_1123 VDD VSS sg13g2_decap_8
XFILLER_117_725 VDD VSS sg13g2_decap_8
XFILLER_8_882 VDD VSS sg13g2_decap_8
XFILLER_15_1197 VDD VSS sg13g2_decap_8
XFILLER_7_84 VDD VSS sg13g2_decap_8
XFILLER_7_392 VDD VSS sg13g2_decap_8
XFILLER_172_853 VDD VSS sg13g2_fill_2
XFILLER_171_341 VDD VSS sg13g2_decap_8
X_09930_ _14515_/D _14515_/Q _09930_/A1 _09935_/S VDD VSS sg13g2_mux2_1
XFILLER_113_942 VDD VSS sg13g2_decap_8
Xfanout806 _12507_/S1 fanout816/X VDD VSS sg13g2_buf_1
XFILLER_112_430 VDD VSS sg13g2_fill_1
Xfanout817 _12590_/S1 _12614_/S1 VDD VSS sg13g2_buf_1
X_09861_ _14448_/D _14448_/Q _10159_/A1 _09863_/S VDD VSS sg13g2_mux2_1
Xfanout828 _12787_/S1 _12782_/S1 VDD VSS sg13g2_buf_1
Xfanout839 _12767_/S1 _12773_/S1 VDD VSS sg13g2_buf_1
X_08812_ _08812_/Y _13482_/A _15193_/Q VDD VSS sg13g2_nand2_1
X_09792_ _14381_/D _09924_/A1 _14381_/Q _09796_/S VDD VSS sg13g2_mux2_1
X_14574__1605 _14574_/RESET_B VDD VSS sg13g2_tiehi
XFILLER_61_1151 VDD VSS sg13g2_decap_8
XFILLER_85_347 VDD VSS sg13g2_decap_8
XFILLER_100_658 VDD VSS sg13g2_fill_2
X_08743_ _08743_/Y _13666_/Q _08781_/B VDD VSS sg13g2_nor2_1
X_15160__2637 _15160_/RESET_B VDD VSS sg13g2_tiehi
XFILLER_6_1365 VDD VSS sg13g2_decap_8
XFILLER_22_1135 VDD VSS sg13g2_decap_8
XFILLER_2_1218 VDD VSS sg13g2_decap_8
XFILLER_26_403 VDD VSS sg13g2_decap_8
X_08674_ _08674_/Y _08684_/A _08674_/A2 _08674_/B1 _08673_/X _08672_/X VDD VSS sg13g2_a221oi_1
XFILLER_148_1315 VDD VSS sg13g2_decap_8
XFILLER_26_447 VDD VSS sg13g2_fill_1
X_07625_ _07625_/Y _13398_/B VDD VSS sg13g2_inv_1
XFILLER_26_49 VDD VSS sg13g2_decap_8
XFILLER_14_609 VDD VSS sg13g2_decap_8
XFILLER_26_469 VDD VSS sg13g2_fill_2
XFILLER_13_119 VDD VSS sg13g2_decap_8
XFILLER_59_1091 VDD VSS sg13g2_decap_4
XFILLER_41_439 VDD VSS sg13g2_fill_2
XFILLER_107_1001 VDD VSS sg13g2_fill_1
X_14897__2750 _14897_/RESET_B VDD VSS sg13g2_tiehi
XFILLER_10_826 VDD VSS sg13g2_decap_8
X_09226_ _13837_/D _10156_/A1 _13837_/Q _09226_/S VDD VSS sg13g2_mux2_1
XFILLER_6_819 VDD VSS sg13g2_decap_8
XFILLER_33_1253 VDD VSS sg13g2_decap_8
XFILLER_21_196 VDD VSS sg13g2_decap_8
XFILLER_166_168 VDD VSS sg13g2_decap_8
X_09157_ _09158_/C _14924_/Q _14923_/Q _09157_/C _09157_/D VDD VSS sg13g2_nand4_1
XFILLER_5_329 VDD VSS sg13g2_decap_8
X_08108_ _08112_/C _15104_/Q _15091_/Q _08105_/Y VDD VSS sg13g2_o21ai_1
XFILLER_108_758 VDD VSS sg13g2_decap_8
X_09088_ _09103_/D _14914_/Q _14913_/Q _13088_/A VDD VSS sg13g2_and3_1
XFILLER_162_341 VDD VSS sg13g2_decap_8
XFILLER_163_875 VDD VSS sg13g2_decap_8
XFILLER_135_577 VDD VSS sg13g2_decap_4
XFILLER_155_1308 VDD VSS sg13g2_fill_1
X_08039_ _08039_/Y _08039_/A _08039_/B _08039_/C _08039_/D VDD VSS sg13g2_nand4_1
XFILLER_174_47 VDD VSS sg13g2_decap_8
XFILLER_89_631 VDD VSS sg13g2_decap_4
X_11050_ _11051_/B _11036_/Y _11064_/C _11032_/Y VDD VSS sg13g2_a21oi_1
XFILLER_1_546 VDD VSS sg13g2_decap_8
XFILLER_153_1021 VDD VSS sg13g2_decap_8
XFILLER_131_772 VDD VSS sg13g2_decap_8
XFILLER_153_1054 VDD VSS sg13g2_decap_8
X_10001_ _14584_/D _10167_/A1 _14584_/Q _10002_/S VDD VSS sg13g2_mux2_1
XFILLER_88_163 VDD VSS sg13g2_fill_2
XFILLER_118_1185 VDD VSS sg13g2_decap_8
XFILLER_76_314 VDD VSS sg13g2_decap_8
XFILLER_67_56 VDD VSS sg13g2_decap_8
XFILLER_103_496 VDD VSS sg13g2_fill_1
XFILLER_114_1038 VDD VSS sg13g2_decap_8
XFILLER_76_347 VDD VSS sg13g2_decap_8
XFILLER_131_1330 VDD VSS sg13g2_decap_8
XFILLER_76_358 VDD VSS sg13g2_fill_1
XFILLER_40_1246 VDD VSS sg13g2_decap_8
XFILLER_29_252 VDD VSS sg13g2_decap_8
X_14740_ _14740_/Q clkload15/A _14740_/D _14740_/RESET_B VDD VSS sg13g2_dfrbpq_1
XFILLER_29_263 VDD VSS sg13g2_fill_1
X_11952_ _11953_/B _11952_/A _11952_/B _12026_/C VDD VSS sg13g2_nand3_1
XFILLER_123_84 VDD VSS sg13g2_decap_8
XFILLER_18_959 VDD VSS sg13g2_decap_8
XFILLER_83_44 VDD VSS sg13g2_decap_8
X_10903_ _10903_/Y _10903_/A _10903_/B VDD VSS sg13g2_nand2_1
X_14671_ _14671_/Q clkload6/A _14671_/D _14671_/RESET_B VDD VSS sg13g2_dfrbpq_1
X_11883_ _11883_/X _11900_/B _11882_/X _11881_/Y VDD VSS sg13g2_a21o_1
XFILLER_17_469 VDD VSS sg13g2_decap_8
X_13622_ _13730_/D _13622_/A VDD VSS sg13g2_buf_1
XFILLER_83_99 VDD VSS sg13g2_decap_8
X_10834_ _10834_/Y _10869_/A _10876_/D _10830_/X _10832_/X VDD VSS sg13g2_a22oi_1
XFILLER_73_1011 VDD VSS sg13g2_fill_2
XFILLER_44_288 VDD VSS sg13g2_fill_1
XFILLER_38_1142 VDD VSS sg13g2_decap_8
XFILLER_158_614 VDD VSS sg13g2_decap_8
XFILLER_160_1003 VDD VSS sg13g2_decap_4
X_13553_ _13553_/Y _07913_/A _13567_/A2 _13552_/Y VDD VSS sg13g2_a21oi_1
XFILLER_9_602 VDD VSS sg13g2_decap_8
XFILLER_160_1014 VDD VSS sg13g2_fill_1
X_10765_ _10765_/Y _13189_/A _11133_/B VDD VSS sg13g2_nand2_1
XFILLER_13_686 VDD VSS sg13g2_decap_8
X_12504_ _12504_/X _14694_/Q _14726_/Q _13766_/Q _13798_/Q _12507_/S0 _12507_/S1 VDD
+ VSS sg13g2_mux4_1
XFILLER_8_112 VDD VSS sg13g2_decap_8
X_13484_ _15123_/D _13484_/A _13484_/B _13484_/C VDD VSS sg13g2_nand3_1
X_10696_ _14901_/D _10696_/A VDD VSS sg13g2_inv_1
XFILLER_12_196 VDD VSS sg13g2_decap_8
X_15223_ _15223_/Q clkload67/A _15223_/D _15223_/RESET_B VDD VSS sg13g2_dfrbpq_1
XFILLER_9_679 VDD VSS sg13g2_decap_8
X_12435_ _12435_/X _14113_/Q _14145_/Q _14177_/Q _14209_/Q _12767_/S0 _12767_/S1 VDD
+ VSS sg13g2_mux4_1
XFILLER_32_70 VDD VSS sg13g2_decap_8
XFILLER_172_105 VDD VSS sg13g2_decap_8
XFILLER_12_1337 VDD VSS sg13g2_decap_8
XFILLER_166_680 VDD VSS sg13g2_decap_8
XFILLER_8_189 VDD VSS sg13g2_decap_8
XFILLER_148_70 VDD VSS sg13g2_decap_4
XFILLER_154_842 VDD VSS sg13g2_fill_2
X_14652__1527 _14652_/RESET_B VDD VSS sg13g2_tiehi
X_15154_ _15154_/Q clkload68/A _15154_/D _15154_/RESET_B VDD VSS sg13g2_dfrbpq_1
X_12366_ _12366_/X _13724_/Q _14076_/Q _14428_/Q _14524_/Q _12783_/S0 _12783_/S1 VDD
+ VSS sg13g2_mux4_1
XFILLER_153_341 VDD VSS sg13g2_decap_8
XFILLER_59_7 VDD VSS sg13g2_decap_8
XFILLER_10_1050 VDD VSS sg13g2_decap_8
X_14105_ _14105_/Q clkload21/A _14105_/D _14105_/RESET_B VDD VSS sg13g2_dfrbpq_1
XFILLER_114_728 VDD VSS sg13g2_decap_8
X_11317_ _11318_/A _11320_/S0 _14493_/Q _11325_/B1 VDD VSS sg13g2_a21oi_1
X_15085_ _15085_/Q clkload71/A _15085_/D _15085_/RESET_B VDD VSS sg13g2_dfrbpq_1
X_14081__2098 _14081_/RESET_B VDD VSS sg13g2_tiehi
X_12297_ _14987_/D _12297_/A _12297_/B VDD VSS sg13g2_nand2_1
XFILLER_5_896 VDD VSS sg13g2_decap_8
X_14036_ _14036_/Q _14666_/CLK _14036_/D _14036_/RESET_B VDD VSS sg13g2_dfrbpq_1
X_11248_ _11248_/Y _11248_/A _11248_/B VDD VSS sg13g2_nor2_1
XFILLER_80_1004 VDD VSS sg13g2_decap_8
XFILLER_136_1241 VDD VSS sg13g2_fill_1
XFILLER_80_1015 VDD VSS sg13g2_fill_1
XFILLER_80_1026 VDD VSS sg13g2_decap_8
XFILLER_132_1105 VDD VSS sg13g2_decap_4
XFILLER_164_91 VDD VSS sg13g2_decap_8
XFILLER_80_1037 VDD VSS sg13g2_decap_8
XFILLER_45_1168 VDD VSS sg13g2_decap_8
XFILLER_121_271 VDD VSS sg13g2_decap_8
XFILLER_136_1285 VDD VSS sg13g2_decap_8
X_14189__1990 _14189_/RESET_B VDD VSS sg13g2_tiehi
X_11179_ _11179_/X _11186_/B _11191_/A VDD VSS sg13g2_and2_1
XFILLER_68_848 VDD VSS sg13g2_decap_8
XFILLER_171_1176 VDD VSS sg13g2_decap_8
X_15020__2567 _15020_/RESET_B VDD VSS sg13g2_tiehi
XFILLER_82_306 VDD VSS sg13g2_decap_8
XFILLER_76_870 VDD VSS sg13g2_decap_8
XFILLER_48_583 VDD VSS sg13g2_decap_8
X_14938_ _14938_/Q clkload52/A _14938_/D _14938_/RESET_B VDD VSS sg13g2_dfrbpq_1
XFILLER_75_380 VDD VSS sg13g2_decap_8
XFILLER_91_840 VDD VSS sg13g2_decap_8
XFILLER_63_531 VDD VSS sg13g2_decap_8
X_14869_ _14869_/Q _14874_/CLK _14869_/D _14869_/RESET_B VDD VSS sg13g2_dfrbpq_1
XFILLER_21_1190 VDD VSS sg13g2_decap_8
XFILLER_91_884 VDD VSS sg13g2_decap_8
XFILLER_23_406 VDD VSS sg13g2_decap_8
X_08390_ _08390_/Y _07790_/A _08160_/A _08412_/A VDD VSS sg13g2_o21ai_1
XFILLER_1_1295 VDD VSS sg13g2_decap_8
XFILLER_149_603 VDD VSS sg13g2_fill_1
XFILLER_32_951 VDD VSS sg13g2_fill_2
XFILLER_17_1204 VDD VSS sg13g2_decap_8
XFILLER_149_614 VDD VSS sg13g2_decap_8
XFILLER_91_1144 VDD VSS sg13g2_decap_8
XFILLER_32_962 VDD VSS sg13g2_decap_8
XFILLER_31_450 VDD VSS sg13g2_fill_1
XFILLER_85_0 VDD VSS sg13g2_decap_8
XFILLER_52_1139 VDD VSS sg13g2_fill_2
X_14291__1888 _14291_/RESET_B VDD VSS sg13g2_tiehi
X_09011_ _09030_/D _09011_/A _09011_/B _09011_/C _09011_/D VDD VSS sg13g2_nor4_1
XFILLER_117_500 VDD VSS sg13g2_decap_8
XFILLER_163_105 VDD VSS sg13g2_decap_8
XFILLER_117_511 VDD VSS sg13g2_fill_1
XFILLER_89_1040 VDD VSS sg13g2_decap_8
XFILLER_145_853 VDD VSS sg13g2_decap_8
X_14628__1551 _14628_/RESET_B VDD VSS sg13g2_tiehi
XFILLER_160_812 VDD VSS sg13g2_decap_8
XFILLER_105_728 VDD VSS sg13g2_fill_2
XFILLER_137_1005 VDD VSS sg13g2_decap_8
XFILLER_144_363 VDD VSS sg13g2_decap_8
XFILLER_144_374 VDD VSS sg13g2_fill_1
XFILLER_137_1016 VDD VSS sg13g2_decap_8
XFILLER_144_385 VDD VSS sg13g2_decap_8
XFILLER_171_182 VDD VSS sg13g2_decap_8
X_09913_ _14498_/D _14498_/Q _09913_/A1 _09936_/S VDD VSS sg13g2_mux2_1
XFILLER_67_1371 VDD VSS sg13g2_fill_2
XFILLER_28_1322 VDD VSS sg13g2_decap_8
XFILLER_132_558 VDD VSS sg13g2_fill_2
Xfanout603 _10735_/A _08838_/Y VDD VSS sg13g2_buf_1
XFILLER_99_962 VDD VSS sg13g2_decap_4
XFILLER_113_750 VDD VSS sg13g2_decap_8
XFILLER_120_709 VDD VSS sg13g2_fill_1
XFILLER_144_28 VDD VSS sg13g2_decap_8
Xfanout614 _08940_/S _08955_/S VDD VSS sg13g2_buf_1
XFILLER_154_1352 VDD VSS sg13g2_fill_2
Xfanout625 _13407_/A _13440_/A VDD VSS sg13g2_buf_1
XFILLER_98_461 VDD VSS sg13g2_decap_8
Xfanout636 _08674_/A2 _08522_/C VDD VSS sg13g2_buf_1
XFILLER_63_1246 VDD VSS sg13g2_fill_2
Xfanout647 _12791_/C1 _07737_/Y VDD VSS sg13g2_buf_1
X_09844_ _14431_/D _14431_/Q _10109_/A0 _09862_/S VDD VSS sg13g2_mux2_1
Xfanout658 _13248_/B _07727_/Y VDD VSS sg13g2_buf_1
XFILLER_59_848 VDD VSS sg13g2_decap_8
XFILLER_115_1347 VDD VSS sg13g2_decap_4
Xfanout669 _11183_/B1 _11056_/B1 VDD VSS sg13g2_buf_1
XFILLER_86_656 VDD VSS sg13g2_decap_8
XFILLER_58_347 VDD VSS sg13g2_fill_2
X_09775_ _14364_/D _10139_/A1 _14364_/Q _09799_/S VDD VSS sg13g2_mux2_1
XFILLER_86_678 VDD VSS sg13g2_fill_2
XFILLER_85_144 VDD VSS sg13g2_fill_2
XFILLER_74_818 VDD VSS sg13g2_fill_1
XFILLER_6_1162 VDD VSS sg13g2_decap_8
XFILLER_27_701 VDD VSS sg13g2_decap_8
XFILLER_27_712 VDD VSS sg13g2_fill_2
X_08726_ _08727_/D _13506_/A _13481_/A VDD VSS sg13g2_or2_1
XFILLER_96_1000 VDD VSS sg13g2_fill_1
XFILLER_39_572 VDD VSS sg13g2_fill_2
XFILLER_2_1015 VDD VSS sg13g2_decap_8
XFILLER_96_1011 VDD VSS sg13g2_decap_4
XFILLER_160_49 VDD VSS sg13g2_decap_8
XFILLER_113_1093 VDD VSS sg13g2_decap_8
X_08657_ _08657_/Y _08079_/S _08655_/Y _08656_/X VDD VSS sg13g2_a21oi_1
XFILLER_82_862 VDD VSS sg13g2_decap_8
XFILLER_148_1134 VDD VSS sg13g2_decap_8
XFILLER_163_7 VDD VSS sg13g2_decap_8
XFILLER_14_406 VDD VSS sg13g2_decap_8
XFILLER_96_1077 VDD VSS sg13g2_decap_8
XFILLER_26_266 VDD VSS sg13g2_decap_8
X_14730__1449 _14730_/RESET_B VDD VSS sg13g2_tiehi
XFILLER_53_14 VDD VSS sg13g2_decap_8
XFILLER_54_597 VDD VSS sg13g2_decap_8
X_08588_ _08596_/A _08587_/Y _08588_/B _08588_/C VDD VSS sg13g2_nand3b_1
XFILLER_169_14 VDD VSS sg13g2_decap_8
XFILLER_161_1301 VDD VSS sg13g2_fill_1
XFILLER_41_258 VDD VSS sg13g2_decap_8
XFILLER_168_956 VDD VSS sg13g2_decap_8
XFILLER_70_1228 VDD VSS sg13g2_decap_4
XFILLER_10_623 VDD VSS sg13g2_decap_8
X_10550_ _10550_/Y _14865_/Q _10556_/D _10557_/C VDD VSS sg13g2_o21ai_1
XFILLER_50_792 VDD VSS sg13g2_decap_8
XFILLER_22_483 VDD VSS sg13g2_decap_8
XFILLER_139_146 VDD VSS sg13g2_decap_8
XFILLER_167_455 VDD VSS sg13g2_decap_8
XFILLER_122_1329 VDD VSS sg13g2_decap_8
XFILLER_127_308 VDD VSS sg13g2_decap_8
X_09209_ _13820_/D _09907_/A1 _13820_/Q _09233_/S VDD VSS sg13g2_mux2_1
XFILLER_154_105 VDD VSS sg13g2_decap_8
XFILLER_6_616 VDD VSS sg13g2_decap_8
X_10481_ _10481_/Y _10489_/C _14847_/Q _10486_/D _10492_/C VDD VSS sg13g2_nand4_1
X_12220_ _12220_/Y _12219_/S _12215_/X _12214_/Y VDD VSS sg13g2_o21ai_1
XFILLER_5_126 VDD VSS sg13g2_decap_8
XFILLER_147_190 VDD VSS sg13g2_decap_8
XFILLER_170_609 VDD VSS sg13g2_decap_8
XFILLER_108_566 VDD VSS sg13g2_decap_8
XFILLER_163_661 VDD VSS sg13g2_decap_8
XFILLER_120_1086 VDD VSS sg13g2_decap_8
XFILLER_123_503 VDD VSS sg13g2_decap_8
X_12151_ _12151_/Y _12152_/A _13666_/Q VDD VSS sg13g2_nor2_1
XFILLER_162_182 VDD VSS sg13g2_decap_8
XFILLER_2_833 VDD VSS sg13g2_decap_8
X_11102_ _11102_/Y _14949_/Q _11133_/B VDD VSS sg13g2_nand2_1
X_12082_ _12125_/A _12084_/A _12082_/B VDD VSS sg13g2_nor2_1
XFILLER_81_1324 VDD VSS sg13g2_fill_2
XFILLER_1_343 VDD VSS sg13g2_decap_8
XFILLER_78_77 VDD VSS sg13g2_decap_4
X_11033_ _11064_/C _14760_/Q _11033_/B VDD VSS sg13g2_xor2_1
XFILLER_103_271 VDD VSS sg13g2_decap_8
XFILLER_94_21 VDD VSS sg13g2_decap_8
XFILLER_37_509 VDD VSS sg13g2_decap_8
X_14066__2113 _14066_/RESET_B VDD VSS sg13g2_tiehi
X_12984_ _15032_/D _13266_/A _12984_/B VDD VSS sg13g2_nor2_1
XFILLER_40_1054 VDD VSS sg13g2_decap_4
XFILLER_94_87 VDD VSS sg13g2_decap_8
XFILLER_18_756 VDD VSS sg13g2_decap_8
XFILLER_166_1201 VDD VSS sg13g2_fill_2
X_14723_ _14723_/Q clkload19/A _14723_/D _14723_/RESET_B VDD VSS sg13g2_dfrbpq_1
X_11935_ _11986_/A _11936_/A _13129_/B VDD VSS sg13g2_nor2_1
XFILLER_27_70 VDD VSS sg13g2_decap_8
XFILLER_33_704 VDD VSS sg13g2_decap_4
XFILLER_17_266 VDD VSS sg13g2_decap_8
XFILLER_75_1128 VDD VSS sg13g2_decap_8
XFILLER_60_501 VDD VSS sg13g2_decap_8
X_14654_ _14654_/Q clkload36/A _14654_/D _14654_/RESET_B VDD VSS sg13g2_dfrbpq_1
XFILLER_32_214 VDD VSS sg13g2_decap_8
X_14706__1473 _14706_/RESET_B VDD VSS sg13g2_tiehi
X_11866_ _11868_/B _11867_/A _11867_/B _11910_/C VDD VSS sg13g2_a21o_1
X_13605_ _13605_/Y _13600_/A _13611_/A2 hold3170/X VDD VSS sg13g2_a21oi_1
XFILLER_159_923 VDD VSS sg13g2_fill_1
X_10817_ _10821_/A _10818_/B _10818_/A VDD VSS sg13g2_nand2_1
XFILLER_14_973 VDD VSS sg13g2_decap_8
X_14585_ _14585_/Q _14649_/CLK _14585_/D _14585_/RESET_B VDD VSS sg13g2_dfrbpq_1
X_11797_ _11907_/A _11798_/A _13676_/Q VDD VSS sg13g2_nor2_1
XFILLER_13_483 VDD VSS sg13g2_decap_8
X_13536_ _15144_/D _13535_/B _13534_/Y _13535_/Y VDD VSS sg13g2_a21oi_1
XFILLER_159_978 VDD VSS sg13g2_fill_2
X_10748_ _11078_/B _14946_/Q _10794_/A2 _10747_/Y VDD VSS sg13g2_a21oi_1
XFILLER_43_91 VDD VSS sg13g2_decap_8
XFILLER_159_989 VDD VSS sg13g2_decap_8
XFILLER_118_319 VDD VSS sg13g2_fill_2
XFILLER_159_91 VDD VSS sg13g2_decap_8
XFILLER_9_476 VDD VSS sg13g2_decap_8
XFILLER_158_499 VDD VSS sg13g2_fill_2
XFILLER_16_1281 VDD VSS sg13g2_decap_8
X_13467_ _13468_/D _15169_/Q _15170_/Q _15171_/Q _15172_/Q VDD VSS sg13g2_nand4_1
X_10679_ _10818_/B _08980_/X _10669_/S _08844_/Y VDD VSS sg13g2_a21oi_1
XFILLER_51_1172 VDD VSS sg13g2_fill_2
XFILLER_12_1134 VDD VSS sg13g2_decap_8
X_15038__2549 _15038_/RESET_B VDD VSS sg13g2_tiehi
X_15206_ _15206_/Q clkload72/A _15206_/D _15206_/RESET_B VDD VSS sg13g2_dfrbpq_1
XFILLER_51_1183 VDD VSS sg13g2_fill_2
X_12418_ _12418_/X _14112_/Q _14144_/Q _14176_/Q _14208_/Q _12450_/S0 _12450_/S1 VDD
+ VSS sg13g2_mux4_1
XFILLER_173_458 VDD VSS sg13g2_decap_8
XFILLER_103_1273 VDD VSS sg13g2_decap_4
XFILLER_173_469 VDD VSS sg13g2_decap_8
X_13398_ _13398_/Y _13407_/A _13398_/B _15087_/Q VDD VSS sg13g2_nand3_1
XFILLER_127_897 VDD VSS sg13g2_decap_8
XFILLER_160_119 VDD VSS sg13g2_decap_8
X_15137_ _15137_/Q clkload59/A _15137_/D _15137_/RESET_B VDD VSS sg13g2_dfrbpq_1
XFILLER_141_300 VDD VSS sg13g2_decap_8
X_12349_ _12349_/X _13819_/Q _13851_/Q _13883_/Q _13915_/Q _12617_/S0 _12617_/S1 VDD
+ VSS sg13g2_mux4_1
XFILLER_86_1257 VDD VSS sg13g2_decap_8
XFILLER_114_525 VDD VSS sg13g2_fill_1
XFILLER_141_311 VDD VSS sg13g2_fill_1
XFILLER_86_1268 VDD VSS sg13g2_fill_1
X_14881__2782 _14881_/RESET_B VDD VSS sg13g2_tiehi
XFILLER_5_693 VDD VSS sg13g2_decap_8
X_14276__1903 _14276_/RESET_B VDD VSS sg13g2_tiehi
XFILLER_99_247 VDD VSS sg13g2_decap_4
X_15068_ _15068_/Q _15183_/CLK _15068_/D _15068_/RESET_B VDD VSS sg13g2_dfrbpq_1
XFILLER_99_269 VDD VSS sg13g2_decap_8
XFILLER_4_63 VDD VSS sg13g2_decap_8
X_14019_ _14019_/Q _14659_/CLK _14019_/D _14019_/RESET_B VDD VSS sg13g2_dfrbpq_1
XFILLER_122_580 VDD VSS sg13g2_decap_4
X_07890_ _07904_/A _07924_/C _07890_/B VDD VSS sg13g2_nor2_1
XFILLER_68_634 VDD VSS sg13g2_decap_8
XFILLER_68_667 VDD VSS sg13g2_decap_8
XFILLER_3_1302 VDD VSS sg13g2_decap_8
XFILLER_23_1230 VDD VSS sg13g2_decap_8
XFILLER_62_1290 VDD VSS sg13g2_fill_1
X_09560_ _14158_/D _09859_/A1 _14158_/Q _09566_/S VDD VSS sg13g2_mux2_1
X_08511_ _08511_/X _08427_/X _08510_/X _08511_/S VDD VSS sg13g2_mux2_1
XFILLER_97_1353 VDD VSS sg13g2_decap_4
XFILLER_82_147 VDD VSS sg13g2_decap_8
X_09491_ _14091_/D _10121_/A0 _14091_/Q _09497_/S VDD VSS sg13g2_mux2_1
XFILLER_3_1379 VDD VSS sg13g2_decap_4
XFILLER_91_670 VDD VSS sg13g2_decap_8
XFILLER_64_884 VDD VSS sg13g2_decap_8
XFILLER_64_895 VDD VSS sg13g2_fill_1
XFILLER_23_203 VDD VSS sg13g2_decap_8
X_08442_ _08443_/B _08574_/A _08442_/B VDD VSS sg13g2_nor2_1
XFILLER_93_1239 VDD VSS sg13g2_decap_8
XFILLER_36_597 VDD VSS sg13g2_fill_2
XFILLER_63_394 VDD VSS sg13g2_decap_8
XFILLER_1_1092 VDD VSS sg13g2_decap_8
XFILLER_17_1001 VDD VSS sg13g2_decap_8
X_08373_ _15232_/D _08372_/Y _08373_/B _08373_/C VDD VSS sg13g2_nand3b_1
X_13764__2415 _13764_/RESET_B VDD VSS sg13g2_tiehi
XFILLER_23_28 VDD VSS sg13g2_decap_8
XFILLER_20_910 VDD VSS sg13g2_decap_8
XFILLER_143_1031 VDD VSS sg13g2_decap_8
XFILLER_149_444 VDD VSS sg13g2_decap_8
XFILLER_32_792 VDD VSS sg13g2_decap_8
XFILLER_139_28 VDD VSS sg13g2_decap_8
XFILLER_17_1078 VDD VSS sg13g2_decap_8
XFILLER_104_1037 VDD VSS sg13g2_decap_8
X_15092__2797 _15092_/RESET_B VDD VSS sg13g2_tiehi
XFILLER_30_1212 VDD VSS sg13g2_decap_8
XFILLER_20_987 VDD VSS sg13g2_decap_8
XFILLER_118_842 VDD VSS sg13g2_decap_8
XFILLER_164_469 VDD VSS sg13g2_decap_8
X_14144__2035 _14144_/RESET_B VDD VSS sg13g2_tiehi
XFILLER_30_1289 VDD VSS sg13g2_decap_8
XFILLER_132_300 VDD VSS sg13g2_decap_8
XFILLER_133_834 VDD VSS sg13g2_decap_8
XFILLER_155_49 VDD VSS sg13g2_decap_8
XFILLER_144_182 VDD VSS sg13g2_decap_4
XFILLER_172_491 VDD VSS sg13g2_decap_8
Xfanout400 _09160_/S _09112_/S VDD VSS sg13g2_buf_1
XFILLER_120_517 VDD VSS sg13g2_decap_8
Xfanout411 _12400_/A _12348_/Y VDD VSS sg13g2_buf_1
Xfanout1409 _13302_/C fanout1413/X VDD VSS sg13g2_buf_1
XFILLER_59_601 VDD VSS sg13g2_decap_8
XFILLER_160_686 VDD VSS sg13g2_decap_8
Xfanout422 _10027_/S _10036_/S VDD VSS sg13g2_buf_1
XFILLER_48_14 VDD VSS sg13g2_decap_8
Xfanout433 _09837_/S _09838_/S VDD VSS sg13g2_buf_1
XFILLER_119_1291 VDD VSS sg13g2_decap_8
Xfanout444 _09673_/S _09641_/X VDD VSS sg13g2_buf_1
XFILLER_8_1246 VDD VSS sg13g2_decap_8
Xfanout455 _09535_/S _09538_/S VDD VSS sg13g2_buf_1
XFILLER_98_291 VDD VSS sg13g2_fill_2
Xfanout466 _09403_/S _09406_/S VDD VSS sg13g2_buf_1
XFILLER_87_965 VDD VSS sg13g2_fill_2
XFILLER_28_1196 VDD VSS sg13g2_decap_8
Xfanout477 _09233_/S _09239_/S VDD VSS sg13g2_buf_1
X_09827_ _14415_/D _09926_/A1 _14415_/Q _09831_/S VDD VSS sg13g2_mux2_1
Xfanout488 _08765_/A1 _08729_/Y VDD VSS sg13g2_buf_1
Xfanout499 _13502_/A _07989_/Y VDD VSS sg13g2_buf_1
XFILLER_86_475 VDD VSS sg13g2_decap_8
XFILLER_101_786 VDD VSS sg13g2_decap_8
XFILLER_41_1341 VDD VSS sg13g2_decap_8
XFILLER_104_42 VDD VSS sg13g2_fill_1
X_09758_ _14348_/D _14348_/Q _09923_/A1 _09766_/S VDD VSS sg13g2_mux2_1
XFILLER_104_75 VDD VSS sg13g2_decap_8
X_08709_ _15187_/D hold3083/X _15187_/Q _10203_/S VDD VSS sg13g2_mux2_1
X_09689_ _14281_/D _10152_/A1 _14281_/Q _09705_/S VDD VSS sg13g2_mux2_1
XFILLER_54_350 VDD VSS sg13g2_fill_2
XFILLER_27_564 VDD VSS sg13g2_decap_8
XFILLER_14_203 VDD VSS sg13g2_decap_8
X_11720_ _11720_/Y _12293_/A1 _11718_/X _11719_/Y VDD VSS sg13g2_o21ai_1
XFILLER_27_597 VDD VSS sg13g2_decap_8
XFILLER_54_394 VDD VSS sg13g2_decap_8
XFILLER_81_180 VDD VSS sg13g2_decap_8
XFILLER_42_556 VDD VSS sg13g2_decap_8
X_11651_ _11651_/X _13959_/Q _13991_/Q _14023_/Q _14055_/Q _11651_/S0 _11651_/S1 VDD
+ VSS sg13g2_mux4_1
XFILLER_39_1281 VDD VSS sg13g2_decap_8
XFILLER_11_910 VDD VSS sg13g2_decap_8
XFILLER_23_770 VDD VSS sg13g2_decap_8
XFILLER_168_742 VDD VSS sg13g2_fill_2
X_14354__1825 _14354_/RESET_B VDD VSS sg13g2_tiehi
X_10602_ _14877_/D _10643_/A _10602_/B _10602_/C VDD VSS sg13g2_nor3_1
X_14370_ _14370_/Q clkload25/A _14370_/D _14370_/RESET_B VDD VSS sg13g2_dfrbpq_1
XFILLER_10_420 VDD VSS sg13g2_decap_8
XFILLER_156_904 VDD VSS sg13g2_decap_8
X_11582_ _11584_/B _11747_/A _11582_/B VDD VSS sg13g2_nor2_1
XFILLER_7_903 VDD VSS sg13g2_decap_8
XFILLER_22_280 VDD VSS sg13g2_decap_8
XFILLER_128_617 VDD VSS sg13g2_decap_8
XFILLER_167_252 VDD VSS sg13g2_decap_8
X_13321_ _13322_/A _15111_/Q _13306_/B _13324_/A VDD VSS sg13g2_a21oi_1
X_10533_ _10535_/A _14860_/Q _10533_/B VDD VSS sg13g2_nand2b_1
XFILLER_11_987 VDD VSS sg13g2_decap_8
XFILLER_6_413 VDD VSS sg13g2_decap_8
XFILLER_127_138 VDD VSS sg13g2_fill_2
XFILLER_10_497 VDD VSS sg13g2_decap_8
X_13252_ _13252_/X input25/X _12914_/A _13264_/B1 VDD VSS sg13g2_a21o_1
X_10464_ _14843_/D _10471_/C _10471_/D _10463_/Y VDD VSS sg13g2_a21oi_1
XFILLER_89_21 VDD VSS sg13g2_decap_8
XFILLER_170_406 VDD VSS sg13g2_decap_8
XFILLER_142_108 VDD VSS sg13g2_fill_1
X_12203_ _12272_/A _12203_/A _13665_/Q VDD VSS sg13g2_xnor2_1
X_13183_ _13184_/B _13253_/B2 _13178_/X _13177_/X _13303_/A _13182_/Y VDD VSS sg13g2_a221oi_1
XFILLER_159_1071 VDD VSS sg13g2_decap_8
X_10395_ _10396_/D _10395_/A _10400_/C _10395_/C VDD VSS sg13g2_nor3_1
XFILLER_108_396 VDD VSS sg13g2_fill_1
XFILLER_2_630 VDD VSS sg13g2_decap_8
X_12134_ _12134_/X _13749_/Q _14101_/Q _14453_/Q _14549_/Q _12140_/S0 _12140_/S1 VDD
+ VSS sg13g2_mux4_1
XFILLER_89_98 VDD VSS sg13g2_decap_8
XFILLER_150_152 VDD VSS sg13g2_decap_8
XFILLER_97_729 VDD VSS sg13g2_fill_2
XFILLER_96_206 VDD VSS sg13g2_decap_8
XFILLER_1_140 VDD VSS sg13g2_decap_8
XFILLER_123_377 VDD VSS sg13g2_fill_2
XFILLER_133_1200 VDD VSS sg13g2_decap_8
X_12065_ _12065_/Y _12065_/A _12065_/B VDD VSS sg13g2_nand2_1
XFILLER_78_932 VDD VSS sg13g2_decap_8
XFILLER_49_100 VDD VSS sg13g2_fill_1
XFILLER_49_111 VDD VSS sg13g2_fill_1
XFILLER_150_196 VDD VSS sg13g2_decap_4
XFILLER_46_1274 VDD VSS sg13g2_decap_8
X_11016_ _11016_/Y _11042_/D _10995_/Y _11052_/D VDD VSS sg13g2_o21ai_1
XFILLER_81_1176 VDD VSS sg13g2_fill_1
X_16873_ _16873_/X _16873_/A VDD VSS sg13g2_buf_1
X_13842__2337 _13842_/RESET_B VDD VSS sg13g2_tiehi
XFILLER_77_475 VDD VSS sg13g2_decap_8
X_13988__2191 _13988_/RESET_B VDD VSS sg13g2_tiehi
XFILLER_133_1299 VDD VSS sg13g2_decap_8
X_14858__2828 _14858_/RESET_B VDD VSS sg13g2_tiehi
XFILLER_161_70 VDD VSS sg13g2_decap_8
XFILLER_38_91 VDD VSS sg13g2_decap_4
XFILLER_18_553 VDD VSS sg13g2_decap_8
X_12967_ _12967_/Y _12900_/A _12884_/C input5/X VDD VSS sg13g2_a21oi_1
XFILLER_80_618 VDD VSS sg13g2_decap_8
XFILLER_80_629 VDD VSS sg13g2_fill_1
X_14706_ _14706_/Q _14706_/CLK _14706_/D _14706_/RESET_B VDD VSS sg13g2_dfrbpq_1
X_11918_ _11918_/X _14575_/Q _14607_/Q _14639_/Q _14671_/Q _11925_/S0 _11925_/S1 VDD
+ VSS sg13g2_mux4_1
XFILLER_127_1004 VDD VSS sg13g2_fill_1
X_12898_ _12898_/Y _12895_/Y _12896_/Y _12897_/Y VDD VSS sg13g2_a21oi_1
XFILLER_61_854 VDD VSS sg13g2_decap_4
XFILLER_33_556 VDD VSS sg13g2_decap_8
XFILLER_21_707 VDD VSS sg13g2_decap_8
X_14637_ _14637_/Q clkload3/A _14637_/D _14637_/RESET_B VDD VSS sg13g2_dfrbpq_1
X_11849_ _11849_/X _13837_/Q _13869_/Q _13901_/Q _13933_/Q _11854_/S0 _07654_/A VDD
+ VSS sg13g2_mux4_1
XFILLER_14_770 VDD VSS sg13g2_decap_8
XFILLER_53_1223 VDD VSS sg13g2_decap_8
XFILLER_92_1283 VDD VSS sg13g2_decap_8
XFILLER_20_217 VDD VSS sg13g2_decap_8
XFILLER_60_397 VDD VSS sg13g2_decap_8
X_14568_ _14568_/Q _14728_/CLK _14568_/D _14568_/RESET_B VDD VSS sg13g2_dfrbpq_1
XFILLER_18_1365 VDD VSS sg13g2_decap_8
XFILLER_13_280 VDD VSS sg13g2_decap_8
XFILLER_14_1218 VDD VSS sg13g2_decap_8
XFILLER_158_263 VDD VSS sg13g2_decap_8
XFILLER_159_786 VDD VSS sg13g2_fill_2
X_13519_ _13519_/Y _13519_/A _13519_/B VDD VSS sg13g2_nor2_1
X_14499_ _14499_/Q clkload22/A _14499_/D _14499_/RESET_B VDD VSS sg13g2_dfrbpq_1
XFILLER_9_273 VDD VSS sg13g2_decap_8
Xclkload10 clkload10/Y clkload10/A VDD VSS sg13g2_inv_1
XFILLER_174_756 VDD VSS sg13g2_decap_8
Xclkload21 clkload21/Y clkload21/A VDD VSS sg13g2_inv_2
XFILLER_134_609 VDD VSS sg13g2_decap_4
Xclkload32 clkload32/Y clkload32/A VDD VSS sg13g2_inv_2
XFILLER_174_778 VDD VSS sg13g2_fill_2
XFILLER_174_789 VDD VSS sg13g2_fill_2
XFILLER_155_970 VDD VSS sg13g2_fill_2
Xclkload43 clkload43/Y clkload43/A VDD VSS sg13g2_inv_2
XFILLER_173_266 VDD VSS sg13g2_decap_8
Xclkload54 clkload54/X clkload54/A VDD VSS sg13g2_buf_8
Xclkload65 clkload65/Y clkload65/A VDD VSS sg13g2_inv_2
XFILLER_6_980 VDD VSS sg13g2_decap_8
XFILLER_138_1122 VDD VSS sg13g2_decap_8
XFILLER_142_631 VDD VSS sg13g2_decap_8
XFILLER_47_1005 VDD VSS sg13g2_decap_8
XFILLER_115_856 VDD VSS sg13g2_decap_8
XFILLER_5_490 VDD VSS sg13g2_decap_8
XFILLER_48_0 VDD VSS sg13g2_decap_8
XFILLER_138_1155 VDD VSS sg13g2_decap_4
XFILLER_142_664 VDD VSS sg13g2_fill_1
X_08991_ _08992_/B _15026_/Q _15223_/Q _09009_/S VDD VSS sg13g2_mux2_1
XFILLER_130_815 VDD VSS sg13g2_decap_8
XFILLER_88_729 VDD VSS sg13g2_fill_1
XFILLER_138_1177 VDD VSS sg13g2_fill_2
XFILLER_142_686 VDD VSS sg13g2_fill_1
XFILLER_134_1019 VDD VSS sg13g2_fill_2
XFILLER_138_1188 VDD VSS sg13g2_decap_8
XFILLER_141_163 VDD VSS sg13g2_decap_8
X_07942_ _07942_/Y _07942_/A VDD VSS sg13g2_inv_1
XFILLER_87_228 VDD VSS sg13g2_decap_8
XFILLER_69_932 VDD VSS sg13g2_decap_8
XFILLER_96_740 VDD VSS sg13g2_decap_8
XFILLER_69_965 VDD VSS sg13g2_fill_2
X_07873_ _08188_/B _07909_/B _07910_/A VDD VSS sg13g2_nor2_1
XFILLER_25_1358 VDD VSS sg13g2_decap_8
XFILLER_112_1328 VDD VSS sg13g2_decap_8
X_14432__1747 _14432_/RESET_B VDD VSS sg13g2_tiehi
X_09612_ _14208_/D _10076_/A0 _14208_/Q _09634_/S VDD VSS sg13g2_mux2_1
XFILLER_83_412 VDD VSS sg13g2_fill_1
XFILLER_18_28 VDD VSS sg13g2_decap_8
X_13818__2361 _13818_/RESET_B VDD VSS sg13g2_tiehi
XFILLER_84_946 VDD VSS sg13g2_decap_4
XFILLER_84_979 VDD VSS sg13g2_decap_8
X_09543_ _14141_/D _09609_/A0 _14141_/Q _09566_/S VDD VSS sg13g2_mux2_1
XFILLER_3_1176 VDD VSS sg13g2_decap_8
XFILLER_24_501 VDD VSS sg13g2_decap_8
X_09474_ _09474_/X _09905_/A _09938_/B _10037_/A _10137_/C VDD VSS sg13g2_or4_1
XFILLER_36_394 VDD VSS sg13g2_decap_4
XFILLER_24_556 VDD VSS sg13g2_fill_1
XFILLER_12_707 VDD VSS sg13g2_decap_8
X_08425_ _08441_/C _08659_/A _08058_/X _08676_/B2 VDD VSS sg13g2_o21ai_1
XFILLER_34_49 VDD VSS sg13g2_decap_8
XFILLER_169_539 VDD VSS sg13g2_decap_8
XFILLER_52_887 VDD VSS sg13g2_decap_8
XFILLER_11_217 VDD VSS sg13g2_decap_8
X_08356_ _08668_/B _08361_/A1 _08196_/Y _08241_/Y VDD VSS sg13g2_o21ai_1
XFILLER_165_712 VDD VSS sg13g2_decap_8
Xclkload4 clkload4/X clkload4/A VDD VSS sg13g2_buf_8
XFILLER_109_116 VDD VSS sg13g2_fill_2
X_08287_ _08287_/Y _07797_/A _07927_/Y _07932_/Y VDD VSS sg13g2_o21ai_1
XFILLER_126_7 VDD VSS sg13g2_decap_8
XFILLER_20_784 VDD VSS sg13g2_decap_8
XFILLER_164_266 VDD VSS sg13g2_decap_8
X_13920__2259 _13920_/RESET_B VDD VSS sg13g2_tiehi
XFILLER_4_917 VDD VSS sg13g2_decap_8
X_14680__1499 _14680_/RESET_B VDD VSS sg13g2_tiehi
XFILLER_146_981 VDD VSS sg13g2_decap_8
XFILLER_3_427 VDD VSS sg13g2_decap_8
XFILLER_106_845 VDD VSS sg13g2_decap_8
XFILLER_161_940 VDD VSS sg13g2_decap_8
XFILLER_106_856 VDD VSS sg13g2_fill_1
XFILLER_117_182 VDD VSS sg13g2_decap_8
XFILLER_161_973 VDD VSS sg13g2_decap_8
X_10180_ _14747_/D _10173_/Y _10176_/Y _10179_/Y VDD VSS sg13g2_o21ai_1
XFILLER_59_35 VDD VSS sg13g2_fill_2
XFILLER_105_366 VDD VSS sg13g2_fill_2
XFILLER_106_889 VDD VSS sg13g2_decap_8
XFILLER_161_984 VDD VSS sg13g2_fill_1
X_14969__2618 _14969_/RESET_B VDD VSS sg13g2_tiehi
XFILLER_156_1266 VDD VSS sg13g2_decap_8
XFILLER_117_1228 VDD VSS sg13g2_decap_8
XFILLER_120_303 VDD VSS sg13g2_decap_8
XFILLER_132_174 VDD VSS sg13g2_fill_2
Xfanout1206 _10342_/A _14798_/Q VDD VSS sg13g2_buf_1
Xfanout1217 _13129_/B _13672_/Q VDD VSS sg13g2_buf_1
Xfanout230 _09920_/A1 _10152_/A1 VDD VSS sg13g2_buf_1
Xfanout1228 _12118_/C _12334_/C VDD VSS sg13g2_buf_1
Xfanout241 _11341_/A2 _11247_/X VDD VSS sg13g2_buf_1
Xfanout1239 _11450_/A1 _13660_/Q VDD VSS sg13g2_buf_1
XFILLER_8_1043 VDD VSS sg13g2_decap_8
Xfanout252 _09918_/A1 _10150_/A1 VDD VSS sg13g2_buf_1
Xfanout263 _10068_/S _10037_/Y VDD VSS sg13g2_buf_1
XFILLER_59_453 VDD VSS sg13g2_fill_2
XFILLER_115_63 VDD VSS sg13g2_decap_4
Xfanout274 _09604_/S _09573_/X VDD VSS sg13g2_buf_1
Xfanout285 _09750_/A1 _09517_/A0 VDD VSS sg13g2_buf_1
XFILLER_75_924 VDD VSS sg13g2_decap_8
Xfanout296 _10144_/A1 _09001_/X VDD VSS sg13g2_buf_1
XFILLER_75_935 VDD VSS sg13g2_decap_4
X_13870_ _13870_/Q _14734_/CLK _13870_/D _13870_/RESET_B VDD VSS sg13g2_dfrbpq_1
XFILLER_74_423 VDD VSS sg13g2_fill_1
XFILLER_46_114 VDD VSS sg13g2_decap_8
X_14408__1771 _14408_/RESET_B VDD VSS sg13g2_tiehi
XFILLER_75_67 VDD VSS sg13g2_decap_4
XFILLER_46_147 VDD VSS sg13g2_fill_1
XFILLER_41_1171 VDD VSS sg13g2_decap_4
XFILLER_28_851 VDD VSS sg13g2_fill_2
X_12821_ _12821_/Y _14895_/Q _12836_/B VDD VSS sg13g2_nand2_1
XFILLER_27_350 VDD VSS sg13g2_decap_4
X_12752_ _12752_/X _13848_/Q _13880_/Q _13912_/Q _13944_/Q _12752_/S0 _12752_/S1 VDD
+ VSS sg13g2_mux4_1
XFILLER_76_1256 VDD VSS sg13g2_decap_8
XFILLER_42_331 VDD VSS sg13g2_decap_8
XFILLER_37_1207 VDD VSS sg13g2_decap_4
XFILLER_152_0 VDD VSS sg13g2_decap_8
X_11703_ _11771_/B _11635_/A _13681_/Q _13680_/Q _11661_/A VDD VSS sg13g2_a22oi_1
XFILLER_15_567 VDD VSS sg13g2_decap_8
XFILLER_43_876 VDD VSS sg13g2_decap_8
X_12683_ _12683_/X _13747_/Q _14099_/Q _14451_/Q _14547_/Q _12689_/S0 _12689_/S1 VDD
+ VSS sg13g2_mux4_1
XFILLER_42_375 VDD VSS sg13g2_decap_8
XFILLER_91_88 VDD VSS sg13g2_decap_8
X_14422_ _14422_/Q clkload28/A _14422_/D _14422_/RESET_B VDD VSS sg13g2_dfrbpq_1
XFILLER_70_695 VDD VSS sg13g2_fill_1
X_11634_ _11643_/A _11635_/A _13681_/Q VDD VSS sg13g2_xor2_1
XFILLER_129_904 VDD VSS sg13g2_decap_8
XFILLER_7_700 VDD VSS sg13g2_decap_8
X_14353_ _14353_/Q _14667_/CLK _14353_/D _14353_/RESET_B VDD VSS sg13g2_dfrbpq_1
XFILLER_129_948 VDD VSS sg13g2_decap_4
X_11565_ _11566_/B _11527_/Y _11722_/B2 _11564_/Y VDD VSS sg13g2_a21oi_1
XFILLER_11_784 VDD VSS sg13g2_decap_8
XFILLER_156_745 VDD VSS sg13g2_decap_8
XFILLER_6_210 VDD VSS sg13g2_decap_8
X_13304_ _13320_/A _13303_/A _13304_/B VDD VSS sg13g2_nand2b_1
X_10516_ _14854_/D _10453_/C _10521_/D _10499_/B _07623_/Y _10490_/A VDD VSS sg13g2_a221oi_1
XFILLER_10_294 VDD VSS sg13g2_decap_8
XFILLER_156_778 VDD VSS sg13g2_decap_8
X_14284_ _14284_/Q clkload35/A _14284_/D _14284_/RESET_B VDD VSS sg13g2_dfrbpq_1
X_11496_ _11496_/X _11486_/X _11487_/X _11490_/X _11491_/X _11443_/A _12293_/A1 VDD
+ VSS sg13g2_mux4_1
XFILLER_7_777 VDD VSS sg13g2_decap_8
XFILLER_137_981 VDD VSS sg13g2_decap_8
XFILLER_170_203 VDD VSS sg13g2_decap_8
X_14510__1669 _14510_/RESET_B VDD VSS sg13g2_tiehi
X_13235_ _13235_/Y _14827_/Q _13206_/B _13249_/B _14891_/Q _13274_/C1 VDD VSS sg13g2_a221oi_1
XFILLER_13_1295 VDD VSS sg13g2_decap_8
X_10447_ _14838_/D _10521_/C _10514_/A _10444_/B _07624_/Y _13141_/A VDD VSS sg13g2_a221oi_1
XFILLER_87_1352 VDD VSS sg13g2_fill_1
XFILLER_6_287 VDD VSS sg13g2_decap_8
XFILLER_48_1314 VDD VSS sg13g2_decap_8
XFILLER_171_759 VDD VSS sg13g2_decap_4
XFILLER_87_1374 VDD VSS sg13g2_decap_4
XFILLER_156_70 VDD VSS sg13g2_decap_8
XFILLER_83_1216 VDD VSS sg13g2_decap_8
XFILLER_112_804 VDD VSS sg13g2_fill_1
X_13166_ _13166_/Y _13166_/A1 _13161_/X _13165_/Y VDD VSS sg13g2_a21oi_1
XFILLER_41_7 VDD VSS sg13g2_decap_8
XFILLER_123_141 VDD VSS sg13g2_decap_8
X_10378_ _10379_/A _14815_/Q _14816_/Q _14817_/Q _10378_/D VDD VSS sg13g2_and4_1
XFILLER_123_152 VDD VSS sg13g2_fill_1
XFILLER_112_826 VDD VSS sg13g2_fill_1
XFILLER_123_163 VDD VSS sg13g2_decap_4
XFILLER_152_995 VDD VSS sg13g2_fill_2
XFILLER_170_1208 VDD VSS sg13g2_fill_2
XFILLER_112_837 VDD VSS sg13g2_decap_4
X_12117_ _12118_/B _12106_/Y _12108_/X _12332_/B1 VDD VSS sg13g2_o21ai_1
XFILLER_3_994 VDD VSS sg13g2_decap_8
XFILLER_111_325 VDD VSS sg13g2_decap_8
X_13097_ _13097_/Y _13094_/Y _13095_/Y _13096_/Y VDD VSS sg13g2_a21oi_1
XFILLER_46_1082 VDD VSS sg13g2_decap_8
X_12048_ _12048_/Y _12048_/A1 _12043_/X _12047_/Y VDD VSS sg13g2_a21oi_1
XFILLER_78_773 VDD VSS sg13g2_fill_2
XFILLER_133_1063 VDD VSS sg13g2_decap_8
XFILLER_38_626 VDD VSS sg13g2_decap_8
XFILLER_133_1074 VDD VSS sg13g2_fill_1
XFILLER_172_91 VDD VSS sg13g2_decap_8
XFILLER_133_1085 VDD VSS sg13g2_fill_2
X_16856_ _16856_/X _16856_/A VDD VSS sg13g2_buf_1
XFILLER_1_42 VDD VSS sg13g2_decap_8
XFILLER_20_1211 VDD VSS sg13g2_decap_8
XFILLER_19_840 VDD VSS sg13g2_decap_8
XFILLER_77_1009 VDD VSS sg13g2_fill_2
XFILLER_93_787 VDD VSS sg13g2_fill_1
XFILLER_65_478 VDD VSS sg13g2_decap_8
X_15108__2745 _15108_/RESET_B VDD VSS sg13g2_tiehi
XFILLER_93_798 VDD VSS sg13g2_decap_8
XFILLER_18_350 VDD VSS sg13g2_decap_8
X_13999_ _13999_/Q clkload6/A _13999_/D _13999_/RESET_B VDD VSS sg13g2_dfrbpq_1
XFILLER_111_1383 VDD VSS sg13g2_fill_1
XFILLER_92_286 VDD VSS sg13g2_decap_8
XFILLER_20_1288 VDD VSS sg13g2_decap_8
XFILLER_33_331 VDD VSS sg13g2_decap_8
XFILLER_21_504 VDD VSS sg13g2_decap_8
X_08210_ _08211_/A _08246_/A1 _08197_/X _08209_/X _08110_/D _08193_/Y VDD VSS sg13g2_a221oi_1
X_09190_ _13806_/D _13806_/Q _09859_/A1 _09202_/S VDD VSS sg13g2_mux2_1
XFILLER_18_1162 VDD VSS sg13g2_decap_8
XFILLER_14_1015 VDD VSS sg13g2_decap_8
XFILLER_159_572 VDD VSS sg13g2_decap_8
X_08141_ _08141_/Y _08522_/C _08140_/Y _08404_/B1 VDD VSS sg13g2_a21oi_1
XFILLER_53_1075 VDD VSS sg13g2_decap_8
XFILLER_140_1056 VDD VSS sg13g2_decap_8
X_08072_ _08078_/B _07882_/Y _08142_/A _08071_/Y _08073_/A _08070_/X VDD VSS sg13g2_a221oi_1
XFILLER_105_1198 VDD VSS sg13g2_decap_8
XFILLER_135_929 VDD VSS sg13g2_decap_8
XFILLER_31_1351 VDD VSS sg13g2_decap_8
XFILLER_88_1149 VDD VSS sg13g2_decap_4
XFILLER_161_203 VDD VSS sg13g2_decap_8
XFILLER_170_770 VDD VSS sg13g2_fill_1
XFILLER_88_515 VDD VSS sg13g2_fill_1
XFILLER_115_697 VDD VSS sg13g2_fill_1
X_08974_ _10675_/B _09009_/S _15023_/Q VDD VSS sg13g2_nor2_1
XFILLER_9_1330 VDD VSS sg13g2_decap_8
XFILLER_102_347 VDD VSS sg13g2_decap_4
XFILLER_130_667 VDD VSS sg13g2_decap_8
X_14665__1514 _14665_/RESET_B VDD VSS sg13g2_tiehi
X_07925_ _07925_/Y _07926_/A _07926_/B VDD VSS sg13g2_nor2_1
XFILLER_60_1013 VDD VSS sg13g2_fill_1
XFILLER_29_49 VDD VSS sg13g2_decap_8
XFILLER_130_678 VDD VSS sg13g2_fill_2
XFILLER_152_28 VDD VSS sg13g2_decap_8
XFILLER_60_1035 VDD VSS sg13g2_decap_8
XFILLER_25_1155 VDD VSS sg13g2_decap_8
XFILLER_99_1223 VDD VSS sg13g2_decap_8
XFILLER_84_721 VDD VSS sg13g2_decap_4
XFILLER_21_1008 VDD VSS sg13g2_decap_8
XFILLER_110_380 VDD VSS sg13g2_fill_2
X_07856_ _07856_/Y _07855_/A _07855_/B _08641_/A VDD VSS sg13g2_o21ai_1
XFILLER_57_957 VDD VSS sg13g2_decap_8
X_14094__2085 _14094_/RESET_B VDD VSS sg13g2_tiehi
XFILLER_112_1158 VDD VSS sg13g2_decap_8
XFILLER_95_1109 VDD VSS sg13g2_decap_8
XFILLER_84_776 VDD VSS sg13g2_decap_8
XFILLER_84_787 VDD VSS sg13g2_fill_2
X_07787_ _07796_/B _08414_/A _08414_/B VDD VSS sg13g2_nor2_1
XFILLER_71_415 VDD VSS sg13g2_decap_8
X_09526_ _14125_/D _09625_/A0 _14125_/Q _09530_/S VDD VSS sg13g2_mux2_1
XFILLER_43_128 VDD VSS sg13g2_decap_8
XFILLER_24_320 VDD VSS sg13g2_decap_8
XFILLER_52_640 VDD VSS sg13g2_fill_1
XFILLER_80_960 VDD VSS sg13g2_fill_1
XFILLER_25_865 VDD VSS sg13g2_decap_4
X_15033__2554 _15033_/RESET_B VDD VSS sg13g2_tiehi
X_09457_ _14058_/D _09622_/A0 _14058_/Q _09467_/S VDD VSS sg13g2_mux2_1
XFILLER_12_504 VDD VSS sg13g2_decap_8
XFILLER_169_336 VDD VSS sg13g2_decap_8
XFILLER_61_14 VDD VSS sg13g2_decap_8
X_08408_ _08408_/Y _08431_/C _08236_/X _08034_/Y VDD VSS sg13g2_o21ai_1
XFILLER_24_397 VDD VSS sg13g2_decap_8
XFILLER_40_857 VDD VSS sg13g2_fill_2
X_09388_ _13991_/D _09984_/A0 _13991_/Q _09403_/S VDD VSS sg13g2_mux2_1
X_08339_ _08339_/Y _08599_/B _08337_/X _08338_/Y VDD VSS sg13g2_o21ai_1
XFILLER_71_1175 VDD VSS sg13g2_decap_8
XFILLER_123_1265 VDD VSS sg13g2_fill_1
XFILLER_32_1159 VDD VSS sg13g2_fill_2
XFILLER_20_581 VDD VSS sg13g2_decap_8
XFILLER_165_553 VDD VSS sg13g2_decap_8
X_11350_ _11350_/Y _11350_/A1 _13790_/Q _11894_/B VDD VSS sg13g2_a21oi_1
XFILLER_138_789 VDD VSS sg13g2_decap_8
XFILLER_4_714 VDD VSS sg13g2_decap_8
X_10301_ _10301_/Y _14794_/Q _10299_/Y _10353_/C VDD VSS sg13g2_o21ai_1
XFILLER_119_992 VDD VSS sg13g2_decap_8
XFILLER_153_748 VDD VSS sg13g2_decap_8
XFILLER_106_620 VDD VSS sg13g2_decap_4
X_11281_ _11281_/Y _12307_/C _11277_/X _11280_/Y VDD VSS sg13g2_o21ai_1
XFILLER_3_224 VDD VSS sg13g2_decap_8
X_13020_ _13021_/B _07682_/A _13019_/Y _13012_/Y _13009_/Y _13016_/Y VDD VSS sg13g2_a221oi_1
XFILLER_69_1071 VDD VSS sg13g2_fill_1
X_10232_ _14772_/D _10232_/A _10232_/B _10441_/C VDD VSS sg13g2_and3_1
XFILLER_117_1003 VDD VSS sg13g2_fill_1
XFILLER_105_163 VDD VSS sg13g2_decap_8
XFILLER_117_1014 VDD VSS sg13g2_decap_4
XFILLER_105_174 VDD VSS sg13g2_fill_1
XFILLER_10_84 VDD VSS sg13g2_decap_8
XFILLER_133_483 VDD VSS sg13g2_fill_1
XFILLER_161_792 VDD VSS sg13g2_decap_8
XFILLER_133_494 VDD VSS sg13g2_decap_8
XFILLER_156_1085 VDD VSS sg13g2_fill_1
X_14926__2692 _14926_/RESET_B VDD VSS sg13g2_tiehi
Xfanout1003 _10776_/C _10793_/A VDD VSS sg13g2_buf_1
X_10163_ _14740_/D _14740_/Q _10163_/A1 _10163_/S VDD VSS sg13g2_mux2_1
XFILLER_86_11 VDD VSS sg13g2_fill_1
XFILLER_79_548 VDD VSS sg13g2_fill_2
XFILLER_126_73 VDD VSS sg13g2_fill_2
Xfanout1014 _10781_/B _09016_/C VDD VSS sg13g2_buf_1
Xfanout1025 _08692_/C _15020_/Q VDD VSS sg13g2_buf_1
XFILLER_120_144 VDD VSS sg13g2_decap_4
XFILLER_121_667 VDD VSS sg13g2_decap_8
Xfanout1036 _08201_/A _08174_/A VDD VSS sg13g2_buf_1
XFILLER_94_507 VDD VSS sg13g2_decap_8
XFILLER_0_975 VDD VSS sg13g2_decap_8
Xfanout1047 _13529_/A _08161_/A2 VDD VSS sg13g2_buf_1
XFILLER_120_166 VDD VSS sg13g2_fill_2
X_14971_ _14971_/Q _15247_/CLK _14971_/D _14971_/RESET_B VDD VSS sg13g2_dfrbpq_1
X_10094_ _14674_/D _10161_/A1 _14674_/Q _10098_/S VDD VSS sg13g2_mux2_1
Xfanout1058 _08103_/B _08377_/B VDD VSS sg13g2_buf_1
XFILLER_48_924 VDD VSS sg13g2_decap_8
Xfanout1069 _07884_/A _08207_/S1 VDD VSS sg13g2_buf_1
X_13922_ _13922_/Q clkload31/A _13922_/D _13922_/RESET_B VDD VSS sg13g2_dfrbpq_1
XFILLER_101_391 VDD VSS sg13g2_decap_4
XFILLER_130_1247 VDD VSS sg13g2_decap_8
XFILLER_19_147 VDD VSS sg13g2_decap_8
XFILLER_130_1258 VDD VSS sg13g2_fill_1
XFILLER_90_702 VDD VSS sg13g2_decap_8
XFILLER_63_927 VDD VSS sg13g2_fill_2
X_13853_ _13853_/Q clkload45/A _13853_/D _13853_/RESET_B VDD VSS sg13g2_dfrbpq_1
XFILLER_56_990 VDD VSS sg13g2_decap_8
X_12804_ _12804_/Y input4/X _12841_/B _12803_/X input34/X _12800_/X VDD VSS sg13g2_a221oi_1
XFILLER_16_854 VDD VSS sg13g2_decap_8
X_13784_ _13784_/Q clkload23/A _13784_/D _13784_/RESET_B VDD VSS sg13g2_dfrbpq_1
X_10996_ _10996_/Y _11043_/A _10996_/B VDD VSS sg13g2_nand2_1
XFILLER_43_662 VDD VSS sg13g2_fill_1
XFILLER_35_70 VDD VSS sg13g2_decap_8
XFILLER_15_364 VDD VSS sg13g2_decap_8
XFILLER_163_1023 VDD VSS sg13g2_fill_2
X_12735_ _12736_/B _13666_/Q _12763_/A2 _12734_/X _12415_/A _12763_/C1 VDD VSS sg13g2_a221oi_1
XFILLER_37_1026 VDD VSS sg13g2_decap_8
XFILLER_163_1034 VDD VSS sg13g2_fill_2
XFILLER_37_1037 VDD VSS sg13g2_fill_2
XFILLER_30_312 VDD VSS sg13g2_fill_2
X_12666_ _15011_/D _12666_/A _12666_/B VDD VSS sg13g2_nor2_1
XFILLER_54_1340 VDD VSS sg13g2_decap_8
XFILLER_15_1302 VDD VSS sg13g2_decap_8
X_13792__2387 _13792_/RESET_B VDD VSS sg13g2_tiehi
XFILLER_54_1351 VDD VSS sg13g2_fill_1
XFILLER_30_345 VDD VSS sg13g2_fill_2
XFILLER_129_712 VDD VSS sg13g2_decap_8
XFILLER_89_7 VDD VSS sg13g2_decap_8
X_14405_ _14405_/Q clkload7/A _14405_/D _14405_/RESET_B VDD VSS sg13g2_dfrbpq_1
X_14818__2895 _14818_/RESET_B VDD VSS sg13g2_tiehi
X_11617_ _11617_/Y _12040_/A1 _13862_/Q _12038_/B1 VDD VSS sg13g2_a21oi_1
XFILLER_50_1215 VDD VSS sg13g2_fill_2
X_12597_ _15006_/D _12597_/A _12597_/B VDD VSS sg13g2_nor2_1
XFILLER_11_581 VDD VSS sg13g2_decap_8
X_14743__1436 _14743_/RESET_B VDD VSS sg13g2_tiehi
XFILLER_15_1379 VDD VSS sg13g2_fill_1
X_14336_ _14336_/Q clkload27/A _14336_/D _14336_/RESET_B VDD VSS sg13g2_dfrbpq_1
X_11548_ _11549_/A _14244_/Q _14276_/Q _14308_/Q _14340_/Q _11649_/S0 _12138_/S1 VDD
+ VSS sg13g2_mux4_1
XFILLER_156_586 VDD VSS sg13g2_fill_1
XFILLER_7_574 VDD VSS sg13g2_decap_8
XFILLER_167_91 VDD VSS sg13g2_decap_8
XFILLER_171_523 VDD VSS sg13g2_decap_8
XFILLER_144_748 VDD VSS sg13g2_decap_8
X_14267_ _14267_/Q _14653_/CLK _14267_/D _14267_/RESET_B VDD VSS sg13g2_dfrbpq_1
XFILLER_13_1092 VDD VSS sg13g2_decap_8
X_11479_ _11479_/Y _14900_/Q _11433_/B _11500_/B2 VDD VSS sg13g2_a21oi_1
XFILLER_143_258 VDD VSS sg13g2_decap_8
X_13218_ _13218_/Y _14858_/Q _13234_/B VDD VSS sg13g2_nand2_1
X_14198_ _14198_/Q _14984_/CLK _14198_/D _14198_/RESET_B VDD VSS sg13g2_dfrbpq_1
XFILLER_124_472 VDD VSS sg13g2_decap_8
XFILLER_174_1152 VDD VSS sg13g2_decap_8
XFILLER_112_623 VDD VSS sg13g2_decap_8
XFILLER_139_1283 VDD VSS sg13g2_decap_8
XFILLER_174_1163 VDD VSS sg13g2_decap_8
X_13149_ _13149_/X input18/X _13272_/A2 _13272_/B1 VDD VSS sg13g2_a21o_1
XFILLER_48_1177 VDD VSS sg13g2_decap_8
XFILLER_83_1068 VDD VSS sg13g2_decap_8
XFILLER_3_791 VDD VSS sg13g2_decap_8
XFILLER_140_965 VDD VSS sg13g2_fill_1
XFILLER_112_678 VDD VSS sg13g2_decap_8
XFILLER_140_987 VDD VSS sg13g2_fill_2
XFILLER_39_902 VDD VSS sg13g2_decap_8
XFILLER_57_209 VDD VSS sg13g2_fill_2
XFILLER_61_1344 VDD VSS sg13g2_decap_4
X_07710_ _07710_/Y _10172_/A _13281_/C VDD VSS sg13g2_nor2_1
XFILLER_22_1317 VDD VSS sg13g2_decap_8
XFILLER_111_199 VDD VSS sg13g2_decap_8
X_08690_ _08690_/X _15103_/Q _15090_/Q _08690_/C VDD VSS sg13g2_or3_1
X_07641_ _10265_/B _14782_/Q VDD VSS sg13g2_inv_1
XFILLER_93_562 VDD VSS sg13g2_decap_4
XFILLER_4_1260 VDD VSS sg13g2_decap_8
XFILLER_65_286 VDD VSS sg13g2_fill_1
XFILLER_81_746 VDD VSS sg13g2_decap_8
XFILLER_80_234 VDD VSS sg13g2_decap_8
XFILLER_0_1157 VDD VSS sg13g2_decap_8
XFILLER_80_245 VDD VSS sg13g2_fill_2
XFILLER_20_1085 VDD VSS sg13g2_decap_8
X_09311_ _13918_/D _10141_/A1 _13918_/Q _09325_/S VDD VSS sg13g2_mux2_1
XFILLER_94_1175 VDD VSS sg13g2_fill_2
XFILLER_59_1295 VDD VSS sg13g2_decap_4
XFILLER_21_301 VDD VSS sg13g2_decap_8
X_14079__2100 _14079_/RESET_B VDD VSS sg13g2_tiehi
X_09242_ _13851_/D _13851_/Q _09906_/A1 _09267_/S VDD VSS sg13g2_mux2_1
XFILLER_167_829 VDD VSS sg13g2_decap_8
XFILLER_142_1129 VDD VSS sg13g2_decap_8
X_14382__1797 _14382_/RESET_B VDD VSS sg13g2_tiehi
X_09173_ _13789_/D _13789_/Q _09908_/A1 _09202_/S VDD VSS sg13g2_mux2_1
XFILLER_21_378 VDD VSS sg13g2_decap_8
XFILLER_31_28 VDD VSS sg13g2_decap_8
X_08124_ _08124_/X _08635_/A1 _08686_/A3 _08010_/B _12278_/A _08009_/S _08124_/S1
+ VDD VSS sg13g2_mux4_1
XFILLER_147_28 VDD VSS sg13g2_decap_8
X_14719__1460 _14719_/RESET_B VDD VSS sg13g2_tiehi
XFILLER_174_361 VDD VSS sg13g2_decap_4
XFILLER_162_523 VDD VSS sg13g2_decap_8
X_08055_ _08167_/B _07859_/B _08620_/A1 _08012_/B _07972_/B _08054_/B _08669_/B1 VDD
+ VSS sg13g2_mux4_1
X_14002__2177 _14002_/RESET_B VDD VSS sg13g2_tiehi
XFILLER_66_1222 VDD VSS sg13g2_fill_1
XFILLER_118_1301 VDD VSS sg13g2_fill_1
XFILLER_150_729 VDD VSS sg13g2_decap_4
XFILLER_116_984 VDD VSS sg13g2_fill_1
XFILLER_118_1312 VDD VSS sg13g2_fill_2
XFILLER_143_770 VDD VSS sg13g2_fill_1
Xoutput39 mem_axi_araddr[10] _16863_/A VDD VSS sg13g2_buf_1
Xhold3100 _13622_/A _13730_/Q VDD VSS sg13g2_dlygate4sd3_1
XFILLER_88_301 VDD VSS sg13g2_decap_4
XFILLER_66_1255 VDD VSS sg13g2_decap_8
XFILLER_1_728 VDD VSS sg13g2_decap_8
Xhold3111 _13619_/A _13727_/Q VDD VSS sg13g2_dlygate4sd3_1
XFILLER_118_1334 VDD VSS sg13g2_decap_8
Xhold3122 _13645_/A _13753_/Q VDD VSS sg13g2_dlygate4sd3_1
XFILLER_130_420 VDD VSS sg13g2_fill_1
Xhold3133 _10987_/A _14941_/Q VDD VSS sg13g2_dlygate4sd3_1
XFILLER_0_238 VDD VSS sg13g2_decap_8
XFILLER_103_645 VDD VSS sg13g2_fill_2
Xhold3144 _10774_/A _14920_/Q VDD VSS sg13g2_dlygate4sd3_1
XFILLER_163_49 VDD VSS sg13g2_decap_8
XFILLER_103_667 VDD VSS sg13g2_decap_8
Xhold3155 hold3155/X _15167_/Q VDD VSS sg13g2_dlygate4sd3_1
XFILLER_88_356 VDD VSS sg13g2_fill_2
Xhold3166 _13543_/A _15146_/Q VDD VSS sg13g2_dlygate4sd3_1
XFILLER_102_155 VDD VSS sg13g2_decap_4
X_08957_ _10137_/B _09905_/A _09938_/B VDD VSS sg13g2_nand2b_1
XFILLER_102_177 VDD VSS sg13g2_fill_2
XFILLER_130_486 VDD VSS sg13g2_decap_4
XFILLER_57_710 VDD VSS sg13g2_fill_2
XFILLER_56_14 VDD VSS sg13g2_decap_8
X_07908_ _13290_/A _07908_/A _07908_/B VDD VSS sg13g2_nand2_1
X_08888_ _08888_/Y _13608_/A1 _08835_/B _16867_/A VDD VSS sg13g2_a21oi_1
XFILLER_5_1057 VDD VSS sg13g2_decap_8
XFILLER_45_905 VDD VSS sg13g2_fill_2
XFILLER_57_776 VDD VSS sg13g2_decap_8
X_07839_ _07969_/A _07979_/C _07981_/C _08697_/B _08698_/A VDD VSS sg13g2_nand4_1
XFILLER_44_404 VDD VSS sg13g2_decap_4
XFILLER_29_489 VDD VSS sg13g2_decap_8
X_10850_ _10850_/Y _10850_/A _10862_/B VDD VSS sg13g2_nand2_1
XFILLER_147_1018 VDD VSS sg13g2_decap_8
XFILLER_71_234 VDD VSS sg13g2_decap_8
XFILLER_53_960 VDD VSS sg13g2_decap_4
XFILLER_164_1321 VDD VSS sg13g2_fill_1
X_09509_ _14108_/D _09608_/A0 _14108_/Q _09533_/S VDD VSS sg13g2_mux2_1
XFILLER_72_35 VDD VSS sg13g2_decap_4
X_10781_ _10781_/X _10781_/A _10781_/B _10781_/C VDD VSS sg13g2_and3_1
XFILLER_12_301 VDD VSS sg13g2_decap_8
XFILLER_53_993 VDD VSS sg13g2_decap_8
XFILLER_24_161 VDD VSS sg13g2_decap_8
XFILLER_169_133 VDD VSS sg13g2_decap_8
XFILLER_158_807 VDD VSS sg13g2_fill_1
X_12520_ _12520_/X _13735_/Q _14087_/Q _14439_/Q _14535_/Q _12522_/S0 _12522_/S1 VDD
+ VSS sg13g2_mux4_1
XFILLER_38_1368 VDD VSS sg13g2_decap_8
XFILLER_73_1259 VDD VSS sg13g2_decap_8
XFILLER_13_868 VDD VSS sg13g2_decap_8
XFILLER_157_317 VDD VSS sg13g2_decap_4
X_14212__1967 _14212_/RESET_B VDD VSS sg13g2_tiehi
X_12451_ _12451_/X _14370_/Q _14402_/Q _14466_/Q _14498_/Q _12452_/S0 _12452_/S1 VDD
+ VSS sg13g2_mux4_1
XFILLER_12_378 VDD VSS sg13g2_decap_8
XFILLER_138_520 VDD VSS sg13g2_fill_1
XFILLER_40_687 VDD VSS sg13g2_fill_1
XFILLER_138_531 VDD VSS sg13g2_fill_1
XFILLER_166_840 VDD VSS sg13g2_fill_2
Xclkbuf_leaf_51_clk_i _15228_/CLK clkbuf_leaf_52_clk_i/A VDD VSS sg13g2_buf_8
X_11402_ _11402_/Y _11397_/Y _11398_/Y _11745_/B VDD VSS sg13g2_a21oi_1
X_15170_ _15170_/Q _15183_/CLK _15170_/D _15170_/RESET_B VDD VSS sg13g2_dfrbpq_1
XFILLER_165_350 VDD VSS sg13g2_decap_8
X_12382_ _12382_/X _14237_/Q _14269_/Q _14301_/Q _14333_/Q _12382_/S0 _12382_/S1 VDD
+ VSS sg13g2_mux4_1
X_15072__2861 _15072_/RESET_B VDD VSS sg13g2_tiehi
XFILLER_158_1103 VDD VSS sg13g2_decap_8
X_14121_ _14121_/Q _14649_/CLK _14121_/D _14121_/RESET_B VDD VSS sg13g2_dfrbpq_1
XFILLER_115_0 VDD VSS sg13g2_decap_8
XFILLER_153_523 VDD VSS sg13g2_decap_8
X_11333_ _11333_/Y _12835_/A _12338_/A2 _07684_/B VDD VSS sg13g2_a21oi_1
XFILLER_4_511 VDD VSS sg13g2_decap_8
XFILLER_10_1232 VDD VSS sg13g2_decap_8
XFILLER_158_1136 VDD VSS sg13g2_fill_1
X_13777__2402 _13777_/RESET_B VDD VSS sg13g2_tiehi
XFILLER_84_1300 VDD VSS sg13g2_fill_1
X_14052_ _14052_/Q clkload17/A _14052_/D _14052_/RESET_B VDD VSS sg13g2_dfrbpq_1
XFILLER_107_973 VDD VSS sg13g2_decap_8
Xclkbuf_leaf_66_clk_i clkload66/A clkbuf_leaf_83_clk_i/A VDD VSS sg13g2_buf_8
X_11264_ _11264_/X _11259_/Y _11260_/Y _11266_/B VDD VSS sg13g2_a21o_1
XFILLER_134_770 VDD VSS sg13g2_decap_4
X_15133__2691 _15133_/RESET_B VDD VSS sg13g2_tiehi
X_13003_ _13003_/Y _13000_/Y _13001_/Y _13002_/Y VDD VSS sg13g2_a21oi_1
XFILLER_4_588 VDD VSS sg13g2_decap_8
X_10215_ _14764_/D _10213_/A _10209_/B hold3019/X VDD VSS sg13g2_a21oi_1
X_11195_ _14955_/D _07614_/Y _10671_/Y _11194_/Y VDD VSS sg13g2_o21ai_1
XFILLER_122_965 VDD VSS sg13g2_decap_8
XFILLER_121_453 VDD VSS sg13g2_decap_4
X_10146_ _14723_/D _14723_/Q _10146_/A1 _10168_/S VDD VSS sg13g2_mux2_1
XFILLER_79_378 VDD VSS sg13g2_decap_4
XFILLER_171_1369 VDD VSS sg13g2_decap_4
XFILLER_0_772 VDD VSS sg13g2_decap_8
X_14157__2022 _14157_/RESET_B VDD VSS sg13g2_tiehi
XFILLER_82_1090 VDD VSS sg13g2_decap_8
XFILLER_94_348 VDD VSS sg13g2_decap_8
X_14954_ _14954_/Q clkload54/A _14954_/D _14954_/RESET_B VDD VSS sg13g2_dfrbpq_1
X_10077_ _14657_/D _10077_/A0 _14657_/Q _10101_/S VDD VSS sg13g2_mux2_1
XFILLER_47_220 VDD VSS sg13g2_fill_2
X_13672__2528 _13672_/RESET_B VDD VSS sg13g2_tiehi
X_13700__2479 _13700_/RESET_B VDD VSS sg13g2_tiehi
XFILLER_48_776 VDD VSS sg13g2_decap_8
X_13905_ _13905_/Q _14662_/CLK _13905_/D _13905_/RESET_B VDD VSS sg13g2_dfrbpq_1
XFILLER_78_1115 VDD VSS sg13g2_decap_8
XFILLER_47_253 VDD VSS sg13g2_decap_4
X_14885_ _14885_/Q _14885_/CLK _14885_/D _14885_/RESET_B VDD VSS sg13g2_dfrbpq_1
XFILLER_75_584 VDD VSS sg13g2_decap_8
XFILLER_35_415 VDD VSS sg13g2_decap_4
XFILLER_63_735 VDD VSS sg13g2_decap_8
XFILLER_21_1372 VDD VSS sg13g2_decap_8
X_13836_ _13836_/Q clkload37/A _13836_/D _13836_/RESET_B VDD VSS sg13g2_dfrbpq_1
XFILLER_21_1383 VDD VSS sg13g2_fill_1
XFILLER_62_245 VDD VSS sg13g2_fill_1
XFILLER_46_91 VDD VSS sg13g2_decap_4
XFILLER_169_1298 VDD VSS sg13g2_decap_8
XFILLER_16_651 VDD VSS sg13g2_decap_8
X_13767_ _13767_/Q _14727_/CLK _13767_/D _13767_/RESET_B VDD VSS sg13g2_dfrbpq_1
X_10979_ _10979_/Y _14759_/Q _11015_/C _11009_/D VDD VSS sg13g2_o21ai_1
XFILLER_31_610 VDD VSS sg13g2_decap_8
XFILLER_15_161 VDD VSS sg13g2_decap_8
XFILLER_91_1337 VDD VSS sg13g2_decap_8
XFILLER_43_470 VDD VSS sg13g2_decap_8
XFILLER_71_790 VDD VSS sg13g2_fill_2
X_12718_ _12718_/X _12713_/X _12715_/X _12712_/X _12714_/X _12692_/S _12719_/S0 VDD
+ VSS sg13g2_mux4_1
X_13698_ _16860_/A _15226_/CLK _13698_/D _13698_/RESET_B VDD VSS sg13g2_dfrbpq_1
Xclkbuf_leaf_19_clk_i clkload26/A clkbuf_leaf_47_clk_i/A VDD VSS sg13g2_buf_8
XFILLER_129_520 VDD VSS sg13g2_decap_4
X_12649_ _12649_/X _12647_/X _12646_/X _12643_/X _12642_/X _12649_/S0 _12539_/S VDD
+ VSS sg13g2_mux4_1
X_14964__2623 _14964_/RESET_B VDD VSS sg13g2_tiehi
XFILLER_8_861 VDD VSS sg13g2_decap_8
XFILLER_89_1222 VDD VSS sg13g2_decap_8
XFILLER_129_575 VDD VSS sg13g2_fill_1
XFILLER_15_1176 VDD VSS sg13g2_decap_8
XFILLER_129_586 VDD VSS sg13g2_fill_2
XFILLER_11_1029 VDD VSS sg13g2_decap_8
XFILLER_7_63 VDD VSS sg13g2_decap_8
XFILLER_50_1089 VDD VSS sg13g2_fill_2
X_14319_ _14319_/Q _14725_/CLK _14319_/D _14319_/RESET_B VDD VSS sg13g2_dfrbpq_1
XFILLER_7_371 VDD VSS sg13g2_decap_8
XFILLER_144_545 VDD VSS sg13g2_decap_8
XFILLER_171_320 VDD VSS sg13g2_decap_8
XFILLER_102_1179 VDD VSS sg13g2_decap_8
XFILLER_116_247 VDD VSS sg13g2_fill_2
X_14367__1812 _14367_/RESET_B VDD VSS sg13g2_tiehi
XFILLER_116_269 VDD VSS sg13g2_decap_8
XFILLER_98_610 VDD VSS sg13g2_decap_8
XFILLER_171_397 VDD VSS sg13g2_decap_8
Xfanout807 _12562_/S1 fanout816/X VDD VSS sg13g2_buf_1
X_09860_ _14447_/D _14447_/Q _10091_/A0 _09863_/S VDD VSS sg13g2_mux2_1
XFILLER_112_420 VDD VSS sg13g2_fill_2
Xfanout818 _12592_/S1 _12614_/S1 VDD VSS sg13g2_buf_1
XFILLER_112_442 VDD VSS sg13g2_decap_8
Xfanout829 _12782_/S1 fanout849/X VDD VSS sg13g2_buf_1
XFILLER_98_665 VDD VSS sg13g2_decap_8
XFILLER_30_0 VDD VSS sg13g2_decap_8
X_08811_ _13688_/D _08811_/A _08811_/B VDD VSS sg13g2_nor2_1
X_09791_ _14380_/D _09923_/A1 _14380_/Q _09799_/S VDD VSS sg13g2_mux2_1
XFILLER_86_849 VDD VSS sg13g2_fill_1
XFILLER_85_326 VDD VSS sg13g2_decap_8
X_08742_ _08742_/Y _07720_/A _08754_/A2 _15196_/Q VDD VSS sg13g2_o21ai_1
XFILLER_97_197 VDD VSS sg13g2_decap_8
XFILLER_6_1344 VDD VSS sg13g2_decap_8
XFILLER_113_1231 VDD VSS sg13g2_decap_8
XFILLER_22_1114 VDD VSS sg13g2_decap_8
XFILLER_26_1294 VDD VSS sg13g2_decap_8
X_15047__2531 _15047_/RESET_B VDD VSS sg13g2_tiehi
X_08673_ _08673_/X _15019_/Q _08673_/B VDD VSS sg13g2_or2_1
XFILLER_38_264 VDD VSS sg13g2_decap_4
XFILLER_66_584 VDD VSS sg13g2_decap_4
XFILLER_81_510 VDD VSS sg13g2_decap_8
XFILLER_26_28 VDD VSS sg13g2_decap_8
X_07624_ _07624_/Y _14838_/Q VDD VSS sg13g2_inv_1
XFILLER_38_297 VDD VSS sg13g2_decap_8
XFILLER_53_256 VDD VSS sg13g2_decap_4
XFILLER_59_1070 VDD VSS sg13g2_decap_8
XFILLER_53_289 VDD VSS sg13g2_fill_2
X_13855__2324 _13855_/RESET_B VDD VSS sg13g2_tiehi
XFILLER_107_1024 VDD VSS sg13g2_decap_8
XFILLER_139_317 VDD VSS sg13g2_fill_2
XFILLER_167_626 VDD VSS sg13g2_fill_2
XFILLER_50_963 VDD VSS sg13g2_fill_2
XFILLER_107_1046 VDD VSS sg13g2_decap_8
XFILLER_10_805 VDD VSS sg13g2_decap_8
X_09225_ _13836_/D _10155_/A1 _13836_/Q _09233_/S VDD VSS sg13g2_mux2_1
XFILLER_42_49 VDD VSS sg13g2_decap_8
XFILLER_107_1057 VDD VSS sg13g2_fill_2
XFILLER_107_1068 VDD VSS sg13g2_fill_2
XFILLER_21_175 VDD VSS sg13g2_decap_8
XFILLER_158_49 VDD VSS sg13g2_decap_8
XFILLER_166_147 VDD VSS sg13g2_decap_8
X_09156_ _09158_/B _14924_/Q _09156_/B VDD VSS sg13g2_nand2b_1
XFILLER_120_1224 VDD VSS sg13g2_fill_2
XFILLER_5_308 VDD VSS sg13g2_decap_8
XFILLER_120_1235 VDD VSS sg13g2_decap_8
XFILLER_148_895 VDD VSS sg13g2_decap_8
XFILLER_108_737 VDD VSS sg13g2_decap_8
XFILLER_120_1246 VDD VSS sg13g2_fill_1
X_08107_ _08112_/D _07879_/A _08103_/B _08106_/Y VDD VSS sg13g2_o21ai_1
XFILLER_162_320 VDD VSS sg13g2_decap_8
X_09087_ _09090_/B _14914_/Q _09087_/B VDD VSS sg13g2_nand2b_1
XFILLER_174_180 VDD VSS sg13g2_decap_8
XFILLER_135_545 VDD VSS sg13g2_decap_8
XFILLER_174_191 VDD VSS sg13g2_decap_8
X_08038_ _08039_/D _08142_/A _07896_/X _08037_/A _08404_/B1 VDD VSS sg13g2_a22oi_1
XFILLER_123_729 VDD VSS sg13g2_decap_4
XFILLER_104_910 VDD VSS sg13g2_fill_2
XFILLER_122_206 VDD VSS sg13g2_fill_2
XFILLER_89_610 VDD VSS sg13g2_decap_8
XFILLER_104_921 VDD VSS sg13g2_fill_1
XFILLER_150_526 VDD VSS sg13g2_decap_8
XFILLER_162_397 VDD VSS sg13g2_decap_8
XFILLER_1_525 VDD VSS sg13g2_decap_8
XFILLER_115_280 VDD VSS sg13g2_decap_8
XFILLER_118_1131 VDD VSS sg13g2_decap_8
XFILLER_118_1142 VDD VSS sg13g2_fill_2
XFILLER_104_976 VDD VSS sg13g2_fill_2
X_10000_ _14583_/D _10099_/A0 _14583_/Q _10002_/S VDD VSS sg13g2_mux2_1
XFILLER_89_665 VDD VSS sg13g2_decap_8
XFILLER_104_987 VDD VSS sg13g2_decap_8
XFILLER_153_1044 VDD VSS sg13g2_fill_1
XFILLER_89_676 VDD VSS sg13g2_fill_1
XFILLER_27_1047 VDD VSS sg13g2_decap_8
XFILLER_67_35 VDD VSS sg13g2_decap_8
X_09989_ _14572_/D _10088_/A0 _14572_/Q _09997_/S VDD VSS sg13g2_mux2_1
XFILLER_88_186 VDD VSS sg13g2_decap_8
XFILLER_153_1099 VDD VSS sg13g2_decap_4
XFILLER_29_231 VDD VSS sg13g2_decap_8
XFILLER_91_318 VDD VSS sg13g2_fill_2
XFILLER_123_63 VDD VSS sg13g2_decap_8
X_11951_ _11952_/B _12025_/A _14672_/Q VDD VSS sg13g2_nand2_1
XFILLER_18_938 VDD VSS sg13g2_decap_8
XFILLER_40_1269 VDD VSS sg13g2_fill_1
XFILLER_44_212 VDD VSS sg13g2_decap_4
X_10902_ _14934_/D _14934_/Q _10941_/B _10901_/Y VDD VSS sg13g2_a21o_1
XFILLER_84_392 VDD VSS sg13g2_fill_1
XFILLER_17_448 VDD VSS sg13g2_decap_8
X_14670_ _14670_/Q clkload39/A _14670_/D _14670_/RESET_B VDD VSS sg13g2_dfrbpq_1
X_11882_ _11882_/X _13742_/Q _14094_/Q _14446_/Q _14542_/Q _11893_/S _11897_/C VDD
+ VSS sg13g2_mux4_1
XFILLER_33_919 VDD VSS sg13g2_fill_2
XFILLER_44_256 VDD VSS sg13g2_decap_4
X_13621_ _13729_/D _13621_/A VDD VSS sg13g2_buf_1
X_10833_ _10876_/D _10844_/A _10844_/B _10851_/D VDD VSS sg13g2_nand3_1
XFILLER_77_1170 VDD VSS sg13g2_decap_8
XFILLER_38_1121 VDD VSS sg13g2_decap_8
XFILLER_32_429 VDD VSS sg13g2_decap_8
XFILLER_26_993 VDD VSS sg13g2_fill_2
XFILLER_53_790 VDD VSS sg13g2_decap_4
X_14445__1734 _14445_/RESET_B VDD VSS sg13g2_tiehi
XFILLER_129_1271 VDD VSS sg13g2_fill_2
XFILLER_129_1282 VDD VSS sg13g2_decap_8
X_13552_ _13552_/Y _15006_/Q _13552_/B _13563_/C VDD VSS sg13g2_nor3_1
X_10764_ _10764_/X _14949_/Q _10767_/A _10762_/Y VDD VSS sg13g2_a21o_1
XFILLER_125_1135 VDD VSS sg13g2_decap_8
XFILLER_13_665 VDD VSS sg13g2_decap_8
XFILLER_38_1198 VDD VSS sg13g2_decap_8
XFILLER_160_1037 VDD VSS sg13g2_decap_4
X_12503_ _12503_/X _13830_/Q _13862_/Q _13894_/Q _13926_/Q _12674_/S0 _12674_/S1 VDD
+ VSS sg13g2_mux4_1
XFILLER_73_1089 VDD VSS sg13g2_decap_8
X_13483_ _13484_/C _13412_/B _13483_/A2 _15123_/Q VDD VSS sg13g2_o21ai_1
XFILLER_12_175 VDD VSS sg13g2_decap_8
XFILLER_139_840 VDD VSS sg13g2_fill_2
X_10695_ _10696_/A _14901_/Q _10862_/B _07753_/B _10871_/A VDD VSS sg13g2_a22oi_1
XFILLER_125_1179 VDD VSS sg13g2_fill_1
XFILLER_157_147 VDD VSS sg13g2_decap_8
XFILLER_160_1059 VDD VSS sg13g2_decap_4
XFILLER_9_658 VDD VSS sg13g2_decap_8
XFILLER_157_158 VDD VSS sg13g2_fill_1
XFILLER_173_607 VDD VSS sg13g2_fill_1
X_15222_ _15222_/Q clkload61/A _15222_/D _15222_/RESET_B VDD VSS sg13g2_dfrbpq_1
X_12434_ _12434_/X _14689_/Q _14721_/Q _13761_/Q _13793_/Q _12450_/S0 _12450_/S1 VDD
+ VSS sg13g2_mux4_1
XFILLER_12_1316 VDD VSS sg13g2_decap_8
XFILLER_139_884 VDD VSS sg13g2_decap_8
XFILLER_8_168 VDD VSS sg13g2_decap_8
X_15153_ _15153_/Q clkload68/A _15153_/D _15153_/RESET_B VDD VSS sg13g2_dfrbpq_1
X_12365_ _12365_/X _14556_/Q _14588_/Q _14620_/Q _14652_/Q _12783_/S0 _12783_/S1 VDD
+ VSS sg13g2_mux4_1
XFILLER_148_93 VDD VSS sg13g2_decap_8
XFILLER_126_567 VDD VSS sg13g2_fill_1
XFILLER_154_876 VDD VSS sg13g2_fill_2
X_14104_ _14104_/Q clkload23/A _14104_/D _14104_/RESET_B VDD VSS sg13g2_dfrbpq_1
X_11316_ _11318_/B _11328_/S0 _14461_/Q VDD VSS sg13g2_nand2b_1
XFILLER_154_887 VDD VSS sg13g2_fill_1
X_15084_ _15084_/Q clkload70/A _15084_/D _15084_/RESET_B VDD VSS sg13g2_dfrbpq_1
XFILLER_5_875 VDD VSS sg13g2_decap_8
X_12296_ _12297_/B _12296_/A1 _12280_/Y _12295_/Y VDD VSS sg13g2_o21ai_1
XFILLER_49_1250 VDD VSS sg13g2_fill_1
X_14035_ _14035_/Q clkload16/A _14035_/D _14035_/RESET_B VDD VSS sg13g2_dfrbpq_1
XFILLER_4_385 VDD VSS sg13g2_decap_8
XFILLER_136_1220 VDD VSS sg13g2_decap_8
X_11247_ _11247_/X _13293_/D _07690_/X _11245_/Y VDD VSS sg13g2_a21o_1
XFILLER_49_1283 VDD VSS sg13g2_fill_1
XFILLER_164_70 VDD VSS sg13g2_decap_8
XFILLER_79_153 VDD VSS sg13g2_decap_4
XFILLER_95_613 VDD VSS sg13g2_fill_1
XFILLER_68_827 VDD VSS sg13g2_decap_8
XFILLER_110_924 VDD VSS sg13g2_decap_8
X_11178_ _11186_/B _11177_/B _11177_/C _11197_/A VDD VSS sg13g2_o21ai_1
XFILLER_132_1117 VDD VSS sg13g2_decap_4
X_13933__2246 _13933_/RESET_B VDD VSS sg13g2_tiehi
XFILLER_67_315 VDD VSS sg13g2_decap_8
X_14693__1486 _14693_/RESET_B VDD VSS sg13g2_tiehi
XFILLER_67_326 VDD VSS sg13g2_fill_2
XFILLER_67_337 VDD VSS sg13g2_fill_2
X_10129_ _14707_/D _10162_/A1 _14707_/Q _10134_/S VDD VSS sg13g2_mux2_1
XFILLER_171_1199 VDD VSS sg13g2_fill_1
XFILLER_48_562 VDD VSS sg13g2_decap_8
X_14937_ _14937_/Q clkload57/A _14937_/D _14937_/RESET_B VDD VSS sg13g2_dfrbpq_1
XFILLER_57_90 VDD VSS sg13g2_decap_8
X_14868_ _14868_/Q _14868_/CLK _14868_/D _14868_/RESET_B VDD VSS sg13g2_dfrbpq_1
XFILLER_1_1274 VDD VSS sg13g2_decap_8
X_13819_ _13819_/Q _14885_/CLK _13819_/D _13819_/RESET_B VDD VSS sg13g2_dfrbpq_1
XFILLER_63_598 VDD VSS sg13g2_decap_8
X_14799_ _14799_/Q _14868_/CLK _14799_/D _14799_/RESET_B VDD VSS sg13g2_dfrbpq_1
XFILLER_56_1232 VDD VSS sg13g2_decap_8
XFILLER_143_1202 VDD VSS sg13g2_decap_8
XFILLER_52_1107 VDD VSS sg13g2_decap_8
XFILLER_91_1167 VDD VSS sg13g2_fill_1
XFILLER_56_1298 VDD VSS sg13g2_fill_2
X_09010_ _09010_/Y _09141_/A _10697_/A _09016_/C VDD VSS sg13g2_nand3_1
X_14867__2810 _14867_/RESET_B VDD VSS sg13g2_tiehi
XFILLER_148_169 VDD VSS sg13g2_decap_4
XFILLER_78_0 VDD VSS sg13g2_decap_8
XFILLER_145_832 VDD VSS sg13g2_decap_8
XFILLER_105_707 VDD VSS sg13g2_fill_2
XFILLER_89_1085 VDD VSS sg13g2_decap_8
XFILLER_132_504 VDD VSS sg13g2_decap_8
XFILLER_132_515 VDD VSS sg13g2_fill_1
XFILLER_171_161 VDD VSS sg13g2_decap_8
XFILLER_67_1350 VDD VSS sg13g2_fill_2
XFILLER_28_1301 VDD VSS sg13g2_decap_8
XFILLER_132_537 VDD VSS sg13g2_fill_2
XFILLER_160_857 VDD VSS sg13g2_decap_8
X_09912_ _14497_/D _14497_/Q _09912_/A1 _09935_/S VDD VSS sg13g2_mux2_1
Xfanout604 _10725_/A _08838_/Y VDD VSS sg13g2_buf_1
XFILLER_67_1383 VDD VSS sg13g2_fill_1
Xfanout615 _08955_/S _08904_/S VDD VSS sg13g2_buf_1
XFILLER_63_1225 VDD VSS sg13g2_decap_8
Xfanout626 _13440_/A _08724_/Y VDD VSS sg13g2_buf_1
XFILLER_59_816 VDD VSS sg13g2_fill_1
Xfanout637 _08522_/C _07994_/X VDD VSS sg13g2_buf_1
X_09843_ _14430_/D _14430_/Q _10074_/A0 _09863_/S VDD VSS sg13g2_mux2_1
XFILLER_86_613 VDD VSS sg13g2_fill_1
XFILLER_58_304 VDD VSS sg13g2_fill_1
Xfanout648 _08659_/B _08429_/B VDD VSS sg13g2_buf_1
XFILLER_28_1378 VDD VSS sg13g2_decap_4
Xfanout659 _12917_/B1 _07727_/Y VDD VSS sg13g2_buf_1
XFILLER_140_592 VDD VSS sg13g2_fill_1
XFILLER_101_957 VDD VSS sg13g2_decap_8
X_14523__1656 _14523_/RESET_B VDD VSS sg13g2_tiehi
XFILLER_101_968 VDD VSS sg13g2_fill_1
X_13909__2270 _13909_/RESET_B VDD VSS sg13g2_tiehi
X_09774_ _14363_/D _09774_/A0 _14363_/Q _09799_/S VDD VSS sg13g2_mux2_1
XFILLER_6_1141 VDD VSS sg13g2_decap_8
XFILLER_67_860 VDD VSS sg13g2_decap_8
XFILLER_26_1091 VDD VSS sg13g2_decap_8
XFILLER_37_49 VDD VSS sg13g2_decap_8
XFILLER_160_28 VDD VSS sg13g2_decap_8
X_08725_ _13482_/A _15129_/Q _15124_/Q _15071_/Q VDD VSS sg13g2_or3_1
X_14777__2936 _14777_/RESET_B VDD VSS sg13g2_tiehi
X_08656_ _08656_/X _08669_/B1 _08619_/Y _08402_/C VDD VSS sg13g2_a21o_1
XFILLER_148_1113 VDD VSS sg13g2_decap_8
XFILLER_26_245 VDD VSS sg13g2_decap_8
XFILLER_96_1056 VDD VSS sg13g2_decap_8
XFILLER_27_779 VDD VSS sg13g2_decap_8
XFILLER_81_351 VDD VSS sg13g2_decap_8
XFILLER_74_1310 VDD VSS sg13g2_fill_1
X_08587_ _08587_/Y _08586_/B _08586_/C _08641_/C VDD VSS sg13g2_a21oi_1
XFILLER_109_1119 VDD VSS sg13g2_decap_4
XFILLER_156_7 VDD VSS sg13g2_decap_8
XFILLER_74_1343 VDD VSS sg13g2_decap_8
XFILLER_161_1313 VDD VSS sg13g2_decap_8
XFILLER_161_1324 VDD VSS sg13g2_fill_2
XFILLER_168_935 VDD VSS sg13g2_decap_8
XFILLER_70_1207 VDD VSS sg13g2_decap_8
XFILLER_10_602 VDD VSS sg13g2_decap_8
XFILLER_23_985 VDD VSS sg13g2_decap_4
XFILLER_22_462 VDD VSS sg13g2_decap_8
XFILLER_167_434 VDD VSS sg13g2_decap_8
XFILLER_122_1308 VDD VSS sg13g2_decap_8
XFILLER_168_979 VDD VSS sg13g2_decap_8
X_09208_ _10070_/C _09905_/A _09938_/B VDD VSS sg13g2_nor2_1
X_10480_ _10482_/A _10489_/C _10489_/D _10630_/C VDD VSS sg13g2_o21ai_1
XFILLER_10_679 VDD VSS sg13g2_decap_8
XFILLER_5_105 VDD VSS sg13g2_decap_8
XFILLER_33_1073 VDD VSS sg13g2_fill_1
XFILLER_148_692 VDD VSS sg13g2_decap_8
X_09139_ _13782_/D _13782_/Q _09768_/A1 _09153_/S VDD VSS sg13g2_mux2_1
XFILLER_120_1043 VDD VSS sg13g2_decap_8
XFILLER_159_1242 VDD VSS sg13g2_decap_8
Xclkbuf_5_14__f_clk_i clkbuf_leaf_44_clk_i/A clkbuf_4_7_0_clk_i/X VDD VSS sg13g2_buf_16
X_12150_ _12150_/Y _12152_/A _12298_/B VDD VSS sg13g2_nor2_1
XFILLER_68_1147 VDD VSS sg13g2_decap_8
XFILLER_162_161 VDD VSS sg13g2_decap_8
XFILLER_2_812 VDD VSS sg13g2_decap_8
XFILLER_68_1169 VDD VSS sg13g2_fill_1
X_11101_ _14948_/D _11100_/Y _11099_/Y _11084_/Y VDD VSS sg13g2_o21ai_1
XFILLER_151_857 VDD VSS sg13g2_decap_8
XFILLER_123_559 VDD VSS sg13g2_decap_8
X_12081_ _14981_/D _12061_/A _12126_/A _12080_/Y VDD VSS sg13g2_a21o_1
XFILLER_81_1303 VDD VSS sg13g2_decap_8
XFILLER_1_322 VDD VSS sg13g2_decap_8
XFILLER_104_740 VDD VSS sg13g2_fill_2
XFILLER_78_56 VDD VSS sg13g2_decap_8
X_11032_ _11032_/Y _11052_/B _14760_/Q VDD VSS sg13g2_nor2b_1
XFILLER_2_889 VDD VSS sg13g2_decap_8
XFILLER_76_101 VDD VSS sg13g2_decap_8
XFILLER_77_635 VDD VSS sg13g2_fill_1
XFILLER_49_326 VDD VSS sg13g2_decap_8
XFILLER_76_123 VDD VSS sg13g2_decap_8
XFILLER_49_337 VDD VSS sg13g2_fill_2
XFILLER_1_399 VDD VSS sg13g2_decap_8
XFILLER_134_84 VDD VSS sg13g2_decap_8
XFILLER_94_66 VDD VSS sg13g2_decap_8
XFILLER_64_329 VDD VSS sg13g2_decap_8
XFILLER_131_1172 VDD VSS sg13g2_decap_8
X_12983_ _12984_/B _07683_/A _12982_/Y _12975_/X _12878_/D _12979_/Y VDD VSS sg13g2_a221oi_1
XFILLER_18_735 VDD VSS sg13g2_decap_8
XFILLER_91_137 VDD VSS sg13g2_decap_8
XFILLER_131_1194 VDD VSS sg13g2_decap_8
X_14722_ _14722_/Q _14722_/CLK _14722_/D _14722_/RESET_B VDD VSS sg13g2_dfrbpq_1
X_11934_ _11934_/Y _11936_/A _12082_/B VDD VSS sg13g2_nor2_1
XFILLER_17_245 VDD VSS sg13g2_decap_8
X_14678__1501 _14678_/RESET_B VDD VSS sg13g2_tiehi
XFILLER_73_896 VDD VSS sg13g2_fill_2
X_14653_ _14653_/Q _14653_/CLK _14653_/D _14653_/RESET_B VDD VSS sg13g2_dfrbpq_1
X_11865_ _11910_/C _11865_/A _13674_/Q VDD VSS sg13g2_xnor2_1
XFILLER_166_1279 VDD VSS sg13g2_decap_8
X_13604_ _15165_/D _13603_/Y _13611_/A2 _13599_/Y VDD VSS sg13g2_a21oi_1
XFILLER_14_952 VDD VSS sg13g2_decap_8
X_10816_ _10816_/Y _10797_/A _10851_/A _10873_/A1 VDD VSS sg13g2_o21ai_1
X_14584_ _14584_/Q _14984_/CLK _14584_/D _14584_/RESET_B VDD VSS sg13g2_dfrbpq_1
X_11796_ _11839_/A _11798_/A _12082_/B VDD VSS sg13g2_nor2_1
XFILLER_13_462 VDD VSS sg13g2_decap_8
XFILLER_43_70 VDD VSS sg13g2_decap_8
X_13535_ _13535_/Y _13535_/A _13535_/B VDD VSS sg13g2_nor2_1
XFILLER_41_782 VDD VSS sg13g2_fill_1
X_10747_ _10747_/Y _10747_/A _10747_/B VDD VSS sg13g2_nor2_1
XFILLER_174_905 VDD VSS sg13g2_fill_2
XFILLER_159_70 VDD VSS sg13g2_decap_8
XFILLER_16_1260 VDD VSS sg13g2_decap_8
XFILLER_9_455 VDD VSS sg13g2_decap_8
XFILLER_71_7 VDD VSS sg13g2_decap_8
XFILLER_51_1151 VDD VSS sg13g2_decap_8
XFILLER_173_404 VDD VSS sg13g2_decap_8
X_13466_ _15108_/D _13459_/Y _13463_/X _13465_/Y VDD VSS sg13g2_o21ai_1
X_10678_ _14896_/D _07705_/B _10813_/A _10674_/Y VDD VSS sg13g2_o21ai_1
XFILLER_173_415 VDD VSS sg13g2_decap_8
XFILLER_12_1113 VDD VSS sg13g2_decap_8
XFILLER_174_949 VDD VSS sg13g2_decap_4
XFILLER_139_692 VDD VSS sg13g2_fill_1
X_14601__1578 _14601_/RESET_B VDD VSS sg13g2_tiehi
X_15205_ _15205_/Q clkload72/A _15205_/D _15205_/RESET_B VDD VSS sg13g2_dfrbpq_1
XFILLER_127_843 VDD VSS sg13g2_decap_8
X_12417_ _14993_/D _12415_/Y _12416_/Y _12403_/Y VDD VSS sg13g2_a21oi_1
X_13397_ _15086_/D _15086_/Q _13470_/A2 _13396_/Y VDD VSS sg13g2_a21o_1
XFILLER_127_876 VDD VSS sg13g2_decap_4
XFILLER_86_1225 VDD VSS sg13g2_fill_2
X_15136_ _15136_/Q clkload59/A _15136_/D _15136_/RESET_B VDD VSS sg13g2_dfrbpq_1
X_12348_ _12348_/Y _12348_/A _15217_/Q _15126_/Q _12348_/D VDD VSS sg13g2_nor4_1
XFILLER_5_672 VDD VSS sg13g2_decap_8
XFILLER_153_183 VDD VSS sg13g2_decap_8
X_15067_ _15067_/Q _15113_/CLK _15067_/D _15067_/RESET_B VDD VSS sg13g2_dfrbpq_1
X_12279_ _12280_/B _12277_/X _12279_/B VDD VSS sg13g2_nand2b_1
XFILLER_4_42 VDD VSS sg13g2_decap_8
XFILLER_4_182 VDD VSS sg13g2_decap_8
XFILLER_68_602 VDD VSS sg13g2_decap_4
X_14018_ _14018_/Q _14722_/CLK _14018_/D _14018_/RESET_B VDD VSS sg13g2_dfrbpq_1
XFILLER_110_732 VDD VSS sg13g2_fill_2
XFILLER_56_808 VDD VSS sg13g2_fill_1
XFILLER_49_871 VDD VSS sg13g2_decap_8
XFILLER_49_882 VDD VSS sg13g2_fill_2
XFILLER_48_370 VDD VSS sg13g2_decap_8
XFILLER_83_649 VDD VSS sg13g2_decap_8
X_08510_ _08510_/X _08559_/A3 _08510_/A1 _08470_/B _07949_/C _08635_/S0 _08635_/S1
+ VDD VSS sg13g2_mux4_1
XFILLER_23_1286 VDD VSS sg13g2_decap_8
XFILLER_3_1358 VDD VSS sg13g2_decap_8
X_09490_ _14090_/D _10086_/A0 _14090_/Q _09497_/S VDD VSS sg13g2_mux2_1
XFILLER_64_863 VDD VSS sg13g2_fill_2
XFILLER_110_1278 VDD VSS sg13g2_fill_2
XFILLER_93_1218 VDD VSS sg13g2_decap_8
X_08441_ _15235_/D _08441_/A _08441_/B _08441_/C _08441_/D VDD VSS sg13g2_nand4_1
XFILLER_63_373 VDD VSS sg13g2_decap_8
XFILLER_1_1071 VDD VSS sg13g2_decap_8
XFILLER_51_535 VDD VSS sg13g2_decap_8
XFILLER_56_1040 VDD VSS sg13g2_fill_2
X_08372_ _08372_/Y _07795_/A _08370_/Y _08371_/Y VDD VSS sg13g2_a21oi_1
XFILLER_149_401 VDD VSS sg13g2_decap_8
XFILLER_23_259 VDD VSS sg13g2_decap_8
Xclkbuf_4_15_0_clk_i clkbuf_4_15_0_clk_i/X clkbuf_0_clk_i/X VDD VSS sg13g2_buf_8
XFILLER_32_771 VDD VSS sg13g2_decap_8
XFILLER_17_1057 VDD VSS sg13g2_decap_8
XFILLER_143_1065 VDD VSS sg13g2_decap_8
XFILLER_149_478 VDD VSS sg13g2_decap_8
X_15074__2853 _15074_/RESET_B VDD VSS sg13g2_tiehi
XFILLER_34_1360 VDD VSS sg13g2_decap_8
XFILLER_20_966 VDD VSS sg13g2_decap_8
XFILLER_158_990 VDD VSS sg13g2_decap_8
XFILLER_164_448 VDD VSS sg13g2_decap_8
XFILLER_121_1363 VDD VSS sg13g2_fill_1
XFILLER_121_1374 VDD VSS sg13g2_fill_1
XFILLER_3_609 VDD VSS sg13g2_decap_8
XFILLER_30_1268 VDD VSS sg13g2_decap_8
XFILLER_105_504 VDD VSS sg13g2_fill_2
XFILLER_118_887 VDD VSS sg13g2_fill_2
XFILLER_105_515 VDD VSS sg13g2_decap_4
XFILLER_145_684 VDD VSS sg13g2_decap_8
XFILLER_155_28 VDD VSS sg13g2_decap_8
XFILLER_172_470 VDD VSS sg13g2_decap_8
XFILLER_2_119 VDD VSS sg13g2_decap_8
XFILLER_105_559 VDD VSS sg13g2_decap_4
XFILLER_87_900 VDD VSS sg13g2_decap_8
XFILLER_160_676 VDD VSS sg13g2_decap_4
Xfanout401 _09153_/S _09112_/S VDD VSS sg13g2_buf_1
XFILLER_132_378 VDD VSS sg13g2_decap_4
XFILLER_154_1150 VDD VSS sg13g2_fill_2
Xfanout423 _10030_/S _10036_/S VDD VSS sg13g2_buf_1
XFILLER_8_1225 VDD VSS sg13g2_decap_8
Xfanout434 _09829_/S _09838_/S VDD VSS sg13g2_buf_1
XFILLER_141_890 VDD VSS sg13g2_fill_2
Xfanout445 _09672_/S _09670_/S VDD VSS sg13g2_buf_1
XFILLER_28_1175 VDD VSS sg13g2_decap_8
XFILLER_154_1183 VDD VSS sg13g2_decap_4
Xfanout456 _09538_/S _09507_/Y VDD VSS sg13g2_buf_1
Xfanout467 _09406_/S _09375_/Y VDD VSS sg13g2_buf_1
X_09826_ _14414_/D _09925_/A1 _14414_/Q _09832_/S VDD VSS sg13g2_mux2_1
XFILLER_115_1156 VDD VSS sg13g2_decap_4
Xfanout478 _10109_/A0 _10142_/A1 VDD VSS sg13g2_buf_1
XFILLER_86_454 VDD VSS sg13g2_decap_8
XFILLER_59_668 VDD VSS sg13g2_fill_2
Xfanout489 _08762_/A1 _08729_/Y VDD VSS sg13g2_buf_1
XFILLER_63_1099 VDD VSS sg13g2_decap_4
XFILLER_47_819 VDD VSS sg13g2_decap_8
XFILLER_171_49 VDD VSS sg13g2_decap_8
XFILLER_104_21 VDD VSS sg13g2_decap_8
XFILLER_74_616 VDD VSS sg13g2_decap_8
X_09757_ _14347_/D _14347_/Q _09889_/A0 _09763_/S VDD VSS sg13g2_mux2_1
XFILLER_104_54 VDD VSS sg13g2_fill_1
XFILLER_100_297 VDD VSS sg13g2_fill_2
XFILLER_64_14 VDD VSS sg13g2_decap_8
XFILLER_39_392 VDD VSS sg13g2_fill_2
X_08708_ _13659_/D _15186_/D _15117_/Q _13652_/S VDD VSS sg13g2_mux2_1
XFILLER_27_543 VDD VSS sg13g2_decap_8
X_09688_ _14280_/D _10151_/A1 _14280_/Q _09697_/S VDD VSS sg13g2_mux2_1
XFILLER_42_513 VDD VSS sg13g2_decap_8
X_08639_ _08640_/B _08678_/B _08674_/B1 _08674_/A2 _08650_/A VDD VSS sg13g2_a22oi_1
XFILLER_15_749 VDD VSS sg13g2_decap_8
X_11650_ _11650_/X _14119_/Q _14151_/Q _14183_/Q _14215_/Q _11651_/S0 _11651_/S1 VDD
+ VSS sg13g2_mux4_1
XFILLER_39_1260 VDD VSS sg13g2_decap_8
XFILLER_14_259 VDD VSS sg13g2_decap_8
X_10601_ _10602_/C _14877_/Q _14876_/Q _14875_/Q _10607_/C VDD VSS sg13g2_and4_1
XFILLER_80_35 VDD VSS sg13g2_decap_4
X_11581_ _11582_/B _11573_/X _11574_/X _11577_/X _11578_/X _11964_/B _11999_/S1 VDD
+ VSS sg13g2_mux4_1
XFILLER_167_231 VDD VSS sg13g2_decap_8
XFILLER_126_1274 VDD VSS sg13g2_fill_1
XFILLER_35_1168 VDD VSS sg13g2_fill_1
XFILLER_11_966 VDD VSS sg13g2_decap_8
X_13320_ _13322_/B _13320_/A _15064_/Q _13320_/C VDD VSS sg13g2_nand3_1
X_10532_ _14859_/D _10533_/B _10535_/C _10532_/C VDD VSS sg13g2_and3_1
XFILLER_122_1138 VDD VSS sg13g2_decap_8
XFILLER_168_798 VDD VSS sg13g2_decap_8
XFILLER_122_1149 VDD VSS sg13g2_fill_1
XFILLER_109_821 VDD VSS sg13g2_decap_8
XFILLER_127_117 VDD VSS sg13g2_decap_8
XFILLER_10_476 VDD VSS sg13g2_decap_8
X_14992__2595 _14992_/RESET_B VDD VSS sg13g2_tiehi
XFILLER_13_84 VDD VSS sg13g2_decap_8
XFILLER_7_959 VDD VSS sg13g2_decap_8
X_13251_ _13251_/Y _13251_/A _13251_/B _13251_/C VDD VSS sg13g2_nand3_1
X_10463_ _10463_/Y _10471_/C _10471_/D _10619_/B VDD VSS sg13g2_o21ai_1
XFILLER_129_84 VDD VSS sg13g2_decap_8
XFILLER_6_469 VDD VSS sg13g2_decap_8
XFILLER_129_95 VDD VSS sg13g2_fill_1
X_12202_ _12274_/A _12203_/A _13665_/Q VDD VSS sg13g2_nand2_1
XFILLER_159_1050 VDD VSS sg13g2_fill_2
X_13182_ _13182_/Y _13179_/Y _13180_/Y _13181_/Y VDD VSS sg13g2_a21oi_1
X_10394_ _10395_/C _14820_/Q _14821_/Q _14822_/Q VDD VSS sg13g2_nand3_1
XFILLER_89_77 VDD VSS sg13g2_decap_8
XFILLER_11_1190 VDD VSS sg13g2_decap_8
XFILLER_135_183 VDD VSS sg13g2_decap_8
X_14395__1784 _14395_/RESET_B VDD VSS sg13g2_tiehi
X_12133_ _12133_/X _14581_/Q _14613_/Q _14645_/Q _14677_/Q _12140_/S0 _12140_/S1 VDD
+ VSS sg13g2_mux4_1
XFILLER_8_0 VDD VSS sg13g2_decap_8
XFILLER_123_356 VDD VSS sg13g2_decap_8
XFILLER_78_911 VDD VSS sg13g2_decap_4
XFILLER_111_529 VDD VSS sg13g2_decap_8
X_14851__2842 _14851_/RESET_B VDD VSS sg13g2_tiehi
X_12064_ _12065_/B _12062_/A _12062_/B _12197_/A VDD VSS sg13g2_a21o_1
XFILLER_104_570 VDD VSS sg13g2_fill_2
XFILLER_46_1253 VDD VSS sg13g2_decap_8
XFILLER_2_686 VDD VSS sg13g2_decap_8
XFILLER_81_1155 VDD VSS sg13g2_decap_8
X_11015_ _11052_/D _11015_/A _11042_/B _11015_/C _11042_/D VDD VSS sg13g2_nand4_1
XFILLER_77_432 VDD VSS sg13g2_decap_8
XFILLER_1_196 VDD VSS sg13g2_decap_8
X_16872_ _16872_/X _16872_/A VDD VSS sg13g2_buf_1
XFILLER_172_1294 VDD VSS sg13g2_decap_8
XFILLER_49_156 VDD VSS sg13g2_decap_4
XFILLER_133_1278 VDD VSS sg13g2_decap_8
X_14015__2164 _14015_/RESET_B VDD VSS sg13g2_tiehi
Xfanout990 _09938_/A _09640_/C VDD VSS sg13g2_buf_1
XFILLER_78_999 VDD VSS sg13g2_decap_8
XFILLER_93_947 VDD VSS sg13g2_fill_1
XFILLER_38_70 VDD VSS sg13g2_decap_8
XFILLER_92_446 VDD VSS sg13g2_decap_8
XFILLER_18_532 VDD VSS sg13g2_decap_8
X_14884__2776 _14884_/RESET_B VDD VSS sg13g2_tiehi
X_12966_ _12966_/Y _12963_/Y _12964_/Y _12965_/Y VDD VSS sg13g2_a21oi_1
XFILLER_92_479 VDD VSS sg13g2_decap_8
XFILLER_79_1062 VDD VSS sg13g2_decap_4
XFILLER_73_671 VDD VSS sg13g2_decap_8
XFILLER_166_1032 VDD VSS sg13g2_decap_8
X_14705_ _14705_/Q _14737_/CLK _14705_/D _14705_/RESET_B VDD VSS sg13g2_dfrbpq_1
X_11917_ _11917_/Y _11917_/A _12055_/A VDD VSS sg13g2_xnor2_1
XFILLER_61_833 VDD VSS sg13g2_decap_8
X_12897_ _12897_/Y _14773_/Q _12918_/A2 _13140_/B2 VDD VSS sg13g2_o21ai_1
X_14636_ _14636_/Q clkload13/A _14636_/D _14636_/RESET_B VDD VSS sg13g2_dfrbpq_1
XFILLER_57_1360 VDD VSS sg13g2_fill_1
XFILLER_54_80 VDD VSS sg13g2_decap_8
X_11848_ _11848_/X _13741_/Q _14093_/Q _14445_/Q _14541_/Q _11848_/S0 _11851_/S1 VDD
+ VSS sg13g2_mux4_1
X_13883__2296 _13883_/RESET_B VDD VSS sg13g2_tiehi
XFILLER_92_1262 VDD VSS sg13g2_decap_8
XFILLER_18_1344 VDD VSS sg13g2_decap_8
X_14567_ _14567_/Q _14727_/CLK _14567_/D _14567_/RESET_B VDD VSS sg13g2_dfrbpq_1
XFILLER_158_242 VDD VSS sg13g2_decap_8
X_11779_ _11779_/Y _11910_/A _11912_/A VDD VSS sg13g2_nor2_1
XFILLER_147_916 VDD VSS sg13g2_decap_8
XFILLER_146_404 VDD VSS sg13g2_decap_8
X_13518_ _13518_/Y _13518_/A1 _13533_/B _08263_/B _13546_/B2 VDD VSS sg13g2_a22oi_1
XFILLER_9_252 VDD VSS sg13g2_decap_8
XFILLER_53_1279 VDD VSS sg13g2_decap_8
XFILLER_174_724 VDD VSS sg13g2_fill_2
X_14498_ _14498_/Q clkload25/A _14498_/D _14498_/RESET_B VDD VSS sg13g2_dfrbpq_1
XFILLER_118_139 VDD VSS sg13g2_decap_8
Xclkload11 clkload11/Y clkload11/A VDD VSS sg13g2_inv_1
X_13449_ _13449_/X _15196_/Q _13449_/B VDD VSS sg13g2_or2_1
Xclkload22 clkload22/Y clkload22/A VDD VSS sg13g2_inv_1
XFILLER_173_245 VDD VSS sg13g2_decap_8
Xclkload33 clkload33/Y clkload33/A VDD VSS sg13g2_inv_2
Xclkload44 clkload44/Y clkload44/A VDD VSS sg13g2_inv_1
Xclkload55 clkload55/Y clkload55/A VDD VSS sg13g2_inv_2
XFILLER_161_429 VDD VSS sg13g2_decap_8
Xclkload66 clkload66/Y clkload66/A VDD VSS sg13g2_inv_1
XFILLER_86_1033 VDD VSS sg13g2_decap_8
XFILLER_86_1044 VDD VSS sg13g2_fill_2
XFILLER_154_492 VDD VSS sg13g2_decap_8
XFILLER_141_120 VDD VSS sg13g2_decap_8
XFILLER_170_952 VDD VSS sg13g2_fill_1
X_14225__1954 _14225_/RESET_B VDD VSS sg13g2_tiehi
X_15119_ _15119_/Q clkload63/A _15119_/D _15119_/RESET_B VDD VSS sg13g2_dfrbpq_1
X_08990_ _13759_/D _13759_/Q _09910_/A1 _09106_/S VDD VSS sg13g2_mux2_1
XFILLER_86_1088 VDD VSS sg13g2_decap_8
XFILLER_69_900 VDD VSS sg13g2_fill_1
XFILLER_142_676 VDD VSS sg13g2_fill_1
XFILLER_69_911 VDD VSS sg13g2_decap_8
XFILLER_114_389 VDD VSS sg13g2_decap_8
X_07941_ _07942_/A _07796_/Y _07940_/Y _07938_/Y VDD VSS sg13g2_a21o_1
XFILLER_151_1334 VDD VSS sg13g2_decap_8
XFILLER_25_1337 VDD VSS sg13g2_decap_8
X_07872_ _07876_/A _07909_/B _07910_/A VDD VSS sg13g2_nand2_1
XFILLER_68_454 VDD VSS sg13g2_fill_2
XFILLER_110_551 VDD VSS sg13g2_decap_8
XFILLER_69_988 VDD VSS sg13g2_decap_8
XFILLER_84_925 VDD VSS sg13g2_decap_8
XFILLER_28_307 VDD VSS sg13g2_fill_2
X_09611_ _14207_/D _09611_/A0 _14207_/Q _09629_/S VDD VSS sg13g2_mux2_1
XFILLER_96_796 VDD VSS sg13g2_decap_8
XFILLER_68_498 VDD VSS sg13g2_fill_1
XFILLER_55_126 VDD VSS sg13g2_fill_2
X_09542_ _14140_/D _09608_/A0 _14140_/Q _09566_/S VDD VSS sg13g2_mux2_1
XFILLER_3_1155 VDD VSS sg13g2_decap_8
XFILLER_23_1083 VDD VSS sg13g2_decap_8
XFILLER_36_340 VDD VSS sg13g2_decap_8
XFILLER_37_874 VDD VSS sg13g2_decap_4
XFILLER_149_1241 VDD VSS sg13g2_decap_8
XFILLER_52_811 VDD VSS sg13g2_decap_8
XFILLER_149_1252 VDD VSS sg13g2_fill_2
X_09473_ _14074_/D _09970_/A1 _14074_/Q _09473_/S VDD VSS sg13g2_mux2_1
XFILLER_51_321 VDD VSS sg13g2_fill_1
XFILLER_34_28 VDD VSS sg13g2_decap_8
XFILLER_169_518 VDD VSS sg13g2_decap_8
X_08424_ _15234_/D _08424_/A1 _08423_/X _08410_/X VDD VSS sg13g2_o21ai_1
XFILLER_52_866 VDD VSS sg13g2_decap_8
X_13713__2466 _13713_/RESET_B VDD VSS sg13g2_tiehi
X_08355_ _15231_/D _08395_/A _08354_/Y _08347_/Y VDD VSS sg13g2_o21ai_1
XFILLER_149_242 VDD VSS sg13g2_decap_8
XFILLER_138_927 VDD VSS sg13g2_fill_1
Xclkload5 clkload5/Y clkload5/A VDD VSS sg13g2_inv_1
X_08286_ _08286_/Y _08286_/A _08286_/B _08286_/C VDD VSS sg13g2_nor3_1
XFILLER_20_763 VDD VSS sg13g2_decap_8
XFILLER_138_949 VDD VSS sg13g2_decap_8
XFILLER_50_49 VDD VSS sg13g2_decap_8
XFILLER_109_139 VDD VSS sg13g2_decap_8
XFILLER_30_1021 VDD VSS sg13g2_decap_8
XFILLER_164_245 VDD VSS sg13g2_decap_8
XFILLER_119_7 VDD VSS sg13g2_decap_8
XFILLER_166_49 VDD VSS sg13g2_decap_8
XFILLER_3_406 VDD VSS sg13g2_decap_8
XFILLER_106_824 VDD VSS sg13g2_decap_8
XFILLER_156_1201 VDD VSS sg13g2_decap_4
XFILLER_118_695 VDD VSS sg13g2_decap_8
XFILLER_69_1264 VDD VSS sg13g2_decap_8
XFILLER_133_632 VDD VSS sg13g2_fill_1
XFILLER_156_1223 VDD VSS sg13g2_decap_8
XFILLER_69_1286 VDD VSS sg13g2_fill_2
XFILLER_59_14 VDD VSS sg13g2_decap_8
XFILLER_105_345 VDD VSS sg13g2_decap_8
XFILLER_161_963 VDD VSS sg13g2_fill_2
XFILLER_1_7 VDD VSS sg13g2_decap_8
XFILLER_117_1207 VDD VSS sg13g2_decap_8
XFILLER_79_719 VDD VSS sg13g2_decap_8
X_14977__2610 _14977_/RESET_B VDD VSS sg13g2_tiehi
XFILLER_105_389 VDD VSS sg13g2_fill_1
Xfanout1207 _11125_/A _11202_/A VDD VSS sg13g2_buf_1
XFILLER_78_229 VDD VSS sg13g2_decap_8
XFILLER_120_326 VDD VSS sg13g2_fill_1
Xfanout220 _10121_/A0 _10154_/A1 VDD VSS sg13g2_buf_1
Xfanout1218 _13190_/B _13669_/Q VDD VSS sg13g2_buf_1
XFILLER_8_1022 VDD VSS sg13g2_decap_8
Xfanout231 _10152_/A1 _09051_/Y VDD VSS sg13g2_buf_1
Xfanout1229 _11231_/S _12334_/C VDD VSS sg13g2_buf_1
Xfanout242 _12082_/B _11724_/B VDD VSS sg13g2_buf_1
XFILLER_115_42 VDD VSS sg13g2_decap_8
Xfanout253 _10150_/A1 _09037_/X VDD VSS sg13g2_buf_1
XFILLER_87_752 VDD VSS sg13g2_decap_8
XFILLER_101_540 VDD VSS sg13g2_decap_8
Xfanout264 _09895_/S _09898_/S VDD VSS sg13g2_buf_1
XFILLER_75_903 VDD VSS sg13g2_decap_8
XFILLER_101_551 VDD VSS sg13g2_fill_1
XFILLER_101_562 VDD VSS sg13g2_fill_2
Xfanout275 _09431_/S _09440_/S VDD VSS sg13g2_buf_1
Xfanout286 _09915_/A1 _09517_/A0 VDD VSS sg13g2_buf_1
Xfanout297 _09610_/A0 fanout301/X VDD VSS sg13g2_buf_1
X_09809_ _14397_/D _09908_/A1 _14397_/Q _09832_/S VDD VSS sg13g2_mux2_1
XFILLER_8_1099 VDD VSS sg13g2_decap_8
XFILLER_87_796 VDD VSS sg13g2_decap_8
XFILLER_86_284 VDD VSS sg13g2_decap_8
XFILLER_19_329 VDD VSS sg13g2_decap_8
XFILLER_101_595 VDD VSS sg13g2_decap_8
XFILLER_41_1150 VDD VSS sg13g2_decap_8
X_12820_ _12820_/Y _12817_/Y _12818_/Y _12819_/Y VDD VSS sg13g2_a21oi_1
XFILLER_90_917 VDD VSS sg13g2_decap_4
XFILLER_41_1183 VDD VSS sg13g2_fill_1
XFILLER_43_822 VDD VSS sg13g2_decap_8
X_12751_ _12764_/A _12751_/A1 _12765_/A2 _15018_/Q VDD VSS sg13g2_a21oi_1
XFILLER_76_1235 VDD VSS sg13g2_fill_2
XFILLER_42_310 VDD VSS sg13g2_decap_4
XFILLER_82_490 VDD VSS sg13g2_decap_8
XFILLER_131_85 VDD VSS sg13g2_decap_4
XFILLER_15_546 VDD VSS sg13g2_decap_8
X_11702_ _14970_/D _11702_/A _11702_/B VDD VSS sg13g2_nor2_1
X_12682_ _12682_/X _14579_/Q _14611_/Q _14643_/Q _14675_/Q _12689_/S0 _12689_/S1 VDD
+ VSS sg13g2_mux4_1
XFILLER_70_663 VDD VSS sg13g2_fill_1
XFILLER_145_0 VDD VSS sg13g2_decap_8
X_14303__1876 _14303_/RESET_B VDD VSS sg13g2_tiehi
X_14421_ _14421_/Q clkload18/A _14421_/D _14421_/RESET_B VDD VSS sg13g2_dfrbpq_1
X_11633_ _11663_/A _11635_/A _13681_/Q VDD VSS sg13g2_nand2_1
XFILLER_126_1060 VDD VSS sg13g2_decap_4
XFILLER_129_916 VDD VSS sg13g2_decap_8
XFILLER_156_724 VDD VSS sg13g2_decap_8
X_14352_ _14352_/Q _14662_/CLK _14352_/D _14352_/RESET_B VDD VSS sg13g2_dfrbpq_1
XFILLER_11_763 VDD VSS sg13g2_decap_8
X_11564_ _11564_/Y _11722_/B2 _11563_/Y _11724_/B VDD VSS sg13g2_o21ai_1
XFILLER_155_212 VDD VSS sg13g2_fill_1
XFILLER_168_595 VDD VSS sg13g2_decap_8
XFILLER_155_234 VDD VSS sg13g2_decap_8
X_13303_ _13306_/B _13303_/A _13304_/B VDD VSS sg13g2_nor2b_1
XFILLER_10_273 VDD VSS sg13g2_decap_8
XFILLER_128_459 VDD VSS sg13g2_decap_8
X_10515_ _10579_/B _10538_/A _10538_/B VDD VSS sg13g2_nor2_1
XFILLER_155_245 VDD VSS sg13g2_fill_1
X_14283_ _14283_/Q clkload1/A _14283_/D _14283_/RESET_B VDD VSS sg13g2_dfrbpq_1
X_11495_ _11495_/Y _11495_/A VDD VSS sg13g2_inv_1
XFILLER_7_756 VDD VSS sg13g2_decap_8
XFILLER_109_651 VDD VSS sg13g2_fill_1
X_13868__2311 _13868_/RESET_B VDD VSS sg13g2_tiehi
XFILLER_109_673 VDD VSS sg13g2_decap_8
XFILLER_13_1274 VDD VSS sg13g2_decap_8
XFILLER_143_429 VDD VSS sg13g2_decap_4
X_13234_ _13234_/Y _14859_/Q _13234_/B VDD VSS sg13g2_nand2_1
X_10446_ _10514_/A _10459_/B _10459_/C VDD VSS sg13g2_nor2_1
XFILLER_6_266 VDD VSS sg13g2_decap_8
XFILLER_109_684 VDD VSS sg13g2_fill_2
XFILLER_109_695 VDD VSS sg13g2_fill_1
XFILLER_124_643 VDD VSS sg13g2_decap_8
XFILLER_170_259 VDD VSS sg13g2_decap_8
X_13165_ _13165_/Y _13162_/Y _13163_/Y _13164_/Y VDD VSS sg13g2_a21oi_1
X_10377_ _10396_/C _14815_/Q _14816_/Q _14817_/Q VDD VSS sg13g2_and3_1
X_14772__2941 _14772_/RESET_B VDD VSS sg13g2_tiehi
XFILLER_69_207 VDD VSS sg13g2_decap_4
XFILLER_3_973 VDD VSS sg13g2_decap_8
XFILLER_174_1367 VDD VSS sg13g2_decap_8
XFILLER_151_473 VDD VSS sg13g2_decap_4
X_12116_ _12116_/Y _12092_/Y _12094_/Y _12332_/B1 VDD VSS sg13g2_a21oi_1
XFILLER_124_698 VDD VSS sg13g2_decap_4
X_13096_ _13096_/Y _14785_/Q _13152_/A2 _13208_/B1 VDD VSS sg13g2_o21ai_1
XFILLER_34_7 VDD VSS sg13g2_decap_8
XFILLER_2_483 VDD VSS sg13g2_decap_8
XFILLER_46_1061 VDD VSS sg13g2_decap_8
X_12047_ _12047_/Y _12027_/Y _12029_/Y _12048_/A1 VDD VSS sg13g2_a21oi_1
XFILLER_78_752 VDD VSS sg13g2_decap_8
XFILLER_120_860 VDD VSS sg13g2_decap_4
XFILLER_172_70 VDD VSS sg13g2_decap_8
XFILLER_93_711 VDD VSS sg13g2_decap_8
XFILLER_1_21 VDD VSS sg13g2_decap_8
X_16855_ _16855_/X _16855_/A VDD VSS sg13g2_buf_1
XFILLER_93_733 VDD VSS sg13g2_fill_2
XFILLER_92_221 VDD VSS sg13g2_decap_8
XFILLER_65_435 VDD VSS sg13g2_decap_8
XFILLER_37_126 VDD VSS sg13g2_decap_8
XFILLER_37_137 VDD VSS sg13g2_fill_1
XFILLER_111_1340 VDD VSS sg13g2_fill_2
XFILLER_93_777 VDD VSS sg13g2_fill_1
XFILLER_53_608 VDD VSS sg13g2_decap_8
XFILLER_37_159 VDD VSS sg13g2_decap_8
XFILLER_111_1351 VDD VSS sg13g2_fill_2
X_13998_ _13998_/Q clkload37/A _13998_/D _13998_/RESET_B VDD VSS sg13g2_dfrbpq_1
XFILLER_1_98 VDD VSS sg13g2_decap_8
XFILLER_20_1267 VDD VSS sg13g2_decap_8
XFILLER_19_896 VDD VSS sg13g2_decap_8
XFILLER_0_1339 VDD VSS sg13g2_decap_8
X_13970__2209 _13970_/RESET_B VDD VSS sg13g2_tiehi
X_12949_ _12949_/Y _14776_/Q _13236_/A2 _13236_/B1 VDD VSS sg13g2_o21ai_1
XFILLER_61_630 VDD VSS sg13g2_fill_2
XFILLER_55_1319 VDD VSS sg13g2_fill_1
XFILLER_34_866 VDD VSS sg13g2_fill_1
XFILLER_61_663 VDD VSS sg13g2_decap_8
X_14619_ _14619_/Q clkload40/A _14619_/D _14619_/RESET_B VDD VSS sg13g2_dfrbpq_1
XFILLER_18_1141 VDD VSS sg13g2_decap_8
XFILLER_33_398 VDD VSS sg13g2_decap_8
XFILLER_105_1100 VDD VSS sg13g2_decap_8
XFILLER_92_1081 VDD VSS sg13g2_decap_4
XFILLER_60_195 VDD VSS sg13g2_fill_1
XFILLER_119_404 VDD VSS sg13g2_fill_2
X_08140_ _08140_/Y _08142_/C _08154_/A VDD VSS sg13g2_nand2_1
X_13681__2510 _13681_/RESET_B VDD VSS sg13g2_tiehi
X_08071_ _08071_/Y _07882_/Y _08432_/A2 _08001_/C VDD VSS sg13g2_o21ai_1
XFILLER_31_1330 VDD VSS sg13g2_decap_8
XFILLER_162_705 VDD VSS sg13g2_fill_1
XFILLER_162_716 VDD VSS sg13g2_decap_4
XFILLER_60_0 VDD VSS sg13g2_decap_8
XFILLER_174_576 VDD VSS sg13g2_decap_8
XFILLER_146_278 VDD VSS sg13g2_fill_1
X_14458__1721 _14458_/RESET_B VDD VSS sg13g2_tiehi
XFILLER_174_587 VDD VSS sg13g2_decap_8
XFILLER_162_749 VDD VSS sg13g2_decap_8
XFILLER_127_481 VDD VSS sg13g2_decap_8
XFILLER_155_790 VDD VSS sg13g2_fill_2
XFILLER_127_492 VDD VSS sg13g2_fill_2
XFILLER_143_952 VDD VSS sg13g2_decap_8
XFILLER_161_259 VDD VSS sg13g2_fill_2
XFILLER_115_676 VDD VSS sg13g2_decap_8
XFILLER_170_782 VDD VSS sg13g2_decap_8
XFILLER_103_838 VDD VSS sg13g2_decap_8
X_08973_ _13756_/D _13756_/Q _10139_/A1 _09167_/S VDD VSS sg13g2_mux2_1
XFILLER_29_28 VDD VSS sg13g2_decap_8
XFILLER_116_1240 VDD VSS sg13g2_fill_1
X_07924_ _07926_/B _08203_/A _14995_/Q _07924_/C VDD VSS sg13g2_nor3_1
XFILLER_25_1134 VDD VSS sg13g2_decap_8
XFILLER_96_560 VDD VSS sg13g2_fill_2
XFILLER_84_700 VDD VSS sg13g2_decap_8
XFILLER_64_1194 VDD VSS sg13g2_decap_8
XFILLER_57_936 VDD VSS sg13g2_decap_8
XFILLER_5_1239 VDD VSS sg13g2_decap_8
XFILLER_56_413 VDD VSS sg13g2_decap_4
X_07855_ _08641_/B _07855_/A _07855_/B VDD VSS sg13g2_or2_1
XFILLER_28_126 VDD VSS sg13g2_decap_8
XFILLER_112_1148 VDD VSS sg13g2_fill_2
XFILLER_56_457 VDD VSS sg13g2_fill_1
X_07786_ _08414_/B _07786_/A _08351_/B VDD VSS sg13g2_and2_1
XFILLER_37_660 VDD VSS sg13g2_fill_1
XFILLER_45_49 VDD VSS sg13g2_decap_8
X_09525_ _14124_/D _09624_/A0 _14124_/Q _09533_/S VDD VSS sg13g2_mux2_1
XFILLER_83_287 VDD VSS sg13g2_decap_8
X_14560__1619 _14560_/RESET_B VDD VSS sg13g2_tiehi
XFILLER_25_844 VDD VSS sg13g2_decap_4
X_13946__2233 _13946_/RESET_B VDD VSS sg13g2_tiehi
XFILLER_169_315 VDD VSS sg13g2_decap_8
X_09456_ _14057_/D _09953_/A1 _14057_/Q _09472_/S VDD VSS sg13g2_mux2_1
XFILLER_80_972 VDD VSS sg13g2_decap_4
XFILLER_101_55 VDD VSS sg13g2_decap_8
XFILLER_25_899 VDD VSS sg13g2_decap_8
XFILLER_24_376 VDD VSS sg13g2_decap_8
X_08407_ _08407_/Y _08599_/B _08327_/X _08406_/X VDD VSS sg13g2_a21oi_1
XFILLER_51_173 VDD VSS sg13g2_fill_2
X_09387_ _13990_/D _09950_/A1 _13990_/Q _09398_/S VDD VSS sg13g2_mux2_1
XFILLER_138_713 VDD VSS sg13g2_decap_8
X_08338_ _08338_/Y _08253_/X _08338_/B VDD VSS sg13g2_nand2b_1
XFILLER_138_735 VDD VSS sg13g2_decap_8
XFILLER_32_1138 VDD VSS sg13g2_decap_8
XFILLER_20_560 VDD VSS sg13g2_decap_8
XFILLER_137_223 VDD VSS sg13g2_decap_8
XFILLER_165_532 VDD VSS sg13g2_decap_8
X_08269_ _15227_/D _08039_/A _08268_/Y _08262_/Y VDD VSS sg13g2_o21ai_1
X_10300_ _14793_/D _10311_/A _10311_/B _10295_/B _10297_/B _10306_/B VDD VSS sg13g2_a221oi_1
XFILLER_158_1318 VDD VSS sg13g2_decap_8
XFILLER_106_610 VDD VSS sg13g2_decap_4
X_11280_ _11280_/Y _11279_/Y _11278_/Y _11881_/C1 VDD VSS sg13g2_a21oi_1
XFILLER_118_470 VDD VSS sg13g2_fill_1
XFILLER_3_203 VDD VSS sg13g2_decap_8
XFILLER_152_237 VDD VSS sg13g2_decap_8
X_10231_ _10232_/B _14771_/Q _14772_/Q _10234_/D VDD VSS sg13g2_nand3_1
XFILLER_105_142 VDD VSS sg13g2_decap_8
XFILLER_106_665 VDD VSS sg13g2_decap_8
XFILLER_10_63 VDD VSS sg13g2_decap_8
XFILLER_161_771 VDD VSS sg13g2_decap_8
XFILLER_106_687 VDD VSS sg13g2_decap_8
X_10162_ _14739_/D _14739_/Q _10162_/A1 _10167_/S VDD VSS sg13g2_mux2_1
XFILLER_105_186 VDD VSS sg13g2_decap_8
Xfanout1004 _10793_/A _10781_/C VDD VSS sg13g2_buf_1
XFILLER_117_1048 VDD VSS sg13g2_fill_2
Xfanout1015 _10793_/B _09016_/C VDD VSS sg13g2_buf_1
XFILLER_0_954 VDD VSS sg13g2_decap_8
Xfanout1026 _07956_/A _15011_/Q VDD VSS sg13g2_buf_1
XFILLER_82_1272 VDD VSS sg13g2_decap_4
X_14970_ _14970_/Q _15247_/CLK _14970_/D _14970_/RESET_B VDD VSS sg13g2_dfrbpq_1
Xfanout1037 _08174_/A _08668_/A VDD VSS sg13g2_buf_1
X_10093_ _14673_/D _10127_/A0 _14673_/Q _10093_/S VDD VSS sg13g2_mux2_1
XFILLER_59_240 VDD VSS sg13g2_fill_1
XFILLER_48_903 VDD VSS sg13g2_decap_8
Xfanout1048 _08340_/A _08103_/A VDD VSS sg13g2_buf_1
XFILLER_82_1283 VDD VSS sg13g2_fill_2
XFILLER_75_700 VDD VSS sg13g2_decap_8
Xfanout1059 _08377_/B _14991_/Q VDD VSS sg13g2_buf_1
X_14760__2956 _14760_/RESET_B VDD VSS sg13g2_tiehi
XFILLER_75_711 VDD VSS sg13g2_fill_2
X_13921_ _13921_/Q clkload25/A _13921_/D _13921_/RESET_B VDD VSS sg13g2_dfrbpq_1
XFILLER_59_284 VDD VSS sg13g2_decap_4
XFILLER_47_424 VDD VSS sg13g2_decap_8
XFILLER_19_126 VDD VSS sg13g2_decap_8
XFILLER_47_446 VDD VSS sg13g2_fill_2
XFILLER_63_906 VDD VSS sg13g2_decap_8
X_13852_ _13852_/Q clkload49/A _13852_/D _13852_/RESET_B VDD VSS sg13g2_dfrbpq_1
XFILLER_62_405 VDD VSS sg13g2_fill_2
X_12803_ _12803_/X _13609_/A _12899_/C _12883_/A VDD VSS sg13g2_and3_1
XFILLER_16_833 VDD VSS sg13g2_decap_8
XFILLER_90_747 VDD VSS sg13g2_fill_1
X_13783_ _13783_/Q clkload34/A _13783_/D _13783_/RESET_B VDD VSS sg13g2_dfrbpq_1
X_10995_ _10995_/Y _10995_/A _10995_/B _10995_/C VDD VSS sg13g2_nor3_1
XFILLER_55_490 VDD VSS sg13g2_decap_8
XFILLER_167_1160 VDD VSS sg13g2_fill_1
XFILLER_15_343 VDD VSS sg13g2_decap_8
XFILLER_163_1002 VDD VSS sg13g2_decap_8
X_14536__1643 _14536_/RESET_B VDD VSS sg13g2_tiehi
XFILLER_37_1005 VDD VSS sg13g2_decap_8
X_12734_ _12734_/X _12733_/X _12732_/X _12790_/S VDD VSS sg13g2_mux2_1
XFILLER_43_674 VDD VSS sg13g2_decap_8
XFILLER_37_1049 VDD VSS sg13g2_decap_8
X_12665_ _12666_/B _13671_/Q _12707_/A2 _12664_/X _12679_/B2 _12707_/C1 VDD VSS sg13g2_a221oi_1
XFILLER_30_324 VDD VSS sg13g2_decap_8
X_15076__2845 _15076_/RESET_B VDD VSS sg13g2_tiehi
XFILLER_128_1199 VDD VSS sg13g2_decap_8
X_14404_ _14404_/Q _14672_/CLK _14404_/D _14404_/RESET_B VDD VSS sg13g2_dfrbpq_1
X_11616_ _11616_/Y _12040_/A1 _13830_/Q VDD VSS sg13g2_nand2b_1
XFILLER_129_735 VDD VSS sg13g2_decap_8
XFILLER_141_1333 VDD VSS sg13g2_decap_8
XFILLER_11_560 VDD VSS sg13g2_decap_8
X_12596_ _12597_/B _13676_/Q _12707_/A2 _12595_/X _12679_/B2 _12707_/C1 VDD VSS sg13g2_a221oi_1
XFILLER_15_1358 VDD VSS sg13g2_decap_8
XFILLER_168_392 VDD VSS sg13g2_decap_8
XFILLER_117_908 VDD VSS sg13g2_fill_2
X_14335_ _14335_/Q clkload14/A _14335_/D _14335_/RESET_B VDD VSS sg13g2_dfrbpq_1
X_11547_ _11547_/Y _11543_/Y _11544_/Y _11546_/Y _11545_/Y _11549_/B VDD VSS sg13g2_a221oi_1
Xwire462 wire462/X wire462/A VDD VSS sg13g2_buf_4
XFILLER_7_553 VDD VSS sg13g2_decap_8
XFILLER_51_92 VDD VSS sg13g2_decap_8
XFILLER_167_70 VDD VSS sg13g2_decap_8
XFILLER_171_502 VDD VSS sg13g2_decap_8
XFILLER_128_278 VDD VSS sg13g2_decap_8
XFILLER_13_1071 VDD VSS sg13g2_decap_8
X_14266_ _14266_/Q _14682_/CLK _14266_/D _14266_/RESET_B VDD VSS sg13g2_dfrbpq_1
X_11478_ _11478_/Y _12293_/A1 _11476_/X _11477_/Y VDD VSS sg13g2_o21ai_1
XFILLER_143_237 VDD VSS sg13g2_decap_8
X_13217_ _13217_/X input23/X _12914_/A _13264_/B1 VDD VSS sg13g2_a21o_1
X_10429_ _10434_/C _10647_/A _14832_/Q _14831_/Q _10510_/B VDD VSS sg13g2_and4_1
XFILLER_139_1251 VDD VSS sg13g2_decap_8
X_14197_ _14197_/Q _14727_/CLK _14197_/D _14197_/RESET_B VDD VSS sg13g2_dfrbpq_1
XFILLER_98_814 VDD VSS sg13g2_decap_8
XFILLER_171_579 VDD VSS sg13g2_decap_8
XFILLER_112_602 VDD VSS sg13g2_decap_8
XFILLER_140_911 VDD VSS sg13g2_fill_1
XFILLER_135_1104 VDD VSS sg13g2_decap_8
XFILLER_83_1036 VDD VSS sg13g2_decap_8
XFILLER_135_1115 VDD VSS sg13g2_fill_2
XFILLER_48_1167 VDD VSS sg13g2_decap_4
XFILLER_3_770 VDD VSS sg13g2_decap_8
X_13148_ _13148_/Y _13170_/C _13148_/B VDD VSS sg13g2_xnor2_1
XFILLER_112_657 VDD VSS sg13g2_decap_8
XFILLER_97_346 VDD VSS sg13g2_decap_4
XFILLER_2_280 VDD VSS sg13g2_decap_8
XFILLER_97_368 VDD VSS sg13g2_decap_8
X_13079_ _13079_/Y _13077_/X _13092_/A _13160_/B VDD VSS sg13g2_nand3b_1
XFILLER_61_1334 VDD VSS sg13g2_decap_4
XFILLER_66_700 VDD VSS sg13g2_fill_1
XFILLER_39_936 VDD VSS sg13g2_fill_2
XFILLER_65_221 VDD VSS sg13g2_fill_2
XFILLER_39_969 VDD VSS sg13g2_decap_8
XFILLER_38_435 VDD VSS sg13g2_decap_4
X_07640_ _10265_/A _14781_/Q VDD VSS sg13g2_inv_1
XFILLER_66_788 VDD VSS sg13g2_fill_1
XFILLER_26_619 VDD VSS sg13g2_decap_8
XFILLER_65_265 VDD VSS sg13g2_decap_8
XFILLER_80_213 VDD VSS sg13g2_decap_8
XFILLER_47_991 VDD VSS sg13g2_decap_8
XFILLER_0_1136 VDD VSS sg13g2_decap_8
XFILLER_20_1064 VDD VSS sg13g2_decap_8
XFILLER_19_693 VDD VSS sg13g2_decap_8
XFILLER_81_769 VDD VSS sg13g2_decap_4
X_09310_ _13917_/D _09310_/A0 _13917_/Q _09325_/S VDD VSS sg13g2_mux2_1
XFILLER_59_1274 VDD VSS sg13g2_decap_8
XFILLER_80_279 VDD VSS sg13g2_fill_1
XFILLER_62_983 VDD VSS sg13g2_decap_8
X_09241_ _09273_/S _09307_/B _10137_/C VDD VSS sg13g2_nor2_1
XFILLER_61_493 VDD VSS sg13g2_decap_8
XFILLER_107_1239 VDD VSS sg13g2_decap_8
XFILLER_21_357 VDD VSS sg13g2_decap_8
XFILLER_166_329 VDD VSS sg13g2_decap_8
X_09172_ _13788_/D _13788_/Q _09907_/A1 _09202_/S VDD VSS sg13g2_mux2_1
XFILLER_147_521 VDD VSS sg13g2_fill_2
XFILLER_159_392 VDD VSS sg13g2_decap_8
X_08123_ _08688_/D _13522_/A1 _08048_/Y _08242_/A VDD VSS sg13g2_o21ai_1
XFILLER_162_502 VDD VSS sg13g2_decap_8
XFILLER_107_429 VDD VSS sg13g2_decap_4
X_08054_ _08054_/Y _07972_/B _08054_/B VDD VSS sg13g2_nand2b_1
XFILLER_66_1201 VDD VSS sg13g2_decap_4
XFILLER_134_248 VDD VSS sg13g2_fill_1
XFILLER_150_708 VDD VSS sg13g2_decap_8
XFILLER_1_707 VDD VSS sg13g2_decap_8
XFILLER_66_1234 VDD VSS sg13g2_decap_8
Xhold3101 _13637_/A _13745_/Q VDD VSS sg13g2_dlygate4sd3_1
XFILLER_115_473 VDD VSS sg13g2_fill_2
XFILLER_153_1204 VDD VSS sg13g2_fill_1
Xhold3112 _13638_/A _13746_/Q VDD VSS sg13g2_dlygate4sd3_1
XFILLER_0_217 VDD VSS sg13g2_decap_8
XFILLER_153_1215 VDD VSS sg13g2_decap_8
XFILLER_163_28 VDD VSS sg13g2_decap_8
Xhold3123 _13623_/A _13731_/Q VDD VSS sg13g2_dlygate4sd3_1
XFILLER_27_1229 VDD VSS sg13g2_decap_8
Xhold3134 _13643_/A _13751_/Q VDD VSS sg13g2_dlygate4sd3_1
Xhold3145 _13539_/A _15145_/Q VDD VSS sg13g2_dlygate4sd3_1
XFILLER_89_869 VDD VSS sg13g2_fill_2
XFILLER_131_966 VDD VSS sg13g2_fill_1
XFILLER_153_1248 VDD VSS sg13g2_decap_8
X_14614__1565 _14614_/RESET_B VDD VSS sg13g2_tiehi
Xhold3156 _11196_/A _14956_/Q VDD VSS sg13g2_dlygate4sd3_1
XFILLER_118_1379 VDD VSS sg13g2_fill_1
Xhold3167 hold3167/X _14795_/Q VDD VSS sg13g2_dlygate4sd3_1
X_08956_ _13722_/D _16884_/A _08955_/X _08956_/S VDD VSS sg13g2_mux2_1
XFILLER_9_1183 VDD VSS sg13g2_decap_8
X_07907_ _07908_/B _15073_/Q _15216_/Q _15215_/Q _07907_/D VDD VSS sg13g2_nor4_1
XFILLER_69_593 VDD VSS sg13g2_fill_1
XFILLER_5_1036 VDD VSS sg13g2_decap_8
X_08887_ _08887_/Y _11706_/A _08891_/S _08886_/Y VDD VSS sg13g2_a21oi_1
XFILLER_29_446 VDD VSS sg13g2_decap_4
XFILLER_99_1054 VDD VSS sg13g2_decap_4
X_07838_ _08684_/A _08697_/B _08698_/A VDD VSS sg13g2_nand2_1
XFILLER_56_265 VDD VSS sg13g2_decap_4
XFILLER_112_21 VDD VSS sg13g2_decap_8
XFILLER_38_980 VDD VSS sg13g2_decap_8
XFILLER_99_1098 VDD VSS sg13g2_decap_8
X_07769_ _08318_/A _08265_/A _08265_/B VDD VSS sg13g2_nor2_1
X_14929__2686 _14929_/RESET_B VDD VSS sg13g2_tiehi
XFILLER_72_14 VDD VSS sg13g2_decap_8
X_09508_ _14107_/D _09574_/A1 _14107_/Q _09533_/S VDD VSS sg13g2_mux2_1
XFILLER_38_1314 VDD VSS sg13g2_fill_1
XFILLER_73_1205 VDD VSS sg13g2_fill_1
XFILLER_24_140 VDD VSS sg13g2_decap_8
XFILLER_169_112 VDD VSS sg13g2_decap_8
X_10780_ _14921_/D _11193_/B1 _11164_/B _10779_/Y VDD VSS sg13g2_o21ai_1
XFILLER_73_1227 VDD VSS sg13g2_fill_2
XFILLER_38_1347 VDD VSS sg13g2_decap_8
XFILLER_13_847 VDD VSS sg13g2_decap_8
X_09439_ _14041_/D _10101_/A0 _14041_/Q _09439_/S VDD VSS sg13g2_mux2_1
XFILLER_12_357 VDD VSS sg13g2_decap_8
XFILLER_169_189 VDD VSS sg13g2_decap_8
X_12450_ _12450_/X _13954_/Q _13986_/Q _14018_/Q _14050_/Q _12450_/S0 _12450_/S1 VDD
+ VSS sg13g2_mux4_1
XFILLER_166_830 VDD VSS sg13g2_fill_2
X_11401_ _11401_/Y _11401_/A _11401_/B _11419_/C VDD VSS sg13g2_nand3_1
X_12381_ _12381_/X _14365_/Q _14397_/Q _14461_/Q _14493_/Q _12382_/S0 _12382_/S1 VDD
+ VSS sg13g2_mux4_1
X_14120_ _14120_/Q _14310_/CLK _14120_/D _14120_/RESET_B VDD VSS sg13g2_dfrbpq_1
XFILLER_10_1211 VDD VSS sg13g2_decap_8
X_11332_ _11332_/Y _11231_/S _11313_/Y _11331_/Y VDD VSS sg13g2_o21ai_1
XFILLER_107_930 VDD VSS sg13g2_decap_8
XFILLER_107_952 VDD VSS sg13g2_decap_8
XFILLER_158_1148 VDD VSS sg13g2_decap_4
XFILLER_21_84 VDD VSS sg13g2_decap_8
XFILLER_108_0 VDD VSS sg13g2_decap_8
X_14051_ _14051_/Q _14659_/CLK _14051_/D _14051_/RESET_B VDD VSS sg13g2_dfrbpq_1
XFILLER_153_579 VDD VSS sg13g2_fill_1
X_11263_ _11263_/Y _12326_/A1 _13916_/Q _11262_/Y VDD VSS sg13g2_a21oi_1
XFILLER_97_11 VDD VSS sg13g2_fill_2
XFILLER_4_567 VDD VSS sg13g2_decap_8
XFILLER_10_1288 VDD VSS sg13g2_decap_8
X_13002_ _13002_/Y _14779_/Q _13236_/A2 _13181_/B1 VDD VSS sg13g2_o21ai_1
X_10214_ _10214_/Y _07661_/Y _10213_/X _14764_/Q VDD VSS sg13g2_a21oi_1
X_11194_ _11194_/Y _11192_/X _11188_/Y _11193_/Y VDD VSS sg13g2_o21ai_1
XFILLER_121_421 VDD VSS sg13g2_decap_4
XFILLER_84_1378 VDD VSS sg13g2_fill_2
XFILLER_133_292 VDD VSS sg13g2_decap_8
X_10145_ _14722_/D _14722_/Q _10145_/A1 _10168_/S VDD VSS sg13g2_mux2_1
XFILLER_171_1348 VDD VSS sg13g2_decap_8
XFILLER_0_751 VDD VSS sg13g2_decap_8
XFILLER_94_316 VDD VSS sg13g2_decap_8
X_14953_ _14953_/Q clkload54/A _14953_/D _14953_/RESET_B VDD VSS sg13g2_dfrbpq_1
X_10076_ _14656_/D _10076_/A0 _14656_/Q _10101_/S VDD VSS sg13g2_mux2_1
XFILLER_130_1023 VDD VSS sg13g2_fill_2
XFILLER_48_755 VDD VSS sg13g2_decap_8
XFILLER_75_541 VDD VSS sg13g2_decap_8
X_13904_ _13904_/Q _14512_/CLK _13904_/D _13904_/RESET_B VDD VSS sg13g2_dfrbpq_1
XFILLER_43_1097 VDD VSS sg13g2_decap_8
XFILLER_169_1233 VDD VSS sg13g2_decap_8
X_14884_ _14884_/Q _14885_/CLK _14884_/D _14884_/RESET_B VDD VSS sg13g2_dfrbpq_1
XFILLER_63_714 VDD VSS sg13g2_decap_8
XFILLER_21_1351 VDD VSS sg13g2_decap_8
X_13835_ _13835_/Q _14667_/CLK _13835_/D _13835_/RESET_B VDD VSS sg13g2_dfrbpq_1
XFILLER_46_70 VDD VSS sg13g2_decap_8
XFILLER_16_630 VDD VSS sg13g2_decap_8
XFILLER_15_140 VDD VSS sg13g2_decap_8
X_13766_ _13766_/Q clkload11/A _13766_/D _13766_/RESET_B VDD VSS sg13g2_dfrbpq_1
X_14052__2127 _14052_/RESET_B VDD VSS sg13g2_tiehi
XFILLER_50_419 VDD VSS sg13g2_decap_8
X_10978_ _10978_/Y _10978_/A _10978_/B VDD VSS sg13g2_nor2_1
XFILLER_91_1316 VDD VSS sg13g2_decap_8
X_12717_ _12717_/X _14261_/Q _14293_/Q _14325_/Q _14357_/Q _12717_/S0 _12717_/S1 VDD
+ VSS sg13g2_mux4_1
X_13697_ _16859_/A _15226_/CLK _13697_/D _13697_/RESET_B VDD VSS sg13g2_dfrbpq_1
X_12648_ _12648_/X _12645_/X _12644_/X _12641_/X _12640_/X _12649_/S0 _12539_/S VDD
+ VSS sg13g2_mux4_1
XFILLER_62_91 VDD VSS sg13g2_decap_8
XFILLER_169_690 VDD VSS sg13g2_decap_8
XFILLER_31_688 VDD VSS sg13g2_decap_4
XFILLER_141_1130 VDD VSS sg13g2_decap_8
XFILLER_129_554 VDD VSS sg13g2_decap_8
XFILLER_141_1152 VDD VSS sg13g2_fill_1
XFILLER_15_1155 VDD VSS sg13g2_decap_8
XFILLER_8_840 VDD VSS sg13g2_decap_8
XFILLER_50_1035 VDD VSS sg13g2_decap_8
XFILLER_141_1163 VDD VSS sg13g2_decap_4
XFILLER_11_1008 VDD VSS sg13g2_decap_8
X_12579_ _12579_/X _12574_/X _12578_/X _12573_/X _12577_/X _12663_/S0 _12663_/S1 VDD
+ VSS sg13g2_mux4_1
XFILLER_7_42 VDD VSS sg13g2_decap_8
XFILLER_7_350 VDD VSS sg13g2_decap_8
XFILLER_141_1196 VDD VSS sg13g2_fill_2
X_14318_ _14318_/Q clkload37/A _14318_/D _14318_/RESET_B VDD VSS sg13g2_dfrbpq_1
XFILLER_102_1158 VDD VSS sg13g2_decap_8
XFILLER_172_833 VDD VSS sg13g2_fill_2
XFILLER_116_226 VDD VSS sg13g2_decap_8
XFILLER_172_855 VDD VSS sg13g2_fill_1
XFILLER_144_568 VDD VSS sg13g2_fill_2
X_14249_ _14249_/Q clkload19/A _14249_/D _14249_/RESET_B VDD VSS sg13g2_dfrbpq_1
XFILLER_171_376 VDD VSS sg13g2_decap_8
XFILLER_113_933 VDD VSS sg13g2_fill_2
XFILLER_124_270 VDD VSS sg13g2_fill_1
XFILLER_139_1070 VDD VSS sg13g2_decap_8
Xfanout808 _12655_/S1 fanout812/X VDD VSS sg13g2_buf_1
XFILLER_98_644 VDD VSS sg13g2_fill_2
Xfanout819 _12614_/S1 _12618_/S1 VDD VSS sg13g2_buf_1
X_08810_ _08811_/B _13688_/Q _08826_/B VDD VSS sg13g2_nor2_1
X_09790_ _14379_/D _09889_/A0 _14379_/Q _09796_/S VDD VSS sg13g2_mux2_1
XFILLER_98_688 VDD VSS sg13g2_decap_4
XFILLER_23_0 VDD VSS sg13g2_decap_8
XFILLER_113_1210 VDD VSS sg13g2_decap_8
XFILLER_6_1323 VDD VSS sg13g2_decap_8
XFILLER_61_1142 VDD VSS sg13g2_decap_4
X_08741_ _13665_/D _08765_/A1 _08739_/Y _08740_/Y VDD VSS sg13g2_a21oi_1
XFILLER_26_1273 VDD VSS sg13g2_decap_8
XFILLER_152_1281 VDD VSS sg13g2_decap_8
X_14262__1917 _14262_/RESET_B VDD VSS sg13g2_tiehi
Xfanout1390 _10392_/B _10499_/C VDD VSS sg13g2_buf_1
XFILLER_39_766 VDD VSS sg13g2_fill_1
XFILLER_38_243 VDD VSS sg13g2_decap_8
X_08672_ _08672_/X _08672_/A _08673_/B _15019_/Q VDD VSS sg13g2_and3_1
XFILLER_54_736 VDD VSS sg13g2_decap_8
XFILLER_53_213 VDD VSS sg13g2_decap_8
X_07623_ _07623_/Y _14854_/Q VDD VSS sg13g2_inv_1
XFILLER_26_438 VDD VSS sg13g2_decap_8
XFILLER_54_758 VDD VSS sg13g2_decap_8
XFILLER_53_235 VDD VSS sg13g2_decap_8
XFILLER_19_490 VDD VSS sg13g2_decap_8
XFILLER_35_950 VDD VSS sg13g2_fill_2
XFILLER_81_566 VDD VSS sg13g2_decap_8
X_14028__2151 _14028_/RESET_B VDD VSS sg13g2_tiehi
XFILLER_62_780 VDD VSS sg13g2_decap_8
XFILLER_22_622 VDD VSS sg13g2_decap_4
XFILLER_146_1063 VDD VSS sg13g2_decap_4
XFILLER_167_616 VDD VSS sg13g2_fill_2
XFILLER_42_28 VDD VSS sg13g2_decap_8
XFILLER_50_975 VDD VSS sg13g2_fill_2
X_09224_ _13835_/D _09922_/A1 _13835_/Q _09230_/S VDD VSS sg13g2_mux2_1
XFILLER_72_1260 VDD VSS sg13g2_decap_4
XFILLER_21_154 VDD VSS sg13g2_decap_8
XFILLER_158_28 VDD VSS sg13g2_decap_8
XFILLER_166_126 VDD VSS sg13g2_decap_8
X_09155_ _09155_/Y _09072_/B _15051_/Q _09154_/Y VDD VSS sg13g2_o21ai_1
XFILLER_33_1288 VDD VSS sg13g2_decap_8
X_08106_ _08106_/Y _08001_/A _08105_/Y _08001_/C VDD VSS sg13g2_o21ai_1
XFILLER_163_833 VDD VSS sg13g2_fill_2
X_13750__2429 _13750_/RESET_B VDD VSS sg13g2_tiehi
XFILLER_120_1258 VDD VSS sg13g2_decap_8
X_09086_ _09086_/Y _09072_/B _15041_/Q _09085_/Y VDD VSS sg13g2_o21ai_1
X_13896__2283 _13896_/RESET_B VDD VSS sg13g2_tiehi
XFILLER_68_1329 VDD VSS sg13g2_decap_8
XFILLER_101_7 VDD VSS sg13g2_decap_8
X_08037_ _08039_/C _08037_/A _08037_/B _08522_/C VDD VSS sg13g2_nand3_1
XFILLER_150_505 VDD VSS sg13g2_decap_8
XFILLER_162_376 VDD VSS sg13g2_decap_8
XFILLER_122_218 VDD VSS sg13g2_decap_8
XFILLER_1_504 VDD VSS sg13g2_decap_8
XFILLER_107_21 VDD VSS sg13g2_fill_1
XFILLER_157_1181 VDD VSS sg13g2_decap_8
XFILLER_131_741 VDD VSS sg13g2_decap_8
XFILLER_89_655 VDD VSS sg13g2_decap_4
XFILLER_27_1026 VDD VSS sg13g2_decap_8
XFILLER_103_443 VDD VSS sg13g2_decap_8
XFILLER_67_14 VDD VSS sg13g2_decap_8
XFILLER_103_454 VDD VSS sg13g2_fill_1
XFILLER_49_508 VDD VSS sg13g2_decap_8
X_14130__2049 _14130_/RESET_B VDD VSS sg13g2_tiehi
X_09988_ _14571_/D _10121_/A0 _14571_/Q _09994_/S VDD VSS sg13g2_mux2_1
XFILLER_103_487 VDD VSS sg13g2_decap_8
X_08939_ _08939_/X _15049_/Q _14953_/Q _10725_/A VDD VSS sg13g2_mux2_1
XFILLER_85_850 VDD VSS sg13g2_decap_8
XFILLER_57_541 VDD VSS sg13g2_decap_8
XFILLER_123_42 VDD VSS sg13g2_decap_8
X_14238__1941 _14238_/RESET_B VDD VSS sg13g2_tiehi
XFILLER_85_861 VDD VSS sg13g2_decap_8
XFILLER_18_917 VDD VSS sg13g2_decap_8
XFILLER_131_1365 VDD VSS sg13g2_decap_8
X_11950_ _11952_/A _12025_/A _14640_/Q VDD VSS sg13g2_nand2b_1
XFILLER_57_574 VDD VSS sg13g2_decap_8
X_15136__2685 _15136_/RESET_B VDD VSS sg13g2_tiehi
XFILLER_84_371 VDD VSS sg13g2_fill_2
XFILLER_17_427 VDD VSS sg13g2_decap_8
X_10901_ _10901_/Y _11045_/A2 _10923_/A _10900_/Y VDD VSS sg13g2_a21oi_1
XFILLER_83_35 VDD VSS sg13g2_decap_4
XFILLER_29_298 VDD VSS sg13g2_decap_8
X_11881_ _11881_/Y _11877_/Y _11878_/Y _11880_/Y _11879_/Y _11881_/C1 VDD VSS sg13g2_a221oi_1
XFILLER_44_235 VDD VSS sg13g2_decap_8
X_13620_ _13728_/D _13620_/A VDD VSS sg13g2_buf_1
X_10832_ _10832_/X _10832_/A _10843_/C VDD VSS sg13g2_and2_1
XFILLER_32_408 VDD VSS sg13g2_decap_8
XFILLER_26_972 VDD VSS sg13g2_decap_8
XFILLER_44_279 VDD VSS sg13g2_decap_8
XFILLER_129_1250 VDD VSS sg13g2_decap_8
XFILLER_16_84 VDD VSS sg13g2_decap_8
XFILLER_164_1152 VDD VSS sg13g2_decap_8
X_13551_ _15148_/D _15148_/Q _13550_/Y _13565_/S VDD VSS sg13g2_mux2_1
XFILLER_13_644 VDD VSS sg13g2_decap_8
X_10763_ _11115_/B _14949_/Q _10767_/A _10762_/Y VDD VSS sg13g2_a21oi_1
XFILLER_73_1046 VDD VSS sg13g2_decap_8
XFILLER_73_1057 VDD VSS sg13g2_fill_1
XFILLER_38_1177 VDD VSS sg13g2_decap_8
X_12502_ _12502_/X _14374_/Q _14406_/Q _14470_/Q _14502_/Q _12507_/S0 _12507_/S1 VDD
+ VSS sg13g2_mux4_1
XFILLER_12_154 VDD VSS sg13g2_decap_8
XFILLER_157_126 VDD VSS sg13g2_decap_8
X_13482_ _13484_/B _13482_/A _13482_/B _15189_/Q VDD VSS sg13g2_nand3_1
XFILLER_9_637 VDD VSS sg13g2_decap_8
XFILLER_125_1169 VDD VSS sg13g2_fill_2
X_10694_ _10871_/A _14932_/Q _09003_/X _10694_/S VDD VSS sg13g2_mux2_1
XFILLER_139_852 VDD VSS sg13g2_fill_2
X_15221_ _15221_/Q clkload61/A _15221_/D _15221_/RESET_B VDD VSS sg13g2_dfrbpq_1
X_12433_ _12433_/X _13825_/Q _13857_/Q _13889_/Q _13921_/Q _12452_/S0 _12452_/S1 VDD
+ VSS sg13g2_mux4_1
XFILLER_8_147 VDD VSS sg13g2_decap_8
XFILLER_173_619 VDD VSS sg13g2_decap_8
XFILLER_138_373 VDD VSS sg13g2_decap_8
XFILLER_139_896 VDD VSS sg13g2_fill_2
X_15152_ _15152_/Q clkload68/A _15152_/D _15152_/RESET_B VDD VSS sg13g2_dfrbpq_1
XFILLER_154_844 VDD VSS sg13g2_fill_1
X_12364_ _12364_/X _13948_/Q _13980_/Q _14012_/Q _14044_/Q _12783_/S0 _12783_/S1 VDD
+ VSS sg13g2_mux4_1
X_14340__1839 _14340_/RESET_B VDD VSS sg13g2_tiehi
XFILLER_154_855 VDD VSS sg13g2_decap_8
X_13726__2453 _13726_/RESET_B VDD VSS sg13g2_tiehi
X_14103_ _14103_/Q clkload32/A _14103_/D _14103_/RESET_B VDD VSS sg13g2_dfrbpq_1
X_14486__1693 _14486_/RESET_B VDD VSS sg13g2_tiehi
XFILLER_5_854 VDD VSS sg13g2_decap_8
X_11315_ _11315_/Y _11328_/S0 _14397_/Q _11328_/S1 VDD VSS sg13g2_a21oi_1
XFILLER_141_505 VDD VSS sg13g2_fill_2
X_15083_ _15083_/Q clkload70/A _15083_/D _15083_/RESET_B VDD VSS sg13g2_dfrbpq_1
X_12295_ _12295_/Y _12293_/Y _12294_/Y _12295_/B1 VDD VSS sg13g2_a21oi_1
XFILLER_153_376 VDD VSS sg13g2_decap_8
XFILLER_4_364 VDD VSS sg13g2_decap_8
XFILLER_153_387 VDD VSS sg13g2_fill_1
XFILLER_10_1085 VDD VSS sg13g2_decap_8
XFILLER_141_538 VDD VSS sg13g2_decap_4
X_14034_ _14034_/Q _14706_/CLK _14034_/D _14034_/RESET_B VDD VSS sg13g2_dfrbpq_1
X_11246_ _11246_/Y _13293_/D _07690_/X _11245_/Y VDD VSS sg13g2_a21oi_1
XFILLER_122_741 VDD VSS sg13g2_decap_4
XFILLER_84_1164 VDD VSS sg13g2_decap_8
XFILLER_45_1126 VDD VSS sg13g2_decap_4
XFILLER_110_903 VDD VSS sg13g2_fill_2
X_11177_ _11177_/X _11197_/A _11177_/B _11177_/C VDD VSS sg13g2_or3_1
XFILLER_136_1276 VDD VSS sg13g2_decap_4
X_14106__2073 _14106_/RESET_B VDD VSS sg13g2_tiehi
XFILLER_0_581 VDD VSS sg13g2_decap_8
X_10128_ _14706_/D _10128_/A0 _14706_/Q _10134_/S VDD VSS sg13g2_mux2_1
XFILLER_48_552 VDD VSS sg13g2_decap_4
X_14936_ _14936_/Q clkload57/A _14936_/D _14936_/RESET_B VDD VSS sg13g2_dfrbpq_1
X_10059_ _14640_/D _10092_/A0 _14640_/Q _10069_/S VDD VSS sg13g2_mux2_1
XFILLER_76_883 VDD VSS sg13g2_fill_2
XFILLER_35_202 VDD VSS sg13g2_decap_4
XFILLER_169_1041 VDD VSS sg13g2_decap_8
XFILLER_36_747 VDD VSS sg13g2_decap_8
XFILLER_169_1063 VDD VSS sg13g2_fill_1
X_14867_ _14867_/Q _14867_/CLK _14867_/D _14867_/RESET_B VDD VSS sg13g2_dfrbpq_1
XFILLER_169_1085 VDD VSS sg13g2_decap_8
XFILLER_1_1253 VDD VSS sg13g2_decap_8
X_13818_ _13818_/Q _14746_/CLK _13818_/D _13818_/RESET_B VDD VSS sg13g2_dfrbpq_1
XFILLER_56_1211 VDD VSS sg13g2_fill_2
X_14798_ _14798_/Q _14868_/CLK _14798_/D _14798_/RESET_B VDD VSS sg13g2_dfrbpq_1
XFILLER_17_994 VDD VSS sg13g2_decap_8
XFILLER_44_791 VDD VSS sg13g2_decap_4
X_13749_ _13749_/Q _14677_/CLK _13749_/D _13749_/RESET_B VDD VSS sg13g2_dfrbpq_1
XFILLER_31_441 VDD VSS sg13g2_decap_8
XFILLER_148_104 VDD VSS sg13g2_fill_1
XFILLER_17_1239 VDD VSS sg13g2_decap_8
XFILLER_91_1179 VDD VSS sg13g2_fill_2
XFILLER_149_649 VDD VSS sg13g2_fill_1
XFILLER_32_997 VDD VSS sg13g2_decap_8
XFILLER_148_126 VDD VSS sg13g2_decap_8
XFILLER_148_137 VDD VSS sg13g2_fill_1
XFILLER_145_811 VDD VSS sg13g2_decap_8
XFILLER_129_395 VDD VSS sg13g2_decap_8
XFILLER_89_1064 VDD VSS sg13g2_fill_2
X_14316__1863 _14316_/RESET_B VDD VSS sg13g2_tiehi
XFILLER_171_140 VDD VSS sg13g2_decap_8
XFILLER_145_888 VDD VSS sg13g2_fill_2
XFILLER_160_836 VDD VSS sg13g2_decap_8
XFILLER_99_920 VDD VSS sg13g2_decap_8
X_09911_ _14496_/D _14496_/Q _09911_/A1 _09935_/S VDD VSS sg13g2_mux2_1
XFILLER_154_1321 VDD VSS sg13g2_decap_8
XFILLER_67_1373 VDD VSS sg13g2_fill_1
Xfanout605 _10675_/A _08838_/Y VDD VSS sg13g2_buf_1
XFILLER_98_441 VDD VSS sg13g2_fill_2
Xfanout616 _08891_/S _08904_/S VDD VSS sg13g2_buf_1
Xclkbuf_4_11_0_clk_i clkbuf_4_11_0_clk_i/X clkbuf_0_clk_i/X VDD VSS sg13g2_buf_8
Xfanout627 _08674_/B1 _07998_/X VDD VSS sg13g2_buf_1
X_09842_ _14429_/D _14429_/Q _10107_/A0 _09863_/S VDD VSS sg13g2_mux2_1
XFILLER_28_1357 VDD VSS sg13g2_decap_8
Xfanout638 _08001_/A _08432_/A2 VDD VSS sg13g2_buf_1
XFILLER_99_997 VDD VSS sg13g2_decap_8
XFILLER_140_571 VDD VSS sg13g2_decap_8
XFILLER_85_102 VDD VSS sg13g2_decap_8
XFILLER_98_496 VDD VSS sg13g2_decap_8
XFILLER_100_424 VDD VSS sg13g2_fill_1
XFILLER_112_284 VDD VSS sg13g2_decap_8
XFILLER_150_1229 VDD VSS sg13g2_decap_8
XFILLER_6_1120 VDD VSS sg13g2_decap_8
XFILLER_112_295 VDD VSS sg13g2_fill_2
X_09773_ _09773_/Y _09905_/A _09938_/B _09938_/C _10105_/B VDD VSS sg13g2_nand4_1
XFILLER_26_1070 VDD VSS sg13g2_decap_8
XFILLER_85_146 VDD VSS sg13g2_fill_1
XFILLER_37_28 VDD VSS sg13g2_decap_8
Xclkbuf_leaf_50_clk_i clkload58/A clkbuf_leaf_52_clk_i/A VDD VSS sg13g2_buf_8
XFILLER_85_157 VDD VSS sg13g2_decap_4
X_08724_ _08724_/Y _08723_/A _10797_/C VDD VSS sg13g2_nand2b_1
XFILLER_82_820 VDD VSS sg13g2_decap_8
XFILLER_113_1084 VDD VSS sg13g2_decap_4
XFILLER_6_1197 VDD VSS sg13g2_decap_8
XFILLER_66_382 VDD VSS sg13g2_fill_2
X_08655_ _08655_/Y _08054_/B _08010_/B _08054_/Y VDD VSS sg13g2_o21ai_1
XFILLER_96_1035 VDD VSS sg13g2_decap_8
XFILLER_26_224 VDD VSS sg13g2_decap_8
XFILLER_54_577 VDD VSS sg13g2_fill_2
XFILLER_42_728 VDD VSS sg13g2_decap_8
X_08586_ _08588_/C _08641_/C _08586_/B _08586_/C VDD VSS sg13g2_nand3_1
XFILLER_148_1169 VDD VSS sg13g2_decap_4
X_13804__2375 _13804_/RESET_B VDD VSS sg13g2_tiehi
Xclkbuf_leaf_65_clk_i clkload65/A clkbuf_leaf_83_clk_i/A VDD VSS sg13g2_buf_8
X_15078__2837 _15078_/RESET_B VDD VSS sg13g2_tiehi
XFILLER_53_49 VDD VSS sg13g2_fill_1
XFILLER_168_914 VDD VSS sg13g2_decap_8
XFILLER_169_49 VDD VSS sg13g2_decap_8
XFILLER_22_441 VDD VSS sg13g2_decap_8
XFILLER_149_7 VDD VSS sg13g2_decap_8
XFILLER_167_413 VDD VSS sg13g2_decap_8
X_09207_ _13819_/D _09774_/A0 _13819_/Q _09233_/S VDD VSS sg13g2_mux2_1
XFILLER_10_658 VDD VSS sg13g2_decap_8
XFILLER_148_671 VDD VSS sg13g2_fill_2
XFILLER_120_1022 VDD VSS sg13g2_decap_8
X_09138_ _09138_/X _09137_/A _10776_/A _09137_/Y VDD VSS sg13g2_a21o_1
XFILLER_118_42 VDD VSS sg13g2_decap_8
XFILLER_162_140 VDD VSS sg13g2_decap_8
XFILLER_151_814 VDD VSS sg13g2_decap_4
X_09069_ _09069_/X _09137_/A _09069_/B _09103_/C VDD VSS sg13g2_or3_1
XFILLER_118_53 VDD VSS sg13g2_fill_2
XFILLER_11_1372 VDD VSS sg13g2_decap_8
XFILLER_11_1383 VDD VSS sg13g2_fill_1
XFILLER_151_836 VDD VSS sg13g2_fill_2
XFILLER_155_1107 VDD VSS sg13g2_decap_8
X_11100_ _11100_/Y _11029_/C _10759_/X _11154_/B1 VDD VSS sg13g2_o21ai_1
XFILLER_1_301 VDD VSS sg13g2_decap_8
XFILLER_118_86 VDD VSS sg13g2_decap_8
XFILLER_78_35 VDD VSS sg13g2_decap_8
X_12080_ _12080_/Y _12079_/Y _12078_/Y _12065_/Y _12156_/A _12126_/A VDD VSS sg13g2_a221oi_1
XFILLER_2_868 VDD VSS sg13g2_decap_8
X_11031_ _14943_/D _11029_/Y _11030_/Y _11021_/X VDD VSS sg13g2_a21o_1
XFILLER_81_1326 VDD VSS sg13g2_fill_1
XFILLER_103_240 VDD VSS sg13g2_decap_8
XFILLER_103_251 VDD VSS sg13g2_fill_1
XFILLER_49_305 VDD VSS sg13g2_decap_8
XFILLER_1_378 VDD VSS sg13g2_decap_8
Xclkbuf_leaf_18_clk_i _14984_/CLK clkbuf_leaf_75_clk_i/A VDD VSS sg13g2_buf_8
XFILLER_44_1170 VDD VSS sg13g2_fill_2
XFILLER_92_617 VDD VSS sg13g2_decap_8
XFILLER_64_308 VDD VSS sg13g2_decap_8
XFILLER_58_861 VDD VSS sg13g2_fill_1
XFILLER_131_1151 VDD VSS sg13g2_decap_8
X_12982_ _12982_/Y _12980_/Y _12981_/Y _12933_/Y VDD VSS sg13g2_o21ai_1
XFILLER_94_56 VDD VSS sg13g2_decap_4
XFILLER_76_179 VDD VSS sg13g2_decap_8
XFILLER_58_883 VDD VSS sg13g2_decap_8
XFILLER_18_714 VDD VSS sg13g2_decap_8
XFILLER_91_116 VDD VSS sg13g2_decap_8
X_14721_ _14721_/Q _14721_/CLK _14721_/D _14721_/RESET_B VDD VSS sg13g2_dfrbpq_1
X_11933_ _14977_/D _11914_/A _11980_/A _11932_/Y VDD VSS sg13g2_a21o_1
XFILLER_17_224 VDD VSS sg13g2_decap_8
XFILLER_166_1203 VDD VSS sg13g2_fill_1
XFILLER_73_853 VDD VSS sg13g2_decap_8
XFILLER_40_1089 VDD VSS sg13g2_decap_8
XFILLER_72_341 VDD VSS sg13g2_decap_4
X_14652_ _14652_/Q clkload44/A _14652_/D _14652_/RESET_B VDD VSS sg13g2_dfrbpq_1
X_11864_ _11864_/Y _11865_/A _13674_/Q VDD VSS sg13g2_nor2_1
XFILLER_45_588 VDD VSS sg13g2_decap_4
XFILLER_26_780 VDD VSS sg13g2_decap_8
XFILLER_14_931 VDD VSS sg13g2_decap_8
X_13603_ _13603_/Y _13602_/Y _13600_/Y _08830_/X VDD VSS sg13g2_o21ai_1
X_10815_ _10815_/Y _10869_/A _10814_/Y _13307_/B VDD VSS sg13g2_a21oi_1
X_14583_ _14583_/Q clkload34/A _14583_/D _14583_/RESET_B VDD VSS sg13g2_dfrbpq_1
X_11795_ _14973_/D _11770_/A _11980_/A _11794_/Y VDD VSS sg13g2_a21o_1
XFILLER_129_1080 VDD VSS sg13g2_fill_2
XFILLER_13_441 VDD VSS sg13g2_decap_8
XFILLER_158_413 VDD VSS sg13g2_decap_8
X_13534_ _13534_/Y _13533_/A _13566_/C _08351_/B _13546_/B2 VDD VSS sg13g2_a22oi_1
X_10746_ _14914_/D _09204_/C _11078_/A _10745_/Y VDD VSS sg13g2_o21ai_1
XFILLER_9_434 VDD VSS sg13g2_decap_8
XFILLER_51_1130 VDD VSS sg13g2_decap_8
X_13465_ _13465_/Y _13412_/B _13483_/A2 _07729_/D VDD VSS sg13g2_o21ai_1
X_14573__1606 _14573_/RESET_B VDD VSS sg13g2_tiehi
X_10677_ _10844_/A _08977_/B _10684_/A2 _10805_/B VDD VSS sg13g2_a21o_1
XFILLER_103_1231 VDD VSS sg13g2_decap_8
X_13959__2220 _13959_/RESET_B VDD VSS sg13g2_tiehi
X_15204_ _15204_/Q _15214_/CLK _15204_/D _15204_/RESET_B VDD VSS sg13g2_dfrbpq_1
XFILLER_103_1242 VDD VSS sg13g2_fill_2
X_12416_ _12416_/Y _12347_/B _12348_/A _12777_/A2 _13689_/Q _13282_/A1 VDD VSS sg13g2_a221oi_1
XFILLER_103_1253 VDD VSS sg13g2_fill_2
XFILLER_154_630 VDD VSS sg13g2_decap_8
XFILLER_166_490 VDD VSS sg13g2_decap_8
X_13396_ _13396_/Y _13401_/C _13401_/B _13396_/C _13396_/D VDD VSS sg13g2_nor4_1
XFILLER_86_1204 VDD VSS sg13g2_decap_8
XFILLER_64_7 VDD VSS sg13g2_decap_8
XFILLER_51_1196 VDD VSS sg13g2_fill_1
XFILLER_154_641 VDD VSS sg13g2_fill_2
XFILLER_12_1169 VDD VSS sg13g2_decap_8
X_15135_ _15135_/Q clkload59/A _15135_/D _15135_/RESET_B VDD VSS sg13g2_dfrbpq_1
XFILLER_103_1297 VDD VSS sg13g2_decap_8
X_12347_ _12348_/D _15122_/Q _12347_/B _15119_/Q _12347_/D VDD VSS sg13g2_nor4_1
XFILLER_5_651 VDD VSS sg13g2_decap_8
XFILLER_114_516 VDD VSS sg13g2_decap_8
XFILLER_173_1207 VDD VSS sg13g2_fill_1
XFILLER_138_1338 VDD VSS sg13g2_decap_4
XFILLER_4_161 VDD VSS sg13g2_decap_8
X_15066_ _15066_/Q _15113_/CLK _15066_/D _15066_/RESET_B VDD VSS sg13g2_dfrbpq_1
XFILLER_4_21 VDD VSS sg13g2_decap_8
XFILLER_142_869 VDD VSS sg13g2_decap_8
X_12278_ _12279_/B _12278_/A _13663_/Q VDD VSS sg13g2_or2_1
X_14017_ _14017_/Q _14722_/CLK _14017_/D _14017_/RESET_B VDD VSS sg13g2_dfrbpq_1
X_11229_ _11229_/X _13819_/Q _13851_/Q _13883_/Q _13915_/Q _11229_/S0 _11229_/S1 VDD
+ VSS sg13g2_mux4_1
XFILLER_150_891 VDD VSS sg13g2_decap_4
XFILLER_96_945 VDD VSS sg13g2_decap_8
XFILLER_4_98 VDD VSS sg13g2_decap_8
XFILLER_96_956 VDD VSS sg13g2_fill_2
XFILLER_67_124 VDD VSS sg13g2_decap_8
XFILLER_136_1095 VDD VSS sg13g2_decap_8
XFILLER_110_766 VDD VSS sg13g2_decap_4
XFILLER_96_989 VDD VSS sg13g2_decap_8
XFILLER_83_606 VDD VSS sg13g2_decap_8
XFILLER_55_319 VDD VSS sg13g2_fill_2
XFILLER_3_1337 VDD VSS sg13g2_decap_8
XFILLER_23_1265 VDD VSS sg13g2_decap_8
X_14919_ _14919_/Q clkload41/A _14919_/D _14919_/RESET_B VDD VSS sg13g2_dfrbpq_1
XFILLER_24_706 VDD VSS sg13g2_fill_1
X_08440_ _08441_/B _08574_/A _08438_/Y _08439_/Y VDD VSS sg13g2_o21ai_1
XFILLER_1_1050 VDD VSS sg13g2_decap_8
XFILLER_24_728 VDD VSS sg13g2_fill_1
XFILLER_36_599 VDD VSS sg13g2_fill_1
XFILLER_17_791 VDD VSS sg13g2_decap_8
XFILLER_23_238 VDD VSS sg13g2_decap_8
X_08371_ _08371_/Y _07795_/A _08370_/Y _08588_/B VDD VSS sg13g2_o21ai_1
XFILLER_95_1090 VDD VSS sg13g2_decap_8
XFILLER_51_558 VDD VSS sg13g2_fill_2
XFILLER_56_1052 VDD VSS sg13g2_fill_1
XFILLER_32_750 VDD VSS sg13g2_decap_8
XFILLER_108_1131 VDD VSS sg13g2_decap_8
XFILLER_90_0 VDD VSS sg13g2_decap_8
XFILLER_17_1036 VDD VSS sg13g2_decap_8
XFILLER_143_1044 VDD VSS sg13g2_decap_8
XFILLER_20_945 VDD VSS sg13g2_decap_8
XFILLER_164_427 VDD VSS sg13g2_decap_8
X_14549__1630 _14549_/RESET_B VDD VSS sg13g2_tiehi
XFILLER_30_1247 VDD VSS sg13g2_decap_8
XFILLER_173_983 VDD VSS sg13g2_decap_4
XFILLER_118_899 VDD VSS sg13g2_decap_4
XFILLER_160_611 VDD VSS sg13g2_decap_8
XFILLER_105_538 VDD VSS sg13g2_fill_1
XFILLER_132_335 VDD VSS sg13g2_fill_2
XFILLER_132_346 VDD VSS sg13g2_fill_1
XFILLER_99_750 VDD VSS sg13g2_decap_8
Xfanout402 _09112_/S wire405/X VDD VSS sg13g2_buf_1
XFILLER_63_1012 VDD VSS sg13g2_decap_8
Xfanout413 _11181_/A _10785_/Y VDD VSS sg13g2_buf_1
XFILLER_8_1204 VDD VSS sg13g2_decap_8
XFILLER_67_1192 VDD VSS sg13g2_decap_8
Xfanout424 _10036_/S _10004_/Y VDD VSS sg13g2_buf_1
XFILLER_28_1154 VDD VSS sg13g2_decap_8
Xfanout435 _09832_/S _09838_/S VDD VSS sg13g2_buf_1
XFILLER_150_1004 VDD VSS sg13g2_fill_1
Xfanout446 _09670_/S _09641_/X VDD VSS sg13g2_buf_1
XFILLER_86_422 VDD VSS sg13g2_decap_8
XFILLER_115_1135 VDD VSS sg13g2_decap_8
Xfanout457 _09464_/S _09473_/S VDD VSS sg13g2_buf_1
X_09825_ _14413_/D _09924_/A1 _14413_/Q _09829_/S VDD VSS sg13g2_mux2_1
XFILLER_48_49 VDD VSS sg13g2_decap_8
XFILLER_150_1026 VDD VSS sg13g2_decap_8
Xfanout468 _09365_/S _09374_/S VDD VSS sg13g2_buf_1
XFILLER_98_293 VDD VSS sg13g2_fill_1
XFILLER_87_967 VDD VSS sg13g2_fill_1
XFILLER_171_28 VDD VSS sg13g2_decap_8
XFILLER_101_755 VDD VSS sg13g2_decap_8
XFILLER_101_766 VDD VSS sg13g2_fill_1
Xfanout479 _09611_/A0 _10142_/A1 VDD VSS sg13g2_buf_1
XFILLER_58_146 VDD VSS sg13g2_decap_8
XFILLER_41_1321 VDD VSS sg13g2_fill_2
X_09756_ _14346_/D _14346_/Q _09921_/A1 _09766_/S VDD VSS sg13g2_mux2_1
XFILLER_27_500 VDD VSS sg13g2_fill_1
X_08707_ _15186_/D hold3071/X _15186_/Q _10203_/S VDD VSS sg13g2_mux2_1
XFILLER_41_1376 VDD VSS sg13g2_fill_1
XFILLER_73_149 VDD VSS sg13g2_fill_1
X_14651__1528 _14651_/RESET_B VDD VSS sg13g2_tiehi
X_09687_ _14279_/D _09720_/A0 _14279_/Q _09703_/S VDD VSS sg13g2_mux2_1
XFILLER_55_864 VDD VSS sg13g2_fill_2
XFILLER_15_728 VDD VSS sg13g2_decap_8
X_08638_ _08640_/A _07844_/X _08672_/A _08544_/B _08330_/Y VDD VSS sg13g2_a22oi_1
XFILLER_120_21 VDD VSS sg13g2_decap_8
XFILLER_14_238 VDD VSS sg13g2_decap_8
X_14080__2099 _14080_/RESET_B VDD VSS sg13g2_tiehi
X_08569_ _08569_/Y _07808_/Y _08568_/Y _08567_/X VDD VSS sg13g2_o21ai_1
XFILLER_80_14 VDD VSS sg13g2_decap_8
X_10600_ _10602_/B _10607_/C _10607_/D _14877_/Q VDD VSS sg13g2_a21oi_1
XFILLER_167_210 VDD VSS sg13g2_decap_8
X_11580_ _11580_/X _14245_/Q _14277_/Q _14309_/Q _14341_/Q _11997_/S0 _11997_/S1 VDD
+ VSS sg13g2_mux4_1
XFILLER_11_945 VDD VSS sg13g2_decap_8
XFILLER_70_1038 VDD VSS sg13g2_decap_8
X_14188__1991 _14188_/RESET_B VDD VSS sg13g2_tiehi
X_10531_ _10533_/B _14859_/Q _10558_/B _10558_/C _10531_/D VDD VSS sg13g2_nand4_1
XFILLER_126_1297 VDD VSS sg13g2_decap_8
XFILLER_10_455 VDD VSS sg13g2_decap_8
XFILLER_156_939 VDD VSS sg13g2_decap_8
XFILLER_13_63 VDD VSS sg13g2_decap_8
XFILLER_167_287 VDD VSS sg13g2_decap_8
XFILLER_7_938 VDD VSS sg13g2_decap_8
XFILLER_155_438 VDD VSS sg13g2_fill_2
XFILLER_108_310 VDD VSS sg13g2_decap_4
X_13250_ _13251_/C _14828_/Q _07729_/B _13234_/B _14860_/Q VDD VSS sg13g2_a22oi_1
X_10462_ _10473_/D _10471_/C _14842_/Q _14841_/Q _10462_/D VDD VSS sg13g2_and4_1
XFILLER_108_332 VDD VSS sg13g2_decap_8
XFILLER_129_63 VDD VSS sg13g2_decap_8
XFILLER_6_448 VDD VSS sg13g2_decap_8
X_12201_ _12204_/A _12060_/Y _12197_/Y _12200_/X VDD VSS sg13g2_a21oi_1
XFILLER_109_877 VDD VSS sg13g2_fill_2
X_13181_ _13181_/Y _14791_/Q _13236_/A2 _13181_/B1 VDD VSS sg13g2_o21ai_1
X_10393_ _10401_/C _14822_/Q _10392_/A VDD VSS sg13g2_nor2b_1
XFILLER_89_56 VDD VSS sg13g2_decap_8
XFILLER_135_162 VDD VSS sg13g2_decap_8
X_12132_ _12132_/Y _12198_/B _12132_/B VDD VSS sg13g2_xnor2_1
XFILLER_124_858 VDD VSS sg13g2_fill_2
X_15060__2493 _15060_/RESET_B VDD VSS sg13g2_tiehi
XFILLER_151_666 VDD VSS sg13g2_decap_8
XFILLER_81_1101 VDD VSS sg13g2_fill_1
XFILLER_46_1221 VDD VSS sg13g2_fill_2
XFILLER_46_1232 VDD VSS sg13g2_decap_8
XFILLER_2_665 VDD VSS sg13g2_decap_8
XFILLER_123_379 VDD VSS sg13g2_fill_1
X_12063_ _12063_/Y _12062_/A _12062_/B _12197_/A VDD VSS sg13g2_a21oi_1
XFILLER_81_1134 VDD VSS sg13g2_decap_8
XFILLER_1_175 VDD VSS sg13g2_decap_8
X_11014_ _11014_/Y _11043_/A _11014_/B VDD VSS sg13g2_nor2_1
XFILLER_42_1107 VDD VSS sg13g2_fill_2
XFILLER_172_1273 VDD VSS sg13g2_decap_8
X_16871_ _16871_/X _16871_/A VDD VSS sg13g2_buf_1
XFILLER_46_1298 VDD VSS sg13g2_decap_8
Xfanout980 _10797_/A _13279_/B VDD VSS sg13g2_buf_1
XFILLER_93_926 VDD VSS sg13g2_decap_8
Xfanout991 _09640_/C _15067_/Q VDD VSS sg13g2_buf_1
XFILLER_65_628 VDD VSS sg13g2_decap_4
X_14290__1889 _14290_/RESET_B VDD VSS sg13g2_tiehi
XFILLER_92_425 VDD VSS sg13g2_decap_8
XFILLER_18_511 VDD VSS sg13g2_decap_8
XFILLER_168_1309 VDD VSS sg13g2_decap_8
X_12965_ _12965_/Y _14777_/Q _13236_/A2 _13236_/B1 VDD VSS sg13g2_o21ai_1
XFILLER_73_650 VDD VSS sg13g2_fill_2
XFILLER_166_1022 VDD VSS sg13g2_decap_4
X_14627__1552 _14627_/RESET_B VDD VSS sg13g2_tiehi
X_14704_ _14704_/Q clkload8/A _14704_/D _14704_/RESET_B VDD VSS sg13g2_dfrbpq_1
X_11916_ _11916_/Y _12055_/A _11917_/A VDD VSS sg13g2_nor2_1
XFILLER_18_588 VDD VSS sg13g2_decap_8
X_12896_ _12896_/Y _14805_/Q _12851_/B _07728_/B _14837_/Q _12917_/B1 VDD VSS sg13g2_a221oi_1
X_14635_ _14635_/Q clkload0/A _14635_/D _14635_/RESET_B VDD VSS sg13g2_dfrbpq_1
XFILLER_166_1077 VDD VSS sg13g2_fill_1
X_11847_ _11847_/X _14573_/Q _14605_/Q _14637_/Q _14669_/Q _11848_/S0 _07654_/A VDD
+ VSS sg13g2_mux4_1
XFILLER_159_711 VDD VSS sg13g2_decap_8
XFILLER_92_1241 VDD VSS sg13g2_fill_1
XFILLER_60_355 VDD VSS sg13g2_decap_8
XFILLER_57_1372 VDD VSS sg13g2_decap_8
XFILLER_18_1323 VDD VSS sg13g2_decap_8
XFILLER_57_1383 VDD VSS sg13g2_fill_1
X_14566_ _14566_/Q _14662_/CLK _14566_/D _14566_/RESET_B VDD VSS sg13g2_dfrbpq_1
X_11778_ _11912_/A _11778_/A _11778_/B VDD VSS sg13g2_nor2_1
XFILLER_9_231 VDD VSS sg13g2_decap_8
XFILLER_53_1258 VDD VSS sg13g2_decap_8
XFILLER_119_608 VDD VSS sg13g2_decap_4
X_13517_ _13517_/X _13517_/A _13566_/C VDD VSS sg13g2_and2_1
XFILLER_159_788 VDD VSS sg13g2_fill_1
X_10729_ _10995_/B _09060_/X _10743_/S _08893_/Y VDD VSS sg13g2_a21oi_1
XFILLER_118_107 VDD VSS sg13g2_decap_8
X_14497_ _14497_/Q clkload31/A _14497_/D _14497_/RESET_B VDD VSS sg13g2_dfrbpq_1
XFILLER_140_1239 VDD VSS sg13g2_decap_8
XFILLER_174_736 VDD VSS sg13g2_decap_8
XFILLER_158_298 VDD VSS sg13g2_decap_8
XFILLER_173_224 VDD VSS sg13g2_decap_8
X_13448_ _13449_/B _15199_/Q _13448_/B _13448_/C _13459_/D VDD VSS sg13g2_nand4_1
Xclkload12 clkload12/Y clkload12/A VDD VSS sg13g2_inv_2
Xclkload23 clkload23/X clkload23/A VDD VSS sg13g2_buf_8
XFILLER_155_950 VDD VSS sg13g2_decap_8
Xclkload34 clkload34/Y clkload34/A VDD VSS sg13g2_inv_1
XFILLER_155_972 VDD VSS sg13g2_fill_1
XFILLER_161_408 VDD VSS sg13g2_decap_8
Xclkload45 clkload45/Y clkload45/A VDD VSS sg13g2_inv_2
XFILLER_86_1012 VDD VSS sg13g2_decap_8
XFILLER_103_1083 VDD VSS sg13g2_decap_4
Xclkload56 clkload56/Y clkload56/A VDD VSS sg13g2_inv_2
X_13379_ _15079_/D _15079_/Q _13407_/A _13378_/Y VDD VSS sg13g2_a21o_1
Xclkload67 clkload67/Y clkload67/A VDD VSS sg13g2_inv_4
XFILLER_127_685 VDD VSS sg13g2_fill_2
XFILLER_138_1102 VDD VSS sg13g2_decap_8
XFILLER_154_471 VDD VSS sg13g2_fill_2
XFILLER_155_994 VDD VSS sg13g2_decap_8
XFILLER_126_173 VDD VSS sg13g2_fill_2
X_15118_ _15118_/Q _15188_/CLK _15118_/D _15118_/RESET_B VDD VSS sg13g2_dfrbpq_1
XFILLER_64_1321 VDD VSS sg13g2_fill_2
X_15049_ _15049_/Q clkload66/A _15049_/D _15049_/RESET_B VDD VSS sg13g2_dfrbpq_1
X_07940_ _07940_/Y _07797_/B _07932_/Y _07939_/Y VDD VSS sg13g2_o21ai_1
XFILLER_87_208 VDD VSS sg13g2_decap_8
XFILLER_142_699 VDD VSS sg13g2_decap_8
XFILLER_151_1313 VDD VSS sg13g2_decap_8
XFILLER_64_1365 VDD VSS sg13g2_decap_8
XFILLER_25_1316 VDD VSS sg13g2_decap_8
XFILLER_141_198 VDD VSS sg13g2_decap_8
X_07871_ _07871_/X _08183_/B _08188_/A VDD VSS sg13g2_or2_1
XFILLER_110_541 VDD VSS sg13g2_decap_4
XFILLER_84_904 VDD VSS sg13g2_decap_8
X_09610_ _14206_/D _09610_/A0 _14206_/Q _09632_/S VDD VSS sg13g2_mux2_1
XFILLER_96_775 VDD VSS sg13g2_decap_8
XFILLER_7_1281 VDD VSS sg13g2_decap_8
XFILLER_23_1062 VDD VSS sg13g2_decap_8
X_09541_ _14139_/D _09574_/A1 _14139_/Q _09566_/S VDD VSS sg13g2_mux2_1
XFILLER_3_1134 VDD VSS sg13g2_decap_8
XFILLER_83_458 VDD VSS sg13g2_decap_8
XFILLER_110_1032 VDD VSS sg13g2_decap_4
X_09472_ _14073_/D _10101_/A0 _14073_/Q _09472_/S VDD VSS sg13g2_mux2_1
XFILLER_58_1147 VDD VSS sg13g2_fill_1
X_08423_ _08423_/X _08574_/B _08423_/B VDD VSS sg13g2_xor2_1
XFILLER_58_1169 VDD VSS sg13g2_decap_4
XFILLER_51_377 VDD VSS sg13g2_decap_4
XFILLER_149_210 VDD VSS sg13g2_decap_8
X_08354_ _08354_/Y _08414_/D _08354_/B VDD VSS sg13g2_xnor2_1
XFILLER_71_1347 VDD VSS sg13g2_fill_1
XFILLER_32_1309 VDD VSS sg13g2_decap_8
XFILLER_20_742 VDD VSS sg13g2_decap_8
Xclkload6 clkload6/Y clkload6/A VDD VSS sg13g2_inv_1
X_08285_ _08286_/C _07923_/Y _07925_/Y _07797_/A VDD VSS sg13g2_a21oi_1
XFILLER_50_28 VDD VSS sg13g2_decap_8
XFILLER_164_224 VDD VSS sg13g2_decap_8
XFILLER_118_630 VDD VSS sg13g2_fill_2
XFILLER_166_28 VDD VSS sg13g2_decap_8
X_14065__2114 _14065_/RESET_B VDD VSS sg13g2_tiehi
XFILLER_118_641 VDD VSS sg13g2_decap_8
XFILLER_106_803 VDD VSS sg13g2_decap_8
XFILLER_106_814 VDD VSS sg13g2_fill_2
XFILLER_132_132 VDD VSS sg13g2_fill_1
X_14705__1474 _14705_/RESET_B VDD VSS sg13g2_tiehi
XFILLER_8_1001 VDD VSS sg13g2_decap_8
XFILLER_160_485 VDD VSS sg13g2_decap_8
Xfanout210 _10156_/A1 _10123_/A0 VDD VSS sg13g2_buf_1
Xfanout1208 _11202_/A _11171_/B VDD VSS sg13g2_buf_1
XFILLER_59_400 VDD VSS sg13g2_decap_8
Xfanout221 _09623_/A0 _10154_/A1 VDD VSS sg13g2_buf_1
Xfanout1219 _11999_/S1 _12048_/A1 VDD VSS sg13g2_buf_1
XFILLER_115_21 VDD VSS sg13g2_decap_8
XFILLER_120_338 VDD VSS sg13g2_fill_2
Xfanout232 _09953_/A1 _09621_/A0 VDD VSS sg13g2_buf_1
XFILLER_99_591 VDD VSS sg13g2_fill_1
Xfanout243 _11724_/B _12298_/B VDD VSS sg13g2_buf_1
Xfanout254 _09950_/A1 _10082_/A0 VDD VSS sg13g2_buf_1
Xfanout265 _09899_/S _09903_/S VDD VSS sg13g2_buf_1
XFILLER_59_455 VDD VSS sg13g2_fill_1
Xfanout276 _09434_/S _09440_/S VDD VSS sg13g2_buf_1
XFILLER_87_775 VDD VSS sg13g2_decap_8
XFILLER_75_14 VDD VSS sg13g2_decap_8
Xfanout287 _10147_/A1 _09517_/A0 VDD VSS sg13g2_buf_1
X_09808_ _14396_/D _10139_/A1 _14396_/Q _09832_/S VDD VSS sg13g2_mux2_1
XFILLER_8_1078 VDD VSS sg13g2_decap_8
XFILLER_19_308 VDD VSS sg13g2_decap_8
XFILLER_115_87 VDD VSS sg13g2_decap_4
Xfanout298 _09909_/A1 fanout301/X VDD VSS sg13g2_buf_1
XFILLER_75_959 VDD VSS sg13g2_decap_8
X_09739_ _14330_/D _09772_/A1 _14330_/Q _09739_/S VDD VSS sg13g2_mux2_1
XFILLER_43_801 VDD VSS sg13g2_decap_8
XFILLER_28_886 VDD VSS sg13g2_fill_1
X_12750_ _15017_/D _12750_/A _12750_/B VDD VSS sg13g2_nor2_1
XFILLER_83_992 VDD VSS sg13g2_decap_8
XFILLER_15_525 VDD VSS sg13g2_decap_8
X_14854__2836 _14854_/RESET_B VDD VSS sg13g2_tiehi
X_11701_ _11702_/B _11664_/A _11700_/X _11664_/Y _11663_/Y _12271_/A VDD VSS sg13g2_a221oi_1
X_12681_ _12694_/A _12709_/A1 _12737_/A2 _15013_/Q VDD VSS sg13g2_a21oi_1
X_14275__1904 _14275_/RESET_B VDD VSS sg13g2_tiehi
X_14420_ _14420_/Q clkload15/A _14420_/D _14420_/RESET_B VDD VSS sg13g2_dfrbpq_1
X_11632_ _14968_/D _11632_/A _11632_/B VDD VSS sg13g2_nor2_1
XFILLER_23_580 VDD VSS sg13g2_decap_8
XFILLER_11_742 VDD VSS sg13g2_decap_8
XFILLER_138_0 VDD VSS sg13g2_decap_8
XFILLER_156_703 VDD VSS sg13g2_decap_8
X_14351_ _14351_/Q clkload8/A _14351_/D _14351_/RESET_B VDD VSS sg13g2_dfrbpq_1
XFILLER_24_84 VDD VSS sg13g2_decap_8
XFILLER_168_574 VDD VSS sg13g2_decap_8
X_11563_ _11563_/Y _10702_/A _12267_/A2 _11559_/Y _11562_/Y VDD VSS sg13g2_a22oi_1
XFILLER_126_1094 VDD VSS sg13g2_decap_8
XFILLER_10_252 VDD VSS sg13g2_decap_8
XFILLER_128_438 VDD VSS sg13g2_decap_8
X_13302_ _15058_/D _13299_/Y _13302_/B _13302_/C VDD VSS sg13g2_nand3b_1
X_10514_ _10538_/B _10514_/A _10514_/B _10514_/C VDD VSS sg13g2_nand3_1
XFILLER_7_735 VDD VSS sg13g2_decap_8
X_14282_ _14282_/Q clkload12/A _14282_/D _14282_/RESET_B VDD VSS sg13g2_dfrbpq_1
XFILLER_52_1280 VDD VSS sg13g2_decap_8
XFILLER_144_909 VDD VSS sg13g2_decap_8
X_11494_ _11495_/A _11488_/X _11489_/X _11493_/X _11492_/X _12214_/B _12293_/A1 VDD
+ VSS sg13g2_mux4_1
XFILLER_13_1253 VDD VSS sg13g2_decap_8
XFILLER_6_245 VDD VSS sg13g2_decap_8
X_13233_ _13233_/X input24/X _13272_/A2 _13264_/B1 VDD VSS sg13g2_a21o_1
XFILLER_143_419 VDD VSS sg13g2_decap_4
X_10445_ _10459_/C _14838_/Q _14837_/Q _14832_/Q _14831_/Q VDD VSS sg13g2_nand4_1
XFILLER_87_1343 VDD VSS sg13g2_decap_8
XFILLER_124_622 VDD VSS sg13g2_fill_2
XFILLER_100_1267 VDD VSS sg13g2_fill_2
XFILLER_170_238 VDD VSS sg13g2_decap_8
XFILLER_152_953 VDD VSS sg13g2_decap_4
X_13164_ _13164_/Y _14790_/Q _13208_/A2 _13208_/B1 VDD VSS sg13g2_o21ai_1
XFILLER_151_430 VDD VSS sg13g2_decap_8
XFILLER_152_964 VDD VSS sg13g2_decap_8
X_10376_ _10379_/C _14817_/Q _10375_/B VDD VSS sg13g2_nor2b_1
XFILLER_48_1349 VDD VSS sg13g2_decap_8
XFILLER_3_952 VDD VSS sg13g2_decap_8
XFILLER_152_975 VDD VSS sg13g2_fill_1
XFILLER_112_817 VDD VSS sg13g2_decap_8
XFILLER_124_677 VDD VSS sg13g2_decap_8
X_12115_ _12115_/X _12317_/B _12114_/X _12113_/Y VDD VSS sg13g2_a21o_1
X_13095_ _13095_/Y _14881_/Q _13162_/B1 _13082_/B VDD VSS sg13g2_a21oi_1
XFILLER_2_462 VDD VSS sg13g2_decap_8
XFILLER_174_1379 VDD VSS sg13g2_decap_4
XFILLER_97_539 VDD VSS sg13g2_decap_8
XFILLER_78_731 VDD VSS sg13g2_decap_8
XFILLER_123_198 VDD VSS sg13g2_decap_8
X_12046_ _12046_/Y _12044_/Y _12046_/B _12174_/A VDD VSS sg13g2_nand3b_1
XFILLER_49_70 VDD VSS sg13g2_decap_4
X_13763__2416 _13763_/RESET_B VDD VSS sg13g2_tiehi
XFILLER_27_7 VDD VSS sg13g2_decap_8
XFILLER_120_883 VDD VSS sg13g2_decap_8
X_16854_ _16854_/X _16854_/A VDD VSS sg13g2_buf_1
XFILLER_92_200 VDD VSS sg13g2_decap_8
XFILLER_77_274 VDD VSS sg13g2_decap_8
XFILLER_37_105 VDD VSS sg13g2_decap_8
XFILLER_65_447 VDD VSS sg13g2_decap_8
XFILLER_168_1128 VDD VSS sg13g2_decap_8
X_13997_ _13997_/Q clkload4/A _13997_/D _13997_/RESET_B VDD VSS sg13g2_dfrbpq_1
XFILLER_1_77 VDD VSS sg13g2_decap_8
XFILLER_20_1246 VDD VSS sg13g2_decap_8
XFILLER_19_875 VDD VSS sg13g2_decap_8
XFILLER_0_1318 VDD VSS sg13g2_decap_8
X_12948_ _12948_/Y _14808_/Q _13014_/A2 _13234_/B _14840_/Q _13248_/B VDD VSS sg13g2_a221oi_1
X_14143__2036 _14143_/RESET_B VDD VSS sg13g2_tiehi
XFILLER_52_119 VDD VSS sg13g2_decap_8
XFILLER_34_834 VDD VSS sg13g2_fill_2
XFILLER_18_385 VDD VSS sg13g2_decap_8
X_12879_ _12879_/Y _14836_/Q _12879_/B VDD VSS sg13g2_nand2_1
XFILLER_53_1000 VDD VSS sg13g2_decap_8
XFILLER_33_377 VDD VSS sg13g2_decap_8
XFILLER_18_1120 VDD VSS sg13g2_decap_8
XFILLER_159_530 VDD VSS sg13g2_decap_4
X_14618_ _14618_/Q clkload41/A _14618_/D _14618_/RESET_B VDD VSS sg13g2_dfrbpq_1
XFILLER_60_174 VDD VSS sg13g2_decap_8
XFILLER_92_1071 VDD VSS sg13g2_decap_4
XFILLER_21_539 VDD VSS sg13g2_decap_8
XFILLER_147_703 VDD VSS sg13g2_decap_8
X_14549_ _14549_/Q _14677_/CLK _14549_/D _14549_/RESET_B VDD VSS sg13g2_dfrbpq_1
XFILLER_53_1066 VDD VSS sg13g2_decap_4
XFILLER_119_427 VDD VSS sg13g2_decap_8
XFILLER_18_1197 VDD VSS sg13g2_decap_8
XFILLER_159_596 VDD VSS sg13g2_decap_8
XFILLER_174_522 VDD VSS sg13g2_decap_8
XFILLER_174_533 VDD VSS sg13g2_decap_8
X_08070_ _08070_/X _08431_/A _08431_/D _08110_/C _08110_/D VDD VSS sg13g2_and4_1
XFILLER_134_419 VDD VSS sg13g2_decap_8
XFILLER_162_728 VDD VSS sg13g2_fill_2
XFILLER_53_0 VDD VSS sg13g2_decap_8
XFILLER_161_238 VDD VSS sg13g2_decap_8
XFILLER_170_761 VDD VSS sg13g2_decap_8
XFILLER_88_506 VDD VSS sg13g2_decap_8
XFILLER_130_603 VDD VSS sg13g2_fill_2
X_08972_ _10105_/A _14895_/Q _08971_/X _08972_/S VDD VSS sg13g2_mux2_1
X_07923_ _07923_/Y _07909_/Y _07921_/Y _07904_/A VDD VSS sg13g2_o21ai_1
XFILLER_29_1282 VDD VSS sg13g2_decap_8
XFILLER_25_1113 VDD VSS sg13g2_decap_8
XFILLER_9_1365 VDD VSS sg13g2_decap_8
X_14353__1826 _14353_/RESET_B VDD VSS sg13g2_tiehi
X_13739__2440 _13739_/RESET_B VDD VSS sg13g2_tiehi
XFILLER_5_1218 VDD VSS sg13g2_decap_8
XFILLER_112_1105 VDD VSS sg13g2_fill_2
X_14499__1680 _14499_/RESET_B VDD VSS sg13g2_tiehi
X_07854_ _08643_/D _07855_/A _07855_/B VDD VSS sg13g2_nor2_1
XFILLER_28_105 VDD VSS sg13g2_decap_8
XFILLER_112_1127 VDD VSS sg13g2_decap_8
XFILLER_112_1138 VDD VSS sg13g2_fill_2
XFILLER_151_1187 VDD VSS sg13g2_decap_8
XFILLER_83_222 VDD VSS sg13g2_decap_4
XFILLER_99_1258 VDD VSS sg13g2_decap_8
XFILLER_99_1269 VDD VSS sg13g2_fill_2
X_07785_ _08414_/A _07786_/A _08351_/B VDD VSS sg13g2_nor2_1
XFILLER_83_266 VDD VSS sg13g2_decap_8
XFILLER_45_28 VDD VSS sg13g2_decap_8
XFILLER_25_801 VDD VSS sg13g2_fill_2
X_09524_ _14123_/D _09623_/A0 _14123_/Q _09530_/S VDD VSS sg13g2_mux2_1
XFILLER_43_119 VDD VSS sg13g2_decap_4
XFILLER_36_160 VDD VSS sg13g2_decap_8
XFILLER_37_694 VDD VSS sg13g2_decap_8
X_14119__2060 _14119_/RESET_B VDD VSS sg13g2_tiehi
X_09455_ _14056_/D _09853_/A1 _14056_/Q _09464_/S VDD VSS sg13g2_mux2_1
X_08406_ _08406_/X _08406_/A _08511_/S VDD VSS sg13g2_and2_1
XFILLER_36_1220 VDD VSS sg13g2_decap_4
XFILLER_12_539 VDD VSS sg13g2_decap_8
X_09386_ _13989_/D _09949_/A1 _13989_/Q _09398_/S VDD VSS sg13g2_mux2_1
XFILLER_75_1280 VDD VSS sg13g2_decap_8
XFILLER_36_1242 VDD VSS sg13g2_decap_8
XFILLER_61_49 VDD VSS sg13g2_decap_4
X_08337_ _08337_/X _11661_/A _08376_/A3 _11591_/A _11570_/A _08635_/S0 _08635_/S1
+ VDD VSS sg13g2_mux4_1
XFILLER_131_7 VDD VSS sg13g2_decap_8
XFILLER_165_511 VDD VSS sg13g2_decap_8
XFILLER_32_1117 VDD VSS sg13g2_decap_8
X_13841__2338 _13841_/RESET_B VDD VSS sg13g2_tiehi
X_08268_ _08268_/Y _08318_/B _08268_/B VDD VSS sg13g2_xnor2_1
X_13987__2192 _13987_/RESET_B VDD VSS sg13g2_tiehi
XFILLER_165_588 VDD VSS sg13g2_decap_8
XFILLER_134_920 VDD VSS sg13g2_decap_8
X_08199_ _08201_/C _08200_/A _08452_/D _08199_/C VDD VSS sg13g2_nor3_1
XFILLER_4_749 VDD VSS sg13g2_decap_8
X_10230_ _10232_/A _14771_/Q _10234_/D _14772_/Q VDD VSS sg13g2_a21o_1
XFILLER_105_121 VDD VSS sg13g2_decap_8
XFILLER_10_42 VDD VSS sg13g2_decap_8
XFILLER_156_1032 VDD VSS sg13g2_fill_2
XFILLER_3_259 VDD VSS sg13g2_decap_8
XFILLER_121_614 VDD VSS sg13g2_fill_1
X_10161_ _14738_/D _14738_/Q _10161_/A1 _10167_/S VDD VSS sg13g2_mux2_1
XFILLER_156_1076 VDD VSS sg13g2_decap_8
XFILLER_160_271 VDD VSS sg13g2_decap_8
XFILLER_0_933 VDD VSS sg13g2_decap_8
Xfanout1005 _10781_/C _15060_/Q VDD VSS sg13g2_buf_1
Xfanout1016 _09016_/C _15058_/Q VDD VSS sg13g2_buf_1
XFILLER_82_1251 VDD VSS sg13g2_decap_8
XFILLER_47_1371 VDD VSS sg13g2_decap_8
XFILLER_134_1330 VDD VSS sg13g2_decap_4
Xfanout1027 _07805_/B _15007_/Q VDD VSS sg13g2_buf_1
XFILLER_47_1382 VDD VSS sg13g2_fill_2
XFILLER_43_1213 VDD VSS sg13g2_decap_4
Xfanout1038 _13533_/A _08668_/A VDD VSS sg13g2_buf_1
X_10092_ _14672_/D _10092_/A0 _14672_/Q _10098_/S VDD VSS sg13g2_mux2_1
Xfanout1049 _08200_/A _08103_/A VDD VSS sg13g2_buf_1
XFILLER_59_252 VDD VSS sg13g2_decap_8
XFILLER_86_79 VDD VSS sg13g2_decap_8
X_13920_ _13920_/Q _14721_/CLK _13920_/D _13920_/RESET_B VDD VSS sg13g2_dfrbpq_1
X_14329__1850 _14329_/RESET_B VDD VSS sg13g2_tiehi
XFILLER_43_1257 VDD VSS sg13g2_fill_2
XFILLER_19_105 VDD VSS sg13g2_decap_8
XFILLER_102_894 VDD VSS sg13g2_decap_8
XFILLER_87_583 VDD VSS sg13g2_fill_2
XFILLER_87_594 VDD VSS sg13g2_decap_4
XFILLER_48_959 VDD VSS sg13g2_decap_8
X_13851_ _13851_/Q clkload46/A _13851_/D _13851_/RESET_B VDD VSS sg13g2_dfrbpq_1
XFILLER_19_84 VDD VSS sg13g2_decap_8
XFILLER_47_469 VDD VSS sg13g2_decap_4
XFILLER_142_85 VDD VSS sg13g2_decap_8
XFILLER_16_812 VDD VSS sg13g2_decap_8
X_12802_ _12802_/Y _12900_/B input11/X _12884_/C VDD VSS sg13g2_nand3_1
XFILLER_62_417 VDD VSS sg13g2_fill_2
X_13782_ _13782_/Q clkload27/A _13782_/D _13782_/RESET_B VDD VSS sg13g2_dfrbpq_1
X_10994_ _11042_/B _10995_/A _10995_/B VDD VSS sg13g2_nor2_1
XFILLER_128_1101 VDD VSS sg13g2_fill_1
XFILLER_15_322 VDD VSS sg13g2_decap_8
XFILLER_90_759 VDD VSS sg13g2_decap_4
XFILLER_27_182 VDD VSS sg13g2_decap_8
X_12733_ _12733_/X _12729_/X _12728_/X _12727_/X _12726_/X _12760_/S0 _12692_/S VDD
+ VSS sg13g2_mux4_1
XFILLER_43_653 VDD VSS sg13g2_decap_8
XFILLER_163_1025 VDD VSS sg13g2_fill_1
XFILLER_167_1194 VDD VSS sg13g2_decap_4
XFILLER_16_889 VDD VSS sg13g2_decap_8
XFILLER_163_1036 VDD VSS sg13g2_fill_1
XFILLER_76_1099 VDD VSS sg13g2_fill_2
X_12664_ _12664_/X _12662_/X _12663_/X _12664_/S VDD VSS sg13g2_mux2_1
XFILLER_43_697 VDD VSS sg13g2_decap_8
XFILLER_15_399 VDD VSS sg13g2_decap_8
XFILLER_163_1069 VDD VSS sg13g2_fill_1
XFILLER_31_859 VDD VSS sg13g2_decap_8
X_14403_ _14403_/Q clkload16/A _14403_/D _14403_/RESET_B VDD VSS sg13g2_dfrbpq_1
XFILLER_141_1312 VDD VSS sg13g2_decap_8
X_11615_ _11615_/X _11615_/A _11763_/B VDD VSS sg13g2_and2_1
XFILLER_30_347 VDD VSS sg13g2_fill_1
XFILLER_169_883 VDD VSS sg13g2_decap_4
XFILLER_30_358 VDD VSS sg13g2_decap_8
XFILLER_128_202 VDD VSS sg13g2_decap_8
XFILLER_168_371 VDD VSS sg13g2_decap_8
X_12595_ _12595_/X _12594_/X _12593_/X _12706_/S VDD VSS sg13g2_mux2_1
XFILLER_15_1337 VDD VSS sg13g2_decap_8
XFILLER_141_1345 VDD VSS sg13g2_decap_4
XFILLER_50_1228 VDD VSS sg13g2_decap_8
X_14334_ _14334_/Q clkload38/A _14334_/D _14334_/RESET_B VDD VSS sg13g2_dfrbpq_1
X_11546_ _11546_/Y _12014_/S _14500_/Q _12023_/B VDD VSS sg13g2_a21oi_1
XFILLER_7_532 VDD VSS sg13g2_decap_8
XFILLER_128_257 VDD VSS sg13g2_decap_8
X_14431__1748 _14431_/RESET_B VDD VSS sg13g2_tiehi
X_13817__2362 _13817_/RESET_B VDD VSS sg13g2_tiehi
XFILLER_13_1050 VDD VSS sg13g2_decap_8
XFILLER_156_577 VDD VSS sg13g2_decap_8
X_14265_ _14265_/Q _14745_/CLK _14265_/D _14265_/RESET_B VDD VSS sg13g2_dfrbpq_1
X_11477_ _11477_/Y _12292_/A _11477_/B VDD VSS sg13g2_nor2_1
XFILLER_137_791 VDD VSS sg13g2_decap_4
XFILLER_109_493 VDD VSS sg13g2_decap_8
X_13216_ _13216_/Y _13271_/C _13216_/B VDD VSS sg13g2_nand2_1
XFILLER_100_1053 VDD VSS sg13g2_fill_1
XFILLER_139_1230 VDD VSS sg13g2_decap_8
X_10428_ _10430_/C _14831_/Q _10453_/C _14832_/Q VDD VSS sg13g2_a21oi_1
XFILLER_171_558 VDD VSS sg13g2_decap_8
X_14196_ _14196_/Q _14516_/CLK _14196_/D _14196_/RESET_B VDD VSS sg13g2_dfrbpq_1
XFILLER_87_1184 VDD VSS sg13g2_decap_8
XFILLER_152_761 VDD VSS sg13g2_fill_1
XFILLER_48_1146 VDD VSS sg13g2_decap_8
XFILLER_140_923 VDD VSS sg13g2_decap_8
X_13147_ _13158_/B _13146_/B _13145_/Y _13170_/C VDD VSS sg13g2_a21o_1
X_10359_ _10359_/Y _10400_/A _10400_/B VDD VSS sg13g2_nor2_1
XFILLER_112_636 VDD VSS sg13g2_decap_8
XFILLER_170_1018 VDD VSS sg13g2_decap_8
X_13684__2504 _13684_/RESET_B VDD VSS sg13g2_tiehi
XFILLER_111_124 VDD VSS sg13g2_decap_4
XFILLER_135_1149 VDD VSS sg13g2_decap_8
XFILLER_100_809 VDD VSS sg13g2_decap_4
X_13078_ _13092_/A _13078_/A _13172_/A _13172_/B VDD VSS sg13g2_nand3_1
X_12029_ _12029_/Y _12029_/A _12190_/B VDD VSS sg13g2_nand2_1
XFILLER_65_244 VDD VSS sg13g2_decap_8
XFILLER_24_1190 VDD VSS sg13g2_decap_8
XFILLER_0_1115 VDD VSS sg13g2_decap_8
XFILLER_111_1160 VDD VSS sg13g2_decap_8
XFILLER_20_1043 VDD VSS sg13g2_decap_8
XFILLER_19_672 VDD VSS sg13g2_decap_8
XFILLER_59_1220 VDD VSS sg13g2_fill_1
XFILLER_25_119 VDD VSS sg13g2_decap_8
XFILLER_98_1280 VDD VSS sg13g2_decap_8
XFILLER_65_299 VDD VSS sg13g2_decap_8
XFILLER_53_439 VDD VSS sg13g2_decap_4
XFILLER_4_1295 VDD VSS sg13g2_decap_8
XFILLER_46_480 VDD VSS sg13g2_fill_1
XFILLER_146_1201 VDD VSS sg13g2_decap_8
XFILLER_18_182 VDD VSS sg13g2_decap_8
XFILLER_22_804 VDD VSS sg13g2_fill_2
XFILLER_146_1245 VDD VSS sg13g2_decap_8
XFILLER_94_1177 VDD VSS sg13g2_fill_1
X_09240_ _10137_/C _10004_/B _10004_/C VDD VSS sg13g2_nand2_1
XFILLER_61_472 VDD VSS sg13g2_decap_8
X_14968__2619 _14968_/RESET_B VDD VSS sg13g2_tiehi
XFILLER_34_697 VDD VSS sg13g2_decap_8
XFILLER_146_1278 VDD VSS sg13g2_decap_8
XFILLER_21_336 VDD VSS sg13g2_decap_8
XFILLER_166_308 VDD VSS sg13g2_decap_8
X_09171_ _13787_/D _13787_/Q _09774_/A0 _09202_/S VDD VSS sg13g2_mux2_1
XFILLER_159_371 VDD VSS sg13g2_decap_8
X_08122_ _08122_/Y _08279_/B _08121_/X _08120_/Y VDD VSS sg13g2_o21ai_1
XFILLER_107_408 VDD VSS sg13g2_fill_1
X_14407__1772 _14407_/RESET_B VDD VSS sg13g2_tiehi
X_08053_ _08053_/Y _07853_/B _08054_/B VDD VSS sg13g2_nand2b_1
XFILLER_134_227 VDD VSS sg13g2_decap_8
XFILLER_31_1183 VDD VSS sg13g2_decap_8
XFILLER_174_396 VDD VSS sg13g2_decap_8
XFILLER_162_558 VDD VSS sg13g2_decap_8
XFILLER_115_430 VDD VSS sg13g2_fill_2
XFILLER_143_761 VDD VSS sg13g2_fill_2
XFILLER_157_1352 VDD VSS sg13g2_decap_8
XFILLER_118_1314 VDD VSS sg13g2_fill_1
Xhold3102 _13617_/A _13725_/Q VDD VSS sg13g2_dlygate4sd3_1
Xhold3113 _13640_/A _13748_/Q VDD VSS sg13g2_dlygate4sd3_1
XFILLER_27_1208 VDD VSS sg13g2_decap_8
XFILLER_103_625 VDD VSS sg13g2_decap_8
Xhold3124 _13627_/A _13735_/Q VDD VSS sg13g2_dlygate4sd3_1
Xhold3135 _11001_/A _14942_/Q VDD VSS sg13g2_dlygate4sd3_1
XFILLER_103_647 VDD VSS sg13g2_fill_1
XFILLER_142_293 VDD VSS sg13g2_decap_8
Xhold3146 _13547_/A _15147_/Q VDD VSS sg13g2_dlygate4sd3_1
Xhold3157 _11133_/A _14951_/Q VDD VSS sg13g2_dlygate4sd3_1
X_08955_ _08955_/X _08954_/X _12300_/A _08955_/S VDD VSS sg13g2_mux2_1
XFILLER_88_358 VDD VSS sg13g2_fill_1
XFILLER_130_455 VDD VSS sg13g2_decap_8
Xhold3168 hold3168/X _15165_/Q VDD VSS sg13g2_dlygate4sd3_1
XFILLER_9_1162 VDD VSS sg13g2_decap_8
XFILLER_69_561 VDD VSS sg13g2_decap_8
XFILLER_116_1060 VDD VSS sg13g2_decap_4
X_07906_ _07908_/A _07797_/X _07906_/B _07906_/C VDD VSS sg13g2_nand3b_1
XFILLER_69_572 VDD VSS sg13g2_fill_1
XFILLER_57_712 VDD VSS sg13g2_fill_1
XFILLER_5_1015 VDD VSS sg13g2_decap_8
XFILLER_57_723 VDD VSS sg13g2_fill_2
X_08886_ _08886_/Y _08884_/Y _08885_/Y _08891_/S VDD VSS sg13g2_a21oi_1
XFILLER_116_1093 VDD VSS sg13g2_decap_8
XFILLER_99_1033 VDD VSS sg13g2_decap_8
XFILLER_84_542 VDD VSS sg13g2_fill_2
XFILLER_56_49 VDD VSS sg13g2_fill_2
X_07837_ _08698_/A _08673_/B _15019_/Q VDD VSS sg13g2_nand2b_1
XFILLER_45_907 VDD VSS sg13g2_fill_1
XFILLER_17_609 VDD VSS sg13g2_decap_8
XFILLER_45_929 VDD VSS sg13g2_fill_2
XFILLER_72_715 VDD VSS sg13g2_decap_8
XFILLER_71_203 VDD VSS sg13g2_decap_8
XFILLER_16_119 VDD VSS sg13g2_decap_8
X_07768_ _08265_/B _07929_/B _08263_/B VDD VSS sg13g2_and2_1
XFILLER_147_1009 VDD VSS sg13g2_decap_4
XFILLER_77_1342 VDD VSS sg13g2_decap_4
XFILLER_37_491 VDD VSS sg13g2_decap_8
X_09507_ _09507_/Y _10037_/A _10105_/B _09606_/C VDD VSS sg13g2_nand3_1
XFILLER_38_1326 VDD VSS sg13g2_decap_8
X_07699_ _07700_/C _15078_/Q _15081_/Q _07694_/Y VDD VSS sg13g2_o21ai_1
XFILLER_13_826 VDD VSS sg13g2_decap_8
X_09438_ _14040_/D _09636_/A0 _14040_/Q _09440_/S VDD VSS sg13g2_mux2_1
XFILLER_12_336 VDD VSS sg13g2_decap_8
XFILLER_24_196 VDD VSS sg13g2_decap_8
XFILLER_169_168 VDD VSS sg13g2_decap_8
XFILLER_9_819 VDD VSS sg13g2_decap_8
XFILLER_36_1050 VDD VSS sg13g2_decap_4
X_09369_ _13973_/D _10031_/A0 _13973_/Q _09370_/S VDD VSS sg13g2_mux2_1
XFILLER_40_678 VDD VSS sg13g2_decap_8
XFILLER_8_329 VDD VSS sg13g2_decap_8
X_11400_ _11401_/B _11400_/A _14655_/Q VDD VSS sg13g2_nand2_1
XFILLER_123_1042 VDD VSS sg13g2_decap_4
XFILLER_123_1053 VDD VSS sg13g2_fill_2
X_12380_ _12380_/X _13949_/Q _13981_/Q _14013_/Q _14045_/Q _12382_/S0 _12382_/S1 VDD
+ VSS sg13g2_mux4_1
XFILLER_126_717 VDD VSS sg13g2_decap_4
X_11331_ _11331_/Y _11231_/S _11330_/X _11236_/C VDD VSS sg13g2_a21oi_1
XFILLER_165_385 VDD VSS sg13g2_decap_8
XFILLER_158_1127 VDD VSS sg13g2_decap_8
XFILLER_21_63 VDD VSS sg13g2_decap_8
XFILLER_125_238 VDD VSS sg13g2_decap_8
XFILLER_125_249 VDD VSS sg13g2_fill_1
XFILLER_153_558 VDD VSS sg13g2_decap_8
X_14050_ _14050_/Q _14722_/CLK _14050_/D _14050_/RESET_B VDD VSS sg13g2_dfrbpq_1
X_11262_ _11262_/Y _11262_/A _11262_/B VDD VSS sg13g2_nand2_1
XFILLER_4_546 VDD VSS sg13g2_decap_8
XFILLER_137_63 VDD VSS sg13g2_decap_8
XFILLER_84_1313 VDD VSS sg13g2_fill_1
XFILLER_10_1267 VDD VSS sg13g2_decap_8
X_13001_ _13001_/Y _14875_/Q _13013_/B _13207_/C1 VDD VSS sg13g2_a21oi_1
X_10213_ _10213_/X _10213_/A _10213_/B VDD VSS sg13g2_and2_1
XFILLER_137_96 VDD VSS sg13g2_decap_4
X_11193_ _11193_/Y _11199_/B _11207_/A2 _11193_/B1 VDD VSS sg13g2_a21oi_1
XFILLER_133_271 VDD VSS sg13g2_decap_8
XFILLER_171_1327 VDD VSS sg13g2_decap_8
XFILLER_0_730 VDD VSS sg13g2_decap_8
XFILLER_79_347 VDD VSS sg13g2_decap_8
X_10144_ _14721_/D _14721_/Q _10144_/A1 _10167_/S VDD VSS sg13g2_mux2_1
XFILLER_43_1010 VDD VSS sg13g2_decap_8
XFILLER_48_701 VDD VSS sg13g2_fill_1
XFILLER_88_881 VDD VSS sg13g2_decap_8
XFILLER_43_1043 VDD VSS sg13g2_fill_1
XFILLER_130_1002 VDD VSS sg13g2_decap_8
X_14952_ _14952_/Q clkload54/A _14952_/D _14952_/RESET_B VDD VSS sg13g2_dfrbpq_1
X_10075_ _14655_/D _10109_/A0 _14655_/Q _10093_/S VDD VSS sg13g2_mux2_1
XFILLER_43_1054 VDD VSS sg13g2_decap_8
XFILLER_153_84 VDD VSS sg13g2_decap_8
XFILLER_75_520 VDD VSS sg13g2_decap_8
X_13903_ _13903_/Q _14703_/CLK _13903_/D _13903_/RESET_B VDD VSS sg13g2_dfrbpq_1
X_14883_ _14883_/Q _14885_/CLK _14883_/D _14883_/RESET_B VDD VSS sg13g2_dfrbpq_1
XFILLER_21_1330 VDD VSS sg13g2_decap_8
XFILLER_78_1139 VDD VSS sg13g2_decap_8
XFILLER_35_428 VDD VSS sg13g2_fill_1
X_13834_ _13834_/Q _14730_/CLK _13834_/D _13834_/RESET_B VDD VSS sg13g2_dfrbpq_1
Xclkbuf_5_5__f_clk_i clkbuf_5_5__f_clk_i/X clkbuf_4_2_0_clk_i/X VDD VSS sg13g2_buf_16
XFILLER_62_225 VDD VSS sg13g2_decap_4
XFILLER_28_491 VDD VSS sg13g2_decap_8
XFILLER_44_951 VDD VSS sg13g2_decap_8
X_13765_ _13765_/Q clkload6/A _13765_/D _13765_/RESET_B VDD VSS sg13g2_dfrbpq_1
X_10977_ _10978_/B _10949_/Y _11004_/A _11009_/B VDD VSS sg13g2_a21oi_1
XFILLER_90_589 VDD VSS sg13g2_decap_8
XFILLER_16_686 VDD VSS sg13g2_decap_8
XFILLER_44_995 VDD VSS sg13g2_fill_2
X_12716_ _12716_/X _14389_/Q _14421_/Q _14485_/Q _14517_/Q _12716_/S0 _12716_/S1 VDD
+ VSS sg13g2_mux4_1
X_13696_ _16858_/A clkload61/A _13696_/D _13696_/RESET_B VDD VSS sg13g2_dfrbpq_1
XFILLER_94_7 VDD VSS sg13g2_decap_8
XFILLER_15_196 VDD VSS sg13g2_decap_8
XFILLER_31_645 VDD VSS sg13g2_decap_8
XFILLER_148_319 VDD VSS sg13g2_decap_8
XFILLER_62_70 VDD VSS sg13g2_decap_8
X_12647_ _12647_/X _13968_/Q _14000_/Q _14032_/Q _14064_/Q _12658_/S0 _12658_/S1 VDD
+ VSS sg13g2_mux4_1
XFILLER_30_144 VDD VSS sg13g2_fill_2
XFILLER_19_1281 VDD VSS sg13g2_decap_8
XFILLER_157_831 VDD VSS sg13g2_decap_8
X_14664__1515 _14664_/RESET_B VDD VSS sg13g2_tiehi
XFILLER_15_1134 VDD VSS sg13g2_decap_8
XFILLER_54_1194 VDD VSS sg13g2_fill_2
XFILLER_156_330 VDD VSS sg13g2_fill_1
XFILLER_7_21 VDD VSS sg13g2_decap_8
XFILLER_30_188 VDD VSS sg13g2_fill_2
X_12578_ _12578_/X _14251_/Q _14283_/Q _14315_/Q _14347_/Q _12601_/S0 _12601_/S1 VDD
+ VSS sg13g2_mux4_1
XFILLER_106_1284 VDD VSS sg13g2_fill_2
XFILLER_157_875 VDD VSS sg13g2_fill_1
XFILLER_141_1175 VDD VSS sg13g2_decap_8
XFILLER_102_1137 VDD VSS sg13g2_decap_8
XFILLER_129_588 VDD VSS sg13g2_fill_1
X_14317_ _14317_/Q clkload10/A _14317_/D _14317_/RESET_B VDD VSS sg13g2_dfrbpq_1
X_11529_ _11533_/A _11528_/X _12023_/B VDD VSS sg13g2_nand2b_1
XFILLER_117_739 VDD VSS sg13g2_decap_8
X_14093__2086 _14093_/RESET_B VDD VSS sg13g2_tiehi
XFILLER_8_896 VDD VSS sg13g2_decap_8
XFILLER_7_98 VDD VSS sg13g2_decap_8
XFILLER_116_249 VDD VSS sg13g2_fill_1
X_14248_ _14248_/Q _14310_/CLK _14248_/D _14248_/RESET_B VDD VSS sg13g2_dfrbpq_1
XFILLER_171_355 VDD VSS sg13g2_decap_8
XFILLER_113_912 VDD VSS sg13g2_decap_8
XFILLER_125_783 VDD VSS sg13g2_fill_2
X_14179_ _14179_/Q _14659_/CLK _14179_/D _14179_/RESET_B VDD VSS sg13g2_dfrbpq_1
XFILLER_98_623 VDD VSS sg13g2_decap_8
XFILLER_140_720 VDD VSS sg13g2_decap_8
XFILLER_124_282 VDD VSS sg13g2_decap_4
X_15032__2555 _15032_/RESET_B VDD VSS sg13g2_tiehi
Xfanout809 _12658_/S1 fanout812/X VDD VSS sg13g2_buf_1
XFILLER_113_956 VDD VSS sg13g2_decap_8
XFILLER_140_742 VDD VSS sg13g2_decap_8
XFILLER_97_133 VDD VSS sg13g2_decap_8
XFILLER_6_1302 VDD VSS sg13g2_decap_8
XFILLER_39_701 VDD VSS sg13g2_fill_1
X_08740_ _08740_/Y _13665_/Q _08761_/B VDD VSS sg13g2_nor2_1
XFILLER_26_1252 VDD VSS sg13g2_decap_8
XFILLER_61_1165 VDD VSS sg13g2_decap_8
XFILLER_16_0 VDD VSS sg13g2_decap_8
Xfanout1380 _13324_/A _13328_/A VDD VSS sg13g2_buf_1
XFILLER_94_851 VDD VSS sg13g2_decap_4
Xfanout1391 _10423_/C _10499_/C VDD VSS sg13g2_buf_1
X_08671_ _08671_/Y _08599_/C _08029_/Y _08520_/X _08599_/A _08670_/Y VDD VSS sg13g2_a221oi_1
XFILLER_6_1379 VDD VSS sg13g2_decap_4
XFILLER_66_553 VDD VSS sg13g2_decap_4
XFILLER_113_1266 VDD VSS sg13g2_fill_1
XFILLER_96_1206 VDD VSS sg13g2_fill_2
XFILLER_22_1149 VDD VSS sg13g2_decap_8
XFILLER_27_929 VDD VSS sg13g2_decap_8
XFILLER_26_417 VDD VSS sg13g2_decap_8
X_07622_ _07622_/Y _14861_/Q VDD VSS sg13g2_inv_1
XFILLER_148_1329 VDD VSS sg13g2_decap_8
XFILLER_81_545 VDD VSS sg13g2_decap_8
XFILLER_4_1092 VDD VSS sg13g2_decap_8
XFILLER_59_1050 VDD VSS sg13g2_decap_8
XFILLER_22_601 VDD VSS sg13g2_decap_8
XFILLER_50_921 VDD VSS sg13g2_fill_2
XFILLER_146_1086 VDD VSS sg13g2_decap_8
X_09223_ _13834_/D _10153_/A1 _13834_/Q _09230_/S VDD VSS sg13g2_mux2_1
XFILLER_21_133 VDD VSS sg13g2_decap_8
XFILLER_166_105 VDD VSS sg13g2_decap_8
XFILLER_167_628 VDD VSS sg13g2_fill_1
XFILLER_22_678 VDD VSS sg13g2_decap_8
XFILLER_33_1212 VDD VSS sg13g2_decap_8
X_09154_ _09154_/Y _15248_/Q _09154_/B VDD VSS sg13g2_nand2b_1
XFILLER_120_1226 VDD VSS sg13g2_fill_1
XFILLER_163_812 VDD VSS sg13g2_fill_2
X_08105_ _08105_/Y _08105_/A _08138_/B VDD VSS sg13g2_nor2_1
XFILLER_135_525 VDD VSS sg13g2_fill_2
X_09085_ _09085_/Y _15238_/Q _09100_/B VDD VSS sg13g2_nand2b_1
X_08036_ _08039_/B _08036_/A _08110_/D _08431_/C _08431_/D VDD VSS sg13g2_nand4_1
XFILLER_162_355 VDD VSS sg13g2_decap_8
XFILLER_66_1010 VDD VSS sg13g2_fill_1
XFILLER_163_889 VDD VSS sg13g2_decap_8
XFILLER_66_1032 VDD VSS sg13g2_fill_2
XFILLER_118_1111 VDD VSS sg13g2_fill_2
XFILLER_107_33 VDD VSS sg13g2_fill_1
XFILLER_153_1002 VDD VSS sg13g2_decap_8
XFILLER_27_1005 VDD VSS sg13g2_decap_8
XFILLER_103_422 VDD VSS sg13g2_decap_8
XFILLER_104_978 VDD VSS sg13g2_fill_1
XFILLER_153_1035 VDD VSS sg13g2_decap_8
XFILLER_77_807 VDD VSS sg13g2_decap_4
X_09987_ _14570_/D _10086_/A0 _14570_/Q _09997_/S VDD VSS sg13g2_mux2_1
XFILLER_66_1098 VDD VSS sg13g2_decap_8
XFILLER_103_466 VDD VSS sg13g2_decap_8
XFILLER_107_88 VDD VSS sg13g2_decap_8
XFILLER_130_252 VDD VSS sg13g2_fill_2
XFILLER_89_689 VDD VSS sg13g2_fill_2
XFILLER_131_786 VDD VSS sg13g2_decap_8
XFILLER_153_1068 VDD VSS sg13g2_decap_4
XFILLER_118_1199 VDD VSS sg13g2_decap_4
X_13791__2388 _13791_/RESET_B VDD VSS sg13g2_tiehi
X_08938_ _13718_/D _16880_/A _08937_/X _08941_/S VDD VSS sg13g2_mux2_1
XFILLER_123_21 VDD VSS sg13g2_decap_8
X_14817__2896 _14817_/RESET_B VDD VSS sg13g2_tiehi
XFILLER_131_1344 VDD VSS sg13g2_fill_2
XFILLER_57_553 VDD VSS sg13g2_decap_8
XFILLER_131_1355 VDD VSS sg13g2_decap_4
X_08869_ _08869_/Y _08893_/A _14935_/Q VDD VSS sg13g2_nor2b_1
XFILLER_45_704 VDD VSS sg13g2_decap_8
X_14742__1437 _14742_/RESET_B VDD VSS sg13g2_tiehi
XFILLER_84_350 VDD VSS sg13g2_decap_8
XFILLER_83_14 VDD VSS sg13g2_decap_8
XFILLER_17_406 VDD VSS sg13g2_decap_8
X_10900_ _10900_/Y _10899_/Y _10896_/Y _11056_/B1 VDD VSS sg13g2_o21ai_1
XFILLER_29_277 VDD VSS sg13g2_decap_8
X_11880_ _11880_/Y _11217_/S _14670_/Q _11894_/B VDD VSS sg13g2_a21oi_1
XFILLER_123_98 VDD VSS sg13g2_decap_8
XFILLER_83_58 VDD VSS sg13g2_decap_8
XFILLER_83_69 VDD VSS sg13g2_fill_2
XFILLER_26_951 VDD VSS sg13g2_decap_8
X_10831_ _10832_/A _10831_/A _10831_/B _10831_/C VDD VSS sg13g2_nand3_1
XFILLER_60_718 VDD VSS sg13g2_decap_8
XFILLER_164_1120 VDD VSS sg13g2_decap_8
XFILLER_41_910 VDD VSS sg13g2_fill_1
XFILLER_164_1131 VDD VSS sg13g2_fill_2
XFILLER_16_63 VDD VSS sg13g2_decap_8
XFILLER_41_921 VDD VSS sg13g2_decap_4
XFILLER_26_995 VDD VSS sg13g2_fill_1
XFILLER_13_623 VDD VSS sg13g2_decap_8
X_13550_ _13550_/Y _13550_/A1 _13567_/A2 _13549_/Y VDD VSS sg13g2_a21oi_1
X_10762_ _10762_/Y _10767_/A _10762_/B VDD VSS sg13g2_nor2_1
XFILLER_129_1273 VDD VSS sg13g2_fill_1
XFILLER_38_1156 VDD VSS sg13g2_decap_8
XFILLER_12_133 VDD VSS sg13g2_decap_8
X_12501_ _12501_/X _14246_/Q _14278_/Q _14310_/Q _14342_/Q _12507_/S0 _12507_/S1 VDD
+ VSS sg13g2_mux4_1
XFILLER_157_105 VDD VSS sg13g2_decap_8
XFILLER_158_628 VDD VSS sg13g2_fill_2
XFILLER_9_616 VDD VSS sg13g2_decap_8
XFILLER_41_976 VDD VSS sg13g2_decap_8
XFILLER_125_1148 VDD VSS sg13g2_decap_8
X_13481_ _13484_/A _13481_/A _15176_/Q _13482_/B VDD VSS sg13g2_nand3_1
X_10693_ _14900_/D _10693_/A VDD VSS sg13g2_inv_1
XFILLER_51_1312 VDD VSS sg13g2_fill_2
XFILLER_139_842 VDD VSS sg13g2_fill_1
X_15220_ _15220_/Q clkload61/A _15220_/D _15220_/RESET_B VDD VSS sg13g2_dfrbpq_1
XFILLER_8_126 VDD VSS sg13g2_decap_8
X_12432_ _12432_/X _13729_/Q _14081_/Q _14433_/Q _14529_/Q _12767_/S0 _12767_/S1 VDD
+ VSS sg13g2_mux4_1
XFILLER_90_1383 VDD VSS sg13g2_fill_1
XFILLER_139_864 VDD VSS sg13g2_fill_2
XFILLER_120_0 VDD VSS sg13g2_decap_8
XFILLER_138_363 VDD VSS sg13g2_decap_4
X_15151_ _15151_/Q clkload68/A _15151_/D _15151_/RESET_B VDD VSS sg13g2_dfrbpq_1
XFILLER_32_84 VDD VSS sg13g2_decap_8
XFILLER_172_119 VDD VSS sg13g2_decap_8
XFILLER_154_823 VDD VSS sg13g2_decap_8
X_12363_ _12363_/X _14108_/Q _14140_/Q _14172_/Q _14204_/Q _12617_/S0 _12617_/S1 VDD
+ VSS sg13g2_mux4_1
XFILLER_166_694 VDD VSS sg13g2_decap_8
XFILLER_5_833 VDD VSS sg13g2_decap_8
XFILLER_165_182 VDD VSS sg13g2_decap_8
X_14102_ _14102_/Q clkload24/A _14102_/D _14102_/RESET_B VDD VSS sg13g2_dfrbpq_1
X_11314_ _11314_/Y _11328_/S0 _14365_/Q VDD VSS sg13g2_nand2b_1
X_15082_ _15082_/Q _15159_/CLK _15082_/D _15082_/RESET_B VDD VSS sg13g2_dfrbpq_1
XFILLER_153_355 VDD VSS sg13g2_decap_8
X_12294_ _12294_/Y _14924_/Q _11655_/B _12294_/B1 VDD VSS sg13g2_a21oi_1
XFILLER_4_343 VDD VSS sg13g2_decap_8
XFILLER_101_1170 VDD VSS sg13g2_decap_8
XFILLER_10_1064 VDD VSS sg13g2_decap_8
X_14033_ _14033_/Q _14737_/CLK _14033_/D _14033_/RESET_B VDD VSS sg13g2_dfrbpq_1
XFILLER_107_783 VDD VSS sg13g2_decap_8
X_11245_ _11245_/Y _11245_/A _11245_/B _11245_/C VDD VSS sg13g2_nand3_1
XFILLER_122_720 VDD VSS sg13g2_decap_8
XFILLER_153_399 VDD VSS sg13g2_decap_8
XFILLER_79_111 VDD VSS sg13g2_fill_1
XFILLER_49_1274 VDD VSS sg13g2_decap_8
X_11176_ _11177_/B _11171_/B _11147_/Y _11175_/Y VDD VSS sg13g2_a21o_1
XFILLER_84_1187 VDD VSS sg13g2_decap_4
XFILLER_45_1138 VDD VSS sg13g2_fill_2
X_14078__2101 _14078_/RESET_B VDD VSS sg13g2_tiehi
XFILLER_0_560 VDD VSS sg13g2_decap_8
XFILLER_79_177 VDD VSS sg13g2_decap_8
X_10127_ _14705_/D _10127_/A0 _14705_/Q _10127_/S VDD VSS sg13g2_mux2_1
XFILLER_121_285 VDD VSS sg13g2_decap_8
XFILLER_136_1299 VDD VSS sg13g2_fill_2
X_14381__1798 _14381_/RESET_B VDD VSS sg13g2_tiehi
X_14935_ _14935_/Q clkload56/A _14935_/D _14935_/RESET_B VDD VSS sg13g2_dfrbpq_1
X_10058_ _14639_/D _10091_/A0 _14639_/Q _10069_/S VDD VSS sg13g2_mux2_1
XFILLER_91_810 VDD VSS sg13g2_decap_4
X_14718__1461 _14718_/RESET_B VDD VSS sg13g2_tiehi
XFILLER_48_597 VDD VSS sg13g2_decap_8
X_14866_ _14866_/Q _14867_/CLK _14866_/D _14866_/RESET_B VDD VSS sg13g2_dfrbpq_1
XFILLER_90_320 VDD VSS sg13g2_decap_8
XFILLER_75_394 VDD VSS sg13g2_decap_4
XFILLER_91_854 VDD VSS sg13g2_fill_2
XFILLER_63_545 VDD VSS sg13g2_fill_2
XFILLER_1_1232 VDD VSS sg13g2_decap_8
XFILLER_91_865 VDD VSS sg13g2_fill_2
XFILLER_35_258 VDD VSS sg13g2_decap_8
X_13817_ _13817_/Q _14745_/CLK _13817_/D _13817_/RESET_B VDD VSS sg13g2_dfrbpq_1
XFILLER_90_353 VDD VSS sg13g2_decap_4
X_14001__2178 _14001_/RESET_B VDD VSS sg13g2_tiehi
XFILLER_17_973 VDD VSS sg13g2_decap_8
X_14797_ _14797_/Q _14868_/CLK _14797_/D _14797_/RESET_B VDD VSS sg13g2_dfrbpq_1
XFILLER_91_898 VDD VSS sg13g2_decap_8
XFILLER_51_729 VDD VSS sg13g2_decap_8
XFILLER_147_1340 VDD VSS sg13g2_decap_8
XFILLER_32_921 VDD VSS sg13g2_decap_8
XFILLER_16_483 VDD VSS sg13g2_decap_8
XFILLER_95_1294 VDD VSS sg13g2_decap_4
X_13748_ _13748_/Q _14644_/CLK _13748_/D _13748_/RESET_B VDD VSS sg13g2_dfrbpq_1
XFILLER_147_1373 VDD VSS sg13g2_fill_2
XFILLER_43_291 VDD VSS sg13g2_decap_8
XFILLER_17_1218 VDD VSS sg13g2_decap_8
XFILLER_149_628 VDD VSS sg13g2_decap_8
XFILLER_91_1158 VDD VSS sg13g2_fill_2
XFILLER_56_1278 VDD VSS sg13g2_fill_2
XFILLER_32_976 VDD VSS sg13g2_decap_8
X_13679_ _13679_/Q _15213_/CLK _13679_/D _13679_/RESET_B VDD VSS sg13g2_dfrbpq_1
XFILLER_129_341 VDD VSS sg13g2_decap_8
XFILLER_157_672 VDD VSS sg13g2_decap_8
XFILLER_89_1021 VDD VSS sg13g2_fill_1
XFILLER_163_119 VDD VSS sg13g2_decap_8
XFILLER_157_694 VDD VSS sg13g2_fill_2
XFILLER_156_171 VDD VSS sg13g2_decap_8
XFILLER_89_1054 VDD VSS sg13g2_decap_4
XFILLER_117_547 VDD VSS sg13g2_decap_4
XFILLER_8_693 VDD VSS sg13g2_decap_8
XFILLER_144_333 VDD VSS sg13g2_decap_8
XFILLER_145_867 VDD VSS sg13g2_decap_8
XFILLER_172_653 VDD VSS sg13g2_decap_8
XFILLER_172_664 VDD VSS sg13g2_fill_1
XFILLER_104_208 VDD VSS sg13g2_fill_1
XFILLER_160_826 VDD VSS sg13g2_fill_2
X_09910_ _14495_/D _14495_/Q _09910_/A1 _09928_/S VDD VSS sg13g2_mux2_1
XFILLER_172_697 VDD VSS sg13g2_decap_8
XFILLER_144_399 VDD VSS sg13g2_decap_8
XFILLER_98_420 VDD VSS sg13g2_decap_8
XFILLER_125_591 VDD VSS sg13g2_fill_2
XFILLER_171_196 VDD VSS sg13g2_decap_8
Xfanout606 _10788_/S _10743_/S VDD VSS sg13g2_buf_1
XFILLER_28_1336 VDD VSS sg13g2_decap_8
Xfanout617 _08860_/S _08904_/S VDD VSS sg13g2_buf_1
X_09841_ _14428_/D _14428_/Q _10072_/A0 _09863_/S VDD VSS sg13g2_mux2_1
XFILLER_99_976 VDD VSS sg13g2_decap_8
XFILLER_112_241 VDD VSS sg13g2_decap_8
XFILLER_140_550 VDD VSS sg13g2_decap_8
Xfanout628 _08404_/B1 _07998_/X VDD VSS sg13g2_buf_1
XFILLER_154_1366 VDD VSS sg13g2_fill_2
Xfanout639 _08432_/A2 _08623_/A2 VDD VSS sg13g2_buf_1
XFILLER_98_475 VDD VSS sg13g2_decap_8
XFILLER_115_1328 VDD VSS sg13g2_decap_8
XFILLER_154_1377 VDD VSS sg13g2_fill_2
XFILLER_113_797 VDD VSS sg13g2_decap_8
X_09772_ _14362_/D _14362_/Q _09772_/A1 _09772_/S VDD VSS sg13g2_mux2_1
X_14211__1968 _14211_/RESET_B VDD VSS sg13g2_tiehi
X_08723_ _08723_/Y _08723_/A _13307_/B VDD VSS sg13g2_nor2_1
XFILLER_39_564 VDD VSS sg13g2_fill_1
XFILLER_6_1176 VDD VSS sg13g2_decap_8
XFILLER_67_884 VDD VSS sg13g2_decap_8
XFILLER_113_1063 VDD VSS sg13g2_decap_8
XFILLER_2_1029 VDD VSS sg13g2_decap_8
XFILLER_26_203 VDD VSS sg13g2_decap_8
X_08654_ _08654_/Y _08654_/A _08654_/B VDD VSS sg13g2_nor2_1
XFILLER_82_876 VDD VSS sg13g2_decap_4
XFILLER_148_1148 VDD VSS sg13g2_decap_8
X_13776__2403 _13776_/RESET_B VDD VSS sg13g2_tiehi
X_08585_ _08586_/C _08608_/B _08576_/Y _08584_/Y VDD VSS sg13g2_o21ai_1
XFILLER_74_1301 VDD VSS sg13g2_decap_8
XFILLER_53_28 VDD VSS sg13g2_decap_8
XFILLER_23_910 VDD VSS sg13g2_decap_8
XFILLER_169_28 VDD VSS sg13g2_decap_8
XFILLER_22_420 VDD VSS sg13g2_decap_8
XFILLER_34_291 VDD VSS sg13g2_decap_8
XFILLER_35_1329 VDD VSS sg13g2_decap_8
X_09206_ _09239_/S _09441_/A _09307_/B _09707_/B _09641_/D VDD VSS sg13g2_or4_1
XFILLER_33_1020 VDD VSS sg13g2_fill_1
XFILLER_10_637 VDD VSS sg13g2_decap_8
XFILLER_22_497 VDD VSS sg13g2_decap_8
XFILLER_167_469 VDD VSS sg13g2_decap_8
X_15139__2679 _15139_/RESET_B VDD VSS sg13g2_tiehi
XFILLER_148_650 VDD VSS sg13g2_decap_8
X_14156__2023 _14156_/RESET_B VDD VSS sg13g2_tiehi
XFILLER_33_1042 VDD VSS sg13g2_fill_2
XFILLER_120_1001 VDD VSS sg13g2_decap_8
XFILLER_124_1170 VDD VSS sg13g2_decap_4
XFILLER_154_119 VDD VSS sg13g2_decap_8
X_09137_ _09137_/Y _09137_/A _09137_/B _09137_/C VDD VSS sg13g2_nor3_1
XFILLER_108_525 VDD VSS sg13g2_decap_8
XFILLER_33_1097 VDD VSS sg13g2_decap_8
XFILLER_159_1233 VDD VSS sg13g2_decap_4
XFILLER_163_642 VDD VSS sg13g2_fill_1
XFILLER_118_21 VDD VSS sg13g2_decap_8
XFILLER_135_344 VDD VSS sg13g2_decap_4
XFILLER_11_1351 VDD VSS sg13g2_decap_8
X_09068_ _09103_/C _14911_/Q _13064_/A _09089_/C VDD VSS sg13g2_and3_1
XFILLER_123_517 VDD VSS sg13g2_fill_1
X_08019_ _08019_/X _08254_/S _08019_/B VDD VSS sg13g2_and2_1
XFILLER_78_14 VDD VSS sg13g2_decap_8
XFILLER_150_336 VDD VSS sg13g2_fill_1
XFILLER_162_196 VDD VSS sg13g2_decap_8
XFILLER_2_847 VDD VSS sg13g2_decap_8
XFILLER_104_742 VDD VSS sg13g2_fill_1
X_11030_ _11030_/Y _11052_/A _11045_/A2 _09204_/C VDD VSS sg13g2_a21oi_1
XFILLER_77_604 VDD VSS sg13g2_fill_1
XFILLER_1_357 VDD VSS sg13g2_decap_8
XFILLER_131_561 VDD VSS sg13g2_fill_2
XFILLER_77_626 VDD VSS sg13g2_decap_8
XFILLER_103_285 VDD VSS sg13g2_decap_8
XFILLER_134_53 VDD VSS sg13g2_decap_8
XFILLER_94_35 VDD VSS sg13g2_decap_8
XFILLER_76_158 VDD VSS sg13g2_decap_8
X_12981_ _12981_/Y input23/X _12795_/Y _12937_/Y VDD VSS sg13g2_o21ai_1
XFILLER_79_1201 VDD VSS sg13g2_fill_1
X_14963__2624 _14963_/RESET_B VDD VSS sg13g2_tiehi
Xclkbuf_5_23__f_clk_i clkbuf_leaf_87_clk_i/A clkbuf_4_11_0_clk_i/X VDD VSS sg13g2_buf_16
XFILLER_79_1212 VDD VSS sg13g2_decap_8
XFILLER_100_981 VDD VSS sg13g2_decap_8
XFILLER_85_681 VDD VSS sg13g2_decap_8
XFILLER_17_203 VDD VSS sg13g2_decap_8
X_14720_ _14720_/Q _14721_/CLK _14720_/D _14720_/RESET_B VDD VSS sg13g2_dfrbpq_1
XFILLER_45_523 VDD VSS sg13g2_decap_8
X_11932_ _11932_/Y _11931_/Y _11930_/Y _11917_/Y _12123_/A1 _11980_/A VDD VSS sg13g2_a221oi_1
XFILLER_72_320 VDD VSS sg13g2_fill_2
XFILLER_27_84 VDD VSS sg13g2_decap_8
XFILLER_150_63 VDD VSS sg13g2_decap_8
XFILLER_168_0 VDD VSS sg13g2_decap_8
X_14651_ _14651_/Q clkload40/A _14651_/D _14651_/RESET_B VDD VSS sg13g2_dfrbpq_1
X_11863_ _11863_/Y _11865_/A _12082_/B VDD VSS sg13g2_nor2_1
XFILLER_79_1289 VDD VSS sg13g2_decap_8
XFILLER_14_910 VDD VSS sg13g2_decap_8
X_14366__1813 _14366_/RESET_B VDD VSS sg13g2_tiehi
XFILLER_60_515 VDD VSS sg13g2_fill_2
X_13602_ _13602_/Y _13602_/A _13609_/B VDD VSS sg13g2_nor2_1
X_10814_ _10814_/Y _10805_/B _10805_/C _10844_/B VDD VSS sg13g2_o21ai_1
XFILLER_32_228 VDD VSS sg13g2_decap_8
XFILLER_13_420 VDD VSS sg13g2_decap_8
X_14582_ _14582_/Q clkload26/A _14582_/D _14582_/RESET_B VDD VSS sg13g2_dfrbpq_1
X_11794_ _11794_/Y _11793_/Y _11792_/Y _11780_/Y _12123_/A1 _11980_/A VDD VSS sg13g2_a221oi_1
XFILLER_14_987 VDD VSS sg13g2_decap_8
X_13533_ _13533_/X _13533_/A _13533_/B VDD VSS sg13g2_and2_1
X_10745_ _10745_/Y _14914_/Q _11048_/B VDD VSS sg13g2_nand2_1
XFILLER_9_413 VDD VSS sg13g2_decap_8
XFILLER_40_261 VDD VSS sg13g2_decap_8
XFILLER_13_497 VDD VSS sg13g2_decap_8
XFILLER_51_1120 VDD VSS sg13g2_decap_4
X_13464_ _15107_/D _13449_/X _13463_/X _13461_/Y VDD VSS sg13g2_o21ai_1
XFILLER_174_918 VDD VSS sg13g2_fill_1
X_10676_ _10813_/A _08977_/B _10669_/S _10805_/B VDD VSS sg13g2_a21oi_1
XFILLER_174_929 VDD VSS sg13g2_fill_2
XFILLER_127_801 VDD VSS sg13g2_decap_8
XFILLER_90_1191 VDD VSS sg13g2_decap_8
XFILLER_142_1270 VDD VSS sg13g2_decap_8
X_15203_ _15203_/Q clkload70/A _15203_/D _15203_/RESET_B VDD VSS sg13g2_dfrbpq_1
X_12415_ _12415_/Y _12415_/A _12415_/B VDD VSS sg13g2_nand2_1
XFILLER_139_683 VDD VSS sg13g2_decap_8
XFILLER_16_1295 VDD VSS sg13g2_decap_8
X_13395_ _13396_/D _13398_/B _15129_/Q _13507_/B VDD VSS sg13g2_nand3_1
XFILLER_12_1148 VDD VSS sg13g2_decap_8
XFILLER_5_630 VDD VSS sg13g2_decap_8
XFILLER_153_130 VDD VSS sg13g2_fill_2
X_15134_ _15134_/Q clkload59/A _15134_/D _15134_/RESET_B VDD VSS sg13g2_dfrbpq_1
X_12346_ _12347_/D _12346_/A _15121_/Q VDD VSS sg13g2_or2_1
XFILLER_86_1227 VDD VSS sg13g2_fill_1
XFILLER_142_804 VDD VSS sg13g2_decap_8
XFILLER_114_506 VDD VSS sg13g2_decap_4
XFILLER_127_889 VDD VSS sg13g2_fill_2
XFILLER_57_7 VDD VSS sg13g2_decap_8
XFILLER_4_140 VDD VSS sg13g2_decap_8
X_15065_ _15065_/Q _15113_/CLK _15065_/D _15065_/RESET_B VDD VSS sg13g2_dfrbpq_1
X_12277_ _12277_/X _12278_/A _13663_/Q VDD VSS sg13g2_and2_1
X_14016_ _14016_/Q _14721_/CLK _14016_/D _14016_/RESET_B VDD VSS sg13g2_dfrbpq_1
X_11228_ _11228_/X _14683_/Q _14715_/Q _13755_/Q _13787_/Q _11229_/S0 _11878_/B1 VDD
+ VSS sg13g2_mux4_1
XFILLER_96_902 VDD VSS sg13g2_decap_8
X_13854__2325 _13854_/RESET_B VDD VSS sg13g2_tiehi
XFILLER_4_77 VDD VSS sg13g2_decap_8
XFILLER_122_561 VDD VSS sg13g2_decap_8
XFILLER_110_734 VDD VSS sg13g2_fill_1
XFILLER_136_1085 VDD VSS sg13g2_decap_4
X_11159_ _11159_/Y _11171_/B _11180_/C _11173_/C VDD VSS sg13g2_a21oi_1
XFILLER_68_648 VDD VSS sg13g2_fill_1
X_14896__2752 _14896_/RESET_B VDD VSS sg13g2_tiehi
XFILLER_3_1316 VDD VSS sg13g2_decap_8
XFILLER_23_1244 VDD VSS sg13g2_decap_8
X_14918_ _14918_/Q _14979_/CLK _14918_/D _14918_/RESET_B VDD VSS sg13g2_dfrbpq_1
XFILLER_64_865 VDD VSS sg13g2_fill_1
XFILLER_36_567 VDD VSS sg13g2_fill_2
XFILLER_58_1329 VDD VSS sg13g2_decap_8
X_14849_ _14849_/Q clkload48/A _14849_/D _14849_/RESET_B VDD VSS sg13g2_dfrbpq_1
XFILLER_17_770 VDD VSS sg13g2_decap_8
XFILLER_23_217 VDD VSS sg13g2_decap_8
X_08370_ _08370_/Y _08391_/A _08367_/Y _08389_/B VDD VSS sg13g2_o21ai_1
XFILLER_108_1110 VDD VSS sg13g2_decap_8
XFILLER_16_280 VDD VSS sg13g2_decap_8
XFILLER_17_1015 VDD VSS sg13g2_decap_8
XFILLER_20_924 VDD VSS sg13g2_decap_8
XFILLER_56_1097 VDD VSS sg13g2_decap_4
XFILLER_83_0 VDD VSS sg13g2_decap_8
XFILLER_104_1018 VDD VSS sg13g2_decap_8
XFILLER_149_458 VDD VSS sg13g2_fill_2
XFILLER_164_406 VDD VSS sg13g2_decap_8
XFILLER_9_980 VDD VSS sg13g2_decap_8
XFILLER_30_1226 VDD VSS sg13g2_decap_8
XFILLER_129_193 VDD VSS sg13g2_decap_8
XFILLER_8_490 VDD VSS sg13g2_decap_8
XFILLER_144_130 VDD VSS sg13g2_decap_4
XFILLER_132_314 VDD VSS sg13g2_decap_8
XFILLER_133_848 VDD VSS sg13g2_decap_8
XFILLER_133_859 VDD VSS sg13g2_fill_2
XFILLER_160_645 VDD VSS sg13g2_fill_2
XFILLER_154_1130 VDD VSS sg13g2_fill_2
Xfanout403 _09167_/S wire405/A VDD VSS sg13g2_buf_1
XFILLER_28_1133 VDD VSS sg13g2_decap_8
Xfanout414 _11163_/A _11164_/A VDD VSS sg13g2_buf_1
X_14444__1735 _14444_/RESET_B VDD VSS sg13g2_tiehi
Xfanout425 _10032_/S _10035_/S VDD VSS sg13g2_buf_1
XFILLER_59_615 VDD VSS sg13g2_decap_8
XFILLER_101_712 VDD VSS sg13g2_decap_8
Xfanout436 _09838_/S _09806_/Y VDD VSS sg13g2_buf_1
XFILLER_48_28 VDD VSS sg13g2_decap_8
XFILLER_98_272 VDD VSS sg13g2_decap_8
XFILLER_87_946 VDD VSS sg13g2_decap_8
Xfanout447 _09563_/S _09572_/S VDD VSS sg13g2_buf_1
X_09824_ _14412_/D _09923_/A1 _14412_/Q _09832_/S VDD VSS sg13g2_mux2_1
Xfanout458 _09467_/S _09473_/S VDD VSS sg13g2_buf_1
Xfanout469 _09368_/S _09374_/S VDD VSS sg13g2_buf_1
XFILLER_41_1311 VDD VSS sg13g2_fill_1
X_09755_ _14345_/D _14345_/Q _09920_/A1 _09771_/S VDD VSS sg13g2_mux2_1
XFILLER_86_489 VDD VSS sg13g2_decap_8
XFILLER_41_1355 VDD VSS sg13g2_decap_8
XFILLER_27_512 VDD VSS sg13g2_decap_8
XFILLER_100_299 VDD VSS sg13g2_fill_1
X_08706_ _13658_/D _15185_/D _15116_/Q _13652_/S VDD VSS sg13g2_mux2_1
X_09686_ _14278_/D _09884_/A0 _14278_/Q _09697_/S VDD VSS sg13g2_mux2_1
XFILLER_104_89 VDD VSS sg13g2_decap_8
Xclkbuf_4_9_0_clk_i clkbuf_4_9_0_clk_i/X clkbuf_0_clk_i/X VDD VSS sg13g2_buf_8
XFILLER_15_707 VDD VSS sg13g2_decap_8
X_08637_ _08640_/D _08637_/A _08637_/B VDD VSS sg13g2_nand2_1
XFILLER_161_7 VDD VSS sg13g2_decap_8
XFILLER_70_813 VDD VSS sg13g2_decap_8
XFILLER_14_217 VDD VSS sg13g2_decap_8
X_08568_ _08568_/Y _15012_/Q _08541_/B _07956_/A _07812_/B VDD VSS sg13g2_a22oi_1
XFILLER_74_1131 VDD VSS sg13g2_decap_8
XFILLER_81_194 VDD VSS sg13g2_fill_2
XFILLER_120_66 VDD VSS sg13g2_fill_2
XFILLER_126_1243 VDD VSS sg13g2_decap_8
XFILLER_35_1126 VDD VSS sg13g2_decap_8
XFILLER_11_924 VDD VSS sg13g2_decap_8
X_15181__2843 _15181_/RESET_B VDD VSS sg13g2_tiehi
X_08499_ _08499_/Y _08527_/B _08498_/Y _08588_/B VDD VSS sg13g2_o21ai_1
XFILLER_74_1197 VDD VSS sg13g2_fill_1
X_10530_ _10532_/C _10558_/B _10543_/C _14859_/Q VDD VSS sg13g2_a21o_1
X_13932__2247 _13932_/RESET_B VDD VSS sg13g2_tiehi
XFILLER_10_434 VDD VSS sg13g2_decap_8
XFILLER_13_42 VDD VSS sg13g2_decap_8
X_14692__1487 _14692_/RESET_B VDD VSS sg13g2_tiehi
XFILLER_7_917 VDD VSS sg13g2_decap_8
XFILLER_22_294 VDD VSS sg13g2_decap_8
XFILLER_161_1189 VDD VSS sg13g2_decap_4
XFILLER_167_266 VDD VSS sg13g2_decap_8
XFILLER_155_417 VDD VSS sg13g2_decap_8
XFILLER_129_42 VDD VSS sg13g2_decap_8
X_10461_ _10502_/A _10471_/C _14842_/Q _14841_/Q VDD VSS sg13g2_nand3_1
XFILLER_6_427 VDD VSS sg13g2_decap_8
X_12200_ _12200_/X _12200_/A _12200_/B VDD VSS sg13g2_or2_1
XFILLER_109_867 VDD VSS sg13g2_fill_1
X_13180_ _13180_/Y _14823_/Q _13206_/B _13249_/B _14887_/Q _13082_/B VDD VSS sg13g2_a221oi_1
XFILLER_89_35 VDD VSS sg13g2_decap_8
XFILLER_135_141 VDD VSS sg13g2_decap_8
XFILLER_164_973 VDD VSS sg13g2_decap_8
X_10392_ _14821_/D _10392_/A _10392_/B _10392_/C VDD VSS sg13g2_and3_1
XFILLER_151_601 VDD VSS sg13g2_fill_2
XFILLER_124_837 VDD VSS sg13g2_decap_8
X_12131_ _12155_/B _12198_/B _12132_/B VDD VSS sg13g2_nand2b_1
XFILLER_163_483 VDD VSS sg13g2_decap_8
XFILLER_151_634 VDD VSS sg13g2_decap_8
XFILLER_159_1085 VDD VSS sg13g2_decap_8
XFILLER_151_645 VDD VSS sg13g2_fill_1
XFILLER_2_644 VDD VSS sg13g2_decap_8
X_12062_ _12065_/A _12062_/A _12062_/B _12197_/A VDD VSS sg13g2_nand3_1
XFILLER_145_63 VDD VSS sg13g2_decap_4
XFILLER_150_166 VDD VSS sg13g2_decap_8
X_15241__3009 _15241_/RESET_B VDD VSS sg13g2_tiehi
XFILLER_1_154 VDD VSS sg13g2_decap_8
XFILLER_133_1214 VDD VSS sg13g2_fill_2
X_11013_ _11022_/B _11012_/B _11012_/C _11064_/A VDD VSS sg13g2_o21ai_1
XFILLER_89_272 VDD VSS sg13g2_fill_1
XFILLER_172_1263 VDD VSS sg13g2_fill_1
X_16870_ _16870_/X _16870_/A VDD VSS sg13g2_buf_1
XFILLER_78_957 VDD VSS sg13g2_decap_4
XFILLER_46_1288 VDD VSS sg13g2_decap_4
Xfanout970 _13427_/C _08391_/A VDD VSS sg13g2_buf_1
XFILLER_133_1269 VDD VSS sg13g2_fill_1
Xfanout981 _10843_/C _13279_/B VDD VSS sg13g2_buf_1
Xfanout992 _09938_/B _10105_/C VDD VSS sg13g2_buf_1
XFILLER_77_489 VDD VSS sg13g2_decap_8
X_12964_ _12964_/Y _14809_/Q _13014_/A2 _13234_/B _14841_/Q _13248_/B VDD VSS sg13g2_a221oi_1
XFILLER_161_84 VDD VSS sg13g2_decap_8
X_14703_ _14703_/Q _14703_/CLK _14703_/D _14703_/RESET_B VDD VSS sg13g2_dfrbpq_1
XFILLER_61_802 VDD VSS sg13g2_decap_8
XFILLER_45_353 VDD VSS sg13g2_decap_8
XFILLER_18_567 VDD VSS sg13g2_decap_8
X_11915_ _12055_/A _11915_/A VDD VSS sg13g2_inv_1
X_12895_ _12895_/Y _14869_/Q _12895_/B VDD VSS sg13g2_nand2_1
XFILLER_166_1056 VDD VSS sg13g2_fill_2
XFILLER_45_397 VDD VSS sg13g2_fill_2
X_14634_ _14634_/Q _14730_/CLK _14634_/D _14634_/RESET_B VDD VSS sg13g2_dfrbpq_1
X_11846_ _11846_/Y _11846_/A _11867_/B VDD VSS sg13g2_nand2_1
XFILLER_57_1351 VDD VSS sg13g2_decap_4
XFILLER_18_1302 VDD VSS sg13g2_decap_8
X_14565_ _14565_/Q clkload5/A _14565_/D _14565_/RESET_B VDD VSS sg13g2_dfrbpq_1
X_11777_ _11778_/B _11777_/A _11777_/B _11777_/C VDD VSS sg13g2_nor3_1
XFILLER_14_784 VDD VSS sg13g2_decap_8
XFILLER_53_1237 VDD VSS sg13g2_decap_8
XFILLER_9_210 VDD VSS sg13g2_decap_8
XFILLER_92_1297 VDD VSS sg13g2_decap_8
X_13516_ _15139_/D _15139_/Q _13545_/A _13519_/B VDD VSS sg13g2_mux2_1
X_10728_ _14909_/D _11193_/B1 _10995_/A _10727_/Y VDD VSS sg13g2_o21ai_1
XFILLER_18_1379 VDD VSS sg13g2_decap_4
XFILLER_13_294 VDD VSS sg13g2_decap_8
X_14496_ _14496_/Q clkload27/A _14496_/D _14496_/RESET_B VDD VSS sg13g2_dfrbpq_1
X_14522__1657 _14522_/RESET_B VDD VSS sg13g2_tiehi
XFILLER_146_417 VDD VSS sg13g2_decap_8
XFILLER_158_277 VDD VSS sg13g2_decap_8
X_13908__2271 _13908_/RESET_B VDD VSS sg13g2_tiehi
XFILLER_174_726 VDD VSS sg13g2_fill_1
X_13447_ _13459_/D _15193_/Q _15194_/Q _15195_/Q _15197_/Q VDD VSS sg13g2_nor4_1
X_10659_ _10661_/B _14891_/Q _10663_/D _14892_/Q VDD VSS sg13g2_a21oi_1
XFILLER_9_287 VDD VSS sg13g2_decap_8
XFILLER_16_1092 VDD VSS sg13g2_decap_8
Xclkload13 clkload13/Y clkload13/A VDD VSS sg13g2_inv_2
Xclkload24 clkload24/X clkload24/A VDD VSS sg13g2_buf_8
Xclkload35 clkload35/Y clkload35/A VDD VSS sg13g2_inv_2
XFILLER_86_1002 VDD VSS sg13g2_fill_2
Xclkload46 clkload46/Y clkload46/A VDD VSS sg13g2_inv_2
XFILLER_115_804 VDD VSS sg13g2_fill_2
XFILLER_127_664 VDD VSS sg13g2_decap_8
X_13378_ _13378_/Y _13396_/C _13494_/B _13378_/C VDD VSS sg13g2_nor3_1
X_14776__2937 _14776_/RESET_B VDD VSS sg13g2_tiehi
Xclkload57 clkload57/Y clkload57/A VDD VSS sg13g2_inv_2
XFILLER_170_921 VDD VSS sg13g2_fill_2
Xclkload68 clkload68/Y clkload68/A VDD VSS sg13g2_inv_1
XFILLER_138_1114 VDD VSS sg13g2_fill_2
X_15117_ _15117_/Q _15188_/CLK _15117_/D _15117_/RESET_B VDD VSS sg13g2_dfrbpq_1
XFILLER_6_994 VDD VSS sg13g2_decap_8
XFILLER_126_185 VDD VSS sg13g2_decap_4
X_12329_ _12329_/Y _12325_/Y _12326_/Y _12328_/Y _12327_/Y _11266_/B VDD VSS sg13g2_a221oi_1
XFILLER_142_645 VDD VSS sg13g2_decap_8
XFILLER_170_976 VDD VSS sg13g2_decap_8
X_15048_ _15048_/Q clkload52/A _15048_/D _15048_/RESET_B VDD VSS sg13g2_dfrbpq_1
Xclkbuf_leaf_64_clk_i clkload55/A clkbuf_leaf_73_clk_i/A VDD VSS sg13g2_buf_8
XFILLER_141_177 VDD VSS sg13g2_decap_8
XFILLER_68_412 VDD VSS sg13g2_decap_8
XFILLER_110_520 VDD VSS sg13g2_decap_8
X_07870_ _08188_/A _11428_/A _08201_/A VDD VSS sg13g2_and2_1
XFILLER_96_754 VDD VSS sg13g2_decap_8
XFILLER_151_1347 VDD VSS sg13g2_fill_2
XFILLER_68_456 VDD VSS sg13g2_fill_1
XFILLER_68_467 VDD VSS sg13g2_fill_1
XFILLER_28_309 VDD VSS sg13g2_fill_1
XFILLER_7_1260 VDD VSS sg13g2_decap_8
XFILLER_3_1113 VDD VSS sg13g2_decap_8
XFILLER_110_1000 VDD VSS sg13g2_fill_2
Xclkbuf_leaf_79_clk_i clkload49/A clkbuf_leaf_88_clk_i/A VDD VSS sg13g2_buf_8
X_09540_ _09540_/Y _10037_/A _10004_/B _10004_/C _09606_/C VDD VSS sg13g2_nand4_1
XFILLER_49_681 VDD VSS sg13g2_decap_8
XFILLER_37_843 VDD VSS sg13g2_decap_8
XFILLER_97_1153 VDD VSS sg13g2_decap_8
X_09471_ _14072_/D _09636_/A0 _14072_/Q _09473_/S VDD VSS sg13g2_mux2_1
XFILLER_93_1006 VDD VSS sg13g2_fill_2
XFILLER_58_1126 VDD VSS sg13g2_decap_8
XFILLER_110_1077 VDD VSS sg13g2_fill_2
XFILLER_97_1186 VDD VSS sg13g2_decap_8
XFILLER_24_515 VDD VSS sg13g2_decap_8
XFILLER_110_1088 VDD VSS sg13g2_decap_4
XFILLER_24_526 VDD VSS sg13g2_fill_1
X_08422_ _08423_/B _08434_/B _08421_/Y _08649_/S VDD VSS sg13g2_mux2_1
XFILLER_145_1107 VDD VSS sg13g2_decap_4
X_08353_ _08354_/B _08353_/A _08353_/B VDD VSS sg13g2_nand2_1
XFILLER_32_581 VDD VSS sg13g2_fill_2
XFILLER_20_721 VDD VSS sg13g2_decap_8
X_08284_ _08293_/B _08270_/Y _08271_/Y _08273_/Y _08381_/A _08283_/Y VDD VSS sg13g2_a221oi_1
Xclkload7 clkload7/Y clkload7/A VDD VSS sg13g2_inv_1
XFILLER_165_726 VDD VSS sg13g2_decap_8
XFILLER_164_203 VDD VSS sg13g2_decap_8
Xclkbuf_leaf_17_clk_i _14744_/CLK clkbuf_5_7__f_clk_i/X VDD VSS sg13g2_buf_8
XFILLER_165_748 VDD VSS sg13g2_decap_4
XFILLER_20_798 VDD VSS sg13g2_decap_8
XFILLER_146_940 VDD VSS sg13g2_decap_8
XFILLER_69_1211 VDD VSS sg13g2_fill_1
XFILLER_146_962 VDD VSS sg13g2_decap_8
XFILLER_117_152 VDD VSS sg13g2_fill_2
XFILLER_146_995 VDD VSS sg13g2_decap_4
XFILLER_117_196 VDD VSS sg13g2_decap_8
X_14677__1502 _14677_/RESET_B VDD VSS sg13g2_tiehi
XFILLER_69_1288 VDD VSS sg13g2_fill_1
XFILLER_160_464 VDD VSS sg13g2_fill_2
Xfanout200 _10092_/A0 _09927_/A1 VDD VSS sg13g2_buf_1
XFILLER_114_881 VDD VSS sg13g2_fill_2
XFILLER_120_317 VDD VSS sg13g2_decap_8
Xfanout211 _10123_/A0 _09076_/Y VDD VSS sg13g2_buf_1
Xfanout1209 _11171_/B _11061_/A2 VDD VSS sg13g2_buf_1
Xfanout222 _09889_/A0 _09922_/A1 VDD VSS sg13g2_buf_1
Xfanout233 _10085_/A0 _09621_/A0 VDD VSS sg13g2_buf_1
Xfanout244 _12298_/B _11246_/Y VDD VSS sg13g2_buf_1
Xfanout255 _10149_/A1 _10082_/A0 VDD VSS sg13g2_buf_1
XFILLER_8_1057 VDD VSS sg13g2_decap_8
Xfanout266 _09903_/S _09898_/S VDD VSS sg13g2_buf_1
XFILLER_86_242 VDD VSS sg13g2_fill_2
Xfanout277 _09440_/S _09408_/Y VDD VSS sg13g2_buf_1
X_09807_ _14395_/D _09906_/A1 _14395_/Q _09832_/S VDD VSS sg13g2_mux2_1
XFILLER_101_564 VDD VSS sg13g2_fill_1
Xfanout288 _09517_/A0 _10080_/A0 VDD VSS sg13g2_buf_1
Xfanout299 _10074_/A0 fanout301/X VDD VSS sg13g2_buf_1
X_07999_ _08001_/D _15097_/Q _15092_/Q _15131_/Q _08027_/B VDD VSS sg13g2_nor4_1
XFILLER_46_128 VDD VSS sg13g2_decap_8
X_09738_ _14329_/D _09936_/A1 _14329_/Q _09738_/S VDD VSS sg13g2_mux2_1
XFILLER_46_139 VDD VSS sg13g2_fill_2
X_14600__1579 _14600_/RESET_B VDD VSS sg13g2_tiehi
XFILLER_55_640 VDD VSS sg13g2_decap_8
XFILLER_131_21 VDD VSS sg13g2_decap_4
XFILLER_167_1321 VDD VSS sg13g2_fill_1
XFILLER_15_504 VDD VSS sg13g2_decap_8
X_09669_ _14262_/D _09768_/A1 _14262_/Q _09670_/S VDD VSS sg13g2_mux2_1
XFILLER_27_375 VDD VSS sg13g2_decap_8
XFILLER_76_1237 VDD VSS sg13g2_fill_1
XFILLER_91_14 VDD VSS sg13g2_decap_8
XFILLER_167_1365 VDD VSS sg13g2_decap_8
X_11700_ _11700_/X _14907_/Q _11655_/B _11699_/Y VDD VSS sg13g2_a21o_1
XFILLER_163_1207 VDD VSS sg13g2_decap_8
X_12680_ _15012_/D _12680_/A _12680_/B VDD VSS sg13g2_nor2_1
X_14880__2784 _14880_/RESET_B VDD VSS sg13g2_tiehi
XFILLER_42_345 VDD VSS sg13g2_decap_8
X_11631_ _11632_/B _11593_/Y _12156_/A _11630_/Y VDD VSS sg13g2_a21oi_1
XFILLER_42_389 VDD VSS sg13g2_decap_8
XFILLER_11_721 VDD VSS sg13g2_decap_8
XFILLER_24_63 VDD VSS sg13g2_decap_8
XFILLER_168_553 VDD VSS sg13g2_decap_8
X_14350_ _14350_/Q clkload37/A _14350_/D _14350_/RESET_B VDD VSS sg13g2_dfrbpq_1
X_11562_ _11562_/Y _11560_/Y _11561_/Y _12292_/A VDD VSS sg13g2_a21oi_1
XFILLER_10_231 VDD VSS sg13g2_decap_8
XFILLER_128_417 VDD VSS sg13g2_decap_8
XFILLER_7_714 VDD VSS sg13g2_decap_8
X_13301_ _13302_/B _07744_/C _13300_/Y _15058_/Q VDD VSS sg13g2_o21ai_1
X_10513_ _10514_/C _14854_/Q _14853_/Q _14852_/Q _10513_/D VDD VSS sg13g2_and4_1
X_14281_ _14281_/Q clkload19/A _14281_/D _14281_/RESET_B VDD VSS sg13g2_dfrbpq_1
XFILLER_13_1232 VDD VSS sg13g2_decap_8
XFILLER_156_759 VDD VSS sg13g2_fill_2
X_11493_ _11493_/X _13954_/Q _13986_/Q _14018_/Q _14050_/Q _11493_/S0 _11493_/S1 VDD
+ VSS sg13g2_mux4_1
XFILLER_11_798 VDD VSS sg13g2_decap_8
XFILLER_6_224 VDD VSS sg13g2_decap_8
X_13232_ _13232_/Y _13232_/A _13244_/B VDD VSS sg13g2_xnor2_1
X_10444_ _14837_/D _10444_/A _10444_/B _10557_/C VDD VSS sg13g2_and3_1
XFILLER_100_1224 VDD VSS sg13g2_fill_1
XFILLER_124_601 VDD VSS sg13g2_decap_8
XFILLER_152_910 VDD VSS sg13g2_decap_8
XFILLER_137_995 VDD VSS sg13g2_decap_4
XFILLER_170_217 VDD VSS sg13g2_decap_8
XFILLER_100_1246 VDD VSS sg13g2_fill_2
XFILLER_108_174 VDD VSS sg13g2_decap_4
XFILLER_152_932 VDD VSS sg13g2_decap_8
XFILLER_136_483 VDD VSS sg13g2_fill_2
X_13163_ _13163_/Y _14822_/Q _13068_/B _13082_/B VDD VSS sg13g2_a21oi_1
XFILLER_174_1314 VDD VSS sg13g2_decap_8
XFILLER_163_280 VDD VSS sg13g2_decap_8
X_10375_ _14816_/D _10375_/A _10375_/B _10630_/C VDD VSS sg13g2_and3_1
XFILLER_48_1328 VDD VSS sg13g2_decap_8
XFILLER_3_931 VDD VSS sg13g2_decap_8
XFILLER_174_1325 VDD VSS sg13g2_decap_8
XFILLER_156_84 VDD VSS sg13g2_decap_8
X_12114_ _12114_/X _14708_/Q _14740_/Q _13780_/Q _13812_/Q _12316_/S0 _12091_/C VDD
+ VSS sg13g2_mux4_1
XFILLER_97_507 VDD VSS sg13g2_fill_2
XFILLER_2_441 VDD VSS sg13g2_decap_8
X_13094_ _13094_/Y _14817_/Q _13068_/B _13150_/B _14849_/Q VDD VSS sg13g2_a22oi_1
XFILLER_123_177 VDD VSS sg13g2_decap_8
XFILLER_78_710 VDD VSS sg13g2_decap_8
XFILLER_46_1041 VDD VSS sg13g2_decap_8
XFILLER_105_892 VDD VSS sg13g2_fill_2
XFILLER_111_339 VDD VSS sg13g2_decap_4
X_12045_ _12046_/B _12034_/Y _12036_/X _12048_/A1 VDD VSS sg13g2_o21ai_1
XFILLER_49_93 VDD VSS sg13g2_decap_8
XFILLER_46_1096 VDD VSS sg13g2_decap_8
XFILLER_24_1372 VDD VSS sg13g2_decap_8
XFILLER_168_1107 VDD VSS sg13g2_decap_8
XFILLER_1_56 VDD VSS sg13g2_decap_8
XFILLER_81_908 VDD VSS sg13g2_decap_8
XFILLER_111_1342 VDD VSS sg13g2_fill_1
X_13996_ _13996_/Q clkload14/A _13996_/D _13996_/RESET_B VDD VSS sg13g2_dfrbpq_1
XFILLER_20_1225 VDD VSS sg13g2_decap_8
XFILLER_19_854 VDD VSS sg13g2_decap_8
XFILLER_111_1353 VDD VSS sg13g2_fill_1
XFILLER_92_256 VDD VSS sg13g2_decap_8
X_12947_ _12947_/Y _14872_/Q _13013_/B VDD VSS sg13g2_nand2_1
XFILLER_74_982 VDD VSS sg13g2_decap_8
XFILLER_18_364 VDD VSS sg13g2_decap_8
XFILLER_65_92 VDD VSS sg13g2_fill_1
XFILLER_60_120 VDD VSS sg13g2_decap_8
XFILLER_45_194 VDD VSS sg13g2_decap_8
XFILLER_2_1190 VDD VSS sg13g2_decap_8
X_12878_ _12878_/Y _12878_/A _12878_/B _12878_/C _12878_/D VDD VSS sg13g2_nand4_1
XFILLER_33_356 VDD VSS sg13g2_decap_8
X_14617_ _14617_/Q _14649_/CLK _14617_/D _14617_/RESET_B VDD VSS sg13g2_dfrbpq_1
XFILLER_21_518 VDD VSS sg13g2_decap_8
X_11829_ _11829_/X _11875_/B _11828_/X _11827_/Y VDD VSS sg13g2_a21o_1
XFILLER_57_1181 VDD VSS sg13g2_decap_8
XFILLER_14_581 VDD VSS sg13g2_decap_8
XFILLER_53_1034 VDD VSS sg13g2_fill_1
XFILLER_144_1173 VDD VSS sg13g2_fill_2
X_14548_ _14548_/Q _14644_/CLK _14548_/D _14548_/RESET_B VDD VSS sg13g2_dfrbpq_1
XFILLER_18_1176 VDD VSS sg13g2_decap_8
XFILLER_144_1184 VDD VSS sg13g2_decap_8
XFILLER_14_1029 VDD VSS sg13g2_decap_8
XFILLER_105_1157 VDD VSS sg13g2_decap_8
XFILLER_147_759 VDD VSS sg13g2_decap_8
X_14479_ _14479_/Q clkload8/A _14479_/D _14479_/RESET_B VDD VSS sg13g2_dfrbpq_1
XFILLER_88_1119 VDD VSS sg13g2_decap_8
XFILLER_128_962 VDD VSS sg13g2_decap_8
XFILLER_128_973 VDD VSS sg13g2_fill_1
XFILLER_31_1365 VDD VSS sg13g2_decap_8
XFILLER_143_910 VDD VSS sg13g2_fill_1
XFILLER_155_770 VDD VSS sg13g2_decap_8
XFILLER_161_217 VDD VSS sg13g2_decap_8
XFILLER_155_781 VDD VSS sg13g2_fill_1
XFILLER_6_791 VDD VSS sg13g2_decap_8
XFILLER_115_645 VDD VSS sg13g2_decap_8
XFILLER_170_740 VDD VSS sg13g2_decap_8
XFILLER_143_976 VDD VSS sg13g2_fill_2
XFILLER_46_0 VDD VSS sg13g2_decap_8
X_08971_ _08971_/X _15022_/Q _15219_/Q _09009_/S VDD VSS sg13g2_mux2_1
XFILLER_130_626 VDD VSS sg13g2_decap_8
XFILLER_29_1261 VDD VSS sg13g2_decap_8
XFILLER_69_732 VDD VSS sg13g2_decap_8
X_07922_ _07922_/Y _07905_/A _07920_/Y _07910_/Y VDD VSS sg13g2_o21ai_1
XFILLER_9_1344 VDD VSS sg13g2_decap_8
XFILLER_69_743 VDD VSS sg13g2_decap_8
XFILLER_116_1253 VDD VSS sg13g2_decap_8
XFILLER_111_873 VDD VSS sg13g2_decap_8
X_07853_ _07855_/B _15015_/Q _07853_/B VDD VSS sg13g2_and2_1
XFILLER_96_562 VDD VSS sg13g2_fill_1
XFILLER_68_253 VDD VSS sg13g2_decap_4
XFILLER_60_1049 VDD VSS sg13g2_fill_2
XFILLER_96_584 VDD VSS sg13g2_decap_8
XFILLER_25_1169 VDD VSS sg13g2_decap_8
XFILLER_99_1237 VDD VSS sg13g2_decap_8
XFILLER_84_746 VDD VSS sg13g2_decap_4
X_07784_ _08414_/D _08411_/A _07784_/B VDD VSS sg13g2_or2_1
X_14991__2596 _14991_/RESET_B VDD VSS sg13g2_tiehi
XFILLER_72_919 VDD VSS sg13g2_decap_8
X_09523_ _14122_/D _09622_/A0 _14122_/Q _09533_/S VDD VSS sg13g2_mux2_1
XFILLER_37_673 VDD VSS sg13g2_decap_8
XFILLER_71_429 VDD VSS sg13g2_decap_8
XFILLER_24_301 VDD VSS sg13g2_decap_8
XFILLER_92_790 VDD VSS sg13g2_decap_8
XFILLER_80_930 VDD VSS sg13g2_decap_4
XFILLER_149_1062 VDD VSS sg13g2_decap_8
X_09454_ _14055_/D _09984_/A0 _14055_/Q _09469_/S VDD VSS sg13g2_mux2_1
XFILLER_24_334 VDD VSS sg13g2_decap_8
X_14394__1785 _14394_/RESET_B VDD VSS sg13g2_tiehi
X_08405_ _08406_/A _11726_/A _08405_/A1 _07946_/B _11706_/A _08635_/S1 _08048_/A VDD
+ VSS sg13g2_mux4_1
XFILLER_12_518 VDD VSS sg13g2_decap_8
X_09385_ _13988_/D _10147_/A1 _13988_/Q _09403_/S VDD VSS sg13g2_mux2_1
XFILLER_75_1270 VDD VSS sg13g2_decap_4
XFILLER_71_1112 VDD VSS sg13g2_decap_4
XFILLER_61_28 VDD VSS sg13g2_decap_8
X_15240__3008 _15240_/RESET_B VDD VSS sg13g2_tiehi
XFILLER_127_1371 VDD VSS sg13g2_decap_4
X_08336_ _08336_/Y _08560_/A _08169_/Y _08241_/Y VDD VSS sg13g2_o21ai_1
XFILLER_71_1145 VDD VSS sg13g2_fill_1
XFILLER_162_1295 VDD VSS sg13g2_decap_8
X_08267_ _08268_/B _08266_/Y _08265_/X _08263_/Y _08264_/Y VDD VSS sg13g2_a22oi_1
XFILLER_71_1189 VDD VSS sg13g2_fill_2
XFILLER_124_7 VDD VSS sg13g2_decap_8
X_14014__2165 _14014_/RESET_B VDD VSS sg13g2_tiehi
XFILLER_153_707 VDD VSS sg13g2_decap_8
XFILLER_20_595 VDD VSS sg13g2_decap_8
XFILLER_165_567 VDD VSS sg13g2_decap_8
X_08198_ _08198_/X _08086_/B _08094_/X _08452_/D VDD VSS sg13g2_mux2_1
XFILLER_4_728 VDD VSS sg13g2_decap_8
XFILLER_106_634 VDD VSS sg13g2_fill_2
XFILLER_10_21 VDD VSS sg13g2_decap_8
XFILLER_106_645 VDD VSS sg13g2_decap_8
XFILLER_3_238 VDD VSS sg13g2_decap_8
XFILLER_134_965 VDD VSS sg13g2_decap_8
XFILLER_161_751 VDD VSS sg13g2_decap_4
XFILLER_126_21 VDD VSS sg13g2_decap_8
X_10160_ _14737_/D _14737_/Q _10160_/A1 _10160_/S VDD VSS sg13g2_mux2_1
XFILLER_134_998 VDD VSS sg13g2_decap_8
XFILLER_0_912 VDD VSS sg13g2_decap_8
XFILLER_133_475 VDD VSS sg13g2_fill_1
XFILLER_47_1350 VDD VSS sg13g2_decap_8
XFILLER_10_98 VDD VSS sg13g2_decap_8
Xfanout1006 _09140_/S _09072_/B VDD VSS sg13g2_buf_1
X_13882__2297 _13882_/RESET_B VDD VSS sg13g2_tiehi
Xfanout1017 _10697_/B _15058_/Q VDD VSS sg13g2_buf_1
X_10091_ _14671_/D _10091_/A0 _14671_/Q _10093_/S VDD VSS sg13g2_mux2_1
Xfanout1028 _08383_/B _15004_/Q VDD VSS sg13g2_buf_1
XFILLER_87_540 VDD VSS sg13g2_decap_8
XFILLER_59_231 VDD VSS sg13g2_decap_8
Xfanout1039 _07911_/A _08668_/A VDD VSS sg13g2_buf_1
XFILLER_87_551 VDD VSS sg13g2_fill_1
XFILLER_82_1285 VDD VSS sg13g2_fill_1
XFILLER_0_989 VDD VSS sg13g2_decap_8
XFILLER_134_1364 VDD VSS sg13g2_fill_2
XFILLER_102_873 VDD VSS sg13g2_decap_8
XFILLER_48_938 VDD VSS sg13g2_decap_8
XFILLER_19_63 VDD VSS sg13g2_decap_8
X_13850_ _13850_/Q _14746_/CLK _13850_/D _13850_/RESET_B VDD VSS sg13g2_dfrbpq_1
X_12801_ _12801_/Y _13609_/A _12801_/B VDD VSS sg13g2_nor2_1
XFILLER_90_716 VDD VSS sg13g2_decap_8
X_13781_ _13781_/Q clkload18/A _13781_/D _13781_/RESET_B VDD VSS sg13g2_dfrbpq_1
X_10993_ _10996_/B _10995_/A _10995_/C _10995_/B VDD VSS sg13g2_o21ai_1
XFILLER_90_738 VDD VSS sg13g2_decap_8
XFILLER_15_301 VDD VSS sg13g2_decap_8
XFILLER_43_610 VDD VSS sg13g2_decap_8
XFILLER_27_161 VDD VSS sg13g2_decap_8
XFILLER_28_695 VDD VSS sg13g2_fill_2
XFILLER_76_1034 VDD VSS sg13g2_decap_8
XFILLER_43_632 VDD VSS sg13g2_decap_8
XFILLER_128_1113 VDD VSS sg13g2_decap_4
X_12732_ _12732_/X _12731_/X _12730_/X _12724_/X _12725_/X _12760_/S0 _12762_/S VDD
+ VSS sg13g2_mux4_1
XFILLER_76_1045 VDD VSS sg13g2_fill_2
XFILLER_16_868 VDD VSS sg13g2_decap_8
XFILLER_150_0 VDD VSS sg13g2_decap_8
X_14224__1955 _14224_/RESET_B VDD VSS sg13g2_tiehi
XFILLER_70_462 VDD VSS sg13g2_fill_1
XFILLER_35_84 VDD VSS sg13g2_decap_8
XFILLER_15_378 VDD VSS sg13g2_decap_8
X_12663_ _12663_/X _12657_/X _12661_/X _12656_/X _12660_/X _12663_/S0 _12663_/S1 VDD
+ VSS sg13g2_mux4_1
XFILLER_93_1370 VDD VSS sg13g2_decap_4
XFILLER_42_164 VDD VSS sg13g2_decap_8
XFILLER_35_95 VDD VSS sg13g2_fill_1
XFILLER_31_838 VDD VSS sg13g2_decap_8
XFILLER_169_862 VDD VSS sg13g2_decap_8
X_14402_ _14402_/Q clkload25/A _14402_/D _14402_/RESET_B VDD VSS sg13g2_dfrbpq_1
X_11614_ _11615_/A _14246_/Q _14278_/Q _14310_/Q _14342_/Q _11597_/A _11760_/C VDD
+ VSS sg13g2_mux4_1
XFILLER_15_1316 VDD VSS sg13g2_decap_8
XFILLER_168_350 VDD VSS sg13g2_decap_8
X_12594_ _12594_/X _12590_/X _12589_/X _12586_/X _12585_/X _12705_/S0 _12567_/S VDD
+ VSS sg13g2_mux4_1
XFILLER_54_1376 VDD VSS sg13g2_fill_1
XFILLER_129_726 VDD VSS sg13g2_decap_4
X_14333_ _14333_/Q clkload45/A _14333_/D _14333_/RESET_B VDD VSS sg13g2_dfrbpq_1
X_15119__2721 _15119_/RESET_B VDD VSS sg13g2_tiehi
XFILLER_7_511 VDD VSS sg13g2_decap_8
XFILLER_129_759 VDD VSS sg13g2_fill_2
X_11545_ _11545_/Y _12014_/S _14468_/Q VDD VSS sg13g2_nand2b_1
XFILLER_11_595 VDD VSS sg13g2_decap_8
X_14264_ _14264_/Q _14979_/CLK _14264_/D _14264_/RESET_B VDD VSS sg13g2_dfrbpq_1
X_11476_ _11476_/X _11473_/X _11472_/X _11468_/X _11469_/X _12214_/B _11446_/A VDD
+ VSS sg13g2_mux4_1
XFILLER_137_770 VDD VSS sg13g2_decap_8
XFILLER_109_472 VDD VSS sg13g2_decap_4
XFILLER_7_588 VDD VSS sg13g2_decap_8
XFILLER_100_1032 VDD VSS sg13g2_decap_8
XFILLER_171_537 VDD VSS sg13g2_decap_8
X_13215_ _13216_/B _13215_/A _13215_/B VDD VSS sg13g2_xnor2_1
X_10427_ _14831_/D _14831_/Q _10453_/C _10426_/Y VDD VSS sg13g2_a21oi_1
X_14195_ _14195_/Q _14660_/CLK _14195_/D _14195_/RESET_B VDD VSS sg13g2_dfrbpq_1
XFILLER_125_965 VDD VSS sg13g2_fill_2
X_13146_ _13148_/B _13146_/A _13146_/B _13146_/C VDD VSS sg13g2_nand3_1
X_10358_ _10400_/B _14809_/Q _14810_/Q _10358_/C VDD VSS sg13g2_nand3_1
X_14169__2010 _14169_/RESET_B VDD VSS sg13g2_tiehi
XFILLER_98_838 VDD VSS sg13g2_decap_8
XFILLER_111_103 VDD VSS sg13g2_decap_8
XFILLER_124_486 VDD VSS sg13g2_decap_8
XFILLER_135_1128 VDD VSS sg13g2_decap_8
XFILLER_139_1297 VDD VSS sg13g2_decap_8
X_13077_ _13077_/X _14910_/Q _13677_/Q _13172_/B VDD VSS sg13g2_and3_1
X_13712__2467 _13712_/RESET_B VDD VSS sg13g2_tiehi
X_10289_ _14790_/D _10281_/D _10298_/D _10284_/Y _10297_/A _10306_/B VDD VSS sg13g2_a221oi_1
X_12028_ _12029_/A _13746_/Q _14098_/Q _14450_/Q _14546_/Q _12014_/S _12018_/C VDD
+ VSS sg13g2_mux4_1
XFILLER_65_223 VDD VSS sg13g2_fill_1
XFILLER_54_919 VDD VSS sg13g2_decap_8
XFILLER_20_1022 VDD VSS sg13g2_decap_8
XFILLER_19_651 VDD VSS sg13g2_decap_8
XFILLER_4_1274 VDD VSS sg13g2_decap_8
X_13979_ _13979_/Q clkload40/A _13979_/D _13979_/RESET_B VDD VSS sg13g2_dfrbpq_1
XFILLER_59_1232 VDD VSS sg13g2_decap_8
XFILLER_18_161 VDD VSS sg13g2_decap_8
XFILLER_55_1107 VDD VSS sg13g2_fill_1
XFILLER_20_1099 VDD VSS sg13g2_decap_8
XFILLER_22_827 VDD VSS sg13g2_decap_8
XFILLER_21_315 VDD VSS sg13g2_decap_8
X_14976__2611 _14976_/RESET_B VDD VSS sg13g2_tiehi
X_09170_ wire378/A _09839_/C _10137_/B _09938_/D VDD VSS sg13g2_nor3_1
XFILLER_159_350 VDD VSS sg13g2_decap_8
XFILLER_109_1090 VDD VSS sg13g2_decap_8
XFILLER_147_523 VDD VSS sg13g2_fill_1
X_08121_ _08121_/X _08598_/A3 _08620_/A3 _08620_/A2 _08620_/A1 _08009_/S _08124_/S1
+ VDD VSS sg13g2_mux4_1
XFILLER_30_871 VDD VSS sg13g2_decap_8
XFILLER_174_342 VDD VSS sg13g2_decap_4
X_14379__1800 _14379_/RESET_B VDD VSS sg13g2_tiehi
XFILLER_135_718 VDD VSS sg13g2_fill_1
X_08052_ _08052_/Y _08079_/S _08047_/Y _08048_/Y _08051_/Y VDD VSS sg13g2_a22oi_1
XFILLER_116_910 VDD VSS sg13g2_fill_2
XFILLER_128_770 VDD VSS sg13g2_decap_4
XFILLER_31_1162 VDD VSS sg13g2_decap_8
XFILLER_116_921 VDD VSS sg13g2_fill_1
XFILLER_162_537 VDD VSS sg13g2_decap_8
XFILLER_157_1320 VDD VSS sg13g2_decap_8
XFILLER_89_805 VDD VSS sg13g2_decap_8
XFILLER_103_604 VDD VSS sg13g2_decap_8
XFILLER_131_913 VDD VSS sg13g2_fill_1
Xhold3103 _13642_/A _13750_/Q VDD VSS sg13g2_dlygate4sd3_1
XFILLER_143_784 VDD VSS sg13g2_decap_8
Xhold3114 _13635_/A _13743_/Q VDD VSS sg13g2_dlygate4sd3_1
XFILLER_170_581 VDD VSS sg13g2_decap_8
Xhold3125 _13625_/A _13733_/Q VDD VSS sg13g2_dlygate4sd3_1
Xhold3136 _11170_/A _14954_/Q VDD VSS sg13g2_dlygate4sd3_1
XFILLER_102_125 VDD VSS sg13g2_fill_2
Xhold3147 _10796_/A _14926_/Q VDD VSS sg13g2_dlygate4sd3_1
Xhold3158 _13590_/A _15162_/Q VDD VSS sg13g2_dlygate4sd3_1
X_08954_ _08954_/X _15052_/Q _14956_/Q _10720_/A VDD VSS sg13g2_mux2_1
XFILLER_131_979 VDD VSS sg13g2_fill_2
XFILLER_9_1141 VDD VSS sg13g2_decap_8
X_14302__1877 _14302_/RESET_B VDD VSS sg13g2_tiehi
Xhold3169 hold3169/X _14894_/Q VDD VSS sg13g2_dlygate4sd3_1
XFILLER_130_467 VDD VSS sg13g2_fill_1
XFILLER_116_1050 VDD VSS sg13g2_fill_2
X_07905_ _07906_/C _07905_/A _07905_/B _07905_/C _07905_/D VDD VSS sg13g2_nor4_1
XFILLER_116_1072 VDD VSS sg13g2_decap_8
X_08885_ _08885_/Y _10720_/A _14939_/Q VDD VSS sg13g2_nand2_1
XFILLER_69_584 VDD VSS sg13g2_decap_8
XFILLER_56_28 VDD VSS sg13g2_decap_8
X_07836_ _08697_/B _15019_/Q _08673_/B VDD VSS sg13g2_nand2b_1
X_13867__2312 _13867_/RESET_B VDD VSS sg13g2_tiehi
X_07767_ _08265_/A _07929_/B _08263_/B VDD VSS sg13g2_nor2_1
XFILLER_71_215 VDD VSS sg13g2_fill_1
XFILLER_37_470 VDD VSS sg13g2_decap_8
XFILLER_25_610 VDD VSS sg13g2_decap_8
XFILLER_72_749 VDD VSS sg13g2_decap_8
XFILLER_25_621 VDD VSS sg13g2_fill_1
X_09506_ _14106_/D _09970_/A1 _14106_/Q _09506_/S VDD VSS sg13g2_mux2_1
X_07698_ _07700_/B _15083_/Q _07701_/B VDD VSS sg13g2_nand2_1
XFILLER_77_1365 VDD VSS sg13g2_decap_8
XFILLER_52_440 VDD VSS sg13g2_fill_2
XFILLER_112_89 VDD VSS sg13g2_fill_2
XFILLER_13_805 VDD VSS sg13g2_decap_8
XFILLER_73_1229 VDD VSS sg13g2_fill_1
XFILLER_72_49 VDD VSS sg13g2_decap_8
XFILLER_25_676 VDD VSS sg13g2_decap_8
X_09437_ _14039_/D _10166_/A1 _14039_/Q _09439_/S VDD VSS sg13g2_mux2_1
XFILLER_25_687 VDD VSS sg13g2_fill_1
XFILLER_12_315 VDD VSS sg13g2_decap_8
XFILLER_25_698 VDD VSS sg13g2_decap_8
XFILLER_24_175 VDD VSS sg13g2_decap_8
XFILLER_169_147 VDD VSS sg13g2_decap_8
X_14771__2942 _14771_/RESET_B VDD VSS sg13g2_tiehi
X_09368_ _13972_/D _09632_/A0 _13972_/Q _09368_/S VDD VSS sg13g2_mux2_1
XFILLER_8_308 VDD VSS sg13g2_decap_8
XFILLER_36_1084 VDD VSS sg13g2_fill_2
X_08319_ _08420_/A _08319_/A _08319_/B _08319_/C VDD VSS sg13g2_nor3_1
XFILLER_21_882 VDD VSS sg13g2_decap_8
X_15100__2771 _15100_/RESET_B VDD VSS sg13g2_tiehi
X_09299_ _13907_/D _13907_/Q _09332_/A0 _09305_/S VDD VSS sg13g2_mux2_1
XFILLER_166_865 VDD VSS sg13g2_decap_8
X_11330_ _11330_/X _11321_/Y _11329_/Y _11378_/S VDD VSS sg13g2_mux2_1
XFILLER_20_392 VDD VSS sg13g2_decap_8
XFILLER_165_364 VDD VSS sg13g2_decap_8
XFILLER_125_206 VDD VSS sg13g2_decap_4
XFILLER_21_42 VDD VSS sg13g2_decap_8
XFILLER_158_1117 VDD VSS sg13g2_decap_4
XFILLER_153_537 VDD VSS sg13g2_decap_8
XFILLER_4_525 VDD VSS sg13g2_decap_8
XFILLER_137_42 VDD VSS sg13g2_decap_8
X_11261_ _11262_/A _12326_/A1 _13884_/Q VDD VSS sg13g2_nand2b_1
XFILLER_10_1246 VDD VSS sg13g2_decap_8
X_15107__2747 _15107_/RESET_B VDD VSS sg13g2_tiehi
X_13000_ _13000_/Y _14811_/Q _13014_/A2 _07727_/B _10511_/D VDD VSS sg13g2_a22oi_1
X_10212_ _14763_/D _13600_/C _10209_/B hold3097/X VDD VSS sg13g2_a21oi_1
XFILLER_107_987 VDD VSS sg13g2_decap_8
XFILLER_84_1336 VDD VSS sg13g2_decap_8
XFILLER_133_250 VDD VSS sg13g2_decap_8
X_11192_ _11192_/X _11191_/Y _11189_/Y _11207_/A2 VDD VSS sg13g2_a21o_1
XFILLER_171_1306 VDD VSS sg13g2_decap_8
XFILLER_79_326 VDD VSS sg13g2_decap_8
XFILLER_122_946 VDD VSS sg13g2_decap_4
X_10143_ _14720_/D _14720_/Q _10143_/A1 _10168_/S VDD VSS sg13g2_mux2_1
X_15148__2661 _15148_/RESET_B VDD VSS sg13g2_tiehi
XFILLER_134_1150 VDD VSS sg13g2_fill_2
X_14951_ _14951_/Q clkload54/A _14951_/D _14951_/RESET_B VDD VSS sg13g2_dfrbpq_1
X_10074_ _14654_/D _10074_/A0 _14654_/Q _10096_/S VDD VSS sg13g2_mux2_1
XFILLER_0_786 VDD VSS sg13g2_decap_8
XFILLER_153_63 VDD VSS sg13g2_decap_8
XFILLER_134_1183 VDD VSS sg13g2_decap_8
XFILLER_87_381 VDD VSS sg13g2_decap_8
X_13902_ _13902_/Q _14734_/CLK _13902_/D _13902_/RESET_B VDD VSS sg13g2_dfrbpq_1
X_14882_ _14882_/Q clkload45/A _14882_/D _14882_/RESET_B VDD VSS sg13g2_dfrbpq_1
XFILLER_36_919 VDD VSS sg13g2_decap_4
XFILLER_78_1129 VDD VSS sg13g2_decap_4
X_13833_ _13833_/Q clkload20/A _13833_/D _13833_/RESET_B VDD VSS sg13g2_dfrbpq_1
XFILLER_62_204 VDD VSS sg13g2_decap_8
XFILLER_47_278 VDD VSS sg13g2_decap_4
XFILLER_75_598 VDD VSS sg13g2_decap_8
XFILLER_169_1268 VDD VSS sg13g2_decap_8
XFILLER_63_749 VDD VSS sg13g2_decap_4
XFILLER_28_470 VDD VSS sg13g2_decap_8
X_14457__1722 _14457_/RESET_B VDD VSS sg13g2_tiehi
X_13764_ _13764_/Q clkload17/A _13764_/D _13764_/RESET_B VDD VSS sg13g2_dfrbpq_1
XFILLER_90_568 VDD VSS sg13g2_decap_8
X_10976_ _11009_/B _14759_/Q _10722_/Y _10942_/Y VDD VSS sg13g2_a21o_1
XFILLER_16_665 VDD VSS sg13g2_decap_8
X_12715_ _12715_/X _13973_/Q _14005_/Q _14037_/Q _14069_/Q _12715_/S0 _12715_/S1 VDD
+ VSS sg13g2_mux4_1
XFILLER_31_624 VDD VSS sg13g2_decap_8
XFILLER_15_175 VDD VSS sg13g2_decap_8
X_13695_ _16857_/A clkload61/A _13695_/D _13695_/RESET_B VDD VSS sg13g2_dfrbpq_1
XFILLER_43_484 VDD VSS sg13g2_decap_8
XFILLER_19_1260 VDD VSS sg13g2_decap_8
X_12646_ _12646_/X _14128_/Q _14160_/Q _14192_/Q _14224_/Q _12658_/S0 _12658_/S1 VDD
+ VSS sg13g2_mux4_1
XFILLER_141_1110 VDD VSS sg13g2_fill_1
XFILLER_157_810 VDD VSS sg13g2_fill_2
XFILLER_15_1113 VDD VSS sg13g2_decap_8
XFILLER_87_7 VDD VSS sg13g2_decap_8
XFILLER_12_882 VDD VSS sg13g2_decap_8
X_12577_ _12577_/X _14379_/Q _14411_/Q _14475_/Q _14507_/Q _12601_/S0 _12601_/S1 VDD
+ VSS sg13g2_mux4_1
XFILLER_102_1116 VDD VSS sg13g2_decap_8
XFILLER_106_1296 VDD VSS sg13g2_decap_8
XFILLER_117_718 VDD VSS sg13g2_decap_8
XFILLER_11_392 VDD VSS sg13g2_decap_8
X_14316_ _14316_/Q clkload35/A _14316_/D _14316_/RESET_B VDD VSS sg13g2_dfrbpq_1
X_11528_ _11528_/X _14116_/Q _14148_/Q _12014_/S VDD VSS sg13g2_mux2_1
XFILLER_8_875 VDD VSS sg13g2_decap_8
XFILLER_144_515 VDD VSS sg13g2_fill_2
XFILLER_7_77 VDD VSS sg13g2_decap_8
XFILLER_7_385 VDD VSS sg13g2_decap_8
XFILLER_144_559 VDD VSS sg13g2_fill_2
X_14247_ _14247_/Q _14735_/CLK _14247_/D _14247_/RESET_B VDD VSS sg13g2_dfrbpq_1
XFILLER_171_334 VDD VSS sg13g2_decap_8
X_11459_ _11459_/Y _11457_/Y _11458_/Y _11451_/Y _11458_/A _11248_/B VDD VSS sg13g2_a221oi_1
XFILLER_125_762 VDD VSS sg13g2_fill_2
XFILLER_124_261 VDD VSS sg13g2_decap_8
X_13945__2234 _13945_/RESET_B VDD VSS sg13g2_tiehi
X_14178_ _14178_/Q clkload29/A _14178_/D _14178_/RESET_B VDD VSS sg13g2_dfrbpq_1
X_13129_ _13133_/C _14915_/Q _13129_/B VDD VSS sg13g2_xor2_1
XFILLER_112_456 VDD VSS sg13g2_decap_4
XFILLER_26_1231 VDD VSS sg13g2_decap_8
XFILLER_79_871 VDD VSS sg13g2_decap_8
XFILLER_65_1291 VDD VSS sg13g2_decap_8
XFILLER_117_1370 VDD VSS sg13g2_decap_4
XFILLER_38_212 VDD VSS sg13g2_decap_8
Xfanout1370 _10633_/A _10490_/A VDD VSS sg13g2_buf_1
XFILLER_6_1358 VDD VSS sg13g2_decap_8
XFILLER_113_1245 VDD VSS sg13g2_fill_1
X_08670_ _08670_/Y _08080_/Y _08012_/Y _08010_/Y _08669_/Y _08402_/C VDD VSS sg13g2_a221oi_1
XFILLER_22_1128 VDD VSS sg13g2_decap_8
XFILLER_113_1256 VDD VSS sg13g2_fill_1
Xfanout1381 _13328_/A _13198_/B1 VDD VSS sg13g2_buf_1
Xfanout1392 _10295_/C _10353_/C VDD VSS sg13g2_buf_1
XFILLER_113_1278 VDD VSS sg13g2_decap_8
X_07621_ _07621_/Y _14868_/Q VDD VSS sg13g2_inv_1
XFILLER_81_524 VDD VSS sg13g2_decap_4
XFILLER_4_1071 VDD VSS sg13g2_decap_8
XFILLER_93_395 VDD VSS sg13g2_decap_8
XFILLER_47_790 VDD VSS sg13g2_fill_2
XFILLER_146_1021 VDD VSS sg13g2_fill_2
XFILLER_59_1084 VDD VSS sg13g2_decap_8
XFILLER_59_1095 VDD VSS sg13g2_fill_1
XFILLER_21_112 VDD VSS sg13g2_decap_8
X_09222_ _13833_/D _09920_/A1 _13833_/Q _09238_/S VDD VSS sg13g2_mux2_1
X_14925__2694 _14925_/RESET_B VDD VSS sg13g2_tiehi
XFILLER_37_1371 VDD VSS sg13g2_decap_8
XFILLER_10_819 VDD VSS sg13g2_decap_8
XFILLER_50_988 VDD VSS sg13g2_decap_4
X_09153_ _13784_/D _13784_/Q _10167_/A1 _09153_/S VDD VSS sg13g2_mux2_1
XFILLER_124_1363 VDD VSS sg13g2_fill_1
XFILLER_33_1246 VDD VSS sg13g2_decap_8
XFILLER_21_189 VDD VSS sg13g2_decap_8
X_08104_ _08104_/Y _08201_/A wire660/X _08104_/C _08104_/D VDD VSS sg13g2_nor4_1
XFILLER_30_690 VDD VSS sg13g2_decap_8
X_09084_ _13774_/D _13774_/Q _09859_/A1 _09167_/S VDD VSS sg13g2_mux2_1
XFILLER_107_206 VDD VSS sg13g2_decap_4
XFILLER_163_835 VDD VSS sg13g2_fill_1
X_08035_ _08035_/X _08659_/A _08659_/B VDD VSS sg13g2_or2_1
XFILLER_162_334 VDD VSS sg13g2_decap_8
XFILLER_163_868 VDD VSS sg13g2_decap_8
XFILLER_174_18 VDD VSS sg13g2_decap_4
XFILLER_89_624 VDD VSS sg13g2_decap_8
X_14535__1644 _14535_/RESET_B VDD VSS sg13g2_tiehi
XFILLER_89_635 VDD VSS sg13g2_fill_1
XFILLER_153_1014 VDD VSS sg13g2_decap_8
XFILLER_1_539 VDD VSS sg13g2_decap_8
XFILLER_115_294 VDD VSS sg13g2_decap_4
XFILLER_131_765 VDD VSS sg13g2_decap_8
X_09986_ _14569_/D _10085_/A0 _14569_/Q _10002_/S VDD VSS sg13g2_mux2_1
XFILLER_88_156 VDD VSS sg13g2_decap_8
XFILLER_118_1178 VDD VSS sg13g2_decap_8
XFILLER_76_307 VDD VSS sg13g2_decap_8
XFILLER_67_49 VDD VSS sg13g2_decap_8
X_08937_ _08937_/X _08936_/X _12152_/A _08940_/S VDD VSS sg13g2_mux2_1
X_14789__2924 _14789_/RESET_B VDD VSS sg13g2_tiehi
XFILLER_131_1323 VDD VSS sg13g2_decap_8
X_08868_ _13700_/D _16862_/A _08867_/X _08892_/S VDD VSS sg13g2_mux2_1
XFILLER_29_245 VDD VSS sg13g2_decap_8
XFILLER_123_77 VDD VSS sg13g2_decap_8
X_07819_ _07822_/A _15009_/Q _07821_/B VDD VSS sg13g2_nor2_1
XFILLER_85_896 VDD VSS sg13g2_decap_8
XFILLER_84_373 VDD VSS sg13g2_fill_1
X_08799_ _13684_/D _08799_/A _08799_/B VDD VSS sg13g2_nor2_1
XFILLER_26_930 VDD VSS sg13g2_decap_8
X_10830_ _10830_/X _10831_/A _10831_/B _10831_/C VDD VSS sg13g2_a21o_1
XFILLER_16_42 VDD VSS sg13g2_decap_8
XFILLER_72_579 VDD VSS sg13g2_fill_1
XFILLER_13_602 VDD VSS sg13g2_decap_8
X_10761_ _14917_/D _11207_/B1 _11115_/A _10760_/Y VDD VSS sg13g2_o21ai_1
XFILLER_12_112 VDD VSS sg13g2_decap_8
XFILLER_158_607 VDD VSS sg13g2_decap_8
X_12500_ _12513_/A _10213_/A _07737_/B _08306_/B VDD VSS sg13g2_a21oi_1
XFILLER_129_1296 VDD VSS sg13g2_decap_4
XFILLER_164_1176 VDD VSS sg13g2_decap_8
X_13480_ _15114_/D _15180_/D _15114_/Q _13499_/A VDD VSS sg13g2_mux2_1
X_10692_ _10693_/A _14900_/Q _10862_/B _07753_/B _10870_/A VDD VSS sg13g2_a22oi_1
XFILLER_13_679 VDD VSS sg13g2_decap_8
XFILLER_8_105 VDD VSS sg13g2_decap_8
X_12431_ _12431_/X _14561_/Q _14593_/Q _14625_/Q _14657_/Q _12767_/S0 _12767_/S1 VDD
+ VSS sg13g2_mux4_1
XFILLER_12_189 VDD VSS sg13g2_decap_8
XFILLER_138_342 VDD VSS sg13g2_decap_8
XFILLER_166_651 VDD VSS sg13g2_decap_8
XFILLER_32_63 VDD VSS sg13g2_decap_8
X_15150_ _15150_/Q clkload68/A _15150_/D _15150_/RESET_B VDD VSS sg13g2_dfrbpq_1
X_12362_ _12362_/X _14364_/Q _14396_/Q _14460_/Q _14492_/Q _12783_/S0 _12783_/S1 VDD
+ VSS sg13g2_mux4_1
XFILLER_126_526 VDD VSS sg13g2_fill_2
XFILLER_148_63 VDD VSS sg13g2_decap_8
XFILLER_165_161 VDD VSS sg13g2_decap_8
XFILLER_5_812 VDD VSS sg13g2_decap_8
XFILLER_148_74 VDD VSS sg13g2_fill_2
XFILLER_113_0 VDD VSS sg13g2_decap_8
X_14101_ _14101_/Q _14677_/CLK _14101_/D _14101_/RESET_B VDD VSS sg13g2_dfrbpq_1
XFILLER_14_1190 VDD VSS sg13g2_decap_8
XFILLER_153_334 VDD VSS sg13g2_decap_8
X_11313_ _11313_/Y _11378_/S _11301_/Y _11312_/Y VDD VSS sg13g2_o21ai_1
X_15081_ _15081_/Q _15159_/CLK _15081_/D _15081_/RESET_B VDD VSS sg13g2_dfrbpq_1
X_12293_ _12293_/Y _12293_/A1 _12289_/X _12292_/Y VDD VSS sg13g2_o21ai_1
XFILLER_4_322 VDD VSS sg13g2_decap_8
XFILLER_10_1043 VDD VSS sg13g2_decap_8
X_14032_ _14032_/Q clkload7/A _14032_/D _14032_/RESET_B VDD VSS sg13g2_dfrbpq_1
X_11244_ _11245_/C _13293_/A _11243_/C _07687_/B VDD VSS sg13g2_a21oi_1
XFILLER_5_889 VDD VSS sg13g2_decap_8
XFILLER_122_710 VDD VSS sg13g2_fill_1
XFILLER_134_581 VDD VSS sg13g2_decap_8
XFILLER_4_399 VDD VSS sg13g2_decap_8
XFILLER_121_220 VDD VSS sg13g2_fill_1
X_11175_ _11175_/Y _11164_/B _11164_/C _11185_/A VDD VSS sg13g2_a21oi_1
XFILLER_171_1125 VDD VSS sg13g2_fill_1
XFILLER_121_231 VDD VSS sg13g2_fill_1
XFILLER_110_905 VDD VSS sg13g2_fill_1
XFILLER_164_84 VDD VSS sg13g2_decap_8
XFILLER_121_253 VDD VSS sg13g2_fill_2
XFILLER_84_1199 VDD VSS sg13g2_decap_8
X_10126_ _14704_/D _10159_/A1 _14704_/Q _10127_/S VDD VSS sg13g2_mux2_1
XFILLER_121_264 VDD VSS sg13g2_decap_8
XFILLER_171_1169 VDD VSS sg13g2_decap_8
XFILLER_48_510 VDD VSS sg13g2_decap_4
XFILLER_95_649 VDD VSS sg13g2_decap_4
X_14934_ _14934_/Q _15226_/CLK _14934_/D _14934_/RESET_B VDD VSS sg13g2_dfrbpq_1
X_10057_ _14638_/D _10090_/A0 _14638_/Q _10063_/S VDD VSS sg13g2_mux2_1
XFILLER_94_159 VDD VSS sg13g2_decap_4
XFILLER_75_351 VDD VSS sg13g2_decap_8
XFILLER_75_362 VDD VSS sg13g2_fill_1
XFILLER_48_576 VDD VSS sg13g2_decap_8
XFILLER_76_896 VDD VSS sg13g2_decap_8
XFILLER_75_373 VDD VSS sg13g2_decap_8
X_14865_ _14865_/Q _14867_/CLK _14865_/D _14865_/RESET_B VDD VSS sg13g2_dfrbpq_1
XFILLER_91_833 VDD VSS sg13g2_decap_8
XFILLER_63_524 VDD VSS sg13g2_decap_8
XFILLER_1_1211 VDD VSS sg13g2_decap_8
X_13816_ _13816_/Q _14744_/CLK _13816_/D _13816_/RESET_B VDD VSS sg13g2_dfrbpq_1
XFILLER_21_1183 VDD VSS sg13g2_decap_8
XFILLER_17_952 VDD VSS sg13g2_decap_8
XFILLER_91_877 VDD VSS sg13g2_decap_8
X_14796_ _14796_/Q _14868_/CLK _14796_/D _14796_/RESET_B VDD VSS sg13g2_dfrbpq_1
XFILLER_32_900 VDD VSS sg13g2_decap_8
XFILLER_16_462 VDD VSS sg13g2_decap_8
XFILLER_1_1288 VDD VSS sg13g2_decap_8
X_13747_ _13747_/Q clkload22/A _13747_/D _13747_/RESET_B VDD VSS sg13g2_dfrbpq_1
X_10959_ _10959_/Y _10959_/A _11170_/B VDD VSS sg13g2_nand2_1
XFILLER_73_92 VDD VSS sg13g2_decap_8
XFILLER_56_1257 VDD VSS sg13g2_decap_8
X_13678_ _13678_/Q _15213_/CLK _13678_/D _13678_/RESET_B VDD VSS sg13g2_dfrbpq_1
X_14613__1566 _14613_/RESET_B VDD VSS sg13g2_tiehi
X_12629_ _12629_/X _14255_/Q _14287_/Q _14319_/Q _14351_/Q _12633_/S0 _12633_/S1 VDD
+ VSS sg13g2_mux4_1
XFILLER_157_651 VDD VSS sg13g2_decap_8
XFILLER_106_1071 VDD VSS sg13g2_decap_8
XFILLER_89_1033 VDD VSS sg13g2_decap_8
XFILLER_8_672 VDD VSS sg13g2_decap_8
XFILLER_144_312 VDD VSS sg13g2_decap_8
XFILLER_145_846 VDD VSS sg13g2_decap_8
XFILLER_172_632 VDD VSS sg13g2_decap_8
XFILLER_7_182 VDD VSS sg13g2_decap_8
XFILLER_99_900 VDD VSS sg13g2_fill_2
XFILLER_171_175 VDD VSS sg13g2_decap_8
XFILLER_28_1315 VDD VSS sg13g2_decap_8
XFILLER_113_743 VDD VSS sg13g2_decap_8
Xfanout607 _10743_/S _08893_/A VDD VSS sg13g2_buf_1
X_09840_ _14427_/D _14427_/Q _10104_/A0 _09863_/S VDD VSS sg13g2_mux2_1
XFILLER_99_966 VDD VSS sg13g2_fill_2
Xfanout618 _08904_/S _08831_/Y VDD VSS sg13g2_buf_1
XFILLER_98_454 VDD VSS sg13g2_decap_8
XFILLER_101_905 VDD VSS sg13g2_decap_4
Xfanout629 _08001_/C _08238_/B VDD VSS sg13g2_buf_1
XFILLER_63_1239 VDD VSS sg13g2_decap_8
X_09771_ _14361_/D _14361_/Q _09936_/A1 _09771_/S VDD VSS sg13g2_mux2_1
XFILLER_86_649 VDD VSS sg13g2_decap_8
XFILLER_39_532 VDD VSS sg13g2_decap_4
X_08722_ _15214_/D _08721_/X _12347_/B _13655_/S VDD VSS sg13g2_mux2_1
XFILLER_6_1155 VDD VSS sg13g2_decap_8
XFILLER_113_1042 VDD VSS sg13g2_decap_8
XFILLER_2_1008 VDD VSS sg13g2_decap_8
X_08653_ _08661_/B _08672_/A _08653_/B _15018_/Q VDD VSS sg13g2_nand3_1
XFILLER_96_1015 VDD VSS sg13g2_fill_2
XFILLER_94_682 VDD VSS sg13g2_fill_2
X_15071__2863 _15071_/RESET_B VDD VSS sg13g2_tiehi
XFILLER_94_693 VDD VSS sg13g2_fill_2
XFILLER_66_384 VDD VSS sg13g2_fill_1
XFILLER_54_524 VDD VSS sg13g2_fill_2
XFILLER_93_181 VDD VSS sg13g2_fill_2
XFILLER_148_1127 VDD VSS sg13g2_decap_8
XFILLER_26_259 VDD VSS sg13g2_decap_8
X_08584_ _08584_/Y _08663_/B _08608_/A VDD VSS sg13g2_nor2_1
XFILLER_54_579 VDD VSS sg13g2_fill_1
X_15132__2693 _15132_/RESET_B VDD VSS sg13g2_tiehi
XFILLER_35_793 VDD VSS sg13g2_decap_4
XFILLER_34_270 VDD VSS sg13g2_decap_8
XFILLER_168_949 VDD VSS sg13g2_decap_8
XFILLER_10_616 VDD VSS sg13g2_decap_8
XFILLER_22_476 VDD VSS sg13g2_decap_8
XFILLER_139_139 VDD VSS sg13g2_decap_8
XFILLER_167_448 VDD VSS sg13g2_decap_8
X_09205_ _09307_/B _09640_/C _09640_/B _09839_/C VDD VSS sg13g2_nand3b_1
XFILLER_72_1081 VDD VSS sg13g2_decap_8
XFILLER_6_609 VDD VSS sg13g2_decap_8
XFILLER_148_673 VDD VSS sg13g2_fill_1
X_09136_ _09137_/C _13142_/A _09136_/B _09150_/C _09164_/C VDD VSS sg13g2_and4_1
XFILLER_136_824 VDD VSS sg13g2_decap_8
XFILLER_5_119 VDD VSS sg13g2_decap_8
XFILLER_11_1330 VDD VSS sg13g2_decap_8
XFILLER_135_323 VDD VSS sg13g2_fill_2
X_09067_ _09069_/B _13064_/A _09089_/C _14911_/Q VDD VSS sg13g2_a21oi_1
XFILLER_108_559 VDD VSS sg13g2_decap_8
XFILLER_120_1079 VDD VSS sg13g2_decap_8
XFILLER_136_879 VDD VSS sg13g2_decap_4
Xclkbuf_4_5_0_clk_i clkbuf_4_5_0_clk_i/X clkbuf_0_clk_i/X VDD VSS sg13g2_buf_8
XFILLER_159_1256 VDD VSS sg13g2_decap_4
X_08018_ _08018_/X _07786_/A _07782_/A _07790_/A _08383_/A _08009_/S _08235_/S0 VDD
+ VSS sg13g2_mux4_1
XFILLER_104_710 VDD VSS sg13g2_decap_8
XFILLER_123_529 VDD VSS sg13g2_decap_8
XFILLER_162_175 VDD VSS sg13g2_decap_8
XFILLER_2_826 VDD VSS sg13g2_decap_8
X_14051__2128 _14051_/RESET_B VDD VSS sg13g2_tiehi
XFILLER_1_336 VDD VSS sg13g2_decap_8
XFILLER_81_1317 VDD VSS sg13g2_decap_8
XFILLER_103_264 VDD VSS sg13g2_decap_8
XFILLER_104_787 VDD VSS sg13g2_fill_2
XFILLER_134_32 VDD VSS sg13g2_decap_8
XFILLER_89_487 VDD VSS sg13g2_fill_1
X_09969_ _14553_/D _14553_/Q _10068_/A0 _09969_/S VDD VSS sg13g2_mux2_1
XFILLER_94_14 VDD VSS sg13g2_decap_8
XFILLER_44_1172 VDD VSS sg13g2_fill_1
XFILLER_58_852 VDD VSS sg13g2_decap_8
X_12980_ _12980_/Y _12900_/A _12997_/A input6/X VDD VSS sg13g2_a21oi_1
XFILLER_134_98 VDD VSS sg13g2_decap_8
XFILLER_85_660 VDD VSS sg13g2_decap_8
XFILLER_57_351 VDD VSS sg13g2_fill_2
XFILLER_44_1194 VDD VSS sg13g2_decap_8
XFILLER_45_502 VDD VSS sg13g2_decap_8
XFILLER_85_671 VDD VSS sg13g2_fill_2
XFILLER_40_1047 VDD VSS sg13g2_decap_8
X_11931_ _11931_/Y _14914_/Q _11792_/B _12123_/A1 VDD VSS sg13g2_a21oi_1
XFILLER_40_1058 VDD VSS sg13g2_fill_1
XFILLER_73_833 VDD VSS sg13g2_fill_2
XFILLER_40_1069 VDD VSS sg13g2_fill_1
XFILLER_18_749 VDD VSS sg13g2_decap_8
XFILLER_79_1257 VDD VSS sg13g2_fill_2
XFILLER_27_63 VDD VSS sg13g2_decap_8
XFILLER_150_42 VDD VSS sg13g2_decap_8
X_14650_ _14650_/Q clkload41/A _14650_/D _14650_/RESET_B VDD VSS sg13g2_dfrbpq_1
X_11862_ _14975_/D _11843_/A _12126_/A _11861_/Y VDD VSS sg13g2_a21o_1
XFILLER_17_259 VDD VSS sg13g2_decap_8
X_13601_ _13609_/B _13601_/A _13601_/B VDD VSS sg13g2_nor2_1
X_10813_ _10851_/A _10813_/A _10818_/B VDD VSS sg13g2_nor2_1
X_14581_ _14581_/Q _14677_/CLK _14581_/D _14581_/RESET_B VDD VSS sg13g2_dfrbpq_1
X_11793_ _11793_/Y wire523/X _11791_/X _12123_/A1 VDD VSS sg13g2_a21oi_1
XFILLER_14_966 VDD VSS sg13g2_decap_8
X_13532_ _15143_/D _13535_/B _13530_/Y _13531_/Y VDD VSS sg13g2_a21oi_1
XFILLER_41_752 VDD VSS sg13g2_decap_8
X_10744_ _11068_/C _10747_/A _09086_/Y _08913_/Y VDD VSS sg13g2_o21ai_1
XFILLER_13_476 VDD VSS sg13g2_decap_8
XFILLER_43_84 VDD VSS sg13g2_decap_8
X_13463_ _13463_/X _15191_/Q _13463_/B _15192_/Q _13463_/D VDD VSS sg13g2_or4_1
X_10675_ _10805_/C _10675_/A _10675_/B _10675_/C VDD VSS sg13g2_nor3_1
XFILLER_142_1260 VDD VSS sg13g2_fill_1
XFILLER_159_84 VDD VSS sg13g2_decap_8
XFILLER_139_662 VDD VSS sg13g2_decap_8
X_15202_ _15202_/Q clkload70/A _15202_/D _15202_/RESET_B VDD VSS sg13g2_dfrbpq_1
XFILLER_9_469 VDD VSS sg13g2_decap_8
XFILLER_167_982 VDD VSS sg13g2_decap_8
XFILLER_16_1274 VDD VSS sg13g2_decap_8
X_12414_ _12415_/B _12413_/X _12412_/X _12539_/S VDD VSS sg13g2_mux2_1
X_14261__1918 _14261_/RESET_B VDD VSS sg13g2_tiehi
XFILLER_51_1165 VDD VSS sg13g2_fill_2
XFILLER_127_835 VDD VSS sg13g2_fill_2
XFILLER_12_1127 VDD VSS sg13g2_decap_8
X_13394_ _15085_/D _13455_/A _13391_/C _13393_/Y VDD VSS sg13g2_o21ai_1
X_15046__2533 _15046_/RESET_B VDD VSS sg13g2_tiehi
XFILLER_103_1266 VDD VSS sg13g2_decap_8
X_15133_ _15133_/Q clkload59/A _15133_/D _15133_/RESET_B VDD VSS sg13g2_dfrbpq_1
XFILLER_103_1277 VDD VSS sg13g2_fill_1
X_12345_ _12345_/X _13723_/Q _14075_/Q _14427_/Q _14523_/Q _12617_/S0 _12617_/S1 VDD
+ VSS sg13g2_mux4_1
X_15064_ _15064_/Q _15064_/CLK _15064_/D _15064_/RESET_B VDD VSS sg13g2_dfrbpq_1
XFILLER_142_849 VDD VSS sg13g2_decap_4
X_12276_ _12280_/A _12273_/Y _12204_/A _12275_/Y VDD VSS sg13g2_o21ai_1
XFILLER_5_686 VDD VSS sg13g2_decap_8
XFILLER_107_581 VDD VSS sg13g2_fill_1
XFILLER_107_592 VDD VSS sg13g2_decap_8
XFILLER_153_197 VDD VSS sg13g2_decap_8
X_14015_ _14015_/Q clkload9/A _14015_/D _14015_/RESET_B VDD VSS sg13g2_dfrbpq_1
X_11227_ _11227_/X _11225_/X _11226_/X _11227_/S VDD VSS sg13g2_mux2_1
XFILLER_4_56 VDD VSS sg13g2_decap_8
XFILLER_4_196 VDD VSS sg13g2_decap_8
XFILLER_122_540 VDD VSS sg13g2_fill_2
XFILLER_49_1083 VDD VSS sg13g2_fill_2
XFILLER_150_860 VDD VSS sg13g2_decap_8
X_14027__2152 _14027_/RESET_B VDD VSS sg13g2_tiehi
XFILLER_122_573 VDD VSS sg13g2_decap_8
XFILLER_95_402 VDD VSS sg13g2_decap_8
XFILLER_122_584 VDD VSS sg13g2_fill_2
X_11158_ _11158_/Y _11144_/Y _11151_/B _11173_/C VDD VSS sg13g2_o21ai_1
XFILLER_96_969 VDD VSS sg13g2_decap_8
X_10109_ _14687_/D _10109_/A0 _14687_/Q _10127_/S VDD VSS sg13g2_mux2_1
XFILLER_23_1223 VDD VSS sg13g2_decap_8
X_11089_ _11091_/B _11125_/A _10754_/X _11058_/Y VDD VSS sg13g2_a21oi_1
XFILLER_62_1283 VDD VSS sg13g2_decap_8
XFILLER_97_1313 VDD VSS sg13g2_decap_4
X_14917_ _14917_/Q clkload42/A _14917_/D _14917_/RESET_B VDD VSS sg13g2_dfrbpq_1
XFILLER_48_384 VDD VSS sg13g2_decap_4
XFILLER_97_1346 VDD VSS sg13g2_decap_8
XFILLER_75_181 VDD VSS sg13g2_decap_8
XFILLER_63_332 VDD VSS sg13g2_decap_8
XFILLER_97_1368 VDD VSS sg13g2_decap_8
X_13895__2284 _13895_/RESET_B VDD VSS sg13g2_tiehi
X_14848_ _14848_/Q _14885_/CLK _14848_/D _14848_/RESET_B VDD VSS sg13g2_dfrbpq_1
XFILLER_91_663 VDD VSS sg13g2_decap_8
XFILLER_64_877 VDD VSS sg13g2_decap_8
XFILLER_63_387 VDD VSS sg13g2_decap_8
XFILLER_1_1085 VDD VSS sg13g2_decap_8
X_14779_ _14779_/Q clkload51/A _14779_/D _14779_/RESET_B VDD VSS sg13g2_dfrbpq_1
XFILLER_51_549 VDD VSS sg13g2_fill_1
XFILLER_20_903 VDD VSS sg13g2_decap_8
XFILLER_143_1024 VDD VSS sg13g2_fill_2
XFILLER_149_437 VDD VSS sg13g2_decap_8
X_15102__2763 _15102_/RESET_B VDD VSS sg13g2_tiehi
XFILLER_32_785 VDD VSS sg13g2_decap_8
XFILLER_165_919 VDD VSS sg13g2_fill_1
XFILLER_76_0 VDD VSS sg13g2_decap_8
XFILLER_34_1374 VDD VSS sg13g2_decap_4
XFILLER_30_1205 VDD VSS sg13g2_decap_8
XFILLER_121_1333 VDD VSS sg13g2_decap_4
XFILLER_129_172 VDD VSS sg13g2_decap_8
X_14237__1942 _14237_/RESET_B VDD VSS sg13g2_tiehi
XFILLER_173_941 VDD VSS sg13g2_decap_8
XFILLER_145_698 VDD VSS sg13g2_decap_8
XFILLER_172_484 VDD VSS sg13g2_decap_8
XFILLER_144_186 VDD VSS sg13g2_fill_1
XFILLER_132_337 VDD VSS sg13g2_fill_1
XFILLER_67_1161 VDD VSS sg13g2_decap_4
XFILLER_28_1112 VDD VSS sg13g2_decap_8
XFILLER_119_1262 VDD VSS sg13g2_fill_1
Xfanout415 _11015_/C _10722_/Y VDD VSS sg13g2_buf_1
XFILLER_115_1104 VDD VSS sg13g2_fill_2
Xfanout426 _10035_/S _10004_/Y VDD VSS sg13g2_buf_1
XFILLER_113_573 VDD VSS sg13g2_decap_8
Xfanout437 _09800_/S _09804_/S VDD VSS sg13g2_buf_1
X_09823_ _14411_/D _09889_/A0 _14411_/Q _09829_/S VDD VSS sg13g2_mux2_1
XFILLER_99_796 VDD VSS sg13g2_decap_8
XFILLER_8_1239 VDD VSS sg13g2_decap_8
XFILLER_58_104 VDD VSS sg13g2_fill_1
XFILLER_115_1126 VDD VSS sg13g2_decap_4
Xfanout448 _09566_/S _09572_/S VDD VSS sg13g2_buf_1
Xfanout459 _09473_/S wire462/X VDD VSS sg13g2_buf_1
XFILLER_28_1189 VDD VSS sg13g2_decap_8
X_09754_ _14344_/D _14344_/Q _10151_/A1 _09763_/S VDD VSS sg13g2_mux2_1
XFILLER_86_468 VDD VSS sg13g2_decap_8
XFILLER_101_779 VDD VSS sg13g2_decap_8
XFILLER_80_1383 VDD VSS sg13g2_fill_1
XFILLER_41_1334 VDD VSS sg13g2_decap_8
XFILLER_104_35 VDD VSS sg13g2_decap_8
X_08705_ _15185_/D hold3088/X _15185_/Q _10203_/S VDD VSS sg13g2_mux2_1
XFILLER_100_289 VDD VSS sg13g2_decap_4
XFILLER_95_991 VDD VSS sg13g2_decap_8
X_09685_ _14277_/D _09916_/A1 _14277_/Q _09697_/S VDD VSS sg13g2_mux2_1
XFILLER_67_693 VDD VSS sg13g2_decap_8
XFILLER_64_28 VDD VSS sg13g2_decap_8
XFILLER_54_332 VDD VSS sg13g2_decap_8
XFILLER_27_557 VDD VSS sg13g2_decap_8
X_08636_ _08637_/A _08406_/A _08488_/B _08560_/C _08635_/X _08511_/S _08329_/B VDD
+ VSS sg13g2_mux4_1
X_13725__2454 _13725_/RESET_B VDD VSS sg13g2_tiehi
X_14485__1694 _14485_/RESET_B VDD VSS sg13g2_tiehi
XFILLER_81_173 VDD VSS sg13g2_decap_8
X_08567_ _08567_/X _08567_/A _08567_/B _08567_/C VDD VSS sg13g2_or3_1
XFILLER_126_1200 VDD VSS sg13g2_decap_4
XFILLER_154_7 VDD VSS sg13g2_decap_8
XFILLER_42_549 VDD VSS sg13g2_decap_8
XFILLER_35_590 VDD VSS sg13g2_fill_2
XFILLER_39_1274 VDD VSS sg13g2_decap_8
XFILLER_11_903 VDD VSS sg13g2_decap_8
XFILLER_165_1282 VDD VSS sg13g2_decap_8
XFILLER_23_763 VDD VSS sg13g2_decap_8
XFILLER_165_1293 VDD VSS sg13g2_fill_2
XFILLER_168_735 VDD VSS sg13g2_decap_8
X_08498_ _08498_/Y _08497_/A _08495_/Y _08497_/Y VDD VSS sg13g2_o21ai_1
XFILLER_168_757 VDD VSS sg13g2_decap_8
XFILLER_35_1149 VDD VSS sg13g2_fill_2
XFILLER_10_413 VDD VSS sg13g2_decap_8
XFILLER_122_1108 VDD VSS sg13g2_decap_8
XFILLER_22_273 VDD VSS sg13g2_decap_8
XFILLER_13_21 VDD VSS sg13g2_decap_8
XFILLER_167_245 VDD VSS sg13g2_decap_8
X_14105__2074 _14105_/RESET_B VDD VSS sg13g2_tiehi
XFILLER_149_971 VDD VSS sg13g2_decap_8
XFILLER_129_21 VDD VSS sg13g2_decap_8
X_10460_ _14842_/D _10471_/D _10633_/A _10460_/C VDD VSS sg13g2_nor3_1
XFILLER_6_406 VDD VSS sg13g2_decap_8
XFILLER_136_621 VDD VSS sg13g2_decap_8
XFILLER_136_632 VDD VSS sg13g2_decap_4
XFILLER_13_98 VDD VSS sg13g2_decap_8
XFILLER_89_14 VDD VSS sg13g2_decap_8
X_09119_ _13779_/D _13779_/Q _09930_/A1 _09153_/S VDD VSS sg13g2_mux2_1
X_10391_ _10392_/A _14820_/Q _14821_/Q _10391_/C _10398_/D VDD VSS sg13g2_nand4_1
XFILLER_163_462 VDD VSS sg13g2_decap_8
XFILLER_108_378 VDD VSS sg13g2_decap_4
X_12130_ _12132_/B _12065_/B _12198_/C _12198_/A VDD VSS sg13g2_a21oi_1
XFILLER_108_389 VDD VSS sg13g2_decap_8
XFILLER_2_623 VDD VSS sg13g2_decap_8
XFILLER_135_197 VDD VSS sg13g2_decap_8
XFILLER_145_42 VDD VSS sg13g2_decap_8
XFILLER_150_145 VDD VSS sg13g2_decap_8
X_12061_ _12197_/A _12061_/A _13190_/B VDD VSS sg13g2_xnor2_1
XFILLER_1_133 VDD VSS sg13g2_decap_8
XFILLER_78_925 VDD VSS sg13g2_fill_1
XFILLER_145_86 VDD VSS sg13g2_fill_2
X_11012_ _11014_/B _11064_/A _11012_/B _11012_/C VDD VSS sg13g2_nor3_1
XFILLER_132_893 VDD VSS sg13g2_decap_8
XFILLER_150_189 VDD VSS sg13g2_decap_8
XFILLER_46_1267 VDD VSS sg13g2_decap_8
XFILLER_81_1169 VDD VSS sg13g2_decap_8
XFILLER_77_446 VDD VSS sg13g2_fill_2
Xfanout960 _13206_/B _13051_/B VDD VSS sg13g2_buf_1
Xfanout971 _08391_/A _15096_/Q VDD VSS sg13g2_buf_1
Xfanout982 _13279_/B _13310_/B2 VDD VSS sg13g2_buf_1
XFILLER_77_468 VDD VSS sg13g2_decap_8
Xfanout993 _10105_/C _09640_/B VDD VSS sg13g2_buf_1
X_14866__2812 _14866_/RESET_B VDD VSS sg13g2_tiehi
XFILLER_86_980 VDD VSS sg13g2_fill_1
XFILLER_58_671 VDD VSS sg13g2_fill_1
XFILLER_58_682 VDD VSS sg13g2_decap_8
XFILLER_46_822 VDD VSS sg13g2_decap_8
XFILLER_38_84 VDD VSS sg13g2_decap_8
XFILLER_161_63 VDD VSS sg13g2_decap_8
X_12963_ _12963_/Y _14873_/Q _13013_/B VDD VSS sg13g2_nand2_1
XFILLER_79_1021 VDD VSS sg13g2_decap_8
XFILLER_46_833 VDD VSS sg13g2_fill_1
XFILLER_38_95 VDD VSS sg13g2_fill_1
XFILLER_18_546 VDD VSS sg13g2_decap_8
X_14702_ _14702_/Q clkload37/A _14702_/D _14702_/RESET_B VDD VSS sg13g2_dfrbpq_1
X_11914_ _11915_/A _11914_/A _13673_/Q VDD VSS sg13g2_xor2_1
XFILLER_73_652 VDD VSS sg13g2_fill_1
X_12894_ _12894_/X _12894_/A _12894_/B VDD VSS sg13g2_xor2_1
XFILLER_79_1076 VDD VSS sg13g2_fill_2
X_14315__1864 _14315_/RESET_B VDD VSS sg13g2_tiehi
XFILLER_73_685 VDD VSS sg13g2_fill_2
XFILLER_2_1372 VDD VSS sg13g2_decap_8
XFILLER_166_1046 VDD VSS sg13g2_fill_1
X_14633_ _14633_/Q clkload21/A _14633_/D _14633_/RESET_B VDD VSS sg13g2_dfrbpq_1
X_11845_ _11867_/B _11907_/A _11910_/B _11845_/C VDD VSS sg13g2_or3_1
XFILLER_61_847 VDD VSS sg13g2_decap_8
XFILLER_57_1330 VDD VSS sg13g2_decap_8
XFILLER_92_1232 VDD VSS sg13g2_decap_8
X_14899__2746 _14899_/RESET_B VDD VSS sg13g2_tiehi
XFILLER_14_763 VDD VSS sg13g2_decap_8
X_14564_ _14564_/Q clkload23/A _14564_/D _14564_/RESET_B VDD VSS sg13g2_dfrbpq_1
X_11776_ _11777_/B _11776_/A _11776_/B VDD VSS sg13g2_nand2_1
XFILLER_92_1276 VDD VSS sg13g2_decap_8
XFILLER_18_1358 VDD VSS sg13g2_decap_8
XFILLER_13_273 VDD VSS sg13g2_decap_8
X_13515_ _15138_/D _15138_/Q _14995_/Q _13535_/B VDD VSS sg13g2_mux2_1
XFILLER_144_1377 VDD VSS sg13g2_fill_2
XFILLER_147_908 VDD VSS sg13g2_fill_2
X_10727_ _10727_/Y _14909_/Q _11021_/B VDD VSS sg13g2_nand2_1
XFILLER_41_593 VDD VSS sg13g2_decap_8
X_14495_ _14495_/Q clkload14/A _14495_/D _14495_/RESET_B VDD VSS sg13g2_dfrbpq_1
XFILLER_174_705 VDD VSS sg13g2_decap_4
XFILLER_9_266 VDD VSS sg13g2_decap_8
XFILLER_16_1071 VDD VSS sg13g2_decap_8
X_13446_ _13446_/Y _13412_/B _13412_/C hold3138/X VDD VSS sg13g2_o21ai_1
X_10658_ _14891_/D _10661_/A _10658_/B _10666_/D VDD VSS sg13g2_nor3_1
XFILLER_174_749 VDD VSS sg13g2_decap_8
XFILLER_139_481 VDD VSS sg13g2_decap_8
Xclkload14 clkload14/Y clkload14/A VDD VSS sg13g2_inv_1
XFILLER_10_980 VDD VSS sg13g2_decap_8
XFILLER_155_941 VDD VSS sg13g2_fill_2
Xclkload25 clkload25/Y clkload25/A VDD VSS sg13g2_inv_2
Xclkload36 clkload36/Y clkload36/A VDD VSS sg13g2_inv_1
XFILLER_173_259 VDD VSS sg13g2_decap_8
X_13377_ _15078_/D _15078_/Q _13407_/A _13376_/Y VDD VSS sg13g2_a21o_1
Xclkload47 clkload47/Y clkload47/A VDD VSS sg13g2_inv_1
Xclkload58 clkload58/Y clkload58/A VDD VSS sg13g2_inv_2
X_10589_ _10592_/B _10649_/B _10594_/D _14874_/Q VDD VSS sg13g2_a21oi_1
Xclkload69 clkload69/Y clkload69/A VDD VSS sg13g2_inv_4
XFILLER_6_973 VDD VSS sg13g2_decap_8
XFILLER_127_687 VDD VSS sg13g2_fill_1
XFILLER_154_473 VDD VSS sg13g2_fill_1
X_15116_ _15116_/Q _15188_/CLK _15116_/D _15116_/RESET_B VDD VSS sg13g2_dfrbpq_1
X_12328_ _12328_/Y _12330_/S0 _13946_/Q _12328_/B1 VDD VSS sg13g2_a21oi_1
XFILLER_115_849 VDD VSS sg13g2_fill_2
XFILLER_141_101 VDD VSS sg13g2_fill_2
XFILLER_5_483 VDD VSS sg13g2_decap_8
XFILLER_138_1148 VDD VSS sg13g2_decap_8
XFILLER_141_134 VDD VSS sg13g2_decap_4
XFILLER_130_808 VDD VSS sg13g2_decap_8
XFILLER_138_1159 VDD VSS sg13g2_fill_1
X_15047_ _15047_/Q clkload64/A _15047_/D _15047_/RESET_B VDD VSS sg13g2_dfrbpq_1
X_13803__2376 _13803_/RESET_B VDD VSS sg13g2_tiehi
X_12259_ _12259_/X _14712_/Q _14744_/Q _13784_/Q _13816_/Q _12017_/A _12169_/C VDD
+ VSS sg13g2_mux4_1
XFILLER_141_156 VDD VSS sg13g2_decap_8
XFILLER_69_925 VDD VSS sg13g2_decap_8
XFILLER_123_882 VDD VSS sg13g2_fill_2
XFILLER_64_1356 VDD VSS sg13g2_fill_1
XFILLER_122_370 VDD VSS sg13g2_fill_1
XFILLER_96_733 VDD VSS sg13g2_decap_8
XFILLER_69_947 VDD VSS sg13g2_decap_4
Xclkbuf_0_clk_i clkbuf_0_clk_i/X clk_i VDD VSS sg13g2_buf_16
XFILLER_84_939 VDD VSS sg13g2_decap_8
XFILLER_62_1080 VDD VSS sg13g2_decap_8
XFILLER_37_822 VDD VSS sg13g2_decap_8
XFILLER_149_1200 VDD VSS sg13g2_decap_8
XFILLER_97_1132 VDD VSS sg13g2_decap_8
XFILLER_48_181 VDD VSS sg13g2_decap_4
XFILLER_64_641 VDD VSS sg13g2_decap_8
XFILLER_64_652 VDD VSS sg13g2_fill_2
XFILLER_58_1105 VDD VSS sg13g2_fill_2
XFILLER_3_1169 VDD VSS sg13g2_decap_8
XFILLER_23_1097 VDD VSS sg13g2_decap_8
X_09470_ _14071_/D _10166_/A1 _14071_/Q _09472_/S VDD VSS sg13g2_mux2_1
XFILLER_36_354 VDD VSS sg13g2_fill_1
XFILLER_63_151 VDD VSS sg13g2_decap_8
XFILLER_63_162 VDD VSS sg13g2_fill_2
XFILLER_52_825 VDD VSS sg13g2_decap_4
X_08421_ _08421_/Y _08419_/Y _08420_/A _08417_/Y VDD VSS sg13g2_o21ai_1
X_08352_ _08353_/B _08352_/A _08352_/B _08369_/B VDD VSS sg13g2_nand3_1
XFILLER_32_560 VDD VSS sg13g2_decap_8
XFILLER_20_700 VDD VSS sg13g2_decap_8
XFILLER_165_705 VDD VSS sg13g2_decap_8
X_08283_ _08283_/Y _08539_/B1 _08282_/Y _08277_/Y VDD VSS sg13g2_o21ai_1
Xclkload8 clkload8/Y clkload8/A VDD VSS sg13g2_inv_2
XFILLER_20_777 VDD VSS sg13g2_decap_8
XFILLER_118_632 VDD VSS sg13g2_fill_1
XFILLER_160_1190 VDD VSS sg13g2_fill_1
XFILLER_164_259 VDD VSS sg13g2_decap_8
XFILLER_117_131 VDD VSS sg13g2_decap_8
XFILLER_173_760 VDD VSS sg13g2_fill_1
XFILLER_106_838 VDD VSS sg13g2_decap_8
XFILLER_161_933 VDD VSS sg13g2_decap_8
XFILLER_160_421 VDD VSS sg13g2_decap_8
X_15184__2815 _15184_/RESET_B VDD VSS sg13g2_tiehi
XFILLER_59_28 VDD VSS sg13g2_decap_8
XFILLER_133_668 VDD VSS sg13g2_fill_2
XFILLER_156_1259 VDD VSS sg13g2_decap_8
XFILLER_161_999 VDD VSS sg13g2_fill_1
Xfanout201 _09927_/A1 _09098_/Y VDD VSS sg13g2_buf_1
Xfanout212 _13166_/A1 _13253_/B2 VDD VSS sg13g2_buf_1
Xfanout223 _09922_/A1 _10154_/A1 VDD VSS sg13g2_buf_1
XFILLER_101_521 VDD VSS sg13g2_fill_2
Xfanout234 _09621_/A0 _09051_/Y VDD VSS sg13g2_buf_1
XFILLER_8_1036 VDD VSS sg13g2_decap_8
XFILLER_86_210 VDD VSS sg13g2_fill_1
Xfanout245 _09853_/A1 _10084_/A0 VDD VSS sg13g2_buf_1
XFILLER_59_435 VDD VSS sg13g2_decap_4
Xfanout256 _10082_/A0 _09032_/X VDD VSS sg13g2_buf_1
XFILLER_115_56 VDD VSS sg13g2_decap_8
Xfanout267 _09898_/S _09904_/S VDD VSS sg13g2_buf_1
X_09806_ _09806_/Y _09839_/C _09806_/B _10004_/C _09806_/D VDD VSS sg13g2_nand4_1
XFILLER_115_67 VDD VSS sg13g2_fill_2
Xfanout278 _09436_/S _09439_/S VDD VSS sg13g2_buf_1
XFILLER_75_917 VDD VSS sg13g2_decap_8
Xfanout289 _10047_/A0 _10080_/A0 VDD VSS sg13g2_buf_1
X_07998_ _07998_/X _15103_/Q _15090_/Q VDD VSS sg13g2_or2_1
XFILLER_41_1131 VDD VSS sg13g2_fill_1
X_14572__1607 _14572_/RESET_B VDD VSS sg13g2_tiehi
X_09737_ _14328_/D _09935_/A1 _14328_/Q _09737_/S VDD VSS sg13g2_mux2_1
X_13958__2221 _13958_/RESET_B VDD VSS sg13g2_tiehi
XFILLER_41_1164 VDD VSS sg13g2_decap_8
XFILLER_67_490 VDD VSS sg13g2_decap_8
XFILLER_39_181 VDD VSS sg13g2_decap_4
XFILLER_167_1300 VDD VSS sg13g2_fill_2
XFILLER_27_332 VDD VSS sg13g2_decap_8
X_09668_ _14261_/D _09932_/A1 _14261_/Q _09672_/S VDD VSS sg13g2_mux2_1
XFILLER_54_140 VDD VSS sg13g2_decap_8
XFILLER_83_983 VDD VSS sg13g2_decap_4
XFILLER_43_836 VDD VSS sg13g2_fill_2
X_08619_ _08619_/Y _08054_/B _08635_/A1 _08053_/Y VDD VSS sg13g2_o21ai_1
XFILLER_76_1249 VDD VSS sg13g2_decap_8
XFILLER_70_633 VDD VSS sg13g2_fill_2
XFILLER_42_324 VDD VSS sg13g2_fill_2
X_09599_ _14196_/D _14196_/Q _09632_/A0 _09599_/S VDD VSS sg13g2_mux2_1
XFILLER_54_195 VDD VSS sg13g2_decap_8
XFILLER_43_869 VDD VSS sg13g2_decap_8
X_11630_ _11630_/Y _12156_/A _11629_/Y _11724_/B VDD VSS sg13g2_o21ai_1
XFILLER_42_368 VDD VSS sg13g2_decap_8
XFILLER_11_700 VDD VSS sg13g2_decap_8
XFILLER_24_42 VDD VSS sg13g2_decap_8
XFILLER_168_532 VDD VSS sg13g2_decap_8
XFILLER_10_210 VDD VSS sg13g2_decap_8
X_11561_ _11561_/Y _11556_/X _12174_/A _12265_/B1 VDD VSS sg13g2_a21oi_1
X_13300_ _13300_/Y _13300_/A _15205_/Q _13300_/C _13312_/A VDD VSS sg13g2_nor4_1
XFILLER_13_1211 VDD VSS sg13g2_decap_8
XFILLER_156_738 VDD VSS sg13g2_decap_8
X_10512_ _10514_/B _10512_/A _10512_/B _10512_/C VDD VSS sg13g2_nor3_1
XFILLER_52_1260 VDD VSS sg13g2_decap_8
XFILLER_11_777 VDD VSS sg13g2_decap_8
X_14280_ _14280_/Q _14310_/CLK _14280_/D _14280_/RESET_B VDD VSS sg13g2_dfrbpq_1
XFILLER_6_203 VDD VSS sg13g2_decap_8
X_11492_ _11492_/X _14114_/Q _14146_/Q _14178_/Q _14210_/Q _11493_/S0 _11493_/S1 VDD
+ VSS sg13g2_mux4_1
XFILLER_10_287 VDD VSS sg13g2_decap_8
X_13231_ _13242_/A _13232_/A _13244_/B VDD VSS sg13g2_nand2b_1
X_10443_ _10444_/B _14837_/Q _14836_/Q _14835_/Q _10443_/D VDD VSS sg13g2_nand4_1
XFILLER_104_1383 VDD VSS sg13g2_fill_1
XFILLER_40_63 VDD VSS sg13g2_fill_1
XFILLER_13_1288 VDD VSS sg13g2_decap_8
XFILLER_3_910 VDD VSS sg13g2_decap_8
XFILLER_151_410 VDD VSS sg13g2_fill_2
X_13162_ _13162_/Y _14854_/Q _07727_/B _13162_/B1 _14886_/Q VDD VSS sg13g2_a22oi_1
XFILLER_156_63 VDD VSS sg13g2_decap_8
X_10374_ _10375_/B _14815_/Q _14816_/Q _10391_/C VDD VSS sg13g2_nand3_1
XFILLER_87_1367 VDD VSS sg13g2_decap_8
XFILLER_87_1378 VDD VSS sg13g2_fill_2
XFILLER_83_1209 VDD VSS sg13g2_decap_8
XFILLER_2_420 VDD VSS sg13g2_decap_8
XFILLER_123_134 VDD VSS sg13g2_decap_8
X_12113_ _12113_/Y _12109_/Y _12110_/Y _12112_/Y _12111_/Y _12317_/B VDD VSS sg13g2_a221oi_1
XFILLER_6_0 VDD VSS sg13g2_decap_8
X_13093_ _13093_/Y _13091_/Y _13093_/B _13160_/B VDD VSS sg13g2_nand3b_1
XFILLER_111_307 VDD VSS sg13g2_decap_8
XFILLER_3_987 VDD VSS sg13g2_decap_8
XFILLER_111_318 VDD VSS sg13g2_decap_8
X_12044_ _12044_/Y _12019_/Y _12021_/Y _12265_/B1 VDD VSS sg13g2_a21oi_1
XFILLER_137_1181 VDD VSS sg13g2_decap_8
XFILLER_2_497 VDD VSS sg13g2_decap_8
XFILLER_77_232 VDD VSS sg13g2_fill_1
XFILLER_46_1075 VDD VSS sg13g2_decap_8
XFILLER_78_766 VDD VSS sg13g2_decap_8
XFILLER_133_1056 VDD VSS sg13g2_decap_8
XFILLER_38_619 VDD VSS sg13g2_decap_8
XFILLER_172_84 VDD VSS sg13g2_decap_8
Xfanout790 _12790_/S _15213_/Q VDD VSS sg13g2_buf_1
XFILLER_24_1351 VDD VSS sg13g2_decap_8
XFILLER_1_35 VDD VSS sg13g2_decap_8
XFILLER_20_1204 VDD VSS sg13g2_decap_8
XFILLER_19_833 VDD VSS sg13g2_decap_8
X_13995_ _13995_/Q clkload1/A _13995_/D _13995_/RESET_B VDD VSS sg13g2_dfrbpq_1
X_15170__2487 _15170_/RESET_B VDD VSS sg13g2_tiehi
X_14548__1631 _14548_/RESET_B VDD VSS sg13g2_tiehi
XFILLER_18_343 VDD VSS sg13g2_decap_8
X_12946_ _12946_/Y _12946_/A _13308_/A _12961_/A VDD VSS sg13g2_nand3_1
XFILLER_92_279 VDD VSS sg13g2_decap_8
XFILLER_34_836 VDD VSS sg13g2_fill_1
XFILLER_33_302 VDD VSS sg13g2_decap_8
X_12877_ _12878_/C _14898_/Q _13689_/Q _12877_/C VDD VSS sg13g2_nand3_1
X_15211__2979 _15211_/RESET_B VDD VSS sg13g2_tiehi
X_14616_ _14616_/Q _14984_/CLK _14616_/D _14616_/RESET_B VDD VSS sg13g2_dfrbpq_1
X_11828_ _11828_/X _14700_/Q _14732_/Q _13772_/Q _13804_/Q _11353_/S _11805_/C VDD
+ VSS sg13g2_mux4_1
XFILLER_61_677 VDD VSS sg13g2_decap_4
XFILLER_14_560 VDD VSS sg13g2_decap_8
XFILLER_81_70 VDD VSS sg13g2_fill_1
X_14547_ _14547_/Q clkload22/A _14547_/D _14547_/RESET_B VDD VSS sg13g2_dfrbpq_1
XFILLER_18_1155 VDD VSS sg13g2_decap_8
XFILLER_105_1114 VDD VSS sg13g2_decap_8
X_11759_ _11760_/B _11759_/A _13930_/Q VDD VSS sg13g2_nand2_1
XFILLER_14_1008 VDD VSS sg13g2_decap_8
XFILLER_81_92 VDD VSS sg13g2_decap_4
XFILLER_147_749 VDD VSS sg13g2_decap_4
X_14478_ _14478_/Q clkload39/A _14478_/D _14478_/RESET_B VDD VSS sg13g2_dfrbpq_1
XFILLER_140_1049 VDD VSS sg13g2_decap_8
XFILLER_128_941 VDD VSS sg13g2_decap_8
XFILLER_31_1344 VDD VSS sg13g2_decap_8
X_13429_ _13429_/Y _13429_/A _13494_/B _13435_/B _13444_/C VDD VSS sg13g2_nor4_1
X_14650__1529 _14650_/RESET_B VDD VSS sg13g2_tiehi
XFILLER_6_770 VDD VSS sg13g2_decap_8
XFILLER_154_270 VDD VSS sg13g2_fill_1
XFILLER_143_966 VDD VSS sg13g2_decap_4
XFILLER_5_280 VDD VSS sg13g2_decap_8
X_08970_ _13755_/D _13755_/Q _09906_/A1 _09167_/S VDD VSS sg13g2_mux2_1
XFILLER_29_1240 VDD VSS sg13g2_decap_8
XFILLER_170_796 VDD VSS sg13g2_decap_8
XFILLER_9_1323 VDD VSS sg13g2_decap_8
X_07921_ _07921_/Y _07876_/A _07876_/B _07912_/Y _07919_/Y VDD VSS sg13g2_a22oi_1
XFILLER_39_0 VDD VSS sg13g2_decap_8
XFILLER_116_1232 VDD VSS sg13g2_fill_1
XFILLER_60_1006 VDD VSS sg13g2_decap_8
XFILLER_111_852 VDD VSS sg13g2_decap_8
X_07852_ _07855_/A _15015_/Q _07853_/B VDD VSS sg13g2_nor2_1
XFILLER_25_1148 VDD VSS sg13g2_decap_8
XFILLER_84_714 VDD VSS sg13g2_decap_8
XFILLER_110_362 VDD VSS sg13g2_decap_8
XFILLER_84_725 VDD VSS sg13g2_fill_1
X_14187__1992 _14187_/RESET_B VDD VSS sg13g2_tiehi
XFILLER_83_213 VDD VSS sg13g2_decap_4
Xinput1 input1/X input1/A VDD VSS sg13g2_buf_1
X_07783_ _07796_/A _08411_/A _07784_/B VDD VSS sg13g2_nor2_1
X_09522_ _14121_/D _09621_/A0 _14121_/Q _09538_/S VDD VSS sg13g2_mux2_1
XFILLER_25_803 VDD VSS sg13g2_fill_1
XFILLER_25_825 VDD VSS sg13g2_fill_1
X_09453_ _14054_/D _09950_/A1 _14054_/Q _09464_/S VDD VSS sg13g2_mux2_1
XFILLER_52_633 VDD VSS sg13g2_decap_8
XFILLER_25_858 VDD VSS sg13g2_decap_8
XFILLER_80_953 VDD VSS sg13g2_decap_8
XFILLER_25_869 VDD VSS sg13g2_fill_2
XFILLER_52_655 VDD VSS sg13g2_decap_4
X_08404_ _08410_/A _07826_/X _08142_/A _08404_/B1 _08436_/B _08402_/Y VDD VSS sg13g2_a221oi_1
XFILLER_169_329 VDD VSS sg13g2_decap_8
X_09384_ _13987_/D _09615_/A0 _13987_/Q _09406_/S VDD VSS sg13g2_mux2_1
XFILLER_80_997 VDD VSS sg13g2_decap_8
X_14850__2844 _14850_/RESET_B VDD VSS sg13g2_tiehi
X_08335_ _15230_/D _08335_/A _08335_/B _08335_/C _08335_/D VDD VSS sg13g2_nand4_1
XFILLER_71_1168 VDD VSS sg13g2_decap_8
XFILLER_138_749 VDD VSS sg13g2_decap_4
X_08266_ _08266_/Y _08300_/A3 _08263_/B _08248_/A VDD VSS sg13g2_a21oi_1
XFILLER_20_574 VDD VSS sg13g2_decap_8
XFILLER_165_546 VDD VSS sg13g2_decap_8
XFILLER_118_440 VDD VSS sg13g2_decap_8
XFILLER_117_7 VDD VSS sg13g2_decap_8
XFILLER_118_451 VDD VSS sg13g2_fill_2
X_08197_ _08197_/X _08397_/B _08079_/X _08081_/X _08085_/A _08279_/B _08617_/A VDD
+ VSS sg13g2_mux4_1
XFILLER_4_707 VDD VSS sg13g2_decap_8
XFILLER_119_985 VDD VSS sg13g2_decap_8
XFILLER_69_1020 VDD VSS sg13g2_decap_8
X_14883__2778 _14883_/RESET_B VDD VSS sg13g2_tiehi
XFILLER_106_624 VDD VSS sg13g2_fill_1
XFILLER_3_217 VDD VSS sg13g2_decap_8
XFILLER_105_112 VDD VSS sg13g2_decap_4
XFILLER_161_730 VDD VSS sg13g2_decap_8
X_14626__1553 _14626_/RESET_B VDD VSS sg13g2_tiehi
XFILLER_105_156 VDD VSS sg13g2_decap_8
XFILLER_10_77 VDD VSS sg13g2_decap_8
XFILLER_117_1018 VDD VSS sg13g2_fill_2
XFILLER_161_785 VDD VSS sg13g2_decap_8
XFILLER_82_1231 VDD VSS sg13g2_fill_2
Xfanout1007 _09072_/B _09161_/S VDD VSS sg13g2_buf_1
X_10090_ _14670_/D _10090_/A0 _14670_/Q _10096_/S VDD VSS sg13g2_mux2_1
XFILLER_160_295 VDD VSS sg13g2_decap_8
Xfanout1018 _08723_/A _13412_/B VDD VSS sg13g2_buf_1
XFILLER_59_210 VDD VSS sg13g2_decap_8
XFILLER_102_841 VDD VSS sg13g2_decap_8
Xfanout1029 _08351_/B _15001_/Q VDD VSS sg13g2_buf_1
XFILLER_87_530 VDD VSS sg13g2_decap_4
XFILLER_0_968 VDD VSS sg13g2_decap_8
XFILLER_102_852 VDD VSS sg13g2_fill_2
XFILLER_48_917 VDD VSS sg13g2_decap_8
XFILLER_43_1259 VDD VSS sg13g2_fill_1
XFILLER_19_42 VDD VSS sg13g2_decap_8
XFILLER_142_21 VDD VSS sg13g2_decap_8
XFILLER_87_585 VDD VSS sg13g2_fill_1
XFILLER_101_384 VDD VSS sg13g2_decap_8
XFILLER_59_298 VDD VSS sg13g2_decap_8
XFILLER_101_395 VDD VSS sg13g2_fill_2
X_12800_ _12800_/X _12883_/A _12884_/C _12899_/C input20/X VDD VSS sg13g2_and4_1
X_13780_ _13780_/Q clkload15/A _13780_/D _13780_/RESET_B VDD VSS sg13g2_dfrbpq_1
XFILLER_27_140 VDD VSS sg13g2_decap_8
X_10992_ _10992_/X _11009_/C _10992_/B VDD VSS sg13g2_xor2_1
XFILLER_76_1002 VDD VSS sg13g2_decap_4
XFILLER_16_847 VDD VSS sg13g2_decap_8
X_12731_ _12731_/X _14710_/Q _14742_/Q _13782_/Q _13814_/Q _12731_/S0 _12731_/S1 VDD
+ VSS sg13g2_mux4_1
XFILLER_76_1057 VDD VSS sg13g2_fill_1
XFILLER_35_63 VDD VSS sg13g2_decap_8
XFILLER_15_357 VDD VSS sg13g2_decap_8
XFILLER_163_1016 VDD VSS sg13g2_decap_8
XFILLER_71_975 VDD VSS sg13g2_decap_4
XFILLER_37_1019 VDD VSS sg13g2_decap_8
X_12662_ _12662_/X _12655_/X _12659_/X _12654_/X _12658_/X _12663_/S0 _12663_/S1 VDD
+ VSS sg13g2_mux4_1
X_15104__2755 _15104_/RESET_B VDD VSS sg13g2_tiehi
XFILLER_43_688 VDD VSS sg13g2_decap_4
XFILLER_30_305 VDD VSS sg13g2_decap_8
XFILLER_169_841 VDD VSS sg13g2_decap_8
Xclkbuf_leaf_63_clk_i clkload62/A clkbuf_leaf_72_clk_i/A VDD VSS sg13g2_buf_8
XFILLER_143_0 VDD VSS sg13g2_decap_8
X_14401_ _14401_/Q clkload24/A _14401_/D _14401_/RESET_B VDD VSS sg13g2_dfrbpq_1
XFILLER_54_1333 VDD VSS sg13g2_decap_8
X_11613_ _11613_/Y _11609_/Y _11610_/Y _11612_/Y _11611_/Y _11763_/B VDD VSS sg13g2_a221oi_1
XFILLER_30_338 VDD VSS sg13g2_decap_8
X_12593_ _12593_/X _12592_/X _12591_/X _12588_/X _12587_/X _12705_/S0 _12567_/S VDD
+ VSS sg13g2_mux4_1
X_14332_ _14332_/Q clkload46/A _14332_/D _14332_/RESET_B VDD VSS sg13g2_dfrbpq_1
Xwire421 wire421/X wire421/A VDD VSS sg13g2_buf_4
X_11544_ _11544_/Y _12014_/S _14404_/Q _12018_/C VDD VSS sg13g2_a21oi_1
XFILLER_11_574 VDD VSS sg13g2_decap_8
X_14263_ _14263_/Q _15015_/CLK _14263_/D _14263_/RESET_B VDD VSS sg13g2_dfrbpq_1
XFILLER_109_451 VDD VSS sg13g2_decap_8
Xclkbuf_leaf_78_clk_i _14746_/CLK clkbuf_leaf_88_clk_i/A VDD VSS sg13g2_buf_8
X_11475_ _11477_/B _12291_/A _11475_/B VDD VSS sg13g2_nor2_1
XFILLER_7_567 VDD VSS sg13g2_decap_8
XFILLER_167_84 VDD VSS sg13g2_decap_8
XFILLER_171_516 VDD VSS sg13g2_decap_8
XFILLER_13_1085 VDD VSS sg13g2_decap_8
X_13214_ _13215_/B _13200_/A _13667_/Q _13203_/Y VDD VSS sg13g2_a21oi_1
X_10426_ _10426_/Y _14831_/Q _10453_/C _10535_/C VDD VSS sg13g2_o21ai_1
X_14194_ _14194_/Q _14512_/CLK _14194_/D _14194_/RESET_B VDD VSS sg13g2_dfrbpq_1
XFILLER_152_752 VDD VSS sg13g2_decap_4
X_13145_ _13145_/Y _13145_/A VDD VSS sg13g2_inv_1
XFILLER_174_1134 VDD VSS sg13g2_decap_8
XFILLER_100_1088 VDD VSS sg13g2_fill_1
XFILLER_124_465 VDD VSS sg13g2_decap_8
XFILLER_139_1265 VDD VSS sg13g2_decap_8
XFILLER_152_774 VDD VSS sg13g2_decap_4
X_10357_ _10358_/C _14807_/Q _14808_/Q _14811_/Q _10357_/D VDD VSS sg13g2_and4_1
XFILLER_174_1145 VDD VSS sg13g2_decap_8
XFILLER_112_616 VDD VSS sg13g2_decap_8
XFILLER_139_1276 VDD VSS sg13g2_fill_2
XFILLER_3_784 VDD VSS sg13g2_decap_8
XFILLER_151_284 VDD VSS sg13g2_fill_2
X_13076_ _13076_/Y _14910_/Q _13064_/B _13172_/B VDD VSS sg13g2_a21oi_1
XFILLER_32_7 VDD VSS sg13g2_decap_8
X_10288_ _10294_/C _10297_/A _10288_/B VDD VSS sg13g2_nor2_1
XFILLER_2_294 VDD VSS sg13g2_decap_8
X_12027_ _12027_/Y _12027_/A _12027_/B _12237_/C VDD VSS sg13g2_nand3_1
XFILLER_61_1348 VDD VSS sg13g2_fill_2
XFILLER_93_522 VDD VSS sg13g2_decap_4
Xclkbuf_leaf_16_clk_i clkload23/A clkbuf_leaf_22_clk_i/A VDD VSS sg13g2_buf_8
XFILLER_65_235 VDD VSS sg13g2_decap_4
XFILLER_20_1001 VDD VSS sg13g2_decap_8
XFILLER_19_630 VDD VSS sg13g2_decap_8
XFILLER_93_555 VDD VSS sg13g2_decap_8
XFILLER_93_566 VDD VSS sg13g2_fill_2
XFILLER_4_1253 VDD VSS sg13g2_decap_8
XFILLER_111_1140 VDD VSS sg13g2_decap_8
X_14064__2115 _14064_/RESET_B VDD VSS sg13g2_tiehi
XFILLER_18_140 VDD VSS sg13g2_decap_8
X_13978_ _13978_/Q _14734_/CLK _13978_/D _13978_/RESET_B VDD VSS sg13g2_dfrbpq_1
XFILLER_65_279 VDD VSS sg13g2_decap_8
XFILLER_62_920 VDD VSS sg13g2_fill_2
XFILLER_80_227 VDD VSS sg13g2_decap_8
X_12929_ _12929_/Y _14871_/Q _13013_/B VDD VSS sg13g2_nand2_1
XFILLER_20_1078 VDD VSS sg13g2_decap_8
XFILLER_59_1288 VDD VSS sg13g2_decap_8
XFILLER_62_997 VDD VSS sg13g2_decap_8
X_14704__1475 _14704_/RESET_B VDD VSS sg13g2_tiehi
XFILLER_33_176 VDD VSS sg13g2_fill_2
X_08120_ _08120_/Y _08119_/X _08279_/B VDD VSS sg13g2_nand2b_1
X_08051_ _08051_/Y _08079_/S _08397_/B VDD VSS sg13g2_nor2_1
XFILLER_31_1141 VDD VSS sg13g2_decap_8
XFILLER_174_365 VDD VSS sg13g2_fill_2
XFILLER_162_516 VDD VSS sg13g2_decap_8
XFILLER_142_240 VDD VSS sg13g2_fill_2
XFILLER_157_1365 VDD VSS sg13g2_fill_1
XFILLER_170_560 VDD VSS sg13g2_decap_8
Xhold3104 _13624_/A _13732_/Q VDD VSS sg13g2_dlygate4sd3_1
XFILLER_66_1248 VDD VSS sg13g2_decap_8
XFILLER_118_1327 VDD VSS sg13g2_decap_8
Xhold3115 _13644_/A _13752_/Q VDD VSS sg13g2_dlygate4sd3_1
Xhold3126 _13621_/A _13729_/Q VDD VSS sg13g2_dlygate4sd3_1
XFILLER_103_638 VDD VSS sg13g2_fill_2
XFILLER_153_1229 VDD VSS sg13g2_fill_2
XFILLER_142_284 VDD VSS sg13g2_decap_4
Xhold3137 hold3137/X _14890_/Q VDD VSS sg13g2_dlygate4sd3_1
X_08953_ _13721_/D _08956_/S _08951_/Y _08952_/Y VDD VSS sg13g2_a21oi_1
XFILLER_9_1120 VDD VSS sg13g2_decap_8
X_14274__1905 _14274_/RESET_B VDD VSS sg13g2_tiehi
Xhold3148 _10850_/A _14931_/Q VDD VSS sg13g2_dlygate4sd3_1
XFILLER_88_349 VDD VSS sg13g2_decap_8
Xhold3159 _13575_/A _15157_/Q VDD VSS sg13g2_dlygate4sd3_1
XFILLER_102_148 VDD VSS sg13g2_decap_8
XFILLER_69_541 VDD VSS sg13g2_decap_4
X_07904_ _07905_/C _07904_/A _07904_/B _07904_/C _08402_/B VDD VSS sg13g2_nand4_1
XFILLER_57_703 VDD VSS sg13g2_decap_8
XFILLER_130_479 VDD VSS sg13g2_decap_8
X_08884_ _08884_/Y _10781_/C _09016_/C _15035_/Q VDD VSS sg13g2_nand3_1
XFILLER_97_883 VDD VSS sg13g2_fill_2
XFILLER_57_725 VDD VSS sg13g2_fill_1
XFILLER_9_1197 VDD VSS sg13g2_decap_8
X_07835_ _07835_/Y _07979_/C _07981_/C VDD VSS sg13g2_nand2_1
XFILLER_57_769 VDD VSS sg13g2_decap_8
XFILLER_99_1079 VDD VSS sg13g2_fill_2
X_07766_ _07766_/Y _14762_/Q _07766_/B VDD VSS sg13g2_nor2_1
X_09505_ _14105_/D _10068_/A0 _14105_/Q _09505_/S VDD VSS sg13g2_mux2_1
XFILLER_71_227 VDD VSS sg13g2_decap_8
XFILLER_53_953 VDD VSS sg13g2_decap_8
X_07697_ _07700_/A _07697_/A _12936_/B VDD VSS sg13g2_nand2_1
XFILLER_72_28 VDD VSS sg13g2_decap_8
XFILLER_53_964 VDD VSS sg13g2_fill_1
XFILLER_72_39 VDD VSS sg13g2_fill_1
X_09436_ _14038_/D _10098_/A0 _14038_/Q _09436_/S VDD VSS sg13g2_mux2_1
XFILLER_53_986 VDD VSS sg13g2_decap_8
XFILLER_169_126 VDD VSS sg13g2_decap_8
XFILLER_24_154 VDD VSS sg13g2_decap_8
XFILLER_125_1309 VDD VSS sg13g2_fill_1
XFILLER_164_1369 VDD VSS sg13g2_decap_4
X_09367_ _13971_/D _09666_/A0 _13971_/Q _09370_/S VDD VSS sg13g2_mux2_1
XFILLER_21_861 VDD VSS sg13g2_decap_8
X_13762__2417 _13762_/RESET_B VDD VSS sg13g2_tiehi
X_08318_ _08319_/B _08318_/A _08318_/B _08318_/C _08318_/D VDD VSS sg13g2_nand4_1
X_09298_ _13906_/D _13906_/Q _10128_/A0 _09305_/S VDD VSS sg13g2_mux2_1
XFILLER_123_1055 VDD VSS sg13g2_fill_1
XFILLER_20_371 VDD VSS sg13g2_decap_8
XFILLER_165_343 VDD VSS sg13g2_decap_8
X_08249_ _08250_/B _08248_/A _07927_/Y _08248_/Y VDD VSS sg13g2_a21oi_1
XFILLER_21_21 VDD VSS sg13g2_decap_8
XFILLER_119_771 VDD VSS sg13g2_fill_2
XFILLER_14_1372 VDD VSS sg13g2_decap_8
XFILLER_153_516 VDD VSS sg13g2_decap_8
XFILLER_4_504 VDD VSS sg13g2_decap_8
XFILLER_137_21 VDD VSS sg13g2_decap_8
XFILLER_14_1383 VDD VSS sg13g2_fill_1
XFILLER_101_1342 VDD VSS sg13g2_decap_4
XFILLER_10_1225 VDD VSS sg13g2_decap_8
X_11260_ _11260_/Y _12326_/A1 _13852_/Q _12307_/C VDD VSS sg13g2_a21oi_1
XFILLER_107_966 VDD VSS sg13g2_decap_8
XFILLER_21_98 VDD VSS sg13g2_decap_8
X_14142__2037 _14142_/RESET_B VDD VSS sg13g2_tiehi
Xclkbuf_5_17__f_clk_i clkbuf_leaf_98_clk_i/A clkbuf_4_8_0_clk_i/X VDD VSS sg13g2_buf_16
X_10211_ _10211_/Y _14763_/Q _10210_/Y VDD VSS sg13g2_nor2b_1
XFILLER_134_774 VDD VSS sg13g2_fill_1
X_11191_ _11191_/Y _11191_/A _11205_/B VDD VSS sg13g2_nor2_1
XFILLER_79_316 VDD VSS sg13g2_decap_4
X_15210__2978 _15210_/RESET_B VDD VSS sg13g2_tiehi
X_10142_ _14719_/D _14719_/Q _10142_/A1 _10160_/S VDD VSS sg13g2_mux2_1
XFILLER_122_958 VDD VSS sg13g2_decap_8
XFILLER_121_457 VDD VSS sg13g2_fill_2
XFILLER_0_765 VDD VSS sg13g2_decap_8
XFILLER_153_42 VDD VSS sg13g2_decap_8
X_14950_ _14950_/Q clkload42/A _14950_/D _14950_/RESET_B VDD VSS sg13g2_dfrbpq_1
X_10073_ _14653_/D _10107_/A0 _14653_/Q _10096_/S VDD VSS sg13g2_mux2_1
XFILLER_82_1083 VDD VSS sg13g2_decap_8
X_13901_ _13901_/Q _14733_/CLK _13901_/D _13901_/RESET_B VDD VSS sg13g2_dfrbpq_1
X_13680__2512 _13680_/RESET_B VDD VSS sg13g2_tiehi
X_14881_ _14881_/Q _14885_/CLK _14881_/D _14881_/RESET_B VDD VSS sg13g2_dfrbpq_1
XFILLER_75_555 VDD VSS sg13g2_fill_1
XFILLER_48_769 VDD VSS sg13g2_decap_8
XFILLER_78_1108 VDD VSS sg13g2_decap_8
X_13832_ _13832_/Q _14728_/CLK _13832_/D _13832_/RESET_B VDD VSS sg13g2_dfrbpq_1
XFILLER_75_577 VDD VSS sg13g2_decap_8
XFILLER_63_728 VDD VSS sg13g2_decap_8
XFILLER_21_1365 VDD VSS sg13g2_decap_8
XFILLER_46_84 VDD VSS sg13g2_decap_8
X_13763_ _13763_/Q clkload19/A _13763_/D _13763_/RESET_B VDD VSS sg13g2_dfrbpq_1
XFILLER_46_95 VDD VSS sg13g2_fill_1
XFILLER_16_644 VDD VSS sg13g2_decap_8
X_10975_ _11009_/D _15115_/Q _10995_/A VDD VSS sg13g2_xnor2_1
X_12714_ _12714_/X _14133_/Q _14165_/Q _14197_/Q _14229_/Q _12715_/S0 _12715_/S1 VDD
+ VSS sg13g2_mux4_1
XFILLER_15_154 VDD VSS sg13g2_decap_8
XFILLER_43_463 VDD VSS sg13g2_decap_8
XFILLER_31_603 VDD VSS sg13g2_decap_8
X_13694_ _16856_/A clkload69/A _13694_/D _13694_/RESET_B VDD VSS sg13g2_dfrbpq_1
XFILLER_44_997 VDD VSS sg13g2_fill_1
X_12645_ _12645_/X _13744_/Q _14096_/Q _14448_/Q _14544_/Q _12645_/S0 _12645_/S1 VDD
+ VSS sg13g2_mux4_1
XFILLER_93_1190 VDD VSS sg13g2_decap_8
XFILLER_106_1231 VDD VSS sg13g2_decap_8
XFILLER_129_513 VDD VSS sg13g2_decap_8
XFILLER_145_1280 VDD VSS sg13g2_decap_4
XFILLER_106_1242 VDD VSS sg13g2_fill_1
XFILLER_12_861 VDD VSS sg13g2_decap_8
X_12576_ _12576_/X _14699_/Q _14731_/Q _13771_/Q _13803_/Q _12601_/S0 _12601_/S1 VDD
+ VSS sg13g2_mux4_1
X_14352__1827 _14352_/RESET_B VDD VSS sg13g2_tiehi
X_13738__2441 _13738_/RESET_B VDD VSS sg13g2_tiehi
XFILLER_54_1196 VDD VSS sg13g2_fill_1
XFILLER_102_1106 VDD VSS sg13g2_decap_4
XFILLER_11_371 VDD VSS sg13g2_decap_8
X_14498__1681 _14498_/RESET_B VDD VSS sg13g2_tiehi
XFILLER_15_1169 VDD VSS sg13g2_decap_8
X_14315_ _14315_/Q clkload4/A _14315_/D _14315_/RESET_B VDD VSS sg13g2_dfrbpq_1
XFILLER_8_854 VDD VSS sg13g2_decap_8
XFILLER_129_568 VDD VSS sg13g2_decap_8
X_11527_ _11527_/Y _11527_/A _11636_/B VDD VSS sg13g2_xnor2_1
XFILLER_7_56 VDD VSS sg13g2_decap_8
XFILLER_7_364 VDD VSS sg13g2_decap_8
X_15186__2807 _15186_/RESET_B VDD VSS sg13g2_tiehi
XFILLER_171_313 VDD VSS sg13g2_decap_8
XFILLER_144_538 VDD VSS sg13g2_decap_8
X_14246_ _14246_/Q clkload11/A _14246_/D _14246_/RESET_B VDD VSS sg13g2_dfrbpq_1
X_11458_ _11458_/Y _11458_/A _11458_/B VDD VSS sg13g2_nor2_1
XFILLER_109_281 VDD VSS sg13g2_decap_8
XFILLER_124_240 VDD VSS sg13g2_decap_8
X_10409_ _14825_/D _14825_/Q _10406_/A _10408_/Y VDD VSS sg13g2_a21oi_1
X_14177_ _14177_/Q _14681_/CLK _14177_/D _14177_/RESET_B VDD VSS sg13g2_dfrbpq_1
XFILLER_125_785 VDD VSS sg13g2_fill_1
X_11389_ _11389_/Y _11814_/S0 _13855_/Q _11419_/C VDD VSS sg13g2_a21oi_1
XFILLER_112_402 VDD VSS sg13g2_decap_8
X_14118__2061 _14118_/RESET_B VDD VSS sg13g2_tiehi
X_13128_ _13146_/A _14915_/Q _13129_/B VDD VSS sg13g2_nand2_1
XFILLER_112_435 VDD VSS sg13g2_decap_8
XFILLER_98_658 VDD VSS sg13g2_fill_2
XFILLER_3_581 VDD VSS sg13g2_decap_8
XFILLER_26_1210 VDD VSS sg13g2_decap_8
XFILLER_65_1270 VDD VSS sg13g2_decap_8
XFILLER_97_157 VDD VSS sg13g2_fill_2
XFILLER_100_608 VDD VSS sg13g2_decap_4
XFILLER_140_777 VDD VSS sg13g2_decap_4
XFILLER_140_788 VDD VSS sg13g2_fill_1
XFILLER_152_1240 VDD VSS sg13g2_fill_2
X_13059_ _13066_/C _12993_/B _12993_/C _13058_/Y VDD VSS sg13g2_a21oi_1
XFILLER_85_319 VDD VSS sg13g2_decap_8
XFILLER_121_980 VDD VSS sg13g2_fill_1
XFILLER_152_1262 VDD VSS sg13g2_fill_1
XFILLER_113_1224 VDD VSS sg13g2_decap_8
XFILLER_6_1337 VDD VSS sg13g2_decap_8
XFILLER_22_1107 VDD VSS sg13g2_decap_8
Xfanout1360 _12282_/S0 _12288_/S0 VDD VSS sg13g2_buf_1
Xfanout1371 _10643_/A _10661_/A VDD VSS sg13g2_buf_1
XFILLER_26_1287 VDD VSS sg13g2_decap_8
XFILLER_152_1295 VDD VSS sg13g2_decap_8
Xfanout1382 _13198_/B1 _07625_/Y VDD VSS sg13g2_buf_1
Xfanout1393 _10353_/C _10499_/C VDD VSS sg13g2_buf_1
XFILLER_38_257 VDD VSS sg13g2_decap_8
X_13840__2339 _13840_/RESET_B VDD VSS sg13g2_tiehi
X_07620_ _07620_/Y _14880_/Q VDD VSS sg13g2_inv_1
XFILLER_94_886 VDD VSS sg13g2_decap_8
XFILLER_81_503 VDD VSS sg13g2_decap_8
XFILLER_66_577 VDD VSS sg13g2_decap_8
XFILLER_4_1050 VDD VSS sg13g2_decap_8
XFILLER_38_268 VDD VSS sg13g2_fill_2
X_13986__2193 _13986_/RESET_B VDD VSS sg13g2_tiehi
XFILLER_94_897 VDD VSS sg13g2_decap_8
XFILLER_66_588 VDD VSS sg13g2_fill_2
XFILLER_53_249 VDD VSS sg13g2_decap_8
XFILLER_59_1063 VDD VSS sg13g2_decap_8
XFILLER_35_997 VDD VSS sg13g2_fill_1
XFILLER_61_260 VDD VSS sg13g2_fill_1
XFILLER_146_1055 VDD VSS sg13g2_decap_4
XFILLER_62_794 VDD VSS sg13g2_decap_8
XFILLER_107_1017 VDD VSS sg13g2_decap_8
X_09221_ _13832_/D _09919_/A1 _13832_/Q _09230_/S VDD VSS sg13g2_mux2_1
XFILLER_50_956 VDD VSS sg13g2_decap_8
XFILLER_37_1350 VDD VSS sg13g2_decap_8
XFILLER_72_1252 VDD VSS sg13g2_decap_4
XFILLER_147_310 VDD VSS sg13g2_decap_8
X_09152_ _09152_/Y _09162_/A _09148_/Y _09151_/Y VDD VSS sg13g2_o21ai_1
XFILLER_21_168 VDD VSS sg13g2_decap_8
X_14328__1851 _14328_/RESET_B VDD VSS sg13g2_tiehi
X_08103_ _08104_/D _08103_/A _08103_/B _08103_/C VDD VSS sg13g2_nor3_1
X_09083_ _09083_/Y _09090_/A _09079_/Y _09082_/Y VDD VSS sg13g2_o21ai_1
XFILLER_174_162 VDD VSS sg13g2_decap_8
XFILLER_162_313 VDD VSS sg13g2_decap_8
XFILLER_174_173 VDD VSS sg13g2_decap_8
XFILLER_135_538 VDD VSS sg13g2_decap_8
X_08034_ _08034_/Y _08174_/A _08659_/B VDD VSS sg13g2_nor2_1
XFILLER_115_240 VDD VSS sg13g2_fill_2
XFILLER_150_519 VDD VSS sg13g2_decap_8
XFILLER_116_774 VDD VSS sg13g2_fill_1
XFILLER_66_1034 VDD VSS sg13g2_fill_1
XFILLER_118_1113 VDD VSS sg13g2_fill_1
XFILLER_1_518 VDD VSS sg13g2_decap_8
XFILLER_171_880 VDD VSS sg13g2_decap_4
XFILLER_171_891 VDD VSS sg13g2_decap_8
XFILLER_118_1124 VDD VSS sg13g2_decap_8
XFILLER_88_113 VDD VSS sg13g2_fill_2
XFILLER_157_1195 VDD VSS sg13g2_decap_8
X_09985_ _14568_/D _10084_/A0 _14568_/Q _09994_/S VDD VSS sg13g2_mux2_1
XFILLER_153_1048 VDD VSS sg13g2_fill_1
XFILLER_67_28 VDD VSS sg13g2_decap_8
X_08936_ _08936_/X _15048_/Q _14952_/Q _08943_/A VDD VSS sg13g2_mux2_1
XFILLER_88_179 VDD VSS sg13g2_decap_8
XFILLER_112_980 VDD VSS sg13g2_decap_4
XFILLER_112_991 VDD VSS sg13g2_decap_8
XFILLER_170_1362 VDD VSS sg13g2_decap_8
XFILLER_97_691 VDD VSS sg13g2_fill_2
XFILLER_69_393 VDD VSS sg13g2_decap_8
XFILLER_29_224 VDD VSS sg13g2_decap_8
X_08867_ _08867_/X _08866_/X _08867_/A1 _08891_/S VDD VSS sg13g2_mux2_1
XFILLER_123_56 VDD VSS sg13g2_decap_8
XFILLER_85_875 VDD VSS sg13g2_decap_8
XFILLER_131_1379 VDD VSS sg13g2_fill_1
X_07818_ _07818_/Y _15010_/Q _07818_/B VDD VSS sg13g2_xnor2_1
X_14430__1749 _14430_/RESET_B VDD VSS sg13g2_tiehi
X_13816__2363 _13816_/RESET_B VDD VSS sg13g2_tiehi
X_08798_ _08799_/B _12942_/B _08818_/B VDD VSS sg13g2_nor2_1
XFILLER_84_385 VDD VSS sg13g2_decap_8
XFILLER_44_216 VDD VSS sg13g2_fill_2
XFILLER_38_780 VDD VSS sg13g2_decap_8
XFILLER_26_920 VDD VSS sg13g2_decap_4
Xclkbuf_4_1_0_clk_i clkbuf_4_1_0_clk_i/X clkbuf_0_clk_i/X VDD VSS sg13g2_buf_8
XFILLER_72_536 VDD VSS sg13g2_fill_2
XFILLER_16_21 VDD VSS sg13g2_decap_8
X_07749_ _07750_/A _07738_/Y _07744_/D _07748_/Y VDD VSS sg13g2_o21ai_1
XFILLER_44_249 VDD VSS sg13g2_decap_8
XFILLER_77_1163 VDD VSS sg13g2_decap_8
XFILLER_38_1114 VDD VSS sg13g2_decap_8
XFILLER_26_986 VDD VSS sg13g2_decap_8
X_10760_ _10760_/Y _10760_/A _11133_/B VDD VSS sg13g2_nand2_1
XFILLER_53_783 VDD VSS sg13g2_decap_8
XFILLER_129_1264 VDD VSS sg13g2_decap_8
XFILLER_77_1196 VDD VSS sg13g2_decap_4
XFILLER_16_98 VDD VSS sg13g2_decap_8
XFILLER_80_591 VDD VSS sg13g2_fill_1
XFILLER_164_1166 VDD VSS sg13g2_decap_4
X_09419_ _14021_/D _09949_/A1 _14021_/Q _09431_/S VDD VSS sg13g2_mux2_1
XFILLER_125_1128 VDD VSS sg13g2_decap_8
XFILLER_13_658 VDD VSS sg13g2_decap_8
XFILLER_139_800 VDD VSS sg13g2_fill_2
X_10691_ _10691_/X _14931_/Q _08998_/X _10691_/S VDD VSS sg13g2_mux2_1
XFILLER_12_168 VDD VSS sg13g2_decap_8
X_12430_ _14994_/D _07910_/A _12443_/A2 _12429_/Y VDD VSS sg13g2_a21oi_1
XFILLER_51_1314 VDD VSS sg13g2_fill_1
XFILLER_32_42 VDD VSS sg13g2_decap_8
XFILLER_12_1309 VDD VSS sg13g2_decap_8
XFILLER_139_866 VDD VSS sg13g2_fill_1
XFILLER_148_42 VDD VSS sg13g2_decap_8
XFILLER_165_140 VDD VSS sg13g2_decap_8
X_12361_ _12361_/X _14236_/Q _14268_/Q _14300_/Q _14332_/Q _12783_/S0 _12783_/S1 VDD
+ VSS sg13g2_mux4_1
X_14100_ _14100_/Q _14644_/CLK _14100_/D _14100_/RESET_B VDD VSS sg13g2_dfrbpq_1
X_11312_ _11312_/Y _11306_/Y _11311_/Y _11378_/S VDD VSS sg13g2_o21ai_1
XFILLER_4_301 VDD VSS sg13g2_decap_8
XFILLER_10_1022 VDD VSS sg13g2_decap_8
XFILLER_148_86 VDD VSS sg13g2_decap_8
X_15080_ _15080_/Q _15159_/CLK _15080_/D _15080_/RESET_B VDD VSS sg13g2_dfrbpq_1
X_12292_ _12292_/Y _12292_/A _12292_/B VDD VSS sg13g2_nor2_1
XFILLER_154_869 VDD VSS sg13g2_decap_8
XFILLER_101_1161 VDD VSS sg13g2_decap_4
XFILLER_5_868 VDD VSS sg13g2_decap_8
XFILLER_106_0 VDD VSS sg13g2_decap_8
X_14031_ _14031_/Q clkload6/A _14031_/D _14031_/RESET_B VDD VSS sg13g2_dfrbpq_1
X_11243_ _11245_/B _13300_/C _13293_/D _11243_/C VDD VSS sg13g2_or3_1
XFILLER_134_560 VDD VSS sg13g2_decap_8
XFILLER_4_378 VDD VSS sg13g2_decap_8
XFILLER_10_1099 VDD VSS sg13g2_decap_8
XFILLER_164_63 VDD VSS sg13g2_decap_8
X_11174_ _11177_/C _11127_/A _11127_/B _11173_/Y VDD VSS sg13g2_a21oi_1
XFILLER_79_146 VDD VSS sg13g2_decap_8
XFILLER_110_917 VDD VSS sg13g2_decap_8
XFILLER_95_606 VDD VSS sg13g2_decap_8
XFILLER_79_157 VDD VSS sg13g2_fill_2
X_10125_ _14703_/D _10125_/A0 _14703_/Q _10127_/S VDD VSS sg13g2_mux2_1
XFILLER_67_308 VDD VSS sg13g2_decap_8
XFILLER_171_1159 VDD VSS sg13g2_decap_4
XFILLER_122_799 VDD VSS sg13g2_decap_4
XFILLER_95_639 VDD VSS sg13g2_fill_2
XFILLER_94_116 VDD VSS sg13g2_fill_1
XFILLER_0_595 VDD VSS sg13g2_decap_8
X_14933_ _14933_/Q _15226_/CLK _14933_/D _14933_/RESET_B VDD VSS sg13g2_dfrbpq_1
X_10056_ _14637_/D _10056_/A0 _14637_/Q _10060_/S VDD VSS sg13g2_mux2_1
XFILLER_57_61 VDD VSS sg13g2_decap_8
XFILLER_169_1011 VDD VSS sg13g2_decap_8
X_14864_ _14864_/Q _14868_/CLK _14864_/D _14864_/RESET_B VDD VSS sg13g2_dfrbpq_1
XFILLER_90_311 VDD VSS sg13g2_decap_4
X_14406__1773 _14406_/RESET_B VDD VSS sg13g2_tiehi
XFILLER_17_931 VDD VSS sg13g2_decap_8
XFILLER_21_1162 VDD VSS sg13g2_decap_8
X_13815_ _13815_/Q clkload33/A _13815_/D _13815_/RESET_B VDD VSS sg13g2_dfrbpq_1
X_14795_ _14795_/Q _14868_/CLK _14795_/D _14795_/RESET_B VDD VSS sg13g2_dfrbpq_1
XFILLER_95_1241 VDD VSS sg13g2_fill_2
XFILLER_16_441 VDD VSS sg13g2_decap_8
XFILLER_169_1099 VDD VSS sg13g2_decap_8
XFILLER_95_1252 VDD VSS sg13g2_decap_4
XFILLER_1_1267 VDD VSS sg13g2_decap_8
XFILLER_73_60 VDD VSS sg13g2_decap_8
X_13746_ _13746_/Q _14706_/CLK _13746_/D _13746_/RESET_B VDD VSS sg13g2_dfrbpq_1
XFILLER_56_1225 VDD VSS sg13g2_decap_8
X_10958_ _14938_/D _10956_/Y _10957_/Y _10941_/X VDD VSS sg13g2_a21o_1
XFILLER_50_219 VDD VSS sg13g2_decap_4
XFILLER_43_271 VDD VSS sg13g2_decap_8
XFILLER_108_1326 VDD VSS sg13g2_decap_4
X_13677_ _13677_/Q _15188_/CLK _13677_/D _13677_/RESET_B VDD VSS sg13g2_dfrbpq_1
X_10889_ _10948_/A _14755_/Q _10923_/A VDD VSS sg13g2_xor2_1
X_12628_ _12628_/X _14383_/Q _14415_/Q _14479_/Q _14511_/Q _12633_/S0 _12633_/S1 VDD
+ VSS sg13g2_mux4_1
XFILLER_129_321 VDD VSS sg13g2_fill_2
XFILLER_169_490 VDD VSS sg13g2_decap_8
XFILLER_106_1050 VDD VSS sg13g2_decap_8
XFILLER_156_140 VDD VSS sg13g2_decap_8
XFILLER_8_651 VDD VSS sg13g2_decap_8
X_12559_ _12559_/X _14378_/Q _14410_/Q _14474_/Q _14506_/Q _12614_/S0 _12614_/S1 VDD
+ VSS sg13g2_mux4_1
XFILLER_145_825 VDD VSS sg13g2_decap_8
XFILLER_172_611 VDD VSS sg13g2_decap_8
XFILLER_7_161 VDD VSS sg13g2_decap_8
XFILLER_89_1078 VDD VSS sg13g2_decap_8
X_14229_ _14229_/Q _14727_/CLK _14229_/D _14229_/RESET_B VDD VSS sg13g2_dfrbpq_1
XFILLER_67_1332 VDD VSS sg13g2_decap_8
XFILLER_171_154 VDD VSS sg13g2_decap_8
XFILLER_160_828 VDD VSS sg13g2_fill_1
X_14928__2688 _14928_/RESET_B VDD VSS sg13g2_tiehi
XFILLER_99_934 VDD VSS sg13g2_fill_1
XFILLER_113_722 VDD VSS sg13g2_decap_8
XFILLER_125_593 VDD VSS sg13g2_fill_1
Xfanout608 _10691_/S _10684_/A2 VDD VSS sg13g2_buf_1
XFILLER_63_1218 VDD VSS sg13g2_decap_8
Xfanout619 _13508_/C _08835_/B VDD VSS sg13g2_buf_1
XFILLER_113_777 VDD VSS sg13g2_decap_4
XFILLER_154_1379 VDD VSS sg13g2_fill_1
X_09770_ _14360_/D _14360_/Q _09935_/A1 _09772_/S VDD VSS sg13g2_mux2_1
XFILLER_101_939 VDD VSS sg13g2_fill_2
XFILLER_39_500 VDD VSS sg13g2_decap_8
XFILLER_140_585 VDD VSS sg13g2_decap_8
XFILLER_85_116 VDD VSS sg13g2_decap_8
XFILLER_21_0 VDD VSS sg13g2_decap_8
X_08721_ _08721_/X hold3068/X _15193_/Q _08721_/S VDD VSS sg13g2_mux2_1
XFILLER_79_691 VDD VSS sg13g2_decap_8
XFILLER_6_1134 VDD VSS sg13g2_decap_8
XFILLER_113_1021 VDD VSS sg13g2_fill_2
XFILLER_152_1081 VDD VSS sg13g2_fill_1
XFILLER_67_853 VDD VSS sg13g2_decap_8
XFILLER_26_1084 VDD VSS sg13g2_decap_8
Xfanout1190 _12859_/A _14898_/Q VDD VSS sg13g2_buf_1
X_08652_ _08661_/A _08659_/A _08336_/Y _08676_/B2 VDD VSS sg13g2_o21ai_1
XFILLER_81_300 VDD VSS sg13g2_fill_2
XFILLER_96_1049 VDD VSS sg13g2_decap_8
XFILLER_93_193 VDD VSS sg13g2_decap_8
XFILLER_26_238 VDD VSS sg13g2_decap_8
X_08583_ _08586_/B _07963_/Y _08583_/B VDD VSS sg13g2_nand2b_1
XFILLER_81_344 VDD VSS sg13g2_decap_8
XFILLER_41_208 VDD VSS sg13g2_decap_4
XFILLER_81_399 VDD VSS sg13g2_decap_8
XFILLER_74_1336 VDD VSS sg13g2_decap_8
XFILLER_50_720 VDD VSS sg13g2_fill_1
XFILLER_161_1306 VDD VSS sg13g2_decap_8
XFILLER_168_928 VDD VSS sg13g2_decap_8
XFILLER_23_978 VDD VSS sg13g2_decap_8
XFILLER_167_427 VDD VSS sg13g2_decap_8
XFILLER_23_989 VDD VSS sg13g2_fill_2
XFILLER_22_455 VDD VSS sg13g2_decap_8
X_09204_ _10105_/B _09441_/A _10004_/B _09204_/C _09204_/D VDD VSS sg13g2_nor4_1
XFILLER_124_1150 VDD VSS sg13g2_fill_1
XFILLER_33_1044 VDD VSS sg13g2_fill_1
X_09135_ _09164_/C _14921_/Q _13200_/A VDD VSS sg13g2_and2_1
XFILLER_33_1066 VDD VSS sg13g2_decap_8
XFILLER_120_1036 VDD VSS sg13g2_decap_8
X_09066_ _09066_/Y _09072_/B _15038_/Q _09065_/Y VDD VSS sg13g2_o21ai_1
XFILLER_162_154 VDD VSS sg13g2_decap_8
XFILLER_163_677 VDD VSS sg13g2_fill_2
X_08017_ _08019_/B _07929_/B _08258_/C _08300_/A1 _07775_/A _08253_/S0 _08235_/S0
+ VDD VSS sg13g2_mux4_1
XFILLER_2_805 VDD VSS sg13g2_decap_8
XFILLER_144_880 VDD VSS sg13g2_fill_1
XFILLER_1_315 VDD VSS sg13g2_decap_8
XFILLER_78_49 VDD VSS sg13g2_decap_8
XFILLER_134_11 VDD VSS sg13g2_decap_8
X_09968_ _14552_/D _14552_/Q _10167_/A1 _09968_/S VDD VSS sg13g2_mux2_1
XFILLER_49_319 VDD VSS sg13g2_decap_8
XFILLER_104_799 VDD VSS sg13g2_fill_1
XFILLER_58_831 VDD VSS sg13g2_decap_8
X_08919_ _08919_/X _08918_/X _11936_/A _08955_/S VDD VSS sg13g2_mux2_1
XFILLER_134_77 VDD VSS sg13g2_decap_8
X_14663__1516 _14663_/RESET_B VDD VSS sg13g2_tiehi
XFILLER_131_1132 VDD VSS sg13g2_decap_4
X_09899_ _14485_/D _09932_/A1 _14485_/Q _09899_/S VDD VSS sg13g2_mux2_1
X_11930_ _11930_/Y _12192_/A _11928_/X _11929_/Y VDD VSS sg13g2_o21ai_1
XFILLER_73_812 VDD VSS sg13g2_decap_8
XFILLER_57_363 VDD VSS sg13g2_fill_2
XFILLER_131_1165 VDD VSS sg13g2_decap_8
XFILLER_58_897 VDD VSS sg13g2_decap_4
XFILLER_18_728 VDD VSS sg13g2_decap_8
XFILLER_27_42 VDD VSS sg13g2_decap_8
XFILLER_150_21 VDD VSS sg13g2_decap_8
XFILLER_72_322 VDD VSS sg13g2_fill_1
X_14092__2087 _14092_/RESET_B VDD VSS sg13g2_tiehi
XFILLER_17_238 VDD VSS sg13g2_decap_8
X_11861_ _11861_/Y _11860_/Y _11859_/Y _11846_/Y _11868_/A _11980_/A VDD VSS sg13g2_a221oi_1
XFILLER_73_878 VDD VSS sg13g2_fill_1
X_13600_ _13600_/Y _13600_/A _13600_/B _13600_/C VDD VSS sg13g2_nand3_1
XFILLER_73_889 VDD VSS sg13g2_decap_8
X_10812_ _14927_/D _10811_/Y _10810_/Y _10800_/Y VDD VSS sg13g2_o21ai_1
X_14580_ _14580_/Q _14644_/CLK _14580_/D _14580_/RESET_B VDD VSS sg13g2_dfrbpq_1
X_11792_ _11792_/Y _13064_/A _11792_/B VDD VSS sg13g2_nand2_1
XFILLER_26_794 VDD VSS sg13g2_decap_8
XFILLER_14_945 VDD VSS sg13g2_decap_8
XFILLER_53_591 VDD VSS sg13g2_decap_8
X_13531_ _13531_/Y _13531_/A _13535_/B VDD VSS sg13g2_nor2_1
X_10743_ _11078_/A _07615_/Y _09086_/Y _10743_/S VDD VSS sg13g2_mux2_1
XFILLER_25_293 VDD VSS sg13g2_decap_8
X_15031__2556 _15031_/RESET_B VDD VSS sg13g2_tiehi
XFILLER_13_455 VDD VSS sg13g2_decap_8
XFILLER_158_427 VDD VSS sg13g2_fill_2
XFILLER_43_63 VDD VSS sg13g2_decap_8
X_13462_ _13463_/B _15189_/Q _15190_/Q VDD VSS sg13g2_nand2b_1
XFILLER_159_63 VDD VSS sg13g2_decap_8
X_10674_ _10674_/Y _10674_/A _13294_/B VDD VSS sg13g2_nand2_1
XFILLER_139_641 VDD VSS sg13g2_fill_2
XFILLER_9_448 VDD VSS sg13g2_decap_8
XFILLER_103_1201 VDD VSS sg13g2_fill_2
XFILLER_16_1253 VDD VSS sg13g2_decap_8
X_15201_ _15201_/Q clkload71/A _15201_/D _15201_/RESET_B VDD VSS sg13g2_dfrbpq_1
XFILLER_167_972 VDD VSS sg13g2_fill_2
X_12413_ _12413_/X _12409_/X _12408_/X _12405_/X _12404_/X _12608_/S1 _12664_/S VDD
+ VSS sg13g2_mux4_1
XFILLER_51_1144 VDD VSS sg13g2_decap_8
XFILLER_12_1106 VDD VSS sg13g2_decap_8
X_13393_ _13393_/Y _08723_/A _13493_/A2 _15085_/Q VDD VSS sg13g2_o21ai_1
XFILLER_142_1294 VDD VSS sg13g2_fill_2
X_15132_ _15132_/Q clkload59/A _15132_/D _15132_/RESET_B VDD VSS sg13g2_dfrbpq_1
XFILLER_126_324 VDD VSS sg13g2_decap_4
X_12344_ _12344_/X _14555_/Q _14587_/Q _14619_/Q _14651_/Q _12617_/S0 _12617_/S1 VDD
+ VSS sg13g2_mux4_1
XFILLER_86_1218 VDD VSS sg13g2_decap_8
XFILLER_126_346 VDD VSS sg13g2_decap_4
XFILLER_127_869 VDD VSS sg13g2_decap_8
X_15063_ _15063_/Q _15113_/CLK _15063_/D _15063_/RESET_B VDD VSS sg13g2_dfrbpq_1
XFILLER_5_665 VDD VSS sg13g2_decap_8
X_12275_ _12275_/Y _12229_/A _13664_/Q _12274_/Y VDD VSS sg13g2_a21oi_1
XFILLER_153_176 VDD VSS sg13g2_decap_8
X_14014_ _14014_/Q _14686_/CLK _14014_/D _14014_/RESET_B VDD VSS sg13g2_dfrbpq_1
XFILLER_4_175 VDD VSS sg13g2_decap_8
X_11226_ _11226_/X _14235_/Q _14267_/Q _14299_/Q _14331_/Q _11212_/S _11878_/B1 VDD
+ VSS sg13g2_mux4_1
XFILLER_4_35 VDD VSS sg13g2_decap_8
XFILLER_68_606 VDD VSS sg13g2_fill_1
X_11157_ _11173_/C _11171_/B _11164_/C VDD VSS sg13g2_xnor2_1
XFILLER_68_60 VDD VSS sg13g2_fill_2
XFILLER_67_105 VDD VSS sg13g2_fill_2
XFILLER_110_725 VDD VSS sg13g2_decap_8
XFILLER_1_882 VDD VSS sg13g2_decap_8
XFILLER_68_93 VDD VSS sg13g2_decap_8
XFILLER_23_1202 VDD VSS sg13g2_decap_8
X_10108_ _14686_/D _10141_/A1 _14686_/Q _10136_/S VDD VSS sg13g2_mux2_1
XFILLER_67_138 VDD VSS sg13g2_decap_4
XFILLER_0_392 VDD VSS sg13g2_decap_8
X_11088_ _11091_/A _11088_/A _11118_/B _11118_/A VDD VSS sg13g2_nand3_1
XFILLER_49_864 VDD VSS sg13g2_decap_8
X_14639__1540 _14639_/RESET_B VDD VSS sg13g2_tiehi
XFILLER_114_1374 VDD VSS sg13g2_fill_1
XFILLER_82_108 VDD VSS sg13g2_decap_4
X_14916_ _14916_/Q clkload42/A _14916_/D _14916_/RESET_B VDD VSS sg13g2_dfrbpq_1
X_10039_ _14620_/D _10072_/A0 _14620_/Q _10063_/S VDD VSS sg13g2_mux2_1
XFILLER_48_363 VDD VSS sg13g2_decap_8
XFILLER_63_300 VDD VSS sg13g2_decap_4
XFILLER_23_1279 VDD VSS sg13g2_decap_8
X_14847_ _14847_/Q _14885_/CLK _14847_/D _14847_/RESET_B VDD VSS sg13g2_dfrbpq_1
XFILLER_63_366 VDD VSS sg13g2_decap_8
XFILLER_1_1064 VDD VSS sg13g2_decap_8
XFILLER_90_163 VDD VSS sg13g2_fill_2
XFILLER_51_528 VDD VSS sg13g2_decap_8
X_14778_ _14778_/Q clkload51/A _14778_/D _14778_/RESET_B VDD VSS sg13g2_dfrbpq_1
XFILLER_56_1033 VDD VSS sg13g2_decap_8
XFILLER_90_196 VDD VSS sg13g2_fill_1
X_13729_ _13729_/Q _14681_/CLK _13729_/D _13729_/RESET_B VDD VSS sg13g2_dfrbpq_1
XFILLER_31_230 VDD VSS sg13g2_decap_4
XFILLER_32_764 VDD VSS sg13g2_decap_8
X_15007__2580 _15007_/RESET_B VDD VSS sg13g2_tiehi
XFILLER_56_1088 VDD VSS sg13g2_decap_4
XFILLER_31_252 VDD VSS sg13g2_decap_8
XFILLER_31_263 VDD VSS sg13g2_fill_2
XFILLER_143_1058 VDD VSS sg13g2_decap_8
XFILLER_108_1189 VDD VSS sg13g2_fill_1
XFILLER_20_959 VDD VSS sg13g2_decap_8
X_13790__2389 _13790_/RESET_B VDD VSS sg13g2_tiehi
XFILLER_34_1353 VDD VSS sg13g2_decap_8
XFILLER_121_1312 VDD VSS sg13g2_fill_2
XFILLER_129_151 VDD VSS sg13g2_decap_8
XFILLER_158_983 VDD VSS sg13g2_decap_8
XFILLER_160_1383 VDD VSS sg13g2_fill_1
X_14816__2897 _14816_/RESET_B VDD VSS sg13g2_tiehi
XFILLER_145_622 VDD VSS sg13g2_decap_8
XFILLER_69_0 VDD VSS sg13g2_decap_8
X_14741__1438 _14741_/RESET_B VDD VSS sg13g2_tiehi
X_15135__2687 _15135_/RESET_B VDD VSS sg13g2_tiehi
XFILLER_172_463 VDD VSS sg13g2_decap_8
XFILLER_105_519 VDD VSS sg13g2_fill_2
XFILLER_160_625 VDD VSS sg13g2_fill_2
XFILLER_67_1140 VDD VSS sg13g2_decap_8
XFILLER_126_891 VDD VSS sg13g2_decap_8
XFILLER_160_669 VDD VSS sg13g2_decap_8
XFILLER_154_1132 VDD VSS sg13g2_fill_1
XFILLER_99_764 VDD VSS sg13g2_fill_1
Xfanout416 _10127_/S _10123_/S VDD VSS sg13g2_buf_1
Xfanout427 _09994_/S _10003_/S VDD VSS sg13g2_buf_1
X_09822_ _14410_/D _09921_/A1 _14410_/Q _09832_/S VDD VSS sg13g2_mux2_1
XFILLER_98_252 VDD VSS sg13g2_decap_8
XFILLER_8_1218 VDD VSS sg13g2_decap_8
XFILLER_141_883 VDD VSS sg13g2_decap_8
Xfanout438 _09804_/S _09805_/S VDD VSS sg13g2_buf_1
XFILLER_28_1168 VDD VSS sg13g2_decap_8
XFILLER_100_202 VDD VSS sg13g2_fill_2
Xfanout449 _09572_/S _09540_/Y VDD VSS sg13g2_buf_1
XFILLER_115_1149 VDD VSS sg13g2_decap_8
XFILLER_41_1302 VDD VSS sg13g2_decap_8
X_09753_ _14343_/D _14343_/Q _09918_/A1 _09768_/S VDD VSS sg13g2_mux2_1
XFILLER_104_14 VDD VSS sg13g2_decap_8
X_08704_ _13657_/D _15184_/D _15115_/Q _13656_/S VDD VSS sg13g2_mux2_1
XFILLER_104_47 VDD VSS sg13g2_decap_8
XFILLER_95_981 VDD VSS sg13g2_decap_4
XFILLER_67_672 VDD VSS sg13g2_decap_8
X_09684_ _14276_/D _09750_/A1 _14276_/Q _09703_/S VDD VSS sg13g2_mux2_1
XFILLER_39_374 VDD VSS sg13g2_fill_1
XFILLER_39_385 VDD VSS sg13g2_decap_8
XFILLER_54_311 VDD VSS sg13g2_decap_8
XFILLER_27_536 VDD VSS sg13g2_decap_8
X_08635_ _08635_/X _07972_/B _08635_/A1 _07853_/B _07859_/B _08635_/S0 _08635_/S1
+ VDD VSS sg13g2_mux4_1
XFILLER_42_506 VDD VSS sg13g2_decap_8
XFILLER_81_152 VDD VSS sg13g2_decap_8
X_08566_ _08574_/D _08567_/A _08567_/B _08566_/C VDD VSS sg13g2_nor3_1
XFILLER_165_1261 VDD VSS sg13g2_decap_8
XFILLER_23_742 VDD VSS sg13g2_decap_8
XFILLER_120_68 VDD VSS sg13g2_fill_1
X_08497_ _08497_/Y _08497_/A _08497_/B VDD VSS sg13g2_nand2_1
XFILLER_147_7 VDD VSS sg13g2_decap_8
XFILLER_80_28 VDD VSS sg13g2_decap_8
XFILLER_70_1008 VDD VSS sg13g2_fill_2
XFILLER_80_39 VDD VSS sg13g2_fill_2
XFILLER_22_252 VDD VSS sg13g2_decap_8
XFILLER_167_224 VDD VSS sg13g2_decap_8
XFILLER_126_1267 VDD VSS sg13g2_decap_8
X_14077__2102 _14077_/RESET_B VDD VSS sg13g2_tiehi
XFILLER_168_769 VDD VSS sg13g2_decap_4
XFILLER_11_959 VDD VSS sg13g2_decap_8
XFILLER_149_950 VDD VSS sg13g2_decap_8
X_14380__1799 _14380_/RESET_B VDD VSS sg13g2_tiehi
XFILLER_10_469 VDD VSS sg13g2_decap_8
XFILLER_13_77 VDD VSS sg13g2_decap_8
XFILLER_149_994 VDD VSS sg13g2_decap_4
X_09118_ _09118_/Y _09117_/A _10762_/B _09117_/Y VDD VSS sg13g2_o21ai_1
XFILLER_129_77 VDD VSS sg13g2_decap_8
XFILLER_135_121 VDD VSS sg13g2_decap_8
X_10390_ _10392_/C _10378_/D _10387_/X _14821_/Q VDD VSS sg13g2_a21o_1
XFILLER_136_655 VDD VSS sg13g2_decap_4
XFILLER_163_441 VDD VSS sg13g2_decap_8
XFILLER_159_1043 VDD VSS sg13g2_decap_8
X_14717__1462 _14717_/RESET_B VDD VSS sg13g2_tiehi
X_09049_ _09049_/Y _14908_/Q _09056_/C _09051_/A1 VDD VSS sg13g2_o21ai_1
XFILLER_2_602 VDD VSS sg13g2_decap_8
XFILLER_135_176 VDD VSS sg13g2_decap_8
XFILLER_11_1183 VDD VSS sg13g2_decap_8
XFILLER_145_21 VDD VSS sg13g2_decap_8
X_14000__2179 _14000_/RESET_B VDD VSS sg13g2_tiehi
X_12060_ _12060_/Y _12062_/A _12062_/B VDD VSS sg13g2_nand2_1
XFILLER_1_112 VDD VSS sg13g2_decap_8
XFILLER_137_1341 VDD VSS sg13g2_decap_8
XFILLER_137_1352 VDD VSS sg13g2_fill_1
XFILLER_78_915 VDD VSS sg13g2_fill_1
X_11011_ _11011_/Y _11012_/B _11012_/C VDD VSS sg13g2_nor2_1
XFILLER_85_1295 VDD VSS sg13g2_decap_8
XFILLER_46_1246 VDD VSS sg13g2_decap_8
XFILLER_2_679 VDD VSS sg13g2_decap_8
XFILLER_81_1148 VDD VSS sg13g2_decap_8
XFILLER_77_425 VDD VSS sg13g2_decap_8
XFILLER_1_189 VDD VSS sg13g2_decap_8
X_15049__2527 _15049_/RESET_B VDD VSS sg13g2_tiehi
Xfanout950 _13013_/B _07729_/D VDD VSS sg13g2_buf_1
XFILLER_172_1287 VDD VSS sg13g2_decap_8
Xfanout961 _13051_/B _13014_/A2 VDD VSS sg13g2_buf_1
Xfanout972 _11139_/B1 _11206_/A1 VDD VSS sg13g2_buf_1
XFILLER_49_149 VDD VSS sg13g2_decap_8
Xfanout983 _13310_/B2 _15070_/Q VDD VSS sg13g2_buf_1
Xfanout994 _09640_/B _15066_/Q VDD VSS sg13g2_buf_1
XFILLER_38_63 VDD VSS sg13g2_decap_8
XFILLER_161_42 VDD VSS sg13g2_decap_8
XFILLER_79_1000 VDD VSS sg13g2_decap_8
X_12962_ _12962_/Y _12960_/Y _12962_/B _13308_/A VDD VSS sg13g2_nand3b_1
XFILLER_92_439 VDD VSS sg13g2_decap_8
XFILLER_18_525 VDD VSS sg13g2_decap_8
X_14892__2760 _14892_/RESET_B VDD VSS sg13g2_tiehi
XFILLER_85_491 VDD VSS sg13g2_fill_1
X_14701_ _14701_/Q clkload3/A _14701_/D _14701_/RESET_B VDD VSS sg13g2_dfrbpq_1
X_11913_ _11917_/A _11913_/A _11913_/B VDD VSS sg13g2_nor2_1
XFILLER_57_193 VDD VSS sg13g2_fill_2
XFILLER_173_0 VDD VSS sg13g2_decap_8
XFILLER_166_1003 VDD VSS sg13g2_fill_2
XFILLER_79_1055 VDD VSS sg13g2_decap_8
X_12893_ _12925_/B _12894_/A _12894_/B VDD VSS sg13g2_nand2_1
XFILLER_2_1351 VDD VSS sg13g2_decap_8
XFILLER_73_664 VDD VSS sg13g2_decap_8
XFILLER_61_815 VDD VSS sg13g2_decap_4
X_14632_ _14632_/Q _14632_/CLK _14632_/D _14632_/RESET_B VDD VSS sg13g2_dfrbpq_1
X_11844_ _11846_/A _11907_/A _11845_/C _11910_/B VDD VSS sg13g2_o21ai_1
XFILLER_73_697 VDD VSS sg13g2_decap_8
XFILLER_54_51 VDD VSS sg13g2_fill_1
XFILLER_45_399 VDD VSS sg13g2_fill_1
XFILLER_54_73 VDD VSS sg13g2_decap_8
XFILLER_26_591 VDD VSS sg13g2_decap_4
XFILLER_14_742 VDD VSS sg13g2_decap_8
X_14563_ _14563_/Q clkload19/A _14563_/D _14563_/RESET_B VDD VSS sg13g2_dfrbpq_1
X_11775_ _11778_/A _11725_/Y _11772_/Y _11774_/Y VDD VSS sg13g2_o21ai_1
XFILLER_92_1255 VDD VSS sg13g2_decap_8
XFILLER_159_725 VDD VSS sg13g2_fill_2
XFILLER_60_369 VDD VSS sg13g2_fill_1
XFILLER_18_1337 VDD VSS sg13g2_decap_8
XFILLER_13_252 VDD VSS sg13g2_decap_8
X_13514_ _15137_/D _15137_/Q _14994_/Q _13519_/B VDD VSS sg13g2_mux2_1
X_10726_ _10995_/A _14940_/Q _10725_/A _10725_/Y VDD VSS sg13g2_a21oi_1
XFILLER_158_235 VDD VSS sg13g2_decap_8
X_14494_ _14494_/Q clkload38/A _14494_/D _14494_/RESET_B VDD VSS sg13g2_dfrbpq_1
XFILLER_9_245 VDD VSS sg13g2_decap_8
XFILLER_16_1050 VDD VSS sg13g2_decap_8
XFILLER_174_717 VDD VSS sg13g2_decap_8
X_13445_ _15104_/D _15104_/Q _13470_/A2 _13444_/Y VDD VSS sg13g2_a21o_1
XFILLER_139_460 VDD VSS sg13g2_decap_8
X_14210__1969 _14210_/RESET_B VDD VSS sg13g2_tiehi
X_10657_ _10666_/D _14891_/Q _10663_/D VDD VSS sg13g2_and2_1
XFILLER_155_920 VDD VSS sg13g2_decap_8
XFILLER_167_780 VDD VSS sg13g2_fill_2
Xclkload15 clkload15/Y clkload15/A VDD VSS sg13g2_inv_1
XFILLER_173_238 VDD VSS sg13g2_decap_8
Xclkload26 clkload26/Y clkload26/A VDD VSS sg13g2_inv_1
X_13376_ _13376_/Y _13389_/A _13389_/B _13396_/C _13378_/C VDD VSS sg13g2_nor4_1
Xclkload37 clkload37/Y clkload37/A VDD VSS sg13g2_inv_1
XFILLER_62_7 VDD VSS sg13g2_decap_8
XFILLER_154_441 VDD VSS sg13g2_fill_1
XFILLER_155_964 VDD VSS sg13g2_fill_1
X_10588_ _14873_/D _10649_/B _10594_/D _10587_/Y VDD VSS sg13g2_a21oi_1
XFILLER_6_952 VDD VSS sg13g2_decap_8
XFILLER_115_806 VDD VSS sg13g2_fill_1
Xclkload48 clkload48/Y clkload48/A VDD VSS sg13g2_inv_1
Xclkload59 clkload59/X clkload59/A VDD VSS sg13g2_buf_8
XFILLER_86_1026 VDD VSS sg13g2_decap_8
X_15115_ _15115_/Q _15213_/CLK _15115_/D _15115_/RESET_B VDD VSS sg13g2_dfrbpq_1
X_12327_ _12327_/Y _12326_/A1 _13914_/Q VDD VSS sg13g2_nand2b_1
XFILLER_170_923 VDD VSS sg13g2_fill_1
XFILLER_5_462 VDD VSS sg13g2_decap_8
XFILLER_127_699 VDD VSS sg13g2_decap_8
XFILLER_138_1116 VDD VSS sg13g2_fill_1
XFILLER_154_485 VDD VSS sg13g2_decap_8
XFILLER_170_945 VDD VSS sg13g2_decap_8
X_13775__2404 _13775_/RESET_B VDD VSS sg13g2_tiehi
X_15046_ _15046_/Q clkload54/A _15046_/D _15046_/RESET_B VDD VSS sg13g2_dfrbpq_1
X_12258_ _12258_/Y _12254_/Y _12255_/Y _12257_/Y _12256_/Y _12246_/B VDD VSS sg13g2_a221oi_1
X_11209_ _14956_/D _11209_/A _11209_/B VDD VSS sg13g2_nand2_1
XFILLER_96_712 VDD VSS sg13g2_decap_8
XFILLER_64_1346 VDD VSS sg13g2_decap_4
X_12189_ _12190_/A _14710_/Q _14742_/Q _13782_/Q _13814_/Q _12186_/A _12187_/C VDD
+ VSS sg13g2_mux4_1
XFILLER_95_200 VDD VSS sg13g2_decap_4
XFILLER_151_1327 VDD VSS sg13g2_decap_8
XFILLER_64_1379 VDD VSS sg13g2_decap_4
XFILLER_84_918 VDD VSS sg13g2_decap_8
XFILLER_96_789 VDD VSS sg13g2_decap_8
XFILLER_49_661 VDD VSS sg13g2_fill_2
X_14155__2024 _14155_/RESET_B VDD VSS sg13g2_tiehi
XFILLER_95_91 VDD VSS sg13g2_decap_8
XFILLER_7_1295 VDD VSS sg13g2_decap_8
XFILLER_64_620 VDD VSS sg13g2_decap_8
XFILLER_114_1193 VDD VSS sg13g2_decap_4
XFILLER_23_1076 VDD VSS sg13g2_decap_8
XFILLER_3_1148 VDD VSS sg13g2_decap_8
XFILLER_37_867 VDD VSS sg13g2_decap_8
XFILLER_149_1234 VDD VSS sg13g2_decap_8
XFILLER_52_804 VDD VSS sg13g2_decap_8
XFILLER_37_878 VDD VSS sg13g2_fill_2
X_08420_ _08575_/C _08420_/A _08419_/A VDD VSS sg13g2_nor2b_1
XFILLER_91_483 VDD VSS sg13g2_fill_2
XFILLER_63_174 VDD VSS sg13g2_fill_1
X_08351_ _08352_/B _08376_/A3 _08351_/B VDD VSS sg13g2_nand2b_1
XFILLER_71_1306 VDD VSS sg13g2_fill_2
X_08282_ _08282_/Y _08452_/A _08234_/Y _08363_/S0 _08280_/X VDD VSS sg13g2_a22oi_1
XFILLER_32_583 VDD VSS sg13g2_fill_1
Xclkload9 clkload9/Y clkload9/A VDD VSS sg13g2_inv_2
XFILLER_20_756 VDD VSS sg13g2_decap_8
XFILLER_149_279 VDD VSS sg13g2_decap_8
XFILLER_30_1014 VDD VSS sg13g2_decap_8
XFILLER_117_110 VDD VSS sg13g2_decap_8
XFILLER_164_238 VDD VSS sg13g2_decap_8
X_14962__2625 _14962_/RESET_B VDD VSS sg13g2_tiehi
XFILLER_30_1047 VDD VSS sg13g2_fill_1
XFILLER_145_452 VDD VSS sg13g2_decap_8
XFILLER_117_154 VDD VSS sg13g2_fill_1
XFILLER_161_912 VDD VSS sg13g2_decap_8
XFILLER_118_688 VDD VSS sg13g2_decap_8
XFILLER_160_400 VDD VSS sg13g2_decap_8
XFILLER_133_625 VDD VSS sg13g2_decap_8
XFILLER_172_260 VDD VSS sg13g2_decap_8
XFILLER_156_1216 VDD VSS sg13g2_decap_8
XFILLER_172_271 VDD VSS sg13g2_decap_8
XFILLER_105_338 VDD VSS sg13g2_decap_8
XFILLER_161_956 VDD VSS sg13g2_decap_8
X_14365__1814 _14365_/RESET_B VDD VSS sg13g2_tiehi
XFILLER_160_466 VDD VSS sg13g2_fill_1
Xfanout202 _09760_/A1 _09859_/A1 VDD VSS sg13g2_buf_1
Xfanout213 _13253_/B2 _13048_/X VDD VSS sg13g2_buf_1
XFILLER_8_1015 VDD VSS sg13g2_decap_8
Xfanout224 _10154_/A1 _09063_/X VDD VSS sg13g2_buf_1
XFILLER_59_414 VDD VSS sg13g2_decap_4
XFILLER_119_1082 VDD VSS sg13g2_decap_8
Xfanout235 _11980_/A _12126_/A VDD VSS sg13g2_buf_1
XFILLER_115_35 VDD VSS sg13g2_decap_8
Xfanout246 _10084_/A0 _09045_/Y VDD VSS sg13g2_buf_1
XFILLER_101_533 VDD VSS sg13g2_decap_8
Xfanout257 _09884_/A0 _09917_/A1 VDD VSS sg13g2_buf_1
X_09805_ _14394_/D _09937_/A1 _14394_/Q _09805_/S VDD VSS sg13g2_mux2_1
XFILLER_86_233 VDD VSS sg13g2_decap_4
XFILLER_86_244 VDD VSS sg13g2_fill_1
Xfanout279 _09439_/S _09408_/Y VDD VSS sg13g2_buf_1
X_07997_ _07997_/Y _15103_/Q _15090_/Q VDD VSS sg13g2_nor2_1
XFILLER_86_255 VDD VSS sg13g2_fill_1
XFILLER_87_789 VDD VSS sg13g2_decap_8
XFILLER_75_28 VDD VSS sg13g2_decap_4
XFILLER_86_277 VDD VSS sg13g2_decap_8
XFILLER_41_1143 VDD VSS sg13g2_decap_8
X_09736_ _14327_/D _09934_/A1 _14327_/Q _09736_/S VDD VSS sg13g2_mux2_1
XFILLER_55_620 VDD VSS sg13g2_fill_2
XFILLER_28_834 VDD VSS sg13g2_fill_2
X_09667_ _14260_/D _09898_/A0 _14260_/Q _09667_/S VDD VSS sg13g2_mux2_1
XFILLER_43_815 VDD VSS sg13g2_decap_8
X_08618_ _08622_/A _08030_/Y _08537_/X _08637_/B VDD VSS sg13g2_o21ai_1
XFILLER_82_483 VDD VSS sg13g2_decap_8
XFILLER_131_78 VDD VSS sg13g2_decap_8
XFILLER_15_539 VDD VSS sg13g2_decap_8
X_09598_ _14195_/D _14195_/Q _09666_/A0 _09601_/S VDD VSS sg13g2_mux2_1
X_08549_ _08549_/Y _08522_/A _08529_/Y _08548_/Y VDD VSS sg13g2_a21oi_1
XFILLER_24_21 VDD VSS sg13g2_decap_8
XFILLER_168_511 VDD VSS sg13g2_decap_8
XFILLER_39_1072 VDD VSS sg13g2_fill_1
X_13853__2326 _13853_/RESET_B VDD VSS sg13g2_tiehi
XFILLER_126_1053 VDD VSS sg13g2_decap_8
X_11560_ _11560_/Y _11540_/Y _11542_/X _12192_/A VDD VSS sg13g2_o21ai_1
X_13999__2180 _13999_/RESET_B VDD VSS sg13g2_tiehi
X_14869__2806 _14869_/RESET_B VDD VSS sg13g2_tiehi
XFILLER_126_1064 VDD VSS sg13g2_fill_1
XFILLER_23_594 VDD VSS sg13g2_decap_8
XFILLER_11_756 VDD VSS sg13g2_decap_8
XFILLER_156_717 VDD VSS sg13g2_decap_8
X_10511_ _10512_/C _14850_/Q _14845_/Q _14844_/Q _10511_/D VDD VSS sg13g2_nand4_1
XFILLER_24_98 VDD VSS sg13g2_decap_8
XFILLER_155_205 VDD VSS sg13g2_decap_8
XFILLER_168_588 VDD VSS sg13g2_decap_8
X_11491_ _11491_/X _13730_/Q _14082_/Q _14434_/Q _14530_/Q _11493_/S0 _11493_/S1 VDD
+ VSS sg13g2_mux4_1
XFILLER_104_1340 VDD VSS sg13g2_decap_8
XFILLER_109_611 VDD VSS sg13g2_decap_8
XFILLER_109_622 VDD VSS sg13g2_fill_1
XFILLER_10_266 VDD VSS sg13g2_decap_8
XFILLER_149_791 VDD VSS sg13g2_decap_8
XFILLER_137_942 VDD VSS sg13g2_fill_1
X_13230_ _13244_/B _13245_/A _13665_/Q VDD VSS sg13g2_xor2_1
XFILLER_7_749 VDD VSS sg13g2_decap_8
XFILLER_109_644 VDD VSS sg13g2_decap_8
XFILLER_137_953 VDD VSS sg13g2_decap_8
X_10442_ _10444_/A _14837_/Q _10442_/B VDD VSS sg13g2_nand2b_1
XFILLER_87_1302 VDD VSS sg13g2_fill_1
XFILLER_52_1294 VDD VSS sg13g2_decap_8
XFILLER_40_42 VDD VSS sg13g2_decap_8
XFILLER_13_1267 VDD VSS sg13g2_decap_8
XFILLER_6_259 VDD VSS sg13g2_decap_8
XFILLER_108_154 VDD VSS sg13g2_fill_2
XFILLER_156_42 VDD VSS sg13g2_decap_8
X_13161_ _13161_/X input19/X _13205_/A2 _13205_/B1 VDD VSS sg13g2_a21o_1
X_10373_ _10375_/A _14815_/Q _10378_/D _14816_/Q VDD VSS sg13g2_a21o_1
XFILLER_136_485 VDD VSS sg13g2_fill_1
XFILLER_124_636 VDD VSS sg13g2_decap_8
X_12112_ _12112_/Y _12316_/S0 _13940_/Q _12328_/B1 VDD VSS sg13g2_a21oi_1
XFILLER_151_444 VDD VSS sg13g2_fill_2
X_13092_ _13093_/B _13092_/A _13112_/A _13092_/C VDD VSS sg13g2_nand3_1
XFILLER_3_966 VDD VSS sg13g2_decap_8
XFILLER_85_1070 VDD VSS sg13g2_decap_8
XFILLER_151_477 VDD VSS sg13g2_fill_2
X_12043_ _12043_/X _12239_/B _12042_/X _12041_/Y VDD VSS sg13g2_a21o_1
XFILLER_105_883 VDD VSS sg13g2_fill_2
XFILLER_2_476 VDD VSS sg13g2_decap_8
XFILLER_105_894 VDD VSS sg13g2_fill_1
XFILLER_46_1054 VDD VSS sg13g2_decap_8
XFILLER_104_382 VDD VSS sg13g2_fill_2
XFILLER_132_691 VDD VSS sg13g2_decap_8
XFILLER_78_745 VDD VSS sg13g2_decap_8
XFILLER_120_853 VDD VSS sg13g2_decap_8
XFILLER_172_63 VDD VSS sg13g2_decap_8
XFILLER_120_864 VDD VSS sg13g2_fill_2
XFILLER_93_704 VDD VSS sg13g2_decap_8
XFILLER_24_1330 VDD VSS sg13g2_decap_8
XFILLER_1_14 VDD VSS sg13g2_decap_8
Xfanout780 _12553_/S _12692_/S VDD VSS sg13g2_buf_1
Xfanout791 _12663_/S1 _12649_/S0 VDD VSS sg13g2_buf_1
XFILLER_19_812 VDD VSS sg13g2_decap_8
XFILLER_120_897 VDD VSS sg13g2_fill_2
XFILLER_92_214 VDD VSS sg13g2_decap_8
XFILLER_65_428 VDD VSS sg13g2_decap_8
XFILLER_37_119 VDD VSS sg13g2_decap_8
X_13994_ _13994_/Q _14666_/CLK _13994_/D _13994_/RESET_B VDD VSS sg13g2_dfrbpq_1
XFILLER_111_1333 VDD VSS sg13g2_decap_8
XFILLER_18_322 VDD VSS sg13g2_decap_8
X_12945_ _12945_/Y _12945_/A _12988_/B VDD VSS sg13g2_nor2_1
XFILLER_19_889 VDD VSS sg13g2_decap_8
XFILLER_45_174 VDD VSS sg13g2_fill_2
XFILLER_18_399 VDD VSS sg13g2_decap_8
X_12876_ _12878_/B _12876_/A _12877_/C VDD VSS sg13g2_nand2_1
XFILLER_73_494 VDD VSS sg13g2_decap_8
X_14615_ _14615_/Q clkload34/A _14615_/D _14615_/RESET_B VDD VSS sg13g2_dfrbpq_1
X_11827_ _11827_/Y _11823_/Y _11824_/Y _11826_/Y _11825_/Y _11875_/B VDD VSS sg13g2_a221oi_1
XFILLER_144_1120 VDD VSS sg13g2_fill_1
XFILLER_53_1014 VDD VSS sg13g2_fill_2
XFILLER_18_1134 VDD VSS sg13g2_decap_8
XFILLER_144_1142 VDD VSS sg13g2_decap_4
X_14443__1736 _14443_/RESET_B VDD VSS sg13g2_tiehi
X_14546_ _14546_/Q _14706_/CLK _14546_/D _14546_/RESET_B VDD VSS sg13g2_dfrbpq_1
X_11758_ _11760_/A _11759_/A _13898_/Q VDD VSS sg13g2_nand2b_1
XFILLER_92_1085 VDD VSS sg13g2_fill_1
XFILLER_60_188 VDD VSS sg13g2_decap_8
X_13829__2350 _13829_/RESET_B VDD VSS sg13g2_tiehi
X_14589__1590 _14589_/RESET_B VDD VSS sg13g2_tiehi
XFILLER_144_1175 VDD VSS sg13g2_fill_1
XFILLER_147_717 VDD VSS sg13g2_fill_1
X_10709_ _10954_/A _09027_/X _10743_/S _08873_/Y VDD VSS sg13g2_a21oi_1
X_14477_ _14477_/Q clkload10/A _14477_/D _14477_/RESET_B VDD VSS sg13g2_dfrbpq_1
X_11689_ _11689_/X _14120_/Q _14152_/Q _11692_/A VDD VSS sg13g2_mux2_1
XFILLER_31_1323 VDD VSS sg13g2_decap_8
XFILLER_70_1383 VDD VSS sg13g2_fill_1
XFILLER_174_558 VDD VSS sg13g2_decap_8
X_13428_ _15096_/D _13421_/Y _13425_/Y _13427_/Y VDD VSS sg13g2_o21ai_1
XFILLER_174_569 VDD VSS sg13g2_decap_8
XFILLER_127_474 VDD VSS sg13g2_decap_8
X_13359_ _13438_/D _13401_/B _13401_/C VDD VSS sg13g2_nor2b_1
XFILLER_154_282 VDD VSS sg13g2_decap_4
XFILLER_115_669 VDD VSS sg13g2_decap_8
XFILLER_143_978 VDD VSS sg13g2_fill_1
XFILLER_170_775 VDD VSS sg13g2_fill_2
XFILLER_9_1302 VDD VSS sg13g2_decap_8
XFILLER_142_477 VDD VSS sg13g2_fill_2
X_07920_ _07920_/Y _07918_/Y _07871_/X _07911_/Y VDD VSS sg13g2_a21oi_1
X_15029_ _15029_/Q _15226_/CLK _15029_/D _15029_/RESET_B VDD VSS sg13g2_dfrbpq_1
XFILLER_111_820 VDD VSS sg13g2_fill_1
XFILLER_111_831 VDD VSS sg13g2_decap_8
XFILLER_29_1296 VDD VSS sg13g2_decap_8
XFILLER_25_1127 VDD VSS sg13g2_decap_8
XFILLER_110_330 VDD VSS sg13g2_decap_8
X_07851_ _08641_/A _08643_/C _08646_/A VDD VSS sg13g2_nand2_1
XFILLER_69_767 VDD VSS sg13g2_decap_4
XFILLER_64_1187 VDD VSS sg13g2_decap_8
XFILLER_9_1379 VDD VSS sg13g2_decap_4
XFILLER_96_553 VDD VSS sg13g2_fill_2
XFILLER_57_929 VDD VSS sg13g2_decap_8
XFILLER_56_406 VDD VSS sg13g2_decap_8
X_13931__2248 _13931_/RESET_B VDD VSS sg13g2_tiehi
XFILLER_56_417 VDD VSS sg13g2_fill_1
XFILLER_111_897 VDD VSS sg13g2_decap_8
X_14691__1488 _14691_/RESET_B VDD VSS sg13g2_tiehi
XFILLER_68_288 VDD VSS sg13g2_fill_2
XFILLER_28_119 VDD VSS sg13g2_decap_8
Xinput2 input2/X input2/A VDD VSS sg13g2_buf_1
X_07782_ _07784_/B _07782_/A _15002_/Q VDD VSS sg13g2_and2_1
XFILLER_7_1092 VDD VSS sg13g2_decap_8
X_09521_ _14120_/D _09853_/A1 _14120_/Q _09530_/S VDD VSS sg13g2_mux2_1
XFILLER_37_642 VDD VSS sg13g2_decap_8
XFILLER_65_973 VDD VSS sg13g2_decap_8
XFILLER_80_910 VDD VSS sg13g2_decap_8
X_09452_ _14053_/D _09949_/A1 _14053_/Q _09464_/S VDD VSS sg13g2_mux2_1
XFILLER_80_921 VDD VSS sg13g2_fill_1
XFILLER_25_837 VDD VSS sg13g2_decap_8
XFILLER_64_483 VDD VSS sg13g2_decap_8
XFILLER_36_174 VDD VSS sg13g2_decap_4
XFILLER_169_308 VDD VSS sg13g2_decap_8
X_08403_ _08410_/D _15100_/Q _15089_/Q _08574_/B VDD VSS sg13g2_o21ai_1
XFILLER_80_965 VDD VSS sg13g2_decap_8
X_09383_ _13986_/D _10078_/A0 _13986_/Q _09403_/S VDD VSS sg13g2_mux2_1
XFILLER_80_976 VDD VSS sg13g2_fill_1
XFILLER_101_48 VDD VSS sg13g2_decap_8
XFILLER_51_166 VDD VSS sg13g2_decap_8
X_08334_ _08335_/D _08381_/A _08333_/Y _08637_/B _08330_/Y VDD VSS sg13g2_a22oi_1
XFILLER_162_1242 VDD VSS sg13g2_decap_4
XFILLER_75_1294 VDD VSS sg13g2_decap_8
XFILLER_36_1256 VDD VSS sg13g2_decap_4
XFILLER_138_706 VDD VSS sg13g2_decap_8
XFILLER_32_380 VDD VSS sg13g2_decap_8
X_14419__1760 _14419_/RESET_B VDD VSS sg13g2_tiehi
X_08265_ _08265_/X _08265_/A _08265_/B _08319_/A _08319_/C VDD VSS sg13g2_or4_1
XFILLER_20_553 VDD VSS sg13g2_decap_8
XFILLER_137_216 VDD VSS sg13g2_decap_8
XFILLER_165_525 VDD VSS sg13g2_decap_8
X_08196_ _08196_/Y _08194_/B _08079_/X _08688_/A VDD VSS sg13g2_o21ai_1
XFILLER_106_603 VDD VSS sg13g2_decap_8
XFILLER_106_614 VDD VSS sg13g2_fill_2
XFILLER_134_934 VDD VSS sg13g2_decap_4
XFILLER_106_636 VDD VSS sg13g2_fill_1
XFILLER_173_591 VDD VSS sg13g2_fill_1
XFILLER_105_135 VDD VSS sg13g2_decap_8
XFILLER_10_56 VDD VSS sg13g2_decap_8
XFILLER_161_764 VDD VSS sg13g2_decap_8
XFILLER_69_1098 VDD VSS sg13g2_decap_8
XFILLER_160_252 VDD VSS sg13g2_decap_8
XFILLER_105_179 VDD VSS sg13g2_decap_8
Xfanout1008 _09100_/B _09154_/B VDD VSS sg13g2_buf_1
XFILLER_0_947 VDD VSS sg13g2_decap_8
Xfanout1019 _13412_/B _15057_/Q VDD VSS sg13g2_buf_1
XFILLER_82_1265 VDD VSS sg13g2_decap_8
XFILLER_82_1276 VDD VSS sg13g2_fill_2
XFILLER_19_21 VDD VSS sg13g2_decap_8
XFILLER_134_1366 VDD VSS sg13g2_fill_1
XFILLER_59_266 VDD VSS sg13g2_decap_8
XFILLER_47_406 VDD VSS sg13g2_decap_8
XFILLER_47_417 VDD VSS sg13g2_decap_8
XFILLER_59_277 VDD VSS sg13g2_decap_8
X_14521__1658 _14521_/RESET_B VDD VSS sg13g2_tiehi
XFILLER_19_119 VDD VSS sg13g2_decap_8
X_13907__2272 _13907_/RESET_B VDD VSS sg13g2_tiehi
XFILLER_56_940 VDD VSS sg13g2_decap_8
XFILLER_19_98 VDD VSS sg13g2_decap_8
X_09719_ _14310_/D _09917_/A1 _14310_/Q _09730_/S VDD VSS sg13g2_mux2_1
X_10991_ _10992_/B _10979_/Y _10978_/B _10974_/Y VDD VSS sg13g2_o21ai_1
XFILLER_142_99 VDD VSS sg13g2_decap_8
XFILLER_16_826 VDD VSS sg13g2_decap_8
X_14775__2938 _14775_/RESET_B VDD VSS sg13g2_tiehi
XFILLER_83_781 VDD VSS sg13g2_decap_8
X_12730_ _12730_/X _13846_/Q _13878_/Q _13910_/Q _13942_/Q _12731_/S0 _12731_/S1 VDD
+ VSS sg13g2_mux4_1
XFILLER_55_483 VDD VSS sg13g2_decap_8
XFILLER_15_336 VDD VSS sg13g2_decap_8
XFILLER_35_42 VDD VSS sg13g2_decap_8
XFILLER_27_196 VDD VSS sg13g2_decap_8
X_12661_ _12661_/X _14257_/Q _14289_/Q _14321_/Q _14353_/Q _12661_/S0 _12661_/S1 VDD
+ VSS sg13g2_mux4_1
XFILLER_43_667 VDD VSS sg13g2_decap_8
XFILLER_169_820 VDD VSS sg13g2_decap_8
XFILLER_54_1312 VDD VSS sg13g2_decap_8
XFILLER_42_155 VDD VSS sg13g2_decap_4
X_14400_ _14400_/Q clkload27/A _14400_/D _14400_/RESET_B VDD VSS sg13g2_dfrbpq_1
X_11612_ _11612_/Y _11759_/A _14502_/Q _11690_/B VDD VSS sg13g2_a21oi_1
X_12592_ _12592_/X _14700_/Q _14732_/Q _13772_/Q _13804_/Q _12592_/S0 _12592_/S1 VDD
+ VSS sg13g2_mux4_1
XFILLER_141_1326 VDD VSS sg13g2_decap_8
XFILLER_11_553 VDD VSS sg13g2_decap_8
XFILLER_136_0 VDD VSS sg13g2_decap_8
X_14331_ _14331_/Q _14885_/CLK _14331_/D _14331_/RESET_B VDD VSS sg13g2_dfrbpq_1
X_11543_ _11543_/Y _12014_/S _14372_/Q VDD VSS sg13g2_nand2b_1
XFILLER_168_385 VDD VSS sg13g2_decap_8
XFILLER_156_536 VDD VSS sg13g2_fill_2
X_14262_ _14262_/Q clkload28/A _14262_/D _14262_/RESET_B VDD VSS sg13g2_dfrbpq_1
XFILLER_7_546 VDD VSS sg13g2_decap_8
XFILLER_52_1080 VDD VSS sg13g2_decap_8
X_11474_ _11475_/B _11471_/X _11470_/X _11467_/X _11466_/X _12214_/B _11559_/C VDD
+ VSS sg13g2_mux4_1
XFILLER_167_63 VDD VSS sg13g2_decap_8
XFILLER_13_1064 VDD VSS sg13g2_decap_8
X_13213_ _13215_/A _14921_/Q _13666_/Q VDD VSS sg13g2_xor2_1
X_10425_ _10538_/A _10647_/A _10510_/B VDD VSS sg13g2_nand2_1
X_14193_ _14193_/Q _14667_/CLK _14193_/D _14193_/RESET_B VDD VSS sg13g2_dfrbpq_1
XFILLER_124_422 VDD VSS sg13g2_fill_2
XFILLER_139_1244 VDD VSS sg13g2_decap_8
X_13144_ _13145_/A _13146_/A _13146_/C VDD VSS sg13g2_nand2_1
X_10356_ _10364_/C _10400_/A _10397_/B _10395_/A VDD VSS sg13g2_nor3_1
XFILLER_98_807 VDD VSS sg13g2_decap_8
XFILLER_87_1198 VDD VSS sg13g2_decap_8
XFILLER_3_763 VDD VSS sg13g2_decap_8
XFILLER_140_948 VDD VSS sg13g2_fill_1
X_13075_ _13172_/B _14911_/Q _13676_/Q VDD VSS sg13g2_xor2_1
X_10287_ _10298_/D _14788_/Q _14789_/Q _14790_/Q _10305_/B VDD VSS sg13g2_and4_1
XFILLER_97_339 VDD VSS sg13g2_decap_8
XFILLER_2_273 VDD VSS sg13g2_decap_8
XFILLER_111_149 VDD VSS sg13g2_fill_2
X_12026_ _12027_/B _12026_/A _12026_/B _12026_/C VDD VSS sg13g2_nand3_1
XFILLER_61_1327 VDD VSS sg13g2_decap_8
XFILLER_61_1338 VDD VSS sg13g2_fill_1
XFILLER_25_7 VDD VSS sg13g2_decap_8
XFILLER_93_501 VDD VSS sg13g2_decap_8
XFILLER_65_214 VDD VSS sg13g2_decap_8
XFILLER_38_428 VDD VSS sg13g2_decap_8
XFILLER_4_1232 VDD VSS sg13g2_decap_8
XFILLER_65_258 VDD VSS sg13g2_decap_8
X_13977_ _13977_/Q _14649_/CLK _13977_/D _13977_/RESET_B VDD VSS sg13g2_dfrbpq_1
XFILLER_47_984 VDD VSS sg13g2_decap_8
XFILLER_0_1129 VDD VSS sg13g2_decap_8
XFILLER_20_1057 VDD VSS sg13g2_decap_8
XFILLER_19_686 VDD VSS sg13g2_decap_8
X_12928_ _12928_/X _12988_/A _12928_/B VDD VSS sg13g2_xor2_1
XFILLER_98_1294 VDD VSS sg13g2_decap_8
XFILLER_94_1147 VDD VSS sg13g2_fill_1
XFILLER_59_1267 VDD VSS sg13g2_decap_8
XFILLER_18_196 VDD VSS sg13g2_decap_8
XFILLER_33_133 VDD VSS sg13g2_fill_2
XFILLER_62_976 VDD VSS sg13g2_decap_8
X_14676__1503 _14676_/RESET_B VDD VSS sg13g2_tiehi
XFILLER_61_453 VDD VSS sg13g2_fill_2
X_12859_ _12861_/B _12859_/A _13689_/Q VDD VSS sg13g2_xnor2_1
XFILLER_61_486 VDD VSS sg13g2_decap_8
X_14529_ _14529_/Q _14681_/CLK _14529_/D _14529_/RESET_B VDD VSS sg13g2_dfrbpq_1
XFILLER_159_385 VDD VSS sg13g2_decap_8
X_08050_ _08242_/A _15102_/Q _15094_/Q _08048_/B VDD VSS sg13g2_o21ai_1
XFILLER_31_1120 VDD VSS sg13g2_decap_8
XFILLER_157_1300 VDD VSS sg13g2_decap_8
XFILLER_127_271 VDD VSS sg13g2_fill_1
XFILLER_31_1197 VDD VSS sg13g2_decap_8
XFILLER_51_0 VDD VSS sg13g2_decap_8
XFILLER_66_1227 VDD VSS sg13g2_decap_8
XFILLER_89_818 VDD VSS sg13g2_decap_4
X_14853__2838 _14853_/RESET_B VDD VSS sg13g2_tiehi
XFILLER_131_926 VDD VSS sg13g2_fill_2
Xhold3105 _13626_/A _13734_/Q VDD VSS sg13g2_dlygate4sd3_1
Xhold3116 _10837_/A _14930_/Q VDD VSS sg13g2_dlygate4sd3_1
Xhold3127 _13618_/A _13726_/Q VDD VSS sg13g2_dlygate4sd3_1
Xhold3138 hold3138/X _15105_/Q VDD VSS sg13g2_dlygate4sd3_1
X_08952_ _08952_/Y _13608_/A1 _08835_/B _16883_/A VDD VSS sg13g2_a21oi_1
XFILLER_131_959 VDD VSS sg13g2_decap_8
XFILLER_69_520 VDD VSS sg13g2_decap_8
Xhold3149 _13519_/A _15140_/Q VDD VSS sg13g2_dlygate4sd3_1
XFILLER_97_840 VDD VSS sg13g2_decap_8
X_07903_ _08402_/B _08063_/A _07903_/B VDD VSS sg13g2_nand2_1
X_08883_ _13704_/D _16866_/A _08882_/X _08892_/S VDD VSS sg13g2_mux2_1
XFILLER_9_1176 VDD VSS sg13g2_decap_8
XFILLER_84_501 VDD VSS sg13g2_fill_2
X_07834_ _07974_/D _07834_/A _07834_/B VDD VSS sg13g2_nor2_1
XFILLER_5_1029 VDD VSS sg13g2_decap_8
XFILLER_111_694 VDD VSS sg13g2_decap_8
XFILLER_96_383 VDD VSS sg13g2_decap_4
XFILLER_29_439 VDD VSS sg13g2_decap_8
XFILLER_99_1047 VDD VSS sg13g2_decap_8
XFILLER_56_258 VDD VSS sg13g2_decap_8
X_07765_ _15215_/D _15099_/Q _15088_/Q _15076_/Q VDD VSS sg13g2_or3_1
XFILLER_112_14 VDD VSS sg13g2_decap_8
XFILLER_38_973 VDD VSS sg13g2_decap_8
XFILLER_72_729 VDD VSS sg13g2_fill_2
X_09504_ _14104_/D _10167_/A1 _14104_/Q _09504_/S VDD VSS sg13g2_mux2_1
X_14937__2670 _14937_/RESET_B VDD VSS sg13g2_tiehi
X_07696_ _15203_/D _07696_/A _07696_/B _07696_/C VDD VSS sg13g2_nand3_1
XFILLER_80_740 VDD VSS sg13g2_decap_8
X_09435_ _14037_/D _10097_/A0 _14037_/Q _09436_/S VDD VSS sg13g2_mux2_1
XFILLER_24_133 VDD VSS sg13g2_decap_8
XFILLER_169_105 VDD VSS sg13g2_decap_8
XFILLER_80_762 VDD VSS sg13g2_decap_8
X_09366_ _13970_/D _09630_/A0 _13970_/Q _09374_/S VDD VSS sg13g2_mux2_1
XFILLER_123_1001 VDD VSS sg13g2_fill_2
XFILLER_21_840 VDD VSS sg13g2_decap_8
XFILLER_162_1061 VDD VSS sg13g2_decap_4
X_08317_ _08418_/A _08315_/Y _08318_/D _08316_/Y VDD VSS sg13g2_a21oi_1
XFILLER_36_1064 VDD VSS sg13g2_fill_2
X_09297_ _13905_/D _13905_/Q _10160_/A1 _09297_/S VDD VSS sg13g2_mux2_1
XFILLER_36_1086 VDD VSS sg13g2_fill_1
XFILLER_20_350 VDD VSS sg13g2_decap_8
XFILLER_165_322 VDD VSS sg13g2_decap_8
X_08248_ _08248_/Y _08248_/A _08319_/A _08319_/C VDD VSS sg13g2_nor3_1
XFILLER_14_1351 VDD VSS sg13g2_decap_8
XFILLER_10_1204 VDD VSS sg13g2_decap_8
XFILLER_107_923 VDD VSS sg13g2_decap_8
XFILLER_165_399 VDD VSS sg13g2_decap_8
X_08179_ _08179_/Y _08402_/C _08066_/Y _08178_/Y VDD VSS sg13g2_o21ai_1
XFILLER_21_77 VDD VSS sg13g2_decap_8
X_10210_ _10210_/Y _13600_/C _14749_/Q input1/X _10210_/D VDD VSS sg13g2_nand4_1
X_11190_ _11205_/B _11190_/A _11199_/B _11190_/C VDD VSS sg13g2_nor3_1
XFILLER_122_915 VDD VSS sg13g2_decap_4
XFILLER_137_88 VDD VSS sg13g2_decap_4
XFILLER_106_466 VDD VSS sg13g2_fill_2
XFILLER_161_561 VDD VSS sg13g2_decap_8
XFILLER_161_572 VDD VSS sg13g2_fill_2
X_10141_ _14718_/D _14718_/Q _10141_/A1 _10163_/S VDD VSS sg13g2_mux2_1
XFILLER_121_425 VDD VSS sg13g2_fill_1
XFILLER_133_285 VDD VSS sg13g2_decap_8
X_14829__2884 _14829_/RESET_B VDD VSS sg13g2_tiehi
XFILLER_0_744 VDD VSS sg13g2_decap_8
XFILLER_153_21 VDD VSS sg13g2_decap_8
XFILLER_134_1130 VDD VSS sg13g2_fill_2
X_10072_ _14652_/D _10072_/A0 _14652_/Q _10096_/S VDD VSS sg13g2_mux2_1
XFILLER_43_1024 VDD VSS sg13g2_fill_1
XFILLER_94_309 VDD VSS sg13g2_decap_8
XFILLER_130_970 VDD VSS sg13g2_decap_4
XFILLER_102_672 VDD VSS sg13g2_decap_8
XFILLER_88_895 VDD VSS sg13g2_decap_8
X_13900_ _13900_/Q clkload36/A _13900_/D _13900_/RESET_B VDD VSS sg13g2_dfrbpq_1
XFILLER_130_1016 VDD VSS sg13g2_decap_8
XFILLER_153_98 VDD VSS sg13g2_decap_8
X_14880_ _14880_/Q _14885_/CLK _14880_/D _14880_/RESET_B VDD VSS sg13g2_dfrbpq_1
XFILLER_75_534 VDD VSS sg13g2_decap_8
XFILLER_48_748 VDD VSS sg13g2_decap_8
XFILLER_169_1226 VDD VSS sg13g2_decap_8
X_13831_ _13831_/Q _14727_/CLK _13831_/D _13831_/RESET_B VDD VSS sg13g2_dfrbpq_1
XFILLER_63_707 VDD VSS sg13g2_decap_8
XFILLER_60_1382 VDD VSS sg13g2_fill_2
XFILLER_35_409 VDD VSS sg13g2_fill_2
XFILLER_21_1344 VDD VSS sg13g2_decap_8
XFILLER_46_63 VDD VSS sg13g2_decap_8
XFILLER_90_526 VDD VSS sg13g2_fill_2
XFILLER_16_623 VDD VSS sg13g2_decap_8
X_13762_ _13762_/Q _14722_/CLK _13762_/D _13762_/RESET_B VDD VSS sg13g2_dfrbpq_1
X_10974_ _10974_/Y _10995_/A _15115_/Q VDD VSS sg13g2_nand2b_1
XFILLER_44_943 VDD VSS sg13g2_decap_4
XFILLER_15_133 VDD VSS sg13g2_decap_8
XFILLER_43_442 VDD VSS sg13g2_decap_8
X_12713_ _12713_/X _13749_/Q _14101_/Q _14453_/Q _14549_/Q _12715_/S0 _12715_/S1 VDD
+ VSS sg13g2_mux4_1
XFILLER_91_1309 VDD VSS sg13g2_decap_8
XFILLER_44_976 VDD VSS sg13g2_fill_2
X_13693_ _16855_/A _15214_/CLK _13693_/D _13693_/RESET_B VDD VSS sg13g2_dfrbpq_1
XFILLER_54_1120 VDD VSS sg13g2_decap_4
X_12644_ _12644_/X _14576_/Q _14608_/Q _14640_/Q _14672_/Q _12758_/S0 _12758_/S1 VDD
+ VSS sg13g2_mux4_1
XFILLER_31_659 VDD VSS sg13g2_fill_1
XFILLER_12_840 VDD VSS sg13g2_decap_8
XFILLER_141_1101 VDD VSS sg13g2_decap_8
XFILLER_157_812 VDD VSS sg13g2_fill_1
XFILLER_62_84 VDD VSS sg13g2_decap_8
XFILLER_169_683 VDD VSS sg13g2_decap_8
XFILLER_54_1164 VDD VSS sg13g2_decap_4
XFILLER_141_1123 VDD VSS sg13g2_decap_8
X_12575_ _12575_/X _13835_/Q _13867_/Q _13899_/Q _13931_/Q _12660_/S0 _12660_/S1 VDD
+ VSS sg13g2_mux4_1
XFILLER_19_1295 VDD VSS sg13g2_decap_8
XFILLER_11_350 VDD VSS sg13g2_decap_8
XFILLER_157_845 VDD VSS sg13g2_fill_1
XFILLER_15_1148 VDD VSS sg13g2_decap_8
XFILLER_168_182 VDD VSS sg13g2_decap_8
XFILLER_8_833 VDD VSS sg13g2_decap_8
XFILLER_129_547 VDD VSS sg13g2_decap_8
X_14314_ _14314_/Q clkload12/A _14314_/D _14314_/RESET_B VDD VSS sg13g2_dfrbpq_1
XFILLER_7_35 VDD VSS sg13g2_decap_8
XFILLER_141_1167 VDD VSS sg13g2_fill_2
X_11526_ _11636_/B _11526_/A _12942_/B VDD VSS sg13g2_xor2_1
XFILLER_7_343 VDD VSS sg13g2_decap_8
XFILLER_141_1189 VDD VSS sg13g2_decap_8
XFILLER_116_219 VDD VSS sg13g2_decap_8
X_14245_ _14245_/Q _14725_/CLK _14245_/D _14245_/RESET_B VDD VSS sg13g2_dfrbpq_1
X_14990__2597 _14990_/RESET_B VDD VSS sg13g2_tiehi
X_11457_ _11457_/Y _11457_/A _11457_/B _11457_/C VDD VSS sg13g2_nand3_1
X_10408_ _10408_/Y _14825_/Q _10406_/A _10392_/B VDD VSS sg13g2_o21ai_1
X_14176_ _14176_/Q clkload30/A _14176_/D _14176_/RESET_B VDD VSS sg13g2_dfrbpq_1
XFILLER_171_369 VDD VSS sg13g2_decap_8
X_11388_ _11388_/Y _11418_/A _13823_/Q VDD VSS sg13g2_nand2b_1
XFILLER_152_561 VDD VSS sg13g2_decap_8
XFILLER_139_1063 VDD VSS sg13g2_decap_8
XFILLER_125_797 VDD VSS sg13g2_decap_8
XFILLER_3_560 VDD VSS sg13g2_decap_8
X_13127_ _15041_/D _13155_/A _13127_/B VDD VSS sg13g2_nor2_1
X_10339_ _10357_/D _10345_/C _10345_/D VDD VSS sg13g2_and2_1
XFILLER_98_637 VDD VSS sg13g2_decap_8
XFILLER_140_734 VDD VSS sg13g2_fill_2
X_14393__1786 _14393_/RESET_B VDD VSS sg13g2_tiehi
XFILLER_124_296 VDD VSS sg13g2_decap_8
XFILLER_140_756 VDD VSS sg13g2_decap_4
XFILLER_97_147 VDD VSS sg13g2_decap_4
X_13058_ _13058_/Y _13058_/A _13058_/B _13058_/C _13058_/D VDD VSS sg13g2_nand4_1
XFILLER_79_862 VDD VSS sg13g2_decap_4
XFILLER_6_1316 VDD VSS sg13g2_decap_8
XFILLER_61_1135 VDD VSS sg13g2_decap_8
XFILLER_113_1203 VDD VSS sg13g2_decap_8
XFILLER_152_1252 VDD VSS sg13g2_decap_4
XFILLER_78_361 VDD VSS sg13g2_fill_1
Xfanout1350 _12138_/S0 fanout1358/X VDD VSS sg13g2_buf_1
X_12009_ _12010_/B _12009_/A _13670_/Q VDD VSS sg13g2_nand2_1
XFILLER_61_1146 VDD VSS sg13g2_fill_1
XFILLER_39_726 VDD VSS sg13g2_fill_2
XFILLER_26_1266 VDD VSS sg13g2_decap_8
XFILLER_121_992 VDD VSS sg13g2_decap_8
XFILLER_152_1274 VDD VSS sg13g2_decap_8
Xfanout1361 _12286_/S0 _12288_/S0 VDD VSS sg13g2_buf_1
Xfanout1372 _10661_/A _10667_/A VDD VSS sg13g2_buf_1
XFILLER_61_1179 VDD VSS sg13g2_fill_2
XFILLER_120_491 VDD VSS sg13g2_fill_1
Xfanout1383 _13239_/A _13266_/A VDD VSS sg13g2_buf_1
Xfanout1394 _10499_/C _13005_/C VDD VSS sg13g2_buf_1
X_14013__2166 _14013_/RESET_B VDD VSS sg13g2_tiehi
XFILLER_53_206 VDD VSS sg13g2_fill_2
XFILLER_19_483 VDD VSS sg13g2_decap_8
XFILLER_81_559 VDD VSS sg13g2_decap_8
XFILLER_146_1012 VDD VSS sg13g2_decap_4
XFILLER_146_1023 VDD VSS sg13g2_fill_1
XFILLER_62_773 VDD VSS sg13g2_decap_8
XFILLER_22_615 VDD VSS sg13g2_decap_8
X_09220_ _13831_/D _09720_/A0 _13831_/Q _09238_/S VDD VSS sg13g2_mux2_1
XFILLER_34_486 VDD VSS sg13g2_fill_2
XFILLER_61_272 VDD VSS sg13g2_decap_8
XFILLER_22_637 VDD VSS sg13g2_decap_8
XFILLER_146_1067 VDD VSS sg13g2_fill_2
XFILLER_167_609 VDD VSS sg13g2_decap_8
XFILLER_99_0 VDD VSS sg13g2_decap_8
XFILLER_61_283 VDD VSS sg13g2_fill_2
XFILLER_21_147 VDD VSS sg13g2_decap_8
XFILLER_166_119 VDD VSS sg13g2_decap_8
X_13881__2298 _13881_/RESET_B VDD VSS sg13g2_tiehi
X_09151_ _09151_/Y _09162_/A _09151_/B _09156_/B VDD VSS sg13g2_nand3_1
XFILLER_159_182 VDD VSS sg13g2_decap_8
XFILLER_30_670 VDD VSS sg13g2_fill_2
X_08102_ _08103_/C _08142_/C _07910_/B _07879_/A _07912_/B _08033_/A _08063_/A VDD
+ VSS sg13g2_mux4_1
X_09082_ _09082_/Y _09090_/A _09082_/B _09087_/B VDD VSS sg13g2_nand3_1
XFILLER_163_826 VDD VSS sg13g2_fill_2
X_08033_ _08036_/A _08033_/A _08402_/B VDD VSS sg13g2_nor2_1
XFILLER_163_848 VDD VSS sg13g2_fill_2
XFILLER_128_580 VDD VSS sg13g2_decap_8
XFILLER_147_399 VDD VSS sg13g2_fill_2
XFILLER_116_753 VDD VSS sg13g2_decap_4
XFILLER_162_369 VDD VSS sg13g2_decap_8
XFILLER_107_14 VDD VSS sg13g2_decap_8
XFILLER_118_1103 VDD VSS sg13g2_fill_2
XFILLER_143_561 VDD VSS sg13g2_fill_2
XFILLER_157_1152 VDD VSS sg13g2_fill_1
XFILLER_116_797 VDD VSS sg13g2_decap_8
XFILLER_131_734 VDD VSS sg13g2_decap_8
XFILLER_27_1019 VDD VSS sg13g2_decap_8
XFILLER_103_436 VDD VSS sg13g2_decap_8
X_14223__1956 _14223_/RESET_B VDD VSS sg13g2_tiehi
X_09984_ _14567_/D _09984_/A0 _14567_/Q _09999_/S VDD VSS sg13g2_mux2_1
XFILLER_89_659 VDD VSS sg13g2_fill_2
XFILLER_83_1360 VDD VSS sg13g2_fill_1
Xclkbuf_leaf_62_clk_i clkload69/A clkbuf_leaf_62_clk_i/A VDD VSS sg13g2_buf_8
X_08935_ _13717_/D _16879_/A _08934_/X _08941_/S VDD VSS sg13g2_mux2_1
XFILLER_170_1341 VDD VSS sg13g2_decap_8
XFILLER_131_1303 VDD VSS sg13g2_decap_4
XFILLER_69_372 VDD VSS sg13g2_fill_1
X_08866_ _08866_/X _15030_/Q _10694_/S _08865_/Y VDD VSS sg13g2_a21o_1
XFILLER_85_843 VDD VSS sg13g2_decap_8
XFILLER_123_35 VDD VSS sg13g2_decap_8
XFILLER_57_567 VDD VSS sg13g2_decap_8
X_07817_ _08527_/A _15010_/Q _07818_/B VDD VSS sg13g2_xor2_1
XFILLER_45_718 VDD VSS sg13g2_fill_1
X_08797_ _08799_/A _10797_/A _14755_/Q _08727_/X _15198_/Q _13490_/B VDD VSS sg13g2_a221oi_1
XFILLER_84_364 VDD VSS sg13g2_decap_8
XFILLER_83_28 VDD VSS sg13g2_decap_8
Xclkbuf_leaf_77_clk_i clkload43/A clkbuf_leaf_77_clk_i/A VDD VSS sg13g2_buf_8
XFILLER_83_39 VDD VSS sg13g2_fill_1
XFILLER_44_228 VDD VSS sg13g2_decap_8
X_07748_ _07748_/Y _11241_/A _07748_/B _13499_/C _13300_/A VDD VSS sg13g2_nand4_1
XFILLER_77_1142 VDD VSS sg13g2_decap_8
XFILLER_26_965 VDD VSS sg13g2_decap_8
XFILLER_129_1243 VDD VSS sg13g2_decap_8
X_07679_ _07679_/Y _15084_/Q _15085_/Q _15083_/Q _07679_/D VDD VSS sg13g2_nor4_1
XFILLER_25_475 VDD VSS sg13g2_fill_2
XFILLER_164_1145 VDD VSS sg13g2_decap_8
XFILLER_16_77 VDD VSS sg13g2_decap_8
XFILLER_73_1039 VDD VSS sg13g2_decap_8
XFILLER_13_637 VDD VSS sg13g2_decap_8
X_14168__2011 _14168_/RESET_B VDD VSS sg13g2_tiehi
X_09418_ _14020_/D _10147_/A1 _14020_/Q _09436_/S VDD VSS sg13g2_mux2_1
X_10690_ _14899_/D _07705_/B _10876_/A _10689_/Y VDD VSS sg13g2_o21ai_1
X_13683__2506 _13683_/RESET_B VDD VSS sg13g2_tiehi
XFILLER_12_147 VDD VSS sg13g2_decap_8
XFILLER_157_119 VDD VSS sg13g2_decap_8
XFILLER_90_1353 VDD VSS sg13g2_fill_2
XFILLER_51_1304 VDD VSS sg13g2_fill_2
X_13711__2468 _13711_/RESET_B VDD VSS sg13g2_tiehi
XFILLER_32_21 VDD VSS sg13g2_decap_8
X_09349_ _13953_/D _09448_/A0 _13953_/Q _09370_/S VDD VSS sg13g2_mux2_1
XFILLER_138_322 VDD VSS sg13g2_fill_2
XFILLER_148_21 VDD VSS sg13g2_decap_8
X_12360_ _14989_/D _13550_/A1 _12443_/A2 _12359_/Y _12356_/Y VDD VSS sg13g2_a22oi_1
X_11311_ _11311_/Y _11307_/Y _11308_/Y _11310_/Y _11309_/Y _12092_/C VDD VSS sg13g2_a221oi_1
XFILLER_32_98 VDD VSS sg13g2_decap_8
XFILLER_10_1001 VDD VSS sg13g2_decap_8
Xclkbuf_leaf_15_clk_i _14706_/CLK clkbuf_5_6__f_clk_i/X VDD VSS sg13g2_buf_8
X_12291_ _12292_/B _12291_/A _12291_/B VDD VSS sg13g2_nor2_1
XFILLER_5_847 VDD VSS sg13g2_decap_8
XFILLER_165_196 VDD VSS sg13g2_decap_8
X_14030_ _14030_/Q clkload37/A _14030_/D _14030_/RESET_B VDD VSS sg13g2_dfrbpq_1
XFILLER_88_1260 VDD VSS sg13g2_decap_8
X_11242_ _13298_/B _13300_/C _13312_/A VDD VSS sg13g2_nor2_1
XFILLER_153_369 VDD VSS sg13g2_decap_8
XFILLER_4_357 VDD VSS sg13g2_decap_8
XFILLER_49_1233 VDD VSS sg13g2_fill_1
XFILLER_101_1184 VDD VSS sg13g2_fill_2
XFILLER_106_241 VDD VSS sg13g2_fill_2
XFILLER_10_1078 VDD VSS sg13g2_decap_8
XFILLER_122_701 VDD VSS sg13g2_decap_8
XFILLER_106_274 VDD VSS sg13g2_fill_2
XFILLER_107_797 VDD VSS sg13g2_decap_8
XFILLER_164_42 VDD VSS sg13g2_decap_8
XFILLER_122_734 VDD VSS sg13g2_decap_8
X_11173_ _11173_/Y _11150_/B _11173_/B _11173_/C VDD VSS sg13g2_nand3b_1
XFILLER_121_211 VDD VSS sg13g2_decap_8
XFILLER_161_380 VDD VSS sg13g2_decap_8
XFILLER_45_1119 VDD VSS sg13g2_decap_8
X_10124_ _14702_/D _10157_/A1 _14702_/Q _10136_/S VDD VSS sg13g2_mux2_1
XFILLER_136_1269 VDD VSS sg13g2_decap_8
XFILLER_121_255 VDD VSS sg13g2_fill_1
X_14975__2612 _14975_/RESET_B VDD VSS sg13g2_tiehi
XFILLER_0_574 VDD VSS sg13g2_decap_8
XFILLER_88_670 VDD VSS sg13g2_decap_8
X_14932_ _14932_/Q _15226_/CLK _14932_/D _14932_/RESET_B VDD VSS sg13g2_dfrbpq_1
X_10055_ _14636_/D _10088_/A0 _14636_/Q _10063_/S VDD VSS sg13g2_mux2_1
XFILLER_48_556 VDD VSS sg13g2_fill_1
X_14863_ _14863_/Q clkload50/A _14863_/D _14863_/RESET_B VDD VSS sg13g2_dfrbpq_1
X_14378__1801 _14378_/RESET_B VDD VSS sg13g2_tiehi
XFILLER_35_206 VDD VSS sg13g2_fill_1
XFILLER_17_910 VDD VSS sg13g2_decap_8
XFILLER_35_217 VDD VSS sg13g2_decap_4
XFILLER_21_1141 VDD VSS sg13g2_decap_8
XFILLER_112_1280 VDD VSS sg13g2_decap_8
X_13814_ _13814_/Q clkload28/A _13814_/D _13814_/RESET_B VDD VSS sg13g2_dfrbpq_1
XFILLER_112_1291 VDD VSS sg13g2_fill_2
XFILLER_169_1078 VDD VSS sg13g2_decap_8
XFILLER_16_420 VDD VSS sg13g2_decap_8
X_14794_ _14794_/Q clkload51/A _14794_/D _14794_/RESET_B VDD VSS sg13g2_dfrbpq_1
XFILLER_63_559 VDD VSS sg13g2_fill_2
XFILLER_1_1246 VDD VSS sg13g2_decap_8
XFILLER_113_90 VDD VSS sg13g2_fill_1
XFILLER_44_740 VDD VSS sg13g2_decap_8
XFILLER_56_1204 VDD VSS sg13g2_decap_8
X_13745_ _13745_/Q _14737_/CLK _13745_/D _13745_/RESET_B VDD VSS sg13g2_dfrbpq_1
XFILLER_17_987 VDD VSS sg13g2_decap_8
X_10957_ _10957_/Y _10954_/C _11045_/A2 _11193_/B1 VDD VSS sg13g2_a21oi_1
XFILLER_43_250 VDD VSS sg13g2_decap_8
XFILLER_147_1354 VDD VSS sg13g2_decap_8
XFILLER_44_795 VDD VSS sg13g2_fill_1
XFILLER_32_935 VDD VSS sg13g2_decap_4
XFILLER_16_497 VDD VSS sg13g2_decap_8
XFILLER_92_7 VDD VSS sg13g2_decap_8
XFILLER_31_434 VDD VSS sg13g2_decap_8
X_13676_ _13676_/Q _15188_/CLK _13676_/D _13676_/RESET_B VDD VSS sg13g2_dfrbpq_1
XFILLER_108_1349 VDD VSS sg13g2_fill_2
X_10888_ _10888_/Y _10923_/A _14755_/Q VDD VSS sg13g2_nor2b_1
X_12627_ _12627_/X _13967_/Q _13999_/Q _14031_/Q _14063_/Q _12633_/S0 _12633_/S1 VDD
+ VSS sg13g2_mux4_1
X_14301__1878 _14301_/RESET_B VDD VSS sg13g2_tiehi
XFILLER_19_1092 VDD VSS sg13g2_decap_8
XFILLER_8_630 VDD VSS sg13g2_decap_8
XFILLER_89_1002 VDD VSS sg13g2_fill_2
XFILLER_129_355 VDD VSS sg13g2_decap_4
XFILLER_145_804 VDD VSS sg13g2_decap_8
X_12558_ _12558_/X _14698_/Q _14730_/Q _13770_/Q _13802_/Q _12562_/S0 _12562_/S1 VDD
+ VSS sg13g2_mux4_1
XFILLER_7_140 VDD VSS sg13g2_decap_8
XFILLER_129_388 VDD VSS sg13g2_decap_8
X_11509_ _11509_/X _14371_/Q _14403_/Q _14467_/Q _14499_/Q _12138_/S0 _12137_/S1 VDD
+ VSS sg13g2_mux4_1
XFILLER_32_1281 VDD VSS sg13g2_decap_8
X_12489_ _12489_/X _14373_/Q _14405_/Q _14469_/Q _14501_/Q _12655_/S0 _12655_/S1 VDD
+ VSS sg13g2_mux4_1
XFILLER_144_347 VDD VSS sg13g2_fill_2
XFILLER_171_133 VDD VSS sg13g2_decap_8
X_13866__2313 _13866_/RESET_B VDD VSS sg13g2_tiehi
X_14228_ _14228_/Q _14734_/CLK _14228_/D _14228_/RESET_B VDD VSS sg13g2_dfrbpq_1
XFILLER_99_913 VDD VSS sg13g2_decap_8
X_14159_ _14159_/Q clkload6/A _14159_/D _14159_/RESET_B VDD VSS sg13g2_dfrbpq_1
XFILLER_98_434 VDD VSS sg13g2_decap_8
Xfanout609 _10669_/S _10684_/A2 VDD VSS sg13g2_buf_1
XFILLER_112_255 VDD VSS sg13g2_decap_4
XFILLER_140_564 VDD VSS sg13g2_decap_8
X_14770__2943 _14770_/RESET_B VDD VSS sg13g2_tiehi
XFILLER_98_489 VDD VSS sg13g2_decap_8
XFILLER_79_670 VDD VSS sg13g2_decap_8
XFILLER_6_1113 VDD VSS sg13g2_decap_8
XFILLER_113_1000 VDD VSS sg13g2_decap_8
XFILLER_152_1060 VDD VSS sg13g2_decap_8
X_08720_ _15213_/D _15192_/D _15122_/Q _13656_/S VDD VSS sg13g2_mux2_1
XFILLER_26_1063 VDD VSS sg13g2_decap_8
XFILLER_78_191 VDD VSS sg13g2_fill_1
XFILLER_14_0 VDD VSS sg13g2_decap_8
XFILLER_152_1093 VDD VSS sg13g2_fill_1
Xfanout1180 _13601_/A _14957_/Q VDD VSS sg13g2_buf_1
Xfanout1191 _10681_/A _14897_/Q VDD VSS sg13g2_buf_1
X_08651_ _15246_/D _08395_/A _08650_/X _08640_/X VDD VSS sg13g2_o21ai_1
XFILLER_94_662 VDD VSS sg13g2_fill_2
XFILLER_82_813 VDD VSS sg13g2_decap_8
XFILLER_27_729 VDD VSS sg13g2_fill_2
XFILLER_113_1077 VDD VSS sg13g2_decap_8
XFILLER_94_684 VDD VSS sg13g2_fill_1
XFILLER_66_375 VDD VSS sg13g2_decap_8
XFILLER_96_1028 VDD VSS sg13g2_decap_8
XFILLER_54_526 VDD VSS sg13g2_fill_1
XFILLER_26_217 VDD VSS sg13g2_decap_8
XFILLER_54_537 VDD VSS sg13g2_fill_1
X_08582_ _08583_/B _08641_/D _08577_/B _08649_/S VDD VSS sg13g2_a21oi_1
XFILLER_19_280 VDD VSS sg13g2_decap_8
XFILLER_35_751 VDD VSS sg13g2_decap_4
X_15086__2821 _15086_/RESET_B VDD VSS sg13g2_tiehi
XFILLER_168_907 VDD VSS sg13g2_decap_8
XFILLER_22_434 VDD VSS sg13g2_decap_8
XFILLER_167_406 VDD VSS sg13g2_decap_8
X_09203_ _10004_/C _09441_/A _09204_/C _09204_/D VDD VSS sg13g2_nor3_1
X_09134_ _10776_/A _15048_/Q _15245_/Q _09140_/S VDD VSS sg13g2_mux2_1
XFILLER_148_664 VDD VSS sg13g2_decap_8
XFILLER_120_1015 VDD VSS sg13g2_decap_8
XFILLER_124_1184 VDD VSS sg13g2_fill_2
XFILLER_147_174 VDD VSS sg13g2_decap_8
X_09065_ _09065_/Y _15235_/Q _09107_/B VDD VSS sg13g2_nand2b_1
XFILLER_135_325 VDD VSS sg13g2_fill_1
XFILLER_147_185 VDD VSS sg13g2_fill_1
XFILLER_118_35 VDD VSS sg13g2_decap_8
XFILLER_162_133 VDD VSS sg13g2_decap_8
X_08016_ _08016_/Y _08340_/A _08015_/Y _08008_/Y VDD VSS sg13g2_a21oi_1
XFILLER_11_1365 VDD VSS sg13g2_decap_8
XFILLER_151_818 VDD VSS sg13g2_fill_1
XFILLER_159_1269 VDD VSS sg13g2_fill_1
XFILLER_151_829 VDD VSS sg13g2_decap_8
X_14456__1723 _14456_/RESET_B VDD VSS sg13g2_tiehi
XFILLER_78_28 VDD VSS sg13g2_decap_8
XFILLER_104_756 VDD VSS sg13g2_decap_8
XFILLER_143_391 VDD VSS sg13g2_decap_8
XFILLER_103_233 VDD VSS sg13g2_decap_8
XFILLER_89_467 VDD VSS sg13g2_fill_1
X_09967_ _14551_/D _14551_/Q _09967_/A1 _09969_/S VDD VSS sg13g2_mux2_1
XFILLER_58_810 VDD VSS sg13g2_decap_8
X_08918_ _08918_/X _15042_/Q _14946_/Q _10747_/A VDD VSS sg13g2_mux2_1
XFILLER_44_1163 VDD VSS sg13g2_decap_8
XFILLER_69_180 VDD VSS sg13g2_decap_8
X_09898_ _14484_/D _09898_/A0 _14484_/Q _09898_/S VDD VSS sg13g2_mux2_1
XFILLER_131_1144 VDD VSS sg13g2_decap_8
XFILLER_94_49 VDD VSS sg13g2_decap_8
XFILLER_58_876 VDD VSS sg13g2_decap_8
XFILLER_18_707 VDD VSS sg13g2_decap_8
XFILLER_91_109 VDD VSS sg13g2_decap_8
X_08849_ _08849_/X _15025_/Q _10691_/S _08848_/Y VDD VSS sg13g2_a21o_1
XFILLER_27_21 VDD VSS sg13g2_decap_8
XFILLER_79_1226 VDD VSS sg13g2_fill_2
XFILLER_100_995 VDD VSS sg13g2_decap_4
XFILLER_17_217 VDD VSS sg13g2_decap_8
XFILLER_73_846 VDD VSS sg13g2_decap_8
X_11860_ _11860_/Y _13088_/A _11792_/B _11868_/A VDD VSS sg13g2_a21oi_1
XFILLER_72_334 VDD VSS sg13g2_decap_8
XFILLER_72_345 VDD VSS sg13g2_fill_2
XFILLER_27_98 VDD VSS sg13g2_decap_8
X_10811_ _10811_/Y _10873_/A1 _10844_/A _07753_/B VDD VSS sg13g2_o21ai_1
X_11791_ _11791_/X _11789_/X _11790_/X _11975_/A VDD VSS sg13g2_mux2_1
XFILLER_26_773 VDD VSS sg13g2_decap_8
XFILLER_14_924 VDD VSS sg13g2_decap_8
XFILLER_53_570 VDD VSS sg13g2_decap_8
X_13530_ _13530_/Y _13529_/A _13533_/B _08306_/B _13546_/B2 VDD VSS sg13g2_a22oi_1
X_13944__2235 _13944_/RESET_B VDD VSS sg13g2_tiehi
XFILLER_41_732 VDD VSS sg13g2_fill_2
XFILLER_0_1290 VDD VSS sg13g2_decap_8
XFILLER_13_434 VDD VSS sg13g2_decap_8
X_10742_ _14913_/D _09204_/C _11052_/B _10741_/Y VDD VSS sg13g2_o21ai_1
XFILLER_43_42 VDD VSS sg13g2_decap_8
XFILLER_159_42 VDD VSS sg13g2_decap_8
X_13461_ _13461_/Y _13412_/B _13483_/A2 _12879_/B VDD VSS sg13g2_o21ai_1
X_10673_ _14895_/D _10673_/A VDD VSS sg13g2_inv_1
XFILLER_9_427 VDD VSS sg13g2_decap_8
XFILLER_16_1232 VDD VSS sg13g2_decap_8
XFILLER_51_1112 VDD VSS sg13g2_decap_4
XFILLER_40_275 VDD VSS sg13g2_fill_1
XFILLER_167_951 VDD VSS sg13g2_decap_8
X_15200_ _15200_/Q clkload63/A _15200_/D _15200_/RESET_B VDD VSS sg13g2_dfrbpq_1
XFILLER_22_990 VDD VSS sg13g2_decap_8
X_12412_ _12412_/X _12411_/X _12410_/X _12407_/X _12406_/X _12608_/S1 _12567_/S VDD
+ VSS sg13g2_mux4_1
XFILLER_103_1224 VDD VSS sg13g2_decap_8
X_13392_ _15084_/D _15084_/Q _13407_/A _13391_/Y VDD VSS sg13g2_a21o_1
XFILLER_51_1167 VDD VSS sg13g2_fill_1
XFILLER_138_163 VDD VSS sg13g2_fill_1
XFILLER_127_837 VDD VSS sg13g2_fill_1
XFILLER_138_174 VDD VSS sg13g2_decap_4
XFILLER_154_623 VDD VSS sg13g2_decap_8
XFILLER_166_483 VDD VSS sg13g2_decap_8
X_15131_ _15131_/Q clkload61/A _15131_/D _15131_/RESET_B VDD VSS sg13g2_dfrbpq_1
XFILLER_51_1189 VDD VSS sg13g2_decap_8
X_12343_ _12343_/X _14107_/Q _14139_/Q _14171_/Q _14203_/Q _12617_/S0 _12617_/S1 VDD
+ VSS sg13g2_mux4_1
XFILLER_5_644 VDD VSS sg13g2_decap_8
XFILLER_154_667 VDD VSS sg13g2_decap_4
X_15062_ _15062_/Q clkload71/A _15062_/D _15062_/RESET_B VDD VSS sg13g2_dfrbpq_1
X_12274_ _12274_/Y _12274_/A _12274_/B VDD VSS sg13g2_nor2_1
XFILLER_4_154 VDD VSS sg13g2_decap_8
XFILLER_107_572 VDD VSS sg13g2_decap_8
XFILLER_4_14 VDD VSS sg13g2_decap_8
X_14013_ _14013_/Q clkload38/A _14013_/D _14013_/RESET_B VDD VSS sg13g2_dfrbpq_1
X_11225_ _11225_/X _14363_/Q _14395_/Q _14459_/Q _14491_/Q _11212_/S _11878_/B1 VDD
+ VSS sg13g2_mux4_1
XFILLER_134_391 VDD VSS sg13g2_decap_8
XFILLER_122_542 VDD VSS sg13g2_fill_1
XFILLER_49_1085 VDD VSS sg13g2_fill_1
XFILLER_96_916 VDD VSS sg13g2_fill_2
X_11156_ _11156_/Y _14953_/Q _11170_/B VDD VSS sg13g2_nand2_1
XFILLER_1_861 VDD VSS sg13g2_decap_8
XFILLER_150_884 VDD VSS sg13g2_decap_8
XFILLER_150_895 VDD VSS sg13g2_fill_1
XFILLER_67_117 VDD VSS sg13g2_decap_8
X_10107_ _14685_/D _10107_/A0 _14685_/Q _10136_/S VDD VSS sg13g2_mux2_1
XFILLER_89_990 VDD VSS sg13g2_fill_1
XFILLER_0_371 VDD VSS sg13g2_decap_8
XFILLER_62_1252 VDD VSS sg13g2_decap_4
X_11087_ _11087_/X _11118_/A _11118_/B VDD VSS sg13g2_and2_1
XFILLER_48_331 VDD VSS sg13g2_decap_8
X_14915_ _14915_/Q clkload43/A _14915_/D _14915_/RESET_B VDD VSS sg13g2_dfrbpq_1
X_10038_ _14619_/D _10104_/A0 _14619_/Q _10063_/S VDD VSS sg13g2_mux2_1
XFILLER_23_1258 VDD VSS sg13g2_decap_8
XFILLER_64_824 VDD VSS sg13g2_fill_2
XFILLER_84_60 VDD VSS sg13g2_fill_2
X_14846_ _14846_/Q _14854_/CLK _14846_/D _14846_/RESET_B VDD VSS sg13g2_dfrbpq_1
XFILLER_5_1190 VDD VSS sg13g2_decap_8
XFILLER_90_120 VDD VSS sg13g2_decap_4
XFILLER_1_1043 VDD VSS sg13g2_decap_8
XFILLER_90_142 VDD VSS sg13g2_decap_8
XFILLER_56_1001 VDD VSS sg13g2_fill_1
X_14777_ _14777_/Q clkload51/A _14777_/D _14777_/RESET_B VDD VSS sg13g2_dfrbpq_1
X_11989_ _11989_/Y _11989_/A _11989_/B VDD VSS sg13g2_xnor2_1
XFILLER_17_784 VDD VSS sg13g2_decap_8
XFILLER_95_1083 VDD VSS sg13g2_decap_8
X_13728_ _13728_/Q clkload30/A _13728_/D _13728_/RESET_B VDD VSS sg13g2_dfrbpq_1
XFILLER_32_743 VDD VSS sg13g2_decap_8
XFILLER_108_1124 VDD VSS sg13g2_decap_8
XFILLER_16_294 VDD VSS sg13g2_decap_8
X_14534__1645 _14534_/RESET_B VDD VSS sg13g2_tiehi
XFILLER_147_1195 VDD VSS sg13g2_fill_1
XFILLER_17_1029 VDD VSS sg13g2_decap_8
X_13659_ _13659_/Q _15064_/CLK _13659_/D _13659_/RESET_B VDD VSS sg13g2_dfrbpq_1
XFILLER_20_938 VDD VSS sg13g2_decap_8
XFILLER_158_940 VDD VSS sg13g2_fill_2
XFILLER_34_1332 VDD VSS sg13g2_decap_8
XFILLER_158_962 VDD VSS sg13g2_decap_8
X_14788__2925 _14788_/RESET_B VDD VSS sg13g2_tiehi
XFILLER_145_601 VDD VSS sg13g2_decap_8
XFILLER_9_994 VDD VSS sg13g2_decap_8
XFILLER_172_442 VDD VSS sg13g2_decap_8
XFILLER_145_667 VDD VSS sg13g2_decap_4
XFILLER_126_870 VDD VSS sg13g2_decap_8
XFILLER_132_328 VDD VSS sg13g2_decap_8
XFILLER_99_743 VDD VSS sg13g2_decap_8
XFILLER_63_1005 VDD VSS sg13g2_decap_8
XFILLER_98_231 VDD VSS sg13g2_decap_8
Xfanout406 _13435_/B _13444_/B VDD VSS sg13g2_buf_1
XFILLER_141_862 VDD VSS sg13g2_decap_8
Xfanout417 _10135_/S _10123_/S VDD VSS sg13g2_buf_1
X_09821_ _14409_/D _09920_/A1 _14409_/Q _09831_/S VDD VSS sg13g2_mux2_1
XFILLER_28_1147 VDD VSS sg13g2_decap_8
XFILLER_115_1106 VDD VSS sg13g2_fill_1
Xfanout428 _09997_/S _10003_/S VDD VSS sg13g2_buf_1
Xfanout439 _09796_/S _09805_/S VDD VSS sg13g2_buf_1
XFILLER_86_415 VDD VSS sg13g2_decap_8
XFILLER_59_629 VDD VSS sg13g2_decap_4
XFILLER_101_726 VDD VSS sg13g2_decap_4
XFILLER_98_286 VDD VSS sg13g2_fill_1
XFILLER_101_748 VDD VSS sg13g2_decap_8
X_09752_ _14342_/D _14342_/Q _09884_/A0 _09763_/S VDD VSS sg13g2_mux2_1
XFILLER_58_139 VDD VSS sg13g2_decap_8
X_08703_ _15184_/D hold3054/X _15184_/Q _10203_/S VDD VSS sg13g2_mux2_1
X_09683_ _14275_/D _09914_/A1 _14275_/Q _09705_/S VDD VSS sg13g2_mux2_1
XFILLER_41_1369 VDD VSS sg13g2_decap_8
XFILLER_94_481 VDD VSS sg13g2_decap_8
XFILLER_82_621 VDD VSS sg13g2_fill_1
XFILLER_27_526 VDD VSS sg13g2_decap_4
X_08634_ _08640_/C _08600_/A _08333_/Y _08676_/B2 VDD VSS sg13g2_o21ai_1
XFILLER_55_857 VDD VSS sg13g2_decap_8
XFILLER_120_14 VDD VSS sg13g2_decap_8
X_08565_ _08581_/A _07862_/Y _08674_/A2 _08672_/A _08608_/B _08563_/Y VDD VSS sg13g2_a221oi_1
XFILLER_35_592 VDD VSS sg13g2_fill_1
X_08496_ _08497_/B _08434_/B _07829_/B _07950_/Y VDD VSS sg13g2_a21oi_1
XFILLER_22_231 VDD VSS sg13g2_decap_8
XFILLER_167_203 VDD VSS sg13g2_decap_8
XFILLER_126_1257 VDD VSS sg13g2_fill_1
XFILLER_11_938 VDD VSS sg13g2_decap_8
XFILLER_10_448 VDD VSS sg13g2_decap_8
XFILLER_13_56 VDD VSS sg13g2_decap_8
XFILLER_148_450 VDD VSS sg13g2_fill_2
XFILLER_108_314 VDD VSS sg13g2_fill_1
XFILLER_129_56 VDD VSS sg13g2_decap_8
XFILLER_148_483 VDD VSS sg13g2_fill_2
X_09117_ _09117_/Y _09117_/A _09117_/B _09117_/C VDD VSS sg13g2_nand3_1
XFILLER_108_325 VDD VSS sg13g2_decap_8
XFILLER_163_420 VDD VSS sg13g2_decap_8
XFILLER_159_1022 VDD VSS sg13g2_decap_8
X_09048_ _10720_/B _09107_/B _15035_/Q _09047_/Y VDD VSS sg13g2_o21ai_1
XFILLER_89_49 VDD VSS sg13g2_decap_8
XFILLER_135_155 VDD VSS sg13g2_decap_8
XFILLER_11_1162 VDD VSS sg13g2_decap_8
XFILLER_150_103 VDD VSS sg13g2_decap_4
XFILLER_163_497 VDD VSS sg13g2_decap_8
X_15042__2541 _15042_/RESET_B VDD VSS sg13g2_tiehi
XFILLER_116_380 VDD VSS sg13g2_fill_2
XFILLER_159_1099 VDD VSS sg13g2_fill_2
XFILLER_132_840 VDD VSS sg13g2_fill_1
XFILLER_151_659 VDD VSS sg13g2_decap_8
XFILLER_46_1214 VDD VSS sg13g2_decap_8
XFILLER_2_658 VDD VSS sg13g2_decap_8
X_11010_ _11012_/B _11010_/A _11010_/B _11010_/C VDD VSS sg13g2_nand3_1
XFILLER_137_1364 VDD VSS sg13g2_decap_8
XFILLER_1_168 VDD VSS sg13g2_decap_8
XFILLER_145_99 VDD VSS sg13g2_decap_4
Xfanout940 _13389_/A _10199_/A1 VDD VSS sg13g2_buf_1
Xfanout951 _12895_/B _07729_/D VDD VSS sg13g2_buf_1
X_14612__1567 _14612_/RESET_B VDD VSS sg13g2_tiehi
Xfanout962 _13014_/A2 _15106_/Q VDD VSS sg13g2_buf_1
Xfanout973 _11206_/A1 _11191_/A VDD VSS sg13g2_buf_1
XFILLER_58_640 VDD VSS sg13g2_decap_8
XFILLER_38_42 VDD VSS sg13g2_decap_8
XFILLER_161_21 VDD VSS sg13g2_decap_8
Xfanout984 _07720_/A _08760_/A1 VDD VSS sg13g2_buf_1
XFILLER_86_960 VDD VSS sg13g2_fill_1
XFILLER_58_651 VDD VSS sg13g2_fill_2
Xfanout995 _10037_/A _09938_/C VDD VSS sg13g2_buf_1
XFILLER_92_418 VDD VSS sg13g2_decap_8
X_12961_ _12962_/B _12961_/A _12988_/C _12961_/C VDD VSS sg13g2_nand3_1
XFILLER_18_504 VDD VSS sg13g2_decap_8
XFILLER_85_470 VDD VSS sg13g2_fill_1
X_14700_ _14700_/Q clkload13/A _14700_/D _14700_/RESET_B VDD VSS sg13g2_dfrbpq_1
X_11912_ _11913_/B _11912_/A _11912_/B VDD VSS sg13g2_nor2_1
XFILLER_73_643 VDD VSS sg13g2_decap_8
XFILLER_2_1330 VDD VSS sg13g2_decap_8
XFILLER_161_98 VDD VSS sg13g2_decap_8
X_12892_ _12894_/B _14900_/Q _13687_/Q VDD VSS sg13g2_xor2_1
XFILLER_46_868 VDD VSS sg13g2_decap_8
XFILLER_166_1026 VDD VSS sg13g2_fill_1
XFILLER_33_507 VDD VSS sg13g2_decap_4
XFILLER_166_0 VDD VSS sg13g2_decap_8
X_14631_ _14631_/Q _14727_/CLK _14631_/D _14631_/RESET_B VDD VSS sg13g2_dfrbpq_1
X_11843_ _11910_/B _11843_/A _13675_/Q VDD VSS sg13g2_xnor2_1
XFILLER_72_164 VDD VSS sg13g2_fill_1
XFILLER_60_304 VDD VSS sg13g2_decap_8
XFILLER_92_1212 VDD VSS sg13g2_fill_1
XFILLER_14_721 VDD VSS sg13g2_decap_8
XFILLER_144_1302 VDD VSS sg13g2_decap_8
XFILLER_159_704 VDD VSS sg13g2_decap_8
X_14562_ _14562_/Q clkload29/A _14562_/D _14562_/RESET_B VDD VSS sg13g2_dfrbpq_1
XFILLER_60_348 VDD VSS sg13g2_decap_8
XFILLER_57_1365 VDD VSS sg13g2_decap_8
XFILLER_18_1316 VDD VSS sg13g2_decap_8
X_11774_ _11774_/Y _11774_/A _11776_/B VDD VSS sg13g2_nand2_1
XFILLER_13_231 VDD VSS sg13g2_decap_8
X_13513_ _15136_/D _15136_/Q _13533_/A _13519_/B VDD VSS sg13g2_mux2_1
XFILLER_41_562 VDD VSS sg13g2_fill_2
X_10725_ _10725_/Y _10725_/A _10725_/B VDD VSS sg13g2_nor2_1
XFILLER_14_798 VDD VSS sg13g2_decap_8
X_14493_ _14493_/Q clkload45/A _14493_/D _14493_/RESET_B VDD VSS sg13g2_dfrbpq_1
XFILLER_9_224 VDD VSS sg13g2_decap_8
XFILLER_144_1379 VDD VSS sg13g2_fill_1
XFILLER_110_91 VDD VSS sg13g2_decap_8
X_13444_ _13444_/Y _13444_/A _13444_/B _13444_/C VDD VSS sg13g2_nor3_1
X_10656_ _10658_/B _14891_/Q _10663_/D VDD VSS sg13g2_nor2_1
XFILLER_173_206 VDD VSS sg13g2_decap_8
XFILLER_103_1021 VDD VSS sg13g2_fill_1
XFILLER_107_1190 VDD VSS sg13g2_decap_4
XFILLER_142_1070 VDD VSS sg13g2_fill_1
XFILLER_173_217 VDD VSS sg13g2_decap_8
XFILLER_127_612 VDD VSS sg13g2_decap_4
XFILLER_155_943 VDD VSS sg13g2_fill_1
Xclkload16 clkload16/Y clkload16/A VDD VSS sg13g2_inv_1
XFILLER_6_931 VDD VSS sg13g2_decap_8
XFILLER_166_280 VDD VSS sg13g2_decap_8
X_13375_ _13378_/C _15124_/Q _13507_/B VDD VSS sg13g2_nand2_1
Xclkload27 clkload27/Y clkload27/A VDD VSS sg13g2_inv_2
X_10587_ _10587_/Y _10649_/B _10594_/D _10353_/C VDD VSS sg13g2_o21ai_1
Xclkload38 clkload38/Y clkload38/A VDD VSS sg13g2_inv_4
XFILLER_103_1076 VDD VSS sg13g2_decap_8
Xclkload49 clkload49/Y clkload49/A VDD VSS sg13g2_inv_1
X_15114_ _15114_/Q _15183_/CLK _15114_/D _15114_/RESET_B VDD VSS sg13g2_dfrbpq_1
XFILLER_103_1087 VDD VSS sg13g2_fill_2
XFILLER_127_678 VDD VSS sg13g2_decap_8
XFILLER_154_464 VDD VSS sg13g2_decap_8
X_12326_ _12326_/Y _12326_/A1 _13882_/Q _11262_/B VDD VSS sg13g2_a21oi_1
XFILLER_5_441 VDD VSS sg13g2_decap_8
XFILLER_55_7 VDD VSS sg13g2_decap_8
XFILLER_170_957 VDD VSS sg13g2_decap_4
X_15045_ _15045_/Q _15064_/CLK _15045_/D _15045_/RESET_B VDD VSS sg13g2_dfrbpq_1
X_12257_ _12257_/Y _12257_/A1 _13944_/Q _12015_/B VDD VSS sg13g2_a21oi_1
XFILLER_64_1336 VDD VSS sg13g2_decap_4
X_11208_ _11209_/B _11206_/Y _11204_/Y _11207_/Y VDD VSS sg13g2_o21ai_1
X_12188_ _12188_/Y _12188_/A _12188_/B _12188_/C VDD VSS sg13g2_nand3_1
XFILLER_123_884 VDD VSS sg13g2_fill_1
XFILLER_151_1306 VDD VSS sg13g2_decap_8
XFILLER_96_724 VDD VSS sg13g2_decap_4
XFILLER_25_1309 VDD VSS sg13g2_decap_8
XFILLER_110_534 VDD VSS sg13g2_decap_8
X_11139_ _11139_/Y _11190_/C _11163_/A _11139_/B1 VDD VSS sg13g2_a21oi_1
XFILLER_110_545 VDD VSS sg13g2_fill_2
XFILLER_96_768 VDD VSS sg13g2_decap_8
XFILLER_27_1180 VDD VSS sg13g2_decap_8
XFILLER_7_1274 VDD VSS sg13g2_decap_8
XFILLER_37_813 VDD VSS sg13g2_decap_4
XFILLER_23_1055 VDD VSS sg13g2_decap_8
XFILLER_3_1127 VDD VSS sg13g2_decap_8
XFILLER_76_481 VDD VSS sg13g2_decap_8
XFILLER_49_695 VDD VSS sg13g2_decap_8
XFILLER_110_1025 VDD VSS sg13g2_decap_8
XFILLER_110_1036 VDD VSS sg13g2_fill_2
XFILLER_58_1107 VDD VSS sg13g2_fill_1
XFILLER_40_1380 VDD VSS sg13g2_decap_4
XFILLER_97_1167 VDD VSS sg13g2_fill_2
X_14829_ _14829_/Q _14890_/CLK _14829_/D _14829_/RESET_B VDD VSS sg13g2_dfrbpq_1
XFILLER_64_698 VDD VSS sg13g2_decap_8
XFILLER_17_581 VDD VSS sg13g2_decap_8
X_08350_ _08352_/A _07934_/Y _08350_/B VDD VSS sg13g2_nand2b_1
XFILLER_149_203 VDD VSS sg13g2_decap_8
X_14050__2129 _14050_/RESET_B VDD VSS sg13g2_tiehi
X_08281_ _08281_/Y _08338_/B _08207_/X _08279_/X VDD VSS sg13g2_a21oi_1
XFILLER_81_0 VDD VSS sg13g2_decap_8
XFILLER_32_595 VDD VSS sg13g2_decap_8
XFILLER_20_735 VDD VSS sg13g2_decap_8
XFILLER_164_217 VDD VSS sg13g2_decap_8
XFILLER_118_623 VDD VSS sg13g2_decap_8
XFILLER_160_1181 VDD VSS sg13g2_decap_8
XFILLER_121_1143 VDD VSS sg13g2_decap_4
XFILLER_9_791 VDD VSS sg13g2_decap_8
XFILLER_121_1176 VDD VSS sg13g2_fill_2
XFILLER_121_1187 VDD VSS sg13g2_decap_8
XFILLER_69_1247 VDD VSS sg13g2_decap_4
XFILLER_145_486 VDD VSS sg13g2_decap_4
Xfanout203 _09859_/A1 _10157_/A1 VDD VSS sg13g2_buf_1
XFILLER_113_350 VDD VSS sg13g2_fill_2
XFILLER_160_478 VDD VSS sg13g2_decap_8
Xfanout214 _10414_/B _10313_/X VDD VSS sg13g2_buf_1
XFILLER_87_713 VDD VSS sg13g2_fill_2
XFILLER_115_14 VDD VSS sg13g2_decap_8
XFILLER_119_1061 VDD VSS sg13g2_decap_8
Xfanout225 _10153_/A1 _09789_/A0 VDD VSS sg13g2_buf_1
Xfanout236 _12126_/A _11247_/X VDD VSS sg13g2_buf_1
Xfanout247 _10151_/A1 _09919_/A1 VDD VSS sg13g2_buf_1
X_09804_ _14393_/D _09936_/A1 _14393_/Q _09804_/S VDD VSS sg13g2_mux2_1
Xfanout258 _09917_/A1 _09032_/X VDD VSS sg13g2_buf_1
Xfanout269 _09596_/S _09605_/S VDD VSS sg13g2_buf_1
X_07996_ _07996_/X _15104_/Q _15091_/Q VDD VSS sg13g2_or2_1
X_09735_ _14326_/D _09768_/A1 _14326_/Q _09736_/S VDD VSS sg13g2_mux2_1
XFILLER_68_982 VDD VSS sg13g2_decap_8
XFILLER_28_813 VDD VSS sg13g2_fill_2
XFILLER_80_1193 VDD VSS sg13g2_decap_8
XFILLER_132_1272 VDD VSS sg13g2_fill_2
XFILLER_95_790 VDD VSS sg13g2_decap_8
X_14260__1919 _14260_/RESET_B VDD VSS sg13g2_tiehi
XFILLER_83_941 VDD VSS sg13g2_decap_8
XFILLER_167_1302 VDD VSS sg13g2_fill_1
X_09666_ _14259_/D _09666_/A0 _14259_/Q _09672_/S VDD VSS sg13g2_mux2_1
XFILLER_15_518 VDD VSS sg13g2_decap_8
X_08617_ _08622_/C _08617_/A _08617_/B VDD VSS sg13g2_nor2_1
XFILLER_82_462 VDD VSS sg13g2_decap_8
X_14862__2820 _14862_/RESET_B VDD VSS sg13g2_tiehi
X_09597_ _14194_/D _14194_/Q _09630_/A0 _09603_/S VDD VSS sg13g2_mux2_1
XFILLER_27_389 VDD VSS sg13g2_decap_4
XFILLER_91_28 VDD VSS sg13g2_decap_8
XFILLER_70_635 VDD VSS sg13g2_fill_1
XFILLER_42_326 VDD VSS sg13g2_fill_1
XFILLER_167_1379 VDD VSS sg13g2_fill_1
X_08548_ _08548_/Y _08548_/A _08548_/B VDD VSS sg13g2_nand2_1
XFILLER_39_1051 VDD VSS sg13g2_decap_8
XFILLER_42_359 VDD VSS sg13g2_decap_4
XFILLER_165_1092 VDD VSS sg13g2_fill_2
X_14026__2153 _14026_/RESET_B VDD VSS sg13g2_tiehi
X_08479_ _08479_/Y _07805_/B _08493_/B2 _08663_/B VDD VSS sg13g2_a21oi_1
XFILLER_11_735 VDD VSS sg13g2_decap_8
XFILLER_24_77 VDD VSS sg13g2_decap_8
XFILLER_168_567 VDD VSS sg13g2_decap_8
X_10510_ _10576_/C _10647_/A _10510_/B _10521_/D VDD VSS sg13g2_and3_1
X_14895__2754 _14895_/RESET_B VDD VSS sg13g2_tiehi
X_11490_ _11490_/X _14562_/Q _14594_/Q _14626_/Q _14658_/Q _11493_/S0 _11493_/S1 VDD
+ VSS sg13g2_mux4_1
XFILLER_10_245 VDD VSS sg13g2_decap_8
XFILLER_7_728 VDD VSS sg13g2_decap_8
X_10441_ _14836_/D _10441_/A _10442_/B _10441_/C VDD VSS sg13g2_and3_1
XFILLER_13_1246 VDD VSS sg13g2_decap_8
XFILLER_148_280 VDD VSS sg13g2_decap_8
XFILLER_40_21 VDD VSS sg13g2_decap_8
XFILLER_6_238 VDD VSS sg13g2_decap_8
XFILLER_156_21 VDD VSS sg13g2_decap_8
XFILLER_87_1336 VDD VSS sg13g2_decap_8
X_13160_ _13160_/Y _13159_/Y _13160_/B _13160_/C VDD VSS sg13g2_nand3b_1
X_10372_ _14815_/D _14815_/Q _10378_/D _10371_/Y VDD VSS sg13g2_a21oi_1
XFILLER_124_615 VDD VSS sg13g2_decap_8
XFILLER_152_924 VDD VSS sg13g2_fill_2
XFILLER_151_412 VDD VSS sg13g2_fill_1
XFILLER_152_946 VDD VSS sg13g2_decap_8
XFILLER_151_423 VDD VSS sg13g2_decap_8
X_13894__2285 _13894_/RESET_B VDD VSS sg13g2_tiehi
X_12111_ _12111_/Y _12250_/A1 _13908_/Q VDD VSS sg13g2_nand2b_1
XFILLER_152_957 VDD VSS sg13g2_fill_2
XFILLER_163_294 VDD VSS sg13g2_decap_8
X_13091_ _13091_/Y _13092_/A _13092_/C _13112_/A VDD VSS sg13g2_a21oi_1
XFILLER_3_945 VDD VSS sg13g2_decap_8
XFILLER_156_98 VDD VSS sg13g2_decap_8
X_12042_ _12042_/X _13970_/Q _14002_/Q _14034_/Q _14066_/Q _12025_/A _12236_/C VDD
+ VSS sg13g2_mux4_1
XFILLER_2_455 VDD VSS sg13g2_decap_8
XFILLER_104_361 VDD VSS sg13g2_decap_8
XFILLER_132_670 VDD VSS sg13g2_decap_4
XFILLER_78_724 VDD VSS sg13g2_decap_8
XFILLER_120_821 VDD VSS sg13g2_decap_4
XFILLER_49_63 VDD VSS sg13g2_decap_8
XFILLER_49_74 VDD VSS sg13g2_fill_1
XFILLER_172_42 VDD VSS sg13g2_decap_8
XFILLER_59_960 VDD VSS sg13g2_decap_8
XFILLER_120_876 VDD VSS sg13g2_decap_8
Xfanout770 _10510_/B _15250_/Q VDD VSS sg13g2_buf_1
XFILLER_77_267 VDD VSS sg13g2_decap_8
Xfanout781 _12692_/S _12762_/S VDD VSS sg13g2_buf_1
XFILLER_111_1301 VDD VSS sg13g2_fill_1
X_15073__2857 _15073_/RESET_B VDD VSS sg13g2_tiehi
Xfanout792 _12608_/S1 _12649_/S0 VDD VSS sg13g2_buf_1
X_13993_ _13993_/Q clkload20/A _13993_/D _13993_/RESET_B VDD VSS sg13g2_dfrbpq_1
XFILLER_18_301 VDD VSS sg13g2_decap_8
XFILLER_150_1383 VDD VSS sg13g2_fill_1
XFILLER_105_91 VDD VSS sg13g2_decap_8
X_12944_ _12946_/A _12945_/A _12944_/B _12988_/B VDD VSS sg13g2_nand3_1
XFILLER_92_248 VDD VSS sg13g2_fill_1
XFILLER_74_952 VDD VSS sg13g2_decap_8
X_14236__1943 _14236_/RESET_B VDD VSS sg13g2_tiehi
XFILLER_20_1239 VDD VSS sg13g2_decap_8
XFILLER_19_868 VDD VSS sg13g2_decap_8
X_15088__2813 _15088_/RESET_B VDD VSS sg13g2_tiehi
XFILLER_74_996 VDD VSS sg13g2_decap_8
XFILLER_46_687 VDD VSS sg13g2_fill_2
XFILLER_18_378 VDD VSS sg13g2_decap_8
X_12875_ _12875_/Y _12861_/B _12877_/C VDD VSS sg13g2_nand2b_1
XFILLER_60_101 VDD VSS sg13g2_fill_1
Xclkbuf_5_8__f_clk_i clkbuf_leaf_9_clk_i/A clkbuf_4_4_0_clk_i/X VDD VSS sg13g2_buf_16
XFILLER_27_890 VDD VSS sg13g2_fill_2
X_14614_ _14614_/Q clkload26/A _14614_/D _14614_/RESET_B VDD VSS sg13g2_dfrbpq_1
X_11826_ _11826_/Y _11353_/S _13932_/Q _11894_/B VDD VSS sg13g2_a21oi_1
XFILLER_60_134 VDD VSS sg13g2_fill_2
XFILLER_18_1113 VDD VSS sg13g2_decap_8
XFILLER_121_90 VDD VSS sg13g2_decap_4
XFILLER_42_860 VDD VSS sg13g2_decap_8
XFILLER_42_871 VDD VSS sg13g2_fill_2
XFILLER_159_534 VDD VSS sg13g2_fill_1
X_14545_ _14545_/Q _14737_/CLK _14545_/D _14545_/RESET_B VDD VSS sg13g2_dfrbpq_1
XFILLER_92_1075 VDD VSS sg13g2_fill_2
X_11757_ _11761_/A _11756_/X _11802_/B VDD VSS sg13g2_nand2b_1
XFILLER_57_1195 VDD VSS sg13g2_fill_1
XFILLER_41_370 VDD VSS sg13g2_decap_8
XFILLER_14_595 VDD VSS sg13g2_decap_8
XFILLER_41_392 VDD VSS sg13g2_decap_4
XFILLER_140_1018 VDD VSS sg13g2_decap_4
X_10708_ _10708_/Y _14905_/Q _10903_/B VDD VSS sg13g2_nand2_1
XFILLER_174_504 VDD VSS sg13g2_decap_8
X_14476_ _14476_/Q clkload35/A _14476_/D _14476_/RESET_B VDD VSS sg13g2_dfrbpq_1
XFILLER_31_1302 VDD VSS sg13g2_decap_8
XFILLER_174_515 VDD VSS sg13g2_decap_8
XFILLER_144_1198 VDD VSS sg13g2_decap_8
X_11688_ _11688_/Y _11685_/Y _11687_/X _11747_/A VDD VSS sg13g2_o21ai_1
X_13427_ _13427_/Y _13427_/A _13427_/B _13427_/C VDD VSS sg13g2_nand3_1
X_10639_ _10639_/Y _14887_/Q _10642_/C _10643_/A VDD VSS sg13g2_a21oi_1
XFILLER_31_1379 VDD VSS sg13g2_decap_4
X_13358_ _15072_/D _15072_/Q _13470_/A2 _13357_/Y VDD VSS sg13g2_a21o_1
X_13724__2455 _13724_/RESET_B VDD VSS sg13g2_tiehi
X_12309_ _12310_/A _13978_/Q _14010_/Q _14042_/Q _14074_/Q _12303_/S _12307_/C VDD
+ VSS sg13g2_mux4_1
XFILLER_115_659 VDD VSS sg13g2_fill_2
XFILLER_170_754 VDD VSS sg13g2_decap_8
X_14484__1695 _14484_/RESET_B VDD VSS sg13g2_tiehi
X_13289_ _13290_/D _13293_/C _13293_/D _13289_/C _13289_/D VDD VSS sg13g2_nor4_1
XFILLER_114_158 VDD VSS sg13g2_decap_4
X_15028_ _15028_/Q clkload55/A _15028_/D _15028_/RESET_B VDD VSS sg13g2_dfrbpq_1
XFILLER_69_702 VDD VSS sg13g2_decap_4
XFILLER_123_670 VDD VSS sg13g2_decap_4
XFILLER_155_1261 VDD VSS sg13g2_fill_2
XFILLER_29_1275 VDD VSS sg13g2_decap_8
XFILLER_25_1106 VDD VSS sg13g2_decap_8
XFILLER_9_1358 VDD VSS sg13g2_decap_8
X_07850_ _08646_/A _15016_/Q _08012_/B VDD VSS sg13g2_nand2_1
XFILLER_69_757 VDD VSS sg13g2_decap_4
XFILLER_64_1177 VDD VSS sg13g2_decap_4
XFILLER_116_1267 VDD VSS sg13g2_decap_4
XFILLER_111_887 VDD VSS sg13g2_fill_2
X_14104__2075 _14104_/RESET_B VDD VSS sg13g2_tiehi
X_07781_ _08411_/A _07782_/A _15002_/Q VDD VSS sg13g2_nor2_1
XFILLER_96_598 VDD VSS sg13g2_decap_8
XFILLER_7_1071 VDD VSS sg13g2_decap_8
XFILLER_37_610 VDD VSS sg13g2_decap_4
Xinput3 input3/X input3/A VDD VSS sg13g2_buf_1
XFILLER_83_226 VDD VSS sg13g2_fill_2
X_09520_ _14119_/D _10083_/A0 _14119_/Q _09535_/S VDD VSS sg13g2_mux2_1
XFILLER_49_492 VDD VSS sg13g2_decap_4
XFILLER_83_259 VDD VSS sg13g2_decap_8
XFILLER_149_1032 VDD VSS sg13g2_decap_8
X_09451_ _14052_/D _10147_/A1 _14052_/Q _09469_/S VDD VSS sg13g2_mux2_1
XFILLER_51_112 VDD VSS sg13g2_fill_1
XFILLER_149_1076 VDD VSS sg13g2_decap_8
X_08402_ _08402_/Y _08402_/A _08402_/B _08402_/C _08625_/A VDD VSS sg13g2_nor4_1
XFILLER_24_348 VDD VSS sg13g2_fill_1
X_09382_ _13985_/D _09448_/A0 _13985_/Q _09403_/S VDD VSS sg13g2_mux2_1
XFILLER_36_1213 VDD VSS sg13g2_decap_8
XFILLER_162_1221 VDD VSS sg13g2_decap_8
X_08333_ _08333_/Y _08560_/A _08149_/Y _08241_/Y VDD VSS sg13g2_o21ai_1
XFILLER_36_1235 VDD VSS sg13g2_decap_8
XFILLER_123_1216 VDD VSS sg13g2_decap_4
XFILLER_20_532 VDD VSS sg13g2_decap_8
XFILLER_165_504 VDD VSS sg13g2_decap_8
X_08264_ _08264_/Y _07927_/Y _07930_/A _08160_/A VDD VSS sg13g2_a21oi_1
XFILLER_71_1159 VDD VSS sg13g2_fill_2
XFILLER_36_1279 VDD VSS sg13g2_decap_4
XFILLER_119_932 VDD VSS sg13g2_decap_8
X_08195_ _08195_/Y _08194_/B _08085_/A _08194_/Y VDD VSS sg13g2_o21ai_1
XFILLER_134_913 VDD VSS sg13g2_decap_8
XFILLER_133_412 VDD VSS sg13g2_decap_8
XFILLER_10_35 VDD VSS sg13g2_decap_8
XFILLER_106_659 VDD VSS sg13g2_fill_1
XFILLER_156_1025 VDD VSS sg13g2_decap_8
XFILLER_69_1077 VDD VSS sg13g2_fill_1
XFILLER_160_231 VDD VSS sg13g2_decap_8
X_14314__1865 _14314_/RESET_B VDD VSS sg13g2_tiehi
XFILLER_134_979 VDD VSS sg13g2_fill_2
XFILLER_121_607 VDD VSS sg13g2_decap_8
XFILLER_126_35 VDD VSS sg13g2_fill_1
XFILLER_156_1069 VDD VSS sg13g2_decap_8
XFILLER_0_926 VDD VSS sg13g2_decap_8
Xfanout1009 _09154_/B _09107_/B VDD VSS sg13g2_buf_1
XFILLER_82_1244 VDD VSS sg13g2_decap_8
XFILLER_47_1364 VDD VSS sg13g2_decap_8
XFILLER_173_1361 VDD VSS sg13g2_decap_8
XFILLER_134_1323 VDD VSS sg13g2_decap_8
XFILLER_43_1206 VDD VSS sg13g2_decap_8
XFILLER_99_392 VDD VSS sg13g2_decap_8
XFILLER_86_39 VDD VSS sg13g2_fill_2
XFILLER_59_245 VDD VSS sg13g2_decap_8
XFILLER_102_887 VDD VSS sg13g2_decap_8
X_13879__2300 _13879_/RESET_B VDD VSS sg13g2_tiehi
X_07979_ _07979_/Y _07979_/A _07981_/C _07979_/C VDD VSS sg13g2_nand3_1
XFILLER_19_77 VDD VSS sg13g2_decap_8
X_09718_ _14309_/D _09916_/A1 _14309_/Q _09730_/S VDD VSS sg13g2_mux2_1
XFILLER_142_78 VDD VSS sg13g2_decap_8
X_10990_ _11009_/C _15116_/Q _10995_/B VDD VSS sg13g2_xnor2_1
XFILLER_16_805 VDD VSS sg13g2_decap_8
XFILLER_55_462 VDD VSS sg13g2_decap_8
X_09649_ _14242_/D _09913_/A1 _14242_/Q _09672_/S VDD VSS sg13g2_mux2_1
XFILLER_35_21 VDD VSS sg13g2_decap_8
XFILLER_15_315 VDD VSS sg13g2_decap_8
X_14783__2930 _14783_/RESET_B VDD VSS sg13g2_tiehi
XFILLER_27_175 VDD VSS sg13g2_decap_8
XFILLER_43_646 VDD VSS sg13g2_decap_8
XFILLER_82_292 VDD VSS sg13g2_decap_8
XFILLER_167_1187 VDD VSS sg13g2_decap_8
X_12660_ _12660_/X _14385_/Q _14417_/Q _14481_/Q _14513_/Q _12660_/S0 _12660_/S1 VDD
+ VSS sg13g2_mux4_1
XFILLER_93_1351 VDD VSS sg13g2_fill_1
XFILLER_167_1198 VDD VSS sg13g2_fill_1
X_13802__2377 _13802_/RESET_B VDD VSS sg13g2_tiehi
X_11611_ _11611_/Y _11597_/A _14470_/Q VDD VSS sg13g2_nand2b_1
XFILLER_42_178 VDD VSS sg13g2_fill_2
X_12591_ _12591_/X _13836_/Q _13868_/Q _13900_/Q _13932_/Q _12592_/S0 _12592_/S1 VDD
+ VSS sg13g2_mux4_1
XFILLER_169_876 VDD VSS sg13g2_decap_8
XFILLER_11_532 VDD VSS sg13g2_decap_8
XFILLER_169_887 VDD VSS sg13g2_fill_1
X_14330_ _14330_/Q _14682_/CLK _14330_/D _14330_/RESET_B VDD VSS sg13g2_dfrbpq_1
XFILLER_23_392 VDD VSS sg13g2_decap_8
XFILLER_168_364 VDD VSS sg13g2_decap_8
X_11542_ _11542_/X _11542_/A _12190_/B VDD VSS sg13g2_and2_1
XFILLER_51_42 VDD VSS sg13g2_decap_8
XFILLER_141_1349 VDD VSS sg13g2_fill_2
XFILLER_51_53 VDD VSS sg13g2_fill_1
XFILLER_7_525 VDD VSS sg13g2_decap_8
XFILLER_51_64 VDD VSS sg13g2_fill_1
XFILLER_129_0 VDD VSS sg13g2_decap_8
XFILLER_167_42 VDD VSS sg13g2_decap_8
X_14261_ _14261_/Q clkload16/A _14261_/D _14261_/RESET_B VDD VSS sg13g2_dfrbpq_1
XFILLER_17_1190 VDD VSS sg13g2_decap_8
X_11473_ _11473_/X _14689_/Q _14721_/Q _13761_/Q _13793_/Q _11493_/S0 _12213_/S1 VDD
+ VSS sg13g2_mux4_1
XFILLER_13_1043 VDD VSS sg13g2_decap_8
X_13212_ _13228_/A _14921_/Q _13666_/Q VDD VSS sg13g2_nand2_1
X_10424_ _10521_/C _10647_/A _10510_/B VDD VSS sg13g2_and2_1
XFILLER_124_401 VDD VSS sg13g2_decap_8
X_14192_ _14192_/Q clkload8/A _14192_/D _14192_/RESET_B VDD VSS sg13g2_dfrbpq_1
XFILLER_109_486 VDD VSS sg13g2_decap_8
XFILLER_125_935 VDD VSS sg13g2_fill_2
XFILLER_137_795 VDD VSS sg13g2_fill_1
XFILLER_100_1046 VDD VSS sg13g2_decap_8
XFILLER_139_1223 VDD VSS sg13g2_decap_8
XFILLER_164_581 VDD VSS sg13g2_decap_8
XFILLER_174_1103 VDD VSS sg13g2_fill_2
X_13143_ _13170_/C _14916_/Q _13671_/Q VDD VSS sg13g2_xnor2_1
X_10355_ _10395_/A _14809_/Q _14810_/Q _14811_/Q VDD VSS sg13g2_nand3_1
XFILLER_48_1139 VDD VSS sg13g2_decap_8
XFILLER_3_742 VDD VSS sg13g2_decap_8
XFILLER_139_1278 VDD VSS sg13g2_fill_1
X_13074_ _15037_/D _13067_/Y _13073_/Y _13155_/A VDD VSS sg13g2_a21oi_1
X_10286_ _14789_/D _10286_/A _10288_/B _10295_/C VDD VSS sg13g2_and3_1
XFILLER_2_252 VDD VSS sg13g2_decap_8
XFILLER_111_117 VDD VSS sg13g2_decap_8
X_12025_ _12026_/B _12025_/A _14674_/Q VDD VSS sg13g2_nand2_1
XFILLER_120_662 VDD VSS sg13g2_fill_1
X_14469__1710 _14469_/RESET_B VDD VSS sg13g2_tiehi
XFILLER_4_1211 VDD VSS sg13g2_decap_8
XFILLER_18_7 VDD VSS sg13g2_decap_8
XFILLER_120_695 VDD VSS sg13g2_decap_4
XFILLER_76_94 VDD VSS sg13g2_decap_8
XFILLER_24_1183 VDD VSS sg13g2_decap_8
X_13976_ _13976_/Q _14632_/CLK _13976_/D _13976_/RESET_B VDD VSS sg13g2_dfrbpq_1
XFILLER_111_1153 VDD VSS sg13g2_decap_8
XFILLER_47_974 VDD VSS sg13g2_decap_4
XFILLER_20_1036 VDD VSS sg13g2_decap_8
XFILLER_19_665 VDD VSS sg13g2_decap_8
XFILLER_0_1108 VDD VSS sg13g2_decap_8
XFILLER_98_1262 VDD VSS sg13g2_decap_8
XFILLER_59_1213 VDD VSS sg13g2_decap_8
XFILLER_4_1288 VDD VSS sg13g2_decap_8
X_12927_ _12944_/B _12943_/A _12988_/A _12943_/D VDD VSS sg13g2_or3_1
XFILLER_74_782 VDD VSS sg13g2_fill_2
XFILLER_62_922 VDD VSS sg13g2_fill_1
XFILLER_34_613 VDD VSS sg13g2_fill_2
XFILLER_59_1246 VDD VSS sg13g2_decap_4
XFILLER_18_175 VDD VSS sg13g2_decap_8
XFILLER_73_281 VDD VSS sg13g2_fill_1
XFILLER_33_112 VDD VSS sg13g2_decap_8
XFILLER_73_292 VDD VSS sg13g2_decap_8
XFILLER_61_432 VDD VSS sg13g2_decap_8
XFILLER_146_1238 VDD VSS sg13g2_decap_8
X_12858_ _12874_/A _12859_/A _13689_/Q VDD VSS sg13g2_and2_1
XFILLER_61_465 VDD VSS sg13g2_decap_8
XFILLER_15_882 VDD VSS sg13g2_decap_8
X_11809_ _11809_/Y _11814_/S0 _14572_/Q VDD VSS sg13g2_nand2b_1
XFILLER_21_329 VDD VSS sg13g2_decap_8
X_12789_ _12789_/X _12785_/X _12784_/X _12781_/X _12780_/X _12789_/S0 _12789_/S1 VDD
+ VSS sg13g2_mux4_1
XFILLER_14_392 VDD VSS sg13g2_decap_8
XFILLER_159_364 VDD VSS sg13g2_decap_8
X_14528_ _14528_/Q clkload30/A _14528_/D _14528_/RESET_B VDD VSS sg13g2_dfrbpq_1
XFILLER_119_206 VDD VSS sg13g2_decap_8
XFILLER_30_885 VDD VSS sg13g2_decap_8
X_14459_ _14459_/Q _14885_/CLK _14459_/D _14459_/RESET_B VDD VSS sg13g2_dfrbpq_1
XFILLER_128_762 VDD VSS sg13g2_decap_4
X_14571__1608 _14571_/RESET_B VDD VSS sg13g2_tiehi
X_13957__2222 _13957_/RESET_B VDD VSS sg13g2_tiehi
XFILLER_174_378 VDD VSS sg13g2_decap_8
XFILLER_31_1176 VDD VSS sg13g2_decap_8
XFILLER_174_389 VDD VSS sg13g2_decap_8
XFILLER_115_423 VDD VSS sg13g2_decap_8
XFILLER_143_754 VDD VSS sg13g2_decap_8
XFILLER_157_1345 VDD VSS sg13g2_decap_8
XFILLER_142_242 VDD VSS sg13g2_fill_1
Xhold3106 _13629_/A _13737_/Q VDD VSS sg13g2_dlygate4sd3_1
XFILLER_44_0 VDD VSS sg13g2_decap_8
XFILLER_103_618 VDD VSS sg13g2_decap_8
XFILLER_142_264 VDD VSS sg13g2_fill_1
XFILLER_157_1378 VDD VSS sg13g2_decap_4
Xhold3117 _13641_/A _13749_/Q VDD VSS sg13g2_dlygate4sd3_1
XFILLER_143_798 VDD VSS sg13g2_fill_2
X_08951_ _08951_/Y _12278_/A _08940_/S _08950_/Y VDD VSS sg13g2_a21oi_1
Xhold3128 _13634_/A _13742_/Q VDD VSS sg13g2_dlygate4sd3_1
XFILLER_124_990 VDD VSS sg13g2_fill_2
XFILLER_170_595 VDD VSS sg13g2_decap_8
Xhold3139 _10929_/A _14937_/Q VDD VSS sg13g2_dlygate4sd3_1
XFILLER_29_1050 VDD VSS sg13g2_fill_2
XFILLER_130_448 VDD VSS sg13g2_decap_8
X_07902_ _08074_/B _08063_/A _07903_/B _07884_/Y VDD VSS sg13g2_o21ai_1
XFILLER_116_1031 VDD VSS sg13g2_fill_2
X_08882_ _08882_/X _08881_/X _11661_/A _08891_/S VDD VSS sg13g2_mux2_1
XFILLER_9_1155 VDD VSS sg13g2_decap_8
XFILLER_69_554 VDD VSS sg13g2_decap_8
XFILLER_5_1008 VDD VSS sg13g2_decap_8
XFILLER_99_1004 VDD VSS sg13g2_decap_4
XFILLER_110_150 VDD VSS sg13g2_fill_2
X_07833_ _07981_/C _08692_/C _08692_/B VDD VSS sg13g2_nand2b_1
XFILLER_99_1015 VDD VSS sg13g2_fill_1
XFILLER_116_1086 VDD VSS sg13g2_decap_8
XFILLER_99_1026 VDD VSS sg13g2_decap_8
XFILLER_84_535 VDD VSS sg13g2_decap_8
XFILLER_2_91 VDD VSS sg13g2_decap_8
X_07764_ _15216_/D _15098_/Q _15087_/Q _15074_/Q VDD VSS sg13g2_or3_1
XFILLER_72_708 VDD VSS sg13g2_decap_8
XFILLER_84_579 VDD VSS sg13g2_decap_4
X_09503_ _14103_/D _10099_/A0 _14103_/Q _09505_/S VDD VSS sg13g2_mux2_1
XFILLER_77_1335 VDD VSS sg13g2_decap_8
XFILLER_37_484 VDD VSS sg13g2_decap_8
X_07695_ _07696_/C _15079_/Q _15082_/Q _07694_/Y VDD VSS sg13g2_o21ai_1
XFILLER_77_1346 VDD VSS sg13g2_fill_2
XFILLER_52_410 VDD VSS sg13g2_fill_1
XFILLER_52_421 VDD VSS sg13g2_fill_1
XFILLER_24_112 VDD VSS sg13g2_decap_8
X_09434_ _14036_/D _09632_/A0 _14036_/Q _09434_/S VDD VSS sg13g2_mux2_1
XFILLER_38_1319 VDD VSS sg13g2_decap_8
XFILLER_77_1379 VDD VSS sg13g2_decap_4
XFILLER_13_819 VDD VSS sg13g2_decap_8
XFILLER_36_1021 VDD VSS sg13g2_decap_8
XFILLER_12_329 VDD VSS sg13g2_decap_8
X_09365_ _13969_/D _09629_/A0 _13969_/Q _09365_/S VDD VSS sg13g2_mux2_1
XFILLER_24_189 VDD VSS sg13g2_decap_8
XFILLER_33_690 VDD VSS sg13g2_decap_8
XFILLER_127_1171 VDD VSS sg13g2_fill_1
XFILLER_162_1051 VDD VSS sg13g2_decap_4
X_08316_ _08316_/Y _08275_/A _08303_/Y _08304_/Y VDD VSS sg13g2_o21ai_1
XFILLER_127_1182 VDD VSS sg13g2_decap_8
XANTENNA_30 _16881_/A VDD VSS sg13g2_antennanp
XFILLER_165_301 VDD VSS sg13g2_decap_8
X_09296_ _13904_/D _13904_/Q _10092_/A0 _09297_/S VDD VSS sg13g2_mux2_1
XFILLER_123_1035 VDD VSS sg13g2_decap_8
XFILLER_123_1046 VDD VSS sg13g2_fill_2
XFILLER_138_537 VDD VSS sg13g2_decap_4
XFILLER_14_1330 VDD VSS sg13g2_decap_8
XFILLER_21_896 VDD VSS sg13g2_decap_8
X_08247_ _08319_/C _08247_/A _08247_/B _08247_/C VDD VSS sg13g2_nor3_1
XFILLER_122_7 VDD VSS sg13g2_decap_8
XFILLER_166_879 VDD VSS sg13g2_fill_2
XFILLER_119_751 VDD VSS sg13g2_decap_4
XFILLER_119_773 VDD VSS sg13g2_fill_1
XFILLER_165_378 VDD VSS sg13g2_decap_8
X_14547__1632 _14547_/RESET_B VDD VSS sg13g2_tiehi
X_08178_ _08178_/Y _08060_/X _08029_/Y _08340_/A _08177_/X VDD VSS sg13g2_a22oi_1
XFILLER_21_56 VDD VSS sg13g2_decap_8
XFILLER_106_412 VDD VSS sg13g2_fill_1
XFILLER_119_795 VDD VSS sg13g2_decap_8
XFILLER_134_721 VDD VSS sg13g2_decap_8
XFILLER_106_423 VDD VSS sg13g2_decap_4
XFILLER_4_539 VDD VSS sg13g2_decap_8
XFILLER_137_56 VDD VSS sg13g2_decap_8
XFILLER_84_1306 VDD VSS sg13g2_decap_8
XFILLER_161_540 VDD VSS sg13g2_decap_8
X_10140_ _14717_/D _14717_/Q _10140_/A1 _10163_/S VDD VSS sg13g2_mux2_1
XFILLER_133_264 VDD VSS sg13g2_decap_8
XFILLER_0_723 VDD VSS sg13g2_decap_8
X_10071_ _14651_/D _10104_/A0 _14651_/Q _10096_/S VDD VSS sg13g2_mux2_1
XFILLER_43_1003 VDD VSS sg13g2_decap_8
XFILLER_43_1036 VDD VSS sg13g2_decap_8
XFILLER_48_716 VDD VSS sg13g2_fill_1
XFILLER_75_513 VDD VSS sg13g2_decap_8
XFILLER_153_77 VDD VSS sg13g2_decap_8
XFILLER_134_1197 VDD VSS sg13g2_decap_4
X_13830_ _13830_/Q _14310_/CLK _13830_/D _13830_/RESET_B VDD VSS sg13g2_dfrbpq_1
XFILLER_21_1323 VDD VSS sg13g2_decap_8
XFILLER_46_42 VDD VSS sg13g2_decap_8
XFILLER_16_602 VDD VSS sg13g2_decap_8
XFILLER_62_218 VDD VSS sg13g2_decap_8
X_13761_ _13761_/Q _14721_/CLK _13761_/D _13761_/RESET_B VDD VSS sg13g2_dfrbpq_1
Xclkbuf_5_26__f_clk_i clkbuf_leaf_52_clk_i/A clkbuf_4_13_0_clk_i/X VDD VSS sg13g2_buf_16
XFILLER_62_229 VDD VSS sg13g2_fill_2
X_10973_ _10973_/Y _10973_/A _11170_/B VDD VSS sg13g2_nand2_1
XFILLER_28_484 VDD VSS sg13g2_decap_8
XFILLER_15_112 VDD VSS sg13g2_decap_8
XFILLER_90_549 VDD VSS sg13g2_decap_4
XFILLER_43_421 VDD VSS sg13g2_decap_8
X_12712_ _12712_/X _14581_/Q _14613_/Q _14645_/Q _14677_/Q _12715_/S0 _12715_/S1 VDD
+ VSS sg13g2_mux4_1
XFILLER_55_292 VDD VSS sg13g2_decap_8
X_13692_ _13692_/Q clkload65/A _13692_/D _13692_/RESET_B VDD VSS sg13g2_dfrbpq_1
XFILLER_16_679 VDD VSS sg13g2_decap_8
XFILLER_44_988 VDD VSS sg13g2_decap_8
X_12643_ _12643_/X _14256_/Q _14288_/Q _14320_/Q _14352_/Q _12658_/S0 _12658_/S1 VDD
+ VSS sg13g2_mux4_1
XFILLER_15_189 VDD VSS sg13g2_decap_8
XFILLER_62_52 VDD VSS sg13g2_decap_8
XFILLER_43_498 VDD VSS sg13g2_decap_8
XFILLER_31_638 VDD VSS sg13g2_decap_8
XFILLER_19_1274 VDD VSS sg13g2_decap_8
XFILLER_15_1127 VDD VSS sg13g2_decap_8
XFILLER_168_161 VDD VSS sg13g2_decap_8
X_12574_ _12574_/X _13963_/Q _13995_/Q _14027_/Q _14059_/Q _12601_/S0 _12601_/S1 VDD
+ VSS sg13g2_mux4_1
XFILLER_8_812 VDD VSS sg13g2_decap_8
XFILLER_50_1007 VDD VSS sg13g2_fill_2
XFILLER_7_14 VDD VSS sg13g2_decap_8
XFILLER_54_1187 VDD VSS sg13g2_decap_8
XFILLER_141_1146 VDD VSS sg13g2_fill_1
X_14313_ _14313_/Q _14505_/CLK _14313_/D _14313_/RESET_B VDD VSS sg13g2_dfrbpq_1
XFILLER_12_896 VDD VSS sg13g2_decap_8
X_11525_ _11638_/A _11526_/A _12942_/B VDD VSS sg13g2_nor2_1
XFILLER_7_322 VDD VSS sg13g2_decap_8
X_14186__1993 _14186_/RESET_B VDD VSS sg13g2_tiehi
X_14244_ _14244_/Q _14703_/CLK _14244_/D _14244_/RESET_B VDD VSS sg13g2_dfrbpq_1
XFILLER_8_889 VDD VSS sg13g2_decap_8
XFILLER_109_261 VDD VSS sg13g2_fill_2
X_11456_ _11458_/B _11457_/A _11457_/B _11457_/C VDD VSS sg13g2_a21oi_1
XFILLER_125_721 VDD VSS sg13g2_decap_4
XFILLER_7_399 VDD VSS sg13g2_decap_8
X_10407_ _10407_/Y _14823_/Q _14824_/Q _14825_/Q _10413_/B VDD VSS sg13g2_nand4_1
XFILLER_171_348 VDD VSS sg13g2_decap_8
X_14175_ _14175_/Q clkload9/A _14175_/D _14175_/RESET_B VDD VSS sg13g2_dfrbpq_1
X_11387_ _14960_/D _11384_/A _11248_/B _11386_/Y VDD VSS sg13g2_a21o_1
XFILLER_125_776 VDD VSS sg13g2_decap_8
X_13126_ _13127_/B _13166_/A1 _13125_/X _13120_/X _13303_/A _13124_/Y VDD VSS sg13g2_a221oi_1
XFILLER_124_275 VDD VSS sg13g2_decap_8
X_10338_ _10345_/D _14803_/Q _14804_/Q _14805_/Q _14806_/Q VDD VSS sg13g2_and4_1
XFILLER_112_426 VDD VSS sg13g2_decap_4
XFILLER_113_949 VDD VSS sg13g2_decap_8
XFILLER_65_1250 VDD VSS sg13g2_decap_8
X_13057_ _13058_/B _13057_/A _13057_/B _13057_/C VDD VSS sg13g2_and3_1
X_10269_ _14784_/D _10269_/A _10299_/B _10295_/C VDD VSS sg13g2_and3_1
XFILLER_94_800 VDD VSS sg13g2_decap_8
XFILLER_26_1245 VDD VSS sg13g2_decap_8
XFILLER_121_971 VDD VSS sg13g2_decap_8
Xfanout1340 _12303_/S _12306_/A VDD VSS sg13g2_buf_1
XFILLER_94_811 VDD VSS sg13g2_fill_1
X_12008_ _12008_/Y _12009_/A _13670_/Q VDD VSS sg13g2_nor2_1
Xfanout1351 _12014_/S _12242_/A_N VDD VSS sg13g2_buf_1
XFILLER_61_1158 VDD VSS sg13g2_decap_8
XFILLER_39_738 VDD VSS sg13g2_fill_1
Xfanout1362 _12288_/S0 fanout1369/X VDD VSS sg13g2_buf_1
Xfanout1373 _10599_/A _10667_/A VDD VSS sg13g2_buf_1
XFILLER_94_844 VDD VSS sg13g2_decap_8
XFILLER_38_226 VDD VSS sg13g2_fill_2
Xfanout1384 _13266_/A _07625_/Y VDD VSS sg13g2_buf_1
XFILLER_66_546 VDD VSS sg13g2_decap_8
XFILLER_66_557 VDD VSS sg13g2_fill_1
Xfanout1395 _10334_/C _10557_/C VDD VSS sg13g2_buf_1
XFILLER_66_568 VDD VSS sg13g2_fill_1
XFILLER_47_760 VDD VSS sg13g2_decap_8
XFILLER_35_900 VDD VSS sg13g2_fill_1
XFILLER_35_911 VDD VSS sg13g2_decap_4
XFILLER_19_462 VDD VSS sg13g2_decap_8
X_13959_ _13959_/Q _14607_/CLK _13959_/D _13959_/RESET_B VDD VSS sg13g2_dfrbpq_1
XFILLER_81_538 VDD VSS sg13g2_decap_8
XFILLER_4_1085 VDD VSS sg13g2_decap_8
XFILLER_98_1092 VDD VSS sg13g2_decap_8
XFILLER_59_1043 VDD VSS sg13g2_decap_8
X_14625__1554 _14625_/RESET_B VDD VSS sg13g2_tiehi
XFILLER_50_914 VDD VSS sg13g2_decap_8
X_14907__2730 _14907_/RESET_B VDD VSS sg13g2_tiehi
XFILLER_72_1221 VDD VSS sg13g2_decap_8
XFILLER_21_126 VDD VSS sg13g2_decap_8
XFILLER_146_1079 VDD VSS sg13g2_decap_8
X_13689__2494 _13689_/RESET_B VDD VSS sg13g2_tiehi
XFILLER_124_1322 VDD VSS sg13g2_fill_2
X_09150_ _09156_/B _14923_/Q _09150_/B _09150_/C _09157_/D VDD VSS sg13g2_nand4_1
XFILLER_159_161 VDD VSS sg13g2_decap_8
X_08101_ _08101_/Y _08063_/A _07879_/A _08033_/A VDD VSS sg13g2_a21oi_1
X_09081_ _09087_/B _14913_/Q _13088_/A _09103_/C VDD VSS sg13g2_nand3_1
XFILLER_163_805 VDD VSS sg13g2_decap_8
X_08032_ _08032_/Y _08201_/A wire660/X _08032_/C _08032_/D VDD VSS sg13g2_nor4_1
XFILLER_162_348 VDD VSS sg13g2_decap_8
XFILLER_115_242 VDD VSS sg13g2_fill_1
XFILLER_107_26 VDD VSS sg13g2_decap_8
XFILLER_103_415 VDD VSS sg13g2_decap_8
X_09983_ _14566_/D _10082_/A0 _14566_/Q _09994_/S VDD VSS sg13g2_mux2_1
XFILLER_66_1058 VDD VSS sg13g2_fill_2
XFILLER_153_1028 VDD VSS sg13g2_decap_8
XFILLER_170_392 VDD VSS sg13g2_decap_8
XFILLER_44_1312 VDD VSS sg13g2_fill_2
XFILLER_103_459 VDD VSS sg13g2_decap_8
XFILLER_170_1320 VDD VSS sg13g2_decap_8
X_08934_ _08934_/X _08933_/X _12128_/A _08940_/S VDD VSS sg13g2_mux2_1
XFILLER_83_1372 VDD VSS sg13g2_decap_4
XFILLER_131_779 VDD VSS sg13g2_decap_8
X_15075__2849 _15075_/RESET_B VDD VSS sg13g2_tiehi
XFILLER_97_671 VDD VSS sg13g2_decap_8
XFILLER_131_1315 VDD VSS sg13g2_fill_1
XFILLER_85_822 VDD VSS sg13g2_decap_8
X_08865_ _08865_/Y _10694_/S _14934_/Q VDD VSS sg13g2_nor2b_1
XFILLER_97_693 VDD VSS sg13g2_fill_1
XFILLER_123_14 VDD VSS sg13g2_decap_8
XFILLER_44_1378 VDD VSS sg13g2_fill_2
XFILLER_131_1337 VDD VSS sg13g2_decap_8
XFILLER_131_1359 VDD VSS sg13g2_fill_2
X_15118__2723 _15118_/RESET_B VDD VSS sg13g2_tiehi
X_07816_ _07816_/X _15010_/Q _07818_/B VDD VSS sg13g2_and2_1
XFILLER_84_343 VDD VSS sg13g2_decap_8
XFILLER_29_259 VDD VSS sg13g2_decap_4
X_08796_ _13683_/D _08796_/A _08796_/B VDD VSS sg13g2_nor2_1
XFILLER_77_1110 VDD VSS sg13g2_decap_8
X_07747_ _13320_/C _13499_/C _13303_/A VDD VSS sg13g2_nand2_1
XFILLER_26_944 VDD VSS sg13g2_decap_8
XFILLER_25_421 VDD VSS sg13g2_decap_8
XFILLER_53_741 VDD VSS sg13g2_decap_8
XFILLER_164_1113 VDD VSS sg13g2_decap_8
XFILLER_16_56 VDD VSS sg13g2_decap_8
X_07678_ _07679_/D _13293_/A _13302_/C _11243_/C VDD VSS sg13g2_nand3b_1
XFILLER_13_616 VDD VSS sg13g2_decap_8
XFILLER_41_925 VDD VSS sg13g2_fill_2
X_09417_ _14019_/D _09615_/A0 _14019_/Q _09439_/S VDD VSS sg13g2_mux2_1
XFILLER_38_1149 VDD VSS sg13g2_decap_8
XFILLER_90_1310 VDD VSS sg13g2_decap_8
XFILLER_41_958 VDD VSS sg13g2_fill_2
XFILLER_12_126 VDD VSS sg13g2_decap_8
XFILLER_139_802 VDD VSS sg13g2_fill_1
XFILLER_9_609 VDD VSS sg13g2_decap_8
XFILLER_41_969 VDD VSS sg13g2_decap_8
X_09348_ _13952_/D _10076_/A0 _13952_/Q _09370_/S VDD VSS sg13g2_mux2_1
XFILLER_138_301 VDD VSS sg13g2_decap_8
XFILLER_8_119 VDD VSS sg13g2_decap_8
X_09279_ _13887_/D _13887_/Q _09910_/A1 _09297_/S VDD VSS sg13g2_mux2_1
XFILLER_21_693 VDD VSS sg13g2_decap_8
XFILLER_138_356 VDD VSS sg13g2_decap_8
XFILLER_166_665 VDD VSS sg13g2_fill_1
XFILLER_32_77 VDD VSS sg13g2_decap_8
XFILLER_138_367 VDD VSS sg13g2_fill_2
XFILLER_154_816 VDD VSS sg13g2_decap_8
XFILLER_166_687 VDD VSS sg13g2_decap_8
X_11310_ _11310_/Y _11310_/A1 _14525_/Q _11325_/B1 VDD VSS sg13g2_a21oi_1
XFILLER_165_175 VDD VSS sg13g2_decap_8
X_12290_ _12291_/B _12281_/X _12282_/X _12285_/X _12286_/X _12290_/S0 _12290_/S1 VDD
+ VSS sg13g2_mux4_1
XFILLER_5_826 VDD VSS sg13g2_decap_8
X_14063__2116 _14063_/RESET_B VDD VSS sg13g2_tiehi
XFILLER_153_348 VDD VSS sg13g2_decap_8
XFILLER_49_1212 VDD VSS sg13g2_decap_8
X_11241_ _11245_/A _11241_/A _11243_/C _11241_/C VDD VSS sg13g2_nand3_1
XFILLER_4_336 VDD VSS sg13g2_decap_8
XFILLER_10_1057 VDD VSS sg13g2_decap_8
XFILLER_162_860 VDD VSS sg13g2_fill_2
XFILLER_164_21 VDD VSS sg13g2_decap_8
XFILLER_162_882 VDD VSS sg13g2_decap_8
XFILLER_49_1267 VDD VSS sg13g2_decap_8
X_11172_ _11197_/A _11185_/A _11181_/A VDD VSS sg13g2_xnor2_1
XFILLER_134_595 VDD VSS sg13g2_decap_8
XFILLER_136_1237 VDD VSS sg13g2_decap_4
X_10123_ _14701_/D _10123_/A0 _14701_/Q _10123_/S VDD VSS sg13g2_mux2_1
X_14703__1476 _14703_/RESET_B VDD VSS sg13g2_tiehi
XFILLER_164_98 VDD VSS sg13g2_decap_8
XFILLER_0_553 VDD VSS sg13g2_decap_8
XFILLER_103_982 VDD VSS sg13g2_decap_8
XFILLER_121_278 VDD VSS sg13g2_decap_8
X_14931_ _14931_/Q _15226_/CLK _14931_/D _14931_/RESET_B VDD VSS sg13g2_dfrbpq_1
X_10054_ _14635_/D _10121_/A0 _14635_/Q _10060_/S VDD VSS sg13g2_mux2_1
X_14862_ _14862_/Q _14874_/CLK _14862_/D _14862_/RESET_B VDD VSS sg13g2_dfrbpq_1
XFILLER_91_803 VDD VSS sg13g2_fill_2
XFILLER_76_877 VDD VSS sg13g2_fill_2
XFILLER_21_1120 VDD VSS sg13g2_decap_8
XFILLER_29_760 VDD VSS sg13g2_fill_1
XFILLER_169_1035 VDD VSS sg13g2_fill_2
XFILLER_5_1372 VDD VSS sg13g2_fill_2
X_13813_ _13813_/Q clkload18/A _13813_/D _13813_/RESET_B VDD VSS sg13g2_dfrbpq_1
XFILLER_75_387 VDD VSS sg13g2_decap_8
XFILLER_91_847 VDD VSS sg13g2_decap_8
XFILLER_63_538 VDD VSS sg13g2_decap_8
XFILLER_1_1225 VDD VSS sg13g2_decap_8
X_14793_ _14793_/Q clkload51/A _14793_/D _14793_/RESET_B VDD VSS sg13g2_dfrbpq_1
XFILLER_95_1221 VDD VSS sg13g2_fill_2
XFILLER_75_398 VDD VSS sg13g2_fill_2
XFILLER_28_270 VDD VSS sg13g2_decap_4
XFILLER_90_346 VDD VSS sg13g2_decap_8
XFILLER_90_357 VDD VSS sg13g2_fill_1
XFILLER_21_1197 VDD VSS sg13g2_decap_8
XFILLER_17_966 VDD VSS sg13g2_decap_8
X_13744_ _13744_/Q clkload8/A _13744_/D _13744_/RESET_B VDD VSS sg13g2_dfrbpq_1
XFILLER_147_1333 VDD VSS sg13g2_decap_8
X_10956_ _10956_/Y _10956_/A _10956_/B _10956_/C VDD VSS sg13g2_nand3_1
XFILLER_32_914 VDD VSS sg13g2_decap_8
XFILLER_16_476 VDD VSS sg13g2_decap_8
XFILLER_95_1298 VDD VSS sg13g2_fill_1
XFILLER_32_947 VDD VSS sg13g2_decap_4
X_13675_ _13675_/Q _15188_/CLK _13675_/D _13675_/RESET_B VDD VSS sg13g2_dfrbpq_1
XFILLER_143_1219 VDD VSS sg13g2_fill_1
X_10887_ _14933_/D _10886_/X _10885_/Y _10875_/Y VDD VSS sg13g2_o21ai_1
XFILLER_32_969 VDD VSS sg13g2_decap_8
X_12626_ _12626_/X _14127_/Q _14159_/Q _14191_/Q _14223_/Q _12633_/S0 _12633_/S1 VDD
+ VSS sg13g2_mux4_1
X_14273__1906 _14273_/RESET_B VDD VSS sg13g2_tiehi
XFILLER_19_1071 VDD VSS sg13g2_decap_8
XFILLER_157_621 VDD VSS sg13g2_decap_8
XFILLER_85_7 VDD VSS sg13g2_decap_8
XFILLER_12_693 VDD VSS sg13g2_decap_8
X_12557_ _12557_/X _13834_/Q _13866_/Q _13898_/Q _13930_/Q _12562_/S0 _12562_/S1 VDD
+ VSS sg13g2_mux4_1
XFILLER_157_665 VDD VSS sg13g2_decap_8
XFILLER_117_507 VDD VSS sg13g2_decap_4
XFILLER_172_602 VDD VSS sg13g2_decap_4
X_11508_ _11508_/X _14691_/Q _14723_/Q _13763_/Q _13795_/Q _11715_/S0 _11715_/S1 VDD
+ VSS sg13g2_mux4_1
XFILLER_32_1260 VDD VSS sg13g2_decap_8
XFILLER_8_686 VDD VSS sg13g2_decap_8
XFILLER_89_1047 VDD VSS sg13g2_decap_4
XFILLER_144_326 VDD VSS sg13g2_decap_8
X_12488_ _12488_/X _14693_/Q _14725_/Q _13765_/Q _13797_/Q _12655_/S0 _12655_/S1 VDD
+ VSS sg13g2_mux4_1
XFILLER_89_1058 VDD VSS sg13g2_fill_1
XFILLER_172_646 VDD VSS sg13g2_decap_8
XFILLER_171_112 VDD VSS sg13g2_decap_8
X_14227_ _14227_/Q _14660_/CLK _14227_/D _14227_/RESET_B VDD VSS sg13g2_dfrbpq_1
XFILLER_7_196 VDD VSS sg13g2_decap_8
X_14039__2140 _14039_/RESET_B VDD VSS sg13g2_tiehi
X_11439_ _11445_/A _12214_/B _11439_/B VDD VSS sg13g2_or2_1
XFILLER_160_819 VDD VSS sg13g2_decap_8
XFILLER_125_551 VDD VSS sg13g2_decap_8
XFILLER_125_562 VDD VSS sg13g2_fill_2
XFILLER_153_871 VDD VSS sg13g2_fill_2
XFILLER_98_413 VDD VSS sg13g2_decap_8
XFILLER_112_201 VDD VSS sg13g2_fill_2
X_14158_ _14158_/Q clkload36/A _14158_/D _14158_/RESET_B VDD VSS sg13g2_dfrbpq_1
XFILLER_171_189 VDD VSS sg13g2_decap_8
XFILLER_28_1329 VDD VSS sg13g2_decap_8
XFILLER_113_757 VDD VSS sg13g2_fill_2
XFILLER_140_543 VDD VSS sg13g2_decap_8
XFILLER_154_1348 VDD VSS sg13g2_decap_4
X_13109_ _13109_/Y _13106_/Y _13107_/Y _13108_/Y VDD VSS sg13g2_a21oi_1
XFILLER_98_468 VDD VSS sg13g2_decap_8
X_14089_ _14089_/Q clkload20/A _14089_/D _14089_/RESET_B VDD VSS sg13g2_dfrbpq_1
XFILLER_65_1080 VDD VSS sg13g2_decap_8
XFILLER_26_1042 VDD VSS sg13g2_decap_8
X_13761__2418 _13761_/RESET_B VDD VSS sg13g2_tiehi
Xfanout1170 _08137_/A2 _11291_/A VDD VSS sg13g2_buf_1
Xfanout1181 _13245_/A _14922_/Q VDD VSS sg13g2_buf_1
X_08650_ _08650_/X _08650_/A _08650_/B VDD VSS sg13g2_xor2_1
XFILLER_6_1169 VDD VSS sg13g2_decap_8
XFILLER_27_708 VDD VSS sg13g2_decap_4
XFILLER_113_1056 VDD VSS sg13g2_decap_8
Xfanout1192 _10674_/A _14896_/Q VDD VSS sg13g2_buf_1
XFILLER_67_877 VDD VSS sg13g2_decap_8
XFILLER_81_313 VDD VSS sg13g2_decap_8
X_08581_ _15242_/D _08581_/A _08581_/B _08581_/C _08581_/D VDD VSS sg13g2_nand4_1
XFILLER_82_869 VDD VSS sg13g2_decap_8
X_15106__2749 _15106_/RESET_B VDD VSS sg13g2_tiehi
XFILLER_23_903 VDD VSS sg13g2_decap_8
X_14141__2038 _14141_/RESET_B VDD VSS sg13g2_tiehi
XFILLER_50_711 VDD VSS sg13g2_fill_2
XFILLER_62_582 VDD VSS sg13g2_decap_8
XFILLER_22_413 VDD VSS sg13g2_decap_8
XFILLER_34_284 VDD VSS sg13g2_decap_8
X_09202_ _13818_/D _13818_/Q _10169_/A1 _09202_/S VDD VSS sg13g2_mux2_1
X_14249__1930 _14249_/RESET_B VDD VSS sg13g2_tiehi
XFILLER_50_799 VDD VSS sg13g2_decap_8
XFILLER_37_1193 VDD VSS sg13g2_decap_8
XFILLER_148_643 VDD VSS sg13g2_decap_8
X_15147__2663 _15147_/RESET_B VDD VSS sg13g2_tiehi
X_09133_ _09137_/B _13200_/A _09157_/C _14921_/Q VDD VSS sg13g2_a21oi_1
XFILLER_31_991 VDD VSS sg13g2_fill_1
XFILLER_124_1163 VDD VSS sg13g2_decap_8
XFILLER_72_1095 VDD VSS sg13g2_decap_8
XFILLER_124_1174 VDD VSS sg13g2_fill_2
XFILLER_33_1079 VDD VSS sg13g2_decap_8
X_09064_ _13771_/D _13771_/Q _09922_/A1 _09106_/S VDD VSS sg13g2_mux2_1
XFILLER_163_635 VDD VSS sg13g2_decap_8
XFILLER_118_14 VDD VSS sg13g2_decap_8
XFILLER_159_1226 VDD VSS sg13g2_fill_2
XFILLER_162_112 VDD VSS sg13g2_decap_8
XFILLER_147_197 VDD VSS sg13g2_decap_8
XFILLER_11_1344 VDD VSS sg13g2_decap_8
XFILLER_135_348 VDD VSS sg13g2_fill_1
X_08015_ _08015_/Y _08014_/B _08013_/X _08014_/Y VDD VSS sg13g2_o21ai_1
XFILLER_163_668 VDD VSS sg13g2_fill_2
XFILLER_163_679 VDD VSS sg13g2_fill_1
XFILLER_116_551 VDD VSS sg13g2_decap_4
XFILLER_104_724 VDD VSS sg13g2_fill_1
XFILLER_150_329 VDD VSS sg13g2_decap_8
XFILLER_162_189 VDD VSS sg13g2_decap_8
XFILLER_103_212 VDD VSS sg13g2_decap_8
XFILLER_131_521 VDD VSS sg13g2_fill_2
X_09966_ _14550_/D _14550_/Q _10165_/A1 _09966_/S VDD VSS sg13g2_mux2_1
XFILLER_77_619 VDD VSS sg13g2_decap_8
XFILLER_103_278 VDD VSS sg13g2_decap_8
XFILLER_134_46 VDD VSS sg13g2_decap_8
XFILLER_44_1142 VDD VSS sg13g2_decap_8
X_08917_ _13711_/D _08932_/S _08915_/Y _08916_/Y VDD VSS sg13g2_a21oi_1
XFILLER_131_1101 VDD VSS sg13g2_fill_1
XFILLER_135_1270 VDD VSS sg13g2_decap_4
X_09897_ _14483_/D _09930_/A1 _14483_/Q _09899_/S VDD VSS sg13g2_mux2_1
XFILLER_94_28 VDD VSS sg13g2_decap_8
XFILLER_170_1194 VDD VSS sg13g2_fill_2
X_14351__1828 _14351_/RESET_B VDD VSS sg13g2_tiehi
X_13737__2442 _13737_/RESET_B VDD VSS sg13g2_tiehi
X_08848_ _08848_/Y _10691_/S _14929_/Q VDD VSS sg13g2_nor2b_1
X_14497__1682 _14497_/RESET_B VDD VSS sg13g2_tiehi
XFILLER_84_140 VDD VSS sg13g2_fill_2
XFILLER_57_365 VDD VSS sg13g2_fill_1
XFILLER_72_302 VDD VSS sg13g2_decap_8
XFILLER_45_516 VDD VSS sg13g2_decap_8
X_08779_ _08779_/Y _07720_/C _15115_/Q _15184_/Q _07719_/X VDD VSS sg13g2_a22oi_1
XFILLER_27_77 VDD VSS sg13g2_decap_8
XFILLER_150_56 VDD VSS sg13g2_decap_8
X_10810_ _10810_/Y _10809_/Y _10807_/Y _10801_/Y VDD VSS sg13g2_a21oi_1
XFILLER_26_752 VDD VSS sg13g2_decap_8
XFILLER_14_903 VDD VSS sg13g2_decap_8
XFILLER_60_508 VDD VSS sg13g2_decap_8
X_11790_ _11790_/X _11783_/X _11784_/X _11787_/X _11788_/X _11973_/B _11999_/S1 VDD
+ VSS sg13g2_mux4_1
XFILLER_13_413 VDD VSS sg13g2_decap_8
XFILLER_25_273 VDD VSS sg13g2_fill_2
X_14117__2062 _14117_/RESET_B VDD VSS sg13g2_tiehi
X_10741_ _10741_/Y _14913_/Q _11048_/B VDD VSS sg13g2_nand2_1
XFILLER_43_21 VDD VSS sg13g2_decap_8
XFILLER_159_919 VDD VSS sg13g2_decap_4
XFILLER_80_390 VDD VSS sg13g2_decap_8
XFILLER_129_1096 VDD VSS sg13g2_fill_1
XFILLER_159_21 VDD VSS sg13g2_decap_8
XFILLER_9_406 VDD VSS sg13g2_decap_8
XFILLER_16_1211 VDD VSS sg13g2_decap_8
X_13460_ _15106_/D _13456_/X _13459_/Y _13458_/Y VDD VSS sg13g2_o21ai_1
X_10672_ _10673_/A _07753_/B _10807_/B _13294_/B _14895_/Q VDD VSS sg13g2_a22oi_1
XFILLER_40_254 VDD VSS sg13g2_decap_8
XFILLER_167_930 VDD VSS sg13g2_decap_8
XFILLER_142_1230 VDD VSS sg13g2_fill_2
XFILLER_41_799 VDD VSS sg13g2_fill_1
XFILLER_139_643 VDD VSS sg13g2_fill_1
X_12411_ _12411_/X _14687_/Q _14719_/Q _13759_/Q _13791_/Q _12507_/S0 _12507_/S1 VDD
+ VSS sg13g2_mux4_1
XFILLER_51_1124 VDD VSS sg13g2_fill_2
XFILLER_43_98 VDD VSS sg13g2_decap_8
XFILLER_103_1203 VDD VSS sg13g2_fill_1
XFILLER_90_1184 VDD VSS sg13g2_decap_8
X_13391_ _13391_/Y _13438_/B _13494_/B _13391_/C VDD VSS sg13g2_nor3_1
XFILLER_159_98 VDD VSS sg13g2_decap_8
XFILLER_21_490 VDD VSS sg13g2_decap_8
XFILLER_139_676 VDD VSS sg13g2_decap_8
XFILLER_166_462 VDD VSS sg13g2_decap_8
XFILLER_167_996 VDD VSS sg13g2_decap_8
XFILLER_16_1288 VDD VSS sg13g2_decap_8
X_15130_ _15130_/Q _15214_/CLK _15130_/D _15130_/RESET_B VDD VSS sg13g2_dfrbpq_1
X_12342_ _12342_/X _13947_/Q _13979_/Q _14011_/Q _14043_/Q _12617_/S0 _12617_/S1 VDD
+ VSS sg13g2_mux4_1
XFILLER_51_1179 VDD VSS sg13g2_decap_4
XFILLER_153_112 VDD VSS sg13g2_decap_8
XFILLER_5_623 VDD VSS sg13g2_decap_8
XFILLER_111_0 VDD VSS sg13g2_decap_8
X_13985__2194 _13985_/RESET_B VDD VSS sg13g2_tiehi
X_15061_ _15061_/Q clkload71/A _15061_/D _15061_/RESET_B VDD VSS sg13g2_dfrbpq_1
X_12273_ _12273_/Y _12273_/A VDD VSS sg13g2_inv_1
XFILLER_4_133 VDD VSS sg13g2_decap_8
XFILLER_107_551 VDD VSS sg13g2_decap_8
XFILLER_141_307 VDD VSS sg13g2_decap_4
XFILLER_49_1031 VDD VSS sg13g2_decap_4
X_14012_ _14012_/Q clkload44/A _14012_/D _14012_/RESET_B VDD VSS sg13g2_dfrbpq_1
X_11224_ _11236_/D _11224_/A _11224_/B _11224_/C VDD VSS sg13g2_nor3_1
XFILLER_134_370 VDD VSS sg13g2_decap_8
XFILLER_150_830 VDD VSS sg13g2_decap_8
XFILLER_136_1023 VDD VSS sg13g2_decap_4
XFILLER_1_840 VDD VSS sg13g2_decap_8
XFILLER_122_554 VDD VSS sg13g2_decap_8
X_11155_ _14952_/D _11154_/Y _11153_/Y _11143_/Y VDD VSS sg13g2_o21ai_1
XFILLER_150_874 VDD VSS sg13g2_decap_4
XFILLER_68_62 VDD VSS sg13g2_fill_1
XFILLER_0_350 VDD VSS sg13g2_decap_8
X_14924__2696 _14924_/RESET_B VDD VSS sg13g2_tiehi
X_10106_ _14684_/D _14684_/Q _10136_/S _10105_/X VDD VSS sg13g2_a21o_1
XFILLER_27_1362 VDD VSS sg13g2_decap_8
X_11086_ _11118_/C _11125_/A _11115_/A VDD VSS sg13g2_xnor2_1
XFILLER_48_310 VDD VSS sg13g2_decap_8
XFILLER_62_1264 VDD VSS sg13g2_fill_2
XFILLER_3_1309 VDD VSS sg13g2_decap_8
XFILLER_23_1237 VDD VSS sg13g2_decap_8
X_14914_ _14914_/Q clkload43/A _14914_/D _14914_/RESET_B VDD VSS sg13g2_dfrbpq_1
X_10037_ _10037_/Y _10037_/A _10037_/B _10070_/C VDD VSS sg13g2_nand3_1
XFILLER_76_663 VDD VSS sg13g2_fill_2
X_14327__1852 _14327_/RESET_B VDD VSS sg13g2_tiehi
X_14845_ _14845_/Q _14854_/CLK _14845_/D _14845_/RESET_B VDD VSS sg13g2_dfrbpq_1
XFILLER_75_195 VDD VSS sg13g2_decap_8
XFILLER_1_1022 VDD VSS sg13g2_decap_8
XFILLER_84_94 VDD VSS sg13g2_decap_8
XFILLER_91_677 VDD VSS sg13g2_decap_8
X_14776_ _14776_/Q _14868_/CLK _14776_/D _14776_/RESET_B VDD VSS sg13g2_dfrbpq_1
XFILLER_17_763 VDD VSS sg13g2_decap_8
X_11988_ _11988_/Y _11986_/A _11988_/B _11989_/A VDD VSS sg13g2_nand3b_1
XFILLER_16_273 VDD VSS sg13g2_decap_8
X_13727_ _13727_/Q _14733_/CLK _13727_/D _13727_/RESET_B VDD VSS sg13g2_dfrbpq_1
XFILLER_32_722 VDD VSS sg13g2_decap_8
XFILLER_1_1099 VDD VSS sg13g2_decap_8
XFILLER_147_1163 VDD VSS sg13g2_fill_2
X_10939_ _10939_/Y _10956_/C _10936_/B _11183_/B1 VDD VSS sg13g2_o21ai_1
XFILLER_44_593 VDD VSS sg13g2_decap_8
XFILLER_17_1008 VDD VSS sg13g2_decap_8
XFILLER_20_917 VDD VSS sg13g2_decap_8
XFILLER_143_1038 VDD VSS sg13g2_fill_2
X_13658_ _13658_/Q _15213_/CLK _13658_/D _13658_/RESET_B VDD VSS sg13g2_dfrbpq_1
XFILLER_34_1311 VDD VSS sg13g2_decap_8
XFILLER_108_1169 VDD VSS sg13g2_fill_2
XFILLER_158_930 VDD VSS sg13g2_decap_4
Xclkbuf_leaf_61_clk_i clkload72/A clkbuf_leaf_61_clk_i/A VDD VSS sg13g2_buf_8
XFILLER_73_1371 VDD VSS sg13g2_decap_8
XFILLER_160_1330 VDD VSS sg13g2_fill_2
XFILLER_32_799 VDD VSS sg13g2_decap_8
XFILLER_13_980 VDD VSS sg13g2_decap_8
X_12609_ _12609_/X _12607_/X _12608_/X _12664_/S VDD VSS sg13g2_mux2_1
XFILLER_160_1352 VDD VSS sg13g2_decap_4
XFILLER_118_805 VDD VSS sg13g2_decap_4
XFILLER_121_1314 VDD VSS sg13g2_fill_1
X_13589_ _13589_/Y _15003_/Q _13566_/B _13569_/S _15019_/Q _13541_/X VDD VSS sg13g2_a221oi_1
XFILLER_12_490 VDD VSS sg13g2_decap_8
XFILLER_9_973 VDD VSS sg13g2_decap_8
XFILLER_30_1219 VDD VSS sg13g2_decap_8
XFILLER_118_849 VDD VSS sg13g2_fill_2
XFILLER_129_186 VDD VSS sg13g2_decap_8
XFILLER_145_635 VDD VSS sg13g2_decap_4
XFILLER_172_421 VDD VSS sg13g2_decap_8
XFILLER_8_483 VDD VSS sg13g2_decap_8
XFILLER_144_123 VDD VSS sg13g2_decap_8
XFILLER_144_134 VDD VSS sg13g2_fill_2
X_13815__2364 _13815_/RESET_B VDD VSS sg13g2_tiehi
Xclkbuf_leaf_76_clk_i clkload42/A clkbuf_leaf_77_clk_i/A VDD VSS sg13g2_buf_8
XFILLER_132_307 VDD VSS sg13g2_decap_8
XFILLER_160_627 VDD VSS sg13g2_fill_1
XFILLER_160_638 VDD VSS sg13g2_decap_8
XFILLER_172_498 VDD VSS sg13g2_decap_8
XFILLER_98_210 VDD VSS sg13g2_decap_8
XFILLER_28_1126 VDD VSS sg13g2_decap_8
Xfanout407 _13470_/A2 _13353_/Y VDD VSS sg13g2_buf_1
X_09820_ _14408_/D _09045_/Y _14408_/Q _09829_/S VDD VSS sg13g2_mux2_1
Xfanout418 _10134_/S _10123_/S VDD VSS sg13g2_buf_1
XFILLER_59_608 VDD VSS sg13g2_decap_8
XFILLER_101_705 VDD VSS sg13g2_decap_8
Xfanout429 _10003_/S _09971_/Y VDD VSS sg13g2_buf_1
XFILLER_100_204 VDD VSS sg13g2_fill_1
XFILLER_119_1298 VDD VSS sg13g2_fill_1
XFILLER_140_373 VDD VSS sg13g2_fill_2
X_09751_ _14341_/D _14341_/Q _09916_/A1 _09763_/S VDD VSS sg13g2_mux2_1
XFILLER_100_248 VDD VSS sg13g2_fill_2
X_08702_ _15249_/D _08700_/Y _08701_/Y _08694_/Y VDD VSS sg13g2_o21ai_1
X_09682_ _14274_/D _10145_/A1 _14274_/Q _09705_/S VDD VSS sg13g2_mux2_1
XFILLER_41_1348 VDD VSS sg13g2_decap_8
XFILLER_27_505 VDD VSS sg13g2_fill_2
X_08633_ _15245_/D _08633_/A _08633_/B _08633_/C VDD VSS sg13g2_nand3_1
Xclkbuf_leaf_14_clk_i _14632_/CLK clkbuf_5_6__f_clk_i/X VDD VSS sg13g2_buf_8
XFILLER_54_346 VDD VSS sg13g2_decap_4
X_08564_ _08581_/D _15013_/Q _07861_/B _08674_/B1 VDD VSS sg13g2_o21ai_1
XFILLER_39_1211 VDD VSS sg13g2_decap_8
XFILLER_82_699 VDD VSS sg13g2_fill_2
XFILLER_165_1241 VDD VSS sg13g2_fill_1
XFILLER_81_187 VDD VSS sg13g2_decap_8
XFILLER_39_1244 VDD VSS sg13g2_decap_4
XFILLER_22_210 VDD VSS sg13g2_decap_8
XFILLER_168_705 VDD VSS sg13g2_fill_2
X_08495_ _08495_/Y _08447_/B _08574_/C _08494_/Y VDD VSS sg13g2_a21oi_1
XFILLER_50_541 VDD VSS sg13g2_fill_1
XFILLER_39_1288 VDD VSS sg13g2_decap_4
XFILLER_11_917 VDD VSS sg13g2_decap_8
Xclkbuf_leaf_29_clk_i _14659_/CLK clkbuf_leaf_9_clk_i/A VDD VSS sg13g2_buf_8
XFILLER_50_563 VDD VSS sg13g2_decap_8
XFILLER_39_1299 VDD VSS sg13g2_decap_4
XFILLER_23_777 VDD VSS sg13g2_decap_4
XFILLER_10_427 VDD VSS sg13g2_decap_8
XFILLER_22_287 VDD VSS sg13g2_decap_8
XFILLER_13_35 VDD VSS sg13g2_decap_8
XFILLER_167_259 VDD VSS sg13g2_decap_8
XFILLER_109_805 VDD VSS sg13g2_decap_8
XFILLER_129_35 VDD VSS sg13g2_decap_8
XFILLER_149_985 VDD VSS sg13g2_decap_4
X_09116_ _09117_/C _13189_/A _10760_/A _13142_/A _09136_/B VDD VSS sg13g2_nand4_1
XFILLER_89_28 VDD VSS sg13g2_decap_8
XFILLER_135_134 VDD VSS sg13g2_decap_8
XFILLER_164_966 VDD VSS sg13g2_decap_8
XFILLER_11_1141 VDD VSS sg13g2_decap_8
X_09047_ _09047_/Y _15232_/Q _09107_/B VDD VSS sg13g2_nand2b_1
X_14405__1774 _14405_/RESET_B VDD VSS sg13g2_tiehi
XFILLER_163_476 VDD VSS sg13g2_decap_8
XFILLER_159_1078 VDD VSS sg13g2_decap_8
XFILLER_104_510 VDD VSS sg13g2_decap_8
XFILLER_2_637 VDD VSS sg13g2_decap_8
XFILLER_116_392 VDD VSS sg13g2_fill_1
XFILLER_145_56 VDD VSS sg13g2_decap_8
XFILLER_150_159 VDD VSS sg13g2_decap_8
XFILLER_89_243 VDD VSS sg13g2_fill_2
XFILLER_145_67 VDD VSS sg13g2_fill_2
XFILLER_1_147 VDD VSS sg13g2_decap_8
XFILLER_133_1207 VDD VSS sg13g2_decap_8
XFILLER_78_939 VDD VSS sg13g2_fill_2
Xfanout930 _12844_/C _12936_/B VDD VSS sg13g2_buf_1
XFILLER_131_373 VDD VSS sg13g2_fill_2
Xfanout941 _10199_/A1 _15181_/Q VDD VSS sg13g2_buf_1
Xfanout952 _07729_/D _15108_/Q VDD VSS sg13g2_buf_1
X_09949_ _14533_/D _14533_/Q _09949_/A1 _09961_/S VDD VSS sg13g2_mux2_1
XFILLER_38_21 VDD VSS sg13g2_decap_8
Xfanout963 _12851_/B _07729_/B VDD VSS sg13g2_buf_1
Xfanout974 _11191_/A _10983_/A1 VDD VSS sg13g2_buf_1
Xfanout985 _08760_/A1 _15069_/Q VDD VSS sg13g2_buf_1
X_12960_ _12960_/Y _12961_/A _12961_/C _12988_/C VDD VSS sg13g2_a21oi_1
Xfanout996 _10070_/A _09938_/C VDD VSS sg13g2_buf_1
X_11911_ _11912_/B _12056_/A _12056_/B VDD VSS sg13g2_nand2_1
XFILLER_58_696 VDD VSS sg13g2_decap_8
XFILLER_161_77 VDD VSS sg13g2_decap_8
XFILLER_45_324 VDD VSS sg13g2_fill_2
X_12891_ _12925_/A _14900_/Q _13687_/Q VDD VSS sg13g2_nand2_1
XFILLER_72_132 VDD VSS sg13g2_decap_4
X_14630_ _14630_/Q _14662_/CLK _14630_/D _14630_/RESET_B VDD VSS sg13g2_dfrbpq_1
X_11842_ _11867_/A _11843_/A _13675_/Q VDD VSS sg13g2_nand2_1
XFILLER_14_700 VDD VSS sg13g2_decap_8
XFILLER_54_42 VDD VSS sg13g2_decap_8
XFILLER_159_0 VDD VSS sg13g2_decap_8
X_14561_ _14561_/Q _14681_/CLK _14561_/D _14561_/RESET_B VDD VSS sg13g2_dfrbpq_1
XFILLER_57_1344 VDD VSS sg13g2_decap_8
XFILLER_13_210 VDD VSS sg13g2_decap_8
X_11773_ _11776_/B _11773_/A _11773_/B _11773_/C _11773_/D VDD VSS sg13g2_nor4_1
XFILLER_57_1355 VDD VSS sg13g2_fill_2
XFILLER_41_541 VDD VSS sg13g2_decap_8
XFILLER_159_727 VDD VSS sg13g2_fill_1
X_13512_ _15135_/D _15135_/Q _08621_/A _13519_/B VDD VSS sg13g2_mux2_1
XFILLER_14_777 VDD VSS sg13g2_decap_8
X_10724_ _14908_/D _10724_/A VDD VSS sg13g2_inv_1
XFILLER_159_749 VDD VSS sg13g2_fill_2
X_14492_ _14492_/Q _14854_/CLK _14492_/D _14492_/RESET_B VDD VSS sg13g2_dfrbpq_1
XFILLER_9_203 VDD VSS sg13g2_decap_8
XFILLER_13_287 VDD VSS sg13g2_decap_8
X_13443_ _15103_/D _15103_/Q _13353_/Y _13442_/Y VDD VSS sg13g2_a21o_1
X_10655_ _14890_/D _10663_/D _10661_/A _10655_/C VDD VSS sg13g2_nor3_1
XFILLER_167_782 VDD VSS sg13g2_fill_1
XFILLER_16_1085 VDD VSS sg13g2_decap_8
XFILLER_6_910 VDD VSS sg13g2_decap_8
X_13374_ _15077_/D _13361_/C _13444_/A _13372_/Y VDD VSS sg13g2_o21ai_1
Xclkload17 clkload17/Y clkload17/A VDD VSS sg13g2_inv_1
XFILLER_126_112 VDD VSS sg13g2_decap_8
XFILLER_139_495 VDD VSS sg13g2_decap_8
Xclkload28 clkload28/Y clkload28/A VDD VSS sg13g2_inv_2
X_10586_ _10597_/D _10649_/B _14872_/Q _14871_/Q _10586_/D VDD VSS sg13g2_and4_1
XFILLER_10_994 VDD VSS sg13g2_decap_8
XFILLER_126_123 VDD VSS sg13g2_fill_2
XFILLER_127_657 VDD VSS sg13g2_decap_8
X_15113_ _15113_/Q _15113_/CLK _15113_/D _15113_/RESET_B VDD VSS sg13g2_dfrbpq_1
Xclkload39 clkload39/Y clkload39/A VDD VSS sg13g2_inv_2
XFILLER_5_420 VDD VSS sg13g2_decap_8
X_12325_ _12325_/Y _12326_/A1 _13850_/Q VDD VSS sg13g2_nand2b_1
XFILLER_170_914 VDD VSS sg13g2_decap_8
X_15070__2865 _15070_/RESET_B VDD VSS sg13g2_tiehi
XFILLER_6_987 VDD VSS sg13g2_decap_8
XFILLER_138_1129 VDD VSS sg13g2_fill_2
XFILLER_142_638 VDD VSS sg13g2_decap_8
X_15044_ _15044_/Q _15064_/CLK _15044_/D _15044_/RESET_B VDD VSS sg13g2_dfrbpq_1
XFILLER_126_189 VDD VSS sg13g2_fill_2
X_12256_ _12256_/Y _12017_/A _13912_/Q VDD VSS sg13g2_nand2b_1
XFILLER_5_497 VDD VSS sg13g2_decap_8
XFILLER_48_7 VDD VSS sg13g2_decap_8
XFILLER_170_969 VDD VSS sg13g2_decap_8
X_11207_ _11207_/Y _11205_/A _11207_/A2 _11207_/B1 VDD VSS sg13g2_a21oi_1
X_15131__2695 _15131_/RESET_B VDD VSS sg13g2_tiehi
X_12187_ _12188_/B _12187_/A _12187_/B _12187_/C VDD VSS sg13g2_nand3_1
XFILLER_69_939 VDD VSS sg13g2_decap_4
XFILLER_110_513 VDD VSS sg13g2_decap_8
XFILLER_150_682 VDD VSS sg13g2_decap_8
X_11138_ _11138_/Y _11163_/A _11138_/B _11138_/C VDD VSS sg13g2_nand3b_1
XFILLER_96_747 VDD VSS sg13g2_decap_8
XFILLER_7_1253 VDD VSS sg13g2_decap_8
XFILLER_114_1151 VDD VSS sg13g2_decap_8
X_11069_ _11069_/Y _11078_/B _11069_/B VDD VSS sg13g2_xnor2_1
XFILLER_3_1106 VDD VSS sg13g2_decap_8
XFILLER_62_1094 VDD VSS sg13g2_decap_8
XFILLER_37_836 VDD VSS sg13g2_decap_8
XFILLER_97_1146 VDD VSS sg13g2_decap_8
XFILLER_92_964 VDD VSS sg13g2_fill_1
XFILLER_110_1059 VDD VSS sg13g2_decap_8
XFILLER_64_666 VDD VSS sg13g2_fill_1
XFILLER_24_508 VDD VSS sg13g2_decap_8
X_14828_ _14828_/Q _14890_/CLK _14828_/D _14828_/RESET_B VDD VSS sg13g2_dfrbpq_1
XFILLER_97_1179 VDD VSS sg13g2_decap_8
XFILLER_17_560 VDD VSS sg13g2_decap_8
X_14759_ _14759_/Q _15183_/CLK _14759_/D _14759_/RESET_B VDD VSS sg13g2_dfrbpq_1
X_08280_ _08280_/X _08338_/B _08207_/X _08279_/X VDD VSS sg13g2_a21o_1
XFILLER_32_574 VDD VSS sg13g2_decap_8
XFILLER_20_714 VDD VSS sg13g2_decap_8
XFILLER_34_1141 VDD VSS sg13g2_fill_1
XFILLER_165_719 VDD VSS sg13g2_decap_8
XFILLER_118_602 VDD VSS sg13g2_decap_8
XFILLER_158_782 VDD VSS sg13g2_decap_8
X_14662__1517 _14662_/RESET_B VDD VSS sg13g2_tiehi
XFILLER_9_770 VDD VSS sg13g2_decap_8
XFILLER_74_0 VDD VSS sg13g2_decap_8
XFILLER_121_1133 VDD VSS sg13g2_fill_2
XFILLER_146_933 VDD VSS sg13g2_decap_8
XFILLER_8_280 VDD VSS sg13g2_decap_8
XFILLER_117_145 VDD VSS sg13g2_decap_8
XFILLER_118_668 VDD VSS sg13g2_fill_2
XFILLER_146_988 VDD VSS sg13g2_decap_8
XFILLER_146_999 VDD VSS sg13g2_fill_1
X_14091__2088 _14091_/RESET_B VDD VSS sg13g2_tiehi
XFILLER_117_189 VDD VSS sg13g2_decap_8
XFILLER_161_947 VDD VSS sg13g2_decap_4
XFILLER_160_435 VDD VSS sg13g2_fill_2
XFILLER_114_841 VDD VSS sg13g2_decap_4
XFILLER_114_874 VDD VSS sg13g2_decap_8
Xfanout204 _10090_/A0 _10157_/A1 VDD VSS sg13g2_buf_1
XFILLER_5_91 VDD VSS sg13g2_decap_8
X_14199__1980 _14199_/RESET_B VDD VSS sg13g2_tiehi
Xfanout215 _09624_/A0 fanout219/X VDD VSS sg13g2_buf_1
Xfanout226 _10086_/A0 _09789_/A0 VDD VSS sg13g2_buf_1
Xfanout237 _12271_/A _12295_/B1 VDD VSS sg13g2_buf_1
X_09803_ _14392_/D _09935_/A1 _14392_/Q _09804_/S VDD VSS sg13g2_mux2_1
X_15030__2557 _15030_/RESET_B VDD VSS sg13g2_tiehi
XFILLER_140_170 VDD VSS sg13g2_decap_8
Xfanout248 _09919_/A1 _09045_/Y VDD VSS sg13g2_buf_1
XFILLER_140_181 VDD VSS sg13g2_fill_2
Xfanout259 _10060_/S _10069_/S VDD VSS sg13g2_buf_1
X_07995_ _08275_/B _15104_/Q _15091_/Q VDD VSS sg13g2_nor2_1
X_09734_ _14325_/D _09932_/A1 _14325_/Q _09738_/S VDD VSS sg13g2_mux2_1
XFILLER_68_961 VDD VSS sg13g2_decap_8
XFILLER_45_1292 VDD VSS sg13g2_decap_8
XFILLER_74_419 VDD VSS sg13g2_decap_4
XFILLER_83_920 VDD VSS sg13g2_decap_8
X_09665_ _14258_/D _10061_/A0 _14258_/Q _09673_/S VDD VSS sg13g2_mux2_1
XFILLER_131_14 VDD VSS sg13g2_decap_8
X_15045__2535 _15045_/RESET_B VDD VSS sg13g2_tiehi
XFILLER_131_25 VDD VSS sg13g2_fill_2
XFILLER_82_441 VDD VSS sg13g2_decap_8
X_08616_ _08616_/Y _13533_/A _08616_/B VDD VSS sg13g2_nand2b_1
XFILLER_54_154 VDD VSS sg13g2_decap_8
X_09596_ _14193_/D _14193_/Q _09629_/A0 _09596_/S VDD VSS sg13g2_mux2_1
XFILLER_167_1358 VDD VSS sg13g2_decap_8
X_08547_ _08547_/Y _07956_/A _07812_/B _08497_/A VDD VSS sg13g2_a21oi_1
XFILLER_42_338 VDD VSS sg13g2_decap_8
XFILLER_152_7 VDD VSS sg13g2_decap_8
XFILLER_165_1071 VDD VSS sg13g2_decap_8
XFILLER_11_714 VDD VSS sg13g2_decap_8
X_08478_ _08478_/Y _07805_/B _07949_/C _08447_/B VDD VSS sg13g2_o21ai_1
XFILLER_24_56 VDD VSS sg13g2_decap_8
XFILLER_168_546 VDD VSS sg13g2_decap_8
XFILLER_10_224 VDD VSS sg13g2_decap_8
XFILLER_91_1290 VDD VSS sg13g2_fill_1
XFILLER_7_707 VDD VSS sg13g2_decap_8
XFILLER_17_1372 VDD VSS sg13g2_decap_8
XFILLER_137_922 VDD VSS sg13g2_decap_8
XFILLER_13_1225 VDD VSS sg13g2_decap_8
Xwire649 wire649/X wire649/A VDD VSS sg13g2_buf_2
X_10440_ _10442_/B _14836_/Q _14835_/Q _10443_/D VDD VSS sg13g2_nand3_1
XFILLER_6_217 VDD VSS sg13g2_decap_8
XFILLER_52_1274 VDD VSS sg13g2_fill_1
X_14638__1541 _14638_/RESET_B VDD VSS sg13g2_tiehi
XFILLER_100_1217 VDD VSS sg13g2_decap_8
XFILLER_109_657 VDD VSS sg13g2_decap_8
XFILLER_152_903 VDD VSS sg13g2_decap_8
XFILLER_137_988 VDD VSS sg13g2_decap_8
X_10371_ _10371_/Y _14815_/Q _10378_/D _10630_/C VDD VSS sg13g2_o21ai_1
XFILLER_108_156 VDD VSS sg13g2_fill_1
XFILLER_137_999 VDD VSS sg13g2_fill_2
XFILLER_108_167 VDD VSS sg13g2_decap_8
XFILLER_174_1307 VDD VSS sg13g2_decap_8
XFILLER_108_178 VDD VSS sg13g2_fill_1
XFILLER_163_273 VDD VSS sg13g2_decap_8
X_12110_ _12110_/Y _12250_/A1 _13876_/Q _12312_/B1 VDD VSS sg13g2_a21oi_1
XFILLER_3_924 VDD VSS sg13g2_decap_8
XFILLER_156_77 VDD VSS sg13g2_decap_8
X_13090_ _13092_/C _14911_/Q _13676_/Q _13077_/X VDD VSS sg13g2_a21oi_1
XFILLER_105_841 VDD VSS sg13g2_fill_2
XFILLER_2_434 VDD VSS sg13g2_decap_8
XFILLER_123_148 VDD VSS sg13g2_decap_4
XFILLER_105_863 VDD VSS sg13g2_decap_4
X_12041_ _12041_/Y _12037_/Y _12038_/Y _12040_/Y _12039_/Y _12239_/B VDD VSS sg13g2_a221oi_1
XFILLER_104_340 VDD VSS sg13g2_decap_8
XFILLER_78_703 VDD VSS sg13g2_decap_8
XFILLER_49_42 VDD VSS sg13g2_decap_8
XFILLER_172_21 VDD VSS sg13g2_decap_8
XFILLER_172_1053 VDD VSS sg13g2_decap_4
XFILLER_104_395 VDD VSS sg13g2_decap_4
XFILLER_137_1195 VDD VSS sg13g2_decap_4
X_15006__2581 _15006_/RESET_B VDD VSS sg13g2_tiehi
XFILLER_49_86 VDD VSS sg13g2_decap_8
XFILLER_46_1089 VDD VSS sg13g2_decap_8
Xfanout760 _08063_/A _13550_/A1 VDD VSS sg13g2_buf_1
Xfanout771 _10873_/A1 _10912_/A1 VDD VSS sg13g2_buf_1
Xfanout782 _12762_/S fanout783/X VDD VSS sg13g2_buf_1
X_13992_ _13992_/Q _14310_/CLK _13992_/D _13992_/RESET_B VDD VSS sg13g2_dfrbpq_1
XFILLER_172_98 VDD VSS sg13g2_decap_8
Xfanout793 _12761_/S0 _12649_/S0 VDD VSS sg13g2_buf_1
XFILLER_105_70 VDD VSS sg13g2_decap_8
XFILLER_24_1365 VDD VSS sg13g2_decap_8
XFILLER_1_49 VDD VSS sg13g2_decap_8
XFILLER_74_931 VDD VSS sg13g2_decap_8
X_12943_ _12961_/A _12943_/A _12988_/A _12988_/B _12943_/D VDD VSS sg13g2_or4_1
X_14815__2898 _14815_/RESET_B VDD VSS sg13g2_tiehi
XFILLER_20_1218 VDD VSS sg13g2_decap_8
XFILLER_19_847 VDD VSS sg13g2_decap_8
XFILLER_73_430 VDD VSS sg13g2_decap_8
X_14740__1439 _14740_/RESET_B VDD VSS sg13g2_tiehi
XFILLER_74_975 VDD VSS sg13g2_decap_8
XFILLER_18_357 VDD VSS sg13g2_decap_8
X_12874_ _12878_/A _12874_/A _12876_/A _12877_/C VDD VSS sg13g2_or3_1
XFILLER_45_176 VDD VSS sg13g2_fill_1
XFILLER_45_187 VDD VSS sg13g2_decap_8
XFILLER_2_1183 VDD VSS sg13g2_decap_8
X_14613_ _14613_/Q _14677_/CLK _14613_/D _14613_/RESET_B VDD VSS sg13g2_dfrbpq_1
X_11825_ _11825_/Y _11353_/S _13900_/Q VDD VSS sg13g2_nand2b_1
XFILLER_33_338 VDD VSS sg13g2_fill_1
XFILLER_96_1190 VDD VSS sg13g2_fill_1
XFILLER_33_349 VDD VSS sg13g2_decap_8
XFILLER_148_1280 VDD VSS sg13g2_fill_1
X_14544_ _14544_/Q _14672_/CLK _14544_/D _14544_/RESET_B VDD VSS sg13g2_dfrbpq_1
X_11756_ _11756_/X _13834_/Q _13866_/Q _11759_/A VDD VSS sg13g2_mux2_1
XFILLER_109_1264 VDD VSS sg13g2_decap_4
XFILLER_14_574 VDD VSS sg13g2_decap_8
XFILLER_144_1166 VDD VSS sg13g2_decap_8
X_10707_ _14904_/D _10999_/B1 _10923_/B _10706_/Y VDD VSS sg13g2_o21ai_1
XFILLER_18_1169 VDD VSS sg13g2_decap_8
XFILLER_159_579 VDD VSS sg13g2_decap_8
X_14475_ _14475_/Q clkload3/A _14475_/D _14475_/RESET_B VDD VSS sg13g2_dfrbpq_1
XFILLER_70_1330 VDD VSS sg13g2_decap_8
X_11687_ _11687_/X _11687_/A _12036_/B VDD VSS sg13g2_and2_1
X_13426_ _15095_/D _13435_/B _13425_/Y _13423_/Y VDD VSS sg13g2_o21ai_1
X_10638_ _10640_/A _14886_/Q _10633_/C _14887_/Q VDD VSS sg13g2_a21oi_1
XFILLER_128_955 VDD VSS sg13g2_decap_8
XFILLER_31_1358 VDD VSS sg13g2_decap_8
XFILLER_10_791 VDD VSS sg13g2_decap_8
XFILLER_143_903 VDD VSS sg13g2_fill_1
XFILLER_154_240 VDD VSS sg13g2_decap_8
XFILLER_155_763 VDD VSS sg13g2_decap_8
X_13357_ _13357_/Y _13401_/C _13401_/B _13429_/A _13361_/C VDD VSS sg13g2_nor4_1
XFILLER_154_251 VDD VSS sg13g2_fill_2
X_10569_ _14868_/D _10576_/C _10576_/D _10557_/B _07621_/Y _10572_/B VDD VSS sg13g2_a221oi_1
X_12308_ _12308_/Y _12308_/A _12308_/B _12308_/C VDD VSS sg13g2_nand3_1
XFILLER_6_784 VDD VSS sg13g2_decap_8
XFILLER_170_733 VDD VSS sg13g2_decap_8
X_13288_ _13289_/D _15204_/Q _13506_/A VDD VSS sg13g2_nand2b_1
XFILLER_5_294 VDD VSS sg13g2_decap_8
X_15027_ _15027_/Q clkload55/A _15027_/D _15027_/RESET_B VDD VSS sg13g2_dfrbpq_1
X_12239_ _12239_/Y _12239_/A _12239_/B VDD VSS sg13g2_nand2_1
XFILLER_130_619 VDD VSS sg13g2_decap_8
XFILLER_142_479 VDD VSS sg13g2_fill_1
XFILLER_29_1254 VDD VSS sg13g2_decap_8
XFILLER_9_1337 VDD VSS sg13g2_decap_8
XFILLER_69_725 VDD VSS sg13g2_decap_8
XFILLER_123_693 VDD VSS sg13g2_decap_8
XFILLER_151_1115 VDD VSS sg13g2_fill_2
XFILLER_116_1246 VDD VSS sg13g2_decap_8
XFILLER_111_866 VDD VSS sg13g2_decap_8
XFILLER_68_246 VDD VSS sg13g2_decap_8
X_14076__2103 _14076_/RESET_B VDD VSS sg13g2_tiehi
XFILLER_151_1159 VDD VSS sg13g2_fill_2
XFILLER_96_577 VDD VSS sg13g2_decap_8
XFILLER_7_1050 VDD VSS sg13g2_decap_8
X_07780_ _07797_/B _08318_/C _08318_/D VDD VSS sg13g2_or2_1
XFILLER_110_376 VDD VSS sg13g2_decap_4
XFILLER_49_471 VDD VSS sg13g2_decap_8
Xinput4 input4/X input4/A VDD VSS sg13g2_buf_1
XFILLER_36_121 VDD VSS sg13g2_decap_8
XFILLER_149_1011 VDD VSS sg13g2_decap_8
XFILLER_37_666 VDD VSS sg13g2_decap_8
X_09450_ _14051_/D _09615_/A0 _14051_/Q _09472_/S VDD VSS sg13g2_mux2_1
X_14716__1463 _14716_/RESET_B VDD VSS sg13g2_tiehi
XFILLER_92_783 VDD VSS sg13g2_decap_8
XFILLER_91_260 VDD VSS sg13g2_decap_8
XFILLER_149_1055 VDD VSS sg13g2_decap_8
X_08401_ _08625_/A _15097_/Q _15092_/Q _07911_/A VDD VSS sg13g2_o21ai_1
XFILLER_24_327 VDD VSS sg13g2_decap_8
X_09381_ _13984_/D _10076_/A0 _13984_/Q _09403_/S VDD VSS sg13g2_mux2_1
XFILLER_75_1230 VDD VSS sg13g2_fill_1
XFILLER_51_124 VDD VSS sg13g2_decap_4
XFILLER_75_1241 VDD VSS sg13g2_fill_2
XFILLER_162_1200 VDD VSS sg13g2_decap_8
XFILLER_75_1263 VDD VSS sg13g2_decap_8
X_08332_ _08335_/C _08270_/B _08157_/X _08331_/Y VDD VSS sg13g2_o21ai_1
XFILLER_71_1105 VDD VSS sg13g2_decap_8
XFILLER_75_1274 VDD VSS sg13g2_fill_2
XFILLER_33_883 VDD VSS sg13g2_fill_1
XFILLER_20_511 VDD VSS sg13g2_decap_8
XFILLER_60_680 VDD VSS sg13g2_fill_1
X_08263_ _08263_/Y _07929_/B _08263_/B VDD VSS sg13g2_nand2b_1
XFILLER_162_1288 VDD VSS sg13g2_decap_8
X_08194_ _08194_/Y _08081_/X _08194_/B VDD VSS sg13g2_nand2b_1
XFILLER_20_588 VDD VSS sg13g2_decap_8
X_14865__2814 _14865_/RESET_B VDD VSS sg13g2_tiehi
XFILLER_146_774 VDD VSS sg13g2_decap_8
XFILLER_119_999 VDD VSS sg13g2_fill_2
XFILLER_69_1034 VDD VSS sg13g2_decap_4
XFILLER_173_560 VDD VSS sg13g2_decap_8
XFILLER_10_14 VDD VSS sg13g2_decap_8
XFILLER_173_571 VDD VSS sg13g2_fill_2
XFILLER_160_210 VDD VSS sg13g2_decap_8
XFILLER_161_744 VDD VSS sg13g2_decap_8
XFILLER_126_14 VDD VSS sg13g2_decap_8
XFILLER_161_755 VDD VSS sg13g2_fill_1
XFILLER_0_905 VDD VSS sg13g2_decap_8
XFILLER_82_1212 VDD VSS sg13g2_decap_8
XFILLER_102_800 VDD VSS sg13g2_decap_8
XFILLER_47_1343 VDD VSS sg13g2_decap_8
XFILLER_173_1340 VDD VSS sg13g2_decap_8
XFILLER_161_799 VDD VSS sg13g2_fill_2
X_14898__2748 _14898_/RESET_B VDD VSS sg13g2_tiehi
XFILLER_99_371 VDD VSS sg13g2_decap_8
XFILLER_59_224 VDD VSS sg13g2_decap_8
XFILLER_43_1229 VDD VSS sg13g2_fill_1
X_07978_ _07978_/Y _07905_/D _07960_/Y _07979_/A VDD VSS sg13g2_o21ai_1
XFILLER_19_56 VDD VSS sg13g2_decap_8
XFILLER_142_35 VDD VSS sg13g2_decap_4
XFILLER_28_611 VDD VSS sg13g2_decap_8
X_09717_ _14308_/D _09750_/A1 _14308_/Q _09738_/S VDD VSS sg13g2_mux2_1
XFILLER_68_791 VDD VSS sg13g2_fill_1
XFILLER_90_709 VDD VSS sg13g2_decap_8
X_09648_ _14241_/D _09780_/A0 _14241_/Q _09672_/S VDD VSS sg13g2_mux2_1
XFILLER_27_154 VDD VSS sg13g2_decap_8
XFILLER_70_400 VDD VSS sg13g2_fill_2
XFILLER_56_997 VDD VSS sg13g2_decap_4
XFILLER_28_688 VDD VSS sg13g2_decap_8
XFILLER_128_1106 VDD VSS sg13g2_fill_2
XFILLER_42_102 VDD VSS sg13g2_decap_8
XFILLER_82_282 VDD VSS sg13g2_fill_2
XFILLER_70_422 VDD VSS sg13g2_decap_8
XFILLER_128_1117 VDD VSS sg13g2_fill_1
X_09579_ _14176_/D _14176_/Q _10076_/A0 _09601_/S VDD VSS sg13g2_mux2_1
X_13774__2405 _13774_/RESET_B VDD VSS sg13g2_tiehi
XFILLER_35_77 VDD VSS sg13g2_decap_8
X_11610_ _11610_/Y _11759_/A _14406_/Q _11760_/C VDD VSS sg13g2_a21oi_1
XFILLER_93_1363 VDD VSS sg13g2_decap_8
XFILLER_24_861 VDD VSS sg13g2_decap_8
XFILLER_93_1374 VDD VSS sg13g2_fill_1
X_12590_ _12590_/X _13740_/Q _14092_/Q _14444_/Q _14540_/Q _12590_/S0 _12590_/S1 VDD
+ VSS sg13g2_mux4_1
XFILLER_169_855 VDD VSS sg13g2_decap_8
XFILLER_11_511 VDD VSS sg13g2_decap_8
XFILLER_54_1347 VDD VSS sg13g2_decap_4
XFILLER_51_680 VDD VSS sg13g2_decap_8
XFILLER_23_371 VDD VSS sg13g2_decap_8
XFILLER_15_1309 VDD VSS sg13g2_decap_8
XFILLER_168_343 VDD VSS sg13g2_decap_8
X_11541_ _11542_/A _13732_/Q _14084_/Q _14436_/Q _14532_/Q _11531_/A _12018_/C VDD
+ VSS sg13g2_mux4_1
XFILLER_54_1369 VDD VSS sg13g2_decap_8
XFILLER_51_21 VDD VSS sg13g2_decap_8
XFILLER_129_719 VDD VSS sg13g2_decap_8
XFILLER_7_504 VDD VSS sg13g2_decap_8
XFILLER_167_21 VDD VSS sg13g2_decap_8
XFILLER_156_538 VDD VSS sg13g2_fill_1
X_14260_ _14260_/Q _14644_/CLK _14260_/D _14260_/RESET_B VDD VSS sg13g2_dfrbpq_1
XFILLER_11_588 VDD VSS sg13g2_decap_8
XFILLER_13_1022 VDD VSS sg13g2_decap_8
XFILLER_156_549 VDD VSS sg13g2_fill_1
X_11472_ _11472_/X _13825_/Q _13857_/Q _13889_/Q _13921_/Q _11489_/S0 _11489_/S1 VDD
+ VSS sg13g2_mux4_1
XFILLER_104_1150 VDD VSS sg13g2_decap_8
X_13211_ _15047_/D _13266_/A _13211_/B VDD VSS sg13g2_nor2_1
X_14154__2025 _14154_/RESET_B VDD VSS sg13g2_tiehi
X_10423_ _14830_/D _10423_/A _10423_/B _10423_/C VDD VSS sg13g2_and3_1
XFILLER_109_465 VDD VSS sg13g2_decap_8
X_14191_ _14191_/Q _14735_/CLK _14191_/D _14191_/RESET_B VDD VSS sg13g2_dfrbpq_1
XFILLER_100_1025 VDD VSS sg13g2_decap_8
XFILLER_164_560 VDD VSS sg13g2_decap_8
XFILLER_109_476 VDD VSS sg13g2_fill_1
XFILLER_167_98 VDD VSS sg13g2_decap_8
XFILLER_13_1099 VDD VSS sg13g2_decap_8
X_13142_ _13174_/A _13142_/A _13671_/Q VDD VSS sg13g2_nand2_1
X_10354_ _10360_/C _14811_/Q _10353_/B VDD VSS sg13g2_nor2b_1
XFILLER_3_721 VDD VSS sg13g2_decap_8
XFILLER_30_1380 VDD VSS sg13g2_decap_4
XFILLER_151_243 VDD VSS sg13g2_decap_4
XFILLER_4_0 VDD VSS sg13g2_decap_8
XFILLER_2_231 VDD VSS sg13g2_decap_8
XFILLER_124_479 VDD VSS sg13g2_decap_8
X_13073_ _13073_/Y _13166_/A1 _13072_/X _13071_/Y VDD VSS sg13g2_a21oi_1
X_10285_ _10288_/B _14788_/Q _14789_/Q _10305_/A _10305_/B VDD VSS sg13g2_nand4_1
XFILLER_3_798 VDD VSS sg13g2_decap_8
X_12024_ _12026_/A _12025_/A _14642_/Q VDD VSS sg13g2_nand2b_1
XFILLER_78_544 VDD VSS sg13g2_fill_1
Xfanout590 _13294_/B _10903_/B VDD VSS sg13g2_buf_1
XFILLER_24_1162 VDD VSS sg13g2_decap_8
XFILLER_20_1015 VDD VSS sg13g2_decap_8
XFILLER_19_644 VDD VSS sg13g2_decap_8
X_13975_ _13975_/Q clkload34/A _13975_/D _13975_/RESET_B VDD VSS sg13g2_dfrbpq_1
XFILLER_98_1241 VDD VSS sg13g2_decap_8
XFILLER_150_1192 VDD VSS sg13g2_decap_8
XFILLER_4_1267 VDD VSS sg13g2_decap_8
X_14961__2626 _14961_/RESET_B VDD VSS sg13g2_tiehi
XFILLER_34_603 VDD VSS sg13g2_fill_2
XFILLER_18_154 VDD VSS sg13g2_decap_8
X_12926_ _12928_/B _14901_/Q _13686_/Q _12989_/B VDD VSS sg13g2_o21ai_1
XFILLER_59_1225 VDD VSS sg13g2_decap_8
XFILLER_73_260 VDD VSS sg13g2_decap_8
XFILLER_94_1127 VDD VSS sg13g2_decap_8
X_12857_ _12861_/A _12846_/Y _12848_/X _12847_/X VDD VSS sg13g2_a21oi_1
XFILLER_15_861 VDD VSS sg13g2_decap_8
X_14364__1815 _14364_/RESET_B VDD VSS sg13g2_tiehi
XFILLER_21_308 VDD VSS sg13g2_decap_8
X_11808_ _11808_/Y _11808_/A _11815_/B VDD VSS sg13g2_nand2_1
X_12788_ _12788_/X _12787_/X _12786_/X _12783_/X _12782_/X _12789_/S0 _12789_/S1 VDD
+ VSS sg13g2_mux4_1
XFILLER_14_371 VDD VSS sg13g2_decap_8
XFILLER_159_343 VDD VSS sg13g2_decap_8
XFILLER_109_1083 VDD VSS sg13g2_decap_8
X_14527_ _14527_/Q clkload9/A _14527_/D _14527_/RESET_B VDD VSS sg13g2_dfrbpq_1
X_11739_ _11743_/A _11738_/X _11739_/B VDD VSS sg13g2_nand2b_1
XFILLER_174_324 VDD VSS sg13g2_decap_8
X_14458_ _14458_/Q _14734_/CLK _14458_/D _14458_/RESET_B VDD VSS sg13g2_dfrbpq_1
XFILLER_174_335 VDD VSS sg13g2_decap_8
XFILLER_70_1182 VDD VSS sg13g2_decap_8
XFILLER_174_346 VDD VSS sg13g2_fill_2
XFILLER_70_1193 VDD VSS sg13g2_fill_2
XFILLER_116_903 VDD VSS sg13g2_decap_8
XFILLER_122_1272 VDD VSS sg13g2_decap_8
X_13409_ _13409_/Y _13507_/B _15092_/Q VDD VSS sg13g2_nor2b_1
XFILLER_31_1155 VDD VSS sg13g2_decap_8
XFILLER_128_774 VDD VSS sg13g2_fill_1
X_14389_ _14389_/Q clkload18/A _14389_/D _14389_/RESET_B VDD VSS sg13g2_dfrbpq_1
XFILLER_143_711 VDD VSS sg13g2_decap_4
XFILLER_155_571 VDD VSS sg13g2_decap_8
XFILLER_155_582 VDD VSS sg13g2_fill_1
XFILLER_6_581 VDD VSS sg13g2_decap_8
XFILLER_66_1218 VDD VSS sg13g2_decap_4
XFILLER_143_777 VDD VSS sg13g2_decap_8
Xhold3107 _13628_/A _13736_/Q VDD VSS sg13g2_dlygate4sd3_1
X_08950_ _08950_/Y _08948_/Y _08949_/Y _08940_/S VDD VSS sg13g2_a21oi_1
XFILLER_170_574 VDD VSS sg13g2_decap_8
Xhold3118 _13639_/A _13747_/Q VDD VSS sg13g2_dlygate4sd3_1
XFILLER_130_416 VDD VSS sg13g2_decap_4
Xhold3129 _13632_/A _13740_/Q VDD VSS sg13g2_dlygate4sd3_1
X_07901_ _07904_/C _08073_/A _08073_/C _08073_/B VDD VSS sg13g2_a21oi_1
XFILLER_37_0 VDD VSS sg13g2_decap_8
XFILLER_9_1134 VDD VSS sg13g2_decap_8
X_08881_ _08881_/X _15034_/Q _14938_/Q _10725_/A VDD VSS sg13g2_mux2_1
X_13852__2327 _13852_/RESET_B VDD VSS sg13g2_tiehi
XFILLER_96_341 VDD VSS sg13g2_decap_4
X_13998__2181 _13998_/RESET_B VDD VSS sg13g2_tiehi
X_07832_ _07834_/B _08692_/C _08692_/B VDD VSS sg13g2_nor2b_1
XFILLER_84_503 VDD VSS sg13g2_fill_1
XFILLER_69_577 VDD VSS sg13g2_decap_8
XFILLER_42_1240 VDD VSS sg13g2_decap_4
XFILLER_2_70 VDD VSS sg13g2_decap_8
X_07763_ _15204_/D _07744_/B _07738_/Y _07762_/Y VDD VSS sg13g2_o21ai_1
XFILLER_65_750 VDD VSS sg13g2_decap_8
X_09502_ _14102_/D _10165_/A1 _14102_/Q _09502_/S VDD VSS sg13g2_mux2_1
XFILLER_25_603 VDD VSS sg13g2_decap_8
XFILLER_37_463 VDD VSS sg13g2_decap_8
X_07694_ _07694_/Y _11241_/A _11241_/C _07674_/Y VDD VSS sg13g2_a21oi_1
XFILLER_53_923 VDD VSS sg13g2_decap_4
XFILLER_25_636 VDD VSS sg13g2_fill_2
X_09433_ _14035_/D _09666_/A0 _14035_/Q _09436_/S VDD VSS sg13g2_mux2_1
XFILLER_164_1317 VDD VSS sg13g2_decap_4
XFILLER_52_433 VDD VSS sg13g2_decap_8
XFILLER_25_669 VDD VSS sg13g2_decap_8
XFILLER_12_308 VDD VSS sg13g2_decap_8
X_09364_ _13968_/D _09696_/A0 _13968_/Q _09374_/S VDD VSS sg13g2_mux2_1
XFILLER_24_168 VDD VSS sg13g2_decap_8
XFILLER_127_1150 VDD VSS sg13g2_fill_1
X_08315_ _08315_/Y _08315_/A _08315_/B _08315_/C VDD VSS sg13g2_nor3_1
XFILLER_36_1044 VDD VSS sg13g2_fill_1
XANTENNA_20 _12791_/C1 VDD VSS sg13g2_antennanp
X_09295_ _13903_/D _13903_/Q _09926_/A1 _09301_/S VDD VSS sg13g2_mux2_1
XANTENNA_31 _16881_/A VDD VSS sg13g2_antennanp
XFILLER_21_875 VDD VSS sg13g2_decap_8
X_08246_ _08246_/Y _08246_/A1 _08243_/Y _08244_/Y _08245_/Y _08240_/Y VDD VSS sg13g2_a221oi_1
XFILLER_165_357 VDD VSS sg13g2_decap_8
XFILLER_20_385 VDD VSS sg13g2_decap_8
XFILLER_21_35 VDD VSS sg13g2_decap_8
XFILLER_107_914 VDD VSS sg13g2_fill_1
X_08177_ _08177_/X _08042_/X _08059_/X _08177_/S VDD VSS sg13g2_mux2_1
XFILLER_115_7 VDD VSS sg13g2_decap_8
XFILLER_140_1383 VDD VSS sg13g2_fill_1
XFILLER_4_518 VDD VSS sg13g2_decap_8
XFILLER_10_1239 VDD VSS sg13g2_decap_8
XFILLER_137_35 VDD VSS sg13g2_decap_8
XFILLER_107_947 VDD VSS sg13g2_fill_1
XFILLER_84_1329 VDD VSS sg13g2_decap_8
XFILLER_133_243 VDD VSS sg13g2_decap_8
XFILLER_106_468 VDD VSS sg13g2_fill_1
XFILLER_0_702 VDD VSS sg13g2_decap_8
XFILLER_47_1140 VDD VSS sg13g2_decap_4
XFILLER_82_1042 VDD VSS sg13g2_fill_1
X_10070_ _10070_/Y _10070_/A _10070_/B _10070_/C VDD VSS sg13g2_nand3_1
XFILLER_88_842 VDD VSS sg13g2_decap_8
XFILLER_88_853 VDD VSS sg13g2_fill_2
XFILLER_87_341 VDD VSS sg13g2_decap_8
XFILLER_134_1143 VDD VSS sg13g2_decap_8
XFILLER_0_779 VDD VSS sg13g2_decap_8
XFILLER_153_56 VDD VSS sg13g2_decap_8
X_14442__1737 _14442_/RESET_B VDD VSS sg13g2_tiehi
XFILLER_87_352 VDD VSS sg13g2_fill_1
X_13828__2351 _13828_/RESET_B VDD VSS sg13g2_tiehi
XFILLER_82_1097 VDD VSS sg13g2_decap_4
X_14588__1591 _14588_/RESET_B VDD VSS sg13g2_tiehi
XFILLER_87_374 VDD VSS sg13g2_decap_8
XFILLER_47_216 VDD VSS sg13g2_decap_4
XFILLER_130_1029 VDD VSS sg13g2_decap_8
XFILLER_21_1302 VDD VSS sg13g2_decap_8
XFILLER_46_21 VDD VSS sg13g2_decap_8
X_13760_ _13760_/Q _14721_/CLK _13760_/D _13760_/RESET_B VDD VSS sg13g2_dfrbpq_1
XFILLER_28_463 VDD VSS sg13g2_decap_8
X_10972_ _14939_/D _10971_/Y _10970_/Y _10959_/Y VDD VSS sg13g2_o21ai_1
XFILLER_43_400 VDD VSS sg13g2_decap_8
XFILLER_55_260 VDD VSS sg13g2_decap_8
XFILLER_21_1379 VDD VSS sg13g2_decap_4
X_12711_ _12711_/X _13845_/Q _13877_/Q _13909_/Q _13941_/Q _12717_/S0 _12717_/S1 VDD
+ VSS sg13g2_mux4_1
XFILLER_16_658 VDD VSS sg13g2_decap_8
X_13691_ _13691_/Q clkload55/A _13691_/D _13691_/RESET_B VDD VSS sg13g2_dfrbpq_1
XFILLER_15_168 VDD VSS sg13g2_decap_8
X_12642_ _12642_/X _14384_/Q _14416_/Q _14480_/Q _14512_/Q _12674_/S0 _12674_/S1 VDD
+ VSS sg13g2_mux4_1
XFILLER_43_477 VDD VSS sg13g2_decap_8
XFILLER_31_617 VDD VSS sg13g2_decap_8
XFILLER_30_105 VDD VSS sg13g2_fill_2
XFILLER_102_93 VDD VSS sg13g2_decap_4
XFILLER_58_1291 VDD VSS sg13g2_decap_4
XFILLER_19_1253 VDD VSS sg13g2_decap_8
XFILLER_141_0 VDD VSS sg13g2_decap_8
XFILLER_169_652 VDD VSS sg13g2_decap_8
XFILLER_70_296 VDD VSS sg13g2_decap_4
XFILLER_157_803 VDD VSS sg13g2_decap_8
XFILLER_168_140 VDD VSS sg13g2_decap_8
XFILLER_15_1106 VDD VSS sg13g2_decap_8
XFILLER_169_674 VDD VSS sg13g2_fill_1
X_12573_ _12573_/X _14123_/Q _14155_/Q _14187_/Q _14219_/Q _12601_/S0 _12601_/S1 VDD
+ VSS sg13g2_mux4_1
XFILLER_12_875 VDD VSS sg13g2_decap_8
XFILLER_7_301 VDD VSS sg13g2_decap_8
X_14312_ _14312_/Q _14666_/CLK _14312_/D _14312_/RESET_B VDD VSS sg13g2_dfrbpq_1
X_11524_ _11527_/A _11502_/A _13685_/Q _11505_/X VDD VSS sg13g2_a21oi_1
XFILLER_11_385 VDD VSS sg13g2_decap_8
X_13930__2249 _13930_/RESET_B VDD VSS sg13g2_tiehi
XFILLER_89_1229 VDD VSS sg13g2_decap_8
X_14690__1489 _14690_/RESET_B VDD VSS sg13g2_tiehi
XFILLER_8_868 VDD VSS sg13g2_decap_8
X_14243_ _14243_/Q _14659_/CLK _14243_/D _14243_/RESET_B VDD VSS sg13g2_dfrbpq_1
X_11455_ _11457_/C _11430_/B _11430_/A _11427_/X VDD VSS sg13g2_a21o_1
XFILLER_7_378 VDD VSS sg13g2_decap_8
XFILLER_171_327 VDD VSS sg13g2_decap_8
XFILLER_137_593 VDD VSS sg13g2_fill_2
X_10406_ _14824_/D _10406_/A _10643_/A _10406_/C VDD VSS sg13g2_nor3_1
X_14174_ _14174_/Q _14686_/CLK _14174_/D _14174_/RESET_B VDD VSS sg13g2_dfrbpq_1
XFILLER_109_295 VDD VSS sg13g2_decap_8
XFILLER_124_221 VDD VSS sg13g2_decap_8
X_11386_ _11386_/Y _07684_/B _11385_/Y _11380_/Y _11381_/Y _11248_/B VDD VSS sg13g2_a221oi_1
X_14979__2608 _14979_/RESET_B VDD VSS sg13g2_tiehi
X_13125_ _13125_/X input16/X _13205_/A2 _13205_/B1 VDD VSS sg13g2_a21o_1
XFILLER_98_617 VDD VSS sg13g2_fill_1
X_10337_ _14805_/D _10337_/A _10337_/B _13499_/B VDD VSS sg13g2_and3_1
XFILLER_112_416 VDD VSS sg13g2_decap_4
XFILLER_139_1087 VDD VSS sg13g2_fill_1
XFILLER_140_736 VDD VSS sg13g2_fill_1
XFILLER_112_449 VDD VSS sg13g2_decap_8
X_13056_ _15036_/D _13043_/Y _13055_/Y _13021_/A VDD VSS sg13g2_a21oi_1
XFILLER_3_595 VDD VSS sg13g2_decap_8
XFILLER_30_7 VDD VSS sg13g2_decap_8
X_10268_ _10299_/B _14782_/Q _14783_/Q _14784_/Q _10268_/D VDD VSS sg13g2_nand4_1
XFILLER_26_1224 VDD VSS sg13g2_decap_8
XFILLER_152_1232 VDD VSS sg13g2_fill_2
XFILLER_65_1284 VDD VSS sg13g2_decap_8
XFILLER_117_1363 VDD VSS sg13g2_decap_8
Xfanout1330 _11320_/S0 _11229_/S0 VDD VSS sg13g2_buf_1
X_12007_ _12053_/A _12009_/A _12082_/B VDD VSS sg13g2_nor2_1
XFILLER_117_1374 VDD VSS sg13g2_fill_1
Xfanout1341 _12326_/A1 _12330_/S0 VDD VSS sg13g2_buf_1
Xfanout1352 _11531_/A _12242_/A_N VDD VSS sg13g2_buf_1
XFILLER_38_205 VDD VSS sg13g2_decap_8
X_14418__1761 _14418_/RESET_B VDD VSS sg13g2_tiehi
X_10199_ _15181_/D hold3023/X _10199_/A1 _13477_/S VDD VSS sg13g2_mux2_1
XFILLER_113_1238 VDD VSS sg13g2_decap_8
Xfanout1363 _11489_/S0 _11469_/S0 VDD VSS sg13g2_buf_1
XFILLER_93_311 VDD VSS sg13g2_fill_2
XFILLER_120_482 VDD VSS sg13g2_decap_4
Xfanout1374 _10306_/B _10667_/A VDD VSS sg13g2_buf_1
Xfanout1385 _10172_/A _13507_/A VDD VSS sg13g2_buf_1
Xfanout1396 _10557_/C _13499_/B VDD VSS sg13g2_buf_1
XFILLER_19_441 VDD VSS sg13g2_decap_8
XFILLER_93_366 VDD VSS sg13g2_fill_2
XFILLER_81_517 VDD VSS sg13g2_decap_8
XFILLER_53_208 VDD VSS sg13g2_fill_1
XFILLER_4_1064 VDD VSS sg13g2_decap_8
XFILLER_81_528 VDD VSS sg13g2_fill_1
X_13958_ _13958_/Q clkload2/A _13958_/D _13958_/RESET_B VDD VSS sg13g2_dfrbpq_1
XFILLER_34_422 VDD VSS sg13g2_decap_8
XFILLER_62_742 VDD VSS sg13g2_decap_8
XFILLER_34_433 VDD VSS sg13g2_fill_1
X_12909_ _12909_/Y _12925_/A _12925_/B _12909_/C VDD VSS sg13g2_nand3_1
X_13889_ _13889_/Q clkload25/A _13889_/D _13889_/RESET_B VDD VSS sg13g2_dfrbpq_1
XFILLER_59_1077 VDD VSS sg13g2_decap_8
XFILLER_72_1200 VDD VSS sg13g2_fill_2
XFILLER_34_488 VDD VSS sg13g2_fill_1
XFILLER_21_105 VDD VSS sg13g2_decap_8
XFILLER_37_1364 VDD VSS sg13g2_decap_8
XFILLER_159_140 VDD VSS sg13g2_decap_8
X_08100_ _08104_/C _08103_/A _08138_/B _08200_/C VDD VSS sg13g2_nor3_1
XFILLER_147_324 VDD VSS sg13g2_decap_8
X_09080_ _09082_/B _13088_/A _09103_/C _14913_/Q VDD VSS sg13g2_a21o_1
XFILLER_124_1378 VDD VSS sg13g2_fill_2
XFILLER_147_368 VDD VSS sg13g2_fill_2
X_14520__1659 _14520_/RESET_B VDD VSS sg13g2_tiehi
X_08031_ _08032_/D _08103_/A _08431_/D _08031_/C VDD VSS sg13g2_nor3_1
X_13906__2273 _13906_/RESET_B VDD VSS sg13g2_tiehi
XFILLER_156_880 VDD VSS sg13g2_fill_1
XFILLER_162_327 VDD VSS sg13g2_decap_8
XFILLER_174_198 VDD VSS sg13g2_decap_8
XFILLER_116_766 VDD VSS sg13g2_fill_2
X_14774__2939 _14774_/RESET_B VDD VSS sg13g2_tiehi
XFILLER_104_917 VDD VSS sg13g2_decap_4
XFILLER_118_1105 VDD VSS sg13g2_fill_1
XFILLER_131_703 VDD VSS sg13g2_decap_4
XFILLER_89_617 VDD VSS sg13g2_decap_8
X_09982_ _14565_/D _10048_/A0 _14565_/Q _09994_/S VDD VSS sg13g2_mux2_1
XFILLER_104_939 VDD VSS sg13g2_fill_1
XFILLER_130_202 VDD VSS sg13g2_decap_4
XFILLER_115_287 VDD VSS sg13g2_decap_8
XFILLER_170_371 VDD VSS sg13g2_decap_8
XFILLER_118_1138 VDD VSS sg13g2_decap_4
XFILLER_115_298 VDD VSS sg13g2_fill_1
X_08933_ _08933_/X _15047_/Q _14951_/Q _08943_/A VDD VSS sg13g2_mux2_1
X_08864_ _13699_/D _16861_/A _08863_/X _08892_/S VDD VSS sg13g2_mux2_1
XFILLER_170_1376 VDD VSS sg13g2_decap_4
X_07815_ _07815_/X _15010_/Q _07818_/B VDD VSS sg13g2_or2_1
XFILLER_29_238 VDD VSS sg13g2_decap_8
X_08795_ _08796_/B _13683_/Q _08818_/B VDD VSS sg13g2_nor2_1
XFILLER_26_901 VDD VSS sg13g2_fill_1
X_07746_ _07750_/B _13481_/A _15124_/Q _07746_/C VDD VSS sg13g2_nor3_1
XFILLER_25_400 VDD VSS sg13g2_decap_8
XFILLER_16_35 VDD VSS sg13g2_decap_8
X_07677_ _07677_/Y _13398_/B _07677_/B _07677_/C _07721_/A VDD VSS sg13g2_nand4_1
XFILLER_53_753 VDD VSS sg13g2_fill_2
XFILLER_77_1177 VDD VSS sg13g2_decap_4
XFILLER_38_1128 VDD VSS sg13g2_decap_8
X_09416_ _14018_/D _10078_/A0 _14018_/Q _09436_/S VDD VSS sg13g2_mux2_1
XFILLER_77_1188 VDD VSS sg13g2_fill_1
XFILLER_40_403 VDD VSS sg13g2_fill_2
XFILLER_12_105 VDD VSS sg13g2_decap_8
XFILLER_129_1289 VDD VSS sg13g2_fill_2
XFILLER_40_436 VDD VSS sg13g2_decap_8
X_09347_ _13951_/D _09611_/A0 _13951_/Q _09365_/S VDD VSS sg13g2_mux2_1
XFILLER_90_1355 VDD VSS sg13g2_fill_1
XFILLER_139_825 VDD VSS sg13g2_decap_4
XFILLER_138_324 VDD VSS sg13g2_fill_1
XFILLER_21_672 VDD VSS sg13g2_decap_8
XFILLER_138_335 VDD VSS sg13g2_decap_8
XFILLER_166_644 VDD VSS sg13g2_decap_8
X_09278_ _13886_/D _13886_/Q _10141_/A1 _09292_/S VDD VSS sg13g2_mux2_1
XFILLER_32_56 VDD VSS sg13g2_decap_8
XFILLER_20_182 VDD VSS sg13g2_decap_8
XFILLER_148_56 VDD VSS sg13g2_decap_8
XFILLER_165_154 VDD VSS sg13g2_decap_8
X_08229_ _08229_/Y _08229_/A _08248_/A _08229_/C VDD VSS sg13g2_nand3_1
XFILLER_5_805 VDD VSS sg13g2_decap_8
XFILLER_107_700 VDD VSS sg13g2_decap_8
XFILLER_14_1183 VDD VSS sg13g2_decap_8
XFILLER_4_315 VDD VSS sg13g2_decap_8
XFILLER_107_733 VDD VSS sg13g2_fill_1
X_11240_ _11248_/A _11249_/A _15123_/Q _11239_/Y VDD VSS sg13g2_a21oi_1
XFILLER_10_1036 VDD VSS sg13g2_decap_8
XFILLER_84_1126 VDD VSS sg13g2_fill_2
XFILLER_134_574 VDD VSS sg13g2_decap_8
X_11171_ _11186_/A _11181_/A _11171_/B VDD VSS sg13g2_nand2_1
XFILLER_106_276 VDD VSS sg13g2_fill_1
X_14675__1504 _14675_/RESET_B VDD VSS sg13g2_tiehi
X_10122_ _14700_/D _10155_/A1 _14700_/Q _10136_/S VDD VSS sg13g2_mux2_1
XFILLER_164_77 VDD VSS sg13g2_decap_8
XFILLER_0_532 VDD VSS sg13g2_decap_8
XFILLER_103_950 VDD VSS sg13g2_fill_2
XFILLER_103_961 VDD VSS sg13g2_decap_8
XFILLER_103_972 VDD VSS sg13g2_fill_2
X_14930_ _14930_/Q clkload62/A _14930_/D _14930_/RESET_B VDD VSS sg13g2_dfrbpq_1
X_10053_ _14634_/D _10086_/A0 _14634_/Q _10063_/S VDD VSS sg13g2_mux2_1
XFILLER_76_823 VDD VSS sg13g2_fill_1
XFILLER_48_514 VDD VSS sg13g2_fill_1
XFILLER_130_780 VDD VSS sg13g2_decap_8
XFILLER_57_42 VDD VSS sg13g2_decap_8
X_14861_ _14861_/Q _14874_/CLK _14861_/D _14861_/RESET_B VDD VSS sg13g2_dfrbpq_1
XFILLER_5_1351 VDD VSS sg13g2_decap_8
XFILLER_48_569 VDD VSS sg13g2_decap_8
XFILLER_76_889 VDD VSS sg13g2_decap_8
XFILLER_57_97 VDD VSS sg13g2_decap_8
XFILLER_60_1181 VDD VSS sg13g2_decap_8
XFILLER_1_1204 VDD VSS sg13g2_decap_8
X_13812_ _13812_/Q _14516_/CLK _13812_/D _13812_/RESET_B VDD VSS sg13g2_dfrbpq_1
XFILLER_91_826 VDD VSS sg13g2_fill_2
XFILLER_60_1192 VDD VSS sg13g2_fill_1
X_14792_ _14792_/Q clkload51/A _14792_/D _14792_/RESET_B VDD VSS sg13g2_dfrbpq_1
XFILLER_17_945 VDD VSS sg13g2_decap_8
XFILLER_21_1176 VDD VSS sg13g2_decap_8
XFILLER_147_1312 VDD VSS sg13g2_decap_8
XFILLER_28_293 VDD VSS sg13g2_decap_8
X_13743_ _13743_/Q _14607_/CLK _13743_/D _13743_/RESET_B VDD VSS sg13g2_dfrbpq_1
X_10955_ _10956_/B _10954_/C _10965_/C _10953_/Y VDD VSS sg13g2_a21o_1
XFILLER_16_455 VDD VSS sg13g2_decap_8
X_15061__2489 _15061_/RESET_B VDD VSS sg13g2_tiehi
XFILLER_56_1239 VDD VSS sg13g2_fill_1
XFILLER_143_1209 VDD VSS sg13g2_decap_4
X_13674_ _13674_/Q _15188_/CLK _13674_/D _13674_/RESET_B VDD VSS sg13g2_dfrbpq_1
X_10886_ _10886_/X _10897_/A _11045_/A2 _07705_/B VDD VSS sg13g2_a21o_1
XFILLER_43_285 VDD VSS sg13g2_fill_2
XFILLER_19_1050 VDD VSS sg13g2_decap_8
X_12625_ _15008_/D _12625_/A _12625_/B VDD VSS sg13g2_nor2_1
XFILLER_31_469 VDD VSS sg13g2_fill_2
XFILLER_12_672 VDD VSS sg13g2_decap_8
X_12556_ _12569_/A _12709_/A1 _12737_/A2 _08383_/B VDD VSS sg13g2_a21oi_1
XFILLER_106_1064 VDD VSS sg13g2_fill_2
XFILLER_89_1004 VDD VSS sg13g2_fill_1
XFILLER_78_7 VDD VSS sg13g2_decap_8
XFILLER_11_182 VDD VSS sg13g2_decap_8
XFILLER_156_154 VDD VSS sg13g2_decap_8
X_11507_ _11507_/X _13827_/Q _13859_/Q _13891_/Q _13923_/Q _11715_/S0 _11715_/S1 VDD
+ VSS sg13g2_mux4_1
XFILLER_8_665 VDD VSS sg13g2_decap_8
XFILLER_89_1026 VDD VSS sg13g2_decap_8
XFILLER_145_839 VDD VSS sg13g2_decap_8
X_12487_ _12487_/X _13829_/Q _13861_/Q _13893_/Q _13925_/Q _12655_/S0 _12655_/S1 VDD
+ VSS sg13g2_mux4_1
XFILLER_172_625 VDD VSS sg13g2_decap_8
XFILLER_7_175 VDD VSS sg13g2_decap_8
XFILLER_144_349 VDD VSS sg13g2_fill_1
X_14226_ _14226_/Q _14512_/CLK _14226_/D _14226_/RESET_B VDD VSS sg13g2_dfrbpq_1
X_11438_ _11439_/B _14240_/Q _14272_/Q _14304_/Q _14336_/Q _11489_/S0 _11489_/S1 VDD
+ VSS sg13g2_mux4_1
XFILLER_171_168 VDD VSS sg13g2_decap_8
X_14157_ _14157_/Q clkload3/A _14157_/D _14157_/RESET_B VDD VSS sg13g2_dfrbpq_1
XFILLER_67_1346 VDD VSS sg13g2_decap_4
X_11369_ _11369_/Y _11367_/Y _11366_/Y _11881_/C1 _11368_/X VDD VSS sg13g2_a22oi_1
XFILLER_28_1308 VDD VSS sg13g2_decap_8
XFILLER_4_882 VDD VSS sg13g2_decap_8
XFILLER_113_736 VDD VSS sg13g2_decap_8
XFILLER_152_382 VDD VSS sg13g2_fill_1
X_13108_ _13108_/Y _14786_/Q _13152_/A2 _13208_/B1 VDD VSS sg13g2_o21ai_1
XFILLER_98_447 VDD VSS sg13g2_decap_8
X_14088_ _14088_/Q _14512_/CLK _14088_/D _14088_/RESET_B VDD VSS sg13g2_dfrbpq_1
XFILLER_3_392 VDD VSS sg13g2_decap_8
XFILLER_26_1021 VDD VSS sg13g2_decap_8
XFILLER_79_661 VDD VSS sg13g2_fill_1
XFILLER_67_801 VDD VSS sg13g2_decap_8
X_13039_ _13057_/C _14909_/Q _13678_/Q VDD VSS sg13g2_nand2_1
XFILLER_39_514 VDD VSS sg13g2_decap_8
XFILLER_39_525 VDD VSS sg13g2_decap_8
XFILLER_94_620 VDD VSS sg13g2_fill_1
XFILLER_66_311 VDD VSS sg13g2_fill_1
XFILLER_117_1193 VDD VSS sg13g2_decap_8
Xfanout1160 _11454_/A _07910_/B VDD VSS sg13g2_buf_1
XFILLER_6_1148 VDD VSS sg13g2_decap_8
XFILLER_39_536 VDD VSS sg13g2_fill_1
XFILLER_113_1035 VDD VSS sg13g2_decap_8
Xfanout1171 _11291_/A _14958_/Q VDD VSS sg13g2_buf_1
XFILLER_66_333 VDD VSS sg13g2_fill_1
Xfanout1182 _13200_/A _14920_/Q VDD VSS sg13g2_buf_1
XFILLER_67_867 VDD VSS sg13g2_fill_2
XFILLER_26_1098 VDD VSS sg13g2_decap_8
XFILLER_93_130 VDD VSS sg13g2_fill_2
Xfanout1193 _12835_/A _14896_/Q VDD VSS sg13g2_buf_1
XFILLER_94_675 VDD VSS sg13g2_decap_8
X_08580_ _08581_/B _08641_/D _08578_/Y _08579_/Y VDD VSS sg13g2_o21ai_1
XFILLER_47_591 VDD VSS sg13g2_decap_8
XFILLER_81_358 VDD VSS sg13g2_fill_2
XFILLER_35_797 VDD VSS sg13g2_fill_1
XFILLER_34_263 VDD VSS sg13g2_decap_8
XFILLER_23_948 VDD VSS sg13g2_fill_2
X_09201_ _13817_/D _13817_/Q _09338_/A0 _09201_/S VDD VSS sg13g2_mux2_1
X_14828__2885 _14828_/RESET_B VDD VSS sg13g2_tiehi
XFILLER_10_609 VDD VSS sg13g2_decap_8
XFILLER_148_611 VDD VSS sg13g2_decap_4
XFILLER_22_469 VDD VSS sg13g2_decap_8
XFILLER_31_970 VDD VSS sg13g2_decap_8
X_09132_ _13781_/D _13781_/Q _10164_/A1 _09160_/S VDD VSS sg13g2_mux2_1
XFILLER_72_1074 VDD VSS sg13g2_decap_8
XFILLER_136_817 VDD VSS sg13g2_decap_8
X_09063_ _09063_/X _09137_/A _09060_/X _09062_/Y VDD VSS sg13g2_a21o_1
XFILLER_8_91 VDD VSS sg13g2_decap_8
XFILLER_135_316 VDD VSS sg13g2_decap_8
XFILLER_148_699 VDD VSS sg13g2_fill_1
XFILLER_11_1323 VDD VSS sg13g2_decap_8
X_08014_ _08014_/Y _08011_/X _08014_/B VDD VSS sg13g2_nand2b_1
XFILLER_50_1383 VDD VSS sg13g2_fill_1
XFILLER_116_530 VDD VSS sg13g2_decap_8
XFILLER_159_1249 VDD VSS sg13g2_decap_8
XFILLER_162_168 VDD VSS sg13g2_decap_8
XFILLER_2_819 VDD VSS sg13g2_decap_8
XFILLER_143_360 VDD VSS sg13g2_decap_8
XFILLER_89_414 VDD VSS sg13g2_decap_4
XFILLER_1_329 VDD VSS sg13g2_decap_8
X_09965_ _14549_/D _14549_/Q _10031_/A0 _09966_/S VDD VSS sg13g2_mux2_1
XFILLER_134_25 VDD VSS sg13g2_decap_8
XFILLER_76_108 VDD VSS sg13g2_decap_8
X_08916_ _08916_/Y _13608_/A1 _08835_/B _16873_/A VDD VSS sg13g2_a21oi_1
XFILLER_170_1151 VDD VSS sg13g2_decap_8
XFILLER_112_780 VDD VSS sg13g2_decap_4
X_09896_ _14482_/D _10128_/A0 _14482_/Q _09903_/S VDD VSS sg13g2_mux2_1
XFILLER_85_620 VDD VSS sg13g2_decap_8
XFILLER_100_931 VDD VSS sg13g2_decap_4
XFILLER_58_845 VDD VSS sg13g2_decap_8
XFILLER_44_1187 VDD VSS sg13g2_decap_8
XFILLER_40_1018 VDD VSS sg13g2_fill_2
XFILLER_100_964 VDD VSS sg13g2_decap_8
X_08847_ _13694_/D _16856_/A _08846_/Y _08855_/S VDD VSS sg13g2_mux2_1
XFILLER_85_653 VDD VSS sg13g2_decap_8
XFILLER_73_826 VDD VSS sg13g2_decap_8
XFILLER_131_1179 VDD VSS sg13g2_fill_2
X_08778_ _08778_/Y _13678_/Q _08781_/B VDD VSS sg13g2_nor2_1
XFILLER_85_697 VDD VSS sg13g2_fill_2
XFILLER_150_35 VDD VSS sg13g2_decap_8
XFILLER_27_56 VDD VSS sg13g2_decap_8
XFILLER_26_731 VDD VSS sg13g2_decap_8
X_07729_ wire649/A _15105_/Q _07729_/B _12879_/B _07729_/D VDD VSS sg13g2_nor4_1
XFILLER_25_252 VDD VSS sg13g2_decap_8
X_10740_ _11033_/B _10747_/A _09079_/Y _08907_/Y VDD VSS sg13g2_o21ai_1
XFILLER_14_959 VDD VSS sg13g2_decap_8
X_14392__1787 _14392_/RESET_B VDD VSS sg13g2_tiehi
XFILLER_40_233 VDD VSS sg13g2_fill_1
X_10671_ _10671_/Y _13304_/B _13440_/B VDD VSS sg13g2_nand2b_1
XFILLER_13_469 VDD VSS sg13g2_decap_8
XFILLER_139_622 VDD VSS sg13g2_decap_8
XFILLER_43_77 VDD VSS sg13g2_decap_8
X_12410_ _12410_/X _13823_/Q _13855_/Q _13887_/Q _13919_/Q _12590_/S0 _12590_/S1 VDD
+ VSS sg13g2_mux4_1
XFILLER_159_77 VDD VSS sg13g2_decap_8
X_13390_ _15083_/D _15083_/Q _13407_/A _13389_/Y VDD VSS sg13g2_a21o_1
XFILLER_139_655 VDD VSS sg13g2_decap_8
XFILLER_166_441 VDD VSS sg13g2_decap_8
X_14729__1450 _14729_/RESET_B VDD VSS sg13g2_tiehi
XFILLER_16_1267 VDD VSS sg13g2_decap_8
XFILLER_51_1158 VDD VSS sg13g2_decap_8
X_12341_ _14988_/D _12302_/Y _12340_/Y _12298_/Y VDD VSS sg13g2_a21oi_1
XFILLER_5_602 VDD VSS sg13g2_decap_8
XFILLER_103_1259 VDD VSS sg13g2_decap_8
X_14012__2167 _14012_/RESET_B VDD VSS sg13g2_tiehi
X_15060_ _15060_/Q clkload72/A _15060_/D _15060_/RESET_B VDD VSS sg13g2_dfrbpq_1
XFILLER_4_112 VDD VSS sg13g2_decap_8
XFILLER_107_530 VDD VSS sg13g2_fill_1
X_12272_ _12273_/A _12272_/A _12231_/A VDD VSS sg13g2_nor2b_1
X_14011_ _14011_/Q _14653_/CLK _14011_/D _14011_/RESET_B VDD VSS sg13g2_dfrbpq_1
XFILLER_104_0 VDD VSS sg13g2_decap_8
XFILLER_135_872 VDD VSS sg13g2_decap_4
X_11223_ _11224_/C _11231_/S _11223_/B _11223_/C VDD VSS sg13g2_nor3_1
XFILLER_88_1081 VDD VSS sg13g2_decap_8
XFILLER_5_679 VDD VSS sg13g2_decap_8
XFILLER_122_511 VDD VSS sg13g2_fill_2
XFILLER_4_189 VDD VSS sg13g2_decap_8
XFILLER_4_49 VDD VSS sg13g2_decap_8
XFILLER_49_1076 VDD VSS sg13g2_decap_8
XFILLER_150_853 VDD VSS sg13g2_decap_8
X_11154_ _11154_/Y _11109_/B _11180_/C _11154_/B1 VDD VSS sg13g2_o21ai_1
X_10105_ _10105_/X _10105_/A _10105_/B _10105_/C _10105_/D VDD VSS sg13g2_and4_1
XFILLER_27_1341 VDD VSS sg13g2_decap_8
X_11085_ _11085_/Y _11145_/A _11115_/A VDD VSS sg13g2_nor2_1
XFILLER_62_1243 VDD VSS sg13g2_decap_4
XFILLER_153_1371 VDD VSS sg13g2_decap_4
X_13880__2299 _13880_/RESET_B VDD VSS sg13g2_tiehi
XFILLER_1_896 VDD VSS sg13g2_decap_8
XFILLER_23_1216 VDD VSS sg13g2_decap_8
XFILLER_76_631 VDD VSS sg13g2_decap_4
XFILLER_62_1276 VDD VSS sg13g2_decap_8
X_14913_ _14913_/Q clkload43/A _14913_/D _14913_/RESET_B VDD VSS sg13g2_dfrbpq_1
X_10036_ _14618_/D _10102_/A0 _14618_/Q _10036_/S VDD VSS sg13g2_mux2_1
XFILLER_97_1306 VDD VSS sg13g2_decap_8
XFILLER_49_878 VDD VSS sg13g2_decap_4
XFILLER_97_1317 VDD VSS sg13g2_fill_2
XFILLER_75_141 VDD VSS sg13g2_decap_8
XFILLER_48_377 VDD VSS sg13g2_decap_8
X_14844_ _14844_/Q _14854_/CLK _14844_/D _14844_/RESET_B VDD VSS sg13g2_dfrbpq_1
XFILLER_48_388 VDD VSS sg13g2_fill_1
XFILLER_1_1001 VDD VSS sg13g2_decap_8
XFILLER_63_325 VDD VSS sg13g2_decap_8
XFILLER_91_656 VDD VSS sg13g2_decap_8
XFILLER_17_742 VDD VSS sg13g2_decap_8
Xclkbuf_5_10__f_clk_i clkbuf_leaf_35_clk_i/A clkbuf_4_5_0_clk_i/X VDD VSS sg13g2_buf_16
X_14775_ _14775_/Q _14868_/CLK _14775_/D _14775_/RESET_B VDD VSS sg13g2_dfrbpq_1
X_11987_ _11989_/B _11936_/A _13129_/B _11988_/B VDD VSS sg13g2_o21ai_1
XFILLER_16_252 VDD VSS sg13g2_decap_8
XFILLER_32_701 VDD VSS sg13g2_decap_8
XFILLER_1_1078 VDD VSS sg13g2_decap_8
X_13726_ _13726_/Q clkload36/A _13726_/D _13726_/RESET_B VDD VSS sg13g2_dfrbpq_1
XFILLER_108_1104 VDD VSS sg13g2_fill_2
X_10938_ _10938_/Y _10937_/Y _11043_/A _10935_/Y _10934_/Y _11045_/A2 VDD VSS sg13g2_a221oi_1
XFILLER_31_200 VDD VSS sg13g2_fill_2
XFILLER_149_408 VDD VSS sg13g2_decap_4
X_14222__1957 _14222_/RESET_B VDD VSS sg13g2_tiehi
X_13657_ _13657_/Q _15213_/CLK _13657_/D _13657_/RESET_B VDD VSS sg13g2_dfrbpq_1
X_10869_ _10869_/Y _10869_/A _10869_/B VDD VSS sg13g2_nor2_1
XFILLER_32_778 VDD VSS sg13g2_decap_8
X_12608_ _12608_/X _12602_/X _12606_/X _12601_/X _12605_/X _12663_/S0 _12608_/S1 VDD
+ VSS sg13g2_mux4_1
XFILLER_121_1304 VDD VSS sg13g2_fill_2
X_13588_ _15161_/D _13593_/B _13586_/Y _13587_/Y VDD VSS sg13g2_a21oi_1
XFILLER_9_952 VDD VSS sg13g2_decap_8
XFILLER_34_1367 VDD VSS sg13g2_decap_8
XFILLER_121_1326 VDD VSS sg13g2_decap_8
XFILLER_34_1378 VDD VSS sg13g2_fill_2
XFILLER_121_1337 VDD VSS sg13g2_fill_1
XFILLER_129_165 VDD VSS sg13g2_decap_8
XFILLER_158_997 VDD VSS sg13g2_decap_8
X_12539_ _12539_/X _12537_/X _12538_/X _12539_/S VDD VSS sg13g2_mux2_1
XFILLER_8_462 VDD VSS sg13g2_decap_8
XFILLER_172_400 VDD VSS sg13g2_decap_8
XFILLER_172_477 VDD VSS sg13g2_decap_8
X_14209_ _14209_/Q _14681_/CLK _14209_/D _14209_/RESET_B VDD VSS sg13g2_dfrbpq_1
X_15189_ _15189_/Q clkload63/A _15189_/D _15189_/RESET_B VDD VSS sg13g2_dfrbpq_1
XFILLER_67_1154 VDD VSS sg13g2_decap_8
XFILLER_28_1105 VDD VSS sg13g2_decap_8
XFILLER_125_393 VDD VSS sg13g2_fill_2
XFILLER_119_1255 VDD VSS sg13g2_fill_2
Xfanout408 _12679_/B2 _12721_/B2 VDD VSS sg13g2_buf_1
XFILLER_87_907 VDD VSS sg13g2_fill_2
XFILLER_154_1146 VDD VSS sg13g2_decap_4
Xfanout419 _10123_/S wire421/X VDD VSS sg13g2_buf_1
XFILLER_113_566 VDD VSS sg13g2_decap_8
X_14167__2012 _14167_/RESET_B VDD VSS sg13g2_tiehi
XFILLER_98_266 VDD VSS sg13g2_fill_2
XFILLER_80_1321 VDD VSS sg13g2_decap_8
X_09750_ _14340_/D _14340_/Q _09750_/A1 _09768_/S VDD VSS sg13g2_mux2_1
XFILLER_100_216 VDD VSS sg13g2_fill_1
X_13710__2469 _13710_/RESET_B VDD VSS sg13g2_tiehi
XFILLER_67_631 VDD VSS sg13g2_decap_4
X_08701_ _08701_/Y _07835_/Y _08699_/Y _08588_/B VDD VSS sg13g2_o21ai_1
XFILLER_41_1327 VDD VSS sg13g2_decap_8
X_09681_ _14273_/D _09912_/A1 _14273_/Q _09705_/S VDD VSS sg13g2_mux2_1
XFILLER_104_28 VDD VSS sg13g2_decap_8
X_08632_ _08633_/A _08641_/A _08630_/Y _08631_/Y VDD VSS sg13g2_o21ai_1
XFILLER_82_612 VDD VSS sg13g2_decap_8
XFILLER_67_686 VDD VSS sg13g2_decap_8
XFILLER_54_325 VDD VSS sg13g2_decap_8
XFILLER_130_1190 VDD VSS sg13g2_decap_8
X_08563_ _08563_/Y _08560_/A _08407_/Y _08562_/Y VDD VSS sg13g2_a21oi_1
XFILLER_81_166 VDD VSS sg13g2_decap_8
X_08494_ _08494_/Y _08494_/A _08494_/B VDD VSS sg13g2_nor2_1
XFILLER_62_391 VDD VSS sg13g2_decap_8
XFILLER_39_1267 VDD VSS sg13g2_decap_8
XFILLER_165_1275 VDD VSS sg13g2_decap_8
XFILLER_23_756 VDD VSS sg13g2_decap_8
XFILLER_10_406 VDD VSS sg13g2_decap_8
XFILLER_22_266 VDD VSS sg13g2_decap_8
XFILLER_13_14 VDD VSS sg13g2_decap_8
XFILLER_167_238 VDD VSS sg13g2_decap_8
X_14974__2613 _14974_/RESET_B VDD VSS sg13g2_tiehi
XFILLER_149_964 VDD VSS sg13g2_decap_8
XFILLER_129_14 VDD VSS sg13g2_decap_8
X_09115_ _09117_/B _10760_/A _09150_/B _13189_/A VDD VSS sg13g2_a21o_1
XFILLER_109_828 VDD VSS sg13g2_decap_4
XFILLER_136_636 VDD VSS sg13g2_fill_2
XFILLER_11_1120 VDD VSS sg13g2_decap_8
X_09046_ _13768_/D _13768_/Q _09919_/A1 _09106_/S VDD VSS sg13g2_mux2_1
X_14377__1802 _14377_/RESET_B VDD VSS sg13g2_tiehi
XFILLER_163_455 VDD VSS sg13g2_decap_8
XFILLER_2_616 VDD VSS sg13g2_decap_8
XFILLER_116_371 VDD VSS sg13g2_fill_1
XFILLER_11_1197 VDD VSS sg13g2_decap_8
XFILLER_145_35 VDD VSS sg13g2_decap_8
XFILLER_150_138 VDD VSS sg13g2_decap_8
XFILLER_8_7 VDD VSS sg13g2_decap_8
XFILLER_1_126 VDD VSS sg13g2_decap_8
XFILLER_172_1224 VDD VSS sg13g2_fill_2
XFILLER_104_566 VDD VSS sg13g2_decap_4
XFILLER_81_1129 VDD VSS sg13g2_fill_1
XFILLER_145_79 VDD VSS sg13g2_decap_8
Xfanout920 _13304_/B _15205_/Q VDD VSS sg13g2_buf_1
XFILLER_132_886 VDD VSS sg13g2_decap_8
Xfanout931 _12936_/B _15202_/Q VDD VSS sg13g2_buf_1
Xfanout942 _13499_/C _15128_/Q VDD VSS sg13g2_buf_1
X_09948_ _14532_/D _14532_/Q _10047_/A0 _09966_/S VDD VSS sg13g2_mux2_1
XFILLER_77_439 VDD VSS sg13g2_decap_8
Xfanout953 _13150_/B _07727_/B VDD VSS sg13g2_buf_1
Xfanout964 _07729_/B _15106_/Q VDD VSS sg13g2_buf_1
Xfanout975 _11027_/B1 _10983_/A1 VDD VSS sg13g2_buf_1
XFILLER_135_1090 VDD VSS sg13g2_decap_8
X_14300__1879 _14300_/RESET_B VDD VSS sg13g2_tiehi
Xfanout986 _11288_/A _08754_/A2 VDD VSS sg13g2_buf_1
Xfanout997 _09938_/C _09839_/C VDD VSS sg13g2_buf_1
X_09879_ _14465_/D _09912_/A1 _14465_/Q _09903_/S VDD VSS sg13g2_mux2_1
XFILLER_58_664 VDD VSS sg13g2_decap_8
XFILLER_100_761 VDD VSS sg13g2_decap_8
XFILLER_38_77 VDD VSS sg13g2_decap_8
XFILLER_161_56 VDD VSS sg13g2_decap_8
XFILLER_79_1014 VDD VSS sg13g2_decap_8
X_11910_ _12056_/B _11910_/A _11910_/B _11910_/C VDD VSS sg13g2_nor3_1
XFILLER_18_539 VDD VSS sg13g2_decap_8
X_12890_ _12894_/A _12875_/Y _12861_/A _12889_/Y VDD VSS sg13g2_o21ai_1
XFILLER_22_1282 VDD VSS sg13g2_decap_8
X_11841_ _11845_/C _11770_/A _13064_/B _13676_/Q _11798_/A _11779_/Y VDD VSS sg13g2_a221oi_1
XFILLER_96_1350 VDD VSS sg13g2_fill_1
XFILLER_54_21 VDD VSS sg13g2_decap_8
XFILLER_2_1365 VDD VSS sg13g2_decap_8
XFILLER_73_678 VDD VSS sg13g2_decap_8
XFILLER_166_1039 VDD VSS sg13g2_decap_8
X_13865__2314 _13865_/RESET_B VDD VSS sg13g2_tiehi
XFILLER_57_1323 VDD VSS sg13g2_decap_8
X_14560_ _14560_/Q clkload29/A _14560_/D _14560_/RESET_B VDD VSS sg13g2_dfrbpq_1
X_11772_ _11772_/Y _11706_/A _13679_/Q _13678_/Q _11726_/A _11771_/Y VDD VSS sg13g2_a221oi_1
XFILLER_41_520 VDD VSS sg13g2_decap_8
XFILLER_54_87 VDD VSS sg13g2_decap_4
XFILLER_14_756 VDD VSS sg13g2_decap_8
X_13511_ _15134_/D _15134_/Q _13525_/A _13519_/B VDD VSS sg13g2_mux2_1
X_10723_ _10724_/A _14908_/Q _11021_/B _11183_/B1 _11015_/C VDD VSS sg13g2_a22oi_1
XFILLER_92_1269 VDD VSS sg13g2_decap_8
X_14491_ _14491_/Q _14885_/CLK _14491_/D _14491_/RESET_B VDD VSS sg13g2_dfrbpq_1
XFILLER_41_564 VDD VSS sg13g2_fill_1
XFILLER_110_60 VDD VSS sg13g2_fill_2
XFILLER_13_266 VDD VSS sg13g2_decap_8
XFILLER_158_249 VDD VSS sg13g2_decap_4
X_13442_ _13442_/Y _13442_/A _13444_/B _13444_/C VDD VSS sg13g2_nor3_1
X_10654_ _10663_/D _10654_/A _10654_/B VDD VSS sg13g2_nor2_1
XFILLER_9_259 VDD VSS sg13g2_decap_8
XFILLER_16_1064 VDD VSS sg13g2_decap_8
XFILLER_139_474 VDD VSS sg13g2_decap_8
X_13373_ _13444_/A _13401_/C _13401_/B _13429_/A VDD VSS sg13g2_nand3_1
XFILLER_10_973 VDD VSS sg13g2_decap_8
XFILLER_155_934 VDD VSS sg13g2_decap_8
XFILLER_167_794 VDD VSS sg13g2_decap_8
X_10585_ _14872_/D _10591_/C _10591_/D _10581_/Y VDD VSS sg13g2_a21oi_1
Xclkload18 clkload18/Y clkload18/A VDD VSS sg13g2_inv_1
Xclkload29 clkload29/Y clkload29/A VDD VSS sg13g2_inv_1
X_15112_ _15112_/Q _15113_/CLK _15112_/D _15112_/RESET_B VDD VSS sg13g2_dfrbpq_1
X_12324_ _12324_/X _12324_/A _12324_/B VDD VSS sg13g2_and2_1
XFILLER_6_966 VDD VSS sg13g2_decap_8
X_15043_ _15043_/Q clkload50/A _15043_/D _15043_/RESET_B VDD VSS sg13g2_dfrbpq_1
X_12255_ _12255_/Y _12257_/A1 _13880_/Q _12169_/C VDD VSS sg13g2_a21oi_1
XFILLER_5_476 VDD VSS sg13g2_decap_8
XFILLER_154_499 VDD VSS sg13g2_decap_8
XFILLER_141_127 VDD VSS sg13g2_decap_8
XFILLER_64_1305 VDD VSS sg13g2_fill_2
XFILLER_141_138 VDD VSS sg13g2_fill_1
X_11206_ _11206_/Y _11206_/A1 _11205_/X _11109_/B VDD VSS sg13g2_o21ai_1
XFILLER_141_149 VDD VSS sg13g2_decap_8
X_12186_ _12187_/B _12186_/A _13942_/Q VDD VSS sg13g2_nand2_1
XFILLER_69_918 VDD VSS sg13g2_decap_8
XFILLER_123_875 VDD VSS sg13g2_decap_8
XFILLER_110_503 VDD VSS sg13g2_decap_4
X_11137_ _11152_/B _11163_/A _11190_/C VDD VSS sg13g2_nor2_1
XFILLER_7_1232 VDD VSS sg13g2_decap_8
XFILLER_1_693 VDD VSS sg13g2_decap_8
X_11068_ _11097_/C _11068_/A _11068_/B _11068_/C VDD VSS sg13g2_nand3_1
X_10019_ _14601_/D _10085_/A0 _14601_/Q _10035_/S VDD VSS sg13g2_mux2_1
XFILLER_92_921 VDD VSS sg13g2_decap_4
XFILLER_77_995 VDD VSS sg13g2_decap_8
XFILLER_48_163 VDD VSS sg13g2_fill_1
XFILLER_97_1125 VDD VSS sg13g2_decap_8
XFILLER_48_174 VDD VSS sg13g2_decap_8
XFILLER_64_634 VDD VSS sg13g2_decap_8
XFILLER_48_185 VDD VSS sg13g2_fill_2
XFILLER_149_1215 VDD VSS sg13g2_decap_4
XFILLER_36_347 VDD VSS sg13g2_decap_8
X_14827_ _14827_/Q _14890_/CLK _14827_/D _14827_/RESET_B VDD VSS sg13g2_dfrbpq_1
XFILLER_97_1169 VDD VSS sg13g2_fill_1
XFILLER_63_144 VDD VSS sg13g2_decap_8
XFILLER_149_1248 VDD VSS sg13g2_decap_4
XFILLER_52_818 VDD VSS sg13g2_decap_8
XFILLER_52_829 VDD VSS sg13g2_fill_2
X_14455__1724 _14455_/RESET_B VDD VSS sg13g2_tiehi
X_14758_ _14758_/Q clkload66/A _14758_/D _14758_/RESET_B VDD VSS sg13g2_dfrbpq_1
XFILLER_60_840 VDD VSS sg13g2_decap_8
X_13709_ _16871_/A clkload50/A _13709_/D _13709_/RESET_B VDD VSS sg13g2_dfrbpq_1
XFILLER_32_553 VDD VSS sg13g2_decap_8
X_14689_ _14689_/Q clkload31/A _14689_/D _14689_/RESET_B VDD VSS sg13g2_dfrbpq_1
XFILLER_60_884 VDD VSS sg13g2_fill_1
XFILLER_34_1120 VDD VSS sg13g2_decap_8
XFILLER_149_249 VDD VSS sg13g2_fill_2
XFILLER_146_901 VDD VSS sg13g2_decap_8
XFILLER_145_400 VDD VSS sg13g2_decap_8
XFILLER_30_1028 VDD VSS sg13g2_fill_1
XFILLER_117_124 VDD VSS sg13g2_decap_8
XFILLER_30_1039 VDD VSS sg13g2_fill_2
XFILLER_67_0 VDD VSS sg13g2_decap_8
XFILLER_121_1178 VDD VSS sg13g2_fill_1
XFILLER_172_241 VDD VSS sg13g2_decap_8
XFILLER_133_606 VDD VSS sg13g2_decap_8
XFILLER_145_466 VDD VSS sg13g2_fill_2
XFILLER_161_926 VDD VSS sg13g2_decap_8
XFILLER_160_414 VDD VSS sg13g2_decap_8
XFILLER_126_680 VDD VSS sg13g2_decap_8
XFILLER_99_520 VDD VSS sg13g2_decap_8
XFILLER_172_296 VDD VSS sg13g2_decap_8
XFILLER_99_531 VDD VSS sg13g2_fill_2
XFILLER_5_70 VDD VSS sg13g2_decap_8
XFILLER_119_1041 VDD VSS sg13g2_decap_8
Xfanout205 _09925_/A1 _10157_/A1 VDD VSS sg13g2_buf_1
XFILLER_87_704 VDD VSS sg13g2_fill_1
XFILLER_113_352 VDD VSS sg13g2_fill_1
XFILLER_87_715 VDD VSS sg13g2_fill_1
X_13943__2236 _13943_/RESET_B VDD VSS sg13g2_tiehi
Xfanout216 _09923_/A1 fanout219/X VDD VSS sg13g2_buf_1
XFILLER_113_363 VDD VSS sg13g2_fill_1
Xfanout227 _09622_/A0 _09921_/A1 VDD VSS sg13g2_buf_1
X_09802_ _14391_/D _09934_/A1 _14391_/Q _09804_/S VDD VSS sg13g2_mux2_1
XFILLER_8_1029 VDD VSS sg13g2_decap_8
XFILLER_140_160 VDD VSS sg13g2_decap_4
XFILLER_141_683 VDD VSS sg13g2_fill_1
Xfanout238 _12295_/B1 _11501_/A2 VDD VSS sg13g2_buf_1
XFILLER_59_428 VDD VSS sg13g2_decap_8
XFILLER_119_1096 VDD VSS sg13g2_decap_4
XFILLER_141_694 VDD VSS sg13g2_decap_4
Xfanout249 _09984_/A0 _10083_/A0 VDD VSS sg13g2_buf_1
X_07994_ _07994_/X _15100_/Q _15089_/Q VDD VSS sg13g2_or2_1
XFILLER_59_439 VDD VSS sg13g2_fill_1
XFILLER_113_396 VDD VSS sg13g2_decap_8
XFILLER_115_49 VDD VSS sg13g2_decap_8
XFILLER_87_759 VDD VSS sg13g2_fill_2
XFILLER_101_547 VDD VSS sg13g2_decap_4
XFILLER_41_1102 VDD VSS sg13g2_fill_2
X_09733_ _14324_/D _09898_/A0 _14324_/Q _09733_/S VDD VSS sg13g2_mux2_1
XFILLER_132_1263 VDD VSS sg13g2_decap_4
XFILLER_39_152 VDD VSS sg13g2_fill_2
XFILLER_41_1157 VDD VSS sg13g2_decap_8
X_09664_ _14257_/D _09928_/A1 _14257_/Q _09664_/S VDD VSS sg13g2_mux2_1
XFILLER_54_133 VDD VSS sg13g2_decap_8
X_08615_ _15244_/D _08615_/A _08615_/B _08615_/C VDD VSS sg13g2_nand3_1
X_09595_ _14192_/D _14192_/Q _09828_/A0 _09603_/S VDD VSS sg13g2_mux2_1
XFILLER_43_829 VDD VSS sg13g2_decap_8
XFILLER_70_626 VDD VSS sg13g2_decap_8
XFILLER_82_497 VDD VSS sg13g2_decap_8
XFILLER_54_188 VDD VSS sg13g2_decap_8
X_08546_ _08546_/Y _07956_/A _07812_/B _08529_/Y VDD VSS sg13g2_o21ai_1
XFILLER_24_35 VDD VSS sg13g2_decap_8
X_08477_ _08477_/Y _08443_/Y _07807_/C _08476_/Y VDD VSS sg13g2_a21oi_1
XFILLER_145_7 VDD VSS sg13g2_decap_8
XFILLER_168_525 VDD VSS sg13g2_decap_8
XFILLER_10_203 VDD VSS sg13g2_decap_8
XFILLER_17_1351 VDD VSS sg13g2_decap_8
XFILLER_52_1242 VDD VSS sg13g2_decap_8
XFILLER_13_1204 VDD VSS sg13g2_decap_8
XFILLER_52_1253 VDD VSS sg13g2_decap_8
XFILLER_136_400 VDD VSS sg13g2_decap_8
X_10370_ _14814_/D _10370_/A _10643_/A _10370_/C VDD VSS sg13g2_nor3_1
XFILLER_40_56 VDD VSS sg13g2_decap_8
XFILLER_100_1229 VDD VSS sg13g2_fill_2
XFILLER_136_455 VDD VSS sg13g2_fill_1
XFILLER_3_903 VDD VSS sg13g2_decap_8
XFILLER_152_926 VDD VSS sg13g2_fill_1
XFILLER_163_252 VDD VSS sg13g2_decap_8
XFILLER_151_403 VDD VSS sg13g2_decap_8
XFILLER_156_56 VDD VSS sg13g2_decap_8
X_09029_ _09031_/C _14905_/Q _12957_/A _10702_/A _09030_/D VDD VSS sg13g2_and4_1
XFILLER_123_105 VDD VSS sg13g2_fill_2
XFILLER_164_797 VDD VSS sg13g2_fill_2
XFILLER_2_413 VDD VSS sg13g2_decap_8
XFILLER_105_831 VDD VSS sg13g2_fill_2
XFILLER_123_127 VDD VSS sg13g2_decap_8
X_12040_ _12040_/Y _12040_/A1 _14226_/Q _12023_/B VDD VSS sg13g2_a21oi_1
XFILLER_85_1051 VDD VSS sg13g2_fill_2
XFILLER_46_1002 VDD VSS sg13g2_fill_2
XFILLER_49_21 VDD VSS sg13g2_decap_8
XFILLER_120_801 VDD VSS sg13g2_decap_8
XFILLER_85_1084 VDD VSS sg13g2_decap_8
X_14533__1646 _14533_/RESET_B VDD VSS sg13g2_tiehi
XFILLER_133_1016 VDD VSS sg13g2_fill_1
X_13919__2260 _13919_/RESET_B VDD VSS sg13g2_tiehi
XFILLER_46_1068 VDD VSS sg13g2_decap_8
XFILLER_77_225 VDD VSS sg13g2_decap_8
Xfanout750 fanout750/X _07631_/Y VDD VSS sg13g2_buf_1
XFILLER_78_759 VDD VSS sg13g2_decap_8
XFILLER_63_1371 VDD VSS sg13g2_decap_8
Xclkbuf_leaf_60_clk_i _15214_/CLK clkbuf_leaf_61_clk_i/A VDD VSS sg13g2_buf_8
Xfanout761 _13550_/A1 _08048_/A VDD VSS sg13g2_buf_1
XFILLER_172_77 VDD VSS sg13g2_decap_8
Xfanout772 _10797_/C _10912_/A1 VDD VSS sg13g2_buf_1
XFILLER_93_718 VDD VSS sg13g2_decap_8
X_13991_ _13991_/Q _14607_/CLK _13991_/D _13991_/RESET_B VDD VSS sg13g2_dfrbpq_1
Xfanout783 fanout783/X _15214_/Q VDD VSS sg13g2_buf_1
XFILLER_24_1344 VDD VSS sg13g2_decap_8
XFILLER_1_28 VDD VSS sg13g2_decap_8
Xfanout794 _12649_/S0 _15212_/Q VDD VSS sg13g2_buf_1
X_14787__2926 _14787_/RESET_B VDD VSS sg13g2_tiehi
XFILLER_19_826 VDD VSS sg13g2_decap_8
XFILLER_92_228 VDD VSS sg13g2_decap_8
X_12942_ _12988_/B _14903_/Q _12942_/B VDD VSS sg13g2_xnor2_1
XFILLER_86_792 VDD VSS sg13g2_decap_8
XFILLER_100_580 VDD VSS sg13g2_fill_1
X_14823__2890 _14823_/RESET_B VDD VSS sg13g2_tiehi
XFILLER_18_336 VDD VSS sg13g2_decap_8
XFILLER_171_0 VDD VSS sg13g2_decap_8
XFILLER_65_64 VDD VSS sg13g2_fill_2
X_12873_ _12877_/C _14899_/Q _13688_/Q VDD VSS sg13g2_xor2_1
X_15134__2689 _15134_/RESET_B VDD VSS sg13g2_tiehi
XFILLER_46_689 VDD VSS sg13g2_fill_1
XFILLER_2_1162 VDD VSS sg13g2_decap_8
Xclkbuf_leaf_75_clk_i clkload54/A clkbuf_leaf_75_clk_i/A VDD VSS sg13g2_buf_8
X_14612_ _14612_/Q _14644_/CLK _14612_/D _14612_/RESET_B VDD VSS sg13g2_dfrbpq_1
X_11824_ _11824_/Y _11353_/S _13868_/Q _11374_/C VDD VSS sg13g2_a21oi_1
XFILLER_57_1131 VDD VSS sg13g2_decap_8
XFILLER_92_1022 VDD VSS sg13g2_decap_8
XFILLER_60_136 VDD VSS sg13g2_fill_1
XFILLER_57_1153 VDD VSS sg13g2_decap_4
XFILLER_14_553 VDD VSS sg13g2_decap_8
X_14543_ _14543_/Q _14607_/CLK _14543_/D _14543_/RESET_B VDD VSS sg13g2_dfrbpq_1
X_11755_ _11755_/Y _11752_/Y _11754_/X _12118_/C VDD VSS sg13g2_o21ai_1
XFILLER_42_884 VDD VSS sg13g2_decap_4
XFILLER_18_1148 VDD VSS sg13g2_decap_8
XFILLER_105_1107 VDD VSS sg13g2_decap_8
XFILLER_144_1156 VDD VSS sg13g2_fill_2
X_10706_ _10706_/Y _12957_/A _10862_/B VDD VSS sg13g2_nand2_1
X_14474_ _14474_/Q _14666_/CLK _14474_/D _14474_/RESET_B VDD VSS sg13g2_dfrbpq_1
XFILLER_81_96 VDD VSS sg13g2_fill_1
X_11686_ _11687_/A _14248_/Q _14280_/Q _14312_/Q _14344_/Q _11692_/A _12026_/C VDD
+ VSS sg13g2_mux4_1
XFILLER_146_208 VDD VSS sg13g2_fill_2
X_13425_ _13425_/Y _13427_/B _15130_/Q _13469_/C VDD VSS sg13g2_nand3_1
XFILLER_128_934 VDD VSS sg13g2_decap_8
X_10637_ _14886_/D _10642_/C _10637_/B VDD VSS sg13g2_nor2_1
XFILLER_31_1337 VDD VSS sg13g2_decap_8
XFILLER_10_770 VDD VSS sg13g2_decap_8
XFILLER_127_444 VDD VSS sg13g2_decap_4
XFILLER_60_7 VDD VSS sg13g2_decap_8
X_13356_ _13361_/C _13506_/A _13398_/B _13507_/B VDD VSS sg13g2_nand3_1
X_10568_ _10591_/C _10579_/B _10579_/C VDD VSS sg13g2_and2_1
XFILLER_6_763 VDD VSS sg13g2_decap_8
XFILLER_154_263 VDD VSS sg13g2_decap_8
XFILLER_170_712 VDD VSS sg13g2_decap_8
Xclkbuf_leaf_13_clk_i _14512_/CLK clkbuf_leaf_4_clk_i/A VDD VSS sg13g2_buf_8
XFILLER_127_488 VDD VSS sg13g2_decap_4
X_12307_ _12308_/B _12307_/A _12307_/B _12307_/C VDD VSS sg13g2_nand3_1
XFILLER_143_959 VDD VSS sg13g2_decap_8
X_13287_ _13291_/B _13287_/A _13287_/B _13287_/C VDD VSS sg13g2_or3_1
X_10499_ _14853_/D _10499_/A _10499_/B _10499_/C VDD VSS sg13g2_and3_1
XFILLER_5_273 VDD VSS sg13g2_decap_8
XFILLER_142_447 VDD VSS sg13g2_fill_2
X_15026_ _15026_/Q clkload55/A _15026_/D _15026_/RESET_B VDD VSS sg13g2_dfrbpq_1
X_12238_ _12239_/A _13976_/Q _14008_/Q _14040_/Q _14072_/Q _12238_/S0 _12236_/C VDD
+ VSS sg13g2_mux4_1
XFILLER_29_1233 VDD VSS sg13g2_decap_8
XFILLER_155_1241 VDD VSS sg13g2_fill_2
XFILLER_170_789 VDD VSS sg13g2_decap_8
XFILLER_9_1316 VDD VSS sg13g2_decap_8
XFILLER_151_981 VDD VSS sg13g2_decap_8
XFILLER_155_1263 VDD VSS sg13g2_fill_1
X_12169_ _12170_/B _12169_/A _12169_/B _12169_/C VDD VSS sg13g2_nand3_1
XFILLER_2_980 VDD VSS sg13g2_decap_8
XFILLER_111_845 VDD VSS sg13g2_decap_8
X_14509__1670 _14509_/RESET_B VDD VSS sg13g2_tiehi
Xclkbuf_leaf_28_clk_i _14677_/CLK clkbuf_leaf_9_clk_i/A VDD VSS sg13g2_buf_8
X_15180__2847 _15180_/RESET_B VDD VSS sg13g2_tiehi
XFILLER_110_344 VDD VSS sg13g2_fill_1
XFILLER_84_707 VDD VSS sg13g2_decap_8
XFILLER_1_490 VDD VSS sg13g2_decap_8
XFILLER_110_355 VDD VSS sg13g2_decap_8
XFILLER_111_889 VDD VSS sg13g2_fill_1
XFILLER_49_450 VDD VSS sg13g2_decap_8
XFILLER_83_206 VDD VSS sg13g2_decap_8
XFILLER_83_217 VDD VSS sg13g2_fill_1
Xinput5 input5/X input5/A VDD VSS sg13g2_buf_1
XFILLER_64_431 VDD VSS sg13g2_fill_2
XFILLER_37_656 VDD VSS sg13g2_decap_4
XFILLER_92_762 VDD VSS sg13g2_decap_8
X_08400_ _08400_/Y _08659_/B _08600_/A VDD VSS sg13g2_nor2b_1
XFILLER_51_103 VDD VSS sg13g2_fill_1
X_09380_ _13983_/D _09611_/A0 _13983_/Q _09398_/S VDD VSS sg13g2_mux2_1
XFILLER_80_946 VDD VSS sg13g2_decap_8
XFILLER_52_659 VDD VSS sg13g2_fill_2
XFILLER_127_1321 VDD VSS sg13g2_decap_8
X_08331_ _08331_/Y _08147_/Y _08241_/A _08027_/Y VDD VSS sg13g2_a21oi_1
XFILLER_33_873 VDD VSS sg13g2_fill_1
X_08262_ _08262_/Y _08256_/Y _08257_/Y _08252_/Y _08381_/A _08261_/Y VDD VSS sg13g2_a221oi_1
XFILLER_32_394 VDD VSS sg13g2_decap_8
X_15048__2529 _15048_/RESET_B VDD VSS sg13g2_tiehi
XFILLER_118_400 VDD VSS sg13g2_fill_1
X_14611__1568 _14611_/RESET_B VDD VSS sg13g2_tiehi
XFILLER_20_567 VDD VSS sg13g2_decap_8
XFILLER_165_539 VDD VSS sg13g2_decap_8
X_08193_ _08193_/Y _07890_/B _08191_/Y _08192_/Y VDD VSS sg13g2_a21oi_1
XFILLER_146_731 VDD VSS sg13g2_decap_8
XFILLER_118_433 VDD VSS sg13g2_decap_8
XFILLER_69_1002 VDD VSS sg13g2_decap_8
XFILLER_119_978 VDD VSS sg13g2_decap_8
XFILLER_161_701 VDD VSS sg13g2_decap_8
X_14891__2762 _14891_/RESET_B VDD VSS sg13g2_tiehi
XFILLER_105_105 VDD VSS sg13g2_decap_8
XFILLER_12_1281 VDD VSS sg13g2_decap_8
XFILLER_105_116 VDD VSS sg13g2_fill_1
XFILLER_105_149 VDD VSS sg13g2_decap_8
XFILLER_47_1322 VDD VSS sg13g2_decap_8
XFILLER_161_778 VDD VSS sg13g2_decap_8
XFILLER_86_1382 VDD VSS sg13g2_fill_2
XFILLER_173_1330 VDD VSS sg13g2_decap_4
XFILLER_160_266 VDD VSS sg13g2_fill_1
XFILLER_142_981 VDD VSS sg13g2_decap_8
XFILLER_160_288 VDD VSS sg13g2_decap_8
XFILLER_59_203 VDD VSS sg13g2_decap_8
XFILLER_113_160 VDD VSS sg13g2_decap_4
XFILLER_87_523 VDD VSS sg13g2_decap_8
XFILLER_102_834 VDD VSS sg13g2_decap_8
XFILLER_87_534 VDD VSS sg13g2_fill_2
XFILLER_101_322 VDD VSS sg13g2_decap_8
XFILLER_113_182 VDD VSS sg13g2_decap_8
XFILLER_75_707 VDD VSS sg13g2_decap_4
XFILLER_19_35 VDD VSS sg13g2_decap_8
XFILLER_142_14 VDD VSS sg13g2_decap_8
X_07977_ _07977_/Y _08577_/B _07866_/Y _07976_/X VDD VSS sg13g2_a21oi_1
X_09716_ _14307_/D _09914_/A1 _14307_/Q _09738_/S VDD VSS sg13g2_mux2_1
XFILLER_56_965 VDD VSS sg13g2_decap_8
XFILLER_55_442 VDD VSS sg13g2_decap_8
XFILLER_27_133 VDD VSS sg13g2_decap_8
X_09647_ _14240_/D _09911_/A1 _14240_/Q _09672_/S VDD VSS sg13g2_mux2_1
XFILLER_76_1006 VDD VSS sg13g2_fill_1
XFILLER_82_261 VDD VSS sg13g2_decap_8
XFILLER_83_795 VDD VSS sg13g2_fill_1
XFILLER_55_497 VDD VSS sg13g2_decap_8
XFILLER_163_1009 VDD VSS sg13g2_decap_8
XFILLER_167_1178 VDD VSS sg13g2_decap_4
X_09578_ _14175_/D _14175_/Q _09611_/A0 _09596_/S VDD VSS sg13g2_mux2_1
XFILLER_35_56 VDD VSS sg13g2_decap_8
XFILLER_71_979 VDD VSS sg13g2_fill_1
X_08529_ _08529_/Y _08566_/C _08495_/Y _08567_/C VDD VSS sg13g2_o21ai_1
XFILLER_169_834 VDD VSS sg13g2_decap_8
XFILLER_54_1326 VDD VSS sg13g2_decap_8
XFILLER_23_350 VDD VSS sg13g2_decap_8
XFILLER_168_322 VDD VSS sg13g2_decap_8
X_11540_ _11540_/Y _11536_/Y _11537_/Y _11539_/Y _11538_/Y _12190_/B VDD VSS sg13g2_a221oi_1
XFILLER_11_567 VDD VSS sg13g2_decap_8
XFILLER_13_1001 VDD VSS sg13g2_decap_8
X_11471_ _11471_/X _13729_/Q _14081_/Q _14433_/Q _14529_/Q _12286_/S0 _12282_/S1 VDD
+ VSS sg13g2_mux4_1
XFILLER_168_399 VDD VSS sg13g2_decap_8
X_13210_ _13211_/B _13253_/B2 _13205_/X _13204_/Y _13303_/A _13209_/Y VDD VSS sg13g2_a221oi_1
X_10422_ _10423_/B _14828_/Q _14829_/Q _14830_/Q _10422_/D VDD VSS sg13g2_nand4_1
XFILLER_52_1094 VDD VSS sg13g2_decap_8
XFILLER_51_99 VDD VSS sg13g2_decap_4
XFILLER_109_444 VDD VSS sg13g2_decap_8
XFILLER_171_509 VDD VSS sg13g2_decap_8
XFILLER_167_77 VDD VSS sg13g2_decap_8
X_14190_ _14190_/Q clkload36/A _14190_/D _14190_/RESET_B VDD VSS sg13g2_dfrbpq_1
XFILLER_87_1124 VDD VSS sg13g2_fill_2
XFILLER_13_1078 VDD VSS sg13g2_decap_8
XFILLER_125_937 VDD VSS sg13g2_fill_1
XFILLER_3_700 VDD VSS sg13g2_decap_8
XFILLER_152_723 VDD VSS sg13g2_decap_4
X_13141_ _15042_/D _13141_/A _13141_/B VDD VSS sg13g2_nor2_1
X_10353_ _14810_/D _10353_/A _10353_/B _10353_/C VDD VSS sg13g2_and3_1
XFILLER_152_745 VDD VSS sg13g2_decap_8
XFILLER_174_1116 VDD VSS sg13g2_decap_8
XFILLER_152_756 VDD VSS sg13g2_fill_1
XFILLER_2_210 VDD VSS sg13g2_decap_8
XFILLER_174_1127 VDD VSS sg13g2_decap_8
XFILLER_139_1258 VDD VSS sg13g2_decap_8
XFILLER_140_907 VDD VSS sg13g2_decap_4
XFILLER_152_767 VDD VSS sg13g2_decap_8
X_13072_ _13072_/X input11/X _13205_/A2 _13205_/B1 VDD VSS sg13g2_a21o_1
XFILLER_112_609 VDD VSS sg13g2_decap_8
XFILLER_152_778 VDD VSS sg13g2_fill_1
X_10284_ _10284_/Y _14788_/Q _14789_/Q _10305_/A _10305_/B VDD VSS sg13g2_nand4_1
XFILLER_3_777 VDD VSS sg13g2_decap_8
X_12023_ _12027_/A _12022_/X _12023_/B VDD VSS sg13g2_nand2b_1
XFILLER_133_992 VDD VSS sg13g2_fill_1
XFILLER_2_287 VDD VSS sg13g2_decap_8
XFILLER_116_92 VDD VSS sg13g2_decap_4
XFILLER_93_515 VDD VSS sg13g2_decap_8
XFILLER_24_1141 VDD VSS sg13g2_decap_8
Xfanout580 _11904_/A2 _12338_/A2 VDD VSS sg13g2_buf_1
XFILLER_93_526 VDD VSS sg13g2_fill_1
Xfanout591 _10903_/B _10670_/Y VDD VSS sg13g2_buf_1
XFILLER_65_228 VDD VSS sg13g2_decap_8
XFILLER_98_1220 VDD VSS sg13g2_decap_8
XFILLER_47_932 VDD VSS sg13g2_fill_2
XFILLER_19_623 VDD VSS sg13g2_decap_8
X_13974_ _13974_/Q _14660_/CLK _13974_/D _13974_/RESET_B VDD VSS sg13g2_dfrbpq_1
XFILLER_93_548 VDD VSS sg13g2_decap_8
XFILLER_65_239 VDD VSS sg13g2_fill_1
XFILLER_4_1246 VDD VSS sg13g2_decap_8
XFILLER_111_1133 VDD VSS sg13g2_decap_8
XFILLER_59_1204 VDD VSS sg13g2_fill_1
XFILLER_18_133 VDD VSS sg13g2_decap_8
X_12925_ _12989_/B _12925_/A _12925_/B _12925_/C VDD VSS sg13g2_nand3_1
XFILLER_47_998 VDD VSS sg13g2_decap_8
XFILLER_94_1139 VDD VSS sg13g2_fill_2
X_12856_ _15024_/D _12855_/Y _12850_/X _13239_/A VDD VSS sg13g2_a21oi_1
XFILLER_15_840 VDD VSS sg13g2_decap_8
X_11807_ _11808_/A _13964_/Q _13996_/Q _14028_/Q _14060_/Q _11804_/A _11805_/C VDD
+ VSS sg13g2_mux4_1
XFILLER_14_350 VDD VSS sg13g2_decap_8
XFILLER_33_169 VDD VSS sg13g2_decap_8
XFILLER_159_322 VDD VSS sg13g2_decap_8
X_12787_ _12787_/X _14714_/Q _14746_/Q _13786_/Q _13818_/Q _12787_/S0 _12787_/S1 VDD
+ VSS sg13g2_mux4_1
XFILLER_109_1062 VDD VSS sg13g2_decap_8
X_14526_ _14526_/Q _14686_/CLK _14526_/D _14526_/RESET_B VDD VSS sg13g2_dfrbpq_1
X_11738_ _11738_/X _14570_/Q _14602_/Q _11759_/A VDD VSS sg13g2_mux2_1
XFILLER_159_399 VDD VSS sg13g2_decap_8
X_14457_ _14457_/Q clkload21/A _14457_/D _14457_/RESET_B VDD VSS sg13g2_dfrbpq_1
X_11669_ _11669_/Y _11665_/Y _11666_/Y _11668_/Y _11667_/Y _12036_/B VDD VSS sg13g2_a221oi_1
XFILLER_70_1172 VDD VSS sg13g2_fill_2
XFILLER_128_742 VDD VSS sg13g2_decap_8
XFILLER_31_1134 VDD VSS sg13g2_decap_8
X_13408_ _15091_/D _13444_/A _13396_/D _13407_/Y VDD VSS sg13g2_o21ai_1
XFILLER_162_509 VDD VSS sg13g2_decap_8
X_14388_ _14388_/Q clkload15/A _14388_/D _14388_/RESET_B VDD VSS sg13g2_dfrbpq_1
XFILLER_122_1295 VDD VSS sg13g2_decap_8
XFILLER_6_560 VDD VSS sg13g2_decap_8
X_13339_ _13341_/A _13346_/A _13502_/B _15175_/D _13351_/B VDD VSS sg13g2_or4_1
XFILLER_142_233 VDD VSS sg13g2_fill_2
XFILLER_170_553 VDD VSS sg13g2_decap_8
XFILLER_115_469 VDD VSS sg13g2_decap_4
Xhold3108 _13636_/A _13744_/Q VDD VSS sg13g2_dlygate4sd3_1
Xhold3119 _13631_/A _13739_/Q VDD VSS sg13g2_dlygate4sd3_1
XFILLER_142_277 VDD VSS sg13g2_decap_8
XFILLER_9_1113 VDD VSS sg13g2_decap_8
XFILLER_142_288 VDD VSS sg13g2_fill_1
X_15009_ _15009_/Q clkload33/A _15009_/D _15009_/RESET_B VDD VSS sg13g2_dfrbpq_1
X_07900_ _07900_/Y _07903_/B _07900_/B VDD VSS sg13g2_nand2b_1
XFILLER_29_1052 VDD VSS sg13g2_fill_1
XFILLER_123_480 VDD VSS sg13g2_fill_2
X_08880_ _13703_/D _16865_/A _08879_/X _08892_/S VDD VSS sg13g2_mux2_1
XFILLER_69_534 VDD VSS sg13g2_decap_8
XFILLER_116_1033 VDD VSS sg13g2_fill_1
XFILLER_155_1093 VDD VSS sg13g2_decap_8
X_14025__2154 _14025_/RESET_B VDD VSS sg13g2_tiehi
X_14868__2808 _14868_/RESET_B VDD VSS sg13g2_tiehi
X_07831_ _07979_/C _08692_/B _08692_/C VDD VSS sg13g2_nand2b_1
XFILLER_42_1230 VDD VSS sg13g2_decap_4
XFILLER_38_921 VDD VSS sg13g2_decap_8
X_07762_ _07762_/Y _13302_/C _15204_/Q _07754_/Y VDD VSS sg13g2_a21oi_1
XFILLER_38_943 VDD VSS sg13g2_decap_4
XFILLER_49_291 VDD VSS sg13g2_decap_8
X_09501_ _14101_/D _10031_/A0 _14101_/Q _09502_/S VDD VSS sg13g2_mux2_1
XFILLER_112_28 VDD VSS sg13g2_decap_8
X_07693_ _07696_/B _15084_/Q _07701_/B VDD VSS sg13g2_nand2_1
XFILLER_38_987 VDD VSS sg13g2_fill_1
XFILLER_38_998 VDD VSS sg13g2_decap_8
XFILLER_65_784 VDD VSS sg13g2_decap_4
XFILLER_52_401 VDD VSS sg13g2_decap_8
X_09432_ _14034_/D _09630_/A0 _14034_/Q _09440_/S VDD VSS sg13g2_mux2_1
XFILLER_64_283 VDD VSS sg13g2_decap_8
XFILLER_53_946 VDD VSS sg13g2_decap_8
XFILLER_64_294 VDD VSS sg13g2_decap_8
X_13893__2286 _13893_/RESET_B VDD VSS sg13g2_tiehi
XFILLER_24_147 VDD VSS sg13g2_decap_8
XFILLER_169_119 VDD VSS sg13g2_decap_8
XFILLER_80_776 VDD VSS sg13g2_fill_2
X_09363_ _13967_/D _10091_/A0 _13967_/Q _09365_/S VDD VSS sg13g2_mux2_1
XFILLER_162_1020 VDD VSS sg13g2_decap_4
XFILLER_33_670 VDD VSS sg13g2_decap_8
X_08314_ _08350_/B _08315_/B _07776_/Y _08287_/Y _07779_/Y _07773_/Y VDD VSS sg13g2_a221oi_1
X_09294_ _13902_/D _13902_/Q _09859_/A1 _09300_/S VDD VSS sg13g2_mux2_1
XANTENNA_10 _09702_/S VDD VSS sg13g2_antennanp
XANTENNA_21 _12791_/C1 VDD VSS sg13g2_antennanp
XFILLER_21_854 VDD VSS sg13g2_decap_8
XANTENNA_32 _16881_/A VDD VSS sg13g2_antennanp
X_08245_ _08245_/Y _08431_/C _08021_/A _08027_/Y VDD VSS sg13g2_a21oi_1
XFILLER_123_1059 VDD VSS sg13g2_fill_2
XFILLER_20_364 VDD VSS sg13g2_decap_8
XFILLER_119_731 VDD VSS sg13g2_fill_1
XFILLER_165_336 VDD VSS sg13g2_decap_8
XFILLER_21_14 VDD VSS sg13g2_decap_8
XFILLER_119_764 VDD VSS sg13g2_decap_8
XFILLER_14_1365 VDD VSS sg13g2_decap_8
XFILLER_153_509 VDD VSS sg13g2_decap_8
X_08176_ _08187_/C _08188_/B _08142_/A _08175_/Y _07876_/A _08174_/Y VDD VSS sg13g2_a221oi_1
XFILLER_101_1335 VDD VSS sg13g2_decap_8
XFILLER_10_1218 VDD VSS sg13g2_decap_8
XFILLER_137_14 VDD VSS sg13g2_decap_8
XFILLER_101_1346 VDD VSS sg13g2_fill_2
XFILLER_107_937 VDD VSS sg13g2_fill_2
X_14235__1944 _14235_/RESET_B VDD VSS sg13g2_tiehi
XFILLER_107_959 VDD VSS sg13g2_decap_8
XFILLER_108_7 VDD VSS sg13g2_decap_4
XFILLER_133_222 VDD VSS sg13g2_decap_8
XFILLER_133_299 VDD VSS sg13g2_fill_1
XFILLER_99_180 VDD VSS sg13g2_decap_8
XFILLER_0_758 VDD VSS sg13g2_decap_8
XFILLER_153_35 VDD VSS sg13g2_decap_8
XFILLER_99_191 VDD VSS sg13g2_fill_1
XFILLER_82_1076 VDD VSS sg13g2_decap_8
XFILLER_101_130 VDD VSS sg13g2_decap_4
XFILLER_102_653 VDD VSS sg13g2_fill_2
XFILLER_102_686 VDD VSS sg13g2_fill_2
XFILLER_130_995 VDD VSS sg13g2_decap_8
XFILLER_75_548 VDD VSS sg13g2_decap_8
XFILLER_28_442 VDD VSS sg13g2_decap_8
XFILLER_56_762 VDD VSS sg13g2_decap_8
XFILLER_21_1358 VDD VSS sg13g2_decap_8
X_10971_ _10971_/Y _11109_/B _10722_/Y _11183_/B1 VDD VSS sg13g2_o21ai_1
XFILLER_46_77 VDD VSS sg13g2_decap_8
XFILLER_16_637 VDD VSS sg13g2_decap_8
X_12710_ _12710_/X _14709_/Q _14741_/Q _13781_/Q _13813_/Q _12715_/S0 _12715_/S1 VDD
+ VSS sg13g2_mux4_1
XFILLER_71_732 VDD VSS sg13g2_fill_2
X_13690_ _13690_/Q clkload66/A _13690_/D _13690_/RESET_B VDD VSS sg13g2_dfrbpq_1
XFILLER_15_147 VDD VSS sg13g2_decap_8
X_13723__2456 _13723_/RESET_B VDD VSS sg13g2_tiehi
XFILLER_71_765 VDD VSS sg13g2_fill_2
XFILLER_43_456 VDD VSS sg13g2_decap_8
X_14483__1696 _14483_/RESET_B VDD VSS sg13g2_tiehi
X_12641_ _12641_/X _14704_/Q _14736_/Q _13776_/Q _13808_/Q _12645_/S0 _12645_/S1 VDD
+ VSS sg13g2_mux4_1
XFILLER_62_21 VDD VSS sg13g2_decap_8
XFILLER_54_1101 VDD VSS sg13g2_fill_2
XFILLER_169_620 VDD VSS sg13g2_fill_1
XFILLER_19_1232 VDD VSS sg13g2_decap_8
XFILLER_145_1273 VDD VSS sg13g2_fill_2
X_12572_ _12572_/X _13739_/Q _14091_/Q _14443_/Q _14539_/Q _12601_/S0 _12601_/S1 VDD
+ VSS sg13g2_mux4_1
XFILLER_129_506 VDD VSS sg13g2_decap_8
XFILLER_12_854 VDD VSS sg13g2_decap_8
XFILLER_145_1284 VDD VSS sg13g2_fill_1
XFILLER_62_98 VDD VSS sg13g2_decap_8
XFILLER_50_1009 VDD VSS sg13g2_fill_1
XFILLER_129_528 VDD VSS sg13g2_decap_8
XFILLER_169_697 VDD VSS sg13g2_decap_8
X_14311_ _14311_/Q _14735_/CLK _14311_/D _14311_/RESET_B VDD VSS sg13g2_dfrbpq_1
XFILLER_129_539 VDD VSS sg13g2_fill_2
X_11523_ _11566_/A _11526_/A _11724_/B VDD VSS sg13g2_nor2_1
XFILLER_11_364 VDD VSS sg13g2_decap_8
XFILLER_168_196 VDD VSS sg13g2_decap_8
XFILLER_8_847 VDD VSS sg13g2_decap_8
X_14103__2076 _14103_/RESET_B VDD VSS sg13g2_tiehi
XFILLER_7_49 VDD VSS sg13g2_decap_8
X_14242_ _14242_/Q _14745_/CLK _14242_/D _14242_/RESET_B VDD VSS sg13g2_dfrbpq_1
XFILLER_109_241 VDD VSS sg13g2_fill_1
X_11454_ _11457_/B _11454_/A _13688_/Q VDD VSS sg13g2_nand2_1
XFILLER_7_357 VDD VSS sg13g2_decap_8
XFILLER_172_829 VDD VSS sg13g2_decap_4
XFILLER_171_306 VDD VSS sg13g2_decap_8
XFILLER_109_274 VDD VSS sg13g2_decap_8
XFILLER_124_200 VDD VSS sg13g2_decap_4
X_10405_ _10406_/A _14823_/Q _14824_/Q _10414_/B _10414_/C VDD VSS sg13g2_and4_1
X_14173_ _14173_/Q clkload47/A _14173_/D _14173_/RESET_B VDD VSS sg13g2_dfrbpq_1
X_11385_ _11385_/Y _11385_/A _11385_/B VDD VSS sg13g2_xnor2_1
XFILLER_124_233 VDD VSS sg13g2_decap_8
X_13124_ _13124_/Y _13121_/Y _13122_/Y _13123_/Y VDD VSS sg13g2_a21oi_1
X_14987__2600 _14987_/RESET_B VDD VSS sg13g2_tiehi
XFILLER_11_91 VDD VSS sg13g2_decap_8
X_10336_ _10337_/B _14803_/Q _14804_/Q _14805_/Q _10336_/D VDD VSS sg13g2_nand4_1
XFILLER_139_1077 VDD VSS sg13g2_decap_4
XFILLER_3_574 VDD VSS sg13g2_decap_8
XFILLER_26_1203 VDD VSS sg13g2_decap_8
X_13055_ _13055_/Y _13253_/B2 _13050_/X _13054_/Y VDD VSS sg13g2_a21oi_1
X_10267_ _10269_/A _14783_/Q _10262_/Y _14784_/Q VDD VSS sg13g2_a21o_1
XFILLER_152_1211 VDD VSS sg13g2_decap_8
XFILLER_65_1263 VDD VSS sg13g2_decap_8
Xfanout1320 _11821_/S0 _11358_/S0 VDD VSS sg13g2_buf_1
X_12006_ _14979_/D _12006_/A _12006_/B VDD VSS sg13g2_nand2_1
XFILLER_39_707 VDD VSS sg13g2_decap_4
Xfanout1331 _11217_/S _11212_/S VDD VSS sg13g2_buf_1
XFILLER_23_7 VDD VSS sg13g2_decap_8
Xfanout1342 _12330_/S0 _11275_/S0 VDD VSS sg13g2_buf_1
X_10198_ _14756_/D _15199_/D _14756_/Q _13502_/A VDD VSS sg13g2_mux2_1
XFILLER_66_504 VDD VSS sg13g2_fill_1
XFILLER_113_1217 VDD VSS sg13g2_decap_8
Xfanout1353 _12168_/A _12017_/A VDD VSS sg13g2_buf_1
Xfanout1364 _11493_/S0 _11469_/S0 VDD VSS sg13g2_buf_1
XFILLER_152_1288 VDD VSS sg13g2_decap_8
Xfanout1375 _10667_/A _10490_/A VDD VSS sg13g2_buf_1
XFILLER_38_228 VDD VSS sg13g2_fill_1
Xfanout1386 _13507_/A _13021_/A VDD VSS sg13g2_buf_1
XFILLER_8_1190 VDD VSS sg13g2_decap_8
XFILLER_19_420 VDD VSS sg13g2_decap_8
Xfanout1397 _10441_/C _13499_/B VDD VSS sg13g2_buf_1
XFILLER_143_90 VDD VSS sg13g2_fill_2
XFILLER_4_1043 VDD VSS sg13g2_decap_8
XFILLER_47_751 VDD VSS sg13g2_decap_4
X_13957_ _13957_/Q clkload5/A _13957_/D _13957_/RESET_B VDD VSS sg13g2_dfrbpq_1
XFILLER_74_581 VDD VSS sg13g2_decap_8
X_12908_ _12910_/A _12925_/A _12925_/B _12909_/C VDD VSS sg13g2_a21oi_1
XFILLER_19_497 VDD VSS sg13g2_decap_8
X_13888_ _13888_/Q _14721_/CLK _13888_/D _13888_/RESET_B VDD VSS sg13g2_dfrbpq_1
XFILLER_146_1037 VDD VSS sg13g2_fill_2
X_14313__1866 _14313_/RESET_B VDD VSS sg13g2_tiehi
XFILLER_146_1048 VDD VSS sg13g2_decap_8
X_12839_ _12840_/B _12836_/Y _12838_/Y _12828_/Y _12870_/A2 _12832_/Y VDD VSS sg13g2_a221oi_1
XFILLER_62_787 VDD VSS sg13g2_decap_8
XFILLER_50_949 VDD VSS sg13g2_decap_8
XFILLER_37_1343 VDD VSS sg13g2_decap_8
XFILLER_72_1245 VDD VSS sg13g2_decap_8
XFILLER_124_1324 VDD VSS sg13g2_fill_1
X_14509_ _14509_/Q clkload10/A _14509_/D _14509_/RESET_B VDD VSS sg13g2_dfrbpq_1
XFILLER_124_1368 VDD VSS sg13g2_fill_1
XFILLER_159_196 VDD VSS sg13g2_decap_4
X_13878__2301 _13878_/RESET_B VDD VSS sg13g2_tiehi
X_08030_ _08030_/Y _08329_/B _08599_/B VDD VSS sg13g2_nand2_1
XFILLER_174_144 VDD VSS sg13g2_decap_8
Xinput30 input30/X input30/A VDD VSS sg13g2_buf_1
XFILLER_174_155 VDD VSS sg13g2_decap_8
XFILLER_162_306 VDD VSS sg13g2_decap_8
XFILLER_116_734 VDD VSS sg13g2_decap_4
XFILLER_128_594 VDD VSS sg13g2_decap_4
XFILLER_115_233 VDD VSS sg13g2_decap_8
X_14782__2931 _14782_/RESET_B VDD VSS sg13g2_tiehi
XFILLER_171_873 VDD VSS sg13g2_decap_8
XFILLER_170_350 VDD VSS sg13g2_decap_8
X_09981_ _14564_/D _10047_/A0 _14564_/Q _09999_/S VDD VSS sg13g2_mux2_1
XFILLER_171_884 VDD VSS sg13g2_fill_1
XFILLER_157_1188 VDD VSS sg13g2_decap_8
X_08932_ _13716_/D _16878_/A _08931_/X _08932_/S VDD VSS sg13g2_mux2_1
X_13801__2378 _13801_/RESET_B VDD VSS sg13g2_tiehi
XFILLER_112_973 VDD VSS sg13g2_decap_8
XFILLER_170_1355 VDD VSS sg13g2_decap_8
X_08863_ _08863_/X _08862_/X _14965_/Q _08891_/S VDD VSS sg13g2_mux2_1
XFILLER_112_984 VDD VSS sg13g2_fill_2
XFILLER_97_684 VDD VSS sg13g2_decap_8
XFILLER_29_217 VDD VSS sg13g2_decap_8
XFILLER_69_386 VDD VSS sg13g2_decap_8
X_07814_ _08567_/B _08522_/A _08548_/B VDD VSS sg13g2_nand2_1
XFILLER_84_334 VDD VSS sg13g2_fill_1
XFILLER_57_548 VDD VSS sg13g2_fill_1
XFILLER_123_49 VDD VSS sg13g2_decap_8
X_08794_ _08796_/A _13345_/B _14756_/Q _08727_/X _15199_/Q _13490_/B VDD VSS sg13g2_a221oi_1
XFILLER_85_868 VDD VSS sg13g2_decap_8
X_07745_ _15208_/D _07741_/Y _07746_/C _07740_/Y VDD VSS sg13g2_o21ai_1
XFILLER_84_378 VDD VSS sg13g2_decap_8
XFILLER_26_913 VDD VSS sg13g2_decap_8
XFILLER_26_924 VDD VSS sg13g2_fill_2
XFILLER_16_14 VDD VSS sg13g2_decap_8
XFILLER_129_1202 VDD VSS sg13g2_decap_8
XFILLER_129_1213 VDD VSS sg13g2_fill_1
X_07676_ _07721_/A _15079_/Q _15082_/Q _15080_/Q VDD VSS sg13g2_nor3_1
XFILLER_77_1156 VDD VSS sg13g2_decap_8
XFILLER_26_979 VDD VSS sg13g2_decap_8
X_09415_ _14017_/D _09448_/A0 _14017_/Q _09436_/S VDD VSS sg13g2_mux2_1
XFILLER_53_776 VDD VSS sg13g2_decap_8
XFILLER_52_253 VDD VSS sg13g2_decap_4
XFILLER_129_1257 VDD VSS sg13g2_fill_2
XFILLER_53_798 VDD VSS sg13g2_decap_8
XFILLER_164_1159 VDD VSS sg13g2_decap_8
XFILLER_80_584 VDD VSS sg13g2_decap_8
X_09346_ _13950_/D _09610_/A0 _13950_/Q _09368_/S VDD VSS sg13g2_mux2_1
XFILLER_51_1318 VDD VSS sg13g2_fill_1
XFILLER_21_651 VDD VSS sg13g2_decap_8
XFILLER_32_35 VDD VSS sg13g2_decap_8
X_09277_ _13885_/D _13885_/Q _09310_/A0 _09292_/S VDD VSS sg13g2_mux2_1
XFILLER_20_161 VDD VSS sg13g2_decap_8
XFILLER_148_35 VDD VSS sg13g2_decap_8
XFILLER_165_133 VDD VSS sg13g2_decap_8
X_14468__1711 _14468_/RESET_B VDD VSS sg13g2_tiehi
X_08228_ _08229_/A _07909_/Y _07921_/Y _07889_/A VDD VSS sg13g2_o21ai_1
XFILLER_14_1162 VDD VSS sg13g2_decap_8
XFILLER_153_306 VDD VSS sg13g2_decap_8
XFILLER_10_1015 VDD VSS sg13g2_decap_8
XFILLER_101_1154 VDD VSS sg13g2_decap_8
X_08159_ _08166_/B _08158_/X _08397_/A _08246_/A1 _08150_/X VDD VSS sg13g2_a22oi_1
XFILLER_107_756 VDD VSS sg13g2_decap_8
XFILLER_134_553 VDD VSS sg13g2_decap_8
X_11170_ _11170_/Y _11170_/A _11170_/B VDD VSS sg13g2_nand2_1
XFILLER_164_56 VDD VSS sg13g2_decap_8
X_10121_ _14699_/D _10121_/A0 _14699_/Q _10127_/S VDD VSS sg13g2_mux2_1
XFILLER_0_511 VDD VSS sg13g2_decap_8
XFILLER_161_394 VDD VSS sg13g2_decap_8
X_15182__2839 _15182_/RESET_B VDD VSS sg13g2_tiehi
XFILLER_79_139 VDD VSS sg13g2_decap_8
X_10052_ _14633_/D _10085_/A0 _14633_/Q _10064_/S VDD VSS sg13g2_mux2_1
XFILLER_57_21 VDD VSS sg13g2_decap_8
XFILLER_0_588 VDD VSS sg13g2_decap_8
XFILLER_88_684 VDD VSS sg13g2_decap_4
XFILLER_102_472 VDD VSS sg13g2_fill_1
X_14860_ _14860_/Q clkload49/A _14860_/D _14860_/RESET_B VDD VSS sg13g2_dfrbpq_1
XFILLER_5_1330 VDD VSS sg13g2_decap_8
XFILLER_169_1004 VDD VSS sg13g2_decap_8
XFILLER_87_194 VDD VSS sg13g2_decap_8
XFILLER_76_879 VDD VSS sg13g2_fill_1
X_13811_ _13811_/Q clkload24/A _13811_/D _13811_/RESET_B VDD VSS sg13g2_dfrbpq_1
XFILLER_5_1374 VDD VSS sg13g2_fill_1
XFILLER_169_1048 VDD VSS sg13g2_fill_1
X_14791_ _14791_/Q _14894_/CLK _14791_/D _14791_/RESET_B VDD VSS sg13g2_dfrbpq_1
XFILLER_90_304 VDD VSS sg13g2_decap_8
XFILLER_169_1059 VDD VSS sg13g2_decap_4
X_14570__1609 _14570_/RESET_B VDD VSS sg13g2_tiehi
XFILLER_90_315 VDD VSS sg13g2_fill_1
XFILLER_21_1155 VDD VSS sg13g2_decap_8
XFILLER_17_924 VDD VSS sg13g2_decap_8
XFILLER_113_60 VDD VSS sg13g2_fill_2
X_13956__2223 _13956_/RESET_B VDD VSS sg13g2_tiehi
XFILLER_56_581 VDD VSS sg13g2_fill_1
X_13742_ _13742_/Q clkload37/A _13742_/D _13742_/RESET_B VDD VSS sg13g2_dfrbpq_1
XFILLER_16_434 VDD VSS sg13g2_decap_8
X_10954_ _10967_/A _10954_/A _10954_/B _10954_/C _10954_/D VDD VSS sg13g2_nor4_1
XFILLER_73_42 VDD VSS sg13g2_fill_1
XFILLER_95_1256 VDD VSS sg13g2_fill_1
XFILLER_44_754 VDD VSS sg13g2_decap_4
XFILLER_73_53 VDD VSS sg13g2_decap_8
XFILLER_56_1218 VDD VSS sg13g2_decap_8
X_13673_ _13673_/Q clkload64/A _13673_/D _13673_/RESET_B VDD VSS sg13g2_dfrbpq_1
XFILLER_43_264 VDD VSS sg13g2_decap_8
XFILLER_108_1319 VDD VSS sg13g2_decap_8
X_10885_ _10885_/Y _10898_/B1 _10883_/X _10884_/Y VDD VSS sg13g2_a21oi_1
X_12624_ _12625_/B _13674_/Q _12721_/A2 _12623_/X _12679_/B2 _12624_/C1 VDD VSS sg13g2_a221oi_1
X_15058__2501 _15058_/RESET_B VDD VSS sg13g2_tiehi
XFILLER_31_448 VDD VSS sg13g2_fill_2
XFILLER_12_651 VDD VSS sg13g2_decap_8
XFILLER_145_1081 VDD VSS sg13g2_decap_8
XFILLER_106_1043 VDD VSS sg13g2_fill_2
XFILLER_169_483 VDD VSS sg13g2_decap_8
X_12555_ _15003_/D _12555_/A _12555_/B VDD VSS sg13g2_nor2_1
XFILLER_11_161 VDD VSS sg13g2_decap_8
XFILLER_156_133 VDD VSS sg13g2_decap_8
XFILLER_8_644 VDD VSS sg13g2_decap_8
XFILLER_145_818 VDD VSS sg13g2_decap_8
X_11506_ _11506_/Y _11636_/A _11506_/B VDD VSS sg13g2_xnor2_1
X_12486_ _12499_/A _12653_/A1 _07737_/B _14999_/Q VDD VSS sg13g2_a21oi_1
XFILLER_7_154 VDD VSS sg13g2_decap_8
XFILLER_138_892 VDD VSS sg13g2_fill_2
X_14225_ _14225_/Q _14667_/CLK _14225_/D _14225_/RESET_B VDD VSS sg13g2_dfrbpq_1
X_11437_ _11445_/C _11436_/X _12188_/C VDD VSS sg13g2_nand2b_1
XFILLER_32_1295 VDD VSS sg13g2_decap_8
XFILLER_137_391 VDD VSS sg13g2_decap_8
XFILLER_171_147 VDD VSS sg13g2_decap_8
XFILLER_67_1325 VDD VSS sg13g2_decap_8
X_14156_ _14156_/Q clkload13/A _14156_/D _14156_/RESET_B VDD VSS sg13g2_dfrbpq_1
XFILLER_99_927 VDD VSS sg13g2_decap_8
XFILLER_4_861 VDD VSS sg13g2_decap_8
XFILLER_113_715 VDD VSS sg13g2_decap_8
X_14936__2672 _14936_/RESET_B VDD VSS sg13g2_tiehi
X_11368_ _11368_/X _14238_/Q _14270_/Q _14302_/Q _14334_/Q _11373_/A _11366_/C VDD
+ VSS sg13g2_mux4_1
XFILLER_112_203 VDD VSS sg13g2_fill_1
X_13107_ _13107_/Y _14818_/Q _13068_/B _13162_/B1 _14882_/Q _13082_/B VDD VSS sg13g2_a221oi_1
XFILLER_3_371 VDD VSS sg13g2_decap_8
XFILLER_112_225 VDD VSS sg13g2_decap_4
X_10319_ _14799_/D _10572_/B _10319_/B _10319_/C VDD VSS sg13g2_nor3_1
XFILLER_113_759 VDD VSS sg13g2_fill_1
X_14087_ _14087_/Q _14607_/CLK _14087_/D _14087_/RESET_B VDD VSS sg13g2_dfrbpq_1
XFILLER_26_1000 VDD VSS sg13g2_decap_8
X_11299_ _11299_/Y _11295_/Y _11296_/Y _11298_/Y _11297_/Y _11329_/B1 VDD VSS sg13g2_a221oi_1
XFILLER_140_578 VDD VSS sg13g2_decap_8
XFILLER_152_1030 VDD VSS sg13g2_fill_1
X_13038_ _13057_/B _14909_/Q _13678_/Q VDD VSS sg13g2_or2_1
XFILLER_85_109 VDD VSS sg13g2_decap_8
XFILLER_117_1172 VDD VSS sg13g2_decap_8
XFILLER_79_684 VDD VSS sg13g2_fill_1
XFILLER_6_1127 VDD VSS sg13g2_decap_8
XFILLER_113_1014 VDD VSS sg13g2_decap_8
Xfanout1150 _08258_/C _08867_/A1 VDD VSS sg13g2_buf_1
XFILLER_121_792 VDD VSS sg13g2_decap_4
XFILLER_152_1074 VDD VSS sg13g2_decap_8
XFILLER_67_846 VDD VSS sg13g2_decap_8
XFILLER_26_1077 VDD VSS sg13g2_decap_8
Xfanout1161 _07910_/B _14962_/Q VDD VSS sg13g2_buf_1
Xfanout1172 _12884_/C _12900_/C VDD VSS sg13g2_buf_1
Xfanout1183 _13189_/A _14918_/Q VDD VSS sg13g2_buf_1
Xfanout1194 _10651_/D _14881_/Q VDD VSS sg13g2_buf_1
XFILLER_43_1380 VDD VSS sg13g2_decap_4
XFILLER_82_827 VDD VSS sg13g2_fill_2
X_14989_ _14989_/Q _15226_/CLK _14989_/D _14989_/RESET_B VDD VSS sg13g2_dfrbpq_1
XFILLER_47_570 VDD VSS sg13g2_decap_8
XFILLER_130_1383 VDD VSS sg13g2_fill_1
X_14546__1633 _14546_/RESET_B VDD VSS sg13g2_tiehi
XFILLER_34_220 VDD VSS sg13g2_decap_8
XFILLER_19_294 VDD VSS sg13g2_decap_8
X_15114__2731 _15114_/RESET_B VDD VSS sg13g2_tiehi
XFILLER_62_562 VDD VSS sg13g2_fill_2
XFILLER_50_713 VDD VSS sg13g2_fill_1
X_09200_ _13816_/D _13816_/Q _10167_/A1 _09200_/S VDD VSS sg13g2_mux2_1
XFILLER_97_0 VDD VSS sg13g2_decap_8
XFILLER_22_448 VDD VSS sg13g2_decap_8
XFILLER_128_1290 VDD VSS sg13g2_decap_8
XFILLER_72_1053 VDD VSS sg13g2_decap_8
XFILLER_37_1173 VDD VSS sg13g2_decap_4
XFILLER_147_100 VDD VSS sg13g2_fill_2
XFILLER_148_623 VDD VSS sg13g2_fill_2
X_09131_ _09131_/X _09137_/A _10772_/A _09130_/Y VDD VSS sg13g2_a21o_1
XFILLER_124_1143 VDD VSS sg13g2_decap_8
X_09062_ _09062_/Y _13064_/A _09089_/C _09061_/Y VDD VSS sg13g2_a21oi_1
XFILLER_8_70 VDD VSS sg13g2_decap_8
XFILLER_11_1302 VDD VSS sg13g2_decap_8
XFILLER_120_1029 VDD VSS sg13g2_decap_8
X_08013_ _08013_/X _07861_/B _07859_/B _07853_/B _08012_/B _08046_/B _08669_/B1 VDD
+ VSS sg13g2_mux4_1
XFILLER_118_49 VDD VSS sg13g2_decap_4
XFILLER_162_147 VDD VSS sg13g2_decap_8
XFILLER_11_1379 VDD VSS sg13g2_decap_4
XFILLER_116_564 VDD VSS sg13g2_fill_2
XFILLER_144_873 VDD VSS sg13g2_decap_8
XFILLER_1_308 VDD VSS sg13g2_decap_8
XFILLER_131_523 VDD VSS sg13g2_fill_1
XFILLER_171_692 VDD VSS sg13g2_decap_8
X_09964_ _14548_/D _14548_/Q _10096_/A0 _09968_/S VDD VSS sg13g2_mux2_1
XFILLER_103_247 VDD VSS sg13g2_decap_4
XFILLER_98_960 VDD VSS sg13g2_fill_2
XFILLER_83_1171 VDD VSS sg13g2_decap_8
XFILLER_170_1130 VDD VSS sg13g2_decap_8
X_08915_ _08915_/Y _11914_/A _08955_/S _08914_/Y VDD VSS sg13g2_a21oi_1
XFILLER_98_971 VDD VSS sg13g2_decap_8
XFILLER_135_1261 VDD VSS sg13g2_decap_4
X_09895_ _14481_/D _09928_/A1 _14481_/Q _09895_/S VDD VSS sg13g2_mux2_1
XFILLER_58_824 VDD VSS sg13g2_decap_8
XFILLER_131_1125 VDD VSS sg13g2_decap_8
XFILLER_97_492 VDD VSS sg13g2_fill_2
X_08846_ _08846_/Y _08860_/S _08845_/Y _08843_/Y VDD VSS sg13g2_o21ai_1
XFILLER_69_194 VDD VSS sg13g2_fill_2
XFILLER_170_1196 VDD VSS sg13g2_fill_1
XFILLER_79_1207 VDD VSS sg13g2_fill_1
XFILLER_73_805 VDD VSS sg13g2_decap_8
XFILLER_131_1158 VDD VSS sg13g2_decap_8
XFILLER_84_142 VDD VSS sg13g2_fill_1
X_14185__1994 _14185_/RESET_B VDD VSS sg13g2_tiehi
XFILLER_27_35 VDD VSS sg13g2_decap_8
XFILLER_150_14 VDD VSS sg13g2_decap_8
X_08777_ _13677_/D _08728_/Y _08776_/Y _08775_/Y VDD VSS sg13g2_a21oi_1
XFILLER_72_315 VDD VSS sg13g2_fill_1
XFILLER_38_570 VDD VSS sg13g2_fill_2
X_07728_ _07728_/X _07729_/B _07728_/B _07729_/D VDD VSS sg13g2_or3_1
XFILLER_25_231 VDD VSS sg13g2_decap_8
XFILLER_129_1021 VDD VSS sg13g2_decap_8
XFILLER_168_1070 VDD VSS sg13g2_decap_8
XFILLER_81_860 VDD VSS sg13g2_decap_8
XFILLER_168_1081 VDD VSS sg13g2_fill_1
XFILLER_26_787 VDD VSS sg13g2_decap_8
XFILLER_14_938 VDD VSS sg13g2_decap_8
X_07659_ wire504/A _14763_/Q _07658_/X VDD VSS sg13g2_nor2b_1
XFILLER_53_584 VDD VSS sg13g2_decap_8
XFILLER_25_275 VDD VSS sg13g2_fill_1
XFILLER_40_212 VDD VSS sg13g2_decap_8
XFILLER_25_286 VDD VSS sg13g2_decap_8
XFILLER_129_1076 VDD VSS sg13g2_decap_4
XFILLER_13_448 VDD VSS sg13g2_decap_8
X_10670_ _10670_/Y _13304_/B _13324_/A VDD VSS sg13g2_nor2_1
XFILLER_43_56 VDD VSS sg13g2_decap_8
XFILLER_142_1221 VDD VSS sg13g2_decap_4
XFILLER_159_56 VDD VSS sg13g2_decap_8
X_09329_ _13936_/D _10092_/A0 _13936_/Q _09330_/S VDD VSS sg13g2_mux2_1
XFILLER_90_1164 VDD VSS sg13g2_decap_4
XFILLER_166_420 VDD VSS sg13g2_decap_8
XFILLER_16_1246 VDD VSS sg13g2_decap_8
XFILLER_51_1137 VDD VSS sg13g2_decap_8
XFILLER_167_965 VDD VSS sg13g2_decap_8
X_12340_ _12340_/Y _12340_/A VDD VSS sg13g2_inv_1
XFILLER_103_1238 VDD VSS sg13g2_decap_4
XFILLER_138_155 VDD VSS sg13g2_decap_4
XFILLER_103_1249 VDD VSS sg13g2_decap_4
XFILLER_126_317 VDD VSS sg13g2_decap_8
XFILLER_126_328 VDD VSS sg13g2_fill_1
XFILLER_154_637 VDD VSS sg13g2_decap_4
XFILLER_166_497 VDD VSS sg13g2_decap_8
XFILLER_126_339 VDD VSS sg13g2_decap_8
X_12271_ _12297_/A _12271_/A _12278_/A VDD VSS sg13g2_nand2_1
XFILLER_107_542 VDD VSS sg13g2_fill_1
XFILLER_135_851 VDD VSS sg13g2_decap_4
XFILLER_5_658 VDD VSS sg13g2_decap_8
X_14010_ _14010_/Q _14734_/CLK _14010_/D _14010_/RESET_B VDD VSS sg13g2_dfrbpq_1
X_11222_ _11223_/C _12092_/C _11222_/B VDD VSS sg13g2_nor2_1
XFILLER_4_168 VDD VSS sg13g2_decap_8
XFILLER_4_28 VDD VSS sg13g2_decap_8
X_14624__1555 _14624_/RESET_B VDD VSS sg13g2_tiehi
X_11153_ _11153_/Y _11152_/Y _11151_/A _11151_/Y _11150_/Y _11207_/A2 VDD VSS sg13g2_a221oi_1
XFILLER_68_42 VDD VSS sg13g2_decap_8
XFILLER_27_1320 VDD VSS sg13g2_decap_8
X_10104_ _14683_/D _10104_/A0 _14683_/Q _10136_/S VDD VSS sg13g2_mux2_1
XFILLER_62_1222 VDD VSS sg13g2_decap_8
X_11084_ _11084_/Y _14948_/Q _11133_/B VDD VSS sg13g2_nand2_1
XFILLER_1_875 VDD VSS sg13g2_decap_8
XFILLER_68_86 VDD VSS sg13g2_decap_8
XFILLER_0_385 VDD VSS sg13g2_decap_8
XFILLER_103_792 VDD VSS sg13g2_decap_4
X_14912_ _14912_/Q clkload43/A _14912_/D _14912_/RESET_B VDD VSS sg13g2_dfrbpq_1
X_10035_ _14617_/D _10101_/A0 _14617_/Q _10035_/S VDD VSS sg13g2_mux2_1
XFILLER_88_492 VDD VSS sg13g2_decap_8
XFILLER_62_1266 VDD VSS sg13g2_fill_1
XFILLER_49_857 VDD VSS sg13g2_decap_8
XFILLER_76_665 VDD VSS sg13g2_fill_1
XFILLER_48_356 VDD VSS sg13g2_decap_8
XFILLER_124_81 VDD VSS sg13g2_fill_1
X_14843_ _14843_/Q _14854_/CLK _14843_/D _14843_/RESET_B VDD VSS sg13g2_dfrbpq_1
XFILLER_76_687 VDD VSS sg13g2_fill_2
XFILLER_75_175 VDD VSS sg13g2_fill_2
XFILLER_29_570 VDD VSS sg13g2_fill_1
XFILLER_57_890 VDD VSS sg13g2_decap_8
XFILLER_17_721 VDD VSS sg13g2_decap_8
X_14774_ _14774_/Q _14867_/CLK _14774_/D _14774_/RESET_B VDD VSS sg13g2_dfrbpq_1
XFILLER_16_231 VDD VSS sg13g2_decap_8
X_11986_ _11986_/Y _11986_/A _11986_/B VDD VSS sg13g2_nor2_1
XFILLER_1_1057 VDD VSS sg13g2_decap_8
XFILLER_90_156 VDD VSS sg13g2_decap_8
X_13725_ _13725_/Q _14653_/CLK _13725_/D _13725_/RESET_B VDD VSS sg13g2_dfrbpq_1
X_10937_ _10937_/Y _10954_/B _10937_/B VDD VSS sg13g2_xnor2_1
XFILLER_17_798 VDD VSS sg13g2_decap_8
XFILLER_95_1097 VDD VSS sg13g2_fill_2
XFILLER_32_757 VDD VSS sg13g2_decap_8
XFILLER_31_223 VDD VSS sg13g2_decap_8
X_13656_ _15122_/D _15192_/D _15122_/Q _13656_/S VDD VSS sg13g2_mux2_1
XFILLER_90_7 VDD VSS sg13g2_decap_8
XFILLER_31_234 VDD VSS sg13g2_fill_1
X_10868_ _10869_/B _10890_/A _10890_/B _10868_/C VDD VSS sg13g2_nor3_1
XFILLER_31_245 VDD VSS sg13g2_decap_8
XFILLER_158_921 VDD VSS sg13g2_fill_2
X_12607_ _12607_/X _12600_/X _12604_/X _12599_/X _12603_/X _12663_/S0 _12608_/S1 VDD
+ VSS sg13g2_mux4_1
XFILLER_160_1332 VDD VSS sg13g2_fill_1
XFILLER_169_280 VDD VSS sg13g2_decap_8
XFILLER_9_931 VDD VSS sg13g2_decap_8
XFILLER_157_431 VDD VSS sg13g2_decap_4
X_13587_ _13587_/Y _13587_/A _13593_/B VDD VSS sg13g2_nor2_1
XFILLER_34_1346 VDD VSS sg13g2_decap_8
X_10799_ _14926_/D _13279_/D _10798_/X _10796_/Y VDD VSS sg13g2_o21ai_1
XFILLER_158_976 VDD VSS sg13g2_decap_8
XFILLER_118_818 VDD VSS sg13g2_decap_4
XFILLER_129_144 VDD VSS sg13g2_decap_8
XFILLER_8_441 VDD VSS sg13g2_decap_8
X_12538_ _12538_/X _12536_/X _12535_/X _12532_/X _12531_/X _12761_/S0 _12664_/S VDD
+ VSS sg13g2_mux4_1
XFILLER_145_615 VDD VSS sg13g2_decap_8
X_15064__2951 _15064_/RESET_B VDD VSS sg13g2_tiehi
X_12469_ _12469_/X _12467_/X _12468_/X _12553_/S VDD VSS sg13g2_mux2_1
X_15143__2671 _15143_/RESET_B VDD VSS sg13g2_tiehi
XFILLER_172_456 VDD VSS sg13g2_decap_8
X_14208_ _14208_/Q clkload30/A _14208_/D _14208_/RESET_B VDD VSS sg13g2_dfrbpq_1
XFILLER_160_618 VDD VSS sg13g2_decap_8
XFILLER_126_884 VDD VSS sg13g2_decap_8
X_15188_ _15188_/Q _15188_/CLK _15188_/D _15188_/RESET_B VDD VSS sg13g2_dfrbpq_1
XFILLER_141_821 VDD VSS sg13g2_fill_2
XFILLER_153_681 VDD VSS sg13g2_decap_4
X_14139_ _14139_/Q _14653_/CLK _14139_/D _14139_/RESET_B VDD VSS sg13g2_dfrbpq_1
XFILLER_99_757 VDD VSS sg13g2_decap_8
Xfanout409 _12721_/B2 _12415_/A VDD VSS sg13g2_buf_1
XFILLER_63_1019 VDD VSS sg13g2_decap_8
XFILLER_140_331 VDD VSS sg13g2_decap_8
XFILLER_98_245 VDD VSS sg13g2_decap_8
XFILLER_67_1199 VDD VSS sg13g2_decap_4
XFILLER_141_876 VDD VSS sg13g2_decap_8
XFILLER_86_429 VDD VSS sg13g2_decap_8
X_13682__2508 _13682_/RESET_B VDD VSS sg13g2_tiehi
X_08700_ _08700_/Y _08698_/X _08697_/Y _08695_/Y _08696_/Y _07974_/D VDD VSS sg13g2_a221oi_1
XFILLER_41_1317 VDD VSS sg13g2_decap_4
X_09680_ _14272_/D _09911_/A1 _14272_/Q _09705_/S VDD VSS sg13g2_mux2_1
XFILLER_66_120 VDD VSS sg13g2_fill_2
XFILLER_12_0 VDD VSS sg13g2_decap_8
XFILLER_95_974 VDD VSS sg13g2_decap_8
XFILLER_67_665 VDD VSS sg13g2_decap_8
XFILLER_95_985 VDD VSS sg13g2_fill_1
XFILLER_27_507 VDD VSS sg13g2_fill_1
X_08631_ _08631_/Y _08641_/A _08630_/Y _08667_/A1 VDD VSS sg13g2_a21oi_1
XFILLER_54_304 VDD VSS sg13g2_decap_8
XFILLER_130_1180 VDD VSS sg13g2_fill_2
X_08562_ _08562_/Y _08030_/Y _08488_/B _08561_/Y VDD VSS sg13g2_o21ai_1
X_14062__2117 _14062_/RESET_B VDD VSS sg13g2_tiehi
XFILLER_81_145 VDD VSS sg13g2_decap_8
XFILLER_120_28 VDD VSS sg13g2_decap_8
XFILLER_165_1232 VDD VSS sg13g2_decap_8
XFILLER_23_713 VDD VSS sg13g2_fill_2
X_08493_ _08494_/B _15008_/Q _08471_/B _07805_/B _08493_/B2 VDD VSS sg13g2_a22oi_1
XFILLER_165_1254 VDD VSS sg13g2_decap_8
XFILLER_168_707 VDD VSS sg13g2_fill_1
XFILLER_22_245 VDD VSS sg13g2_decap_8
XFILLER_167_217 VDD VSS sg13g2_decap_8
X_14702__1477 _14702_/RESET_B VDD VSS sg13g2_tiehi
XFILLER_149_943 VDD VSS sg13g2_decap_8
X_09114_ _10762_/B _09140_/S _15045_/Q _09113_/Y VDD VSS sg13g2_o21ai_1
XFILLER_149_998 VDD VSS sg13g2_fill_1
XFILLER_159_1003 VDD VSS sg13g2_decap_4
XFILLER_135_114 VDD VSS sg13g2_decap_8
XFILLER_108_339 VDD VSS sg13g2_fill_1
XFILLER_163_434 VDD VSS sg13g2_decap_8
X_09045_ _09045_/Y _09024_/A _10716_/B _09044_/X VDD VSS sg13g2_o21ai_1
XFILLER_159_1036 VDD VSS sg13g2_decap_4
XFILLER_102_1282 VDD VSS sg13g2_decap_8
XFILLER_135_169 VDD VSS sg13g2_decap_8
XFILLER_11_1176 VDD VSS sg13g2_decap_8
XFILLER_145_14 VDD VSS sg13g2_decap_8
XFILLER_1_105 VDD VSS sg13g2_decap_8
XFILLER_131_331 VDD VSS sg13g2_fill_1
XFILLER_85_1288 VDD VSS sg13g2_decap_8
XFILLER_46_1239 VDD VSS sg13g2_decap_8
Xfanout910 _13308_/A _13238_/B2 VDD VSS sg13g2_buf_1
Xfanout921 _13566_/B _13552_/B VDD VSS sg13g2_buf_1
Xfanout932 _13448_/B _15200_/Q VDD VSS sg13g2_buf_1
X_09947_ _14531_/D _14531_/Q _10079_/A0 _09969_/S VDD VSS sg13g2_mux2_1
XFILLER_77_418 VDD VSS sg13g2_decap_8
Xfanout943 _13506_/A _15128_/Q VDD VSS sg13g2_buf_1
X_14272__1907 _14272_/RESET_B VDD VSS sg13g2_tiehi
Xfanout954 _07727_/B _15107_/Q VDD VSS sg13g2_buf_1
Xfanout965 _08663_/B _08497_/A VDD VSS sg13g2_buf_1
Xfanout976 _10983_/A1 _10898_/B1 VDD VSS sg13g2_buf_1
Xfanout987 _08754_/A2 _13342_/A1 VDD VSS sg13g2_buf_1
X_09878_ _14464_/D _09911_/A1 _14464_/Q _09903_/S VDD VSS sg13g2_mux2_1
XFILLER_38_56 VDD VSS sg13g2_decap_8
XFILLER_161_35 VDD VSS sg13g2_decap_8
Xfanout998 _09839_/C _15065_/Q VDD VSS sg13g2_buf_1
XFILLER_86_974 VDD VSS sg13g2_fill_1
XFILLER_46_805 VDD VSS sg13g2_fill_2
X_08829_ _08830_/C _15055_/Q _13283_/A _11241_/C VDD VSS sg13g2_nor3_1
XFILLER_18_518 VDD VSS sg13g2_decap_8
XFILLER_100_795 VDD VSS sg13g2_decap_8
XFILLER_22_1261 VDD VSS sg13g2_decap_8
X_11840_ _11907_/B _11770_/A _13064_/B _13676_/Q _11798_/A VDD VSS sg13g2_a22oi_1
XFILLER_73_657 VDD VSS sg13g2_decap_8
XFILLER_2_1344 VDD VSS sg13g2_decap_8
XFILLER_54_860 VDD VSS sg13g2_decap_8
XFILLER_26_551 VDD VSS sg13g2_fill_1
X_14038__2141 _14038_/RESET_B VDD VSS sg13g2_tiehi
X_11771_ _11771_/Y _11771_/A _11771_/B _11773_/C VDD VSS sg13g2_nor3_1
XFILLER_54_66 VDD VSS sg13g2_decap_8
XFILLER_26_584 VDD VSS sg13g2_decap_8
XFILLER_14_735 VDD VSS sg13g2_decap_8
XFILLER_26_595 VDD VSS sg13g2_fill_1
X_13510_ _15133_/D _15133_/Q _13510_/A1 _13519_/B VDD VSS sg13g2_mux2_1
XFILLER_53_392 VDD VSS sg13g2_decap_8
XFILLER_144_1327 VDD VSS sg13g2_fill_2
XFILLER_159_718 VDD VSS sg13g2_decap_8
X_10722_ _10722_/Y _10720_/A _10720_/B _08885_/Y VDD VSS sg13g2_o21ai_1
XFILLER_57_1379 VDD VSS sg13g2_decap_4
X_14490_ _14490_/Q clkload50/A _14490_/D _14490_/RESET_B VDD VSS sg13g2_dfrbpq_1
XFILLER_13_245 VDD VSS sg13g2_decap_8
XFILLER_158_228 VDD VSS sg13g2_decap_8
X_13441_ _15102_/D _13421_/Y _13438_/Y _13440_/Y VDD VSS sg13g2_o21ai_1
XFILLER_70_21 VDD VSS sg13g2_decap_4
XFILLER_41_587 VDD VSS sg13g2_fill_2
X_10653_ _10654_/B _10653_/A _10653_/B _10653_/C _10653_/D VDD VSS sg13g2_nand4_1
XFILLER_16_1043 VDD VSS sg13g2_decap_8
XFILLER_9_238 VDD VSS sg13g2_decap_8
XFILLER_22_790 VDD VSS sg13g2_decap_8
XFILLER_167_762 VDD VSS sg13g2_decap_8
XFILLER_155_913 VDD VSS sg13g2_decap_8
XFILLER_10_952 VDD VSS sg13g2_decap_8
X_13372_ _13372_/Y _13427_/A _13427_/B _15077_/Q VDD VSS sg13g2_nand3_1
X_13760__2419 _13760_/RESET_B VDD VSS sg13g2_tiehi
X_10584_ _10606_/A _14872_/Q _14871_/Q _10584_/C VDD VSS sg13g2_nand3_1
Xclkload19 clkload19/Y clkload19/A VDD VSS sg13g2_inv_1
XFILLER_142_1095 VDD VSS sg13g2_decap_8
X_15111_ _15111_/Q _15113_/CLK _15111_/D _15111_/RESET_B VDD VSS sg13g2_dfrbpq_1
XFILLER_154_434 VDD VSS sg13g2_decap_8
XFILLER_155_957 VDD VSS sg13g2_decap_8
X_12323_ _12324_/A _14266_/Q _14298_/Q _14330_/Q _14362_/Q _12306_/A _12307_/C VDD
+ VSS sg13g2_mux4_1
XFILLER_166_294 VDD VSS sg13g2_decap_8
XFILLER_6_945 VDD VSS sg13g2_decap_8
XFILLER_154_445 VDD VSS sg13g2_fill_2
XFILLER_86_1019 VDD VSS sg13g2_decap_8
XFILLER_108_851 VDD VSS sg13g2_decap_8
XFILLER_154_478 VDD VSS sg13g2_decap_8
X_15042_ _15042_/Q clkload50/A _15042_/D _15042_/RESET_B VDD VSS sg13g2_dfrbpq_1
XFILLER_5_455 VDD VSS sg13g2_decap_8
XFILLER_170_938 VDD VSS sg13g2_decap_8
X_12254_ _12254_/Y _12017_/A _13848_/Q VDD VSS sg13g2_nand2b_1
XFILLER_108_884 VDD VSS sg13g2_fill_1
XFILLER_79_52 VDD VSS sg13g2_decap_4
X_11205_ _11205_/X _11205_/A _11205_/B VDD VSS sg13g2_xor2_1
X_14140__2039 _14140_/RESET_B VDD VSS sg13g2_tiehi
X_12185_ _12187_/A _12186_/A _13910_/Q VDD VSS sg13g2_nand2b_1
X_15085__2823 _15085_/RESET_B VDD VSS sg13g2_tiehi
XFILLER_96_705 VDD VSS sg13g2_decap_8
X_11136_ _11136_/Y _11146_/B _11136_/B VDD VSS sg13g2_xnor2_1
XFILLER_95_204 VDD VSS sg13g2_fill_2
XFILLER_7_1211 VDD VSS sg13g2_decap_8
XFILLER_1_672 VDD VSS sg13g2_decap_8
XFILLER_77_930 VDD VSS sg13g2_fill_1
XFILLER_49_621 VDD VSS sg13g2_decap_8
XFILLER_77_941 VDD VSS sg13g2_fill_2
XFILLER_0_182 VDD VSS sg13g2_decap_8
XFILLER_153_1180 VDD VSS sg13g2_decap_8
X_14248__1931 _14248_/RESET_B VDD VSS sg13g2_tiehi
X_11067_ _11067_/Y _11118_/A _11088_/A _11066_/Y VDD VSS sg13g2_a21oi_1
XFILLER_49_654 VDD VSS sg13g2_decap_8
XFILLER_27_1194 VDD VSS sg13g2_decap_8
XFILLER_48_142 VDD VSS sg13g2_decap_8
XFILLER_95_84 VDD VSS sg13g2_decap_8
X_10018_ _14600_/D _10084_/A0 _14600_/Q _10027_/S VDD VSS sg13g2_mux2_1
XFILLER_7_1288 VDD VSS sg13g2_decap_8
XFILLER_64_613 VDD VSS sg13g2_decap_8
XFILLER_23_1069 VDD VSS sg13g2_decap_8
XFILLER_114_1197 VDD VSS sg13g2_fill_1
XFILLER_76_495 VDD VSS sg13g2_decap_8
XFILLER_48_197 VDD VSS sg13g2_decap_8
X_14826_ _14826_/Q _14890_/CLK _14826_/D _14826_/RESET_B VDD VSS sg13g2_dfrbpq_1
XFILLER_149_1227 VDD VSS sg13g2_decap_8
XFILLER_91_443 VDD VSS sg13g2_fill_1
XFILLER_92_999 VDD VSS sg13g2_decap_8
X_14757_ _14757_/Q clkload66/A _14757_/D _14757_/RESET_B VDD VSS sg13g2_dfrbpq_1
X_11969_ _11970_/B _11969_/A _13936_/Q VDD VSS sg13g2_nand2_1
XFILLER_17_595 VDD VSS sg13g2_decap_8
X_13708_ _16870_/A clkload43/A _13708_/D _13708_/RESET_B VDD VSS sg13g2_dfrbpq_1
X_14688_ _14688_/Q _14721_/CLK _14688_/D _14688_/RESET_B VDD VSS sg13g2_dfrbpq_1
XFILLER_149_217 VDD VSS sg13g2_decap_4
X_13639_ _13747_/D _13639_/A VDD VSS sg13g2_buf_1
XFILLER_73_1170 VDD VSS sg13g2_fill_1
XFILLER_158_740 VDD VSS sg13g2_decap_8
XFILLER_20_749 VDD VSS sg13g2_decap_8
XFILLER_158_773 VDD VSS sg13g2_decap_4
XFILLER_146_924 VDD VSS sg13g2_fill_1
XFILLER_30_1007 VDD VSS sg13g2_decap_8
XFILLER_173_710 VDD VSS sg13g2_fill_1
XFILLER_117_103 VDD VSS sg13g2_decap_8
XFILLER_173_721 VDD VSS sg13g2_decap_4
X_14350__1829 _14350_/RESET_B VDD VSS sg13g2_tiehi
X_13736__2443 _13736_/RESET_B VDD VSS sg13g2_tiehi
X_14496__1683 _14496_/RESET_B VDD VSS sg13g2_tiehi
XFILLER_145_445 VDD VSS sg13g2_decap_8
XFILLER_161_905 VDD VSS sg13g2_decap_8
XFILLER_133_618 VDD VSS sg13g2_decap_8
XFILLER_172_253 VDD VSS sg13g2_decap_8
XFILLER_156_1209 VDD VSS sg13g2_decap_8
XFILLER_132_128 VDD VSS sg13g2_decap_4
XFILLER_119_1020 VDD VSS sg13g2_decap_8
Xfanout206 _10157_/A1 _09083_/Y VDD VSS sg13g2_buf_1
XFILLER_8_1008 VDD VSS sg13g2_decap_8
X_14116__2063 _14116_/RESET_B VDD VSS sg13g2_tiehi
Xfanout217 _10088_/A0 fanout219/X VDD VSS sg13g2_buf_1
X_09801_ _14390_/D _09900_/A0 _14390_/Q _09804_/S VDD VSS sg13g2_mux2_1
XFILLER_59_407 VDD VSS sg13g2_decap_8
Xfanout228 _09921_/A1 _09789_/A0 VDD VSS sg13g2_buf_1
XFILLER_115_28 VDD VSS sg13g2_decap_8
XFILLER_119_1075 VDD VSS sg13g2_decap_8
Xfanout239 _11501_/A2 _11247_/X VDD VSS sg13g2_buf_1
X_07993_ _07993_/Y _15100_/Q _15089_/Q VDD VSS sg13g2_nor2_1
XFILLER_86_237 VDD VSS sg13g2_fill_1
XFILLER_45_1261 VDD VSS sg13g2_decap_8
X_09732_ _14323_/D _09930_/A1 _14323_/Q _09736_/S VDD VSS sg13g2_mux2_1
XFILLER_45_1272 VDD VSS sg13g2_fill_2
XFILLER_132_1253 VDD VSS sg13g2_fill_1
XFILLER_68_996 VDD VSS sg13g2_decap_8
X_09663_ _14256_/D _09696_/A0 _14256_/Q _09673_/S VDD VSS sg13g2_mux2_1
XFILLER_95_782 VDD VSS sg13g2_decap_4
XFILLER_54_101 VDD VSS sg13g2_decap_4
XFILLER_94_281 VDD VSS sg13g2_fill_2
X_08614_ _08615_/B _08641_/B _08612_/X _08613_/Y VDD VSS sg13g2_o21ai_1
X_09594_ _14191_/D _14191_/Q _09959_/A1 _09603_/S VDD VSS sg13g2_mux2_1
XFILLER_43_808 VDD VSS sg13g2_decap_8
X_13984__2195 _13984_/RESET_B VDD VSS sg13g2_tiehi
XFILLER_55_679 VDD VSS sg13g2_fill_1
XFILLER_83_999 VDD VSS sg13g2_fill_2
XFILLER_82_476 VDD VSS sg13g2_decap_8
X_08545_ _08545_/X _08545_/A _08545_/B _08545_/C _08545_/D VDD VSS sg13g2_and4_1
XFILLER_39_1021 VDD VSS sg13g2_fill_1
XFILLER_36_882 VDD VSS sg13g2_fill_2
XFILLER_78_1081 VDD VSS sg13g2_fill_2
XFILLER_39_1032 VDD VSS sg13g2_fill_1
XFILLER_24_14 VDD VSS sg13g2_decap_8
XFILLER_23_532 VDD VSS sg13g2_decap_8
XFILLER_126_1013 VDD VSS sg13g2_decap_4
XFILLER_168_504 VDD VSS sg13g2_decap_8
XFILLER_39_1065 VDD VSS sg13g2_decap_8
XFILLER_23_543 VDD VSS sg13g2_fill_2
X_08476_ _08476_/Y _08476_/A _08663_/B VDD VSS sg13g2_nand2_1
XFILLER_126_1046 VDD VSS sg13g2_decap_8
XFILLER_50_362 VDD VSS sg13g2_decap_8
XFILLER_50_373 VDD VSS sg13g2_fill_2
XFILLER_23_587 VDD VSS sg13g2_decap_8
XFILLER_17_1330 VDD VSS sg13g2_decap_8
XFILLER_91_1270 VDD VSS sg13g2_decap_8
XFILLER_11_749 VDD VSS sg13g2_decap_8
XFILLER_91_1281 VDD VSS sg13g2_fill_1
XFILLER_138_7 VDD VSS sg13g2_decap_8
XFILLER_149_751 VDD VSS sg13g2_decap_8
XFILLER_104_1333 VDD VSS sg13g2_decap_8
XFILLER_10_259 VDD VSS sg13g2_decap_8
XFILLER_149_784 VDD VSS sg13g2_decap_8
XFILLER_52_1287 VDD VSS sg13g2_decap_8
XFILLER_40_35 VDD VSS sg13g2_decap_8
XFILLER_164_754 VDD VSS sg13g2_decap_8
X_14326__1853 _14326_/RESET_B VDD VSS sg13g2_tiehi
XFILLER_163_231 VDD VSS sg13g2_decap_8
XFILLER_108_147 VDD VSS sg13g2_decap_8
XFILLER_156_35 VDD VSS sg13g2_decap_8
X_09028_ _09031_/B _14905_/Q _09024_/B VDD VSS sg13g2_nor2b_1
XFILLER_117_670 VDD VSS sg13g2_fill_1
XFILLER_151_437 VDD VSS sg13g2_decap_8
XFILLER_85_1041 VDD VSS sg13g2_fill_2
XFILLER_3_959 VDD VSS sg13g2_decap_8
XFILLER_105_876 VDD VSS sg13g2_fill_2
XFILLER_2_469 VDD VSS sg13g2_decap_8
XFILLER_104_375 VDD VSS sg13g2_decap_8
XFILLER_131_161 VDD VSS sg13g2_decap_8
XFILLER_132_684 VDD VSS sg13g2_decap_8
XFILLER_78_738 VDD VSS sg13g2_decap_8
XFILLER_131_172 VDD VSS sg13g2_fill_2
XFILLER_120_846 VDD VSS sg13g2_decap_8
Xclkbuf_leaf_9_clk_i _14735_/CLK clkbuf_leaf_9_clk_i/A VDD VSS sg13g2_buf_8
Xfanout740 _10869_/A _07649_/Y VDD VSS sg13g2_buf_1
XFILLER_63_1350 VDD VSS sg13g2_decap_8
Xfanout751 _08617_/A _07629_/Y VDD VSS sg13g2_buf_1
XFILLER_172_56 VDD VSS sg13g2_decap_8
X_15101__2767 _15101_/RESET_B VDD VSS sg13g2_tiehi
Xfanout762 _08048_/A _07626_/Y VDD VSS sg13g2_buf_1
XFILLER_24_1323 VDD VSS sg13g2_decap_8
X_13990_ _13990_/Q clkload2/A _13990_/D _13990_/RESET_B VDD VSS sg13g2_dfrbpq_1
Xfanout773 _10912_/A1 _10956_/C VDD VSS sg13g2_buf_1
XFILLER_59_974 VDD VSS sg13g2_decap_4
XFILLER_19_805 VDD VSS sg13g2_decap_8
Xfanout784 _12663_/S0 _12539_/S VDD VSS sg13g2_buf_1
Xfanout795 _12719_/S0 _12454_/S1 VDD VSS sg13g2_buf_1
XFILLER_92_207 VDD VSS sg13g2_decap_8
X_12941_ _15029_/D _13266_/A _12941_/B VDD VSS sg13g2_nor2_1
XFILLER_65_21 VDD VSS sg13g2_decap_8
XFILLER_18_315 VDD VSS sg13g2_decap_8
XFILLER_65_32 VDD VSS sg13g2_fill_1
X_12872_ _12872_/X _14899_/Q _13688_/Q VDD VSS sg13g2_and2_1
XFILLER_2_1141 VDD VSS sg13g2_decap_8
XFILLER_164_0 VDD VSS sg13g2_decap_8
X_13814__2365 _13814_/RESET_B VDD VSS sg13g2_tiehi
X_14611_ _14611_/Q clkload22/A _14611_/D _14611_/RESET_B VDD VSS sg13g2_dfrbpq_1
X_11823_ _11823_/Y _11353_/S _13836_/Q VDD VSS sg13g2_nand2b_1
XFILLER_14_532 VDD VSS sg13g2_decap_8
X_14542_ _14542_/Q clkload39/A _14542_/D _14542_/RESET_B VDD VSS sg13g2_dfrbpq_1
X_11754_ _11754_/X _11754_/A _11815_/B VDD VSS sg13g2_and2_1
XFILLER_53_1007 VDD VSS sg13g2_decap_8
XFILLER_18_1127 VDD VSS sg13g2_decap_8
XFILLER_109_1255 VDD VSS sg13g2_fill_1
XFILLER_144_1135 VDD VSS sg13g2_decap_8
XFILLER_144_1146 VDD VSS sg13g2_fill_2
X_10705_ _10936_/D _09021_/X _10788_/S _08869_/Y VDD VSS sg13g2_a21o_1
X_14473_ _14473_/Q _14505_/CLK _14473_/D _14473_/RESET_B VDD VSS sg13g2_dfrbpq_1
X_11685_ _11685_/Y _11681_/Y _11682_/Y _11684_/Y _11683_/Y _12036_/B VDD VSS sg13g2_a221oi_1
XFILLER_70_1343 VDD VSS sg13g2_fill_1
X_13424_ _13444_/C _13427_/B _15130_/Q VDD VSS sg13g2_nand2_1
X_10636_ _10642_/C _10636_/A _10636_/B VDD VSS sg13g2_nor2_1
XFILLER_31_1316 VDD VSS sg13g2_decap_8
XFILLER_14_91 VDD VSS sg13g2_decap_8
XFILLER_167_581 VDD VSS sg13g2_decap_8
X_13355_ _13469_/C _13401_/C _13401_/B _13429_/A VDD VSS sg13g2_nor3_1
X_10567_ _10579_/C _10567_/A _10567_/B _10567_/C _10567_/D VDD VSS sg13g2_nor4_1
XFILLER_6_742 VDD VSS sg13g2_decap_8
XFILLER_142_404 VDD VSS sg13g2_decap_4
X_12306_ _12307_/B _12306_/A _14234_/Q VDD VSS sg13g2_nand2_1
XFILLER_5_252 VDD VSS sg13g2_decap_8
XFILLER_154_275 VDD VSS sg13g2_decap_8
X_13286_ _13287_/B _13300_/C _07751_/Y _07710_/Y VDD VSS sg13g2_o21ai_1
XFILLER_53_7 VDD VSS sg13g2_decap_8
XFILLER_114_117 VDD VSS sg13g2_decap_4
XFILLER_136_990 VDD VSS sg13g2_fill_1
X_10498_ _10499_/B _14853_/Q _14852_/Q _10513_/D _10498_/D VDD VSS sg13g2_nand4_1
X_15025_ _15025_/Q clkload72/A _15025_/D _15025_/RESET_B VDD VSS sg13g2_dfrbpq_1
XFILLER_29_1212 VDD VSS sg13g2_decap_8
XFILLER_155_1220 VDD VSS sg13g2_decap_8
X_12237_ _12237_/Y _12237_/A _12237_/B _12237_/C VDD VSS sg13g2_nand3_1
XFILLER_170_768 VDD VSS sg13g2_fill_2
XFILLER_116_1215 VDD VSS sg13g2_decap_4
XFILLER_116_1226 VDD VSS sg13g2_fill_2
X_12168_ _12169_/B _12168_/A _14678_/Q VDD VSS sg13g2_nand2_1
XFILLER_151_1117 VDD VSS sg13g2_fill_1
XFILLER_29_1289 VDD VSS sg13g2_decap_8
XFILLER_110_323 VDD VSS sg13g2_decap_8
XFILLER_96_546 VDD VSS sg13g2_decap_8
X_11119_ _11119_/Y _11119_/A _11119_/B VDD VSS sg13g2_nor2_1
X_12099_ _12099_/Y _12095_/Y _12096_/Y _12098_/Y _12097_/Y _12253_/B VDD VSS sg13g2_a221oi_1
XFILLER_65_900 VDD VSS sg13g2_fill_2
Xinput6 input6/X input6/A VDD VSS sg13g2_buf_1
XFILLER_7_1085 VDD VSS sg13g2_decap_8
XFILLER_77_782 VDD VSS sg13g2_fill_2
XFILLER_77_793 VDD VSS sg13g2_decap_8
XFILLER_37_635 VDD VSS sg13g2_decap_8
XFILLER_92_741 VDD VSS sg13g2_decap_8
XFILLER_65_966 VDD VSS sg13g2_decap_8
XFILLER_80_903 VDD VSS sg13g2_decap_8
XFILLER_64_476 VDD VSS sg13g2_decap_8
XFILLER_36_167 VDD VSS sg13g2_decap_8
X_14404__1775 _14404_/RESET_B VDD VSS sg13g2_tiehi
X_14809_ _14809_/Q clkload51/A _14809_/D _14809_/RESET_B VDD VSS sg13g2_dfrbpq_1
XFILLER_18_882 VDD VSS sg13g2_decap_8
X_15041__2543 _15041_/RESET_B VDD VSS sg13g2_tiehi
X_08330_ _08330_/Y _08329_/B _08484_/C _08329_/Y VDD VSS sg13g2_o21ai_1
XFILLER_17_392 VDD VSS sg13g2_decap_8
XFILLER_60_660 VDD VSS sg13g2_decap_8
XFILLER_32_351 VDD VSS sg13g2_fill_1
XFILLER_162_1235 VDD VSS sg13g2_decap_8
XFILLER_75_1287 VDD VSS sg13g2_decap_8
XFILLER_162_1246 VDD VSS sg13g2_fill_1
XFILLER_36_1249 VDD VSS sg13g2_decap_8
X_08261_ _08261_/Y _08539_/B1 _08590_/B _08260_/Y VDD VSS sg13g2_o21ai_1
XFILLER_32_373 VDD VSS sg13g2_decap_8
X_13969__2210 _13969_/RESET_B VDD VSS sg13g2_tiehi
XFILLER_20_546 VDD VSS sg13g2_decap_8
XFILLER_165_518 VDD VSS sg13g2_decap_8
X_08192_ _08192_/Y _07890_/B _08191_/Y _08000_/X VDD VSS sg13g2_o21ai_1
XFILLER_118_412 VDD VSS sg13g2_decap_8
XFILLER_125_1090 VDD VSS sg13g2_fill_1
XFILLER_134_927 VDD VSS sg13g2_decap_8
XFILLER_12_1260 VDD VSS sg13g2_decap_8
XFILLER_161_724 VDD VSS sg13g2_fill_1
XFILLER_173_584 VDD VSS sg13g2_decap_8
XFILLER_133_426 VDD VSS sg13g2_fill_2
XFILLER_105_128 VDD VSS sg13g2_decap_8
XFILLER_10_49 VDD VSS sg13g2_decap_8
XFILLER_47_1301 VDD VSS sg13g2_decap_8
XFILLER_160_245 VDD VSS sg13g2_decap_8
XFILLER_99_351 VDD VSS sg13g2_fill_1
XFILLER_87_502 VDD VSS sg13g2_decap_4
XFILLER_160_278 VDD VSS sg13g2_fill_1
XFILLER_114_684 VDD VSS sg13g2_fill_2
XFILLER_82_1258 VDD VSS sg13g2_decap_8
XFILLER_47_1378 VDD VSS sg13g2_decap_4
XFILLER_19_14 VDD VSS sg13g2_decap_8
X_07976_ _07976_/X _07976_/A _07976_/B _07976_/C VDD VSS sg13g2_or3_1
XFILLER_59_259 VDD VSS sg13g2_decap_8
X_09715_ _14306_/D _09913_/A1 _14306_/Q _09738_/S VDD VSS sg13g2_mux2_1
XFILLER_56_933 VDD VSS sg13g2_decap_8
XFILLER_132_1072 VDD VSS sg13g2_decap_8
XFILLER_55_421 VDD VSS sg13g2_decap_8
XFILLER_27_112 VDD VSS sg13g2_decap_8
X_09646_ _14239_/D _09877_/A0 _14239_/Q _09664_/S VDD VSS sg13g2_mux2_1
XFILLER_82_240 VDD VSS sg13g2_decap_8
XFILLER_16_819 VDD VSS sg13g2_decap_8
XFILLER_83_774 VDD VSS sg13g2_decap_8
XFILLER_71_925 VDD VSS sg13g2_fill_2
XFILLER_70_402 VDD VSS sg13g2_fill_1
XFILLER_55_476 VDD VSS sg13g2_decap_8
XFILLER_35_35 VDD VSS sg13g2_decap_8
XFILLER_15_329 VDD VSS sg13g2_decap_8
X_09577_ _14174_/D _14174_/Q _09610_/A0 _09599_/S VDD VSS sg13g2_mux2_1
XFILLER_27_189 VDD VSS sg13g2_decap_8
XFILLER_24_841 VDD VSS sg13g2_fill_2
XFILLER_169_813 VDD VSS sg13g2_decap_8
X_08528_ _08567_/C _07815_/X _07822_/B _07816_/X VDD VSS sg13g2_a21oi_1
XFILLER_54_1305 VDD VSS sg13g2_decap_8
XFILLER_168_301 VDD VSS sg13g2_decap_8
XFILLER_42_159 VDD VSS sg13g2_fill_1
X_08459_ _08459_/Y _08281_/Y _08200_/A _08539_/B1 VDD VSS sg13g2_a21oi_1
XFILLER_141_1319 VDD VSS sg13g2_decap_8
XFILLER_11_546 VDD VSS sg13g2_decap_8
Xwire404 wire404/X wire405/X VDD VSS sg13g2_buf_2
XFILLER_128_209 VDD VSS sg13g2_decap_8
XFILLER_168_378 VDD VSS sg13g2_decap_8
X_14559__1620 _14559_/RESET_B VDD VSS sg13g2_tiehi
X_11470_ _11470_/X _14561_/Q _14593_/Q _14625_/Q _14657_/Q _12282_/S0 _12282_/S1 VDD
+ VSS sg13g2_mux4_1
XFILLER_149_581 VDD VSS sg13g2_fill_1
XFILLER_7_539 VDD VSS sg13g2_decap_8
XFILLER_167_56 VDD VSS sg13g2_decap_8
X_10421_ _10423_/A _14830_/Q _10421_/B VDD VSS sg13g2_nand2b_1
XFILLER_13_1057 VDD VSS sg13g2_decap_8
XFILLER_152_702 VDD VSS sg13g2_decap_8
XFILLER_139_1204 VDD VSS sg13g2_fill_2
X_13140_ _13141_/B _13166_/A1 _13136_/X _13139_/Y _13140_/B2 _13135_/Y VDD VSS sg13g2_a221oi_1
XFILLER_124_415 VDD VSS sg13g2_decap_8
X_10352_ _10353_/B _14809_/Q _14810_/Q _10352_/C VDD VSS sg13g2_nand3_1
XFILLER_164_595 VDD VSS sg13g2_decap_8
XFILLER_139_1237 VDD VSS sg13g2_decap_8
X_13071_ _13071_/Y _13068_/Y _13069_/Y _13070_/Y VDD VSS sg13g2_a21oi_1
XFILLER_105_640 VDD VSS sg13g2_fill_1
X_10283_ _10286_/A _14788_/Q _10311_/A _14789_/Q VDD VSS sg13g2_a21o_1
XFILLER_3_756 VDD VSS sg13g2_decap_8
X_12022_ _12022_/X _14578_/Q _14610_/Q _12025_/A VDD VSS sg13g2_mux2_1
XFILLER_104_150 VDD VSS sg13g2_decap_8
XFILLER_2_266 VDD VSS sg13g2_decap_8
XFILLER_116_71 VDD VSS sg13g2_decap_8
XFILLER_76_42 VDD VSS sg13g2_fill_1
XFILLER_24_1120 VDD VSS sg13g2_decap_8
XFILLER_120_676 VDD VSS sg13g2_decap_4
Xfanout570 _13567_/A2 _13600_/B VDD VSS sg13g2_buf_1
XFILLER_8_1372 VDD VSS sg13g2_decap_8
XFILLER_76_53 VDD VSS sg13g2_fill_2
XFILLER_65_207 VDD VSS sg13g2_decap_8
Xfanout581 _12338_/A2 _11288_/Y VDD VSS sg13g2_buf_1
XFILLER_59_771 VDD VSS sg13g2_fill_2
XFILLER_19_602 VDD VSS sg13g2_decap_8
XFILLER_150_1150 VDD VSS sg13g2_decap_8
Xfanout592 _10453_/C _10521_/C VDD VSS sg13g2_buf_1
XFILLER_8_1383 VDD VSS sg13g2_fill_1
X_13973_ _13973_/Q _14677_/CLK _13973_/D _13973_/RESET_B VDD VSS sg13g2_dfrbpq_1
XFILLER_4_1225 VDD VSS sg13g2_decap_8
X_14661__1518 _14661_/RESET_B VDD VSS sg13g2_tiehi
XFILLER_18_112 VDD VSS sg13g2_decap_8
X_12924_ _12943_/D _12925_/A _12925_/B _12925_/C VDD VSS sg13g2_and3_1
XFILLER_24_1197 VDD VSS sg13g2_decap_8
XFILLER_111_1167 VDD VSS sg13g2_fill_1
XFILLER_19_679 VDD VSS sg13g2_decap_8
XFILLER_98_1287 VDD VSS sg13g2_decap_8
XFILLER_146_1208 VDD VSS sg13g2_decap_4
X_12855_ _12855_/Y _12845_/Y _12870_/A2 _12854_/Y VDD VSS sg13g2_a21oi_1
XFILLER_18_189 VDD VSS sg13g2_decap_8
X_14090__2089 _14090_/RESET_B VDD VSS sg13g2_tiehi
X_15183__2819 _15183_/RESET_B VDD VSS sg13g2_tiehi
XFILLER_33_126 VDD VSS sg13g2_decap_8
XFILLER_61_446 VDD VSS sg13g2_decap_8
X_11806_ _11806_/Y _11806_/A _11806_/B _12092_/C VDD VSS sg13g2_nand3_1
XFILLER_159_301 VDD VSS sg13g2_decap_8
X_12786_ _12786_/X _13850_/Q _13882_/Q _13914_/Q _13946_/Q _12787_/S0 _12787_/S1 VDD
+ VSS sg13g2_mux4_1
XFILLER_61_479 VDD VSS sg13g2_decap_8
XFILLER_42_671 VDD VSS sg13g2_decap_8
XFILLER_15_896 VDD VSS sg13g2_decap_8
X_14525_ _14525_/Q clkload47/A _14525_/D _14525_/RESET_B VDD VSS sg13g2_dfrbpq_1
X_14198__1981 _14198_/RESET_B VDD VSS sg13g2_tiehi
X_11737_ _11737_/Y _11734_/Y _11736_/X _12118_/C VDD VSS sg13g2_o21ai_1
XFILLER_30_844 VDD VSS sg13g2_decap_8
XFILLER_159_378 VDD VSS sg13g2_decap_8
X_14456_ _14456_/Q _14744_/CLK _14456_/D _14456_/RESET_B VDD VSS sg13g2_dfrbpq_1
XFILLER_35_1260 VDD VSS sg13g2_fill_2
X_11668_ _11668_/Y _11676_/A1 _13928_/Q _12233_/B VDD VSS sg13g2_a21oi_1
XFILLER_31_1113 VDD VSS sg13g2_decap_8
XFILLER_161_1290 VDD VSS sg13g2_decap_8
X_13407_ _13407_/Y _13407_/A _13427_/B _15091_/Q VDD VSS sg13g2_nand3_1
X_10619_ _14881_/D _10619_/A _10619_/B _10619_/C VDD VSS sg13g2_and3_1
X_14387_ _14387_/Q clkload24/A _14387_/D _14387_/RESET_B VDD VSS sg13g2_dfrbpq_1
X_11599_ _11599_/Y _11599_/A _11599_/B _11743_/C VDD VSS sg13g2_nand3_1
X_13338_ _13351_/B _13338_/A _15170_/D _15169_/D VDD VSS sg13g2_nand3_1
XFILLER_116_949 VDD VSS sg13g2_fill_1
XFILLER_142_212 VDD VSS sg13g2_decap_8
XFILLER_170_532 VDD VSS sg13g2_decap_8
XFILLER_143_768 VDD VSS sg13g2_fill_2
XFILLER_131_919 VDD VSS sg13g2_decap_8
XFILLER_157_1359 VDD VSS sg13g2_fill_2
X_13269_ _13269_/Y _13270_/A _13270_/B _13270_/C VDD VSS sg13g2_a21oi_1
X_14861__2822 _14861_/RESET_B VDD VSS sg13g2_tiehi
Xhold3109 _13620_/A _13728_/Q VDD VSS sg13g2_dlygate4sd3_1
XFILLER_97_800 VDD VSS sg13g2_decap_8
X_15008_ _15008_/Q _15015_/CLK _15008_/D _15008_/RESET_B VDD VSS sg13g2_dfrbpq_1
XFILLER_69_513 VDD VSS sg13g2_decap_8
XFILLER_116_1012 VDD VSS sg13g2_fill_1
XFILLER_111_643 VDD VSS sg13g2_fill_1
X_07830_ _07834_/A _08692_/B _08692_/C VDD VSS sg13g2_nor2b_1
XFILLER_9_1169 VDD VSS sg13g2_decap_8
XFILLER_69_568 VDD VSS sg13g2_decap_4
XFILLER_111_676 VDD VSS sg13g2_fill_2
XFILLER_111_687 VDD VSS sg13g2_decap_8
X_14894__2756 _14894_/RESET_B VDD VSS sg13g2_tiehi
X_07761_ _14766_/D _10177_/A _15204_/Q VDD VSS sg13g2_and2_1
XFILLER_42_1253 VDD VSS sg13g2_decap_4
XFILLER_49_270 VDD VSS sg13g2_decap_8
X_09500_ _14100_/D _10096_/A0 _14100_/Q _09506_/S VDD VSS sg13g2_mux2_1
XFILLER_38_966 VDD VSS sg13g2_decap_8
X_14637__1542 _14637_/RESET_B VDD VSS sg13g2_tiehi
X_07692_ _07701_/B _07690_/A _11241_/C _07679_/D VDD VSS sg13g2_a21oi_1
X_09431_ _14033_/D _09629_/A0 _14033_/Q _09431_/S VDD VSS sg13g2_mux2_1
XFILLER_37_498 VDD VSS sg13g2_decap_8
XFILLER_24_126 VDD VSS sg13g2_decap_8
XFILLER_80_755 VDD VSS sg13g2_decap_8
X_09362_ _13966_/D _09760_/A1 _13966_/Q _09368_/S VDD VSS sg13g2_mux2_1
X_08313_ _15229_/D _08539_/B1 _08625_/B _08312_/Y VDD VSS sg13g2_o21ai_1
XFILLER_36_1035 VDD VSS sg13g2_decap_4
XFILLER_162_1043 VDD VSS sg13g2_fill_2
X_09293_ _13901_/D _13901_/Q _10156_/A1 _09297_/S VDD VSS sg13g2_mux2_1
XFILLER_21_833 VDD VSS sg13g2_decap_8
XANTENNA_11 _16863_/A VDD VSS sg13g2_antennanp
XANTENNA_22 _12215_/S1 VDD VSS sg13g2_antennanp
XFILLER_138_518 VDD VSS sg13g2_fill_2
XANTENNA_33 _16883_/A VDD VSS sg13g2_antennanp
XFILLER_127_1196 VDD VSS sg13g2_decap_8
XFILLER_138_529 VDD VSS sg13g2_fill_2
X_08244_ _08244_/Y _08008_/B _08340_/A VDD VSS sg13g2_nand2b_1
XFILLER_20_343 VDD VSS sg13g2_decap_8
XFILLER_165_315 VDD VSS sg13g2_decap_8
X_15005__2582 _15005_/RESET_B VDD VSS sg13g2_tiehi
XFILLER_14_1344 VDD VSS sg13g2_decap_8
XFILLER_118_231 VDD VSS sg13g2_decap_8
X_08175_ _08175_/Y _08188_/B _08001_/A _08001_/C VDD VSS sg13g2_o21ai_1
X_14814__2899 _14814_/RESET_B VDD VSS sg13g2_tiehi
XFILLER_174_882 VDD VSS sg13g2_decap_4
XFILLER_118_275 VDD VSS sg13g2_fill_2
XFILLER_133_212 VDD VSS sg13g2_decap_4
XFILLER_122_908 VDD VSS sg13g2_decap_8
XFILLER_161_554 VDD VSS sg13g2_decap_8
Xclkbuf_leaf_74_clk_i clkload53/A clkbuf_leaf_75_clk_i/A VDD VSS sg13g2_buf_8
Xoutput140 mem_axi_wvalid _07662_/Y VDD VSS sg13g2_buf_1
XFILLER_115_971 VDD VSS sg13g2_decap_8
XFILLER_133_278 VDD VSS sg13g2_decap_8
XFILLER_134_1101 VDD VSS sg13g2_decap_8
XFILLER_47_1153 VDD VSS sg13g2_fill_2
XFILLER_0_737 VDD VSS sg13g2_decap_8
XFILLER_153_14 VDD VSS sg13g2_decap_8
XFILLER_102_621 VDD VSS sg13g2_decap_8
XFILLER_114_492 VDD VSS sg13g2_decap_8
XFILLER_43_1017 VDD VSS sg13g2_decap_8
XFILLER_130_963 VDD VSS sg13g2_decap_8
XFILLER_102_665 VDD VSS sg13g2_decap_8
XFILLER_130_974 VDD VSS sg13g2_fill_1
XFILLER_88_888 VDD VSS sg13g2_decap_8
XFILLER_130_1009 VDD VSS sg13g2_decap_8
XFILLER_75_527 VDD VSS sg13g2_decap_8
Xclkbuf_leaf_89_clk_i clkload48/A clkbuf_leaf_92_clk_i/A VDD VSS sg13g2_buf_8
X_07959_ _07959_/Y _07961_/B VDD VSS sg13g2_inv_1
XFILLER_28_421 VDD VSS sg13g2_decap_8
XFILLER_169_1219 VDD VSS sg13g2_decap_8
XFILLER_21_1337 VDD VSS sg13g2_decap_8
X_10970_ _10970_/Y _10983_/A1 _10964_/Y _10969_/Y VDD VSS sg13g2_a21oi_1
XFILLER_46_56 VDD VSS sg13g2_decap_8
XFILLER_16_616 VDD VSS sg13g2_decap_8
XFILLER_44_936 VDD VSS sg13g2_decap_8
X_09629_ _14225_/D _09629_/A0 _14225_/Q _09629_/S VDD VSS sg13g2_mux2_1
Xclkbuf_leaf_12_clk_i clkload8/A clkbuf_leaf_4_clk_i/A VDD VSS sg13g2_buf_8
XFILLER_70_210 VDD VSS sg13g2_decap_8
XFILLER_28_498 VDD VSS sg13g2_decap_8
XFILLER_15_126 VDD VSS sg13g2_decap_8
XFILLER_44_958 VDD VSS sg13g2_decap_4
XFILLER_43_435 VDD VSS sg13g2_decap_8
XFILLER_70_232 VDD VSS sg13g2_decap_8
X_12640_ _12640_/X _13840_/Q _13872_/Q _13904_/Q _13936_/Q _12645_/S0 _12645_/S1 VDD
+ VSS sg13g2_mux4_1
XFILLER_70_243 VDD VSS sg13g2_fill_1
XFILLER_70_254 VDD VSS sg13g2_decap_8
XFILLER_19_1211 VDD VSS sg13g2_decap_8
XFILLER_93_1173 VDD VSS sg13g2_fill_2
XFILLER_106_1203 VDD VSS sg13g2_fill_2
XFILLER_12_833 VDD VSS sg13g2_decap_8
XFILLER_145_1252 VDD VSS sg13g2_decap_8
X_12571_ _12571_/X _14571_/Q _14603_/Q _14635_/Q _14667_/Q _12661_/S0 _12661_/S1 VDD
+ VSS sg13g2_mux4_1
XFILLER_145_1263 VDD VSS sg13g2_fill_1
XFILLER_62_77 VDD VSS sg13g2_decap_8
X_14310_ _14310_/Q _14310_/CLK _14310_/D _14310_/RESET_B VDD VSS sg13g2_dfrbpq_1
XFILLER_19_1288 VDD VSS sg13g2_decap_8
XFILLER_11_343 VDD VSS sg13g2_decap_8
X_11522_ _14965_/D _11502_/A _12295_/B1 _11521_/Y VDD VSS sg13g2_a21o_1
XFILLER_157_838 VDD VSS sg13g2_decap_8
XFILLER_168_175 VDD VSS sg13g2_decap_8
Xclkbuf_leaf_27_clk_i _14727_/CLK clkbuf_leaf_9_clk_i/A VDD VSS sg13g2_buf_8
XFILLER_8_826 VDD VSS sg13g2_decap_8
X_14075__2104 _14075_/RESET_B VDD VSS sg13g2_tiehi
XFILLER_7_28 VDD VSS sg13g2_decap_8
XFILLER_127_0 VDD VSS sg13g2_decap_8
X_14241_ _14241_/Q clkload31/A _14241_/D _14241_/RESET_B VDD VSS sg13g2_dfrbpq_1
XFILLER_7_336 VDD VSS sg13g2_decap_8
X_11453_ _11457_/A _11454_/A _13688_/Q VDD VSS sg13g2_or2_1
XFILLER_165_860 VDD VSS sg13g2_decap_8
X_10404_ _10406_/C _14823_/Q _10413_/B _14824_/Q VDD VSS sg13g2_a21oi_1
X_14172_ _14172_/Q clkload40/A _14172_/D _14172_/RESET_B VDD VSS sg13g2_dfrbpq_1
X_11384_ _11385_/B _11384_/A _13690_/Q VDD VSS sg13g2_xnor2_1
XFILLER_139_1023 VDD VSS sg13g2_fill_2
XFILLER_152_532 VDD VSS sg13g2_decap_4
XFILLER_164_392 VDD VSS sg13g2_decap_8
X_13123_ _13123_/Y _14787_/Q _13152_/A2 _13208_/B1 VDD VSS sg13g2_o21ai_1
XFILLER_11_70 VDD VSS sg13g2_decap_8
XFILLER_152_554 VDD VSS sg13g2_decap_8
X_14715__1464 _14715_/RESET_B VDD VSS sg13g2_tiehi
X_10335_ _10337_/A _14805_/Q _10335_/B VDD VSS sg13g2_nand2b_1
XFILLER_139_1056 VDD VSS sg13g2_decap_8
XFILLER_3_553 VDD VSS sg13g2_decap_8
XFILLER_140_727 VDD VSS sg13g2_decap_8
XFILLER_127_81 VDD VSS sg13g2_fill_1
X_13054_ _13054_/Y _13152_/A2 _13052_/Y _13053_/Y VDD VSS sg13g2_a21oi_1
XFILLER_140_749 VDD VSS sg13g2_decap_8
X_10266_ _14783_/D _10278_/C _10661_/A _10266_/C VDD VSS sg13g2_nor3_1
XFILLER_79_844 VDD VSS sg13g2_fill_1
XFILLER_79_855 VDD VSS sg13g2_decap_8
Xfanout1310 _12040_/A1 _12238_/S0 VDD VSS sg13g2_buf_1
X_12005_ _12006_/B _12296_/A1 _11989_/Y _12004_/Y VDD VSS sg13g2_o21ai_1
XFILLER_152_1234 VDD VSS sg13g2_fill_1
Xfanout1321 _11358_/S0 _11896_/A VDD VSS sg13g2_buf_1
XFILLER_79_866 VDD VSS sg13g2_fill_1
XFILLER_6_1309 VDD VSS sg13g2_decap_8
Xfanout1332 _11277_/S _11212_/S VDD VSS sg13g2_buf_1
XFILLER_78_354 VDD VSS sg13g2_decap_8
XFILLER_61_1128 VDD VSS sg13g2_decap_8
XFILLER_152_1256 VDD VSS sg13g2_fill_2
Xfanout1343 _11275_/S0 _12306_/A VDD VSS sg13g2_buf_1
X_10197_ _15199_/D hold3081/X _15199_/Q _13479_/S VDD VSS sg13g2_mux2_1
XFILLER_26_1259 VDD VSS sg13g2_decap_8
XFILLER_121_985 VDD VSS sg13g2_decap_8
XFILLER_152_1267 VDD VSS sg13g2_decap_8
Xfanout1354 _12017_/A _12242_/A_N VDD VSS sg13g2_buf_1
Xfanout1365 _12215_/S0 _11469_/S0 VDD VSS sg13g2_buf_1
Xfanout1376 _10490_/A _13198_/B1 VDD VSS sg13g2_buf_1
XFILLER_16_7 VDD VSS sg13g2_decap_8
Xfanout1387 _13021_/A _07625_/Y VDD VSS sg13g2_buf_1
XFILLER_4_1022 VDD VSS sg13g2_decap_8
Xfanout1398 _13499_/B _10535_/C VDD VSS sg13g2_buf_1
X_13956_ _13956_/Q clkload17/A _13956_/D _13956_/RESET_B VDD VSS sg13g2_dfrbpq_1
XFILLER_74_560 VDD VSS sg13g2_decap_8
XFILLER_47_774 VDD VSS sg13g2_fill_1
XFILLER_47_785 VDD VSS sg13g2_fill_1
XFILLER_19_476 VDD VSS sg13g2_decap_8
X_12907_ _12909_/C _12943_/A _12925_/C VDD VSS sg13g2_nand2b_1
XFILLER_4_1099 VDD VSS sg13g2_decap_8
X_13887_ _13887_/Q clkload9/A _13887_/D _13887_/RESET_B VDD VSS sg13g2_dfrbpq_1
XFILLER_46_284 VDD VSS sg13g2_fill_1
XFILLER_146_1005 VDD VSS sg13g2_decap_8
XFILLER_61_221 VDD VSS sg13g2_fill_2
XFILLER_59_1057 VDD VSS sg13g2_fill_1
XFILLER_146_1016 VDD VSS sg13g2_fill_1
X_12838_ _12838_/Y _12838_/A _12878_/D VDD VSS sg13g2_nor2b_1
XFILLER_22_608 VDD VSS sg13g2_decap_8
XFILLER_61_265 VDD VSS sg13g2_decap_8
XFILLER_37_1322 VDD VSS sg13g2_decap_8
XFILLER_72_1235 VDD VSS sg13g2_decap_4
XFILLER_15_693 VDD VSS sg13g2_decap_8
X_12769_ _12769_/X _14713_/Q _14745_/Q _13785_/Q _13817_/Q _12771_/S0 _12771_/S1 VDD
+ VSS sg13g2_mux4_1
XFILLER_124_1314 VDD VSS sg13g2_decap_4
XFILLER_163_1374 VDD VSS sg13g2_fill_1
XFILLER_124_1336 VDD VSS sg13g2_fill_2
X_14508_ _14508_/Q clkload35/A _14508_/D _14508_/RESET_B VDD VSS sg13g2_dfrbpq_1
XFILLER_159_175 VDD VSS sg13g2_decap_8
XFILLER_174_101 VDD VSS sg13g2_decap_8
Xinput20 input20/X input20/A VDD VSS sg13g2_buf_1
XFILLER_163_819 VDD VSS sg13g2_decap_8
X_14439_ _14439_/Q _14607_/CLK _14439_/D _14439_/RESET_B VDD VSS sg13g2_dfrbpq_1
Xinput31 input31/X input31/A VDD VSS sg13g2_buf_1
XFILLER_128_573 VDD VSS sg13g2_decap_8
XFILLER_143_510 VDD VSS sg13g2_fill_1
XFILLER_116_746 VDD VSS sg13g2_decap_8
XFILLER_66_1006 VDD VSS sg13g2_decap_4
XFILLER_116_757 VDD VSS sg13g2_fill_1
XFILLER_116_768 VDD VSS sg13g2_fill_1
XFILLER_143_543 VDD VSS sg13g2_decap_4
Xclkbuf_5_1__f_clk_i clkbuf_leaf_3_clk_i/A clkbuf_4_0_0_clk_i/X VDD VSS sg13g2_buf_16
XFILLER_157_1145 VDD VSS sg13g2_decap_8
X_09980_ _14563_/D _10079_/A0 _14563_/Q _10002_/S VDD VSS sg13g2_mux2_1
XFILLER_143_576 VDD VSS sg13g2_decap_4
XFILLER_42_0 VDD VSS sg13g2_decap_8
XFILLER_103_429 VDD VSS sg13g2_decap_8
X_08931_ _08931_/X _08930_/X _12084_/A _08931_/S VDD VSS sg13g2_mux2_1
XFILLER_83_1342 VDD VSS sg13g2_decap_8
X_13773__2406 _13773_/RESET_B VDD VSS sg13g2_tiehi
X_15103__2759 _15103_/RESET_B VDD VSS sg13g2_tiehi
XFILLER_130_248 VDD VSS sg13g2_decap_4
XFILLER_97_652 VDD VSS sg13g2_decap_4
XFILLER_170_1334 VDD VSS sg13g2_decap_8
X_08862_ _08862_/X _15029_/Q _14933_/Q _10675_/A VDD VSS sg13g2_mux2_1
XFILLER_96_140 VDD VSS sg13g2_decap_4
XFILLER_69_365 VDD VSS sg13g2_decap_8
X_07813_ _07954_/B _08522_/A _08548_/B VDD VSS sg13g2_and2_1
XFILLER_85_836 VDD VSS sg13g2_decap_8
XFILLER_123_28 VDD VSS sg13g2_decap_8
X_08793_ _13682_/D _08790_/Y _08791_/Y _08792_/Y VDD VSS sg13g2_a21oi_1
XFILLER_84_357 VDD VSS sg13g2_decap_8
X_07744_ _07746_/C _07748_/B _07744_/B _07744_/C _07744_/D VDD VSS sg13g2_nand4_1
XFILLER_38_763 VDD VSS sg13g2_decap_8
X_14153__2026 _14153_/RESET_B VDD VSS sg13g2_tiehi
XFILLER_77_1102 VDD VSS sg13g2_decap_4
XFILLER_77_1124 VDD VSS sg13g2_decap_8
XFILLER_77_1135 VDD VSS sg13g2_decap_8
X_07675_ _07677_/C _15078_/Q _15081_/Q VDD VSS sg13g2_nor2_1
XFILLER_26_958 VDD VSS sg13g2_decap_8
XFILLER_168_1263 VDD VSS sg13g2_fill_2
XFILLER_25_435 VDD VSS sg13g2_fill_2
XFILLER_164_1105 VDD VSS sg13g2_fill_1
XFILLER_53_755 VDD VSS sg13g2_fill_1
XFILLER_129_1236 VDD VSS sg13g2_decap_8
X_15221__2989 _15221_/RESET_B VDD VSS sg13g2_tiehi
X_09414_ _14016_/D _10076_/A0 _14016_/Q _09436_/S VDD VSS sg13g2_mux2_1
XFILLER_41_906 VDD VSS sg13g2_decap_4
XFILLER_164_1127 VDD VSS sg13g2_decap_4
XFILLER_80_552 VDD VSS sg13g2_decap_8
XFILLER_164_1138 VDD VSS sg13g2_decap_8
XFILLER_34_980 VDD VSS sg13g2_decap_8
X_09345_ _13949_/D _09609_/A0 _13949_/Q _09368_/S VDD VSS sg13g2_mux2_1
XFILLER_90_1324 VDD VSS sg13g2_fill_2
XFILLER_21_630 VDD VSS sg13g2_decap_8
XFILLER_166_602 VDD VSS sg13g2_decap_8
XFILLER_32_14 VDD VSS sg13g2_decap_8
XFILLER_138_315 VDD VSS sg13g2_decap_8
X_09276_ _13884_/D _13884_/Q _09907_/A1 _09292_/S VDD VSS sg13g2_mux2_1
XFILLER_20_140 VDD VSS sg13g2_decap_8
XFILLER_148_14 VDD VSS sg13g2_decap_8
XFILLER_165_112 VDD VSS sg13g2_decap_8
X_08227_ _08227_/Y _14963_/Q _14995_/Q _08247_/C VDD VSS sg13g2_a21oi_1
XFILLER_120_7 VDD VSS sg13g2_decap_8
XFILLER_14_1141 VDD VSS sg13g2_decap_8
XFILLER_140_1171 VDD VSS sg13g2_decap_8
XFILLER_101_1133 VDD VSS sg13g2_decap_4
XFILLER_165_189 VDD VSS sg13g2_decap_8
X_08158_ _08158_/X _08005_/X _08019_/B _08018_/X _08031_/C _08431_/C _08431_/D VDD
+ VSS sg13g2_mux4_1
XFILLER_88_1253 VDD VSS sg13g2_decap_8
X_14960__2627 _14960_/RESET_B VDD VSS sg13g2_tiehi
XFILLER_134_532 VDD VSS sg13g2_decap_8
XFILLER_49_1226 VDD VSS sg13g2_decap_8
XFILLER_101_1177 VDD VSS sg13g2_decap_8
XFILLER_88_1275 VDD VSS sg13g2_fill_2
X_08089_ _08090_/C _08253_/S0 _11249_/A _07884_/A _08137_/A2 VDD VSS sg13g2_a22oi_1
XFILLER_88_1297 VDD VSS sg13g2_decap_4
XFILLER_164_35 VDD VSS sg13g2_decap_8
XFILLER_122_727 VDD VSS sg13g2_decap_8
XFILLER_161_373 VDD VSS sg13g2_decap_8
XFILLER_162_896 VDD VSS sg13g2_decap_8
X_10120_ _14698_/D _10153_/A1 _14698_/Q _10123_/S VDD VSS sg13g2_mux2_1
XFILLER_122_749 VDD VSS sg13g2_fill_1
X_14363__1816 _14363_/RESET_B VDD VSS sg13g2_tiehi
X_13749__2430 _13749_/RESET_B VDD VSS sg13g2_tiehi
X_10051_ _14632_/D _10084_/A0 _14632_/Q _10060_/S VDD VSS sg13g2_mux2_1
XFILLER_88_663 VDD VSS sg13g2_decap_8
XFILLER_0_567 VDD VSS sg13g2_decap_8
XFILLER_103_996 VDD VSS sg13g2_decap_8
XFILLER_75_313 VDD VSS sg13g2_fill_1
XFILLER_25_1281 VDD VSS sg13g2_decap_8
X_13810_ _13810_/Q _14744_/CLK _13810_/D _13810_/RESET_B VDD VSS sg13g2_dfrbpq_1
X_14790_ _14790_/Q clkload48/A _14790_/D _14790_/RESET_B VDD VSS sg13g2_dfrbpq_1
XFILLER_21_1134 VDD VSS sg13g2_decap_8
XFILLER_17_903 VDD VSS sg13g2_decap_8
XFILLER_56_560 VDD VSS sg13g2_decap_8
XFILLER_112_1273 VDD VSS sg13g2_decap_8
XFILLER_16_413 VDD VSS sg13g2_decap_8
X_13741_ _13741_/Q clkload3/A _13741_/D _13741_/RESET_B VDD VSS sg13g2_dfrbpq_1
X_14129__2050 _14129_/RESET_B VDD VSS sg13g2_tiehi
XFILLER_90_327 VDD VSS sg13g2_fill_2
XFILLER_44_722 VDD VSS sg13g2_fill_1
XFILLER_1_1239 VDD VSS sg13g2_decap_8
X_10953_ _10953_/Y _10954_/C _10965_/C _11188_/C1 VDD VSS sg13g2_o21ai_1
XFILLER_73_21 VDD VSS sg13g2_decap_8
XFILLER_44_733 VDD VSS sg13g2_decap_8
XFILLER_147_1347 VDD VSS sg13g2_decap_8
X_13672_ _13672_/Q _15113_/CLK _13672_/D _13672_/RESET_B VDD VSS sg13g2_dfrbpq_1
X_10884_ _10884_/Y _10898_/B1 _10878_/Y _10912_/A1 VDD VSS sg13g2_o21ai_1
XFILLER_32_928 VDD VSS sg13g2_decap_8
X_12623_ _12623_/X _12622_/X _12621_/X _12706_/S VDD VSS sg13g2_mux2_1
XFILLER_43_298 VDD VSS sg13g2_decap_8
XFILLER_12_630 VDD VSS sg13g2_decap_8
XFILLER_106_1022 VDD VSS sg13g2_decap_8
XFILLER_169_462 VDD VSS sg13g2_decap_8
X_12554_ _12555_/B _13679_/Q _12763_/A2 _12553_/X _12400_/A _12777_/C1 VDD VSS sg13g2_a221oi_1
XFILLER_19_1085 VDD VSS sg13g2_decap_8
XFILLER_11_140 VDD VSS sg13g2_decap_8
X_13851__2328 _13851_/RESET_B VDD VSS sg13g2_tiehi
XFILLER_156_112 VDD VSS sg13g2_decap_8
XFILLER_8_623 VDD VSS sg13g2_decap_8
XFILLER_40_983 VDD VSS sg13g2_decap_4
XFILLER_106_1066 VDD VSS sg13g2_fill_1
X_13997__2182 _13997_/RESET_B VDD VSS sg13g2_tiehi
XFILLER_129_348 VDD VSS sg13g2_decap_8
X_11505_ _11505_/X _11636_/A _11506_/B VDD VSS sg13g2_and2_1
XFILLER_129_359 VDD VSS sg13g2_fill_1
XFILLER_157_679 VDD VSS sg13g2_decap_4
X_12485_ _14998_/D _12485_/A _12485_/B VDD VSS sg13g2_nor2_1
XFILLER_7_133 VDD VSS sg13g2_decap_8
XFILLER_156_178 VDD VSS sg13g2_decap_4
X_14224_ _14224_/Q _14512_/CLK _14224_/D _14224_/RESET_B VDD VSS sg13g2_dfrbpq_1
XFILLER_32_1274 VDD VSS sg13g2_decap_8
X_11436_ _11436_/X _14368_/Q _14400_/Q _14464_/Q _14496_/Q _11489_/S0 _11489_/S1 VDD
+ VSS sg13g2_mux4_1
XFILLER_22_91 VDD VSS sg13g2_decap_8
XFILLER_171_126 VDD VSS sg13g2_decap_8
XFILLER_99_906 VDD VSS sg13g2_decap_8
X_14155_ _14155_/Q clkload0/A _14155_/D _14155_/RESET_B VDD VSS sg13g2_dfrbpq_1
XFILLER_4_840 VDD VSS sg13g2_decap_8
X_11367_ _11367_/Y _11362_/Y _11363_/Y _11881_/C1 VDD VSS sg13g2_a21oi_1
XFILLER_98_62 VDD VSS sg13g2_decap_4
XFILLER_154_1307 VDD VSS sg13g2_decap_8
X_13106_ _13106_/Y _14850_/Q _13150_/B VDD VSS sg13g2_nand2_1
XFILLER_98_427 VDD VSS sg13g2_decap_8
XFILLER_3_350 VDD VSS sg13g2_decap_8
X_10318_ _10319_/C _10342_/A _14799_/Q _10327_/B _10327_/C VDD VSS sg13g2_and4_1
X_14086_ _14086_/Q _14662_/CLK _14086_/D _14086_/RESET_B VDD VSS sg13g2_dfrbpq_1
X_11298_ _11298_/Y _11300_/S0 _13917_/Q _11325_/B1 VDD VSS sg13g2_a21oi_1
XFILLER_65_1050 VDD VSS sg13g2_decap_8
XFILLER_112_248 VDD VSS sg13g2_decap_8
XFILLER_140_557 VDD VSS sg13g2_decap_8
X_13037_ _13037_/Y _14909_/Q _13678_/Q VDD VSS sg13g2_nor2_1
XFILLER_79_652 VDD VSS sg13g2_decap_8
XFILLER_65_1072 VDD VSS sg13g2_decap_4
X_14339__1840 _14339_/RESET_B VDD VSS sg13g2_tiehi
X_10249_ _10251_/A _14778_/Q _10255_/D _10295_/C VDD VSS sg13g2_o21ai_1
XFILLER_6_1106 VDD VSS sg13g2_decap_8
XFILLER_65_1094 VDD VSS sg13g2_decap_8
XFILLER_152_1053 VDD VSS sg13g2_decap_8
Xfanout1140 _11635_/A _08376_/A3 VDD VSS sg13g2_buf_1
XFILLER_66_302 VDD VSS sg13g2_decap_8
XFILLER_26_1056 VDD VSS sg13g2_decap_8
Xfanout1151 _08867_/A1 _14966_/Q VDD VSS sg13g2_buf_1
Xfanout1162 _11428_/A _07912_/B VDD VSS sg13g2_buf_1
XFILLER_152_1086 VDD VSS sg13g2_decap_8
Xfanout1173 _12900_/C _12867_/C VDD VSS sg13g2_buf_1
Xfanout1184 _10760_/A _14917_/Q VDD VSS sg13g2_buf_1
XFILLER_94_655 VDD VSS sg13g2_decap_8
Xfanout1195 _10649_/B _14873_/Q VDD VSS sg13g2_buf_1
XFILLER_93_143 VDD VSS sg13g2_decap_8
XFILLER_82_806 VDD VSS sg13g2_decap_8
XFILLER_66_368 VDD VSS sg13g2_decap_8
X_14988_ _14988_/Q clkload53/A _14988_/D _14988_/RESET_B VDD VSS sg13g2_dfrbpq_1
XFILLER_19_273 VDD VSS sg13g2_decap_8
X_13939_ _13939_/Q clkload27/A _13939_/D _13939_/RESET_B VDD VSS sg13g2_dfrbpq_1
XFILLER_35_744 VDD VSS sg13g2_decap_8
XFILLER_74_1308 VDD VSS sg13g2_fill_2
XFILLER_35_755 VDD VSS sg13g2_fill_1
XFILLER_74_1319 VDD VSS sg13g2_decap_4
XFILLER_16_980 VDD VSS sg13g2_decap_8
XFILLER_62_596 VDD VSS sg13g2_decap_4
XFILLER_22_427 VDD VSS sg13g2_decap_8
XFILLER_34_298 VDD VSS sg13g2_fill_2
XFILLER_15_490 VDD VSS sg13g2_decap_8
XFILLER_37_1152 VDD VSS sg13g2_decap_8
XFILLER_163_1160 VDD VSS sg13g2_fill_2
XFILLER_124_1122 VDD VSS sg13g2_decap_8
X_09130_ _09130_/Y _13200_/A _09157_/C _09129_/Y VDD VSS sg13g2_a21oi_1
XFILLER_147_112 VDD VSS sg13g2_decap_8
X_14441__1738 _14441_/RESET_B VDD VSS sg13g2_tiehi
XFILLER_148_657 VDD VSS sg13g2_decap_8
X_13827__2352 _13827_/RESET_B VDD VSS sg13g2_tiehi
XFILLER_120_1008 VDD VSS sg13g2_decap_8
X_14587__1592 _14587_/RESET_B VDD VSS sg13g2_tiehi
X_09061_ _09061_/Y _13064_/A _09089_/C _09117_/A VDD VSS sg13g2_o21ai_1
XFILLER_147_167 VDD VSS sg13g2_decap_8
X_08012_ _08012_/Y _08054_/B _08012_/B VDD VSS sg13g2_nand2_1
XFILLER_118_28 VDD VSS sg13g2_decap_8
XFILLER_162_126 VDD VSS sg13g2_decap_8
XFILLER_144_841 VDD VSS sg13g2_decap_8
XFILLER_11_1358 VDD VSS sg13g2_decap_8
XFILLER_143_340 VDD VSS sg13g2_decap_4
XFILLER_143_384 VDD VSS sg13g2_decap_8
X_09963_ _14547_/D _14547_/Q _10095_/A0 _09966_/S VDD VSS sg13g2_mux2_1
XFILLER_103_226 VDD VSS sg13g2_decap_8
XFILLER_104_749 VDD VSS sg13g2_decap_8
X_08914_ _08914_/Y _08912_/Y _08913_/Y _08955_/S VDD VSS sg13g2_a21oi_1
XFILLER_58_803 VDD VSS sg13g2_decap_8
X_09894_ _14480_/D _09927_/A1 _14480_/Q _09895_/S VDD VSS sg13g2_mux2_1
XFILLER_98_994 VDD VSS sg13g2_decap_8
XFILLER_97_471 VDD VSS sg13g2_decap_8
XFILLER_44_1156 VDD VSS sg13g2_decap_8
XFILLER_69_173 VDD VSS sg13g2_decap_8
X_08845_ _08845_/Y _15024_/Q _10669_/S _08844_/Y VDD VSS sg13g2_a21oi_1
XFILLER_27_14 VDD VSS sg13g2_decap_8
XFILLER_79_1219 VDD VSS sg13g2_decap_8
XFILLER_100_988 VDD VSS sg13g2_decap_8
X_08776_ _08776_/Y _07720_/C _15116_/Q _15185_/Q _07719_/X VDD VSS sg13g2_a22oi_1
XFILLER_100_999 VDD VSS sg13g2_fill_2
XFILLER_85_688 VDD VSS sg13g2_decap_4
XFILLER_73_839 VDD VSS sg13g2_decap_8
XFILLER_72_327 VDD VSS sg13g2_decap_8
X_07727_ _07727_/Y _13206_/B _07727_/B _13249_/B VDD VSS sg13g2_nor3_1
XFILLER_66_891 VDD VSS sg13g2_fill_1
XFILLER_38_582 VDD VSS sg13g2_decap_4
XFILLER_25_210 VDD VSS sg13g2_decap_8
XFILLER_168_7 VDD VSS sg13g2_decap_8
XFILLER_26_766 VDD VSS sg13g2_decap_8
XFILLER_14_917 VDD VSS sg13g2_decap_8
X_14978__2609 _14978_/RESET_B VDD VSS sg13g2_tiehi
X_07658_ _07658_/X _14749_/Q _10210_/D VDD VSS sg13g2_and2_1
XFILLER_168_1093 VDD VSS sg13g2_decap_8
XFILLER_81_894 VDD VSS sg13g2_decap_8
XFILLER_0_1283 VDD VSS sg13g2_decap_8
XFILLER_13_427 VDD VSS sg13g2_decap_8
XFILLER_90_1110 VDD VSS sg13g2_decap_8
XFILLER_43_35 VDD VSS sg13g2_decap_8
XFILLER_159_35 VDD VSS sg13g2_decap_8
XFILLER_16_1225 VDD VSS sg13g2_decap_8
X_09328_ _13935_/D _09926_/A1 _13935_/Q _09334_/S VDD VSS sg13g2_mux2_1
XFILLER_138_101 VDD VSS sg13g2_decap_8
XFILLER_40_268 VDD VSS sg13g2_decap_8
XFILLER_139_635 VDD VSS sg13g2_fill_1
XFILLER_167_944 VDD VSS sg13g2_decap_8
XFILLER_22_983 VDD VSS sg13g2_decap_8
XFILLER_90_1198 VDD VSS sg13g2_decap_8
XFILLER_142_1277 VDD VSS sg13g2_decap_4
X_14417__1762 _14417_/RESET_B VDD VSS sg13g2_tiehi
X_09259_ _13868_/D _13868_/Q _10155_/A1 _09267_/S VDD VSS sg13g2_mux2_1
XFILLER_154_616 VDD VSS sg13g2_decap_8
XFILLER_166_476 VDD VSS sg13g2_decap_8
XFILLER_138_178 VDD VSS sg13g2_fill_1
X_12270_ _14986_/D _12270_/A _12270_/B VDD VSS sg13g2_nor2_1
XFILLER_153_126 VDD VSS sg13g2_decap_4
XFILLER_5_637 VDD VSS sg13g2_decap_8
XFILLER_147_690 VDD VSS sg13g2_fill_1
X_11221_ _11222_/B _13723_/Q _14075_/Q _14427_/Q _14523_/Q _11212_/S _11878_/B1 VDD
+ VSS sg13g2_mux4_1
XFILLER_4_147 VDD VSS sg13g2_decap_8
XFILLER_107_565 VDD VSS sg13g2_decap_8
XFILLER_134_384 VDD VSS sg13g2_decap_8
X_11152_ _11152_/Y _11164_/B _11152_/B VDD VSS sg13g2_xnor2_1
XFILLER_150_844 VDD VSS sg13g2_decap_4
XFILLER_68_21 VDD VSS sg13g2_decap_8
XFILLER_96_909 VDD VSS sg13g2_fill_2
XFILLER_62_1201 VDD VSS sg13g2_decap_8
X_14906__2732 _14906_/RESET_B VDD VSS sg13g2_tiehi
X_10103_ wire421/A _10105_/C _10105_/D _10105_/B VDD VSS sg13g2_nand3_1
XFILLER_1_854 VDD VSS sg13g2_decap_8
XFILLER_122_568 VDD VSS sg13g2_fill_1
X_11083_ _14947_/D _11082_/Y _11081_/Y _11074_/Y VDD VSS sg13g2_o21ai_1
X_13688__2496 _13688_/RESET_B VDD VSS sg13g2_tiehi
XFILLER_89_983 VDD VSS sg13g2_decap_8
XFILLER_88_460 VDD VSS sg13g2_fill_2
XFILLER_0_364 VDD VSS sg13g2_decap_8
XFILLER_49_825 VDD VSS sg13g2_decap_4
XFILLER_88_471 VDD VSS sg13g2_decap_8
XFILLER_62_1256 VDD VSS sg13g2_fill_1
XFILLER_27_1376 VDD VSS sg13g2_decap_4
X_14911_ _14911_/Q clkload43/A _14911_/D _14911_/RESET_B VDD VSS sg13g2_dfrbpq_1
X_10034_ _14616_/D _10100_/A0 _14616_/Q _10035_/S VDD VSS sg13g2_mux2_1
XFILLER_48_324 VDD VSS sg13g2_decap_8
X_14842_ _14842_/Q _14854_/CLK _14842_/D _14842_/RESET_B VDD VSS sg13g2_dfrbpq_1
XFILLER_84_42 VDD VSS sg13g2_decap_8
XFILLER_17_700 VDD VSS sg13g2_decap_8
X_13905__2274 _13905_/RESET_B VDD VSS sg13g2_tiehi
X_14939__2666 _14939_/RESET_B VDD VSS sg13g2_tiehi
XFILLER_5_1183 VDD VSS sg13g2_decap_8
XFILLER_90_113 VDD VSS sg13g2_decap_8
XFILLER_16_210 VDD VSS sg13g2_decap_8
X_14773_ _14773_/Q _15113_/CLK _14773_/D _14773_/RESET_B VDD VSS sg13g2_dfrbpq_1
X_11985_ _11988_/B _12055_/A _11917_/A _11986_/B VDD VSS sg13g2_o21ai_1
XFILLER_90_135 VDD VSS sg13g2_decap_8
XFILLER_1_1036 VDD VSS sg13g2_decap_8
XFILLER_56_390 VDD VSS sg13g2_fill_2
X_13724_ _13724_/Q clkload44/A _13724_/D _13724_/RESET_B VDD VSS sg13g2_dfrbpq_1
X_10936_ _10965_/C _10936_/A _10936_/B _10936_/C _10936_/D VDD VSS sg13g2_nand4_1
XFILLER_17_777 VDD VSS sg13g2_decap_8
XFILLER_17_91 VDD VSS sg13g2_decap_8
XFILLER_95_1076 VDD VSS sg13g2_decap_8
XFILLER_108_1117 VDD VSS sg13g2_decap_8
XFILLER_16_287 VDD VSS sg13g2_decap_8
XFILLER_32_736 VDD VSS sg13g2_decap_8
X_13655_ _15121_/D _08717_/X _15121_/Q _13655_/S VDD VSS sg13g2_mux2_1
X_10867_ _10867_/Y _10890_/A _10868_/C _10890_/B VDD VSS sg13g2_o21ai_1
XFILLER_73_1341 VDD VSS sg13g2_decap_8
XFILLER_147_1188 VDD VSS sg13g2_decap_8
XFILLER_9_910 VDD VSS sg13g2_decap_8
X_12606_ _12606_/X _14253_/Q _14285_/Q _14317_/Q _14349_/Q _12606_/S0 _12606_/S1 VDD
+ VSS sg13g2_mux4_1
XFILLER_34_1325 VDD VSS sg13g2_decap_8
X_13586_ _13586_/Y _15002_/Q _13566_/B _13569_/S _15018_/Q _13537_/X VDD VSS sg13g2_a221oi_1
XFILLER_83_7 VDD VSS sg13g2_decap_8
X_10798_ _10798_/X _10807_/B _10798_/B VDD VSS sg13g2_xor2_1
XFILLER_13_994 VDD VSS sg13g2_decap_8
XFILLER_8_420 VDD VSS sg13g2_decap_8
XFILLER_121_1306 VDD VSS sg13g2_fill_1
X_12537_ _12537_/X _12534_/X _12533_/X _12530_/X _12529_/X _12608_/S1 _12664_/S VDD
+ VSS sg13g2_mux4_1
XFILLER_9_987 VDD VSS sg13g2_decap_8
X_15117__2725 _15117_/RESET_B VDD VSS sg13g2_tiehi
X_12468_ _12468_/X _12466_/X _12465_/X _12462_/X _12461_/X _12719_/S0 _12720_/S VDD
+ VSS sg13g2_mux4_1
XFILLER_172_435 VDD VSS sg13g2_decap_8
XFILLER_8_497 VDD VSS sg13g2_decap_8
XFILLER_32_1082 VDD VSS sg13g2_decap_8
XFILLER_126_863 VDD VSS sg13g2_decap_8
X_14207_ _14207_/Q clkload9/A _14207_/D _14207_/RESET_B VDD VSS sg13g2_dfrbpq_1
X_11419_ _11420_/B _11419_/A _11419_/B _11419_/C VDD VSS sg13g2_nand3_1
XFILLER_67_1112 VDD VSS sg13g2_decap_8
X_15187_ _15187_/Q _15188_/CLK _15187_/D _15187_/RESET_B VDD VSS sg13g2_dfrbpq_1
XFILLER_125_351 VDD VSS sg13g2_decap_8
XFILLER_141_800 VDD VSS sg13g2_decap_8
X_12399_ _12400_/B _12397_/X _12398_/X _12790_/S VDD VSS sg13g2_mux2_1
XFILLER_99_725 VDD VSS sg13g2_fill_1
X_14138_ _14138_/Q _14682_/CLK _14138_/D _14138_/RESET_B VDD VSS sg13g2_dfrbpq_1
X_15220__2988 _15220_/RESET_B VDD VSS sg13g2_tiehi
XFILLER_98_224 VDD VSS sg13g2_decap_8
XFILLER_152_181 VDD VSS sg13g2_decap_8
XFILLER_158_1295 VDD VSS sg13g2_fill_1
XFILLER_141_855 VDD VSS sg13g2_decap_8
XFILLER_87_909 VDD VSS sg13g2_fill_1
XFILLER_101_719 VDD VSS sg13g2_decap_8
X_14069_ _14069_/Q _14677_/CLK _14069_/D _14069_/RESET_B VDD VSS sg13g2_dfrbpq_1
XFILLER_86_408 VDD VSS sg13g2_decap_8
XFILLER_98_279 VDD VSS sg13g2_decap_8
XFILLER_39_313 VDD VSS sg13g2_decap_4
XFILLER_95_942 VDD VSS sg13g2_decap_8
XFILLER_95_953 VDD VSS sg13g2_fill_1
XFILLER_39_346 VDD VSS sg13g2_decap_8
X_08630_ _08630_/Y _08649_/S _08629_/Y _08628_/Y VDD VSS sg13g2_o21ai_1
XFILLER_66_143 VDD VSS sg13g2_decap_4
XFILLER_55_828 VDD VSS sg13g2_fill_2
XFILLER_27_519 VDD VSS sg13g2_decap_8
XFILLER_66_176 VDD VSS sg13g2_fill_2
X_08561_ _08561_/Y _08659_/A _08659_/B _08561_/C VDD VSS sg13g2_nor3_1
XFILLER_82_658 VDD VSS sg13g2_decap_8
XFILLER_78_1252 VDD VSS sg13g2_decap_8
XFILLER_78_1263 VDD VSS sg13g2_fill_2
XFILLER_39_1225 VDD VSS sg13g2_fill_2
X_08492_ _08574_/C _07950_/A _07949_/B _07807_/C _08476_/A VDD VSS sg13g2_a22oi_1
XFILLER_78_1296 VDD VSS sg13g2_fill_2
XFILLER_22_224 VDD VSS sg13g2_decap_8
X_14674__1505 _14674_/RESET_B VDD VSS sg13g2_tiehi
XFILLER_165_1299 VDD VSS sg13g2_decap_8
X_09113_ _09113_/Y _15242_/Q _09154_/B VDD VSS sg13g2_nand2b_1
XFILLER_13_49 VDD VSS sg13g2_decap_8
XFILLER_129_49 VDD VSS sg13g2_decap_8
XFILLER_163_413 VDD VSS sg13g2_decap_8
X_09044_ _09044_/X _09057_/A _09044_/B _09056_/C VDD VSS sg13g2_or3_1
XFILLER_135_148 VDD VSS sg13g2_decap_8
XFILLER_11_1155 VDD VSS sg13g2_decap_8
XFILLER_132_822 VDD VSS sg13g2_decap_8
XFILLER_144_682 VDD VSS sg13g2_decap_8
XFILLER_46_1207 VDD VSS sg13g2_decap_8
XFILLER_131_310 VDD VSS sg13g2_decap_8
XFILLER_172_1226 VDD VSS sg13g2_fill_1
XFILLER_137_1357 VDD VSS sg13g2_decap_8
Xfanout900 _12870_/A2 _07682_/A VDD VSS sg13g2_buf_1
Xfanout911 _13238_/B2 _13271_/C VDD VSS sg13g2_buf_1
Xfanout922 _13552_/B _13563_/B VDD VSS sg13g2_buf_1
X_09946_ _14530_/D _14530_/Q _10012_/A0 _09966_/S VDD VSS sg13g2_mux2_1
Xfanout933 _13429_/A _13396_/C VDD VSS sg13g2_buf_1
Xfanout944 _13481_/A _15127_/Q VDD VSS sg13g2_buf_1
XFILLER_58_611 VDD VSS sg13g2_decap_4
Xfanout955 _13234_/B _13273_/B VDD VSS sg13g2_buf_1
Xfanout966 _08698_/B _08497_/A VDD VSS sg13g2_buf_1
XFILLER_58_633 VDD VSS sg13g2_decap_8
XFILLER_38_35 VDD VSS sg13g2_decap_8
XFILLER_161_14 VDD VSS sg13g2_decap_8
Xfanout977 _10898_/B1 _13310_/B2 VDD VSS sg13g2_buf_1
X_09877_ _14463_/D _09877_/A0 _14463_/Q _09895_/S VDD VSS sg13g2_mux2_1
XFILLER_86_953 VDD VSS sg13g2_decap_8
Xfanout988 _13342_/A1 _15068_/Q VDD VSS sg13g2_buf_1
XFILLER_85_441 VDD VSS sg13g2_fill_2
Xfanout999 _09441_/A _15064_/Q VDD VSS sg13g2_buf_1
XFILLER_86_986 VDD VSS sg13g2_decap_4
XFILLER_73_603 VDD VSS sg13g2_decap_4
XFILLER_46_817 VDD VSS sg13g2_fill_1
XFILLER_100_774 VDD VSS sg13g2_fill_2
X_08828_ _08828_/Y _14766_/Q _10172_/A VDD VSS sg13g2_nor2_1
XFILLER_22_1240 VDD VSS sg13g2_decap_8
XFILLER_72_102 VDD VSS sg13g2_fill_2
XFILLER_73_636 VDD VSS sg13g2_decap_8
XFILLER_2_1323 VDD VSS sg13g2_decap_8
X_08759_ _13671_/D _08762_/A1 _08757_/Y _08758_/Y VDD VSS sg13g2_a21oi_1
XFILLER_61_809 VDD VSS sg13g2_fill_2
XFILLER_72_157 VDD VSS sg13g2_decap_8
X_11770_ _11910_/A _11770_/A _13064_/B VDD VSS sg13g2_xnor2_1
XFILLER_92_1205 VDD VSS sg13g2_decap_8
XFILLER_14_714 VDD VSS sg13g2_decap_8
XFILLER_54_894 VDD VSS sg13g2_decap_8
X_13699__2480 _13699_/RESET_B VDD VSS sg13g2_tiehi
X_10721_ _10965_/B _14939_/Q _10735_/A _10720_/Y VDD VSS sg13g2_a21oi_1
XFILLER_18_1309 VDD VSS sg13g2_decap_8
XFILLER_0_1080 VDD VSS sg13g2_decap_8
XFILLER_13_224 VDD VSS sg13g2_decap_8
XFILLER_41_555 VDD VSS sg13g2_decap_8
XFILLER_110_62 VDD VSS sg13g2_fill_1
X_13440_ _13440_/Y _13440_/A _13440_/B _15102_/Q VDD VSS sg13g2_nand3_1
XFILLER_55_1060 VDD VSS sg13g2_decap_8
X_10652_ _10653_/D _10652_/A _10652_/B _10652_/C _10652_/D VDD VSS sg13g2_nor4_1
XFILLER_9_217 VDD VSS sg13g2_decap_8
XFILLER_139_421 VDD VSS sg13g2_decap_8
XFILLER_16_1022 VDD VSS sg13g2_decap_8
XFILLER_110_84 VDD VSS sg13g2_decap_8
XFILLER_22_780 VDD VSS sg13g2_decap_4
XFILLER_103_1003 VDD VSS sg13g2_decap_4
XFILLER_10_931 VDD VSS sg13g2_decap_8
X_13371_ _15076_/D _13361_/C _13442_/A _13369_/Y VDD VSS sg13g2_o21ai_1
XFILLER_107_1183 VDD VSS sg13g2_fill_2
X_10583_ _10594_/D _14872_/Q _14871_/Q _10591_/C _10583_/D VDD VSS sg13g2_and4_1
XFILLER_127_616 VDD VSS sg13g2_fill_2
XFILLER_154_402 VDD VSS sg13g2_decap_8
XFILLER_166_273 VDD VSS sg13g2_decap_8
XFILLER_16_1099 VDD VSS sg13g2_decap_8
X_15110_ _15110_/Q _15113_/CLK _15110_/D _15110_/RESET_B VDD VSS sg13g2_dfrbpq_1
X_12322_ _12322_/Y _12318_/Y _12319_/Y _12321_/Y _12320_/Y _11266_/B VDD VSS sg13g2_a221oi_1
XFILLER_6_924 VDD VSS sg13g2_decap_8
XFILLER_5_434 VDD VSS sg13g2_decap_8
XFILLER_154_457 VDD VSS sg13g2_decap_8
X_15041_ _15041_/Q _15064_/CLK _15041_/D _15041_/RESET_B VDD VSS sg13g2_dfrbpq_1
XFILLER_120_1372 VDD VSS sg13g2_fill_2
X_12253_ _12253_/X _12253_/A _12253_/B VDD VSS sg13g2_and2_1
XFILLER_108_896 VDD VSS sg13g2_fill_1
XFILLER_135_682 VDD VSS sg13g2_fill_2
X_11204_ _11204_/Y _11203_/Y _11201_/A _11201_/Y _11202_/Y _11151_/A VDD VSS sg13g2_a221oi_1
XFILLER_135_693 VDD VSS sg13g2_fill_1
XFILLER_64_1307 VDD VSS sg13g2_fill_1
X_12184_ _12188_/A _12183_/X _12233_/B VDD VSS sg13g2_nand2b_1
XFILLER_79_75 VDD VSS sg13g2_decap_8
X_11135_ _11136_/B _11145_/A _11147_/A _11128_/Y VDD VSS sg13g2_o21ai_1
XFILLER_96_728 VDD VSS sg13g2_fill_1
XFILLER_68_419 VDD VSS sg13g2_decap_4
XFILLER_1_651 VDD VSS sg13g2_decap_8
XFILLER_110_527 VDD VSS sg13g2_decap_8
XFILLER_135_70 VDD VSS sg13g2_decap_8
X_14827__2886 _14827_/RESET_B VDD VSS sg13g2_tiehi
XFILLER_0_161 VDD VSS sg13g2_decap_8
XFILLER_89_791 VDD VSS sg13g2_decap_8
XFILLER_62_1042 VDD VSS sg13g2_decap_8
XFILLER_118_1290 VDD VSS sg13g2_decap_8
X_11066_ _11066_/Y _11118_/A _11088_/A _11139_/B1 VDD VSS sg13g2_o21ai_1
XFILLER_27_1173 VDD VSS sg13g2_decap_8
XFILLER_103_590 VDD VSS sg13g2_decap_8
X_15146__2665 _15146_/RESET_B VDD VSS sg13g2_tiehi
XFILLER_95_63 VDD VSS sg13g2_decap_4
XFILLER_7_1267 VDD VSS sg13g2_decap_8
XFILLER_76_441 VDD VSS sg13g2_decap_8
XFILLER_37_806 VDD VSS sg13g2_decap_8
X_10017_ _14599_/D _10083_/A0 _14599_/Q _10032_/S VDD VSS sg13g2_mux2_1
XFILLER_64_603 VDD VSS sg13g2_fill_2
XFILLER_49_688 VDD VSS sg13g2_decap_8
X_14825_ _14825_/Q _14890_/CLK _14825_/D _14825_/RESET_B VDD VSS sg13g2_dfrbpq_1
XFILLER_63_124 VDD VSS sg13g2_fill_2
XFILLER_40_1373 VDD VSS sg13g2_decap_8
X_14756_ _14756_/Q clkload64/A _14756_/D _14756_/RESET_B VDD VSS sg13g2_dfrbpq_1
XFILLER_17_574 VDD VSS sg13g2_decap_8
X_11968_ _11970_/A _12025_/A _13904_/Q VDD VSS sg13g2_nand2b_1
X_13707_ _16869_/A clkload43/A _13707_/D _13707_/RESET_B VDD VSS sg13g2_dfrbpq_1
X_14289__1890 _14289_/RESET_B VDD VSS sg13g2_tiehi
X_10919_ _10920_/B _10904_/B _10945_/B _10945_/A VDD VSS sg13g2_a21oi_1
X_14687_ _14687_/Q clkload9/A _14687_/D _14687_/RESET_B VDD VSS sg13g2_dfrbpq_1
X_11899_ _11900_/A _13966_/Q _13998_/Q _14030_/Q _14062_/Q _11896_/A _11899_/S1 VDD
+ VSS sg13g2_mux4_1
X_13638_ _13746_/D _13638_/A VDD VSS sg13g2_buf_1
XFILLER_32_588 VDD VSS sg13g2_decap_8
XFILLER_20_728 VDD VSS sg13g2_decap_8
XFILLER_73_1182 VDD VSS sg13g2_fill_1
XFILLER_13_791 VDD VSS sg13g2_decap_8
XFILLER_118_616 VDD VSS sg13g2_decap_8
X_13569_ _13569_/X _14996_/Q _15012_/Q _13569_/S VDD VSS sg13g2_mux2_1
XFILLER_160_1174 VDD VSS sg13g2_decap_8
XFILLER_158_796 VDD VSS sg13g2_decap_8
XFILLER_9_784 VDD VSS sg13g2_decap_8
XFILLER_121_1147 VDD VSS sg13g2_fill_2
XFILLER_146_947 VDD VSS sg13g2_decap_8
XFILLER_172_210 VDD VSS sg13g2_decap_8
XFILLER_146_969 VDD VSS sg13g2_decap_8
XFILLER_8_294 VDD VSS sg13g2_decap_8
XFILLER_145_468 VDD VSS sg13g2_fill_1
XFILLER_145_479 VDD VSS sg13g2_decap_8
X_15239_ _15239_/Q clkload58/A _15239_/D _15239_/RESET_B VDD VSS sg13g2_dfrbpq_1
XFILLER_141_630 VDD VSS sg13g2_decap_8
XFILLER_113_343 VDD VSS sg13g2_decap_8
Xfanout207 _09625_/A0 _10056_/A0 VDD VSS sg13g2_buf_1
X_09800_ _14389_/D _10164_/A1 _14389_/Q _09800_/S VDD VSS sg13g2_mux2_1
XFILLER_141_663 VDD VSS sg13g2_fill_1
Xfanout218 _10155_/A1 fanout219/X VDD VSS sg13g2_buf_1
Xfanout229 _09789_/A0 _09058_/Y VDD VSS sg13g2_buf_1
X_07992_ _15250_/D _13654_/S _07991_/A _07988_/Y VDD VSS sg13g2_a21oi_1
X_14391__1788 _14391_/RESET_B VDD VSS sg13g2_tiehi
X_09731_ _14322_/D _10061_/A0 _14322_/Q _09737_/S VDD VSS sg13g2_mux2_1
XFILLER_80_1153 VDD VSS sg13g2_fill_2
XFILLER_132_1232 VDD VSS sg13g2_decap_8
Xclkbuf_4_14_0_clk_i clkbuf_4_14_0_clk_i/X clkbuf_0_clk_i/X VDD VSS sg13g2_buf_8
XFILLER_171_1292 VDD VSS sg13g2_decap_8
XFILLER_80_1186 VDD VSS sg13g2_decap_8
XFILLER_68_975 VDD VSS sg13g2_decap_8
XFILLER_67_452 VDD VSS sg13g2_decap_8
X_14728__1451 _14728_/RESET_B VDD VSS sg13g2_tiehi
X_09662_ _14255_/D _10125_/A0 _14255_/Q _09664_/S VDD VSS sg13g2_mux2_1
XFILLER_95_772 VDD VSS sg13g2_fill_1
XFILLER_67_474 VDD VSS sg13g2_fill_2
XFILLER_94_260 VDD VSS sg13g2_decap_4
XFILLER_83_934 VDD VSS sg13g2_decap_8
X_08613_ _08613_/Y _08641_/B _08612_/X _08667_/A1 VDD VSS sg13g2_a21oi_1
XFILLER_55_647 VDD VSS sg13g2_fill_1
X_09593_ _14190_/D _14190_/Q _10090_/A0 _09599_/S VDD VSS sg13g2_mux2_1
X_14011__2168 _14011_/RESET_B VDD VSS sg13g2_tiehi
XFILLER_82_455 VDD VSS sg13g2_decap_8
XFILLER_36_861 VDD VSS sg13g2_fill_2
X_08544_ _08545_/D _08544_/A _08544_/B _08617_/A VDD VSS sg13g2_nand3_1
XFILLER_78_1060 VDD VSS sg13g2_decap_8
XFILLER_23_511 VDD VSS sg13g2_decap_8
XFILLER_39_1044 VDD VSS sg13g2_decap_8
X_08475_ _08475_/Y _08475_/A _08475_/B _08475_/C _08475_/D VDD VSS sg13g2_nor4_1
XFILLER_165_1085 VDD VSS sg13g2_decap_8
XFILLER_11_728 VDD VSS sg13g2_decap_8
XFILLER_149_741 VDD VSS sg13g2_fill_2
XFILLER_104_1312 VDD VSS sg13g2_fill_1
XFILLER_10_238 VDD VSS sg13g2_decap_8
X_14923__2698 _14923_/RESET_B VDD VSS sg13g2_tiehi
XFILLER_143_1383 VDD VSS sg13g2_fill_1
XFILLER_40_14 VDD VSS sg13g2_decap_8
XFILLER_137_947 VDD VSS sg13g2_fill_2
XFILLER_13_1239 VDD VSS sg13g2_decap_8
XFILLER_148_273 VDD VSS sg13g2_decap_8
XFILLER_163_210 VDD VSS sg13g2_decap_8
XFILLER_164_733 VDD VSS sg13g2_decap_4
XFILLER_156_14 VDD VSS sg13g2_decap_8
XFILLER_164_766 VDD VSS sg13g2_decap_4
XFILLER_124_608 VDD VSS sg13g2_decap_8
XFILLER_152_917 VDD VSS sg13g2_decap_8
X_09027_ _09027_/X _15032_/Q _15229_/Q _09107_/B VDD VSS sg13g2_mux2_1
XFILLER_164_788 VDD VSS sg13g2_decap_4
XFILLER_152_939 VDD VSS sg13g2_fill_2
XFILLER_85_1020 VDD VSS sg13g2_decap_8
XFILLER_163_287 VDD VSS sg13g2_decap_8
XFILLER_3_938 VDD VSS sg13g2_decap_8
XFILLER_117_682 VDD VSS sg13g2_decap_8
XFILLER_2_448 VDD VSS sg13g2_decap_8
XFILLER_104_354 VDD VSS sg13g2_decap_8
XFILLER_78_717 VDD VSS sg13g2_decap_8
XFILLER_120_814 VDD VSS sg13g2_decap_8
XFILLER_132_674 VDD VSS sg13g2_fill_1
XFILLER_46_1048 VDD VSS sg13g2_fill_2
XFILLER_120_825 VDD VSS sg13g2_fill_1
XFILLER_49_56 VDD VSS sg13g2_decap_8
Xfanout730 _11045_/A2 _13412_/C VDD VSS sg13g2_buf_1
XFILLER_172_35 VDD VSS sg13g2_decap_8
X_14221__1958 _14221_/RESET_B VDD VSS sg13g2_tiehi
Xfanout741 _08177_/S _08511_/S VDD VSS sg13g2_buf_1
XFILLER_24_1302 VDD VSS sg13g2_decap_8
Xfanout752 _08363_/S0 _08329_/B VDD VSS sg13g2_buf_1
X_09929_ _14514_/D _14514_/Q _09111_/Y _09935_/S VDD VSS sg13g2_mux2_1
Xfanout763 _09141_/A _08992_/A VDD VSS sg13g2_buf_1
XFILLER_59_953 VDD VSS sg13g2_decap_8
XFILLER_150_1332 VDD VSS sg13g2_fill_1
Xfanout774 _10956_/C _15250_/Q VDD VSS sg13g2_buf_1
Xfanout785 _12539_/S _12761_/S1 VDD VSS sg13g2_buf_1
Xfanout796 _12775_/S1 _12454_/S1 VDD VSS sg13g2_buf_1
X_12940_ _12941_/B _07683_/A _12939_/Y _12928_/X _12878_/D _12932_/Y VDD VSS sg13g2_a221oi_1
XFILLER_86_772 VDD VSS sg13g2_decap_8
XFILLER_105_84 VDD VSS sg13g2_decap_8
XFILLER_24_1379 VDD VSS sg13g2_fill_1
XFILLER_74_945 VDD VSS sg13g2_decap_8
XFILLER_46_647 VDD VSS sg13g2_fill_2
XFILLER_2_1120 VDD VSS sg13g2_decap_8
X_12871_ _15025_/D _13507_/A _12871_/B VDD VSS sg13g2_nor2_1
XFILLER_73_444 VDD VSS sg13g2_decap_8
XFILLER_65_66 VDD VSS sg13g2_fill_1
XFILLER_74_989 VDD VSS sg13g2_decap_8
X_14610_ _14610_/Q _14706_/CLK _14610_/D _14610_/RESET_B VDD VSS sg13g2_dfrbpq_1
X_11822_ _11822_/X _11822_/A _11875_/B VDD VSS sg13g2_and2_1
XFILLER_27_883 VDD VSS sg13g2_decap_8
XFILLER_14_511 VDD VSS sg13g2_decap_8
Xclkbuf_5_29__f_clk_i clkbuf_leaf_83_clk_i/A clkbuf_4_14_0_clk_i/X VDD VSS sg13g2_buf_16
XFILLER_96_1171 VDD VSS sg13g2_fill_1
XFILLER_92_1013 VDD VSS sg13g2_decap_4
XFILLER_60_127 VDD VSS sg13g2_decap_8
XFILLER_2_1197 VDD VSS sg13g2_decap_8
XFILLER_26_382 VDD VSS sg13g2_decap_8
XFILLER_157_0 VDD VSS sg13g2_decap_8
X_14541_ _14541_/Q clkload3/A _14541_/D _14541_/RESET_B VDD VSS sg13g2_dfrbpq_1
X_11753_ _11754_/A _14250_/Q _14282_/Q _14314_/Q _14346_/Q _11893_/S _11897_/C VDD
+ VSS sg13g2_mux4_1
XFILLER_81_21 VDD VSS sg13g2_decap_8
XFILLER_18_1106 VDD VSS sg13g2_decap_8
XFILLER_42_853 VDD VSS sg13g2_decap_8
XFILLER_121_94 VDD VSS sg13g2_fill_2
X_10704_ _10923_/B _09021_/X _10788_/S _08869_/Y VDD VSS sg13g2_a21oi_1
XFILLER_57_1188 VDD VSS sg13g2_decap_8
XFILLER_41_363 VDD VSS sg13g2_decap_8
XFILLER_14_588 VDD VSS sg13g2_decap_8
X_14472_ _14472_/Q _14666_/CLK _14472_/D _14472_/RESET_B VDD VSS sg13g2_dfrbpq_1
X_11684_ _11684_/Y _12100_/S0 _14504_/Q _11802_/B VDD VSS sg13g2_a21oi_1
X_14166__2013 _14166_/RESET_B VDD VSS sg13g2_tiehi
XFILLER_41_385 VDD VSS sg13g2_decap_8
XFILLER_128_903 VDD VSS sg13g2_decap_4
XFILLER_14_70 VDD VSS sg13g2_decap_8
X_13423_ _13423_/Y _13427_/A _13427_/B _13423_/C VDD VSS sg13g2_nand3_1
X_10635_ _10636_/B _14886_/Q _14885_/Q _14884_/Q _14883_/Q VDD VSS sg13g2_nand4_1
XFILLER_167_560 VDD VSS sg13g2_decap_8
XFILLER_155_722 VDD VSS sg13g2_decap_8
XFILLER_154_210 VDD VSS sg13g2_fill_2
X_13354_ _13364_/B _13401_/C _13401_/B VDD VSS sg13g2_nor2_1
XFILLER_6_721 VDD VSS sg13g2_decap_8
X_10566_ _10567_/D _14868_/Q _14867_/Q _14866_/Q _10566_/D VDD VSS sg13g2_nand4_1
XFILLER_128_969 VDD VSS sg13g2_decap_4
X_12305_ _12307_/A _12303_/S _14202_/Q VDD VSS sg13g2_nand2b_1
XFILLER_5_231 VDD VSS sg13g2_decap_8
XFILLER_155_777 VDD VSS sg13g2_decap_4
X_13285_ _13287_/C _13481_/A _07744_/D _13284_/Y VDD VSS sg13g2_a21oi_1
X_10497_ _10499_/A _14853_/Q _10497_/B VDD VSS sg13g2_nand2b_1
XFILLER_6_798 VDD VSS sg13g2_decap_8
XFILLER_68_1251 VDD VSS sg13g2_fill_2
XFILLER_108_693 VDD VSS sg13g2_decap_8
XFILLER_170_747 VDD VSS sg13g2_decap_8
X_15024_ _15024_/Q clkload72/A _15024_/D _15024_/RESET_B VDD VSS sg13g2_dfrbpq_1
X_12236_ _12237_/B _12236_/A _12236_/B _12236_/C VDD VSS sg13g2_nand3_1
XFILLER_142_449 VDD VSS sg13g2_fill_1
XFILLER_68_1262 VDD VSS sg13g2_fill_1
XFILLER_30_91 VDD VSS sg13g2_decap_8
XFILLER_46_7 VDD VSS sg13g2_decap_8
XFILLER_69_706 VDD VSS sg13g2_fill_2
XFILLER_155_1254 VDD VSS sg13g2_decap_8
X_12167_ _12169_/A _12168_/A _14646_/Q VDD VSS sg13g2_nand2b_1
XFILLER_29_1268 VDD VSS sg13g2_decap_8
XFILLER_151_994 VDD VSS sg13g2_decap_8
XFILLER_155_1276 VDD VSS sg13g2_fill_2
XFILLER_110_313 VDD VSS sg13g2_decap_4
XFILLER_116_1238 VDD VSS sg13g2_fill_2
XFILLER_155_1287 VDD VSS sg13g2_fill_2
XFILLER_150_493 VDD VSS sg13g2_fill_1
X_11118_ _11119_/B _11118_/A _11118_/B _11118_/C _11118_/D VDD VSS sg13g2_nand4_1
X_12098_ _12098_/Y _12316_/S0 _14676_/Q _11739_/B VDD VSS sg13g2_a21oi_1
X_14973__2614 _14973_/RESET_B VDD VSS sg13g2_tiehi
XFILLER_7_1064 VDD VSS sg13g2_decap_8
XFILLER_77_761 VDD VSS sg13g2_decap_8
X_11049_ _11064_/D _11185_/A _11068_/C VDD VSS sg13g2_xnor2_1
XFILLER_37_603 VDD VSS sg13g2_decap_8
XFILLER_37_614 VDD VSS sg13g2_fill_1
Xinput7 input7/X input7/A VDD VSS sg13g2_buf_1
XFILLER_49_485 VDD VSS sg13g2_decap_8
XFILLER_64_411 VDD VSS sg13g2_decap_8
XFILLER_36_102 VDD VSS sg13g2_fill_1
XFILLER_64_422 VDD VSS sg13g2_fill_1
XFILLER_49_496 VDD VSS sg13g2_fill_1
XFILLER_76_293 VDD VSS sg13g2_decap_8
XFILLER_149_1025 VDD VSS sg13g2_decap_8
X_14376__1803 _14376_/RESET_B VDD VSS sg13g2_tiehi
XFILLER_18_861 VDD VSS sg13g2_decap_8
X_14808_ _14808_/Q clkload51/A _14808_/D _14808_/RESET_B VDD VSS sg13g2_dfrbpq_1
XFILLER_24_308 VDD VSS sg13g2_fill_2
XFILLER_92_797 VDD VSS sg13g2_decap_4
XFILLER_149_1069 VDD VSS sg13g2_decap_8
XFILLER_17_371 VDD VSS sg13g2_decap_8
XFILLER_127_1301 VDD VSS sg13g2_fill_2
X_14739_ _14739_/Q clkload25/A _14739_/D _14739_/RESET_B VDD VSS sg13g2_dfrbpq_1
XFILLER_36_1206 VDD VSS sg13g2_decap_8
XFILLER_162_1214 VDD VSS sg13g2_decap_8
X_08260_ _08260_/Y _08318_/B _08522_/C _08259_/Y VDD VSS sg13g2_a21oi_1
XFILLER_123_1209 VDD VSS sg13g2_decap_8
XFILLER_20_525 VDD VSS sg13g2_decap_8
X_08191_ _08191_/Y _07922_/Y _08248_/A _08190_/Y VDD VSS sg13g2_a21oi_1
XFILLER_119_925 VDD VSS sg13g2_decap_8
XFILLER_146_700 VDD VSS sg13g2_decap_8
XFILLER_146_711 VDD VSS sg13g2_fill_1
XFILLER_158_571 VDD VSS sg13g2_decap_8
XFILLER_72_0 VDD VSS sg13g2_decap_8
XFILLER_9_581 VDD VSS sg13g2_decap_8
XFILLER_173_541 VDD VSS sg13g2_decap_8
XFILLER_134_906 VDD VSS sg13g2_decap_8
XFILLER_173_552 VDD VSS sg13g2_fill_1
XFILLER_133_405 VDD VSS sg13g2_decap_8
XFILLER_10_28 VDD VSS sg13g2_decap_8
XFILLER_156_1018 VDD VSS sg13g2_decap_8
XFILLER_173_596 VDD VSS sg13g2_decap_8
XFILLER_160_224 VDD VSS sg13g2_decap_8
XFILLER_126_28 VDD VSS sg13g2_decap_8
X_13864__2315 _13864_/RESET_B VDD VSS sg13g2_tiehi
XFILLER_142_950 VDD VSS sg13g2_decap_8
XFILLER_0_919 VDD VSS sg13g2_decap_8
XFILLER_82_1237 VDD VSS sg13g2_decap_8
XFILLER_47_1357 VDD VSS sg13g2_decap_8
XFILLER_173_1354 VDD VSS sg13g2_decap_8
XFILLER_99_385 VDD VSS sg13g2_decap_8
XFILLER_87_547 VDD VSS sg13g2_decap_4
XFILLER_59_238 VDD VSS sg13g2_fill_2
X_07975_ _07979_/A _07976_/A _07976_/B _07976_/C VDD VSS sg13g2_nor3_1
XFILLER_68_750 VDD VSS sg13g2_fill_1
X_09714_ _14305_/D _09780_/A0 _14305_/Q _09736_/S VDD VSS sg13g2_mux2_1
XFILLER_55_400 VDD VSS sg13g2_decap_8
X_09645_ _14238_/D _09909_/A1 _14238_/Q _09667_/S VDD VSS sg13g2_mux2_1
XFILLER_83_753 VDD VSS sg13g2_fill_1
XFILLER_55_455 VDD VSS sg13g2_decap_8
XFILLER_35_14 VDD VSS sg13g2_decap_8
XFILLER_15_308 VDD VSS sg13g2_decap_8
XFILLER_43_617 VDD VSS sg13g2_fill_2
XFILLER_27_168 VDD VSS sg13g2_decap_8
X_09576_ _14173_/D _14173_/Q _09609_/A0 _09599_/S VDD VSS sg13g2_mux2_1
XFILLER_167_1158 VDD VSS sg13g2_fill_2
XFILLER_43_639 VDD VSS sg13g2_decap_8
XFILLER_42_116 VDD VSS sg13g2_fill_1
XFILLER_93_1333 VDD VSS sg13g2_decap_4
X_08527_ _08566_/C _08527_/A _08527_/B VDD VSS sg13g2_nand2_1
XFILLER_150_7 VDD VSS sg13g2_decap_8
X_15130__2697 _15130_/RESET_B VDD VSS sg13g2_tiehi
X_08458_ _08458_/X _08362_/X _08457_/X _08597_/B VDD VSS sg13g2_mux2_1
XFILLER_169_869 VDD VSS sg13g2_decap_8
XFILLER_11_525 VDD VSS sg13g2_decap_8
XFILLER_51_694 VDD VSS sg13g2_decap_8
XFILLER_23_385 VDD VSS sg13g2_decap_8
XFILLER_168_357 VDD VSS sg13g2_decap_8
XFILLER_51_35 VDD VSS sg13g2_decap_8
Xwire405 wire405/X wire405/A VDD VSS sg13g2_buf_2
X_08389_ _08394_/B _08415_/A _08389_/B VDD VSS sg13g2_nor2_1
XFILLER_7_518 VDD VSS sg13g2_decap_8
XFILLER_167_35 VDD VSS sg13g2_decap_8
XFILLER_17_1183 VDD VSS sg13g2_decap_8
X_10420_ _14829_/D _10420_/A _10421_/B _10423_/C VDD VSS sg13g2_and3_1
XFILLER_136_210 VDD VSS sg13g2_decap_8
XFILLER_13_1036 VDD VSS sg13g2_decap_8
XFILLER_136_221 VDD VSS sg13g2_fill_1
XFILLER_137_744 VDD VSS sg13g2_fill_2
XFILLER_100_1006 VDD VSS sg13g2_fill_1
XFILLER_137_777 VDD VSS sg13g2_decap_8
XFILLER_125_928 VDD VSS sg13g2_decap_8
X_10351_ _10353_/A _14809_/Q _10352_/C _14810_/Q VDD VSS sg13g2_a21o_1
XFILLER_100_1039 VDD VSS sg13g2_decap_8
XFILLER_164_574 VDD VSS sg13g2_decap_8
XFILLER_139_1216 VDD VSS sg13g2_fill_1
X_13070_ _13070_/Y _14783_/Q _13152_/A2 _13208_/B1 VDD VSS sg13g2_o21ai_1
XFILLER_3_735 VDD VSS sg13g2_decap_8
X_10282_ _14788_/D _10282_/A _10281_/Y VDD VSS sg13g2_nor2b_1
XFILLER_133_961 VDD VSS sg13g2_decap_8
X_14454__1725 _14454_/RESET_B VDD VSS sg13g2_tiehi
X_12021_ _12021_/Y _12021_/A _12246_/B VDD VSS sg13g2_nand2_1
XFILLER_2_245 VDD VSS sg13g2_decap_8
XFILLER_78_514 VDD VSS sg13g2_fill_1
XFILLER_105_696 VDD VSS sg13g2_decap_8
XFILLER_132_493 VDD VSS sg13g2_fill_1
XFILLER_76_21 VDD VSS sg13g2_decap_8
Xfanout560 _13264_/B1 _13049_/X VDD VSS sg13g2_buf_1
XFILLER_8_1351 VDD VSS sg13g2_decap_8
XFILLER_63_1170 VDD VSS sg13g2_fill_1
XFILLER_59_750 VDD VSS sg13g2_decap_8
Xfanout571 _13205_/A2 _13272_/A2 VDD VSS sg13g2_buf_1
XFILLER_4_1204 VDD VSS sg13g2_decap_8
Xfanout582 _11133_/B _11196_/B VDD VSS sg13g2_buf_1
XFILLER_120_699 VDD VSS sg13g2_fill_2
X_13972_ _13972_/Q clkload15/A _13972_/D _13972_/RESET_B VDD VSS sg13g2_dfrbpq_1
Xfanout593 _09057_/A _08972_/S VDD VSS sg13g2_buf_1
XFILLER_76_87 VDD VSS sg13g2_decap_8
XFILLER_74_720 VDD VSS sg13g2_fill_2
XFILLER_101_891 VDD VSS sg13g2_decap_8
XFILLER_24_1176 VDD VSS sg13g2_decap_8
XFILLER_47_956 VDD VSS sg13g2_decap_8
X_12923_ _12988_/A _14902_/Q _13685_/Q VDD VSS sg13g2_xnor2_1
XFILLER_47_967 VDD VSS sg13g2_decap_8
XFILLER_20_1029 VDD VSS sg13g2_decap_8
XFILLER_19_658 VDD VSS sg13g2_decap_8
XFILLER_98_1255 VDD VSS sg13g2_decap_8
XFILLER_47_978 VDD VSS sg13g2_fill_2
XFILLER_18_168 VDD VSS sg13g2_decap_8
XFILLER_59_1239 VDD VSS sg13g2_decap_8
X_12854_ _12854_/Y _12851_/Y _12852_/Y _12853_/Y VDD VSS sg13g2_a21oi_1
XFILLER_73_274 VDD VSS sg13g2_decap_8
XFILLER_33_105 VDD VSS sg13g2_decap_8
XFILLER_27_680 VDD VSS sg13g2_decap_8
X_11805_ _11806_/B _11805_/A _11805_/B _11805_/C VDD VSS sg13g2_nand3_1
X_12785_ _12785_/X _13754_/Q _14106_/Q _14458_/Q _14554_/Q _12785_/S0 _12785_/S1 VDD
+ VSS sg13g2_mux4_1
XFILLER_15_875 VDD VSS sg13g2_decap_8
X_14524_ _14524_/Q clkload44/A _14524_/D _14524_/RESET_B VDD VSS sg13g2_dfrbpq_1
X_13942__2237 _13942_/RESET_B VDD VSS sg13g2_tiehi
X_11736_ _11736_/X _11736_/A _11815_/B VDD VSS sg13g2_and2_1
XFILLER_14_385 VDD VSS sg13g2_decap_8
XFILLER_25_91 VDD VSS sg13g2_decap_8
XFILLER_159_357 VDD VSS sg13g2_decap_8
XFILLER_41_171 VDD VSS sg13g2_decap_8
XFILLER_109_1097 VDD VSS sg13g2_decap_8
X_14455_ _14455_/Q clkload33/A _14455_/D _14455_/RESET_B VDD VSS sg13g2_dfrbpq_1
X_11667_ _11667_/Y _11676_/A1 _13896_/Q VDD VSS sg13g2_nand2b_1
XFILLER_30_878 VDD VSS sg13g2_decap_8
X_13406_ _15090_/D _13442_/A _13396_/D _13405_/Y VDD VSS sg13g2_o21ai_1
X_10618_ _10619_/A _10651_/D _14880_/Q _14879_/Q _10629_/C VDD VSS sg13g2_nand4_1
X_14386_ _14386_/Q _14706_/CLK _14386_/D _14386_/RESET_B VDD VSS sg13g2_dfrbpq_1
X_11598_ _11599_/B _11598_/A _11598_/B _11760_/C VDD VSS sg13g2_nand3_1
XFILLER_127_243 VDD VSS sg13g2_decap_4
XFILLER_31_1169 VDD VSS sg13g2_decap_8
X_13337_ _13338_/A _15172_/D _15171_/D VDD VSS sg13g2_nor2b_1
X_15044__2537 _15044_/RESET_B VDD VSS sg13g2_tiehi
X_10549_ _10567_/C _14865_/Q _14864_/Q _14863_/Q VDD VSS sg13g2_nand3_1
XFILLER_170_511 VDD VSS sg13g2_decap_8
XFILLER_157_1327 VDD VSS sg13g2_decap_8
XFILLER_143_747 VDD VSS sg13g2_decap_8
XFILLER_157_1338 VDD VSS sg13g2_decap_8
XFILLER_6_595 VDD VSS sg13g2_decap_8
XFILLER_142_235 VDD VSS sg13g2_fill_1
XFILLER_131_909 VDD VSS sg13g2_decap_4
X_13268_ _13270_/B _14924_/Q _13663_/Q _13259_/A VDD VSS sg13g2_o21ai_1
XFILLER_124_950 VDD VSS sg13g2_decap_4
XFILLER_142_257 VDD VSS sg13g2_decap_8
X_15007_ _15007_/Q _15015_/CLK _15007_/D _15007_/RESET_B VDD VSS sg13g2_dfrbpq_1
XFILLER_124_983 VDD VSS sg13g2_decap_8
XFILLER_170_588 VDD VSS sg13g2_decap_8
X_12219_ _12219_/X _12205_/X _12206_/X _12219_/S VDD VSS sg13g2_mux2_1
XFILLER_69_503 VDD VSS sg13g2_fill_2
X_13199_ _13199_/X _13200_/A _13667_/Q VDD VSS sg13g2_and2_1
XFILLER_97_834 VDD VSS sg13g2_fill_1
XFILLER_9_1148 VDD VSS sg13g2_decap_8
XFILLER_116_1046 VDD VSS sg13g2_decap_4
XFILLER_110_143 VDD VSS sg13g2_decap_8
XFILLER_99_1008 VDD VSS sg13g2_fill_2
XFILLER_116_1079 VDD VSS sg13g2_decap_8
X_07760_ _15205_/D _13302_/C _07759_/Y _07754_/Y VDD VSS sg13g2_a21oi_1
XFILLER_37_411 VDD VSS sg13g2_decap_8
XFILLER_77_580 VDD VSS sg13g2_decap_8
XFILLER_42_1265 VDD VSS sg13g2_decap_8
XFILLER_2_84 VDD VSS sg13g2_decap_8
X_07691_ _07691_/Y _10172_/A _11241_/A _11241_/C VDD VSS sg13g2_o21ai_1
XFILLER_65_764 VDD VSS sg13g2_fill_1
X_09430_ _14032_/D _09696_/A0 _14032_/Q _09440_/S VDD VSS sg13g2_mux2_1
XFILLER_37_477 VDD VSS sg13g2_decap_8
XFILLER_25_617 VDD VSS sg13g2_decap_4
XFILLER_24_105 VDD VSS sg13g2_decap_8
XFILLER_80_734 VDD VSS sg13g2_fill_1
X_09361_ _13965_/D _09625_/A0 _13965_/Q _09365_/S VDD VSS sg13g2_mux2_1
XFILLER_75_1030 VDD VSS sg13g2_decap_8
XFILLER_166_1180 VDD VSS sg13g2_decap_8
X_08312_ _08312_/Y _08312_/A _08312_/B _08312_/C _08312_/D VDD VSS sg13g2_nor4_1
XFILLER_21_812 VDD VSS sg13g2_decap_8
X_09292_ _13900_/D _13900_/Q _10155_/A1 _09292_/S VDD VSS sg13g2_mux2_1
XANTENNA_12 _16867_/A VDD VSS sg13g2_antennanp
XFILLER_162_1055 VDD VSS sg13g2_fill_1
X_14532__1647 _14532_/RESET_B VDD VSS sg13g2_tiehi
XFILLER_20_322 VDD VSS sg13g2_decap_8
XANTENNA_23 _13005_/C VDD VSS sg13g2_antennanp
X_13918__2261 _13918_/RESET_B VDD VSS sg13g2_tiehi
X_08243_ _08243_/Y _08241_/A _08015_/Y _08241_/Y VDD VSS sg13g2_o21ai_1
Xclkbuf_leaf_8_clk_i _14607_/CLK clkbuf_leaf_8_clk_i/A VDD VSS sg13g2_buf_8
XFILLER_14_1323 VDD VSS sg13g2_decap_8
XFILLER_159_880 VDD VSS sg13g2_fill_2
XFILLER_119_722 VDD VSS sg13g2_fill_2
XFILLER_21_889 VDD VSS sg13g2_decap_8
XFILLER_53_1383 VDD VSS sg13g2_fill_1
XFILLER_119_744 VDD VSS sg13g2_decap_8
X_08174_ _08174_/Y _08174_/A _08659_/B _08514_/A VDD VSS sg13g2_nor3_1
XFILLER_101_1304 VDD VSS sg13g2_decap_4
XFILLER_119_755 VDD VSS sg13g2_fill_1
X_14786__2927 _14786_/RESET_B VDD VSS sg13g2_tiehi
XFILLER_20_399 VDD VSS sg13g2_decap_8
XFILLER_107_906 VDD VSS sg13g2_fill_2
XFILLER_21_49 VDD VSS sg13g2_decap_8
XFILLER_134_714 VDD VSS sg13g2_decap_8
X_14822__2891 _14822_/RESET_B VDD VSS sg13g2_tiehi
XFILLER_161_500 VDD VSS sg13g2_decap_8
XFILLER_174_894 VDD VSS sg13g2_decap_8
XFILLER_173_371 VDD VSS sg13g2_decap_8
XFILLER_137_49 VDD VSS sg13g2_decap_8
XFILLER_161_533 VDD VSS sg13g2_decap_8
Xoutput130 mem_axi_wdata[4] _15136_/Q VDD VSS sg13g2_buf_1
XFILLER_133_257 VDD VSS sg13g2_decap_8
Xoutput141 trap _14766_/Q VDD VSS sg13g2_buf_1
XFILLER_88_812 VDD VSS sg13g2_decap_4
XFILLER_0_716 VDD VSS sg13g2_decap_8
XFILLER_142_780 VDD VSS sg13g2_decap_8
XFILLER_138_1293 VDD VSS sg13g2_decap_8
XFILLER_43_1029 VDD VSS sg13g2_decap_8
XFILLER_75_506 VDD VSS sg13g2_decap_8
XFILLER_102_688 VDD VSS sg13g2_fill_1
XFILLER_87_388 VDD VSS sg13g2_decap_8
X_07958_ _07961_/B _07958_/A _07958_/B VDD VSS sg13g2_and2_1
XFILLER_21_1316 VDD VSS sg13g2_decap_8
XFILLER_46_35 VDD VSS sg13g2_decap_8
X_07889_ _07890_/B _07889_/A _08229_/C VDD VSS sg13g2_nand2_1
XFILLER_28_477 VDD VSS sg13g2_decap_8
XFILLER_15_105 VDD VSS sg13g2_decap_8
X_09628_ _14224_/D _09828_/A0 _14224_/Q _09638_/S VDD VSS sg13g2_mux2_1
XFILLER_43_414 VDD VSS sg13g2_decap_8
XFILLER_55_285 VDD VSS sg13g2_decap_8
XFILLER_3_1281 VDD VSS sg13g2_decap_8
X_09559_ _14157_/D _09625_/A0 _14157_/Q _09563_/S VDD VSS sg13g2_mux2_1
XFILLER_54_1103 VDD VSS sg13g2_fill_1
XFILLER_24_650 VDD VSS sg13g2_fill_1
XFILLER_12_812 VDD VSS sg13g2_decap_8
XFILLER_145_1231 VDD VSS sg13g2_decap_8
X_12570_ _12583_/A _12709_/A1 _12737_/A2 _15005_/Q VDD VSS sg13g2_a21oi_1
XFILLER_70_288 VDD VSS sg13g2_decap_4
XFILLER_24_683 VDD VSS sg13g2_fill_1
XFILLER_19_1267 VDD VSS sg13g2_decap_8
XFILLER_11_322 VDD VSS sg13g2_decap_8
XFILLER_169_666 VDD VSS sg13g2_decap_4
XFILLER_8_805 VDD VSS sg13g2_decap_8
XFILLER_23_182 VDD VSS sg13g2_decap_8
XFILLER_168_154 VDD VSS sg13g2_decap_8
X_11521_ _11521_/Y _11520_/Y _11519_/Y _11506_/Y _11722_/B2 _12295_/B1 VDD VSS sg13g2_a221oi_1
X_14508__1671 _14508_/RESET_B VDD VSS sg13g2_tiehi
XFILLER_12_889 VDD VSS sg13g2_decap_8
XFILLER_7_315 VDD VSS sg13g2_decap_8
X_14240_ _14240_/Q clkload31/A _14240_/D _14240_/RESET_B VDD VSS sg13g2_dfrbpq_1
X_11452_ _11463_/A _11454_/A _13688_/Q VDD VSS sg13g2_nor2_1
XFILLER_11_399 VDD VSS sg13g2_decap_8
X_10403_ _14823_/D _14823_/Q _10400_/Y _10402_/Y VDD VSS sg13g2_a21oi_1
XFILLER_109_254 VDD VSS sg13g2_decap_8
X_14171_ _14171_/Q clkload46/A _14171_/D _14171_/RESET_B VDD VSS sg13g2_dfrbpq_1
X_11383_ _11383_/Y _11384_/A _13690_/Q VDD VSS sg13g2_nand2_1
XFILLER_164_371 VDD VSS sg13g2_decap_8
X_13122_ _13122_/Y _14883_/Q _13162_/B1 _13082_/B VDD VSS sg13g2_a21oi_1
X_10334_ _14804_/D _10334_/A _10335_/B _10334_/C VDD VSS sg13g2_and3_1
XFILLER_3_532 VDD VSS sg13g2_decap_8
XFILLER_30_1191 VDD VSS sg13g2_decap_8
XFILLER_125_769 VDD VSS sg13g2_decap_8
XFILLER_2_0 VDD VSS sg13g2_decap_8
XFILLER_106_972 VDD VSS sg13g2_decap_4
XFILLER_124_268 VDD VSS sg13g2_fill_2
X_13053_ _13053_/Y _14782_/Q _13152_/A2 _13208_/B1 VDD VSS sg13g2_o21ai_1
X_10265_ _10278_/C _10265_/A _10265_/B _10265_/C _10265_/D VDD VSS sg13g2_nor4_1
XFILLER_106_994 VDD VSS sg13g2_decap_8
Xfanout1300 _11854_/S0 fanout1316/X VDD VSS sg13g2_buf_1
X_12004_ _12004_/Y _12002_/Y _12003_/Y _11980_/A VDD VSS sg13g2_a21oi_1
Xfanout1311 _11692_/A _12238_/S0 VDD VSS sg13g2_buf_1
XFILLER_26_1238 VDD VSS sg13g2_decap_8
XFILLER_121_964 VDD VSS sg13g2_decap_8
Xfanout1322 _11749_/A1 _11893_/S VDD VSS sg13g2_buf_1
X_10196_ _14755_/D _15198_/D _14755_/Q _13502_/A VDD VSS sg13g2_mux2_1
XFILLER_79_878 VDD VSS sg13g2_fill_1
Xfanout1333 _11212_/S _11229_/S0 VDD VSS sg13g2_buf_1
XFILLER_65_1298 VDD VSS sg13g2_fill_2
Xfanout1344 _12306_/A _12321_/A1 VDD VSS sg13g2_buf_1
XFILLER_79_889 VDD VSS sg13g2_fill_1
Xfanout1355 _12242_/A_N fanout1358/X VDD VSS sg13g2_buf_1
Xfanout1366 _11469_/S0 fanout1369/X VDD VSS sg13g2_buf_1
XFILLER_94_837 VDD VSS sg13g2_decap_8
XFILLER_4_1001 VDD VSS sg13g2_decap_8
XFILLER_38_219 VDD VSS sg13g2_decap_8
Xfanout1377 _13141_/A _13155_/A VDD VSS sg13g2_buf_1
XFILLER_120_496 VDD VSS sg13g2_decap_8
X_14610__1569 _14610_/RESET_B VDD VSS sg13g2_tiehi
Xfanout390 _10143_/A1 _08996_/Y VDD VSS sg13g2_buf_1
Xfanout1388 _10630_/C _10619_/B VDD VSS sg13g2_buf_1
Xfanout1399 _10535_/C _13005_/C VDD VSS sg13g2_buf_1
X_13955_ _13955_/Q _14659_/CLK _13955_/D _13955_/RESET_B VDD VSS sg13g2_dfrbpq_1
XFILLER_46_241 VDD VSS sg13g2_decap_8
XFILLER_19_455 VDD VSS sg13g2_decap_8
X_14864__2816 _14864_/RESET_B VDD VSS sg13g2_tiehi
XFILLER_4_1078 VDD VSS sg13g2_decap_8
XFILLER_46_252 VDD VSS sg13g2_fill_1
X_12906_ _12925_/C _14901_/Q _13686_/Q VDD VSS sg13g2_nand2_1
XFILLER_98_1085 VDD VSS sg13g2_decap_8
XFILLER_62_723 VDD VSS sg13g2_decap_4
XFILLER_59_1036 VDD VSS sg13g2_decap_8
XFILLER_47_797 VDD VSS sg13g2_decap_4
X_13886_ _13886_/Q _14686_/CLK _13886_/D _13886_/RESET_B VDD VSS sg13g2_dfrbpq_1
X_12837_ _12838_/A _14895_/Q _13692_/Q _12836_/C VDD VSS sg13g2_a21oi_1
XFILLER_37_1301 VDD VSS sg13g2_decap_8
XFILLER_15_672 VDD VSS sg13g2_decap_8
XFILLER_76_1383 VDD VSS sg13g2_fill_1
XFILLER_21_119 VDD VSS sg13g2_decap_8
XFILLER_163_1353 VDD VSS sg13g2_decap_8
X_12768_ _12768_/X _13849_/Q _13881_/Q _13913_/Q _13945_/Q _12773_/S0 _12773_/S1 VDD
+ VSS sg13g2_mux4_1
XFILLER_163_1364 VDD VSS sg13g2_decap_4
XFILLER_14_182 VDD VSS sg13g2_decap_8
XFILLER_42_491 VDD VSS sg13g2_fill_2
XFILLER_37_1378 VDD VSS sg13g2_fill_2
XFILLER_159_154 VDD VSS sg13g2_decap_8
X_14507_ _14507_/Q clkload4/A _14507_/D _14507_/RESET_B VDD VSS sg13g2_dfrbpq_1
X_11719_ _11719_/Y _12292_/A _11719_/B VDD VSS sg13g2_nor2_1
X_12699_ _12699_/X _14260_/Q _14292_/Q _14324_/Q _14356_/Q _12703_/S0 _12703_/S1 VDD
+ VSS sg13g2_mux4_1
X_14438_ _14438_/Q _14662_/CLK _14438_/D _14438_/RESET_B VDD VSS sg13g2_dfrbpq_1
Xinput10 input10/X input10/A VDD VSS sg13g2_buf_1
XFILLER_30_697 VDD VSS sg13g2_fill_2
Xinput21 input21/X input21/A VDD VSS sg13g2_buf_1
Xinput32 input32/X input32/A VDD VSS sg13g2_buf_1
XFILLER_128_552 VDD VSS sg13g2_decap_8
X_14369_ _14369_/Q clkload24/A _14369_/D _14369_/RESET_B VDD VSS sg13g2_dfrbpq_1
XFILLER_122_1094 VDD VSS sg13g2_decap_8
XFILLER_7_882 VDD VSS sg13g2_decap_8
XFILLER_6_392 VDD VSS sg13g2_decap_8
XFILLER_100_1370 VDD VSS sg13g2_fill_1
XFILLER_83_1321 VDD VSS sg13g2_fill_1
X_08930_ _08930_/X _15046_/Q _14950_/Q _10767_/A VDD VSS sg13g2_mux2_1
XFILLER_170_385 VDD VSS sg13g2_decap_8
XFILLER_97_631 VDD VSS sg13g2_decap_8
XFILLER_170_1313 VDD VSS sg13g2_decap_8
XFILLER_83_1365 VDD VSS sg13g2_decap_8
XFILLER_35_0 VDD VSS sg13g2_decap_8
XFILLER_83_1376 VDD VSS sg13g2_fill_1
XFILLER_69_333 VDD VSS sg13g2_fill_1
X_08861_ _13698_/D _16860_/A _08860_/X _08892_/S VDD VSS sg13g2_mux2_1
XFILLER_97_664 VDD VSS sg13g2_decap_8
X_07812_ _08548_/B _07956_/A _07812_/B VDD VSS sg13g2_nand2_1
X_08792_ _08792_/Y _13682_/Q _08818_/B VDD VSS sg13g2_nor2_1
X_07743_ _07744_/D _12348_/A _15217_/Q _15126_/Q VDD VSS sg13g2_nor3_1
XFILLER_38_742 VDD VSS sg13g2_decap_8
XFILLER_53_701 VDD VSS sg13g2_fill_2
XFILLER_93_881 VDD VSS sg13g2_fill_2
X_07674_ _07674_/Y _10177_/A _07677_/B VDD VSS sg13g2_nand2_1
XFILLER_26_937 VDD VSS sg13g2_decap_8
XFILLER_25_414 VDD VSS sg13g2_decap_8
XFILLER_53_734 VDD VSS sg13g2_decap_8
XFILLER_16_49 VDD VSS sg13g2_decap_8
X_09413_ _14015_/D _09611_/A0 _14015_/Q _09431_/S VDD VSS sg13g2_mux2_1
XFILLER_13_609 VDD VSS sg13g2_decap_8
XFILLER_129_1259 VDD VSS sg13g2_fill_1
XFILLER_90_1303 VDD VSS sg13g2_decap_8
XFILLER_12_119 VDD VSS sg13g2_decap_8
X_09344_ _13948_/D _09608_/A0 _13948_/Q _09368_/S VDD VSS sg13g2_mux2_1
XFILLER_80_597 VDD VSS sg13g2_decap_8
X_09275_ _13883_/D _13883_/Q _09906_/A1 _09292_/S VDD VSS sg13g2_mux2_1
XFILLER_14_1120 VDD VSS sg13g2_decap_8
X_08226_ _08247_/C _08203_/A _08203_/B _07909_/B _07910_/A _08188_/Y VDD VSS sg13g2_a221oi_1
XFILLER_21_686 VDD VSS sg13g2_decap_8
XFILLER_138_349 VDD VSS sg13g2_decap_8
XFILLER_166_658 VDD VSS sg13g2_decap_8
XFILLER_154_809 VDD VSS sg13g2_decap_8
XFILLER_20_196 VDD VSS sg13g2_decap_8
XFILLER_165_168 VDD VSS sg13g2_decap_8
XFILLER_5_819 VDD VSS sg13g2_decap_8
XFILLER_119_574 VDD VSS sg13g2_decap_8
X_08157_ _08157_/X _08005_/X _08018_/X _08223_/S VDD VSS sg13g2_mux2_1
XFILLER_113_7 VDD VSS sg13g2_decap_8
XFILLER_134_500 VDD VSS sg13g2_decap_8
XFILLER_147_894 VDD VSS sg13g2_decap_8
XFILLER_14_1197 VDD VSS sg13g2_decap_8
XFILLER_4_329 VDD VSS sg13g2_decap_8
XFILLER_49_1205 VDD VSS sg13g2_decap_8
X_08088_ _08088_/Y _07913_/A _08137_/A2 _08160_/A VDD VSS sg13g2_a21oi_1
XFILLER_49_1238 VDD VSS sg13g2_fill_2
XFILLER_164_14 VDD VSS sg13g2_decap_8
XFILLER_161_352 VDD VSS sg13g2_decap_8
XFILLER_162_875 VDD VSS sg13g2_decap_8
XFILLER_134_588 VDD VSS sg13g2_decap_8
X_10050_ _14631_/D _10083_/A0 _14631_/Q _10064_/S VDD VSS sg13g2_mux2_1
XFILLER_0_546 VDD VSS sg13g2_decap_8
XFILLER_102_430 VDD VSS sg13g2_decap_8
XFILLER_87_152 VDD VSS sg13g2_decap_8
X_15172__2953 _15172_/RESET_B VDD VSS sg13g2_tiehi
XFILLER_130_794 VDD VSS sg13g2_decap_8
XFILLER_57_56 VDD VSS sg13g2_fill_1
XFILLER_25_1260 VDD VSS sg13g2_decap_8
XFILLER_21_1113 VDD VSS sg13g2_decap_8
XFILLER_75_358 VDD VSS sg13g2_decap_4
XFILLER_5_1365 VDD VSS sg13g2_decap_8
XFILLER_112_1252 VDD VSS sg13g2_decap_8
XFILLER_44_701 VDD VSS sg13g2_decap_8
XFILLER_1_1218 VDD VSS sg13g2_decap_8
Xclkbuf_leaf_109_clk_i clkload41/A clkbuf_5_18__f_clk_i/X VDD VSS sg13g2_buf_8
XFILLER_28_263 VDD VSS sg13g2_decap_8
XFILLER_113_62 VDD VSS sg13g2_fill_1
X_13740_ _13740_/Q clkload13/A _13740_/D _13740_/RESET_B VDD VSS sg13g2_dfrbpq_1
XFILLER_99_1383 VDD VSS sg13g2_fill_1
X_10952_ _11015_/A _10954_/A _10954_/B _10954_/C _10954_/D VDD VSS sg13g2_nor4_1
XFILLER_90_339 VDD VSS sg13g2_decap_8
XFILLER_28_274 VDD VSS sg13g2_fill_2
XFILLER_17_959 VDD VSS sg13g2_decap_8
XFILLER_147_1326 VDD VSS sg13g2_decap_8
XFILLER_32_907 VDD VSS sg13g2_decap_8
XFILLER_16_469 VDD VSS sg13g2_decap_8
X_13671_ _13671_/Q _15113_/CLK _13671_/D _13671_/RESET_B VDD VSS sg13g2_dfrbpq_1
X_10883_ _10883_/X _10890_/C _10883_/B VDD VSS sg13g2_xor2_1
X_12622_ _12622_/X _12618_/X _12617_/X _12614_/X _12613_/X _12705_/S0 _12567_/S VDD
+ VSS sg13g2_mux4_1
XFILLER_73_99 VDD VSS sg13g2_fill_2
XFILLER_169_441 VDD VSS sg13g2_decap_8
XFILLER_106_1001 VDD VSS sg13g2_decap_8
XFILLER_19_1064 VDD VSS sg13g2_decap_8
XFILLER_157_614 VDD VSS sg13g2_decap_8
X_12553_ _12553_/X _12551_/X _12552_/X _12553_/S VDD VSS sg13g2_mux2_1
XFILLER_8_602 VDD VSS sg13g2_decap_8
X_14024__2155 _14024_/RESET_B VDD VSS sg13g2_tiehi
XFILLER_12_686 VDD VSS sg13g2_decap_8
XFILLER_157_658 VDD VSS sg13g2_decap_8
X_11504_ _11506_/B _11777_/A _11777_/C VDD VSS sg13g2_nor2_1
XFILLER_7_112 VDD VSS sg13g2_decap_8
X_12484_ _12485_/B _12942_/B _12763_/A2 _12483_/X _12415_/A _12624_/C1 VDD VSS sg13g2_a221oi_1
XFILLER_11_196 VDD VSS sg13g2_decap_8
XFILLER_32_1253 VDD VSS sg13g2_decap_8
XFILLER_172_606 VDD VSS sg13g2_fill_2
XFILLER_8_679 VDD VSS sg13g2_decap_8
XFILLER_144_319 VDD VSS sg13g2_decap_8
X_14223_ _14223_/Q _14735_/CLK _14223_/D _14223_/RESET_B VDD VSS sg13g2_dfrbpq_1
XFILLER_22_70 VDD VSS sg13g2_decap_8
X_11435_ _11435_/X _13952_/Q _13984_/Q _14016_/Q _14048_/Q _11493_/S0 _11493_/S1 VDD
+ VSS sg13g2_mux4_1
XFILLER_171_105 VDD VSS sg13g2_decap_8
XFILLER_138_894 VDD VSS sg13g2_fill_1
XFILLER_172_639 VDD VSS sg13g2_decap_8
XFILLER_7_189 VDD VSS sg13g2_decap_8
XFILLER_165_691 VDD VSS sg13g2_decap_8
X_14154_ _14154_/Q _14666_/CLK _14154_/D _14154_/RESET_B VDD VSS sg13g2_dfrbpq_1
X_11366_ _11366_/Y _11366_/A _11366_/B _11366_/C VDD VSS sg13g2_nand3_1
XFILLER_153_864 VDD VSS sg13g2_decap_8
XFILLER_98_406 VDD VSS sg13g2_decap_8
X_13105_ _13105_/X input14/X _13205_/A2 _13205_/B1 VDD VSS sg13g2_a21o_1
X_10317_ _10319_/B _14798_/Q _10342_/C _14799_/Q VDD VSS sg13g2_a21oi_1
X_13892__2287 _13892_/RESET_B VDD VSS sg13g2_tiehi
X_14085_ _14085_/Q clkload5/A _14085_/D _14085_/RESET_B VDD VSS sg13g2_dfrbpq_1
X_11297_ _11297_/Y _11300_/S0 _13885_/Q VDD VSS sg13g2_nand2b_1
XFILLER_4_896 VDD VSS sg13g2_decap_8
XFILLER_140_536 VDD VSS sg13g2_decap_8
XFILLER_79_631 VDD VSS sg13g2_decap_8
X_13036_ _15035_/D _13027_/Y _13035_/Y _13021_/A VDD VSS sg13g2_a21oi_1
X_10248_ _14777_/D _10255_/D _10599_/A _10248_/C VDD VSS sg13g2_nor3_1
XFILLER_78_130 VDD VSS sg13g2_fill_2
XFILLER_26_1035 VDD VSS sg13g2_decap_8
Xfanout1130 _07826_/B _11770_/A VDD VSS sg13g2_buf_1
XFILLER_67_815 VDD VSS sg13g2_fill_1
XFILLER_154_91 VDD VSS sg13g2_decap_8
Xfanout1141 _07786_/A _08376_/A3 VDD VSS sg13g2_buf_1
Xfanout1152 _11502_/A _14965_/Q VDD VSS sg13g2_buf_1
X_10179_ _10179_/Y _10182_/A _13613_/B VDD VSS sg13g2_nand2_1
Xfanout1163 _07912_/B _14961_/Q VDD VSS sg13g2_buf_1
Xfanout1174 _12867_/C _12997_/A VDD VSS sg13g2_buf_1
XFILLER_113_1049 VDD VSS sg13g2_decap_8
Xfanout1185 _13142_/A _14916_/Q VDD VSS sg13g2_buf_1
Xfanout1196 _10647_/C _14869_/Q VDD VSS sg13g2_buf_1
X_14987_ _14987_/Q clkload52/A _14987_/D _14987_/RESET_B VDD VSS sg13g2_dfrbpq_1
XFILLER_82_829 VDD VSS sg13g2_fill_1
XFILLER_81_306 VDD VSS sg13g2_decap_8
XFILLER_19_252 VDD VSS sg13g2_decap_8
XFILLER_93_177 VDD VSS sg13g2_decap_4
X_13938_ _13938_/Q clkload23/A _13938_/D _13938_/RESET_B VDD VSS sg13g2_dfrbpq_1
XFILLER_74_380 VDD VSS sg13g2_decap_8
X_14234__1945 _14234_/RESET_B VDD VSS sg13g2_tiehi
XFILLER_74_391 VDD VSS sg13g2_fill_2
XFILLER_62_542 VDD VSS sg13g2_fill_1
XFILLER_90_862 VDD VSS sg13g2_fill_1
X_13869_ _13869_/Q _14733_/CLK _13869_/D _13869_/RESET_B VDD VSS sg13g2_dfrbpq_1
XFILLER_62_564 VDD VSS sg13g2_fill_1
XFILLER_50_704 VDD VSS sg13g2_decap_8
XFILLER_90_884 VDD VSS sg13g2_decap_4
XFILLER_62_575 VDD VSS sg13g2_decap_8
XFILLER_22_406 VDD VSS sg13g2_decap_8
Xclkbuf_leaf_73_clk_i clkload57/A clkbuf_leaf_73_clk_i/A VDD VSS sg13g2_buf_8
X_15165__2513 _15165_/RESET_B VDD VSS sg13g2_tiehi
XFILLER_34_277 VDD VSS sg13g2_fill_2
XFILLER_76_1180 VDD VSS sg13g2_decap_4
XFILLER_72_1011 VDD VSS sg13g2_fill_2
XFILLER_50_737 VDD VSS sg13g2_decap_8
XFILLER_37_1131 VDD VSS sg13g2_decap_8
XFILLER_76_1191 VDD VSS sg13g2_decap_8
XFILLER_124_1101 VDD VSS sg13g2_decap_8
XFILLER_37_1186 VDD VSS sg13g2_decap_8
XFILLER_148_636 VDD VSS sg13g2_decap_8
XFILLER_31_984 VDD VSS sg13g2_decap_8
XFILLER_72_1088 VDD VSS sg13g2_decap_8
XFILLER_124_1156 VDD VSS sg13g2_decap_8
X_09060_ _09060_/X _15037_/Q _15234_/Q _13305_/A VDD VSS sg13g2_mux2_1
Xclkbuf_leaf_88_clk_i _14854_/CLK clkbuf_leaf_88_clk_i/A VDD VSS sg13g2_buf_8
X_08011_ _08011_/X _07972_/B _08010_/B _08673_/B _08048_/B _08009_/S _08124_/S1 VDD
+ VSS sg13g2_mux4_1
XFILLER_129_872 VDD VSS sg13g2_fill_1
XFILLER_159_1219 VDD VSS sg13g2_decap_8
XFILLER_162_105 VDD VSS sg13g2_decap_8
XFILLER_11_1337 VDD VSS sg13g2_decap_8
XFILLER_116_544 VDD VSS sg13g2_decap_8
XFILLER_116_555 VDD VSS sg13g2_fill_1
X_14179__2000 _14179_/RESET_B VDD VSS sg13g2_tiehi
XFILLER_104_717 VDD VSS sg13g2_decap_8
Xclkbuf_leaf_11_clk_i _14672_/CLK clkbuf_leaf_4_clk_i/A VDD VSS sg13g2_buf_8
XFILLER_103_205 VDD VSS sg13g2_decap_8
XFILLER_143_374 VDD VSS sg13g2_decap_4
X_09962_ _14546_/D _14546_/Q _10161_/A1 _09970_/S VDD VSS sg13g2_mux2_1
X_13722__2457 _13722_/RESET_B VDD VSS sg13g2_tiehi
XFILLER_170_182 VDD VSS sg13g2_decap_8
X_14482__1697 _14482_/RESET_B VDD VSS sg13g2_tiehi
XFILLER_135_1230 VDD VSS sg13g2_decap_8
X_08913_ _08913_/Y _10747_/A _14945_/Q VDD VSS sg13g2_nand2_1
X_09893_ _14479_/D _09926_/A1 _14479_/Q _09899_/S VDD VSS sg13g2_mux2_1
XFILLER_134_39 VDD VSS sg13g2_decap_8
XFILLER_44_1135 VDD VSS sg13g2_decap_8
XFILLER_83_1195 VDD VSS sg13g2_decap_8
XFILLER_69_152 VDD VSS sg13g2_decap_8
XFILLER_135_1274 VDD VSS sg13g2_fill_2
X_08844_ _08844_/Y _10669_/S _14928_/Q VDD VSS sg13g2_nor2b_1
XFILLER_85_634 VDD VSS sg13g2_fill_1
Xclkbuf_leaf_26_clk_i clkload18/A clkbuf_5_9__f_clk_i/X VDD VSS sg13g2_buf_8
XFILLER_58_859 VDD VSS sg13g2_fill_2
XFILLER_170_1187 VDD VSS sg13g2_decap_8
XFILLER_85_667 VDD VSS sg13g2_decap_4
X_08775_ _08775_/Y _13064_/B _08775_/B VDD VSS sg13g2_nor2_1
XFILLER_45_509 VDD VSS sg13g2_decap_8
X_14102__2077 _14102_/RESET_B VDD VSS sg13g2_tiehi
XFILLER_38_550 VDD VSS sg13g2_decap_4
XFILLER_66_870 VDD VSS sg13g2_decap_8
XFILLER_38_572 VDD VSS sg13g2_fill_1
X_07726_ _07735_/C _07726_/A _07726_/B _07726_/C _07726_/D VDD VSS sg13g2_nand4_1
XFILLER_84_199 VDD VSS sg13g2_decap_4
XFILLER_150_49 VDD VSS sg13g2_decap_8
XFILLER_26_745 VDD VSS sg13g2_decap_8
X_07657_ _10210_/D _15165_/Q _15164_/Q _15167_/Q _15166_/Q VDD VSS sg13g2_nor4_1
XFILLER_0_1262 VDD VSS sg13g2_decap_8
XFILLER_13_406 VDD VSS sg13g2_decap_8
XFILLER_20_1190 VDD VSS sg13g2_decap_8
XFILLER_129_1045 VDD VSS sg13g2_fill_2
X_14986__2601 _14986_/RESET_B VDD VSS sg13g2_tiehi
XFILLER_43_14 VDD VSS sg13g2_decap_8
XFILLER_25_266 VDD VSS sg13g2_decap_8
XFILLER_80_383 VDD VSS sg13g2_decap_8
XFILLER_129_1089 VDD VSS sg13g2_decap_8
XFILLER_159_14 VDD VSS sg13g2_decap_8
XFILLER_41_759 VDD VSS sg13g2_decap_8
XFILLER_16_1204 VDD VSS sg13g2_decap_8
XFILLER_167_923 VDD VSS sg13g2_decap_8
X_09327_ _13934_/D _09925_/A1 _13934_/Q _09339_/S VDD VSS sg13g2_mux2_1
XFILLER_22_962 VDD VSS sg13g2_decap_8
XFILLER_90_1177 VDD VSS sg13g2_decap_8
XFILLER_139_669 VDD VSS sg13g2_decap_8
XFILLER_167_978 VDD VSS sg13g2_fill_1
X_09258_ _13867_/D _13867_/Q _09922_/A1 _09264_/S VDD VSS sg13g2_mux2_1
XFILLER_21_483 VDD VSS sg13g2_decap_8
XFILLER_166_455 VDD VSS sg13g2_decap_8
XFILLER_167_989 VDD VSS sg13g2_decap_8
XFILLER_153_105 VDD VSS sg13g2_decap_8
X_08209_ _08209_/X _08209_/A _08452_/C VDD VSS sg13g2_and2_1
XFILLER_5_616 VDD VSS sg13g2_decap_8
X_09189_ _13805_/D _13805_/Q _10156_/A1 _09189_/S VDD VSS sg13g2_mux2_1
XFILLER_88_1040 VDD VSS sg13g2_decap_4
XFILLER_119_393 VDD VSS sg13g2_decap_8
X_11220_ _11223_/B _11325_/B1 _11217_/X _11219_/X VDD VSS sg13g2_a21oi_1
XFILLER_4_126 VDD VSS sg13g2_decap_8
XFILLER_49_1035 VDD VSS sg13g2_fill_2
XFILLER_108_40 VDD VSS sg13g2_fill_2
XFILLER_150_823 VDD VSS sg13g2_decap_8
X_11151_ _11151_/Y _11151_/A _11151_/B VDD VSS sg13g2_nor2_1
XFILLER_107_599 VDD VSS sg13g2_decap_8
XFILLER_1_833 VDD VSS sg13g2_decap_8
XFILLER_122_547 VDD VSS sg13g2_decap_8
XFILLER_161_182 VDD VSS sg13g2_decap_8
X_14312__1867 _14312_/RESET_B VDD VSS sg13g2_tiehi
X_10102_ _14682_/D _10102_/A0 _14682_/Q _10102_/S VDD VSS sg13g2_mux2_1
XFILLER_150_867 VDD VSS sg13g2_decap_8
X_11082_ _11082_/Y _11029_/C _10754_/X _11154_/B1 VDD VSS sg13g2_o21ai_1
XFILLER_89_962 VDD VSS sg13g2_decap_8
XFILLER_66_1382 VDD VSS sg13g2_fill_2
XFILLER_0_343 VDD VSS sg13g2_decap_8
XFILLER_103_750 VDD VSS sg13g2_decap_8
XFILLER_150_878 VDD VSS sg13g2_fill_1
XFILLER_95_409 VDD VSS sg13g2_fill_2
X_14932__2680 _14932_/RESET_B VDD VSS sg13g2_tiehi
XFILLER_27_1355 VDD VSS sg13g2_decap_8
XFILLER_153_1363 VDD VSS sg13g2_fill_2
X_14910_ _14910_/Q clkload43/A _14910_/D _14910_/RESET_B VDD VSS sg13g2_dfrbpq_1
X_10033_ _14615_/D _10099_/A0 _14615_/Q _10035_/S VDD VSS sg13g2_mux2_1
XFILLER_89_995 VDD VSS sg13g2_decap_8
XFILLER_48_303 VDD VSS sg13g2_decap_8
X_14841_ _14841_/Q _14874_/CLK _14841_/D _14841_/RESET_B VDD VSS sg13g2_dfrbpq_1
XFILLER_84_21 VDD VSS sg13g2_decap_8
X_13877__2302 _13877_/RESET_B VDD VSS sg13g2_tiehi
XFILLER_75_155 VDD VSS sg13g2_decap_4
XFILLER_91_615 VDD VSS sg13g2_decap_8
XFILLER_5_1162 VDD VSS sg13g2_decap_8
XFILLER_75_188 VDD VSS sg13g2_decap_8
XFILLER_1_1015 VDD VSS sg13g2_decap_8
X_14772_ _14772_/Q _15113_/CLK _14772_/D _14772_/RESET_B VDD VSS sg13g2_dfrbpq_1
X_11984_ _11986_/B _11914_/A _13673_/Q _13129_/B _11936_/A VDD VSS sg13g2_a22oi_1
XFILLER_29_594 VDD VSS sg13g2_fill_1
XFILLER_112_1093 VDD VSS sg13g2_decap_4
XFILLER_84_87 VDD VSS sg13g2_decap_8
XFILLER_17_756 VDD VSS sg13g2_decap_8
X_13723_ _13723_/Q clkload46/A _13723_/D _13723_/RESET_B VDD VSS sg13g2_dfrbpq_1
XFILLER_95_1044 VDD VSS sg13g2_decap_4
XFILLER_147_1123 VDD VSS sg13g2_decap_4
X_10935_ _10935_/Y _11043_/A _10935_/B VDD VSS sg13g2_nor2_1
XFILLER_17_70 VDD VSS sg13g2_decap_8
XFILLER_16_266 VDD VSS sg13g2_decap_8
X_14781__2932 _14781_/RESET_B VDD VSS sg13g2_tiehi
XFILLER_72_884 VDD VSS sg13g2_decap_4
XFILLER_32_715 VDD VSS sg13g2_decap_8
XFILLER_44_586 VDD VSS sg13g2_decap_8
X_13654_ _15120_/D _08715_/X _15120_/Q _13654_/S VDD VSS sg13g2_mux2_1
X_10866_ _10868_/C _14752_/Q _10870_/A _10857_/A VDD VSS sg13g2_a21oi_1
XFILLER_34_1304 VDD VSS sg13g2_decap_8
X_12605_ _12605_/X _14381_/Q _14413_/Q _14477_/Q _14509_/Q _12606_/S0 _12606_/S1 VDD
+ VSS sg13g2_mux4_1
XFILLER_73_1364 VDD VSS sg13g2_decap_8
XFILLER_13_973 VDD VSS sg13g2_decap_8
XFILLER_158_934 VDD VSS sg13g2_fill_1
XFILLER_160_1323 VDD VSS sg13g2_decap_8
X_13585_ _15160_/D _13593_/B _13583_/Y _13584_/Y VDD VSS sg13g2_a21oi_1
X_13800__2379 _13800_/RESET_B VDD VSS sg13g2_tiehi
X_10797_ _10798_/B _10797_/A _12346_/A _10797_/C VDD VSS sg13g2_nand3_1
XFILLER_160_1345 VDD VSS sg13g2_decap_8
XFILLER_12_483 VDD VSS sg13g2_decap_8
X_12536_ _12536_/X _14696_/Q _14728_/Q _13768_/Q _13800_/Q _12759_/S0 _12759_/S1 VDD
+ VSS sg13g2_mux4_1
XFILLER_9_966 VDD VSS sg13g2_decap_8
XFILLER_76_7 VDD VSS sg13g2_decap_8
XFILLER_33_91 VDD VSS sg13g2_decap_8
XFILLER_129_179 VDD VSS sg13g2_decap_8
XFILLER_145_639 VDD VSS sg13g2_fill_2
XFILLER_8_476 VDD VSS sg13g2_decap_8
XFILLER_32_1061 VDD VSS sg13g2_decap_8
XFILLER_172_414 VDD VSS sg13g2_decap_8
XFILLER_126_820 VDD VSS sg13g2_decap_8
X_12467_ _12467_/X _12464_/X _12463_/X _12460_/X _12459_/X _12719_/S0 _12720_/S VDD
+ VSS sg13g2_mux4_1
XFILLER_173_948 VDD VSS sg13g2_decap_4
X_14206_ _14206_/Q _14686_/CLK _14206_/D _14206_/RESET_B VDD VSS sg13g2_dfrbpq_1
XFILLER_125_330 VDD VSS sg13g2_decap_8
X_11418_ _11419_/B _11418_/A _14207_/Q VDD VSS sg13g2_nand2_1
X_15186_ _15186_/Q _15188_/CLK _15186_/D _15186_/RESET_B VDD VSS sg13g2_dfrbpq_1
X_12398_ _12398_/X _12389_/X _12390_/X _12396_/X _12395_/X _12398_/S0 _12398_/S1 VDD
+ VSS sg13g2_mux4_1
XFILLER_98_203 VDD VSS sg13g2_decap_8
X_14137_ _14137_/Q clkload21/A _14137_/D _14137_/RESET_B VDD VSS sg13g2_dfrbpq_1
XFILLER_119_1236 VDD VSS sg13g2_fill_2
X_11349_ _11349_/Y _11350_/A1 _13758_/Q VDD VSS sg13g2_nand2b_1
XFILLER_28_1119 VDD VSS sg13g2_decap_8
XFILLER_4_693 VDD VSS sg13g2_decap_8
X_14068_ _14068_/Q _14516_/CLK _14068_/D _14068_/RESET_B VDD VSS sg13g2_dfrbpq_1
XFILLER_140_366 VDD VSS sg13g2_decap_8
XFILLER_80_1335 VDD VSS sg13g2_decap_4
XFILLER_79_461 VDD VSS sg13g2_decap_4
XFILLER_79_472 VDD VSS sg13g2_decap_8
X_13019_ _13019_/Y _13017_/Y _13018_/Y _12933_/Y VDD VSS sg13g2_o21ai_1
XFILLER_95_998 VDD VSS sg13g2_decap_8
X_14467__1712 _14467_/RESET_B VDD VSS sg13g2_tiehi
X_08560_ _08561_/C _08560_/A _08599_/B _08560_/C VDD VSS sg13g2_nor3_1
XFILLER_66_199 VDD VSS sg13g2_fill_2
XFILLER_54_339 VDD VSS sg13g2_decap_8
XFILLER_39_1204 VDD VSS sg13g2_decap_8
X_08491_ _08501_/D _08329_/B _08329_/A _08490_/Y VDD VSS sg13g2_o21ai_1
XFILLER_39_1248 VDD VSS sg13g2_fill_1
XFILLER_22_203 VDD VSS sg13g2_decap_8
XFILLER_165_1289 VDD VSS sg13g2_decap_4
XFILLER_149_923 VDD VSS sg13g2_decap_4
XFILLER_13_28 VDD VSS sg13g2_decap_8
X_09112_ _13778_/D _13778_/Q _10128_/A0 _09112_/S VDD VSS sg13g2_mux2_1
XFILLER_149_978 VDD VSS sg13g2_decap_8
Xclkbuf_4_10_0_clk_i clkbuf_4_10_0_clk_i/X clkbuf_0_clk_i/X VDD VSS sg13g2_buf_8
XFILLER_129_28 VDD VSS sg13g2_decap_8
XFILLER_149_989 VDD VSS sg13g2_fill_1
XFILLER_164_915 VDD VSS sg13g2_decap_4
XFILLER_30_291 VDD VSS sg13g2_decap_8
X_09043_ _09056_/C _09043_/A _09043_/B VDD VSS sg13g2_nor2_1
XFILLER_15_1281 VDD VSS sg13g2_decap_8
XFILLER_164_959 VDD VSS sg13g2_decap_8
XFILLER_11_1134 VDD VSS sg13g2_decap_8
XFILLER_117_842 VDD VSS sg13g2_decap_8
XFILLER_102_1273 VDD VSS sg13g2_fill_1
XFILLER_163_469 VDD VSS sg13g2_decap_8
XFILLER_144_650 VDD VSS sg13g2_fill_2
X_13955__2224 _13955_/RESET_B VDD VSS sg13g2_tiehi
XFILLER_132_801 VDD VSS sg13g2_decap_8
XFILLER_104_503 VDD VSS sg13g2_decap_8
XFILLER_137_1303 VDD VSS sg13g2_fill_1
XFILLER_117_897 VDD VSS sg13g2_decap_8
XFILLER_143_182 VDD VSS sg13g2_decap_8
XFILLER_145_49 VDD VSS sg13g2_decap_8
XFILLER_89_236 VDD VSS sg13g2_decap_8
XFILLER_132_856 VDD VSS sg13g2_fill_2
Xfanout901 _13293_/D _13312_/A VDD VSS sg13g2_buf_1
Xfanout912 _13271_/C _15207_/Q VDD VSS sg13g2_buf_1
X_09945_ _14529_/D _14529_/Q _09945_/A1 _09966_/S VDD VSS sg13g2_mux2_1
Xfanout923 _13563_/B _13601_/B VDD VSS sg13g2_buf_1
XFILLER_131_366 VDD VSS sg13g2_decap_8
Xfanout934 _13396_/C _13438_/B VDD VSS sg13g2_buf_1
Xfanout945 _12348_/A _15125_/Q VDD VSS sg13g2_buf_1
XFILLER_38_14 VDD VSS sg13g2_decap_8
Xfanout956 _13273_/B _15107_/Q VDD VSS sg13g2_buf_1
XFILLER_86_932 VDD VSS sg13g2_fill_1
Xfanout967 _08497_/A _08369_/B VDD VSS sg13g2_buf_1
X_09876_ _14462_/D _09909_/A1 _14462_/Q _09898_/S VDD VSS sg13g2_mux2_1
XFILLER_85_420 VDD VSS sg13g2_decap_8
XFILLER_57_111 VDD VSS sg13g2_decap_4
Xfanout978 _07720_/C _13345_/B VDD VSS sg13g2_buf_1
Xfanout989 _09905_/A _09938_/A VDD VSS sg13g2_buf_1
X_08827_ _13692_/D _08825_/Y _08824_/Y _08826_/Y VDD VSS sg13g2_a21oi_1
XFILLER_58_689 VDD VSS sg13g2_decap_8
XFILLER_46_829 VDD VSS sg13g2_decap_4
XFILLER_2_1302 VDD VSS sg13g2_decap_8
XFILLER_39_870 VDD VSS sg13g2_fill_1
XFILLER_39_881 VDD VSS sg13g2_decap_8
XFILLER_72_114 VDD VSS sg13g2_decap_8
X_08758_ _08758_/Y _13671_/Q _08761_/B VDD VSS sg13g2_nor2_1
XFILLER_72_125 VDD VSS sg13g2_decap_8
XFILLER_26_542 VDD VSS sg13g2_decap_8
XFILLER_22_1296 VDD VSS sg13g2_decap_8
X_07709_ _07754_/B _13283_/A _14895_/Q _07708_/Y VDD VSS sg13g2_a21oi_1
XFILLER_54_35 VDD VSS sg13g2_decap_8
XFILLER_2_1379 VDD VSS sg13g2_fill_1
X_14909__2726 _14909_/RESET_B VDD VSS sg13g2_tiehi
X_08689_ _08690_/C _08692_/C _08048_/B _08001_/A VDD VSS sg13g2_a21oi_1
XFILLER_92_1217 VDD VSS sg13g2_fill_1
XFILLER_57_1337 VDD VSS sg13g2_decap_8
XFILLER_13_203 VDD VSS sg13g2_decap_8
XFILLER_81_681 VDD VSS sg13g2_decap_8
X_10720_ _10720_/Y _10720_/A _10720_/B VDD VSS sg13g2_nor2_1
XFILLER_92_1239 VDD VSS sg13g2_fill_2
XFILLER_41_534 VDD VSS sg13g2_decap_8
XFILLER_80_180 VDD VSS sg13g2_decap_8
XFILLER_144_1329 VDD VSS sg13g2_fill_1
XFILLER_16_1001 VDD VSS sg13g2_decap_8
X_10651_ _10652_/D _14886_/Q _14885_/Q _14882_/Q _10651_/D VDD VSS sg13g2_nand4_1
XFILLER_142_1020 VDD VSS sg13g2_decap_8
XFILLER_10_910 VDD VSS sg13g2_decap_8
XFILLER_107_1151 VDD VSS sg13g2_decap_8
XFILLER_167_753 VDD VSS sg13g2_fill_1
XFILLER_107_1173 VDD VSS sg13g2_fill_1
X_13370_ _13442_/A _13401_/C _13401_/B _13429_/A VDD VSS sg13g2_nand3b_1
X_10582_ _10591_/D _14872_/Q _14871_/Q _14870_/Q _10647_/C VDD VSS sg13g2_and4_1
XFILLER_70_67 VDD VSS sg13g2_fill_2
XFILLER_21_280 VDD VSS sg13g2_decap_8
XFILLER_166_252 VDD VSS sg13g2_decap_8
XFILLER_16_1078 VDD VSS sg13g2_decap_8
XFILLER_6_903 VDD VSS sg13g2_decap_8
XFILLER_139_488 VDD VSS sg13g2_decap_8
X_12321_ _12321_/Y _12321_/A1 _14522_/Q _12328_/B1 VDD VSS sg13g2_a21oi_1
XFILLER_10_987 VDD VSS sg13g2_decap_8
XFILLER_5_413 VDD VSS sg13g2_decap_8
X_15040_ _15040_/Q clkload50/A _15040_/D _15040_/RESET_B VDD VSS sg13g2_dfrbpq_1
X_12252_ _12253_/A _14264_/Q _14296_/Q _14328_/Q _14360_/Q _12252_/S0 _12312_/B1 VDD
+ VSS sg13g2_mux4_1
XFILLER_135_650 VDD VSS sg13g2_fill_1
XFILLER_79_21 VDD VSS sg13g2_decap_8
XFILLER_102_0 VDD VSS sg13g2_decap_8
XFILLER_163_981 VDD VSS sg13g2_decap_8
X_14545__1634 _14545_/RESET_B VDD VSS sg13g2_tiehi
X_11203_ _11203_/Y _11202_/A _11199_/Y _11202_/Y VDD VSS sg13g2_a21oi_1
XFILLER_163_992 VDD VSS sg13g2_fill_1
X_12183_ _12183_/X _13846_/Q _13878_/Q _12186_/A VDD VSS sg13g2_mux2_1
XFILLER_134_171 VDD VSS sg13g2_decap_4
XFILLER_150_642 VDD VSS sg13g2_fill_1
XFILLER_1_630 VDD VSS sg13g2_decap_8
X_11134_ _11146_/B _11145_/A _11163_/A VDD VSS sg13g2_xnor2_1
XFILLER_150_675 VDD VSS sg13g2_decap_8
X_14799__2914 _14799_/RESET_B VDD VSS sg13g2_tiehi
XFILLER_0_140 VDD VSS sg13g2_decap_8
XFILLER_27_1152 VDD VSS sg13g2_decap_8
X_11065_ _11088_/A _11119_/A _11011_/Y _11063_/Y VDD VSS sg13g2_o21ai_1
XFILLER_114_1122 VDD VSS sg13g2_decap_8
XFILLER_95_42 VDD VSS sg13g2_decap_8
XFILLER_7_1246 VDD VSS sg13g2_decap_8
XFILLER_114_1133 VDD VSS sg13g2_fill_2
Xhold3090 hold3090/X input14/X VDD VSS sg13g2_dlygate4sd3_1
XFILLER_114_1144 VDD VSS sg13g2_decap_8
X_10016_ _14598_/D _10082_/A0 _14598_/Q _10027_/S VDD VSS sg13g2_mux2_1
XFILLER_62_1087 VDD VSS sg13g2_decap_8
XFILLER_37_829 VDD VSS sg13g2_decap_8
XFILLER_149_1207 VDD VSS sg13g2_fill_2
X_14824_ _14824_/Q _14890_/CLK _14824_/D _14824_/RESET_B VDD VSS sg13g2_dfrbpq_1
XFILLER_97_1139 VDD VSS sg13g2_decap_8
XFILLER_40_1352 VDD VSS sg13g2_decap_8
XFILLER_92_957 VDD VSS sg13g2_decap_8
XFILLER_64_648 VDD VSS sg13g2_decap_4
XFILLER_64_659 VDD VSS sg13g2_decap_8
XFILLER_28_91 VDD VSS sg13g2_decap_8
XFILLER_151_70 VDD VSS sg13g2_decap_8
XFILLER_151_92 VDD VSS sg13g2_decap_4
XFILLER_63_158 VDD VSS sg13g2_decap_4
XFILLER_17_553 VDD VSS sg13g2_decap_8
X_14755_ _14755_/Q clkload64/A _14755_/D _14755_/RESET_B VDD VSS sg13g2_dfrbpq_1
X_11967_ _11971_/A _11966_/X _12023_/B VDD VSS sg13g2_nand2b_1
XFILLER_32_512 VDD VSS sg13g2_decap_8
X_13706_ _16868_/A clkload57/A _13706_/D _13706_/RESET_B VDD VSS sg13g2_dfrbpq_1
X_10918_ _10945_/B _14756_/Q _10936_/D _10888_/Y VDD VSS sg13g2_a21oi_1
XFILLER_72_692 VDD VSS sg13g2_decap_4
XFILLER_32_523 VDD VSS sg13g2_fill_2
X_14686_ _14686_/Q _14686_/CLK _14686_/D _14686_/RESET_B VDD VSS sg13g2_dfrbpq_1
X_11898_ _11898_/Y _11898_/A _11898_/B _12092_/C VDD VSS sg13g2_nand3_1
XFILLER_60_854 VDD VSS sg13g2_fill_1
XFILLER_32_567 VDD VSS sg13g2_decap_8
XFILLER_20_707 VDD VSS sg13g2_decap_8
X_13637_ _13745_/D _13637_/A VDD VSS sg13g2_buf_1
X_10849_ _14930_/D _10849_/A _10849_/B VDD VSS sg13g2_nand2_1
XFILLER_73_1161 VDD VSS sg13g2_decap_8
XFILLER_13_770 VDD VSS sg13g2_decap_8
XFILLER_34_1134 VDD VSS sg13g2_decap_8
XFILLER_160_1142 VDD VSS sg13g2_decap_8
XFILLER_12_280 VDD VSS sg13g2_decap_8
XFILLER_160_1153 VDD VSS sg13g2_fill_1
X_13568_ _15154_/D _15154_/Q _13567_/Y _13570_/S VDD VSS sg13g2_mux2_1
XFILLER_146_915 VDD VSS sg13g2_decap_4
XFILLER_9_763 VDD VSS sg13g2_decap_8
XFILLER_125_1295 VDD VSS sg13g2_decap_8
XFILLER_145_414 VDD VSS sg13g2_fill_2
X_12519_ _12519_/X _14567_/Q _14599_/Q _14631_/Q _14663_/Q _12522_/S0 _12522_/S1 VDD
+ VSS sg13g2_mux4_1
XFILLER_8_273 VDD VSS sg13g2_decap_8
X_13499_ _13499_/Y _13499_/A _13499_/B _13499_/C VDD VSS sg13g2_nand3_1
XFILLER_117_138 VDD VSS sg13g2_decap_8
X_14184__1995 _14184_/RESET_B VDD VSS sg13g2_tiehi
X_15238_ _15238_/Q _15247_/CLK _15238_/D _15238_/RESET_B VDD VSS sg13g2_dfrbpq_1
XFILLER_126_661 VDD VSS sg13g2_decap_4
XFILLER_160_428 VDD VSS sg13g2_decap_8
XFILLER_5_980 VDD VSS sg13g2_decap_8
XFILLER_114_834 VDD VSS sg13g2_decap_8
XFILLER_126_694 VDD VSS sg13g2_fill_1
X_15169_ _15169_/Q _15183_/CLK _15169_/D _15169_/RESET_B VDD VSS sg13g2_dfrbpq_1
XFILLER_114_845 VDD VSS sg13g2_fill_2
XFILLER_158_1082 VDD VSS sg13g2_decap_8
XFILLER_5_84 VDD VSS sg13g2_decap_8
XFILLER_4_490 VDD VSS sg13g2_decap_8
XFILLER_119_1055 VDD VSS sg13g2_fill_1
Xfanout208 _10056_/A0 _10123_/A0 VDD VSS sg13g2_buf_1
Xfanout219 fanout219/X _09070_/Y VDD VSS sg13g2_buf_1
X_07991_ _15057_/D _07991_/A VDD VSS sg13g2_inv_1
XFILLER_80_1110 VDD VSS sg13g2_decap_8
XFILLER_86_206 VDD VSS sg13g2_decap_4
X_09730_ _14321_/D _09928_/A1 _14321_/Q _09730_/S VDD VSS sg13g2_mux2_1
XFILLER_80_1132 VDD VSS sg13g2_decap_4
XFILLER_132_1211 VDD VSS sg13g2_decap_8
XFILLER_68_943 VDD VSS sg13g2_fill_2
XFILLER_171_1271 VDD VSS sg13g2_decap_8
XFILLER_68_954 VDD VSS sg13g2_decap_8
XFILLER_95_751 VDD VSS sg13g2_fill_2
XFILLER_45_1285 VDD VSS sg13g2_decap_8
X_09661_ _14254_/D _09859_/A1 _14254_/Q _09667_/S VDD VSS sg13g2_mux2_1
XFILLER_39_144 VDD VSS sg13g2_decap_4
XFILLER_83_913 VDD VSS sg13g2_decap_8
XFILLER_55_604 VDD VSS sg13g2_decap_4
XFILLER_82_401 VDD VSS sg13g2_decap_8
X_08612_ _08612_/X _08611_/Y _08610_/Y _08649_/S VDD VSS sg13g2_mux2_1
XFILLER_67_497 VDD VSS sg13g2_fill_2
X_09592_ _14189_/D _14189_/Q _09625_/A0 _09596_/S VDD VSS sg13g2_mux2_1
XFILLER_94_294 VDD VSS sg13g2_fill_2
XFILLER_82_434 VDD VSS sg13g2_decap_8
XFILLER_27_339 VDD VSS sg13g2_fill_1
XFILLER_54_147 VDD VSS sg13g2_decap_8
X_08543_ _08545_/C _08553_/A _08522_/C _08542_/Y VDD VSS sg13g2_a21oi_1
XFILLER_36_884 VDD VSS sg13g2_fill_1
XFILLER_51_821 VDD VSS sg13g2_fill_1
XFILLER_78_1094 VDD VSS sg13g2_decap_8
X_08474_ _08475_/A _08138_/X _08400_/Y _08473_/Y VDD VSS sg13g2_a21o_1
XFILLER_165_1064 VDD VSS sg13g2_decap_8
X_14623__1556 _14623_/RESET_B VDD VSS sg13g2_tiehi
XFILLER_11_707 VDD VSS sg13g2_decap_8
XFILLER_24_49 VDD VSS sg13g2_decap_8
XFILLER_168_539 VDD VSS sg13g2_decap_8
XFILLER_143_1340 VDD VSS sg13g2_fill_2
XFILLER_10_217 VDD VSS sg13g2_decap_8
XFILLER_137_904 VDD VSS sg13g2_fill_2
XFILLER_17_1365 VDD VSS sg13g2_decap_8
XFILLER_13_1218 VDD VSS sg13g2_decap_8
XFILLER_148_252 VDD VSS sg13g2_decap_8
XFILLER_52_1267 VDD VSS sg13g2_fill_2
XFILLER_164_712 VDD VSS sg13g2_decap_8
X_09026_ _13765_/D _13765_/Q _10048_/A0 _09106_/S VDD VSS sg13g2_mux2_1
XFILLER_3_917 VDD VSS sg13g2_decap_8
XFILLER_163_266 VDD VSS sg13g2_decap_8
XFILLER_105_823 VDD VSS sg13g2_fill_2
XFILLER_2_427 VDD VSS sg13g2_decap_8
XFILLER_137_1122 VDD VSS sg13g2_decap_4
XFILLER_6_7 VDD VSS sg13g2_decap_8
XFILLER_105_856 VDD VSS sg13g2_decap_8
XFILLER_160_951 VDD VSS sg13g2_fill_2
XFILLER_172_1013 VDD VSS sg13g2_fill_2
XFILLER_105_878 VDD VSS sg13g2_fill_1
XFILLER_137_1155 VDD VSS sg13g2_decap_4
XFILLER_49_35 VDD VSS sg13g2_decap_8
XFILLER_172_14 VDD VSS sg13g2_decap_8
XFILLER_172_1046 VDD VSS sg13g2_decap_8
XFILLER_160_984 VDD VSS sg13g2_fill_1
XFILLER_59_910 VDD VSS sg13g2_decap_8
Xfanout720 _11690_/B _11739_/B VDD VSS sg13g2_buf_1
XFILLER_172_1057 VDD VSS sg13g2_fill_1
XFILLER_104_388 VDD VSS sg13g2_decap_8
XFILLER_137_1188 VDD VSS sg13g2_decap_8
Xfanout731 _13412_/C _13483_/A2 VDD VSS sg13g2_buf_1
XFILLER_172_1068 VDD VSS sg13g2_fill_1
XFILLER_104_399 VDD VSS sg13g2_fill_1
Xfanout742 _08511_/S _08223_/S VDD VSS sg13g2_buf_1
X_09928_ _14513_/D _14513_/Q _09928_/A1 _09928_/S VDD VSS sg13g2_mux2_1
XFILLER_49_79 VDD VSS sg13g2_decap_8
Xfanout753 _08329_/B _07629_/Y VDD VSS sg13g2_buf_1
Xfanout764 _08649_/S _08548_/A VDD VSS sg13g2_buf_1
Xfanout775 _12664_/S fanout783/X VDD VSS sg13g2_buf_1
XFILLER_86_751 VDD VSS sg13g2_decap_8
X_15081__2831 _15081_/RESET_B VDD VSS sg13g2_tiehi
Xfanout786 _12720_/S _12776_/S VDD VSS sg13g2_buf_1
XFILLER_105_63 VDD VSS sg13g2_decap_8
Xfanout797 _12760_/S0 _12454_/S1 VDD VSS sg13g2_buf_1
X_09859_ _14446_/D _14446_/Q _09859_/A1 _09871_/S VDD VSS sg13g2_mux2_1
XFILLER_24_1358 VDD VSS sg13g2_decap_8
XFILLER_74_924 VDD VSS sg13g2_decap_8
XFILLER_73_423 VDD VSS sg13g2_decap_8
X_12870_ _12871_/B _12869_/Y _12870_/A2 _12878_/D _12861_/X _12865_/Y VDD VSS sg13g2_a221oi_1
XFILLER_74_968 VDD VSS sg13g2_decap_8
X_11821_ _11822_/A _14252_/Q _14284_/Q _14316_/Q _14348_/Q _11821_/S0 _11374_/C VDD
+ VSS sg13g2_mux4_1
XFILLER_27_862 VDD VSS sg13g2_decap_4
XFILLER_22_1093 VDD VSS sg13g2_decap_8
XFILLER_33_309 VDD VSS sg13g2_fill_1
X_15167__2505 _15167_/RESET_B VDD VSS sg13g2_tiehi
XFILLER_2_1176 VDD VSS sg13g2_decap_8
XFILLER_96_1183 VDD VSS sg13g2_decap_8
XFILLER_109_1202 VDD VSS sg13g2_decap_8
X_14540_ _14540_/Q clkload13/A _14540_/D _14540_/RESET_B VDD VSS sg13g2_dfrbpq_1
XFILLER_109_1213 VDD VSS sg13g2_fill_2
X_11752_ _11752_/Y _11748_/Y _11749_/Y _11751_/Y _11750_/Y _11815_/B VDD VSS sg13g2_a221oi_1
XFILLER_57_1145 VDD VSS sg13g2_fill_2
XFILLER_92_1036 VDD VSS sg13g2_decap_8
XFILLER_92_1047 VDD VSS sg13g2_decap_4
XFILLER_14_567 VDD VSS sg13g2_decap_8
X_10703_ _14903_/D _10999_/B1 _10923_/A _10702_/Y VDD VSS sg13g2_o21ai_1
X_14471_ _14471_/Q clkload18/A _14471_/D _14471_/RESET_B VDD VSS sg13g2_dfrbpq_1
X_15149__2659 _15149_/RESET_B VDD VSS sg13g2_tiehi
XFILLER_81_66 VDD VSS sg13g2_decap_4
X_11683_ _11683_/Y _11692_/A _14472_/Q VDD VSS sg13g2_nand2b_1
X_13422_ _15094_/D _13490_/D _13421_/Y _13419_/Y VDD VSS sg13g2_o21ai_1
X_10634_ _10637_/B _14886_/Q _10633_/C _10392_/B VDD VSS sg13g2_o21ai_1
XFILLER_139_252 VDD VSS sg13g2_decap_8
XFILLER_6_700 VDD VSS sg13g2_decap_8
XFILLER_128_948 VDD VSS sg13g2_decap_8
X_13353_ _13353_/Y _13507_/A _13507_/B VDD VSS sg13g2_nor2_1
X_10565_ _10576_/D _10567_/C _10565_/B _10565_/C _10565_/D VDD VSS sg13g2_nor4_1
XFILLER_10_784 VDD VSS sg13g2_decap_8
XFILLER_139_296 VDD VSS sg13g2_decap_8
XFILLER_5_210 VDD VSS sg13g2_decap_8
XFILLER_154_233 VDD VSS sg13g2_decap_8
XFILLER_155_756 VDD VSS sg13g2_decap_8
X_12304_ _12308_/A _12303_/X _12304_/B VDD VSS sg13g2_nand2b_1
X_13284_ _13284_/Y _08831_/B _13284_/B _13300_/C VDD VSS sg13g2_nand3b_1
X_10496_ _14852_/D _10497_/B _10619_/B _10496_/C VDD VSS sg13g2_and3_1
XFILLER_6_777 VDD VSS sg13g2_decap_8
XFILLER_108_672 VDD VSS sg13g2_decap_8
XFILLER_170_726 VDD VSS sg13g2_decap_8
X_15023_ _15023_/Q _15214_/CLK _15023_/D _15023_/RESET_B VDD VSS sg13g2_dfrbpq_1
XFILLER_30_70 VDD VSS sg13g2_decap_8
X_14061__2118 _14061_/RESET_B VDD VSS sg13g2_tiehi
X_12235_ _12236_/B _12235_/A _14232_/Q VDD VSS sg13g2_nand2_1
XFILLER_154_299 VDD VSS sg13g2_decap_8
XFILLER_5_287 VDD VSS sg13g2_decap_8
XFILLER_123_631 VDD VSS sg13g2_decap_8
XFILLER_107_193 VDD VSS sg13g2_fill_2
XFILLER_29_1247 VDD VSS sg13g2_decap_8
X_12166_ _12170_/A _12165_/X _12233_/B VDD VSS sg13g2_nand2b_1
XFILLER_69_718 VDD VSS sg13g2_decap_8
XFILLER_39_7 VDD VSS sg13g2_decap_8
XFILLER_123_686 VDD VSS sg13g2_decap_8
XFILLER_151_1108 VDD VSS sg13g2_decap_8
XFILLER_122_163 VDD VSS sg13g2_fill_1
X_11117_ _11117_/Y _11138_/B _11138_/C _11139_/B1 VDD VSS sg13g2_a21oi_1
XFILLER_2_994 VDD VSS sg13g2_decap_8
XFILLER_68_239 VDD VSS sg13g2_decap_8
XFILLER_111_859 VDD VSS sg13g2_decap_8
X_12097_ _12097_/Y _12100_/S0 _14644_/Q VDD VSS sg13g2_nand2b_1
X_14701__1478 _14701_/RESET_B VDD VSS sg13g2_tiehi
XFILLER_7_1043 VDD VSS sg13g2_decap_8
XFILLER_110_369 VDD VSS sg13g2_decap_8
X_11048_ _11048_/Y _11048_/A _11048_/B VDD VSS sg13g2_nand2_1
XFILLER_49_464 VDD VSS sg13g2_decap_8
Xinput8 input8/X input8/A VDD VSS sg13g2_buf_1
XFILLER_77_784 VDD VSS sg13g2_fill_1
XFILLER_162_91 VDD VSS sg13g2_decap_8
XFILLER_149_1004 VDD VSS sg13g2_decap_8
XFILLER_91_231 VDD VSS sg13g2_decap_8
XFILLER_18_840 VDD VSS sg13g2_decap_8
X_14807_ _14807_/Q clkload51/A _14807_/D _14807_/RESET_B VDD VSS sg13g2_dfrbpq_1
XFILLER_92_776 VDD VSS sg13g2_decap_8
XFILLER_17_350 VDD VSS sg13g2_decap_8
X_12999_ _12999_/Y _12996_/Y _12998_/Y _12933_/Y VDD VSS sg13g2_o21ai_1
XFILLER_79_1381 VDD VSS sg13g2_fill_2
XFILLER_75_1212 VDD VSS sg13g2_decap_8
XFILLER_51_117 VDD VSS sg13g2_decap_8
XFILLER_33_821 VDD VSS sg13g2_decap_8
XFILLER_51_128 VDD VSS sg13g2_fill_1
X_14738_ _14738_/Q clkload23/A _14738_/D _14738_/RESET_B VDD VSS sg13g2_dfrbpq_1
XFILLER_75_1256 VDD VSS sg13g2_decap_8
XFILLER_127_1335 VDD VSS sg13g2_decap_4
X_14669_ _14669_/Q clkload2/A _14669_/D _14669_/RESET_B VDD VSS sg13g2_dfrbpq_1
XFILLER_20_504 VDD VSS sg13g2_decap_8
X_08190_ _08190_/Y _08248_/A _08190_/B VDD VSS sg13g2_nor2_1
X_14271__1908 _14271_/RESET_B VDD VSS sg13g2_tiehi
XFILLER_9_560 VDD VSS sg13g2_decap_8
XFILLER_146_745 VDD VSS sg13g2_fill_2
XFILLER_118_447 VDD VSS sg13g2_decap_4
XFILLER_65_0 VDD VSS sg13g2_decap_8
XFILLER_69_1027 VDD VSS sg13g2_decap_8
XFILLER_69_1038 VDD VSS sg13g2_fill_2
XFILLER_161_715 VDD VSS sg13g2_decap_4
XFILLER_127_981 VDD VSS sg13g2_decap_4
XFILLER_133_428 VDD VSS sg13g2_fill_1
XFILLER_160_203 VDD VSS sg13g2_decap_8
XFILLER_161_737 VDD VSS sg13g2_decap_8
XFILLER_12_1295 VDD VSS sg13g2_decap_8
X_14037__2142 _14037_/RESET_B VDD VSS sg13g2_tiehi
XFILLER_47_1336 VDD VSS sg13g2_decap_8
XFILLER_134_1317 VDD VSS sg13g2_fill_2
XFILLER_114_686 VDD VSS sg13g2_fill_1
XFILLER_142_995 VDD VSS sg13g2_decap_4
XFILLER_59_217 VDD VSS sg13g2_decap_8
XFILLER_102_848 VDD VSS sg13g2_decap_4
XFILLER_141_494 VDD VSS sg13g2_decap_8
XFILLER_101_336 VDD VSS sg13g2_fill_2
X_07974_ _07976_/B _08697_/B _08698_/A _07974_/C _07974_/D VDD VSS sg13g2_and4_1
XFILLER_68_740 VDD VSS sg13g2_decap_4
X_09713_ _14304_/D _09911_/A1 _14304_/Q _09736_/S VDD VSS sg13g2_mux2_1
XFILLER_45_1093 VDD VSS sg13g2_decap_8
XFILLER_19_49 VDD VSS sg13g2_decap_8
XFILLER_171_1090 VDD VSS sg13g2_decap_4
XFILLER_142_28 VDD VSS sg13g2_decap_8
XFILLER_68_773 VDD VSS sg13g2_decap_4
XFILLER_142_39 VDD VSS sg13g2_fill_1
XFILLER_110_881 VDD VSS sg13g2_decap_8
X_09644_ _14237_/D _10140_/A1 _14237_/Q _09667_/S VDD VSS sg13g2_mux2_1
XFILLER_27_147 VDD VSS sg13g2_decap_8
X_09575_ _14172_/D _14172_/Q _09608_/A0 _09599_/S VDD VSS sg13g2_mux2_1
XFILLER_71_927 VDD VSS sg13g2_fill_1
XFILLER_110_1372 VDD VSS sg13g2_fill_2
XFILLER_70_415 VDD VSS sg13g2_decap_8
XFILLER_110_1383 VDD VSS sg13g2_fill_1
X_08526_ _08535_/B _08526_/A _08526_/B _08526_/C VDD VSS sg13g2_and3_1
XFILLER_93_1356 VDD VSS sg13g2_decap_8
X_15009__2578 _15009_/RESET_B VDD VSS sg13g2_tiehi
XFILLER_11_504 VDD VSS sg13g2_decap_8
XFILLER_169_848 VDD VSS sg13g2_decap_8
X_08457_ _08457_/X _07949_/C _07945_/B _07946_/B _08383_/A _13509_/A1 _13510_/A1 VDD
+ VSS sg13g2_mux4_1
XFILLER_51_673 VDD VSS sg13g2_decap_8
XFILLER_23_364 VDD VSS sg13g2_decap_8
XFILLER_143_7 VDD VSS sg13g2_decap_8
XFILLER_168_336 VDD VSS sg13g2_decap_8
XFILLER_51_14 VDD VSS sg13g2_decap_8
XFILLER_167_14 VDD VSS sg13g2_decap_8
X_08388_ _08388_/Y _08374_/Y _08375_/Y _08387_/Y VDD VSS sg13g2_o21ai_1
XFILLER_17_1162 VDD VSS sg13g2_decap_8
XFILLER_143_1170 VDD VSS sg13g2_decap_4
XFILLER_13_1015 VDD VSS sg13g2_decap_8
X_14247__1932 _14247_/RESET_B VDD VSS sg13g2_tiehi
XFILLER_149_594 VDD VSS sg13g2_decap_8
XFILLER_109_458 VDD VSS sg13g2_decap_8
XFILLER_164_553 VDD VSS sg13g2_decap_8
X_10350_ _14809_/D _10350_/A _10350_/B _10353_/C VDD VSS sg13g2_and3_1
XFILLER_3_714 VDD VSS sg13g2_decap_8
XFILLER_30_1373 VDD VSS sg13g2_decap_8
X_09009_ _10697_/A _15029_/Q _15226_/Q _09009_/S VDD VSS sg13g2_mux2_1
X_10281_ _10281_/Y _14786_/Q _14787_/Q _14788_/Q _10281_/D VDD VSS sg13g2_nand4_1
XFILLER_2_224 VDD VSS sg13g2_decap_8
X_12020_ _12021_/A _14706_/Q _14738_/Q _13778_/Q _13810_/Q _12238_/S0 _12026_/C VDD
+ VSS sg13g2_mux4_1
XFILLER_78_504 VDD VSS sg13g2_fill_2
XFILLER_120_601 VDD VSS sg13g2_decap_8
XFILLER_78_537 VDD VSS sg13g2_decap_8
XFILLER_8_1330 VDD VSS sg13g2_decap_8
Xfanout550 _08544_/B _08400_/Y VDD VSS sg13g2_buf_1
XFILLER_28_1280 VDD VSS sg13g2_decap_8
Xfanout561 _13546_/B2 _12936_/Y VDD VSS sg13g2_buf_1
Xfanout572 _13272_/A2 _12914_/A VDD VSS sg13g2_buf_1
XFILLER_76_55 VDD VSS sg13g2_fill_1
XFILLER_63_1182 VDD VSS sg13g2_decap_4
XFILLER_47_902 VDD VSS sg13g2_decap_4
X_13971_ _13971_/Q clkload16/A _13971_/D _13971_/RESET_B VDD VSS sg13g2_dfrbpq_1
Xfanout583 _11196_/B _11170_/B VDD VSS sg13g2_buf_1
XFILLER_59_773 VDD VSS sg13g2_fill_1
XFILLER_24_1155 VDD VSS sg13g2_decap_8
Xfanout594 _09006_/A _09137_/A VDD VSS sg13g2_buf_1
X_12922_ _12945_/A _14902_/Q _13685_/Q VDD VSS sg13g2_nand2_1
XFILLER_98_1234 VDD VSS sg13g2_decap_8
XFILLER_58_283 VDD VSS sg13g2_fill_1
XFILLER_20_1008 VDD VSS sg13g2_decap_8
XFILLER_19_637 VDD VSS sg13g2_decap_8
XFILLER_111_1147 VDD VSS sg13g2_fill_1
X_13735__2444 _13735_/RESET_B VDD VSS sg13g2_tiehi
X_14495__1684 _14495_/RESET_B VDD VSS sg13g2_tiehi
XFILLER_18_147 VDD VSS sg13g2_decap_8
XFILLER_92_21 VDD VSS sg13g2_decap_4
XFILLER_73_253 VDD VSS sg13g2_decap_8
X_12853_ _12853_/Y _14770_/Q _13275_/A2 _13140_/B2 VDD VSS sg13g2_o21ai_1
XFILLER_27_670 VDD VSS sg13g2_decap_4
X_11804_ _11805_/B _11804_/A _14220_/Q VDD VSS sg13g2_nand2_1
X_12784_ _12784_/X _14586_/Q _14618_/Q _14650_/Q _14682_/Q _12785_/S0 _12785_/S1 VDD
+ VSS sg13g2_mux4_1
XFILLER_15_854 VDD VSS sg13g2_decap_8
XFILLER_109_1032 VDD VSS sg13g2_fill_2
X_14523_ _14523_/Q clkload46/A _14523_/D _14523_/RESET_B VDD VSS sg13g2_dfrbpq_1
X_11735_ _11736_/A _13962_/Q _13994_/Q _14026_/Q _14058_/Q _11749_/A1 _11897_/C VDD
+ VSS sg13g2_mux4_1
XFILLER_25_70 VDD VSS sg13g2_decap_8
XFILLER_14_364 VDD VSS sg13g2_decap_8
XFILLER_159_336 VDD VSS sg13g2_decap_8
X_14115__2064 _14115_/RESET_B VDD VSS sg13g2_tiehi
XFILLER_109_1076 VDD VSS sg13g2_decap_8
X_14454_ _14454_/Q clkload24/A _14454_/D _14454_/RESET_B VDD VSS sg13g2_dfrbpq_1
X_11666_ _11666_/Y _11676_/A1 _13864_/Q _12038_/B1 VDD VSS sg13g2_a21oi_1
XFILLER_41_194 VDD VSS sg13g2_decap_8
XFILLER_70_1142 VDD VSS sg13g2_decap_8
XFILLER_174_306 VDD VSS sg13g2_decap_8
XFILLER_174_317 VDD VSS sg13g2_decap_8
X_13405_ _13405_/Y _13427_/A _13469_/A _15090_/Q VDD VSS sg13g2_nand3_1
X_10617_ _10619_/C _10651_/D _10622_/C VDD VSS sg13g2_or2_1
X_14385_ _14385_/Q _14667_/CLK _14385_/D _14385_/RESET_B VDD VSS sg13g2_dfrbpq_1
X_11597_ _11598_/B _11597_/A _14214_/Q VDD VSS sg13g2_nand2_1
XFILLER_10_581 VDD VSS sg13g2_decap_8
XFILLER_122_1265 VDD VSS sg13g2_decap_8
XFILLER_31_1148 VDD VSS sg13g2_decap_8
XFILLER_143_704 VDD VSS sg13g2_decap_8
X_13336_ _15172_/D hold3029/X _15172_/Q _13336_/S VDD VSS sg13g2_mux2_1
XFILLER_41_80 VDD VSS sg13g2_fill_2
XFILLER_155_564 VDD VSS sg13g2_decap_8
X_10548_ _14864_/D _10556_/D _10572_/B _10548_/C VDD VSS sg13g2_nor3_1
XFILLER_143_715 VDD VSS sg13g2_fill_1
XFILLER_143_726 VDD VSS sg13g2_fill_2
XFILLER_6_574 VDD VSS sg13g2_decap_8
XFILLER_157_91 VDD VSS sg13g2_decap_8
XFILLER_108_480 VDD VSS sg13g2_decap_8
X_13267_ _13270_/C _14925_/Q _13662_/Q VDD VSS sg13g2_xnor2_1
X_13983__2196 _13983_/RESET_B VDD VSS sg13g2_tiehi
X_10479_ _10505_/B _10489_/C _14847_/Q VDD VSS sg13g2_and2_1
XFILLER_68_1060 VDD VSS sg13g2_fill_2
XFILLER_170_567 VDD VSS sg13g2_decap_8
X_15006_ _15006_/Q _15015_/CLK _15006_/D _15006_/RESET_B VDD VSS sg13g2_dfrbpq_1
XFILLER_130_409 VDD VSS sg13g2_decap_8
XFILLER_155_1030 VDD VSS sg13g2_fill_2
X_12218_ _12223_/B _12217_/Y _12208_/Y _12217_/A _12216_/X _12221_/B1 VDD VSS sg13g2_a221oi_1
XFILLER_111_601 VDD VSS sg13g2_decap_8
X_13198_ _15046_/D _13191_/Y _13197_/Y _13198_/B1 VDD VSS sg13g2_a21oi_1
XFILLER_9_1127 VDD VSS sg13g2_decap_8
XFILLER_151_781 VDD VSS sg13g2_decap_8
XFILLER_151_792 VDD VSS sg13g2_fill_1
X_12149_ _14983_/D _12149_/A _12149_/B VDD VSS sg13g2_nand2_1
XFILLER_96_334 VDD VSS sg13g2_decap_8
XFILLER_2_791 VDD VSS sg13g2_decap_8
XFILLER_96_345 VDD VSS sg13g2_fill_1
XFILLER_111_667 VDD VSS sg13g2_decap_4
XFILLER_111_678 VDD VSS sg13g2_fill_1
XFILLER_81_1282 VDD VSS sg13g2_fill_2
XFILLER_42_1244 VDD VSS sg13g2_fill_1
XFILLER_65_710 VDD VSS sg13g2_decap_8
XFILLER_2_63 VDD VSS sg13g2_decap_8
XFILLER_65_721 VDD VSS sg13g2_fill_1
XFILLER_133_1383 VDD VSS sg13g2_fill_1
XFILLER_65_743 VDD VSS sg13g2_decap_8
X_07690_ _07690_/X _07690_/A _11241_/C VDD VSS sg13g2_and2_1
XFILLER_42_1299 VDD VSS sg13g2_decap_8
XFILLER_53_905 VDD VSS sg13g2_fill_2
XFILLER_37_456 VDD VSS sg13g2_decap_8
X_14325__1854 _14325_/RESET_B VDD VSS sg13g2_tiehi
XFILLER_53_927 VDD VSS sg13g2_fill_2
XFILLER_52_426 VDD VSS sg13g2_decap_8
X_09360_ _13964_/D _09624_/A0 _13964_/Q _09368_/S VDD VSS sg13g2_mux2_1
X_08311_ _08312_/C _08616_/B _08381_/A VDD VSS sg13g2_nor2b_1
X_09291_ _13899_/D _13899_/Q _09922_/A1 _09297_/S VDD VSS sg13g2_mux2_1
XFILLER_32_150 VDD VSS sg13g2_fill_1
XFILLER_20_301 VDD VSS sg13g2_decap_8
XFILLER_162_1045 VDD VSS sg13g2_fill_1
XANTENNA_13 _16872_/A VDD VSS sg13g2_antennanp
XFILLER_127_1176 VDD VSS sg13g2_fill_2
XFILLER_60_481 VDD VSS sg13g2_decap_8
X_08242_ _08688_/B _08242_/A _08270_/B VDD VSS sg13g2_nand2_1
XANTENNA_24 _13005_/C VDD VSS sg13g2_antennanp
XFILLER_14_1302 VDD VSS sg13g2_decap_8
XFILLER_21_868 VDD VSS sg13g2_decap_8
XFILLER_140_1310 VDD VSS sg13g2_decap_4
X_08173_ _08514_/A _08340_/B _08431_/C VDD VSS sg13g2_nand2_1
XFILLER_20_378 VDD VSS sg13g2_decap_8
XFILLER_158_391 VDD VSS sg13g2_fill_2
XFILLER_21_28 VDD VSS sg13g2_decap_8
XFILLER_174_851 VDD VSS sg13g2_fill_2
XFILLER_14_1379 VDD VSS sg13g2_decap_4
XFILLER_173_350 VDD VSS sg13g2_decap_8
XFILLER_137_28 VDD VSS sg13g2_decap_8
XFILLER_118_277 VDD VSS sg13g2_fill_1
XFILLER_161_512 VDD VSS sg13g2_decap_8
XFILLER_146_597 VDD VSS sg13g2_decap_8
XFILLER_12_1092 VDD VSS sg13g2_decap_8
XFILLER_133_236 VDD VSS sg13g2_decap_8
Xoutput120 mem_axi_wdata[24] _15156_/Q VDD VSS sg13g2_buf_1
X_13813__2366 _13813_/RESET_B VDD VSS sg13g2_tiehi
X_15087__2817 _15087_/RESET_B VDD VSS sg13g2_tiehi
Xoutput131 mem_axi_wdata[5] _15137_/Q VDD VSS sg13g2_buf_1
XFILLER_47_1133 VDD VSS sg13g2_decap_8
XFILLER_173_1130 VDD VSS sg13g2_fill_1
XFILLER_173_1141 VDD VSS sg13g2_fill_2
XFILLER_102_612 VDD VSS sg13g2_decap_4
XFILLER_138_1272 VDD VSS sg13g2_decap_8
X_14837__2870 _14837_/RESET_B VDD VSS sg13g2_tiehi
XFILLER_101_100 VDD VSS sg13g2_fill_1
XFILLER_142_792 VDD VSS sg13g2_fill_1
XFILLER_101_111 VDD VSS sg13g2_fill_1
XFILLER_134_1136 VDD VSS sg13g2_decap_8
XFILLER_153_49 VDD VSS sg13g2_decap_8
XFILLER_87_367 VDD VSS sg13g2_decap_8
X_07957_ _07958_/A _08567_/A _07956_/Y _07950_/Y _07829_/A _07954_/Y VDD VSS sg13g2_a221oi_1
XFILLER_96_890 VDD VSS sg13g2_decap_8
XFILLER_46_14 VDD VSS sg13g2_decap_8
XFILLER_56_732 VDD VSS sg13g2_decap_4
XFILLER_29_957 VDD VSS sg13g2_fill_2
X_07888_ _08229_/C _08203_/B _07888_/B VDD VSS sg13g2_nand2_1
XFILLER_44_905 VDD VSS sg13g2_fill_2
XFILLER_56_776 VDD VSS sg13g2_fill_1
X_09627_ _14223_/D _09959_/A1 _14223_/Q _09629_/S VDD VSS sg13g2_mux2_1
XFILLER_55_253 VDD VSS sg13g2_decap_8
XFILLER_3_1260 VDD VSS sg13g2_decap_8
X_09558_ _14156_/D _09624_/A0 _14156_/Q _09566_/S VDD VSS sg13g2_mux2_1
XFILLER_145_1210 VDD VSS sg13g2_decap_8
XFILLER_102_86 VDD VSS sg13g2_decap_8
X_08509_ _08517_/B _08659_/A _08170_/X _08676_/B2 VDD VSS sg13g2_o21ai_1
XFILLER_62_35 VDD VSS sg13g2_decap_8
XFILLER_58_1284 VDD VSS sg13g2_decap_8
XFILLER_102_97 VDD VSS sg13g2_fill_1
XFILLER_93_1175 VDD VSS sg13g2_fill_1
XFILLER_169_645 VDD VSS sg13g2_decap_8
X_09489_ _14089_/D _09953_/A1 _14089_/Q _09505_/S VDD VSS sg13g2_mux2_1
XFILLER_52_993 VDD VSS sg13g2_decap_8
XFILLER_19_1246 VDD VSS sg13g2_decap_8
XFILLER_106_1205 VDD VSS sg13g2_fill_1
XFILLER_11_301 VDD VSS sg13g2_decap_8
XFILLER_23_161 VDD VSS sg13g2_decap_8
XFILLER_168_133 VDD VSS sg13g2_decap_8
XFILLER_93_1197 VDD VSS sg13g2_decap_8
X_11520_ _11520_/Y _14902_/Q _11655_/B _11722_/B2 VDD VSS sg13g2_a21oi_1
XFILLER_106_1238 VDD VSS sg13g2_decap_4
XFILLER_12_868 VDD VSS sg13g2_decap_8
XFILLER_11_378 VDD VSS sg13g2_decap_8
X_11451_ _11451_/Y _11450_/Y _11448_/X _11433_/Y VDD VSS sg13g2_o21ai_1
XFILLER_109_222 VDD VSS sg13g2_decap_8
XFILLER_165_851 VDD VSS sg13g2_fill_1
X_10402_ _10402_/Y _14823_/Q _10413_/B _10392_/B VDD VSS sg13g2_o21ai_1
X_14170_ _14170_/Q _14682_/CLK _14170_/D _14170_/RESET_B VDD VSS sg13g2_dfrbpq_1
XFILLER_164_350 VDD VSS sg13g2_decap_8
XFILLER_165_884 VDD VSS sg13g2_fill_1
X_11382_ _11385_/A _11339_/B _11335_/X _11336_/A VDD VSS sg13g2_a21oi_1
XFILLER_109_288 VDD VSS sg13g2_decap_8
X_13121_ _13121_/Y _14819_/Q _13068_/B _13150_/B _14851_/Q VDD VSS sg13g2_a22oi_1
XFILLER_3_511 VDD VSS sg13g2_decap_8
XFILLER_30_1170 VDD VSS sg13g2_decap_8
X_10333_ _10335_/B _14803_/Q _14804_/Q _10414_/B _10345_/C VDD VSS sg13g2_nand4_1
XFILLER_124_247 VDD VSS sg13g2_decap_4
X_14403__1776 _14403_/RESET_B VDD VSS sg13g2_tiehi
XFILLER_112_409 VDD VSS sg13g2_decap_8
X_13052_ _13052_/Y _14846_/Q _07727_/B _13028_/B _14878_/Q _13051_/X VDD VSS sg13g2_a221oi_1
X_10264_ _10266_/C _14782_/Q _10268_/D _14783_/Q VDD VSS sg13g2_a21oi_1
XFILLER_87_21 VDD VSS sg13g2_decap_8
XFILLER_117_1323 VDD VSS sg13g2_decap_8
XFILLER_3_588 VDD VSS sg13g2_decap_8
X_12003_ _12003_/Y _13142_/A _11792_/B _11868_/A VDD VSS sg13g2_a21oi_1
XFILLER_78_312 VDD VSS sg13g2_decap_4
XFILLER_26_1217 VDD VSS sg13g2_decap_8
XFILLER_156_1383 VDD VSS sg13g2_fill_1
Xfanout1301 _11597_/A _11741_/A VDD VSS sg13g2_buf_1
XFILLER_120_420 VDD VSS sg13g2_fill_1
Xfanout1312 _11676_/A1 _12238_/S0 VDD VSS sg13g2_buf_1
X_10195_ _15198_/D hold3066/X _15198_/Q _13479_/S VDD VSS sg13g2_mux2_1
XFILLER_65_1277 VDD VSS sg13g2_decap_8
XFILLER_117_1356 VDD VSS sg13g2_decap_8
Xfanout1323 _11893_/S _11896_/A VDD VSS sg13g2_buf_1
XFILLER_120_442 VDD VSS sg13g2_fill_2
Xfanout1334 _11229_/S0 fanout1346/X VDD VSS sg13g2_buf_1
XFILLER_87_87 VDD VSS sg13g2_fill_2
Xfanout1345 _12321_/A1 fanout1346/X VDD VSS sg13g2_buf_1
Xfanout1356 _12073_/S0 fanout1358/X VDD VSS sg13g2_buf_1
XFILLER_93_304 VDD VSS sg13g2_decap_8
X_13968__2211 _13968_/RESET_B VDD VSS sg13g2_tiehi
Xfanout1367 _12257_/A1 _12212_/S0 VDD VSS sg13g2_buf_1
XFILLER_120_486 VDD VSS sg13g2_fill_1
X_15055__2511 _15055_/RESET_B VDD VSS sg13g2_tiehi
Xfanout380 _10146_/A1 _09316_/A0 VDD VSS sg13g2_buf_1
Xfanout1378 _13155_/A _13198_/B1 VDD VSS sg13g2_buf_1
Xfanout391 _10043_/A0 _10076_/A0 VDD VSS sg13g2_buf_1
Xfanout1389 _10619_/B _10499_/C VDD VSS sg13g2_buf_1
X_13954_ _13954_/Q _14722_/CLK _13954_/D _13954_/RESET_B VDD VSS sg13g2_dfrbpq_1
XFILLER_19_434 VDD VSS sg13g2_decap_8
XFILLER_98_1031 VDD VSS sg13g2_fill_2
XFILLER_93_359 VDD VSS sg13g2_decap_8
XFILLER_4_1057 VDD VSS sg13g2_decap_8
XFILLER_98_1053 VDD VSS sg13g2_fill_1
X_12905_ _12943_/A _14901_/Q _13686_/Q VDD VSS sg13g2_nor2_1
X_13885_ _13885_/Q clkload45/A _13885_/D _13885_/RESET_B VDD VSS sg13g2_dfrbpq_1
X_14890__2764 _14890_/RESET_B VDD VSS sg13g2_tiehi
X_12836_ _12836_/Y _14895_/Q _12836_/B _12836_/C VDD VSS sg13g2_nand3_1
XFILLER_36_91 VDD VSS sg13g2_decap_8
XFILLER_15_651 VDD VSS sg13g2_decap_8
Xclkbuf_5_13__f_clk_i clkbuf_leaf_47_clk_i/A clkbuf_4_6_0_clk_i/X VDD VSS sg13g2_buf_16
X_12767_ _12767_/X _13753_/Q _14105_/Q _14457_/Q _14553_/Q _12767_/S0 _12767_/S1 VDD
+ VSS sg13g2_mux4_1
XFILLER_14_161 VDD VSS sg13g2_decap_8
XFILLER_159_133 VDD VSS sg13g2_decap_8
XFILLER_37_1357 VDD VSS sg13g2_decap_8
X_14506_ _14506_/Q clkload12/A _14506_/D _14506_/RESET_B VDD VSS sg13g2_dfrbpq_1
X_11718_ _11718_/X _11710_/X _11711_/X _11714_/X _11715_/X _12290_/S0 _12290_/S1 VDD
+ VSS sg13g2_mux4_1
XFILLER_124_1338 VDD VSS sg13g2_fill_1
XFILLER_124_1349 VDD VSS sg13g2_fill_2
X_12698_ _12698_/X _14388_/Q _14420_/Q _14484_/Q _14516_/Q _12785_/S0 _12785_/S1 VDD
+ VSS sg13g2_mux4_1
XFILLER_147_317 VDD VSS sg13g2_decap_8
X_14437_ _14437_/Q clkload5/A _14437_/D _14437_/RESET_B VDD VSS sg13g2_dfrbpq_1
Xinput11 input11/X input11/A VDD VSS sg13g2_buf_1
X_11649_ _11649_/X _14375_/Q _14407_/Q _14471_/Q _14503_/Q _11649_/S0 _12138_/S1 VDD
+ VSS sg13g2_mux4_1
XFILLER_156_840 VDD VSS sg13g2_fill_2
Xinput22 input22/X input22/A VDD VSS sg13g2_buf_1
Xinput33 input33/X input33/A VDD VSS sg13g2_buf_1
XFILLER_156_873 VDD VSS sg13g2_decap_8
X_14368_ _14368_/Q clkload31/A _14368_/D _14368_/RESET_B VDD VSS sg13g2_dfrbpq_1
XFILLER_7_861 VDD VSS sg13g2_decap_8
XFILLER_122_1084 VDD VSS sg13g2_decap_8
XFILLER_156_895 VDD VSS sg13g2_decap_4
X_13319_ _15063_/D _13324_/A _13319_/B VDD VSS sg13g2_nor2_1
XFILLER_6_371 VDD VSS sg13g2_decap_8
X_14299_ _14299_/Q clkload45/A _14299_/D _14299_/RESET_B VDD VSS sg13g2_dfrbpq_1
XFILLER_170_364 VDD VSS sg13g2_decap_8
XFILLER_88_109 VDD VSS sg13g2_decap_4
XFILLER_130_206 VDD VSS sg13g2_fill_1
XFILLER_171_898 VDD VSS sg13g2_fill_1
XFILLER_112_921 VDD VSS sg13g2_fill_1
XFILLER_124_781 VDD VSS sg13g2_decap_8
XFILLER_170_1303 VDD VSS sg13g2_decap_8
X_08860_ _08860_/X _08859_/X _08860_/A1 _08860_/S VDD VSS sg13g2_mux2_1
XFILLER_111_453 VDD VSS sg13g2_fill_2
X_07811_ _08522_/A _07956_/A _07812_/B VDD VSS sg13g2_or2_1
XFILLER_28_0 VDD VSS sg13g2_decap_8
XFILLER_170_1369 VDD VSS sg13g2_decap_8
XFILLER_112_998 VDD VSS sg13g2_decap_8
X_08791_ _08791_/Y _13499_/C _15176_/Q _15119_/Q _13279_/B _08825_/C1 VDD VSS sg13g2_a221oi_1
XFILLER_57_529 VDD VSS sg13g2_fill_2
X_14558__1621 _14558_/RESET_B VDD VSS sg13g2_tiehi
XFILLER_38_732 VDD VSS sg13g2_decap_4
X_07742_ _07744_/C _13300_/C wire649/X VDD VSS sg13g2_and2_1
XFILLER_38_787 VDD VSS sg13g2_decap_8
X_07673_ _07677_/B _15055_/Q _13293_/D VDD VSS sg13g2_nor2b_1
XFILLER_16_28 VDD VSS sg13g2_decap_8
X_09412_ _14014_/D _09610_/A0 _14014_/Q _09434_/S VDD VSS sg13g2_mux2_1
XFILLER_25_437 VDD VSS sg13g2_fill_1
XFILLER_20_1372 VDD VSS sg13g2_decap_8
XFILLER_20_1383 VDD VSS sg13g2_fill_1
X_09343_ _13947_/D _09574_/A1 _13947_/Q _09368_/S VDD VSS sg13g2_mux2_1
XFILLER_139_818 VDD VSS sg13g2_decap_8
XFILLER_139_829 VDD VSS sg13g2_fill_2
X_09274_ _09306_/S _09307_/B _09707_/B _09707_/C VDD VSS sg13g2_nor3_1
XFILLER_21_665 VDD VSS sg13g2_decap_8
X_08225_ _08233_/B _08224_/X _08397_/A _08004_/Y _08214_/X VDD VSS sg13g2_a22oi_1
XFILLER_32_49 VDD VSS sg13g2_decap_8
XFILLER_53_1181 VDD VSS sg13g2_decap_4
XFILLER_20_175 VDD VSS sg13g2_decap_8
XFILLER_140_1140 VDD VSS sg13g2_decap_8
XFILLER_148_49 VDD VSS sg13g2_decap_8
XFILLER_165_147 VDD VSS sg13g2_decap_8
XFILLER_88_1200 VDD VSS sg13g2_fill_1
XFILLER_140_1151 VDD VSS sg13g2_fill_1
X_14660__1519 _14660_/RESET_B VDD VSS sg13g2_tiehi
X_08156_ _08166_/C _08188_/A _08142_/A _08155_/Y _07869_/X _08154_/Y VDD VSS sg13g2_a221oi_1
XFILLER_14_1176 VDD VSS sg13g2_decap_8
XFILLER_4_308 VDD VSS sg13g2_decap_8
XFILLER_107_726 VDD VSS sg13g2_decap_8
XFILLER_10_1029 VDD VSS sg13g2_decap_8
XFILLER_162_832 VDD VSS sg13g2_decap_8
XFILLER_106_7 VDD VSS sg13g2_decap_8
X_08087_ _08087_/X _08085_/A _08079_/X _08086_/B _08081_/X _08270_/B _08279_/B VDD
+ VSS sg13g2_mux4_1
XFILLER_173_180 VDD VSS sg13g2_decap_8
XFILLER_161_331 VDD VSS sg13g2_decap_8
XFILLER_84_1119 VDD VSS sg13g2_decap_8
XFILLER_134_567 VDD VSS sg13g2_decap_8
XFILLER_79_109 VDD VSS sg13g2_fill_2
XFILLER_88_621 VDD VSS sg13g2_decap_8
XFILLER_0_525 VDD VSS sg13g2_decap_8
XFILLER_103_943 VDD VSS sg13g2_decap_8
X_14197__1982 _14197_/RESET_B VDD VSS sg13g2_tiehi
XFILLER_57_35 VDD VSS sg13g2_decap_8
X_08989_ _08989_/X _09006_/A _08985_/X _08988_/Y VDD VSS sg13g2_a21o_1
XFILLER_88_698 VDD VSS sg13g2_decap_8
XFILLER_57_68 VDD VSS sg13g2_fill_1
XFILLER_5_1344 VDD VSS sg13g2_decap_8
XFILLER_112_1231 VDD VSS sg13g2_decap_8
XFILLER_151_1280 VDD VSS sg13g2_decap_8
XFILLER_169_1018 VDD VSS sg13g2_decap_8
XFILLER_60_1174 VDD VSS sg13g2_decap_8
XFILLER_91_819 VDD VSS sg13g2_decap_8
XFILLER_28_242 VDD VSS sg13g2_decap_8
X_10951_ _10956_/A _11004_/A _10949_/Y _10950_/Y VDD VSS sg13g2_o21ai_1
XFILLER_71_510 VDD VSS sg13g2_decap_4
XFILLER_29_798 VDD VSS sg13g2_fill_1
XFILLER_21_1169 VDD VSS sg13g2_decap_8
XFILLER_17_938 VDD VSS sg13g2_decap_8
XFILLER_95_1237 VDD VSS sg13g2_decap_4
XFILLER_28_286 VDD VSS sg13g2_decap_8
XFILLER_147_1305 VDD VSS sg13g2_decap_8
XFILLER_16_448 VDD VSS sg13g2_decap_8
X_13670_ _13670_/Q _15064_/CLK _13670_/D _13670_/RESET_B VDD VSS sg13g2_dfrbpq_1
X_10882_ _10883_/B _14753_/Q _10871_/A _10869_/B VDD VSS sg13g2_a21oi_1
XFILLER_73_67 VDD VSS sg13g2_decap_4
X_12621_ _12621_/X _12620_/X _12619_/X _12616_/X _12615_/X _12705_/S0 _12567_/S VDD
+ VSS sg13g2_mux4_1
XFILLER_169_420 VDD VSS sg13g2_decap_8
XFILLER_43_278 VDD VSS sg13g2_decap_8
XFILLER_25_982 VDD VSS sg13g2_fill_2
XFILLER_145_1040 VDD VSS sg13g2_decap_4
XFILLER_19_1043 VDD VSS sg13g2_decap_8
X_12552_ _12552_/X _12550_/X _12549_/X _12546_/X _12545_/X _12775_/S1 _12720_/S VDD
+ VSS sg13g2_mux4_1
XFILLER_12_665 VDD VSS sg13g2_decap_8
XFILLER_132_0 VDD VSS sg13g2_decap_8
XFILLER_145_1095 VDD VSS sg13g2_fill_1
XFILLER_106_1057 VDD VSS sg13g2_decap_8
XFILLER_169_497 VDD VSS sg13g2_decap_8
X_11503_ _11777_/C _11461_/A _13687_/Q _13686_/Q _11483_/A _11463_/Y VDD VSS sg13g2_a221oi_1
X_12483_ _12483_/X _12481_/X _12482_/X _12776_/S VDD VSS sg13g2_mux2_1
XFILLER_11_175 VDD VSS sg13g2_decap_8
XFILLER_89_1019 VDD VSS sg13g2_fill_2
XFILLER_71_1281 VDD VSS sg13g2_decap_8
XFILLER_156_147 VDD VSS sg13g2_decap_8
XFILLER_8_658 VDD VSS sg13g2_decap_8
X_14222_ _14222_/Q clkload36/A _14222_/D _14222_/RESET_B VDD VSS sg13g2_dfrbpq_1
X_11434_ _11434_/X _14112_/Q _14144_/Q _14176_/Q _14208_/Q _11493_/S0 _11493_/S1 VDD
+ VSS sg13g2_mux4_1
XFILLER_172_618 VDD VSS sg13g2_decap_8
XFILLER_165_670 VDD VSS sg13g2_decap_8
XFILLER_7_168 VDD VSS sg13g2_decap_8
XFILLER_125_523 VDD VSS sg13g2_fill_1
X_14636__1543 _14636_/RESET_B VDD VSS sg13g2_tiehi
XFILLER_67_1306 VDD VSS sg13g2_fill_1
X_14153_ _14153_/Q _14649_/CLK _14153_/D _14153_/RESET_B VDD VSS sg13g2_dfrbpq_1
X_11365_ _11366_/B _11373_/A _14494_/Q VDD VSS sg13g2_nand2_1
XFILLER_152_331 VDD VSS sg13g2_decap_8
XFILLER_67_1339 VDD VSS sg13g2_decap_8
X_13104_ _13104_/Y _13104_/A _13104_/B VDD VSS sg13g2_xnor2_1
XFILLER_152_364 VDD VSS sg13g2_decap_8
X_10316_ _14798_/D _10342_/A _10342_/C _10315_/Y VDD VSS sg13g2_a21oi_1
XFILLER_4_875 VDD VSS sg13g2_decap_8
XFILLER_113_729 VDD VSS sg13g2_decap_8
X_14084_ _14084_/Q clkload17/A _14084_/D _14084_/RESET_B VDD VSS sg13g2_dfrbpq_1
XFILLER_152_375 VDD VSS sg13g2_decap_8
X_11296_ _11296_/Y _11300_/S0 _13853_/Q _11366_/C VDD VSS sg13g2_a21oi_1
XFILLER_79_610 VDD VSS sg13g2_decap_8
X_13035_ _13035_/Y _13034_/Y _13048_/B _13031_/Y VDD VSS sg13g2_a21oi_1
XFILLER_3_385 VDD VSS sg13g2_decap_8
XFILLER_156_1180 VDD VSS sg13g2_decap_8
X_10247_ _10255_/D _14775_/Q _14776_/Q _14777_/Q wire525/X VDD VSS sg13g2_and4_1
XFILLER_26_1014 VDD VSS sg13g2_decap_8
XFILLER_117_1142 VDD VSS sg13g2_decap_8
XFILLER_156_1191 VDD VSS sg13g2_fill_1
XFILLER_154_70 VDD VSS sg13g2_decap_8
Xfanout1120 _08471_/B _08470_/B VDD VSS sg13g2_buf_1
XFILLER_78_142 VDD VSS sg13g2_decap_8
XFILLER_39_507 VDD VSS sg13g2_decap_8
XFILLER_117_1164 VDD VSS sg13g2_fill_2
Xfanout1131 _11770_/A _14973_/Q VDD VSS sg13g2_buf_1
XFILLER_94_602 VDD VSS sg13g2_decap_8
XFILLER_78_153 VDD VSS sg13g2_fill_1
Xfanout1142 _08376_/A3 _14969_/Q VDD VSS sg13g2_buf_1
XFILLER_21_7 VDD VSS sg13g2_decap_8
XFILLER_117_1186 VDD VSS sg13g2_decap_8
Xfanout1153 _07929_/B _08300_/A3 VDD VSS sg13g2_buf_1
X_10178_ _10182_/A _10178_/A _10185_/B _10184_/C VDD VSS sg13g2_nand3_1
XFILLER_79_698 VDD VSS sg13g2_decap_8
XFILLER_113_1028 VDD VSS sg13g2_decap_8
XFILLER_120_272 VDD VSS sg13g2_decap_8
Xclkbuf_leaf_7_clk_i clkload6/A clkbuf_leaf_8_clk_i/A VDD VSS sg13g2_buf_8
Xfanout1164 _08142_/C _14960_/Q VDD VSS sg13g2_buf_1
XFILLER_43_1361 VDD VSS sg13g2_fill_2
XFILLER_120_283 VDD VSS sg13g2_decap_8
X_15004__2583 _15004_/RESET_B VDD VSS sg13g2_tiehi
Xfanout1175 _12997_/A _13602_/A VDD VSS sg13g2_buf_1
XFILLER_152_1099 VDD VSS sg13g2_decap_8
Xfanout1186 _13088_/A _14912_/Q VDD VSS sg13g2_buf_1
Xfanout1197 _10566_/D _14862_/Q VDD VSS sg13g2_buf_1
XFILLER_94_668 VDD VSS sg13g2_fill_2
X_14986_ _14986_/Q clkload28/A _14986_/D _14986_/RESET_B VDD VSS sg13g2_dfrbpq_1
XFILLER_47_540 VDD VSS sg13g2_decap_8
XFILLER_19_231 VDD VSS sg13g2_decap_8
XFILLER_47_551 VDD VSS sg13g2_decap_8
XFILLER_47_562 VDD VSS sg13g2_decap_4
XFILLER_47_90 VDD VSS sg13g2_decap_8
X_13937_ _13937_/Q _14662_/CLK _13937_/D _13937_/RESET_B VDD VSS sg13g2_dfrbpq_1
XFILLER_47_584 VDD VSS sg13g2_decap_8
XFILLER_170_91 VDD VSS sg13g2_decap_8
X_13868_ _13868_/Q clkload37/A _13868_/D _13868_/RESET_B VDD VSS sg13g2_dfrbpq_1
XFILLER_34_256 VDD VSS sg13g2_decap_8
XFILLER_37_1110 VDD VSS sg13g2_decap_8
X_12819_ _12819_/Y _14768_/Q _13275_/A2 _13140_/B2 VDD VSS sg13g2_o21ai_1
X_13799_ _13799_/Q _14727_/CLK _13799_/D _13799_/RESET_B VDD VSS sg13g2_dfrbpq_1
XFILLER_148_604 VDD VSS sg13g2_decap_8
XFILLER_31_963 VDD VSS sg13g2_decap_8
XFILLER_129_840 VDD VSS sg13g2_decap_8
X_08010_ _08010_/Y _08054_/B _08010_/B VDD VSS sg13g2_nand2_1
XFILLER_135_309 VDD VSS sg13g2_decap_8
XFILLER_8_84 VDD VSS sg13g2_decap_8
XFILLER_11_1316 VDD VSS sg13g2_decap_8
XFILLER_144_821 VDD VSS sg13g2_decap_8
XFILLER_143_320 VDD VSS sg13g2_fill_2
XFILLER_144_865 VDD VSS sg13g2_fill_2
XFILLER_89_407 VDD VSS sg13g2_decap_8
X_09961_ _14545_/D _14545_/Q _10127_/A0 _09961_/S VDD VSS sg13g2_mux2_1
XFILLER_89_418 VDD VSS sg13g2_fill_1
XFILLER_170_161 VDD VSS sg13g2_decap_8
X_08912_ _08912_/Y _10776_/C _10793_/B _15041_/Q VDD VSS sg13g2_nand3_1
XFILLER_48_1272 VDD VSS sg13g2_decap_8
XFILLER_112_740 VDD VSS sg13g2_fill_1
XFILLER_134_18 VDD VSS sg13g2_decap_8
X_09892_ _14478_/D _09925_/A1 _14478_/Q _09892_/S VDD VSS sg13g2_mux2_1
XFILLER_69_131 VDD VSS sg13g2_decap_8
XFILLER_83_1185 VDD VSS sg13g2_fill_2
XFILLER_170_1144 VDD VSS sg13g2_decap_8
XFILLER_98_985 VDD VSS sg13g2_decap_4
XFILLER_112_773 VDD VSS sg13g2_decap_8
X_08843_ _08843_/Y _08843_/A _08860_/S VDD VSS sg13g2_nand2_1
XFILLER_85_613 VDD VSS sg13g2_decap_8
XFILLER_100_924 VDD VSS sg13g2_decap_8
XFILLER_112_784 VDD VSS sg13g2_fill_1
XFILLER_58_838 VDD VSS sg13g2_decap_8
XFILLER_100_935 VDD VSS sg13g2_fill_2
XFILLER_84_101 VDD VSS sg13g2_decap_8
X_14074__2105 _14074_/RESET_B VDD VSS sg13g2_tiehi
X_08774_ _13676_/D _08728_/Y _08773_/Y _08772_/Y VDD VSS sg13g2_a21oi_1
XFILLER_73_819 VDD VSS sg13g2_decap_8
XFILLER_26_702 VDD VSS sg13g2_decap_8
X_07725_ _07726_/D _15089_/Q _15086_/Q _15076_/Q _15074_/Q VDD VSS sg13g2_nor4_1
XFILLER_27_49 VDD VSS sg13g2_decap_8
XFILLER_150_28 VDD VSS sg13g2_decap_8
XFILLER_26_724 VDD VSS sg13g2_decap_8
XFILLER_129_1002 VDD VSS sg13g2_fill_1
X_07656_ _07656_/Y _11747_/A VDD VSS sg13g2_inv_1
XFILLER_0_1241 VDD VSS sg13g2_decap_8
XFILLER_25_245 VDD VSS sg13g2_decap_8
XFILLER_129_1035 VDD VSS sg13g2_decap_4
XFILLER_81_874 VDD VSS sg13g2_decap_4
X_14714__1465 _14714_/RESET_B VDD VSS sg13g2_tiehi
XFILLER_80_362 VDD VSS sg13g2_decap_4
XFILLER_53_598 VDD VSS sg13g2_decap_4
XFILLER_40_226 VDD VSS sg13g2_decap_8
XFILLER_167_902 VDD VSS sg13g2_decap_8
XFILLER_139_604 VDD VSS sg13g2_decap_4
X_09326_ _13933_/D _10156_/A1 _13933_/Q _09330_/S VDD VSS sg13g2_mux2_1
XFILLER_139_615 VDD VSS sg13g2_decap_8
XFILLER_107_1355 VDD VSS sg13g2_fill_1
XFILLER_139_648 VDD VSS sg13g2_decap_8
XFILLER_21_462 VDD VSS sg13g2_decap_8
XFILLER_166_434 VDD VSS sg13g2_decap_8
X_09257_ _13866_/D _13866_/Q _10153_/A1 _09264_/S VDD VSS sg13g2_mux2_1
X_08208_ _08209_/A _08452_/A _08207_/X _08452_/D VDD VSS sg13g2_mux2_1
XFILLER_147_670 VDD VSS sg13g2_decap_8
X_09188_ _13804_/D _13804_/Q _10155_/A1 _09202_/S VDD VSS sg13g2_mux2_1
XFILLER_119_372 VDD VSS sg13g2_decap_8
XFILLER_4_105 VDD VSS sg13g2_decap_8
XFILLER_134_320 VDD VSS sg13g2_fill_2
X_08139_ _08182_/B _08142_/C _08154_/A VDD VSS sg13g2_nor2_1
XFILLER_135_865 VDD VSS sg13g2_decap_8
XFILLER_88_1074 VDD VSS sg13g2_decap_8
XFILLER_150_802 VDD VSS sg13g2_decap_8
XFILLER_162_662 VDD VSS sg13g2_decap_8
X_11150_ _11150_/Y _11150_/A _11150_/B VDD VSS sg13g2_nand2_1
XFILLER_161_161 VDD VSS sg13g2_decap_8
XFILLER_1_812 VDD VSS sg13g2_decap_8
XFILLER_108_85 VDD VSS sg13g2_fill_2
X_10101_ _14681_/D _10101_/A0 _14681_/Q _10101_/S VDD VSS sg13g2_mux2_1
XFILLER_89_941 VDD VSS sg13g2_decap_8
XFILLER_0_322 VDD VSS sg13g2_decap_8
X_11081_ _11081_/Y _11139_/B1 _11077_/Y _11080_/Y VDD VSS sg13g2_a21oi_1
XFILLER_27_1334 VDD VSS sg13g2_decap_8
XFILLER_153_1342 VDD VSS sg13g2_decap_8
XFILLER_62_1236 VDD VSS sg13g2_decap_8
X_10032_ _14614_/D _10098_/A0 _14614_/Q _10032_/S VDD VSS sg13g2_mux2_1
XFILLER_1_889 VDD VSS sg13g2_decap_8
XFILLER_103_784 VDD VSS sg13g2_decap_4
XFILLER_23_1209 VDD VSS sg13g2_decap_8
XFILLER_76_635 VDD VSS sg13g2_fill_1
XFILLER_0_399 VDD VSS sg13g2_decap_8
X_14840_ _14840_/Q _14874_/CLK _14840_/D _14840_/RESET_B VDD VSS sg13g2_dfrbpq_1
XFILLER_5_1141 VDD VSS sg13g2_decap_8
XFILLER_29_540 VDD VSS sg13g2_fill_1
XFILLER_91_627 VDD VSS sg13g2_fill_2
XFILLER_112_1061 VDD VSS sg13g2_fill_2
X_14771_ _14771_/Q _15113_/CLK _14771_/D _14771_/RESET_B VDD VSS sg13g2_dfrbpq_1
XFILLER_112_1072 VDD VSS sg13g2_decap_8
X_11983_ _12055_/C _11983_/A _13671_/Q VDD VSS sg13g2_xnor2_1
XFILLER_17_735 VDD VSS sg13g2_decap_8
XFILLER_84_690 VDD VSS sg13g2_decap_4
XFILLER_147_1102 VDD VSS sg13g2_decap_8
X_13722_ _16884_/A clkload53/A _13722_/D _13722_/RESET_B VDD VSS sg13g2_dfrbpq_1
XFILLER_95_1034 VDD VSS sg13g2_decap_4
X_10934_ _10934_/Y _10946_/A _10934_/B _10948_/D VDD VSS sg13g2_nand3_1
XFILLER_16_245 VDD VSS sg13g2_decap_8
XFILLER_71_340 VDD VSS sg13g2_decap_8
XFILLER_140_61 VDD VSS sg13g2_decap_8
XFILLER_140_72 VDD VSS sg13g2_fill_1
X_13653_ _15119_/D _15189_/D _15119_/Q _13656_/S VDD VSS sg13g2_mux2_1
X_10865_ _10865_/Y _10865_/A _10865_/B VDD VSS sg13g2_nand2_1
XFILLER_71_384 VDD VSS sg13g2_decap_4
XFILLER_140_94 VDD VSS sg13g2_decap_8
X_12604_ _12604_/X _14701_/Q _14733_/Q _13773_/Q _13805_/Q _12606_/S0 _12606_/S1 VDD
+ VSS sg13g2_mux4_1
XFILLER_13_952 VDD VSS sg13g2_decap_8
X_13772__2407 _13772_/RESET_B VDD VSS sg13g2_tiehi
X_13584_ _13584_/Y _13584_/A _13584_/B VDD VSS sg13g2_nor2_1
XFILLER_31_259 VDD VSS sg13g2_decap_4
X_10796_ _10796_/Y _10796_/A _13294_/B VDD VSS sg13g2_nand2_1
XFILLER_40_760 VDD VSS sg13g2_fill_2
XFILLER_12_462 VDD VSS sg13g2_decap_8
XFILLER_169_294 VDD VSS sg13g2_decap_8
X_12535_ _12535_/X _13832_/Q _13864_/Q _13896_/Q _13928_/Q _12759_/S0 _12759_/S1 VDD
+ VSS sg13g2_mux4_1
XFILLER_9_945 VDD VSS sg13g2_decap_8
XFILLER_33_70 VDD VSS sg13g2_decap_8
XFILLER_121_1319 VDD VSS sg13g2_decap_8
XFILLER_129_158 VDD VSS sg13g2_decap_8
XFILLER_8_455 VDD VSS sg13g2_decap_8
XFILLER_32_1040 VDD VSS sg13g2_decap_8
XFILLER_145_629 VDD VSS sg13g2_fill_2
X_12466_ _12466_/X _13955_/Q _13987_/Q _14019_/Q _14051_/Q _12715_/S0 _12715_/S1 VDD
+ VSS sg13g2_mux4_1
XFILLER_69_7 VDD VSS sg13g2_decap_8
XFILLER_138_692 VDD VSS sg13g2_decap_8
X_14205_ _14205_/Q clkload47/A _14205_/D _14205_/RESET_B VDD VSS sg13g2_dfrbpq_1
X_15089__2809 _15089_/RESET_B VDD VSS sg13g2_tiehi
X_11417_ _11419_/A _11418_/A _14175_/Q VDD VSS sg13g2_nand2b_1
X_14152__2027 _14152_/RESET_B VDD VSS sg13g2_tiehi
X_15185_ _15185_/Q _15213_/CLK _15185_/D _15185_/RESET_B VDD VSS sg13g2_dfrbpq_1
XFILLER_153_640 VDD VSS sg13g2_decap_4
X_12397_ _12397_/X _12392_/X _12394_/X _12391_/X _12393_/X _12567_/S _12398_/S0 VDD
+ VSS sg13g2_mux4_1
X_14136_ _14136_/Q _14632_/CLK _14136_/D _14136_/RESET_B VDD VSS sg13g2_dfrbpq_1
XFILLER_67_1147 VDD VSS sg13g2_decap_8
XFILLER_126_898 VDD VSS sg13g2_decap_8
X_11348_ _11348_/Y _11350_/A1 _14718_/Q _11366_/C VDD VSS sg13g2_a21oi_1
XFILLER_4_672 VDD VSS sg13g2_decap_8
XFILLER_125_386 VDD VSS sg13g2_decap_8
XFILLER_154_1139 VDD VSS sg13g2_decap_8
XFILLER_165_91 VDD VSS sg13g2_decap_8
XFILLER_113_559 VDD VSS sg13g2_decap_8
X_14067_ _14067_/Q clkload17/A _14067_/D _14067_/RESET_B VDD VSS sg13g2_dfrbpq_1
X_15158__2641 _15158_/RESET_B VDD VSS sg13g2_tiehi
XFILLER_3_182 VDD VSS sg13g2_decap_8
X_11279_ _11279_/Y _11277_/S _14204_/Q _12304_/B VDD VSS sg13g2_a21oi_1
XFILLER_98_259 VDD VSS sg13g2_decap_8
XFILLER_80_1314 VDD VSS sg13g2_decap_8
XFILLER_100_209 VDD VSS sg13g2_decap_8
X_13018_ _13018_/Y input25/X _12795_/Y _12937_/Y VDD VSS sg13g2_o21ai_1
XFILLER_95_911 VDD VSS sg13g2_decap_8
XFILLER_95_922 VDD VSS sg13g2_fill_1
XFILLER_67_624 VDD VSS sg13g2_decap_8
XFILLER_41_1309 VDD VSS sg13g2_fill_2
XFILLER_67_635 VDD VSS sg13g2_fill_2
XFILLER_95_966 VDD VSS sg13g2_fill_2
XFILLER_67_657 VDD VSS sg13g2_decap_4
XFILLER_67_679 VDD VSS sg13g2_decap_8
XFILLER_48_871 VDD VSS sg13g2_decap_8
XFILLER_130_1150 VDD VSS sg13g2_fill_1
XFILLER_54_318 VDD VSS sg13g2_decap_8
X_14969_ _14969_/Q clkload52/A _14969_/D _14969_/RESET_B VDD VSS sg13g2_dfrbpq_1
XFILLER_78_1232 VDD VSS sg13g2_decap_8
XFILLER_47_392 VDD VSS sg13g2_decap_8
X_08490_ _08490_/Y _08489_/Y _08488_/Y _08539_/B1 VDD VSS sg13g2_a21oi_1
XFILLER_81_159 VDD VSS sg13g2_decap_8
XFILLER_39_1227 VDD VSS sg13g2_fill_1
XFILLER_63_885 VDD VSS sg13g2_fill_2
XFILLER_62_362 VDD VSS sg13g2_decap_8
XFILLER_78_1298 VDD VSS sg13g2_fill_1
XFILLER_165_1268 VDD VSS sg13g2_decap_8
XFILLER_23_749 VDD VSS sg13g2_decap_8
XFILLER_95_0 VDD VSS sg13g2_decap_8
XFILLER_22_259 VDD VSS sg13g2_decap_8
X_14362__1817 _14362_/RESET_B VDD VSS sg13g2_tiehi
X_13748__2431 _13748_/RESET_B VDD VSS sg13g2_tiehi
X_09111_ _09111_/Y _09111_/A1 _10757_/B _09110_/X VDD VSS sg13g2_o21ai_1
XFILLER_149_957 VDD VSS sg13g2_decap_8
XFILLER_31_793 VDD VSS sg13g2_decap_8
XFILLER_15_1260 VDD VSS sg13g2_decap_8
X_09042_ _09043_/B _14907_/Q _14906_/Q VDD VSS sg13g2_nand2_1
XFILLER_11_1113 VDD VSS sg13g2_decap_8
XFILLER_50_1162 VDD VSS sg13g2_decap_8
XFILLER_135_128 VDD VSS sg13g2_fill_2
XFILLER_163_448 VDD VSS sg13g2_decap_8
XFILLER_50_1195 VDD VSS sg13g2_decap_8
Xclkbuf_leaf_108_clk_i _14516_/CLK clkbuf_5_18__f_clk_i/X VDD VSS sg13g2_buf_8
XFILLER_89_1372 VDD VSS sg13g2_decap_8
X_14128__2051 _14128_/RESET_B VDD VSS sg13g2_tiehi
XFILLER_2_609 VDD VSS sg13g2_decap_8
XFILLER_102_1296 VDD VSS sg13g2_decap_8
XFILLER_145_28 VDD VSS sg13g2_decap_8
XFILLER_1_119 VDD VSS sg13g2_decap_8
XFILLER_171_481 VDD VSS sg13g2_decap_8
XFILLER_137_1348 VDD VSS sg13g2_decap_4
Xfanout902 _13312_/A _07682_/A VDD VSS sg13g2_buf_1
X_09944_ _14528_/D _14528_/Q _10043_/A0 _09966_/S VDD VSS sg13g2_mux2_1
XFILLER_104_559 VDD VSS sg13g2_decap_8
Xfanout913 _12737_/A2 _12765_/A2 VDD VSS sg13g2_buf_1
Xfanout924 _12997_/B _13601_/B VDD VSS sg13g2_buf_1
Xfanout935 _13438_/B _15183_/Q VDD VSS sg13g2_buf_1
X_15057__2503 _15057_/RESET_B VDD VSS sg13g2_tiehi
Xfanout946 _12346_/A _15120_/Q VDD VSS sg13g2_buf_1
Xfanout957 _07728_/B _12879_/B VDD VSS sg13g2_buf_1
X_09875_ _14461_/D _09908_/A1 _14461_/Q _09898_/S VDD VSS sg13g2_mux2_1
Xfanout968 _08369_/B _08391_/A VDD VSS sg13g2_buf_1
Xfanout979 _13345_/B _13310_/B2 VDD VSS sg13g2_buf_1
X_13850__2329 _13850_/RESET_B VDD VSS sg13g2_tiehi
X_08826_ _08826_/Y _12836_/B _08826_/B VDD VSS sg13g2_nor2_1
XFILLER_86_966 VDD VSS sg13g2_fill_2
XFILLER_58_657 VDD VSS sg13g2_decap_8
XFILLER_100_754 VDD VSS sg13g2_decap_8
XFILLER_161_49 VDD VSS sg13g2_decap_8
X_13996__2183 _13996_/RESET_B VDD VSS sg13g2_tiehi
X_14902__2740 _14902_/RESET_B VDD VSS sg13g2_tiehi
XFILLER_79_1007 VDD VSS sg13g2_decap_8
XFILLER_100_776 VDD VSS sg13g2_fill_1
XFILLER_61_1291 VDD VSS sg13g2_fill_1
X_08757_ _08757_/Y _15069_/Q _13342_/A1 _15191_/Q VDD VSS sg13g2_o21ai_1
XFILLER_113_1381 VDD VSS sg13g2_fill_2
XFILLER_57_189 VDD VSS sg13g2_decap_4
XFILLER_173_7 VDD VSS sg13g2_decap_8
XFILLER_38_381 VDD VSS sg13g2_decap_8
XFILLER_22_1275 VDD VSS sg13g2_decap_8
XFILLER_54_14 VDD VSS sg13g2_decap_8
X_07708_ _07708_/Y _07708_/A _07708_/B _07708_/C VDD VSS sg13g2_nor3_1
XFILLER_96_1343 VDD VSS sg13g2_decap_8
XFILLER_2_1358 VDD VSS sg13g2_decap_8
XFILLER_57_1305 VDD VSS sg13g2_fill_1
X_08688_ _08693_/A _08688_/A _08688_/B _08688_/C _08688_/D VDD VSS sg13g2_nand4_1
XFILLER_57_1316 VDD VSS sg13g2_decap_8
XFILLER_96_1376 VDD VSS sg13g2_decap_4
X_14935__2674 _14935_/RESET_B VDD VSS sg13g2_tiehi
X_07639_ _10237_/B _14774_/Q VDD VSS sg13g2_inv_1
XFILLER_14_749 VDD VSS sg13g2_decap_8
XFILLER_110_53 VDD VSS sg13g2_decap_8
X_10650_ _10652_/C _14890_/Q _14889_/Q _14888_/Q _14887_/Q VDD VSS sg13g2_nand4_1
XFILLER_13_259 VDD VSS sg13g2_decap_8
X_14338__1841 _14338_/RESET_B VDD VSS sg13g2_tiehi
X_09309_ _13916_/D _09907_/A1 _13916_/Q _09325_/S VDD VSS sg13g2_mux2_1
XFILLER_166_231 VDD VSS sg13g2_decap_8
X_10581_ _10581_/Y _14872_/Q _10580_/A _10353_/C VDD VSS sg13g2_o21ai_1
XFILLER_16_1057 VDD VSS sg13g2_decap_8
XFILLER_107_1185 VDD VSS sg13g2_fill_1
XFILLER_139_467 VDD VSS sg13g2_decap_8
XFILLER_103_1027 VDD VSS sg13g2_decap_8
XFILLER_155_927 VDD VSS sg13g2_decap_8
X_12320_ _12320_/Y _12321_/A1 _14490_/Q VDD VSS sg13g2_nand2b_1
XFILLER_10_966 VDD VSS sg13g2_decap_8
XFILLER_167_787 VDD VSS sg13g2_decap_8
XFILLER_120_1330 VDD VSS sg13g2_decap_8
XFILLER_119_180 VDD VSS sg13g2_fill_1
X_12251_ _12251_/Y _12247_/Y _12248_/Y _12250_/Y _12249_/Y _12253_/B VDD VSS sg13g2_a221oi_1
XFILLER_6_959 VDD VSS sg13g2_decap_8
XFILLER_120_1374 VDD VSS sg13g2_fill_1
XFILLER_135_662 VDD VSS sg13g2_decap_8
X_11202_ _11202_/Y _11202_/A _11205_/A VDD VSS sg13g2_xnor2_1
XFILLER_5_469 VDD VSS sg13g2_decap_8
XFILLER_135_673 VDD VSS sg13g2_fill_1
X_12182_ _12182_/Y _12179_/Y _12181_/X _12221_/B1 VDD VSS sg13g2_o21ai_1
X_15113__2733 _15113_/RESET_B VDD VSS sg13g2_tiehi
XFILLER_150_621 VDD VSS sg13g2_decap_8
XFILLER_162_481 VDD VSS sg13g2_decap_8
XFILLER_107_397 VDD VSS sg13g2_decap_8
X_11133_ _11133_/Y _11133_/A _11133_/B VDD VSS sg13g2_nand2_1
Xclkbuf_leaf_72_clk_i _15226_/CLK clkbuf_leaf_72_clk_i/A VDD VSS sg13g2_buf_8
XFILLER_110_507 VDD VSS sg13g2_fill_2
XFILLER_62_1011 VDD VSS sg13g2_decap_8
XFILLER_27_1131 VDD VSS sg13g2_decap_8
X_11064_ _11119_/A _11064_/A _11064_/B _11064_/C _11064_/D VDD VSS sg13g2_nand4_1
XFILLER_95_21 VDD VSS sg13g2_decap_8
XFILLER_7_1225 VDD VSS sg13g2_decap_8
XFILLER_1_686 VDD VSS sg13g2_decap_8
XFILLER_131_890 VDD VSS sg13g2_decap_4
XFILLER_76_421 VDD VSS sg13g2_fill_2
XFILLER_49_635 VDD VSS sg13g2_decap_8
Xhold3080 input27/A mem_axi_rdata[30] VDD VSS sg13g2_dlygate4sd3_1
Xhold3091 input3/A mem_axi_bvalid VDD VSS sg13g2_dlygate4sd3_1
X_10015_ _14597_/D _10048_/A0 _14597_/Q _10027_/S VDD VSS sg13g2_mux2_1
XFILLER_0_196 VDD VSS sg13g2_decap_8
XFILLER_153_1194 VDD VSS sg13g2_fill_2
X_14440__1739 _14440_/RESET_B VDD VSS sg13g2_tiehi
X_13826__2353 _13826_/RESET_B VDD VSS sg13g2_tiehi
XFILLER_92_914 VDD VSS sg13g2_decap_8
XFILLER_48_156 VDD VSS sg13g2_decap_8
X_14586__1593 _14586_/RESET_B VDD VSS sg13g2_tiehi
XFILLER_95_98 VDD VSS sg13g2_decap_8
XFILLER_76_476 VDD VSS sg13g2_fill_1
Xclkbuf_leaf_87_clk_i _14874_/CLK clkbuf_leaf_87_clk_i/A VDD VSS sg13g2_buf_8
XFILLER_64_627 VDD VSS sg13g2_decap_8
X_14823_ _14823_/Q _14890_/CLK _14823_/D _14823_/RESET_B VDD VSS sg13g2_dfrbpq_1
XFILLER_28_70 VDD VSS sg13g2_decap_8
XFILLER_63_126 VDD VSS sg13g2_fill_1
XFILLER_45_830 VDD VSS sg13g2_fill_2
XFILLER_63_137 VDD VSS sg13g2_decap_8
XFILLER_17_532 VDD VSS sg13g2_decap_8
X_14754_ _14754_/Q clkload55/A _14754_/D _14754_/RESET_B VDD VSS sg13g2_dfrbpq_1
X_11966_ _11966_/X _13840_/Q _13872_/Q _11966_/S VDD VSS sg13g2_mux2_1
XFILLER_91_479 VDD VSS sg13g2_decap_4
X_13705_ _16867_/A _15228_/CLK _13705_/D _13705_/RESET_B VDD VSS sg13g2_dfrbpq_1
X_10917_ _10948_/C _15119_/Q _10954_/A VDD VSS sg13g2_xor2_1
X_14685_ _14685_/Q clkload47/A _14685_/D _14685_/RESET_B VDD VSS sg13g2_dfrbpq_1
Xclkbuf_leaf_10_clk_i _14703_/CLK clkbuf_5_9__f_clk_i/X VDD VSS sg13g2_buf_8
X_11897_ _11898_/B _11897_/A _11897_/B _11897_/C VDD VSS sg13g2_nand3_1
XFILLER_32_546 VDD VSS sg13g2_decap_8
X_13636_ _13744_/D _13636_/A VDD VSS sg13g2_buf_1
X_10848_ _10849_/B _10873_/A1 _10851_/C _10847_/Y VDD VSS sg13g2_o21ai_1
XFILLER_73_1151 VDD VSS sg13g2_decap_4
XFILLER_60_877 VDD VSS sg13g2_decap_8
XFILLER_44_91 VDD VSS sg13g2_decap_4
XFILLER_38_1282 VDD VSS sg13g2_decap_8
XFILLER_34_1113 VDD VSS sg13g2_decap_8
XFILLER_125_1252 VDD VSS sg13g2_decap_4
XFILLER_158_754 VDD VSS sg13g2_decap_8
X_13567_ _13567_/Y _08203_/B _13567_/A2 _13566_/Y VDD VSS sg13g2_a21oi_1
X_10779_ _10779_/Y _14921_/Q _11196_/B VDD VSS sg13g2_nand2_1
XFILLER_9_742 VDD VSS sg13g2_decap_8
XFILLER_125_1285 VDD VSS sg13g2_fill_1
Xclkbuf_leaf_25_clk_i clkload17/A clkbuf_5_9__f_clk_i/X VDD VSS sg13g2_buf_8
X_12518_ _12518_/X _14247_/Q _14279_/Q _14311_/Q _14343_/Q _12522_/S0 _12522_/S1 VDD
+ VSS sg13g2_mux4_1
XFILLER_8_252 VDD VSS sg13g2_decap_8
XFILLER_117_117 VDD VSS sg13g2_decap_8
X_13498_ _15127_/D _13498_/A VDD VSS sg13g2_inv_1
XFILLER_69_1209 VDD VSS sg13g2_fill_2
XFILLER_60_90 VDD VSS sg13g2_decap_8
XFILLER_172_234 VDD VSS sg13g2_decap_8
XFILLER_145_459 VDD VSS sg13g2_decap_8
X_15237_ _15237_/Q clkload58/A _15237_/D _15237_/RESET_B VDD VSS sg13g2_dfrbpq_1
X_12449_ _12449_/X _14114_/Q _14146_/Q _14178_/Q _14210_/Q _12450_/S0 _12450_/S1 VDD
+ VSS sg13g2_mux4_1
XFILLER_126_640 VDD VSS sg13g2_decap_8
XFILLER_161_919 VDD VSS sg13g2_decap_8
XFILLER_160_407 VDD VSS sg13g2_decap_8
XFILLER_114_813 VDD VSS sg13g2_decap_4
XFILLER_126_673 VDD VSS sg13g2_decap_8
XFILLER_172_278 VDD VSS sg13g2_decap_8
XFILLER_158_1050 VDD VSS sg13g2_fill_2
X_15168_ _16854_/A _15214_/CLK _15168_/D _15168_/RESET_B VDD VSS sg13g2_dfrbpq_1
XFILLER_99_513 VDD VSS sg13g2_decap_8
XFILLER_172_289 VDD VSS sg13g2_decap_8
XFILLER_141_610 VDD VSS sg13g2_fill_1
XFILLER_154_993 VDD VSS sg13g2_decap_8
XFILLER_158_1061 VDD VSS sg13g2_decap_8
XFILLER_5_63 VDD VSS sg13g2_decap_8
XFILLER_10_1190 VDD VSS sg13g2_decap_8
XFILLER_119_1034 VDD VSS sg13g2_fill_2
X_14119_ _14119_/Q _14735_/CLK _14119_/D _14119_/RESET_B VDD VSS sg13g2_dfrbpq_1
X_15099_ _15099_/Q clkload68/A _15099_/D _15099_/RESET_B VDD VSS sg13g2_dfrbpq_1
Xfanout209 _09924_/A1 _10123_/A0 VDD VSS sg13g2_buf_1
X_07990_ _07991_/A _08831_/B _10172_/A _11458_/A _11241_/A VDD VSS sg13g2_or4_1
XFILLER_140_153 VDD VSS sg13g2_decap_8
XFILLER_113_389 VDD VSS sg13g2_decap_8
XFILLER_119_1089 VDD VSS sg13g2_decap_8
XFILLER_140_164 VDD VSS sg13g2_fill_2
XFILLER_45_1253 VDD VSS sg13g2_decap_4
XFILLER_80_1155 VDD VSS sg13g2_fill_1
X_09660_ _14253_/D _10056_/A0 _14253_/Q _09664_/S VDD VSS sg13g2_mux2_1
XFILLER_10_0 VDD VSS sg13g2_decap_8
XFILLER_132_1267 VDD VSS sg13g2_fill_1
X_14416__1763 _14416_/RESET_B VDD VSS sg13g2_tiehi
X_08611_ _08611_/Y _07864_/Y _07960_/Y _07964_/Y VDD VSS sg13g2_o21ai_1
X_09591_ _14188_/D _14188_/Q _09624_/A0 _09599_/S VDD VSS sg13g2_mux2_1
XFILLER_167_1319 VDD VSS sg13g2_fill_2
X_08542_ _08542_/Y _07808_/Y _08654_/B _08541_/Y VDD VSS sg13g2_o21ai_1
XFILLER_36_863 VDD VSS sg13g2_fill_1
XFILLER_78_1051 VDD VSS sg13g2_fill_1
XFILLER_70_619 VDD VSS sg13g2_decap_8
XFILLER_169_1190 VDD VSS sg13g2_fill_2
XFILLER_165_1043 VDD VSS sg13g2_decap_8
X_08473_ _08473_/Y _08472_/X _08654_/B _08494_/A VDD VSS sg13g2_a21oi_1
XFILLER_90_490 VDD VSS sg13g2_fill_1
XFILLER_24_28 VDD VSS sg13g2_decap_8
XFILLER_168_518 VDD VSS sg13g2_decap_8
XFILLER_50_343 VDD VSS sg13g2_fill_1
XFILLER_52_1213 VDD VSS sg13g2_fill_1
XFILLER_17_1344 VDD VSS sg13g2_decap_8
XFILLER_52_1235 VDD VSS sg13g2_decap_8
XFILLER_148_231 VDD VSS sg13g2_decap_8
XFILLER_91_1295 VDD VSS sg13g2_decap_8
XFILLER_149_765 VDD VSS sg13g2_decap_8
XFILLER_109_618 VDD VSS sg13g2_decap_4
XFILLER_137_938 VDD VSS sg13g2_decap_4
XFILLER_149_798 VDD VSS sg13g2_decap_8
XFILLER_137_949 VDD VSS sg13g2_fill_1
X_09025_ _09025_/X _09057_/A _09021_/X _09024_/X VDD VSS sg13g2_a21o_1
XFILLER_40_49 VDD VSS sg13g2_decap_8
XFILLER_163_245 VDD VSS sg13g2_decap_8
XFILLER_156_49 VDD VSS sg13g2_decap_8
X_13904__2275 _13904_/RESET_B VDD VSS sg13g2_tiehi
XFILLER_105_802 VDD VSS sg13g2_decap_8
XFILLER_2_406 VDD VSS sg13g2_decap_8
XFILLER_144_470 VDD VSS sg13g2_decap_8
XFILLER_116_172 VDD VSS sg13g2_decap_8
XFILLER_132_621 VDD VSS sg13g2_decap_8
XFILLER_160_930 VDD VSS sg13g2_decap_8
XFILLER_132_632 VDD VSS sg13g2_fill_1
XFILLER_116_183 VDD VSS sg13g2_fill_2
XFILLER_49_14 VDD VSS sg13g2_decap_8
Xclkbuf_4_8_0_clk_i clkbuf_4_8_0_clk_i/X clkbuf_0_clk_i/X VDD VSS sg13g2_buf_8
XFILLER_85_1077 VDD VSS sg13g2_decap_8
Xfanout710 _12253_/B fanout712/X VDD VSS sg13g2_buf_1
XFILLER_63_1320 VDD VSS sg13g2_fill_1
XFILLER_133_1009 VDD VSS sg13g2_decap_8
Xfanout721 _12023_/B _12015_/B VDD VSS sg13g2_buf_1
XFILLER_160_996 VDD VSS sg13g2_decap_8
Xfanout732 _13307_/B _13483_/A2 VDD VSS sg13g2_buf_1
XFILLER_77_218 VDD VSS sg13g2_decap_8
XFILLER_132_698 VDD VSS sg13g2_decap_8
X_09927_ _14512_/D _14512_/Q _09927_/A1 _09928_/S VDD VSS sg13g2_mux2_1
Xfanout743 _08279_/B _08597_/B VDD VSS sg13g2_buf_1
Xfanout754 _08431_/C _08426_/A VDD VSS sg13g2_buf_1
XFILLER_63_1364 VDD VSS sg13g2_decap_8
Xfanout765 _08548_/A _08160_/A VDD VSS sg13g2_buf_1
XFILLER_105_42 VDD VSS sg13g2_decap_8
Xfanout776 _12678_/S fanout783/X VDD VSS sg13g2_buf_1
XFILLER_24_1337 VDD VSS sg13g2_decap_8
Xfanout787 _12776_/S _12761_/S1 VDD VSS sg13g2_buf_1
X_09858_ _14445_/D _14445_/Q _10056_/A0 _09862_/S VDD VSS sg13g2_mux2_1
XFILLER_19_819 VDD VSS sg13g2_decap_8
Xfanout798 _12454_/S1 _15212_/Q VDD VSS sg13g2_buf_1
XFILLER_74_914 VDD VSS sg13g2_decap_4
XFILLER_86_785 VDD VSS sg13g2_decap_8
X_08809_ _08811_/A _10797_/A _14751_/Q _08727_/X _15194_/Q _08825_/C1 VDD VSS sg13g2_a221oi_1
XFILLER_18_329 VDD VSS sg13g2_decap_8
X_09789_ _14378_/D _09789_/A0 _14378_/Q _09799_/S VDD VSS sg13g2_mux2_1
XFILLER_46_649 VDD VSS sg13g2_fill_1
XFILLER_45_126 VDD VSS sg13g2_fill_1
XFILLER_27_841 VDD VSS sg13g2_decap_8
X_11820_ _11820_/Y _11816_/Y _11817_/Y _11819_/Y _11818_/Y _11875_/B VDD VSS sg13g2_a221oi_1
XFILLER_22_1072 VDD VSS sg13g2_decap_8
XFILLER_2_1155 VDD VSS sg13g2_decap_8
X_15142__2673 _15142_/RESET_B VDD VSS sg13g2_tiehi
XFILLER_96_1151 VDD VSS sg13g2_fill_2
XFILLER_42_800 VDD VSS sg13g2_decap_4
XFILLER_26_351 VDD VSS sg13g2_fill_2
XFILLER_148_1241 VDD VSS sg13g2_fill_1
XFILLER_57_1124 VDD VSS sg13g2_decap_8
X_11751_ _11751_/Y _11893_/S _14506_/Q _11802_/B VDD VSS sg13g2_a21oi_1
XFILLER_54_682 VDD VSS sg13g2_decap_4
XFILLER_42_822 VDD VSS sg13g2_decap_8
XFILLER_121_63 VDD VSS sg13g2_decap_4
XFILLER_57_1157 VDD VSS sg13g2_fill_2
XFILLER_14_546 VDD VSS sg13g2_decap_8
X_10702_ _10702_/Y _10702_/A _10903_/B VDD VSS sg13g2_nand2_1
XFILLER_53_192 VDD VSS sg13g2_decap_8
X_14470_ _14470_/Q clkload11/A _14470_/D _14470_/RESET_B VDD VSS sg13g2_dfrbpq_1
X_11682_ _11682_/Y _12100_/S0 _14408_/Q _12038_/B1 VDD VSS sg13g2_a21oi_1
XFILLER_42_877 VDD VSS sg13g2_decap_8
XFILLER_42_888 VDD VSS sg13g2_fill_1
X_13421_ _13421_/Y _13448_/B _13421_/B _13459_/C VDD VSS sg13g2_nand3b_1
X_10633_ _14885_/D _10633_/A _10633_/B _10633_/C VDD VSS sg13g2_nor3_1
XFILLER_139_231 VDD VSS sg13g2_decap_8
X_13352_ _15071_/D _15071_/Q _13655_/S _13351_/Y VDD VSS sg13g2_a21o_1
XFILLER_10_763 VDD VSS sg13g2_decap_8
X_10564_ _10565_/D _14860_/Q _14859_/Q _14858_/Q _14857_/Q VDD VSS sg13g2_nand4_1
XFILLER_127_426 VDD VSS sg13g2_fill_2
XFILLER_167_595 VDD VSS sg13g2_decap_8
XFILLER_127_437 VDD VSS sg13g2_decap_8
XFILLER_127_448 VDD VSS sg13g2_fill_1
X_12303_ _12303_/X _14138_/Q _14170_/Q _12303_/S VDD VSS sg13g2_mux2_1
XFILLER_143_908 VDD VSS sg13g2_fill_2
X_13283_ _13291_/A _13283_/A _13287_/A VDD VSS sg13g2_nand2_1
XFILLER_6_756 VDD VSS sg13g2_decap_8
XFILLER_170_705 VDD VSS sg13g2_decap_8
X_10495_ _10497_/B _14852_/Q _10513_/D _14850_/Q _10495_/D VDD VSS sg13g2_nand4_1
X_15022_ _15022_/Q clkload65/A _15022_/D _15022_/RESET_B VDD VSS sg13g2_dfrbpq_1
X_12234_ _12236_/A _12235_/A _14200_/Q VDD VSS sg13g2_nand2b_1
XFILLER_5_266 VDD VSS sg13g2_decap_8
XFILLER_123_610 VDD VSS sg13g2_decap_8
XFILLER_68_1253 VDD VSS sg13g2_fill_1
XFILLER_29_1226 VDD VSS sg13g2_decap_8
XFILLER_155_1234 VDD VSS sg13g2_decap_8
X_12165_ _12165_/X _14582_/Q _14614_/Q _12168_/A VDD VSS sg13g2_mux2_1
XFILLER_9_1309 VDD VSS sg13g2_decap_8
XFILLER_151_974 VDD VSS sg13g2_decap_8
XFILLER_111_816 VDD VSS sg13g2_decap_4
XFILLER_122_142 VDD VSS sg13g2_decap_8
XFILLER_2_973 VDD VSS sg13g2_decap_8
X_11116_ _11190_/C _11138_/B _11138_/C VDD VSS sg13g2_nand2_1
XFILLER_111_838 VDD VSS sg13g2_decap_8
X_14673__1506 _14673_/RESET_B VDD VSS sg13g2_tiehi
X_12096_ _12096_/Y _12100_/S0 _14612_/Q _12091_/C VDD VSS sg13g2_a21oi_1
XFILLER_89_590 VDD VSS sg13g2_decap_8
XFILLER_7_1022 VDD VSS sg13g2_decap_8
XFILLER_1_483 VDD VSS sg13g2_decap_8
XFILLER_110_337 VDD VSS sg13g2_decap_8
X_11047_ _14944_/D _07616_/Y _10671_/Y _11046_/Y VDD VSS sg13g2_o21ai_1
XFILLER_49_443 VDD VSS sg13g2_decap_8
XFILLER_162_70 VDD VSS sg13g2_decap_8
Xinput9 input9/X input9/A VDD VSS sg13g2_buf_1
XFILLER_92_711 VDD VSS sg13g2_fill_2
XFILLER_65_936 VDD VSS sg13g2_fill_2
XFILLER_7_1099 VDD VSS sg13g2_decap_8
XFILLER_37_649 VDD VSS sg13g2_decap_8
XFILLER_92_755 VDD VSS sg13g2_fill_2
X_14806_ _14806_/Q _14868_/CLK _14806_/D _14806_/RESET_B VDD VSS sg13g2_dfrbpq_1
XFILLER_80_917 VDD VSS sg13g2_decap_4
X_12998_ _12998_/Y input24/X _12997_/Y _12937_/Y VDD VSS sg13g2_o21ai_1
XFILLER_55_90 VDD VSS sg13g2_fill_1
XFILLER_18_896 VDD VSS sg13g2_decap_8
XFILLER_127_1303 VDD VSS sg13g2_fill_1
X_14737_ _14737_/Q _14737_/CLK _14737_/D _14737_/RESET_B VDD VSS sg13g2_dfrbpq_1
XFILLER_45_693 VDD VSS sg13g2_fill_1
XFILLER_127_1314 VDD VSS sg13g2_decap_8
X_11949_ _11953_/A _11948_/X _12023_/B VDD VSS sg13g2_nand2b_1
X_14668_ _14668_/Q clkload12/A _14668_/D _14668_/RESET_B VDD VSS sg13g2_dfrbpq_1
XFILLER_60_674 VDD VSS sg13g2_fill_2
XFILLER_32_387 VDD VSS sg13g2_decap_8
X_13619_ _13727_/D _13619_/A VDD VSS sg13g2_buf_1
X_14599_ _14599_/Q _14727_/CLK _14599_/D _14599_/RESET_B VDD VSS sg13g2_dfrbpq_1
XFILLER_118_426 VDD VSS sg13g2_decap_8
XFILLER_12_1274 VDD VSS sg13g2_decap_8
XFILLER_145_278 VDD VSS sg13g2_fill_1
XFILLER_58_0 VDD VSS sg13g2_decap_8
XFILLER_99_310 VDD VSS sg13g2_fill_1
XFILLER_47_1315 VDD VSS sg13g2_decap_8
XFILLER_114_643 VDD VSS sg13g2_decap_4
XFILLER_86_1375 VDD VSS sg13g2_decap_8
XFILLER_173_1323 VDD VSS sg13g2_decap_8
XFILLER_160_259 VDD VSS sg13g2_decap_8
XFILLER_173_1334 VDD VSS sg13g2_fill_2
X_13698__2481 _13698_/RESET_B VDD VSS sg13g2_tiehi
XFILLER_102_816 VDD VSS sg13g2_fill_1
XFILLER_113_153 VDD VSS sg13g2_decap_8
XFILLER_87_516 VDD VSS sg13g2_decap_8
XFILLER_102_827 VDD VSS sg13g2_decap_8
XFILLER_113_164 VDD VSS sg13g2_fill_1
XFILLER_141_473 VDD VSS sg13g2_decap_8
XFILLER_101_315 VDD VSS sg13g2_decap_8
XFILLER_113_175 VDD VSS sg13g2_decap_8
X_07973_ _07974_/C _08663_/A _08678_/A _07971_/Y VDD VSS sg13g2_o21ai_1
X_14649__1530 _14649_/RESET_B VDD VSS sg13g2_tiehi
X_09712_ _14303_/D _09877_/A0 _14303_/Q _09730_/S VDD VSS sg13g2_mux2_1
XFILLER_19_28 VDD VSS sg13g2_decap_8
XFILLER_110_860 VDD VSS sg13g2_decap_8
XFILLER_95_571 VDD VSS sg13g2_decap_8
X_09643_ _14236_/D _10139_/A1 _14236_/Q _09667_/S VDD VSS sg13g2_mux2_1
XFILLER_83_722 VDD VSS sg13g2_decap_4
XFILLER_132_1086 VDD VSS sg13g2_fill_2
XFILLER_55_435 VDD VSS sg13g2_decap_8
XFILLER_28_649 VDD VSS sg13g2_fill_2
XFILLER_27_126 VDD VSS sg13g2_decap_8
XFILLER_23_1370 VDD VSS sg13g2_decap_8
X_09574_ _14171_/D _14171_/Q _09574_/A1 _09599_/S VDD VSS sg13g2_mux2_1
XFILLER_83_788 VDD VSS sg13g2_decap_8
XFILLER_82_254 VDD VSS sg13g2_decap_8
X_08525_ _08526_/A _08209_/X _08544_/B _08521_/X _08637_/B _08524_/Y VDD VSS sg13g2_a221oi_1
XFILLER_35_49 VDD VSS sg13g2_decap_8
XFILLER_35_170 VDD VSS sg13g2_decap_8
XFILLER_169_827 VDD VSS sg13g2_decap_8
X_15017__2570 _15017_/RESET_B VDD VSS sg13g2_tiehi
XFILLER_54_1319 VDD VSS sg13g2_decap_8
XFILLER_23_343 VDD VSS sg13g2_decap_8
XFILLER_168_315 VDD VSS sg13g2_decap_8
X_08456_ _08461_/C _08692_/A _11843_/A _15007_/Q VDD VSS sg13g2_nand3_1
X_15084__2825 _15084_/RESET_B VDD VSS sg13g2_tiehi
XFILLER_50_162 VDD VSS sg13g2_decap_8
XFILLER_17_1141 VDD VSS sg13g2_decap_8
XFILLER_149_540 VDD VSS sg13g2_decap_8
X_08387_ _08387_/Y _08541_/A _08382_/X _08380_/Y _08637_/B _08386_/Y VDD VSS sg13g2_a221oi_1
XFILLER_136_7 VDD VSS sg13g2_decap_8
X_14826__2887 _14826_/RESET_B VDD VSS sg13g2_tiehi
XFILLER_91_1092 VDD VSS sg13g2_decap_8
XFILLER_52_1087 VDD VSS sg13g2_decap_8
XFILLER_137_746 VDD VSS sg13g2_fill_1
XFILLER_164_532 VDD VSS sg13g2_decap_8
XFILLER_87_1106 VDD VSS sg13g2_fill_1
XFILLER_87_1117 VDD VSS sg13g2_decap_8
XFILLER_30_1352 VDD VSS sg13g2_decap_8
XFILLER_152_716 VDD VSS sg13g2_decap_8
XFILLER_152_727 VDD VSS sg13g2_fill_2
X_09008_ _13762_/D _13762_/Q _10078_/A0 _09160_/S VDD VSS sg13g2_mux2_1
XFILLER_174_1109 VDD VSS sg13g2_decap_8
X_10280_ _10282_/A _14788_/Q _10311_/A _10423_/C VDD VSS sg13g2_o21ai_1
XFILLER_2_203 VDD VSS sg13g2_decap_8
XFILLER_117_481 VDD VSS sg13g2_fill_1
XFILLER_145_790 VDD VSS sg13g2_decap_8
XFILLER_105_665 VDD VSS sg13g2_decap_8
XFILLER_160_771 VDD VSS sg13g2_decap_8
X_14288__1891 _14288_/RESET_B VDD VSS sg13g2_tiehi
XFILLER_104_164 VDD VSS sg13g2_decap_4
XFILLER_104_197 VDD VSS sg13g2_decap_8
Xfanout540 _09051_/A1 _08967_/Y VDD VSS sg13g2_buf_1
XFILLER_63_1150 VDD VSS sg13g2_decap_4
XFILLER_116_85 VDD VSS sg13g2_decap_8
Xfanout551 _08676_/B2 _08398_/Y VDD VSS sg13g2_buf_1
XFILLER_63_1161 VDD VSS sg13g2_decap_8
Xfanout562 _13208_/B1 _13236_/B1 VDD VSS sg13g2_buf_1
XFILLER_93_508 VDD VSS sg13g2_decap_8
X_13970_ _13970_/Q _14632_/CLK _13970_/D _13970_/RESET_B VDD VSS sg13g2_dfrbpq_1
Xfanout573 _12914_/A _13561_/S VDD VSS sg13g2_buf_1
XFILLER_24_1134 VDD VSS sg13g2_decap_8
XFILLER_115_1262 VDD VSS sg13g2_decap_8
Xfanout584 _11048_/B _11021_/B VDD VSS sg13g2_buf_1
XFILLER_58_251 VDD VSS sg13g2_decap_8
Xfanout595 _09137_/A _08972_/S VDD VSS sg13g2_buf_1
XFILLER_98_1213 VDD VSS sg13g2_decap_8
XFILLER_47_925 VDD VSS sg13g2_decap_8
XFILLER_19_616 VDD VSS sg13g2_decap_8
XFILLER_111_1126 VDD VSS sg13g2_decap_8
X_12921_ _15028_/D _13239_/A _12921_/B VDD VSS sg13g2_nor2_1
XFILLER_4_1239 VDD VSS sg13g2_decap_8
XFILLER_18_126 VDD VSS sg13g2_decap_8
XFILLER_100_392 VDD VSS sg13g2_decap_4
X_12852_ _12852_/Y _14834_/Q _07728_/B _12895_/B _14866_/Q _12917_/B1 VDD VSS sg13g2_a221oi_1
XFILLER_162_0 VDD VSS sg13g2_decap_8
X_11803_ _11805_/A _11804_/A _14188_/Q VDD VSS sg13g2_nand2b_1
XFILLER_15_833 VDD VSS sg13g2_decap_8
X_12783_ _12783_/X _14266_/Q _14298_/Q _14330_/Q _14362_/Q _12783_/S0 _12783_/S1 VDD
+ VSS sg13g2_mux4_1
XFILLER_42_630 VDD VSS sg13g2_decap_8
XFILLER_148_1060 VDD VSS sg13g2_decap_8
XFILLER_148_1071 VDD VSS sg13g2_fill_2
XFILLER_70_950 VDD VSS sg13g2_fill_2
XFILLER_14_343 VDD VSS sg13g2_decap_8
X_14522_ _14522_/Q clkload49/A _14522_/D _14522_/RESET_B VDD VSS sg13g2_dfrbpq_1
X_11734_ _11734_/Y _11730_/Y _11731_/Y _11733_/Y _11732_/Y _11815_/B VDD VSS sg13g2_a221oi_1
XFILLER_159_315 VDD VSS sg13g2_decap_8
XFILLER_41_140 VDD VSS sg13g2_fill_2
XFILLER_42_685 VDD VSS sg13g2_fill_2
XFILLER_35_1230 VDD VSS sg13g2_fill_1
X_14390__1789 _14390_/RESET_B VDD VSS sg13g2_tiehi
X_14453_ _14453_/Q _14677_/CLK _14453_/D _14453_/RESET_B VDD VSS sg13g2_dfrbpq_1
X_11665_ _11665_/Y _11692_/A _13832_/Q VDD VSS sg13g2_nand2b_1
XFILLER_122_1211 VDD VSS sg13g2_decap_8
XFILLER_161_1260 VDD VSS sg13g2_decap_8
X_13404_ _15089_/D _13435_/A _13396_/D _13403_/Y VDD VSS sg13g2_o21ai_1
X_10616_ _14880_/D _07620_/Y _10611_/A _10615_/Y VDD VSS sg13g2_a21oi_1
XFILLER_168_893 VDD VSS sg13g2_decap_8
X_14384_ _14384_/Q _14512_/CLK _14384_/D _14384_/RESET_B VDD VSS sg13g2_dfrbpq_1
XFILLER_70_1165 VDD VSS sg13g2_decap_8
XFILLER_128_735 VDD VSS sg13g2_decap_8
X_11596_ _11598_/A _11597_/A _14182_/Q VDD VSS sg13g2_nand2b_1
XFILLER_31_1127 VDD VSS sg13g2_decap_8
XFILLER_10_560 VDD VSS sg13g2_decap_8
XFILLER_127_223 VDD VSS sg13g2_fill_2
XFILLER_155_532 VDD VSS sg13g2_decap_4
XFILLER_167_392 VDD VSS sg13g2_decap_8
X_14727__1452 _14727_/RESET_B VDD VSS sg13g2_tiehi
X_13335_ _15170_/D hold3035/X _15170_/Q _13336_/S VDD VSS sg13g2_mux2_1
XFILLER_41_70 VDD VSS sg13g2_decap_4
X_10547_ _10556_/D _14864_/Q _14863_/Q _10566_/D _10547_/D VDD VSS sg13g2_and4_1
XFILLER_122_1288 VDD VSS sg13g2_decap_8
XFILLER_127_267 VDD VSS sg13g2_decap_4
XFILLER_6_553 VDD VSS sg13g2_decap_8
XFILLER_157_70 VDD VSS sg13g2_decap_8
X_13266_ _15051_/D _13266_/A _13266_/B VDD VSS sg13g2_nor2_1
X_14010__2169 _14010_/RESET_B VDD VSS sg13g2_tiehi
XFILLER_51_7 VDD VSS sg13g2_decap_8
XFILLER_142_226 VDD VSS sg13g2_decap_8
X_10478_ _14847_/D _10633_/A _10478_/B _10489_/D VDD VSS sg13g2_nor3_1
XFILLER_170_546 VDD VSS sg13g2_decap_8
X_15005_ _15005_/Q _15015_/CLK _15005_/D _15005_/RESET_B VDD VSS sg13g2_dfrbpq_1
X_12217_ _12217_/Y _12217_/A _12217_/B VDD VSS sg13g2_nor2_1
X_13197_ _13197_/Y _13196_/Y _13297_/A0 _13192_/X _13253_/B2 VDD VSS sg13g2_a22oi_1
XFILLER_9_1106 VDD VSS sg13g2_decap_8
XFILLER_123_473 VDD VSS sg13g2_decap_8
XFILLER_69_527 VDD VSS sg13g2_decap_8
X_12148_ _12149_/B _12296_/A1 _12132_/Y _12147_/Y VDD VSS sg13g2_o21ai_1
XFILLER_97_847 VDD VSS sg13g2_decap_8
XFILLER_2_770 VDD VSS sg13g2_decap_8
XFILLER_155_1075 VDD VSS sg13g2_decap_4
XFILLER_1_280 VDD VSS sg13g2_decap_8
XFILLER_173_91 VDD VSS sg13g2_decap_8
X_12079_ _12079_/Y _14918_/Q _12267_/A2 _12156_/A VDD VSS sg13g2_a21oi_1
XFILLER_42_1234 VDD VSS sg13g2_fill_2
XFILLER_2_42 VDD VSS sg13g2_decap_8
XFILLER_38_936 VDD VSS sg13g2_decap_8
XFILLER_49_284 VDD VSS sg13g2_decap_8
XFILLER_38_947 VDD VSS sg13g2_fill_1
XFILLER_64_232 VDD VSS sg13g2_fill_2
XFILLER_65_777 VDD VSS sg13g2_decap_8
XFILLER_65_788 VDD VSS sg13g2_fill_1
XFILLER_53_939 VDD VSS sg13g2_decap_8
XFILLER_80_747 VDD VSS sg13g2_decap_4
XFILLER_79_1190 VDD VSS sg13g2_decap_8
XFILLER_18_693 VDD VSS sg13g2_decap_8
XFILLER_80_769 VDD VSS sg13g2_decap_8
XFILLER_45_490 VDD VSS sg13g2_fill_2
X_08310_ _08616_/B _13529_/A _08126_/B _08688_/B VDD VSS sg13g2_o21ai_1
XFILLER_162_1013 VDD VSS sg13g2_decap_8
X_09290_ _13898_/D _13898_/Q _10153_/A1 _09292_/S VDD VSS sg13g2_mux2_1
XFILLER_33_663 VDD VSS sg13g2_decap_8
XFILLER_162_1024 VDD VSS sg13g2_fill_2
XFILLER_60_460 VDD VSS sg13g2_fill_2
XFILLER_32_162 VDD VSS sg13g2_decap_8
X_08241_ _08241_/Y _08241_/A _08397_/B VDD VSS sg13g2_nand2_1
XFILLER_75_1098 VDD VSS sg13g2_decap_8
XANTENNA_14 _16881_/A VDD VSS sg13g2_antennanp
XFILLER_21_847 VDD VSS sg13g2_decap_8
XANTENNA_25 _13005_/C VDD VSS sg13g2_antennanp
X_14220__1959 _14220_/RESET_B VDD VSS sg13g2_tiehi
XFILLER_53_1341 VDD VSS sg13g2_decap_8
XFILLER_159_860 VDD VSS sg13g2_fill_2
XFILLER_20_357 VDD VSS sg13g2_decap_8
XFILLER_140_1322 VDD VSS sg13g2_decap_8
XFILLER_146_510 VDD VSS sg13g2_decap_8
XFILLER_165_329 VDD VSS sg13g2_decap_8
X_08172_ _08340_/B _08431_/A _08171_/X _08254_/S VDD VSS sg13g2_mux2_1
XFILLER_118_212 VDD VSS sg13g2_fill_2
XFILLER_158_381 VDD VSS sg13g2_fill_1
XFILLER_14_1358 VDD VSS sg13g2_decap_8
XFILLER_107_908 VDD VSS sg13g2_fill_1
XFILLER_146_565 VDD VSS sg13g2_fill_1
XFILLER_12_1071 VDD VSS sg13g2_decap_8
Xoutput110 mem_axi_wdata[15] _15147_/Q VDD VSS sg13g2_buf_1
Xoutput121 mem_axi_wdata[25] _15157_/Q VDD VSS sg13g2_buf_1
Xoutput132 mem_axi_wdata[6] _15138_/Q VDD VSS sg13g2_buf_1
XFILLER_47_1112 VDD VSS sg13g2_decap_8
XFILLER_161_568 VDD VSS sg13g2_decap_4
XFILLER_99_140 VDD VSS sg13g2_decap_8
XFILLER_115_985 VDD VSS sg13g2_decap_8
XFILLER_130_922 VDD VSS sg13g2_fill_2
XFILLER_87_302 VDD VSS sg13g2_decap_8
XFILLER_134_1115 VDD VSS sg13g2_decap_8
XFILLER_99_173 VDD VSS sg13g2_decap_8
XFILLER_87_313 VDD VSS sg13g2_fill_1
XFILLER_153_28 VDD VSS sg13g2_decap_8
XFILLER_102_635 VDD VSS sg13g2_fill_2
XFILLER_101_123 VDD VSS sg13g2_decap_8
XFILLER_101_134 VDD VSS sg13g2_fill_2
X_14165__2014 _14165_/RESET_B VDD VSS sg13g2_tiehi
X_07956_ _07956_/Y _07956_/A _07812_/B VDD VSS sg13g2_nor2b_1
XFILLER_102_679 VDD VSS sg13g2_decap_8
XFILLER_101_167 VDD VSS sg13g2_fill_2
XFILLER_56_711 VDD VSS sg13g2_decap_8
X_07887_ _07889_/A _08203_/A _14995_/Q VDD VSS sg13g2_nand2_1
XFILLER_28_435 VDD VSS sg13g2_decap_8
X_09626_ _14222_/D _10090_/A0 _14222_/Q _09632_/S VDD VSS sg13g2_mux2_1
XFILLER_102_21 VDD VSS sg13g2_decap_4
XFILLER_71_725 VDD VSS sg13g2_decap_8
XFILLER_37_991 VDD VSS sg13g2_decap_8
X_09557_ _14155_/D _09623_/A0 _14155_/Q _09563_/S VDD VSS sg13g2_mux2_1
XFILLER_43_449 VDD VSS sg13g2_decap_8
XFILLER_102_54 VDD VSS sg13g2_fill_1
XFILLER_93_1132 VDD VSS sg13g2_fill_2
XFILLER_169_602 VDD VSS sg13g2_decap_8
XFILLER_62_14 VDD VSS sg13g2_decap_8
X_08508_ _08517_/A _07818_/Y _08506_/Y _08507_/Y VDD VSS sg13g2_o21ai_1
XFILLER_19_1225 VDD VSS sg13g2_decap_8
X_09488_ _14088_/D _10084_/A0 _14088_/Q _09497_/S VDD VSS sg13g2_mux2_1
XFILLER_23_140 VDD VSS sg13g2_decap_8
XFILLER_168_112 VDD VSS sg13g2_decap_8
XFILLER_12_847 VDD VSS sg13g2_decap_8
X_08439_ _08439_/Y _08574_/A _08438_/Y _08667_/A1 VDD VSS sg13g2_a21oi_1
XFILLER_141_1108 VDD VSS sg13g2_fill_2
XFILLER_134_4 VDD VSS sg13g2_decap_8
XFILLER_11_357 VDD VSS sg13g2_decap_8
XFILLER_168_189 VDD VSS sg13g2_decap_8
X_11450_ _11450_/Y _11450_/A1 _11449_/X wire523/X VDD VSS sg13g2_o21ai_1
XFILLER_149_370 VDD VSS sg13g2_fill_2
X_14972__2615 _14972_/RESET_B VDD VSS sg13g2_tiehi
XFILLER_109_234 VDD VSS sg13g2_decap_8
X_10401_ _14822_/D _10413_/B _10643_/A _10401_/C VDD VSS sg13g2_nor3_1
X_11381_ _11381_/Y _10681_/A _12338_/A2 _11722_/B2 VDD VSS sg13g2_a21oi_1
XFILLER_109_267 VDD VSS sg13g2_decap_8
XFILLER_124_204 VDD VSS sg13g2_fill_2
X_13120_ _13120_/X _13120_/A _13170_/A VDD VSS sg13g2_xor2_1
X_10332_ _10334_/A _14803_/Q _10336_/D _14804_/Q VDD VSS sg13g2_a21o_1
X_14375__1804 _14375_/RESET_B VDD VSS sg13g2_tiehi
XFILLER_65_1201 VDD VSS sg13g2_decap_4
XFILLER_11_84 VDD VSS sg13g2_decap_8
X_13051_ _13051_/X _14814_/Q _13051_/B VDD VSS sg13g2_and2_1
XFILLER_152_568 VDD VSS sg13g2_decap_8
X_10263_ _14782_/D _14782_/Q _10268_/D _10261_/Y VDD VSS sg13g2_a21oi_1
XFILLER_3_567 VDD VSS sg13g2_decap_8
XFILLER_117_1302 VDD VSS sg13g2_decap_8
XFILLER_156_1351 VDD VSS sg13g2_fill_1
X_15040__2545 _15040_/RESET_B VDD VSS sg13g2_tiehi
Xpicorv32_macro_1420 mem_axi_awprot[0] VDD VSS sg13g2_tielo
X_12002_ _12002_/Y _11975_/A _11998_/X _12001_/Y VDD VSS sg13g2_o21ai_1
XFILLER_121_922 VDD VSS sg13g2_decap_8
Xfanout1302 _11759_/A _11741_/A VDD VSS sg13g2_buf_1
X_10194_ _14754_/D _15197_/D _14754_/Q _10194_/S VDD VSS sg13g2_mux2_1
Xfanout1313 _12235_/A _12025_/A VDD VSS sg13g2_buf_1
Xfanout1324 _11896_/A fanout1346/X VDD VSS sg13g2_buf_1
Xfanout1335 _12100_/S0 _12316_/S0 VDD VSS sg13g2_buf_1
Xfanout1346 fanout1346/X _13657_/Q VDD VSS sg13g2_buf_1
Xfanout1357 _12186_/A fanout1358/X VDD VSS sg13g2_buf_1
XFILLER_121_999 VDD VSS sg13g2_decap_8
Xfanout370 _09271_/S _09260_/S VDD VSS sg13g2_buf_1
XFILLER_47_700 VDD VSS sg13g2_fill_2
Xfanout1368 _12212_/S0 fanout1369/X VDD VSS sg13g2_buf_1
Xfanout381 _09615_/A0 _09316_/A0 VDD VSS sg13g2_buf_1
Xfanout1379 _10572_/B _13328_/A VDD VSS sg13g2_buf_1
XFILLER_8_1183 VDD VSS sg13g2_decap_8
XFILLER_19_413 VDD VSS sg13g2_decap_8
Xfanout392 _10076_/A0 _08996_/Y VDD VSS sg13g2_buf_1
X_13953_ _13953_/Q _14649_/CLK _13953_/D _13953_/RESET_B VDD VSS sg13g2_dfrbpq_1
XFILLER_4_1036 VDD VSS sg13g2_decap_8
XFILLER_47_755 VDD VSS sg13g2_fill_1
X_12904_ _15027_/D _13239_/A _12904_/B VDD VSS sg13g2_nor2_1
XFILLER_74_552 VDD VSS sg13g2_decap_4
X_13884_ _13884_/Q clkload49/A _13884_/D _13884_/RESET_B VDD VSS sg13g2_dfrbpq_1
XFILLER_74_574 VDD VSS sg13g2_decap_8
XFILLER_36_70 VDD VSS sg13g2_decap_8
X_12835_ _12836_/C _12835_/A _13691_/Q VDD VSS sg13g2_xor2_1
XFILLER_15_630 VDD VSS sg13g2_decap_8
XFILLER_43_950 VDD VSS sg13g2_fill_2
X_13863__2316 _13863_/RESET_B VDD VSS sg13g2_tiehi
XFILLER_14_140 VDD VSS sg13g2_decap_8
XFILLER_159_112 VDD VSS sg13g2_decap_8
X_12766_ _12766_/X _14585_/Q _14617_/Q _14649_/Q _14681_/Q _12771_/S0 _12771_/S1 VDD
+ VSS sg13g2_mux4_1
XFILLER_61_279 VDD VSS sg13g2_decap_4
XFILLER_37_1336 VDD VSS sg13g2_decap_8
XFILLER_99_7 VDD VSS sg13g2_decap_8
X_14505_ _14505_/Q _14505_/CLK _14505_/D _14505_/RESET_B VDD VSS sg13g2_dfrbpq_1
X_11717_ _11719_/B _12291_/A _11717_/B VDD VSS sg13g2_nor2_1
XFILLER_42_493 VDD VSS sg13g2_fill_1
X_12697_ _12697_/X _13972_/Q _14004_/Q _14036_/Q _14068_/Q _12703_/S0 _12703_/S1 VDD
+ VSS sg13g2_mux4_1
XFILLER_159_189 VDD VSS sg13g2_decap_8
X_14436_ _14436_/Q _14660_/CLK _14436_/D _14436_/RESET_B VDD VSS sg13g2_dfrbpq_1
X_11648_ _11648_/X _14247_/Q _14279_/Q _14311_/Q _14343_/Q _11651_/S0 _11651_/S1 VDD
+ VSS sg13g2_mux4_1
XFILLER_174_126 VDD VSS sg13g2_decap_8
Xinput12 input12/X input12/A VDD VSS sg13g2_buf_1
XFILLER_30_699 VDD VSS sg13g2_fill_1
XFILLER_174_137 VDD VSS sg13g2_decap_8
Xinput23 input23/X input23/A VDD VSS sg13g2_buf_1
XFILLER_122_1052 VDD VSS sg13g2_fill_2
XFILLER_168_91 VDD VSS sg13g2_decap_8
Xinput34 input34/X input34/A VDD VSS sg13g2_buf_1
XFILLER_7_840 VDD VSS sg13g2_decap_8
X_14367_ _14367_/Q clkload14/A _14367_/D _14367_/RESET_B VDD VSS sg13g2_dfrbpq_1
X_11579_ _11579_/X _14373_/Q _14405_/Q _14469_/Q _14501_/Q _11997_/S0 _11997_/S1 VDD
+ VSS sg13g2_mux4_1
XFILLER_116_727 VDD VSS sg13g2_decap_8
XFILLER_6_350 VDD VSS sg13g2_decap_8
XFILLER_128_587 VDD VSS sg13g2_decap_8
XFILLER_116_738 VDD VSS sg13g2_fill_1
XFILLER_128_598 VDD VSS sg13g2_fill_1
XFILLER_157_1115 VDD VSS sg13g2_fill_1
X_13318_ _13319_/B _15110_/Q _13306_/B _13309_/Y _15063_/Q VDD VSS sg13g2_a22oi_1
X_14298_ _14298_/Q _14682_/CLK _14298_/D _14298_/RESET_B VDD VSS sg13g2_dfrbpq_1
XFILLER_170_343 VDD VSS sg13g2_decap_8
XFILLER_112_900 VDD VSS sg13g2_decap_8
X_13249_ _13251_/B _14892_/Q _13249_/B VDD VSS sg13g2_nand2_1
XFILLER_124_760 VDD VSS sg13g2_decap_8
XFILLER_97_600 VDD VSS sg13g2_decap_8
XFILLER_83_1356 VDD VSS sg13g2_decap_4
XFILLER_112_966 VDD VSS sg13g2_decap_8
X_07810_ _08567_/A _15012_/Q _08541_/B VDD VSS sg13g2_xnor2_1
XFILLER_170_1348 VDD VSS sg13g2_decap_8
XFILLER_85_817 VDD VSS sg13g2_fill_1
X_08790_ _08790_/Y _13481_/A _13482_/A _13448_/B VDD VSS sg13g2_o21ai_1
XFILLER_84_327 VDD VSS sg13g2_decap_8
XFILLER_42_1042 VDD VSS sg13g2_decap_8
X_07741_ _07741_/Y _15124_/Q _13481_/A VDD VSS sg13g2_nand2b_1
XFILLER_38_722 VDD VSS sg13g2_decap_4
XFILLER_37_221 VDD VSS sg13g2_fill_2
XFILLER_26_906 VDD VSS sg13g2_decap_8
X_07672_ _07672_/X _07665_/X _07670_/Y _07667_/Y VDD VSS sg13g2_a21o_1
XFILLER_168_1233 VDD VSS sg13g2_decap_4
X_09411_ _14013_/D _09609_/A0 _14013_/Q _09434_/S VDD VSS sg13g2_mux2_1
XFILLER_20_1351 VDD VSS sg13g2_decap_8
XFILLER_19_980 VDD VSS sg13g2_decap_8
XFILLER_80_522 VDD VSS sg13g2_fill_2
XFILLER_77_1149 VDD VSS sg13g2_decap_8
XFILLER_53_769 VDD VSS sg13g2_decap_8
XFILLER_18_490 VDD VSS sg13g2_decap_8
X_09342_ _09342_/Y _10105_/B _09441_/D VDD VSS sg13g2_nand2_1
X_14453__1726 _14453_/RESET_B VDD VSS sg13g2_tiehi
X_13839__2340 _13839_/RESET_B VDD VSS sg13g2_tiehi
XFILLER_33_460 VDD VSS sg13g2_decap_8
X_14599__1580 _14599_/RESET_B VDD VSS sg13g2_tiehi
X_09273_ _13882_/D _13882_/Q _10169_/A1 _09273_/S VDD VSS sg13g2_mux2_1
XFILLER_33_493 VDD VSS sg13g2_decap_8
XFILLER_21_644 VDD VSS sg13g2_decap_8
XFILLER_166_616 VDD VSS sg13g2_fill_1
XFILLER_32_28 VDD VSS sg13g2_decap_8
X_08224_ _08224_/X _08119_/X _08128_/X _08129_/X _08132_/X _08223_/S _08363_/S0 VDD
+ VSS sg13g2_mux4_1
XFILLER_20_154 VDD VSS sg13g2_decap_8
XFILLER_148_28 VDD VSS sg13g2_decap_8
XFILLER_165_126 VDD VSS sg13g2_decap_8
XFILLER_105_1250 VDD VSS sg13g2_fill_2
XFILLER_119_521 VDD VSS sg13g2_decap_8
XFILLER_159_690 VDD VSS sg13g2_decap_8
XFILLER_147_863 VDD VSS sg13g2_fill_2
XFILLER_14_1155 VDD VSS sg13g2_decap_8
X_08155_ _08155_/Y _08188_/A _08432_/A2 _08001_/C VDD VSS sg13g2_o21ai_1
XFILLER_105_1283 VDD VSS sg13g2_fill_2
XFILLER_10_1008 VDD VSS sg13g2_decap_8
XFILLER_174_682 VDD VSS sg13g2_fill_1
XFILLER_107_749 VDD VSS sg13g2_decap_8
XFILLER_161_310 VDD VSS sg13g2_decap_8
X_08086_ _08270_/A _08279_/B _08086_/B VDD VSS sg13g2_nand2_1
XFILLER_88_1267 VDD VSS sg13g2_fill_2
XFILLER_134_546 VDD VSS sg13g2_decap_8
XFILLER_122_708 VDD VSS sg13g2_fill_2
XFILLER_115_760 VDD VSS sg13g2_fill_1
XFILLER_0_504 VDD VSS sg13g2_decap_8
XFILLER_164_49 VDD VSS sg13g2_decap_8
XFILLER_121_218 VDD VSS sg13g2_fill_2
XFILLER_161_387 VDD VSS sg13g2_decap_8
XFILLER_76_806 VDD VSS sg13g2_fill_2
XFILLER_57_14 VDD VSS sg13g2_decap_8
X_13941__2238 _13941_/RESET_B VDD VSS sg13g2_tiehi
XFILLER_88_677 VDD VSS sg13g2_decap_8
X_08988_ _08988_/Y _09057_/A _08988_/B _08988_/C VDD VSS sg13g2_nor3_1
XFILLER_60_1131 VDD VSS sg13g2_decap_8
XFILLER_5_1323 VDD VSS sg13g2_decap_8
XFILLER_112_1210 VDD VSS sg13g2_decap_8
XFILLER_69_891 VDD VSS sg13g2_decap_8
X_07939_ _07939_/Y _08315_/B _07776_/Y _07773_/Y VDD VSS sg13g2_a21oi_1
XFILLER_28_221 VDD VSS sg13g2_decap_8
XFILLER_25_1295 VDD VSS sg13g2_decap_8
XFILLER_84_861 VDD VSS sg13g2_decap_8
X_10950_ _10950_/Y _10949_/Y _11004_/A _11043_/A VDD VSS sg13g2_a21oi_1
XFILLER_21_1148 VDD VSS sg13g2_decap_8
XFILLER_17_917 VDD VSS sg13g2_decap_8
XFILLER_83_360 VDD VSS sg13g2_decap_8
XFILLER_56_574 VDD VSS sg13g2_decap_8
XFILLER_112_1287 VDD VSS sg13g2_decap_4
XFILLER_16_427 VDD VSS sg13g2_decap_8
X_09609_ _14205_/D _09609_/A0 _14205_/Q _09632_/S VDD VSS sg13g2_mux2_1
XFILLER_73_35 VDD VSS sg13g2_decap_8
XFILLER_44_747 VDD VSS sg13g2_decap_8
X_10881_ _10890_/C _14754_/Q _10897_/A VDD VSS sg13g2_xor2_1
XFILLER_44_758 VDD VSS sg13g2_fill_2
XFILLER_43_257 VDD VSS sg13g2_decap_8
X_12620_ _12620_/X _14702_/Q _14734_/Q _13774_/Q _13806_/Q _12703_/S0 _12703_/S1 VDD
+ VSS sg13g2_mux4_1
X_14860__2824 _14860_/RESET_B VDD VSS sg13g2_tiehi
XFILLER_19_1022 VDD VSS sg13g2_decap_8
XFILLER_58_1093 VDD VSS sg13g2_decap_8
X_14429__1750 _14429_/RESET_B VDD VSS sg13g2_tiehi
X_12551_ _12551_/X _12548_/X _12547_/X _12544_/X _12543_/X _12775_/S1 _12720_/S VDD
+ VSS sg13g2_mux4_1
XFILLER_12_644 VDD VSS sg13g2_decap_8
XFILLER_169_476 VDD VSS sg13g2_decap_8
XFILLER_106_1036 VDD VSS sg13g2_decap_8
X_11502_ _11636_/A _11502_/A _13685_/Q VDD VSS sg13g2_xor2_1
XFILLER_19_1099 VDD VSS sg13g2_decap_8
XFILLER_11_154 VDD VSS sg13g2_decap_8
X_12482_ _12482_/X _12480_/X _12479_/X _12476_/X _12475_/X _12719_/S0 _12692_/S VDD
+ VSS sg13g2_mux4_1
XFILLER_71_1260 VDD VSS sg13g2_decap_8
XFILLER_156_126 VDD VSS sg13g2_decap_8
XFILLER_8_637 VDD VSS sg13g2_decap_8
XFILLER_125_0 VDD VSS sg13g2_decap_8
X_14221_ _14221_/Q clkload3/A _14221_/D _14221_/RESET_B VDD VSS sg13g2_dfrbpq_1
X_14893__2758 _14893_/RESET_B VDD VSS sg13g2_tiehi
X_11433_ _11433_/Y _14899_/Q _11433_/B VDD VSS sg13g2_nand2_1
XFILLER_123_1372 VDD VSS sg13g2_decap_8
XFILLER_7_147 VDD VSS sg13g2_decap_8
XFILLER_137_351 VDD VSS sg13g2_decap_8
XFILLER_137_362 VDD VSS sg13g2_fill_2
XFILLER_32_1288 VDD VSS sg13g2_decap_8
X_14152_ _14152_/Q _14310_/CLK _14152_/D _14152_/RESET_B VDD VSS sg13g2_dfrbpq_1
XFILLER_152_310 VDD VSS sg13g2_decap_8
X_11364_ _11366_/A _11373_/A _14462_/Q VDD VSS sg13g2_nand2b_1
XFILLER_153_855 VDD VSS sg13g2_decap_4
XFILLER_138_94 VDD VSS sg13g2_decap_8
X_13103_ _13104_/B _14912_/Q _13675_/Q _13091_/Y VDD VSS sg13g2_a21oi_1
X_10315_ _10315_/Y _10342_/A _10342_/C _10334_/C VDD VSS sg13g2_o21ai_1
XFILLER_4_854 VDD VSS sg13g2_decap_8
X_14083_ _14083_/Q clkload19/A _14083_/D _14083_/RESET_B VDD VSS sg13g2_dfrbpq_1
XFILLER_106_760 VDD VSS sg13g2_decap_8
X_11295_ _11295_/Y _11300_/S0 _13821_/Q VDD VSS sg13g2_nand2b_1
XFILLER_3_364 VDD VSS sg13g2_decap_8
XFILLER_106_782 VDD VSS sg13g2_decap_8
X_13034_ _13034_/Y _13032_/Y _13033_/Y _12933_/Y VDD VSS sg13g2_o21ai_1
XFILLER_112_229 VDD VSS sg13g2_fill_2
X_10246_ _10248_/C _14776_/Q _10250_/D hold3171/X VDD VSS sg13g2_a21oi_1
XFILLER_152_1023 VDD VSS sg13g2_decap_8
Xfanout1110 _07812_/B _08591_/A3 VDD VSS sg13g2_buf_1
Xfanout1121 _08470_/B _11865_/A VDD VSS sg13g2_buf_1
Xfanout1132 _08383_/A _08384_/A1 VDD VSS sg13g2_buf_1
XFILLER_79_677 VDD VSS sg13g2_decap_8
XFILLER_113_1007 VDD VSS sg13g2_decap_8
X_10177_ _10184_/C _10177_/A _14766_/Q VDD VSS sg13g2_nand2_1
X_14531__1648 _14531_/RESET_B VDD VSS sg13g2_tiehi
Xfanout1143 _07775_/A _08306_/C VDD VSS sg13g2_buf_1
XFILLER_67_839 VDD VSS sg13g2_decap_8
XFILLER_152_1067 VDD VSS sg13g2_decap_8
X_13917__2262 _13917_/RESET_B VDD VSS sg13g2_tiehi
Xfanout1154 _08300_/A3 _14965_/Q VDD VSS sg13g2_buf_1
XFILLER_43_1340 VDD VSS sg13g2_fill_2
XFILLER_121_796 VDD VSS sg13g2_fill_1
Xfanout1165 _08843_/A _11384_/A VDD VSS sg13g2_buf_1
Xfanout1176 _13602_/A _14958_/Q VDD VSS sg13g2_buf_1
XFILLER_130_1321 VDD VSS sg13g2_decap_8
XFILLER_14_7 VDD VSS sg13g2_decap_8
XFILLER_43_1373 VDD VSS sg13g2_decap_8
XFILLER_19_210 VDD VSS sg13g2_decap_8
X_14985_ _14985_/Q clkload28/A _14985_/D _14985_/RESET_B VDD VSS sg13g2_dfrbpq_1
Xfanout1187 _13064_/A _14910_/Q VDD VSS sg13g2_buf_1
Xfanout1198 _10558_/B _14858_/Q VDD VSS sg13g2_buf_1
X_14785__2928 _14785_/RESET_B VDD VSS sg13g2_tiehi
X_13936_ _13936_/Q _14512_/CLK _13936_/D _13936_/RESET_B VDD VSS sg13g2_dfrbpq_1
XFILLER_170_70 VDD VSS sg13g2_decap_8
X_14821__2892 _14821_/RESET_B VDD VSS sg13g2_tiehi
XFILLER_19_287 VDD VSS sg13g2_decap_8
XFILLER_90_831 VDD VSS sg13g2_decap_4
XFILLER_34_213 VDD VSS sg13g2_decap_8
X_13867_ _13867_/Q clkload2/A _13867_/D _13867_/RESET_B VDD VSS sg13g2_dfrbpq_1
XFILLER_62_555 VDD VSS sg13g2_decap_8
X_12818_ _12818_/Y _14800_/Q _12851_/B _07728_/B _14832_/Q _13248_/B VDD VSS sg13g2_a221oi_1
XFILLER_34_279 VDD VSS sg13g2_fill_1
XFILLER_163_1130 VDD VSS sg13g2_decap_8
XFILLER_16_994 VDD VSS sg13g2_decap_8
X_13798_ _13798_/Q clkload11/A _13798_/D _13798_/RESET_B VDD VSS sg13g2_dfrbpq_1
XFILLER_43_780 VDD VSS sg13g2_decap_8
XFILLER_31_942 VDD VSS sg13g2_decap_8
XFILLER_128_1283 VDD VSS sg13g2_decap_8
X_12749_ _12750_/B _13665_/Q _12777_/A2 _12748_/X _12400_/A _12777_/C1 VDD VSS sg13g2_a221oi_1
XFILLER_37_1166 VDD VSS sg13g2_decap_8
XFILLER_37_1177 VDD VSS sg13g2_fill_2
XFILLER_124_1136 VDD VSS sg13g2_decap_8
XFILLER_30_452 VDD VSS sg13g2_fill_2
XFILLER_147_126 VDD VSS sg13g2_decap_4
XFILLER_8_63 VDD VSS sg13g2_decap_8
X_14419_ _14419_/Q _14660_/CLK _14419_/D _14419_/RESET_B VDD VSS sg13g2_dfrbpq_1
XFILLER_50_1355 VDD VSS sg13g2_fill_1
XFILLER_144_800 VDD VSS sg13g2_decap_8
XFILLER_116_502 VDD VSS sg13g2_decap_8
XFILLER_128_395 VDD VSS sg13g2_decap_4
XFILLER_144_855 VDD VSS sg13g2_fill_1
XFILLER_170_140 VDD VSS sg13g2_decap_8
Xmax_cap367 _09300_/S _09306_/S VDD VSS sg13g2_buf_2
X_09960_ _14544_/D _14544_/Q _10159_/A1 _09970_/S VDD VSS sg13g2_mux2_1
XFILLER_98_920 VDD VSS sg13g2_decap_4
XFILLER_40_0 VDD VSS sg13g2_decap_8
XFILLER_143_398 VDD VSS sg13g2_decap_8
X_08911_ _13710_/D _08941_/S _08909_/Y _08910_/Y VDD VSS sg13g2_a21oi_1
XFILLER_124_590 VDD VSS sg13g2_fill_1
X_09891_ _14477_/D _09924_/A1 _14477_/Q _09895_/S VDD VSS sg13g2_mux2_1
XFILLER_98_953 VDD VSS sg13g2_decap_8
XFILLER_170_1123 VDD VSS sg13g2_decap_8
XFILLER_135_1254 VDD VSS sg13g2_decap_8
XFILLER_58_817 VDD VSS sg13g2_decap_8
XFILLER_135_1265 VDD VSS sg13g2_fill_1
X_08842_ _13693_/D _08841_/Y _16855_/A _08842_/S VDD VSS sg13g2_mux2_1
XFILLER_97_463 VDD VSS sg13g2_decap_4
XFILLER_131_1118 VDD VSS sg13g2_decap_8
XFILLER_97_485 VDD VSS sg13g2_decap_8
X_14507__1672 _14507_/RESET_B VDD VSS sg13g2_tiehi
XFILLER_69_187 VDD VSS sg13g2_decap_8
X_08773_ _08773_/Y _07720_/C _15117_/Q _15186_/Q _07719_/X VDD VSS sg13g2_a22oi_1
XFILLER_111_295 VDD VSS sg13g2_fill_2
XFILLER_66_850 VDD VSS sg13g2_decap_4
XFILLER_27_28 VDD VSS sg13g2_decap_8
X_07724_ _07726_/C _15073_/Q _15072_/Q _15071_/Q _15083_/Q VDD VSS sg13g2_nor4_1
XFILLER_0_1220 VDD VSS sg13g2_decap_8
X_07655_ _07655_/Y _11743_/C VDD VSS sg13g2_inv_1
XFILLER_25_224 VDD VSS sg13g2_decap_8
XFILLER_129_1014 VDD VSS sg13g2_decap_8
XFILLER_168_1063 VDD VSS sg13g2_decap_8
XFILLER_53_577 VDD VSS sg13g2_decap_8
XFILLER_40_205 VDD VSS sg13g2_decap_8
XFILLER_0_1297 VDD VSS sg13g2_decap_8
XFILLER_107_1301 VDD VSS sg13g2_decap_8
XFILLER_94_1282 VDD VSS sg13g2_decap_8
XFILLER_55_1233 VDD VSS sg13g2_decap_8
X_09325_ _13932_/D _10155_/A1 _13932_/Q _09325_/S VDD VSS sg13g2_mux2_1
XFILLER_94_1293 VDD VSS sg13g2_fill_1
XFILLER_90_1124 VDD VSS sg13g2_decap_4
XFILLER_43_49 VDD VSS sg13g2_decap_8
XFILLER_22_931 VDD VSS sg13g2_fill_1
XFILLER_142_1214 VDD VSS sg13g2_decap_8
XFILLER_146_1383 VDD VSS sg13g2_fill_1
XFILLER_159_49 VDD VSS sg13g2_decap_8
XFILLER_90_1157 VDD VSS sg13g2_decap_8
XFILLER_21_441 VDD VSS sg13g2_decap_8
XFILLER_166_413 VDD VSS sg13g2_decap_8
XFILLER_16_1239 VDD VSS sg13g2_decap_8
XFILLER_90_1168 VDD VSS sg13g2_fill_2
X_09256_ _13865_/D _13865_/Q _09621_/A0 _09272_/S VDD VSS sg13g2_mux2_1
XFILLER_167_958 VDD VSS sg13g2_decap_8
XFILLER_22_997 VDD VSS sg13g2_decap_8
X_08207_ _08207_/X _07888_/B _07910_/B _14961_/Q _08142_/C _13517_/A _08207_/S1 VDD
+ VSS sg13g2_mux4_1
X_09187_ _13803_/D _13803_/Q _09889_/A0 _09193_/S VDD VSS sg13g2_mux2_1
XFILLER_119_351 VDD VSS sg13g2_decap_8
X_08138_ _08138_/X _08138_/A _08138_/B _08452_/C VDD VSS sg13g2_and3_1
XFILLER_135_844 VDD VSS sg13g2_decap_8
XFILLER_135_855 VDD VSS sg13g2_fill_2
XFILLER_107_579 VDD VSS sg13g2_fill_2
XFILLER_108_42 VDD VSS sg13g2_fill_1
XFILLER_135_888 VDD VSS sg13g2_fill_1
XFILLER_161_140 VDD VSS sg13g2_decap_8
X_08069_ _08431_/A _08037_/B _08063_/Y _08033_/A VDD VSS sg13g2_a21oi_1
X_10100_ _14680_/D _10100_/A0 _14680_/Q _10102_/S VDD VSS sg13g2_mux2_1
XFILLER_0_301 VDD VSS sg13g2_decap_8
XFILLER_134_398 VDD VSS sg13g2_decap_8
X_11080_ _11080_/Y _11139_/B1 _11079_/Y _11029_/C VDD VSS sg13g2_o21ai_1
XFILLER_68_35 VDD VSS sg13g2_decap_8
XFILLER_27_1313 VDD VSS sg13g2_decap_8
XFILLER_153_1321 VDD VSS sg13g2_decap_8
XFILLER_88_430 VDD VSS sg13g2_decap_8
XFILLER_62_1215 VDD VSS sg13g2_decap_8
XFILLER_1_868 VDD VSS sg13g2_decap_8
X_10031_ _14613_/D _10031_/A0 _14613_/Q _10032_/S VDD VSS sg13g2_mux2_1
XFILLER_130_560 VDD VSS sg13g2_fill_2
XFILLER_153_1365 VDD VSS sg13g2_fill_1
XFILLER_0_378 VDD VSS sg13g2_decap_8
XFILLER_88_485 VDD VSS sg13g2_decap_8
XFILLER_75_113 VDD VSS sg13g2_fill_1
XFILLER_5_1120 VDD VSS sg13g2_decap_8
XFILLER_48_338 VDD VSS sg13g2_fill_1
XFILLER_124_63 VDD VSS sg13g2_decap_4
XFILLER_48_349 VDD VSS sg13g2_decap_8
XFILLER_25_1092 VDD VSS sg13g2_decap_8
X_14770_ _14770_/Q _14867_/CLK _14770_/D _14770_/RESET_B VDD VSS sg13g2_dfrbpq_1
XFILLER_84_56 VDD VSS sg13g2_decap_4
XFILLER_17_714 VDD VSS sg13g2_decap_8
X_11982_ _11989_/A _11983_/A _13671_/Q VDD VSS sg13g2_xor2_1
XFILLER_57_883 VDD VSS sg13g2_decap_8
XFILLER_44_500 VDD VSS sg13g2_decap_8
XFILLER_5_1197 VDD VSS sg13g2_decap_8
XFILLER_16_224 VDD VSS sg13g2_decap_8
X_13721_ _16883_/A clkload53/A _13721_/D _13721_/RESET_B VDD VSS sg13g2_dfrbpq_1
X_10933_ _10935_/B _10946_/A _10934_/B _10948_/D VDD VSS sg13g2_a21oi_1
XFILLER_90_149 VDD VSS sg13g2_decap_8
XFILLER_72_864 VDD VSS sg13g2_decap_8
XFILLER_73_1300 VDD VSS sg13g2_decap_8
X_13652_ _15118_/D _15187_/D _15118_/Q _13652_/S VDD VSS sg13g2_mux2_1
X_10864_ _10890_/B _14753_/Q _10871_/A VDD VSS sg13g2_xnor2_1
XFILLER_147_1169 VDD VSS sg13g2_fill_2
XFILLER_13_931 VDD VSS sg13g2_decap_8
X_12603_ _12603_/X _13837_/Q _13869_/Q _13901_/Q _13933_/Q _12606_/S0 _12606_/S1 VDD
+ VSS sg13g2_mux4_1
XFILLER_158_914 VDD VSS sg13g2_decap_8
X_13583_ _13583_/Y _15001_/Q _13566_/B _13569_/S _15017_/Q _13533_/X VDD VSS sg13g2_a221oi_1
X_10795_ _14925_/D _11207_/B1 _11205_/A _10792_/Y VDD VSS sg13g2_o21ai_1
XFILLER_12_441 VDD VSS sg13g2_decap_8
XFILLER_169_273 VDD VSS sg13g2_decap_8
XFILLER_9_924 VDD VSS sg13g2_decap_8
XFILLER_34_1339 VDD VSS sg13g2_decap_8
X_12534_ _12534_/X _13736_/Q _14088_/Q _14440_/Q _14536_/Q _12674_/S0 _12674_/S1 VDD
+ VSS sg13g2_mux4_1
XFILLER_158_969 VDD VSS sg13g2_decap_8
XFILLER_8_434 VDD VSS sg13g2_decap_8
XFILLER_40_794 VDD VSS sg13g2_fill_1
XFILLER_149_60 VDD VSS sg13g2_fill_2
XFILLER_145_608 VDD VSS sg13g2_decap_8
X_12465_ _12465_/X _14115_/Q _14147_/Q _14179_/Q _14211_/Q _12715_/S0 _12715_/S1 VDD
+ VSS sg13g2_mux4_1
XFILLER_138_671 VDD VSS sg13g2_decap_8
X_14204_ _14204_/Q clkload40/A _14204_/D _14204_/RESET_B VDD VSS sg13g2_dfrbpq_1
X_11416_ _11420_/A _11415_/X _11802_/B VDD VSS sg13g2_nand2b_1
XFILLER_137_181 VDD VSS sg13g2_decap_4
XFILLER_165_490 VDD VSS sg13g2_decap_8
X_15184_ _15184_/Q _15213_/CLK _15184_/D _15184_/RESET_B VDD VSS sg13g2_dfrbpq_1
X_12396_ _12396_/X _14238_/Q _14270_/Q _14302_/Q _14334_/Q _12396_/S0 _12396_/S1 VDD
+ VSS sg13g2_mux4_1
XFILLER_32_1096 VDD VSS sg13g2_decap_8
XFILLER_172_449 VDD VSS sg13g2_decap_8
XFILLER_126_877 VDD VSS sg13g2_decap_8
X_14135_ _14135_/Q clkload33/A _14135_/D _14135_/RESET_B VDD VSS sg13g2_dfrbpq_1
X_11347_ _11347_/Y _11350_/A1 _14686_/Q VDD VSS sg13g2_nand2b_1
XFILLER_4_651 VDD VSS sg13g2_decap_8
XFILLER_141_814 VDD VSS sg13g2_decap_8
XFILLER_153_674 VDD VSS sg13g2_decap_8
XFILLER_158_1265 VDD VSS sg13g2_fill_2
XFILLER_10_1372 VDD VSS sg13g2_decap_8
XFILLER_153_685 VDD VSS sg13g2_fill_2
XFILLER_165_70 VDD VSS sg13g2_decap_8
XFILLER_3_161 VDD VSS sg13g2_decap_8
XFILLER_98_238 VDD VSS sg13g2_decap_8
X_14066_ _14066_/Q _14632_/CLK _14066_/D _14066_/RESET_B VDD VSS sg13g2_dfrbpq_1
X_11278_ _11278_/Y _11277_/S _14172_/Q VDD VSS sg13g2_nand2b_1
XFILLER_141_869 VDD VSS sg13g2_decap_8
X_13017_ _13017_/Y _13045_/A1 _12900_/C input8/X VDD VSS sg13g2_a21oi_1
X_10229_ _14771_/D _10237_/A _10237_/C _10228_/Y VDD VSS sg13g2_a21oi_1
XFILLER_80_1348 VDD VSS sg13g2_fill_1
XFILLER_66_113 VDD VSS sg13g2_decap_8
XFILLER_58_90 VDD VSS sg13g2_decap_8
XFILLER_48_850 VDD VSS sg13g2_decap_8
XFILLER_43_1170 VDD VSS sg13g2_fill_1
XFILLER_43_1192 VDD VSS sg13g2_decap_8
X_14968_ _14968_/Q clkload28/A _14968_/D _14968_/RESET_B VDD VSS sg13g2_dfrbpq_1
XFILLER_94_488 VDD VSS sg13g2_decap_4
XFILLER_78_1211 VDD VSS sg13g2_decap_8
XFILLER_47_371 VDD VSS sg13g2_decap_8
XFILLER_35_511 VDD VSS sg13g2_decap_8
XFILLER_130_1173 VDD VSS sg13g2_decap_8
X_13919_ _13919_/Q clkload12/A _13919_/D _13919_/RESET_B VDD VSS sg13g2_dfrbpq_1
X_14899_ _14899_/Q clkload62/A _14899_/D _14899_/RESET_B VDD VSS sg13g2_dfrbpq_1
XFILLER_165_1225 VDD VSS sg13g2_decap_8
XFILLER_90_661 VDD VSS sg13g2_decap_8
XFILLER_165_1247 VDD VSS sg13g2_decap_8
XFILLER_90_672 VDD VSS sg13g2_fill_1
XFILLER_16_791 VDD VSS sg13g2_decap_8
XFILLER_22_238 VDD VSS sg13g2_decap_8
XFILLER_128_1080 VDD VSS sg13g2_decap_8
XFILLER_149_936 VDD VSS sg13g2_decap_8
X_09110_ _09110_/X _10760_/A _09150_/B _09109_/Y VDD VSS sg13g2_a21o_1
XFILLER_88_0 VDD VSS sg13g2_decap_8
XFILLER_31_772 VDD VSS sg13g2_decap_8
XFILLER_148_446 VDD VSS sg13g2_decap_4
XFILLER_30_260 VDD VSS sg13g2_decap_4
XFILLER_164_906 VDD VSS sg13g2_decap_4
X_09041_ _09044_/B _14906_/Q _09031_/C _14907_/Q VDD VSS sg13g2_a21oi_1
XFILLER_117_811 VDD VSS sg13g2_decap_8
XFILLER_163_427 VDD VSS sg13g2_decap_8
XFILLER_159_1029 VDD VSS sg13g2_decap_8
XFILLER_116_343 VDD VSS sg13g2_fill_2
XFILLER_11_1169 VDD VSS sg13g2_decap_8
XFILLER_144_652 VDD VSS sg13g2_fill_1
XFILLER_171_460 VDD VSS sg13g2_decap_8
XFILLER_116_376 VDD VSS sg13g2_decap_4
X_13789__2390 _13789_/RESET_B VDD VSS sg13g2_tiehi
XFILLER_132_836 VDD VSS sg13g2_decap_4
XFILLER_144_696 VDD VSS sg13g2_decap_8
XFILLER_131_324 VDD VSS sg13g2_decap_8
XFILLER_132_858 VDD VSS sg13g2_fill_1
X_09943_ _14527_/D _14527_/Q _10109_/A0 _09961_/S VDD VSS sg13g2_mux2_1
Xfanout903 _07682_/A _15209_/Q VDD VSS sg13g2_buf_1
Xfanout914 _12765_/A2 _12542_/A2 VDD VSS sg13g2_buf_1
Xfanout925 _13601_/B _15203_/Q VDD VSS sg13g2_buf_1
Xfanout936 _13401_/B _10201_/A1 VDD VSS sg13g2_buf_1
XFILLER_48_1092 VDD VSS sg13g2_decap_4
Xfanout947 _13249_/B _13028_/B VDD VSS sg13g2_buf_1
X_09874_ _14460_/D _09907_/A1 _14460_/Q _09898_/S VDD VSS sg13g2_mux2_1
Xfanout958 _12879_/B _15107_/Q VDD VSS sg13g2_buf_1
Xfanout969 _08248_/A _08391_/A VDD VSS sg13g2_buf_1
XFILLER_58_647 VDD VSS sg13g2_decap_4
XFILLER_38_49 VDD VSS sg13g2_decap_8
XFILLER_161_28 VDD VSS sg13g2_decap_8
X_08825_ _08825_/Y _13279_/B _12346_/A _08727_/D _15177_/Q _08825_/C1 VDD VSS sg13g2_a221oi_1
X_14023__2156 _14023_/RESET_B VDD VSS sg13g2_tiehi
XFILLER_100_788 VDD VSS sg13g2_decap_8
X_08756_ _13670_/D _08762_/A1 _08754_/Y _08755_/Y VDD VSS sg13g2_a21oi_1
XFILLER_22_1254 VDD VSS sg13g2_decap_8
XFILLER_2_1337 VDD VSS sg13g2_decap_8
X_07707_ _07708_/C _12997_/B _15201_/Q VDD VSS sg13g2_nor2_1
XFILLER_54_853 VDD VSS sg13g2_decap_8
XFILLER_166_7 VDD VSS sg13g2_decap_8
X_08687_ _08687_/X _08465_/X _08537_/X _08621_/C _08686_/X _08597_/B _08617_/A VDD
+ VSS sg13g2_mux4_1
XFILLER_81_672 VDD VSS sg13g2_fill_1
XFILLER_26_577 VDD VSS sg13g2_decap_8
XFILLER_14_728 VDD VSS sg13g2_decap_8
X_07638_ _07638_/Y _14773_/Q VDD VSS sg13g2_inv_1
Xclkbuf_4_4_0_clk_i clkbuf_4_4_0_clk_i/X clkbuf_0_clk_i/X VDD VSS sg13g2_buf_8
XFILLER_110_21 VDD VSS sg13g2_decap_8
XFILLER_53_385 VDD VSS sg13g2_decap_8
XFILLER_0_1094 VDD VSS sg13g2_decap_8
XFILLER_13_238 VDD VSS sg13g2_decap_8
X_13891__2288 _13891_/RESET_B VDD VSS sg13g2_tiehi
XFILLER_94_1090 VDD VSS sg13g2_fill_1
XFILLER_41_569 VDD VSS sg13g2_fill_2
XFILLER_107_1131 VDD VSS sg13g2_decap_8
XFILLER_70_14 VDD VSS sg13g2_decap_8
XFILLER_166_210 VDD VSS sg13g2_decap_8
XFILLER_167_733 VDD VSS sg13g2_decap_8
X_09308_ _13915_/D _09906_/A1 _13915_/Q _09325_/S VDD VSS sg13g2_mux2_1
XFILLER_55_1074 VDD VSS sg13g2_fill_2
XFILLER_139_435 VDD VSS sg13g2_decap_4
XFILLER_16_1036 VDD VSS sg13g2_decap_8
X_10580_ _14871_/D _10580_/A _10599_/A _10580_/C VDD VSS sg13g2_nor3_1
XFILLER_110_98 VDD VSS sg13g2_decap_8
XFILLER_155_906 VDD VSS sg13g2_decap_8
XFILLER_103_1017 VDD VSS sg13g2_decap_4
XFILLER_10_945 VDD VSS sg13g2_decap_8
XFILLER_142_1066 VDD VSS sg13g2_decap_4
Xclkbuf_leaf_6_clk_i clkload5/A clkbuf_leaf_8_clk_i/A VDD VSS sg13g2_buf_8
X_09239_ _13850_/D _10169_/A1 _13850_/Q _09239_/S VDD VSS sg13g2_mux2_1
XFILLER_142_1088 VDD VSS sg13g2_decap_8
XFILLER_33_1372 VDD VSS sg13g2_decap_8
XFILLER_154_427 VDD VSS sg13g2_decap_8
XFILLER_166_287 VDD VSS sg13g2_decap_8
XFILLER_6_938 VDD VSS sg13g2_decap_8
XFILLER_33_1383 VDD VSS sg13g2_fill_1
X_12250_ _12250_/Y _12250_/A1 _14520_/Q _12233_/B VDD VSS sg13g2_a21oi_1
XFILLER_163_950 VDD VSS sg13g2_fill_1
XFILLER_5_448 VDD VSS sg13g2_decap_8
X_11201_ _11201_/Y _11201_/A _11201_/B VDD VSS sg13g2_nand2_1
XFILLER_134_140 VDD VSS sg13g2_decap_8
X_12181_ _12181_/X _12181_/A _12216_/S VDD VSS sg13g2_and2_1
XFILLER_134_151 VDD VSS sg13g2_fill_1
XFILLER_162_460 VDD VSS sg13g2_decap_8
XFILLER_79_56 VDD VSS sg13g2_fill_2
X_14233__1946 _14233_/RESET_B VDD VSS sg13g2_tiehi
X_11132_ _14950_/D _11131_/Y _11130_/Y _11113_/Y VDD VSS sg13g2_o21ai_1
XFILLER_27_1110 VDD VSS sg13g2_decap_8
XFILLER_7_1204 VDD VSS sg13g2_decap_8
X_11063_ _11063_/Y _11060_/X _11035_/Y _11062_/Y VDD VSS sg13g2_a21oi_1
XFILLER_1_665 VDD VSS sg13g2_decap_8
XFILLER_49_614 VDD VSS sg13g2_decap_8
XFILLER_88_260 VDD VSS sg13g2_decap_8
XFILLER_76_400 VDD VSS sg13g2_decap_8
XFILLER_135_84 VDD VSS sg13g2_fill_2
Xhold3070 input12/A mem_axi_rdata[17] VDD VSS sg13g2_dlygate4sd3_1
XFILLER_0_175 VDD VSS sg13g2_decap_8
XFILLER_153_1173 VDD VSS sg13g2_decap_8
Xhold3081 hold3081/X input27/X VDD VSS sg13g2_dlygate4sd3_1
X_10014_ _14596_/D _10080_/A0 _14596_/Q _10032_/S VDD VSS sg13g2_mux2_1
Xhold3092 _10185_/C _10184_/X VDD VSS sg13g2_dlygate4sd3_1
XFILLER_49_647 VDD VSS sg13g2_decap_8
XFILLER_27_1187 VDD VSS sg13g2_decap_8
XFILLER_48_135 VDD VSS sg13g2_decap_8
XFILLER_95_77 VDD VSS sg13g2_decap_8
X_14822_ _14822_/Q _14886_/CLK _14822_/D _14822_/RESET_B VDD VSS sg13g2_dfrbpq_1
XFILLER_76_488 VDD VSS sg13g2_decap_8
XFILLER_149_1209 VDD VSS sg13g2_fill_1
XFILLER_17_511 VDD VSS sg13g2_decap_8
XFILLER_91_436 VDD VSS sg13g2_decap_8
X_14753_ _14753_/Q clkload55/A _14753_/D _14753_/RESET_B VDD VSS sg13g2_dfrbpq_1
X_11965_ _11965_/Y _11962_/Y _11964_/X _11974_/B1 VDD VSS sg13g2_o21ai_1
XFILLER_72_661 VDD VSS sg13g2_decap_4
X_13704_ _16866_/A clkload58/A _13704_/D _13704_/RESET_B VDD VSS sg13g2_dfrbpq_1
X_14178__2001 _14178_/RESET_B VDD VSS sg13g2_tiehi
X_10916_ _10920_/A _15119_/Q _10954_/A VDD VSS sg13g2_xnor2_1
XFILLER_17_588 VDD VSS sg13g2_decap_8
X_14684_ _14684_/Q _14746_/CLK _14684_/D _14684_/RESET_B VDD VSS sg13g2_dfrbpq_1
X_11896_ _11897_/B _11896_/A _14222_/Q VDD VSS sg13g2_nand2_1
X_13635_ _13743_/D _13635_/A VDD VSS sg13g2_buf_1
X_13721__2458 _13721_/RESET_B VDD VSS sg13g2_tiehi
XFILLER_44_70 VDD VSS sg13g2_decap_8
XFILLER_158_700 VDD VSS sg13g2_decap_8
X_14481__1698 _14481_/RESET_B VDD VSS sg13g2_tiehi
X_10847_ _10847_/Y _10843_/Y _10846_/Y _07705_/B VDD VSS sg13g2_a21oi_1
XFILLER_73_1141 VDD VSS sg13g2_decap_4
XFILLER_158_711 VDD VSS sg13g2_fill_1
XFILLER_158_733 VDD VSS sg13g2_decap_8
XFILLER_9_721 VDD VSS sg13g2_decap_8
X_13566_ _13566_/Y _15011_/Q _13566_/B _13566_/C VDD VSS sg13g2_nor3_1
XFILLER_81_7 VDD VSS sg13g2_decap_8
X_10778_ _11180_/C _14952_/Q _08943_/A _10776_/X VDD VSS sg13g2_a21o_1
XFILLER_158_766 VDD VSS sg13g2_fill_2
XFILLER_158_777 VDD VSS sg13g2_fill_1
XFILLER_8_231 VDD VSS sg13g2_decap_8
XFILLER_173_703 VDD VSS sg13g2_fill_1
X_12517_ _12517_/X _14375_/Q _14407_/Q _14471_/Q _14503_/Q _12716_/S0 _12716_/S1 VDD
+ VSS sg13g2_mux4_1
XFILLER_145_416 VDD VSS sg13g2_fill_1
XFILLER_160_1188 VDD VSS sg13g2_fill_2
X_13497_ _13498_/A _13481_/A _13655_/S _15174_/D _13487_/Y VDD VSS sg13g2_a22oi_1
XFILLER_173_725 VDD VSS sg13g2_fill_2
XFILLER_9_798 VDD VSS sg13g2_decap_8
XFILLER_145_438 VDD VSS sg13g2_decap_8
XFILLER_157_298 VDD VSS sg13g2_fill_1
X_15236_ _15236_/Q clkload53/A _15236_/D _15236_/RESET_B VDD VSS sg13g2_dfrbpq_1
XFILLER_173_758 VDD VSS sg13g2_fill_2
XFILLER_172_224 VDD VSS sg13g2_decap_4
X_14101__2078 _14101_/RESET_B VDD VSS sg13g2_tiehi
X_12448_ _12448_/X _14690_/Q _14722_/Q _13762_/Q _13794_/Q _12450_/S0 _12450_/S1 VDD
+ VSS sg13g2_mux4_1
XFILLER_154_950 VDD VSS sg13g2_decap_8
XFILLER_154_961 VDD VSS sg13g2_fill_1
XFILLER_154_972 VDD VSS sg13g2_decap_8
X_15167_ _15167_/Q clkload70/A _15167_/D _15167_/RESET_B VDD VSS sg13g2_dfrbpq_1
X_12379_ _12379_/X _14109_/Q _14141_/Q _14173_/Q _14205_/Q _12382_/S0 _12382_/S1 VDD
+ VSS sg13g2_mux4_1
XFILLER_5_42 VDD VSS sg13g2_decap_8
XFILLER_119_1013 VDD VSS sg13g2_decap_8
X_14118_ _14118_/Q clkload2/A _14118_/D _14118_/RESET_B VDD VSS sg13g2_dfrbpq_1
X_14209__1970 _14209_/RESET_B VDD VSS sg13g2_tiehi
XFILLER_141_644 VDD VSS sg13g2_fill_1
X_14985__2602 _14985_/RESET_B VDD VSS sg13g2_tiehi
X_15098_ _15098_/Q _15159_/CLK _15098_/D _15098_/RESET_B VDD VSS sg13g2_dfrbpq_1
XFILLER_140_132 VDD VSS sg13g2_decap_8
XFILLER_119_1068 VDD VSS sg13g2_decap_8
X_14049_ _14049_/Q _14722_/CLK _14049_/D _14049_/RESET_B VDD VSS sg13g2_dfrbpq_1
XFILLER_122_880 VDD VSS sg13g2_decap_8
XFILLER_68_945 VDD VSS sg13g2_fill_1
XFILLER_132_1246 VDD VSS sg13g2_decap_8
XFILLER_68_989 VDD VSS sg13g2_decap_8
XFILLER_67_466 VDD VSS sg13g2_decap_4
X_08610_ _08610_/Y _08576_/Y _08608_/Y _08643_/A VDD VSS sg13g2_a21oi_1
XFILLER_132_1279 VDD VSS sg13g2_decap_4
X_09590_ _14187_/D _14187_/Q _09623_/A0 _09596_/S VDD VSS sg13g2_mux2_1
XFILLER_95_797 VDD VSS sg13g2_decap_8
XFILLER_94_274 VDD VSS sg13g2_decap_8
XFILLER_54_105 VDD VSS sg13g2_fill_1
XFILLER_83_948 VDD VSS sg13g2_decap_4
XFILLER_67_499 VDD VSS sg13g2_fill_1
XFILLER_94_296 VDD VSS sg13g2_fill_1
X_08541_ _08541_/Y _08541_/A _08541_/B _15012_/Q VDD VSS sg13g2_nand3_1
XFILLER_78_1030 VDD VSS sg13g2_decap_8
XFILLER_82_469 VDD VSS sg13g2_decap_8
XFILLER_36_875 VDD VSS sg13g2_decap_8
X_08472_ _08472_/X _15008_/Q _08471_/B _08623_/A2 VDD VSS sg13g2_a21o_1
XFILLER_78_1074 VDD VSS sg13g2_decap_8
XFILLER_62_160 VDD VSS sg13g2_fill_2
XFILLER_23_525 VDD VSS sg13g2_decap_8
XFILLER_39_1058 VDD VSS sg13g2_decap_8
XFILLER_126_1017 VDD VSS sg13g2_fill_2
XFILLER_50_322 VDD VSS sg13g2_decap_8
XFILLER_62_193 VDD VSS sg13g2_decap_8
X_14311__1868 _14311_/RESET_B VDD VSS sg13g2_tiehi
XFILLER_51_878 VDD VSS sg13g2_decap_4
XFILLER_50_355 VDD VSS sg13g2_decap_8
XFILLER_149_722 VDD VSS sg13g2_decap_8
XFILLER_17_1323 VDD VSS sg13g2_decap_8
X_14905__2734 _14905_/RESET_B VDD VSS sg13g2_tiehi
XFILLER_56_1383 VDD VSS sg13g2_fill_1
XFILLER_143_1342 VDD VSS sg13g2_fill_1
X_13687__2498 _13687_/RESET_B VDD VSS sg13g2_tiehi
XFILLER_137_906 VDD VSS sg13g2_fill_1
XFILLER_149_777 VDD VSS sg13g2_decap_8
XFILLER_52_1269 VDD VSS sg13g2_fill_1
XFILLER_136_427 VDD VSS sg13g2_fill_1
XFILLER_40_28 VDD VSS sg13g2_decap_8
XFILLER_148_287 VDD VSS sg13g2_decap_4
X_09024_ _09024_/X _09024_/A _09024_/B _09024_/C VDD VSS sg13g2_and3_1
XFILLER_163_224 VDD VSS sg13g2_decap_8
X_13876__2303 _13876_/RESET_B VDD VSS sg13g2_tiehi
XFILLER_156_28 VDD VSS sg13g2_decap_8
X_14938__2668 _14938_/RESET_B VDD VSS sg13g2_tiehi
XFILLER_117_663 VDD VSS sg13g2_decap_8
XFILLER_145_972 VDD VSS sg13g2_decap_8
XFILLER_145_983 VDD VSS sg13g2_fill_2
XFILLER_105_825 VDD VSS sg13g2_fill_1
XFILLER_116_151 VDD VSS sg13g2_decap_8
XFILLER_145_994 VDD VSS sg13g2_decap_4
XFILLER_85_1034 VDD VSS sg13g2_decap_8
XFILLER_117_696 VDD VSS sg13g2_fill_2
XFILLER_172_791 VDD VSS sg13g2_fill_1
X_14780__2933 _14780_/RESET_B VDD VSS sg13g2_tiehi
Xfanout700 _12239_/B fanout706/X VDD VSS sg13g2_buf_1
XFILLER_104_368 VDD VSS sg13g2_decap_8
Xfanout711 _12317_/B fanout712/X VDD VSS sg13g2_buf_1
Xfanout722 _12233_/B _12015_/B VDD VSS sg13g2_buf_1
X_09926_ _14511_/D _14511_/Q _09926_/A1 _09936_/S VDD VSS sg13g2_mux2_1
Xfanout733 _13493_/A2 _13483_/A2 VDD VSS sg13g2_buf_1
XFILLER_63_1343 VDD VSS sg13g2_decap_8
XFILLER_58_400 VDD VSS sg13g2_decap_8
Xfanout744 _08597_/B _08223_/S VDD VSS sg13g2_buf_1
XFILLER_172_49 VDD VSS sg13g2_decap_8
Xfanout755 _08426_/A _08110_/C VDD VSS sg13g2_buf_1
XFILLER_24_1316 VDD VSS sg13g2_decap_8
XFILLER_105_21 VDD VSS sg13g2_decap_8
Xfanout766 _08160_/A _08290_/S VDD VSS sg13g2_buf_1
XFILLER_58_433 VDD VSS sg13g2_fill_2
Xfanout777 _12567_/S _12789_/S1 VDD VSS sg13g2_buf_1
X_09857_ _14444_/D _14444_/Q _10088_/A0 _09871_/S VDD VSS sg13g2_mux2_1
XFILLER_59_967 VDD VSS sg13g2_decap_8
Xfanout788 _12761_/S1 _15213_/Q VDD VSS sg13g2_buf_1
Xfanout799 _12398_/S0 _12705_/S0 VDD VSS sg13g2_buf_1
XFILLER_65_14 VDD VSS sg13g2_decap_8
XFILLER_18_308 VDD VSS sg13g2_decap_8
X_08808_ _13687_/D _08808_/A _08808_/B VDD VSS sg13g2_nor2_1
XFILLER_58_488 VDD VSS sg13g2_fill_1
XFILLER_105_98 VDD VSS sg13g2_decap_8
X_09788_ _14377_/D _09920_/A1 _14377_/Q _09800_/S VDD VSS sg13g2_mux2_1
XFILLER_6_1281 VDD VSS sg13g2_decap_8
XFILLER_27_820 VDD VSS sg13g2_decap_8
XFILLER_74_959 VDD VSS sg13g2_decap_4
XFILLER_39_680 VDD VSS sg13g2_decap_8
XFILLER_22_1051 VDD VSS sg13g2_decap_8
X_15116__2727 _15116_/RESET_B VDD VSS sg13g2_tiehi
XFILLER_39_691 VDD VSS sg13g2_fill_1
XFILLER_2_1134 VDD VSS sg13g2_decap_8
X_08739_ _08739_/Y _08760_/A1 _08754_/A2 _15197_/Q VDD VSS sg13g2_o21ai_1
XFILLER_27_853 VDD VSS sg13g2_decap_4
XFILLER_148_1220 VDD VSS sg13g2_fill_1
XFILLER_57_1103 VDD VSS sg13g2_decap_4
XFILLER_54_661 VDD VSS sg13g2_decap_8
X_11750_ _11750_/Y _11749_/A1 _14474_/Q VDD VSS sg13g2_nand2b_1
XFILLER_14_525 VDD VSS sg13g2_decap_8
XFILLER_57_1147 VDD VSS sg13g2_fill_1
XFILLER_26_396 VDD VSS sg13g2_decap_8
X_10701_ _10923_/A _09016_/B _10694_/S _08865_/Y VDD VSS sg13g2_a21oi_1
XFILLER_144_1128 VDD VSS sg13g2_decap_8
XFILLER_42_867 VDD VSS sg13g2_decap_4
XFILLER_109_1248 VDD VSS sg13g2_decap_8
X_11681_ _11681_/Y _12100_/S0 _14376_/Q VDD VSS sg13g2_nand2b_1
X_13420_ _13459_/C _15199_/Q _13448_/C VDD VSS sg13g2_and2_1
XFILLER_41_377 VDD VSS sg13g2_decap_4
X_10632_ _10633_/C _14885_/Q _14884_/Q _14883_/Q _10632_/D VDD VSS sg13g2_and4_1
XFILLER_22_580 VDD VSS sg13g2_decap_8
XFILLER_10_742 VDD VSS sg13g2_decap_8
XFILLER_14_84 VDD VSS sg13g2_decap_8
XFILLER_155_703 VDD VSS sg13g2_fill_2
XFILLER_31_1309 VDD VSS sg13g2_decap_8
XFILLER_167_574 VDD VSS sg13g2_decap_8
X_13351_ _13351_/Y _15183_/D _13351_/B _13351_/C _13351_/D VDD VSS sg13g2_nor4_1
X_10563_ _10565_/C _14866_/Q _10566_/D _14861_/Q VDD VSS sg13g2_nand3_1
X_12302_ _12302_/Y _12299_/Y _12300_/Y _12301_/Y VDD VSS sg13g2_o21ai_1
XFILLER_6_735 VDD VSS sg13g2_decap_8
X_13282_ _13287_/A _13282_/A1 _10671_/Y _07744_/B _07744_/C _13281_/C VDD VSS sg13g2_a221oi_1
X_10494_ _10496_/C _10513_/D _10498_/D _14852_/Q VDD VSS sg13g2_a21o_1
XFILLER_108_641 VDD VSS sg13g2_decap_8
X_14466__1713 _14466_/RESET_B VDD VSS sg13g2_tiehi
XFILLER_5_245 VDD VSS sg13g2_decap_8
XFILLER_142_408 VDD VSS sg13g2_fill_2
X_15021_ _15021_/Q clkload66/A _15021_/D _15021_/RESET_B VDD VSS sg13g2_dfrbpq_1
XFILLER_68_1221 VDD VSS sg13g2_decap_8
X_12233_ _12237_/A _12232_/X _12233_/B VDD VSS sg13g2_nand2b_1
XFILLER_68_1232 VDD VSS sg13g2_fill_1
XFILLER_136_983 VDD VSS sg13g2_decap_8
XFILLER_29_1205 VDD VSS sg13g2_decap_8
XFILLER_135_482 VDD VSS sg13g2_decap_8
XFILLER_163_791 VDD VSS sg13g2_decap_8
X_12164_ _12164_/Y _12161_/Y _12163_/X _12265_/B1 VDD VSS sg13g2_o21ai_1
XFILLER_107_195 VDD VSS sg13g2_fill_1
XFILLER_150_441 VDD VSS sg13g2_decap_4
XFILLER_2_952 VDD VSS sg13g2_decap_8
X_11115_ _11138_/C _11115_/A _11115_/B _11147_/A VDD VSS sg13g2_nor3_1
XFILLER_116_1219 VDD VSS sg13g2_fill_2
XFILLER_155_1268 VDD VSS sg13g2_fill_2
X_12095_ _12095_/Y _12100_/S0 _14580_/Q VDD VSS sg13g2_nand2b_1
XFILLER_7_1001 VDD VSS sg13g2_decap_8
XFILLER_1_462 VDD VSS sg13g2_decap_8
X_11046_ _11046_/Y _11046_/A _11046_/B VDD VSS sg13g2_nand2_1
XFILLER_39_70 VDD VSS sg13g2_decap_8
XFILLER_7_1078 VDD VSS sg13g2_decap_8
XFILLER_77_775 VDD VSS sg13g2_decap_8
XFILLER_37_628 VDD VSS sg13g2_decap_8
X_14805_ _14805_/Q _14867_/CLK _14805_/D _14805_/RESET_B VDD VSS sg13g2_dfrbpq_1
XFILLER_149_1039 VDD VSS sg13g2_decap_8
X_12997_ _12997_/Y _12997_/A _12997_/B VDD VSS sg13g2_nand2_1
Xclkbuf_leaf_107_clk_i _14734_/CLK clkbuf_5_18__f_clk_i/X VDD VSS sg13g2_buf_8
XFILLER_75_1203 VDD VSS sg13g2_decap_4
XFILLER_18_875 VDD VSS sg13g2_decap_8
XFILLER_166_1331 VDD VSS sg13g2_fill_2
XFILLER_79_1383 VDD VSS sg13g2_fill_1
XFILLER_51_108 VDD VSS sg13g2_decap_4
XFILLER_45_672 VDD VSS sg13g2_decap_8
X_13954__2225 _13954_/RESET_B VDD VSS sg13g2_tiehi
X_14736_ _14736_/Q clkload8/A _14736_/D _14736_/RESET_B VDD VSS sg13g2_dfrbpq_1
X_11948_ _11948_/X _14576_/Q _14608_/Q _11966_/S VDD VSS sg13g2_mux2_1
XFILLER_17_385 VDD VSS sg13g2_decap_8
XFILLER_162_1228 VDD VSS sg13g2_decap_8
X_14667_ _14667_/Q _14667_/CLK _14667_/D _14667_/RESET_B VDD VSS sg13g2_dfrbpq_1
XFILLER_32_344 VDD VSS sg13g2_decap_8
X_11879_ _11879_/Y _11217_/S _14638_/Q VDD VSS sg13g2_nand2b_1
X_13618_ _13726_/D _13618_/A VDD VSS sg13g2_buf_1
X_14598_ _14598_/Q _14662_/CLK _14598_/D _14598_/RESET_B VDD VSS sg13g2_dfrbpq_1
XFILLER_20_539 VDD VSS sg13g2_decap_8
XFILLER_118_405 VDD VSS sg13g2_decap_8
XFILLER_119_939 VDD VSS sg13g2_decap_8
X_13549_ _13549_/Y _15005_/Q _13552_/B _13563_/C VDD VSS sg13g2_nor3_1
XFILLER_146_725 VDD VSS sg13g2_fill_1
XFILLER_158_585 VDD VSS sg13g2_fill_1
XFILLER_173_522 VDD VSS sg13g2_decap_8
XFILLER_146_747 VDD VSS sg13g2_fill_1
XFILLER_9_595 VDD VSS sg13g2_decap_8
XFILLER_103_1370 VDD VSS sg13g2_fill_1
XFILLER_12_1253 VDD VSS sg13g2_decap_8
XFILLER_86_1321 VDD VSS sg13g2_decap_4
XFILLER_173_577 VDD VSS sg13g2_decap_8
XFILLER_133_419 VDD VSS sg13g2_decap_8
X_15219_ _15219_/Q clkload61/A _15219_/D _15219_/RESET_B VDD VSS sg13g2_dfrbpq_1
XFILLER_173_1302 VDD VSS sg13g2_decap_8
XFILLER_160_238 VDD VSS sg13g2_decap_8
XFILLER_99_322 VDD VSS sg13g2_decap_8
XFILLER_114_633 VDD VSS sg13g2_fill_2
XFILLER_99_333 VDD VSS sg13g2_fill_1
XFILLER_142_964 VDD VSS sg13g2_decap_8
Xclkbuf_5_4__f_clk_i clkbuf_5_4__f_clk_i/X clkbuf_4_2_0_clk_i/X VDD VSS sg13g2_buf_16
XFILLER_99_344 VDD VSS sg13g2_decap_8
XFILLER_87_506 VDD VSS sg13g2_fill_2
XFILLER_173_1368 VDD VSS sg13g2_decap_8
XFILLER_114_699 VDD VSS sg13g2_fill_2
X_07972_ _08663_/A _15017_/Q _07972_/B VDD VSS sg13g2_nand2b_1
XFILLER_99_399 VDD VSS sg13g2_decap_8
XFILLER_101_338 VDD VSS sg13g2_fill_1
X_09711_ _14302_/D _09909_/A1 _14302_/Q _09733_/S VDD VSS sg13g2_mux2_1
XFILLER_95_550 VDD VSS sg13g2_decap_8
XFILLER_132_1043 VDD VSS sg13g2_decap_8
XFILLER_95_561 VDD VSS sg13g2_fill_2
XFILLER_83_701 VDD VSS sg13g2_decap_8
XFILLER_132_1065 VDD VSS sg13g2_fill_2
X_09642_ _14235_/D _09774_/A0 _14235_/Q _09667_/S VDD VSS sg13g2_mux2_1
XFILLER_55_414 VDD VSS sg13g2_decap_8
XFILLER_27_105 VDD VSS sg13g2_decap_8
XFILLER_82_211 VDD VSS sg13g2_fill_2
XFILLER_132_1098 VDD VSS sg13g2_decap_8
X_09573_ _09573_/X _10037_/A _10037_/B _09606_/C VDD VSS sg13g2_and3_1
XFILLER_83_767 VDD VSS sg13g2_fill_2
XFILLER_55_469 VDD VSS sg13g2_decap_8
XFILLER_35_28 VDD VSS sg13g2_decap_8
XFILLER_36_661 VDD VSS sg13g2_decap_8
X_08524_ _08524_/Y _08548_/B _08275_/B _08523_/Y VDD VSS sg13g2_o21ai_1
X_14544__1635 _14544_/RESET_B VDD VSS sg13g2_tiehi
XFILLER_82_299 VDD VSS sg13g2_decap_8
XFILLER_24_834 VDD VSS sg13g2_decap_8
XFILLER_169_806 VDD VSS sg13g2_decap_8
XFILLER_93_1347 VDD VSS sg13g2_decap_4
XFILLER_23_322 VDD VSS sg13g2_decap_8
X_08455_ _08461_/B _15007_/Q _11843_/A _08454_/X VDD VSS sg13g2_o21ai_1
Xclkbuf_leaf_71_clk_i clkload56/A clkbuf_leaf_73_clk_i/A VDD VSS sg13g2_buf_8
XFILLER_52_1000 VDD VSS sg13g2_decap_4
XFILLER_17_1120 VDD VSS sg13g2_decap_8
X_14798__2915 _14798_/RESET_B VDD VSS sg13g2_tiehi
X_08386_ _08386_/Y _08412_/B _08385_/Y _08381_/Y VDD VSS sg13g2_o21ai_1
XFILLER_91_1060 VDD VSS sg13g2_decap_8
XFILLER_56_1180 VDD VSS sg13g2_decap_8
XFILLER_11_539 VDD VSS sg13g2_decap_8
XFILLER_91_1071 VDD VSS sg13g2_decap_8
XFILLER_23_399 VDD VSS sg13g2_decap_8
XFILLER_52_1033 VDD VSS sg13g2_fill_2
XFILLER_51_49 VDD VSS sg13g2_decap_4
XFILLER_108_1281 VDD VSS sg13g2_decap_8
XFILLER_137_714 VDD VSS sg13g2_decap_4
XFILLER_164_511 VDD VSS sg13g2_decap_8
XFILLER_129_7 VDD VSS sg13g2_decap_8
XFILLER_167_49 VDD VSS sg13g2_decap_8
XFILLER_17_1197 VDD VSS sg13g2_decap_8
X_15145__2667 _15145_/RESET_B VDD VSS sg13g2_tiehi
XFILLER_30_1331 VDD VSS sg13g2_decap_8
XFILLER_118_950 VDD VSS sg13g2_decap_8
Xclkbuf_leaf_86_clk_i clkload51/A clkbuf_leaf_87_clk_i/A VDD VSS sg13g2_buf_8
XFILLER_118_961 VDD VSS sg13g2_fill_1
XFILLER_124_408 VDD VSS sg13g2_decap_8
X_09007_ _09007_/X _09006_/A _09003_/X _09006_/Y VDD VSS sg13g2_a21o_1
XFILLER_105_600 VDD VSS sg13g2_decap_4
XFILLER_118_983 VDD VSS sg13g2_decap_4
XFILLER_151_205 VDD VSS sg13g2_fill_1
XFILLER_164_588 VDD VSS sg13g2_decap_8
XFILLER_133_920 VDD VSS sg13g2_decap_8
XFILLER_133_931 VDD VSS sg13g2_fill_2
XFILLER_117_493 VDD VSS sg13g2_decap_8
XFILLER_3_749 VDD VSS sg13g2_decap_8
XFILLER_133_975 VDD VSS sg13g2_fill_2
XFILLER_2_259 VDD VSS sg13g2_decap_8
XFILLER_105_677 VDD VSS sg13g2_decap_4
XFILLER_116_42 VDD VSS sg13g2_decap_8
XFILLER_116_53 VDD VSS sg13g2_fill_1
XFILLER_116_64 VDD VSS sg13g2_decap_8
Xfanout530 _09574_/A1 _10138_/A1 VDD VSS sg13g2_buf_1
XFILLER_120_647 VDD VSS sg13g2_fill_2
Xfanout541 _13600_/A _13608_/A1 VDD VSS sg13g2_buf_1
XFILLER_59_731 VDD VSS sg13g2_fill_1
XFILLER_120_658 VDD VSS sg13g2_decap_4
Xfanout552 _08688_/C _08398_/Y VDD VSS sg13g2_buf_1
X_09909_ _14494_/D _14494_/Q _09909_/A1 _09931_/S VDD VSS sg13g2_mux2_1
XFILLER_76_35 VDD VSS sg13g2_decap_8
XFILLER_24_1113 VDD VSS sg13g2_decap_8
XFILLER_120_669 VDD VSS sg13g2_decap_8
Xfanout563 _13181_/B1 _13236_/B1 VDD VSS sg13g2_buf_1
Xfanout574 _13569_/S _13561_/S VDD VSS sg13g2_buf_1
XFILLER_8_1365 VDD VSS sg13g2_decap_8
XFILLER_59_764 VDD VSS sg13g2_decap_8
XFILLER_86_550 VDD VSS sg13g2_decap_8
Xfanout585 _11021_/B _11170_/B VDD VSS sg13g2_buf_1
XFILLER_4_1218 VDD VSS sg13g2_decap_8
X_12920_ _12921_/B _07683_/A _12933_/A _12910_/Y _13300_/A _12919_/Y VDD VSS sg13g2_a221oi_1
Xfanout596 _08972_/S _08966_/Y VDD VSS sg13g2_buf_1
XFILLER_86_572 VDD VSS sg13g2_decap_8
XFILLER_86_583 VDD VSS sg13g2_fill_1
XFILLER_18_105 VDD VSS sg13g2_decap_8
XFILLER_46_425 VDD VSS sg13g2_fill_2
Xclkbuf_leaf_24_clk_i clkload16/A clkbuf_5_9__f_clk_i/X VDD VSS sg13g2_buf_8
XFILLER_132_63 VDD VSS sg13g2_fill_2
X_12851_ _12851_/Y _14802_/Q _12851_/B VDD VSS sg13g2_nand2_1
XFILLER_98_1269 VDD VSS sg13g2_decap_8
X_14183__1996 _14183_/RESET_B VDD VSS sg13g2_tiehi
XFILLER_74_778 VDD VSS sg13g2_decap_4
XFILLER_15_812 VDD VSS sg13g2_decap_8
X_11802_ _11806_/A _11801_/X _11802_/B VDD VSS sg13g2_nand2b_1
XFILLER_33_119 VDD VSS sg13g2_decap_8
X_12782_ _12782_/X _14394_/Q _14426_/Q _14490_/Q _14522_/Q _12782_/S0 _12782_/S1 VDD
+ VSS sg13g2_mux4_1
XFILLER_73_299 VDD VSS sg13g2_fill_1
XFILLER_61_439 VDD VSS sg13g2_decap_8
XFILLER_27_694 VDD VSS sg13g2_decap_8
XFILLER_14_322 VDD VSS sg13g2_decap_8
XFILLER_26_182 VDD VSS sg13g2_decap_8
XFILLER_155_0 VDD VSS sg13g2_decap_8
X_14521_ _14521_/Q clkload22/A _14521_/D _14521_/RESET_B VDD VSS sg13g2_dfrbpq_1
X_11733_ _11733_/Y _11749_/A1 _14218_/Q _11802_/B VDD VSS sg13g2_a21oi_1
XFILLER_42_653 VDD VSS sg13g2_decap_4
Xclkbuf_leaf_39_clk_i clkload30/A clkbuf_leaf_44_clk_i/A VDD VSS sg13g2_buf_8
XFILLER_15_889 VDD VSS sg13g2_decap_8
XFILLER_42_664 VDD VSS sg13g2_fill_2
X_14452_ _14452_/Q clkload15/A _14452_/D _14452_/RESET_B VDD VSS sg13g2_dfrbpq_1
XFILLER_30_837 VDD VSS sg13g2_decap_8
XFILLER_14_399 VDD VSS sg13g2_decap_8
X_11664_ _11664_/Y _11664_/A _11664_/B VDD VSS sg13g2_nor2_1
XFILLER_41_185 VDD VSS sg13g2_decap_4
XFILLER_35_1242 VDD VSS sg13g2_decap_8
XFILLER_168_872 VDD VSS sg13g2_decap_8
X_13403_ _13403_/Y _13427_/A _13427_/B _15089_/Q VDD VSS sg13g2_nand3_1
XFILLER_161_1272 VDD VSS sg13g2_fill_2
X_10615_ _10615_/Y _10614_/A _10614_/B _10630_/C VDD VSS sg13g2_o21ai_1
XFILLER_31_1106 VDD VSS sg13g2_decap_8
X_14383_ _14383_/Q clkload8/A _14383_/D _14383_/RESET_B VDD VSS sg13g2_dfrbpq_1
XFILLER_161_1283 VDD VSS sg13g2_decap_8
XFILLER_167_371 VDD VSS sg13g2_decap_8
X_11595_ _11599_/A _11594_/X _11690_/B VDD VSS sg13g2_nand2b_1
X_13334_ _15169_/D hold3033/X _15169_/Q _13336_/S VDD VSS sg13g2_mux2_1
X_10546_ _10561_/A _14864_/Q _14863_/Q VDD VSS sg13g2_nand2_1
XFILLER_6_532 VDD VSS sg13g2_decap_8
XFILLER_142_205 VDD VSS sg13g2_decap_8
XFILLER_143_728 VDD VSS sg13g2_fill_1
X_13265_ _13266_/B _13048_/X _13264_/X _13259_/Y _13160_/B _13263_/Y VDD VSS sg13g2_a221oi_1
XFILLER_124_920 VDD VSS sg13g2_decap_8
XFILLER_170_525 VDD VSS sg13g2_decap_8
X_10477_ _10489_/D _14847_/Q _10486_/D _10477_/C VDD VSS sg13g2_and3_1
XFILLER_124_931 VDD VSS sg13g2_fill_2
X_15004_ _15004_/Q _15247_/CLK _15004_/D _15004_/RESET_B VDD VSS sg13g2_dfrbpq_1
X_12216_ _12216_/X _12211_/X _12212_/X _12216_/S VDD VSS sg13g2_mux2_1
XFILLER_44_7 VDD VSS sg13g2_decap_8
X_13196_ _13196_/Y _13196_/A _13196_/B _13196_/C VDD VSS sg13g2_nand3_1
XFILLER_123_452 VDD VSS sg13g2_decap_8
XFILLER_116_1005 VDD VSS sg13g2_decap_8
X_12147_ _12147_/Y _12145_/Y _12146_/Y _12126_/A VDD VSS sg13g2_a21oi_1
X_14622__1557 _14622_/RESET_B VDD VSS sg13g2_tiehi
XFILLER_29_1079 VDD VSS sg13g2_fill_1
XFILLER_123_496 VDD VSS sg13g2_decap_8
XFILLER_173_70 VDD VSS sg13g2_decap_8
XFILLER_2_21 VDD VSS sg13g2_decap_8
X_12078_ _12078_/Y _12293_/A1 _12076_/X _12077_/Y VDD VSS sg13g2_o21ai_1
XFILLER_38_904 VDD VSS sg13g2_decap_8
XFILLER_81_1284 VDD VSS sg13g2_fill_1
XFILLER_49_263 VDD VSS sg13g2_decap_8
XFILLER_110_179 VDD VSS sg13g2_fill_2
X_11029_ _11029_/Y _11029_/A _11029_/B _11029_/C VDD VSS sg13g2_nand3_1
XFILLER_37_425 VDD VSS sg13g2_decap_4
XFILLER_2_98 VDD VSS sg13g2_decap_8
XFILLER_18_672 VDD VSS sg13g2_decap_8
XFILLER_24_119 VDD VSS sg13g2_decap_8
XFILLER_17_182 VDD VSS sg13g2_decap_8
XFILLER_75_1044 VDD VSS sg13g2_decap_4
X_14719_ _14719_/Q clkload9/A _14719_/D _14719_/RESET_B VDD VSS sg13g2_dfrbpq_1
XFILLER_127_1123 VDD VSS sg13g2_fill_2
XFILLER_166_1194 VDD VSS sg13g2_decap_8
XFILLER_36_1028 VDD VSS sg13g2_decap_8
XFILLER_127_1156 VDD VSS sg13g2_fill_1
X_08240_ _08240_/Y _08539_/B1 _08237_/Y _08239_/Y VDD VSS sg13g2_o21ai_1
XFILLER_21_826 VDD VSS sg13g2_decap_8
XFILLER_53_1320 VDD VSS sg13g2_decap_8
XFILLER_33_697 VDD VSS sg13g2_decap_8
XANTENNA_15 _16883_/A VDD VSS sg13g2_antennanp
XANTENNA_26 _16863_/A VDD VSS sg13g2_antennanp
XFILLER_127_1189 VDD VSS sg13g2_decap_8
XFILLER_20_336 VDD VSS sg13g2_decap_8
XFILLER_165_308 VDD VSS sg13g2_decap_8
X_08171_ _08171_/X _11384_/A _11335_/A _11454_/A _11428_/A _08253_/S0 _07913_/A VDD
+ VSS sg13g2_mux4_1
XFILLER_14_1337 VDD VSS sg13g2_decap_8
XFILLER_70_0 VDD VSS sg13g2_decap_8
XFILLER_118_224 VDD VSS sg13g2_decap_8
XFILLER_158_393 VDD VSS sg13g2_fill_1
XFILLER_9_392 VDD VSS sg13g2_decap_8
XFILLER_174_864 VDD VSS sg13g2_fill_1
XFILLER_174_875 VDD VSS sg13g2_decap_8
XFILLER_12_1050 VDD VSS sg13g2_decap_8
XFILLER_133_205 VDD VSS sg13g2_decap_8
XFILLER_133_216 VDD VSS sg13g2_fill_2
Xoutput100 mem_axi_awaddr[9] _16862_/X VDD VSS sg13g2_buf_1
XFILLER_173_385 VDD VSS sg13g2_decap_4
Xoutput111 mem_axi_wdata[16] _15148_/Q VDD VSS sg13g2_buf_1
XFILLER_161_547 VDD VSS sg13g2_decap_8
Xoutput122 mem_axi_wdata[26] _15158_/Q VDD VSS sg13g2_buf_1
Xoutput133 mem_axi_wdata[7] _15139_/Q VDD VSS sg13g2_buf_1
XFILLER_86_1162 VDD VSS sg13g2_decap_8
XFILLER_115_964 VDD VSS sg13g2_decap_8
XFILLER_130_901 VDD VSS sg13g2_decap_8
XFILLER_114_452 VDD VSS sg13g2_decap_8
XFILLER_88_837 VDD VSS sg13g2_fill_1
X_07955_ _07958_/B _15012_/Q _08541_/B VDD VSS sg13g2_nand2b_1
XFILLER_68_561 VDD VSS sg13g2_fill_2
XFILLER_29_926 VDD VSS sg13g2_decap_4
X_07886_ _07924_/C _08219_/A _13545_/A VDD VSS sg13g2_xor2_1
XFILLER_95_380 VDD VSS sg13g2_decap_8
XFILLER_29_959 VDD VSS sg13g2_fill_1
XFILLER_95_391 VDD VSS sg13g2_fill_1
X_09625_ _14221_/D _09625_/A0 _14221_/Q _09629_/S VDD VSS sg13g2_mux2_1
XFILLER_46_49 VDD VSS sg13g2_decap_8
XFILLER_44_907 VDD VSS sg13g2_fill_1
XFILLER_16_609 VDD VSS sg13g2_decap_8
XFILLER_44_929 VDD VSS sg13g2_decap_8
XFILLER_37_970 VDD VSS sg13g2_decap_8
XFILLER_110_1160 VDD VSS sg13g2_decap_8
XFILLER_15_119 VDD VSS sg13g2_decap_8
XFILLER_70_203 VDD VSS sg13g2_decap_8
XFILLER_110_1171 VDD VSS sg13g2_fill_1
X_09556_ _14154_/D _09622_/A0 _14154_/Q _09566_/S VDD VSS sg13g2_mux2_1
XFILLER_43_428 VDD VSS sg13g2_decap_8
XFILLER_55_299 VDD VSS sg13g2_decap_8
XFILLER_3_1295 VDD VSS sg13g2_decap_8
XFILLER_149_1370 VDD VSS sg13g2_fill_1
X_14060__2119 _14060_/RESET_B VDD VSS sg13g2_tiehi
XFILLER_19_1204 VDD VSS sg13g2_decap_8
X_08507_ _08507_/Y _07818_/Y _08506_/Y _08667_/A1 VDD VSS sg13g2_a21oi_1
XFILLER_52_951 VDD VSS sg13g2_decap_8
XFILLER_169_625 VDD VSS sg13g2_decap_4
X_09487_ _14087_/D _09984_/A0 _14087_/Q _09502_/S VDD VSS sg13g2_mux2_1
XFILLER_93_1166 VDD VSS sg13g2_decap_8
XFILLER_12_826 VDD VSS sg13g2_decap_8
XFILLER_145_1245 VDD VSS sg13g2_decap_8
XFILLER_62_59 VDD VSS sg13g2_fill_1
X_08438_ _08438_/Y _08436_/Y _08437_/Y _08663_/B _08435_/Y VDD VSS sg13g2_a22oi_1
XFILLER_11_336 VDD VSS sg13g2_decap_8
XFILLER_8_819 VDD VSS sg13g2_decap_8
XFILLER_23_196 VDD VSS sg13g2_decap_8
XFILLER_168_168 VDD VSS sg13g2_decap_8
XFILLER_109_202 VDD VSS sg13g2_fill_2
X_14700__1479 _14700_/RESET_B VDD VSS sg13g2_tiehi
X_08369_ _08389_/B _08369_/A _08369_/B VDD VSS sg13g2_nand2_1
XFILLER_7_329 VDD VSS sg13g2_decap_8
XFILLER_165_842 VDD VSS sg13g2_decap_8
X_10400_ _10400_/Y _10400_/A _10400_/B _10400_/C _10400_/D VDD VSS sg13g2_nor4_1
X_11380_ _11380_/Y _11360_/Y _11361_/Y _11379_/Y VDD VSS sg13g2_o21ai_1
XFILLER_139_1005 VDD VSS sg13g2_decap_4
X_10331_ _14803_/D _10331_/A _10331_/B _10334_/C VDD VSS sg13g2_and3_1
XFILLER_152_525 VDD VSS sg13g2_decap_8
XFILLER_164_385 VDD VSS sg13g2_decap_8
XFILLER_118_791 VDD VSS sg13g2_decap_8
XFILLER_11_63 VDD VSS sg13g2_decap_8
X_13050_ _13050_/X _15062_/Q _15061_/Q _13050_/C VDD VSS sg13g2_or3_1
X_10262_ _10262_/Y _10265_/B _10262_/B VDD VSS sg13g2_nor2_1
XFILLER_3_546 VDD VSS sg13g2_decap_8
XFILLER_133_761 VDD VSS sg13g2_decap_8
X_12001_ _12001_/Y _12001_/A _12001_/B VDD VSS sg13g2_nor2_1
Xpicorv32_macro_1421 mem_axi_awprot[1] VDD VSS sg13g2_tielo
XFILLER_79_837 VDD VSS sg13g2_decap_8
XFILLER_65_1257 VDD VSS sg13g2_fill_2
X_10193_ _15197_/D hold3061/X _15197_/Q _13479_/S VDD VSS sg13g2_mux2_1
Xfanout1303 _11741_/A fanout1316/X VDD VSS sg13g2_buf_1
Xfanout1314 _12025_/A _12238_/S0 VDD VSS sg13g2_buf_1
Xfanout1325 _11373_/A _11229_/S0 VDD VSS sg13g2_buf_1
XFILLER_78_347 VDD VSS sg13g2_decap_8
XFILLER_120_444 VDD VSS sg13g2_fill_1
XFILLER_94_807 VDD VSS sg13g2_decap_4
XFILLER_121_978 VDD VSS sg13g2_fill_2
Xfanout1336 _12090_/A _12316_/S0 VDD VSS sg13g2_buf_1
Xfanout1347 _11649_/S0 _11651_/S0 VDD VSS sg13g2_buf_1
Xfanout360 _09334_/S _09338_/S VDD VSS sg13g2_buf_1
Xfanout1358 fanout1358/X fanout1369/X VDD VSS sg13g2_buf_1
XFILLER_8_1162 VDD VSS sg13g2_decap_8
Xfanout371 _09260_/S _09267_/S VDD VSS sg13g2_buf_1
Xfanout1369 fanout1369/X _13657_/Q VDD VSS sg13g2_buf_1
XFILLER_93_317 VDD VSS sg13g2_fill_2
XFILLER_143_62 VDD VSS sg13g2_fill_1
X_14270__1909 _14270_/RESET_B VDD VSS sg13g2_tiehi
Xfanout382 _09914_/A1 _09316_/A0 VDD VSS sg13g2_buf_1
XFILLER_87_881 VDD VSS sg13g2_decap_4
XFILLER_4_1015 VDD VSS sg13g2_decap_8
X_13952_ _13952_/Q _14721_/CLK _13952_/D _13952_/RESET_B VDD VSS sg13g2_dfrbpq_1
Xfanout393 _09609_/A0 _10140_/A1 VDD VSS sg13g2_buf_1
XFILLER_59_594 VDD VSS sg13g2_decap_8
XFILLER_46_211 VDD VSS sg13g2_decap_4
XFILLER_74_531 VDD VSS sg13g2_decap_8
X_12903_ _12904_/B _07683_/A _12902_/Y _12894_/X _12878_/D _12898_/Y VDD VSS sg13g2_a221oi_1
XFILLER_47_767 VDD VSS sg13g2_fill_2
X_13883_ _13883_/Q clkload46/A _13883_/D _13883_/RESET_B VDD VSS sg13g2_dfrbpq_1
XFILLER_19_469 VDD VSS sg13g2_decap_8
X_12834_ _12834_/Y _12835_/A _13691_/Q VDD VSS sg13g2_nor2_1
XFILLER_98_1099 VDD VSS sg13g2_fill_2
XFILLER_37_1315 VDD VSS sg13g2_decap_8
XFILLER_163_1323 VDD VSS sg13g2_decap_8
X_12765_ _12778_/A _12765_/A1 _12765_/A2 _15019_/Q VDD VSS sg13g2_a21oi_1
X_14036__2143 _14036_/RESET_B VDD VSS sg13g2_tiehi
XFILLER_72_1206 VDD VSS sg13g2_decap_8
XFILLER_72_1228 VDD VSS sg13g2_decap_8
XFILLER_15_686 VDD VSS sg13g2_decap_8
X_14504_ _14504_/Q _14644_/CLK _14504_/D _14504_/RESET_B VDD VSS sg13g2_dfrbpq_1
X_11716_ _11717_/B _11708_/X _11709_/X _11712_/X _11713_/X _12290_/S0 _12290_/S1 VDD
+ VSS sg13g2_mux4_1
XFILLER_124_1329 VDD VSS sg13g2_decap_8
X_12696_ _12696_/X _14132_/Q _14164_/Q _14196_/Q _14228_/Q _12785_/S0 _12785_/S1 VDD
+ VSS sg13g2_mux4_1
XFILLER_14_196 VDD VSS sg13g2_decap_8
XFILLER_159_168 VDD VSS sg13g2_decap_8
X_14435_ _14435_/Q clkload19/A _14435_/D _14435_/RESET_B VDD VSS sg13g2_dfrbpq_1
X_11647_ _11647_/X _13735_/Q _14087_/Q _14439_/Q _14535_/Q _11651_/S0 _11651_/S1 VDD
+ VSS sg13g2_mux4_1
XFILLER_168_691 VDD VSS sg13g2_decap_8
Xinput13 input13/X input13/A VDD VSS sg13g2_buf_1
XFILLER_156_842 VDD VSS sg13g2_fill_1
XFILLER_168_70 VDD VSS sg13g2_decap_8
Xinput24 input24/X input24/A VDD VSS sg13g2_buf_1
X_14366_ _14366_/Q clkload38/A _14366_/D _14366_/RESET_B VDD VSS sg13g2_dfrbpq_1
Xinput35 input35/X input35/A VDD VSS sg13g2_buf_1
X_11578_ _11578_/X _13957_/Q _13989_/Q _14021_/Q _14053_/Q _11997_/S0 _11997_/S1 VDD
+ VSS sg13g2_mux4_1
XFILLER_128_566 VDD VSS sg13g2_decap_8
X_13317_ _15062_/D _15078_/Q _07694_/Y _13316_/X VDD VSS sg13g2_a21o_1
X_10529_ _14858_/D _10529_/A _10529_/B _10535_/C VDD VSS sg13g2_and3_1
X_14297_ _14297_/Q _14745_/CLK _14297_/D _14297_/RESET_B VDD VSS sg13g2_dfrbpq_1
XFILLER_7_896 VDD VSS sg13g2_decap_8
XFILLER_109_791 VDD VSS sg13g2_decap_8
XFILLER_143_536 VDD VSS sg13g2_decap_8
XFILLER_157_1127 VDD VSS sg13g2_fill_2
XFILLER_170_322 VDD VSS sg13g2_decap_8
XFILLER_171_856 VDD VSS sg13g2_fill_2
Xclkbuf_5_22__f_clk_i clkbuf_leaf_88_clk_i/A clkbuf_4_11_0_clk_i/X VDD VSS sg13g2_buf_16
X_13248_ _13251_/A _14796_/Q _13248_/B VDD VSS sg13g2_nand2_1
XFILLER_83_1335 VDD VSS sg13g2_decap_8
XFILLER_170_399 VDD VSS sg13g2_decap_8
X_13179_ _13179_/Y _14855_/Q _13234_/B VDD VSS sg13g2_nand2_1
X_15008__2579 _15008_/RESET_B VDD VSS sg13g2_tiehi
XFILLER_96_111 VDD VSS sg13g2_fill_1
XFILLER_170_1327 VDD VSS sg13g2_decap_8
XFILLER_97_645 VDD VSS sg13g2_decap_8
XFILLER_123_293 VDD VSS sg13g2_decap_4
XFILLER_96_133 VDD VSS sg13g2_decap_8
XFILLER_96_144 VDD VSS sg13g2_fill_1
XFILLER_97_678 VDD VSS sg13g2_fill_2
XFILLER_42_1010 VDD VSS sg13g2_fill_1
XFILLER_85_829 VDD VSS sg13g2_decap_8
XFILLER_38_701 VDD VSS sg13g2_decap_8
X_07740_ _07740_/Y _07740_/A _11243_/C VDD VSS sg13g2_nand2_1
XFILLER_81_1092 VDD VSS sg13g2_decap_8
XFILLER_96_199 VDD VSS sg13g2_decap_8
X_14246__1933 _14246_/RESET_B VDD VSS sg13g2_tiehi
XFILLER_38_756 VDD VSS sg13g2_decap_8
X_07671_ _13281_/C _07665_/X _07670_/Y _07667_/Y VDD VSS sg13g2_a21oi_1
X_16869_ _16869_/X _16869_/A VDD VSS sg13g2_buf_1
XFILLER_92_350 VDD VSS sg13g2_decap_8
XFILLER_77_1117 VDD VSS sg13g2_decap_8
XFILLER_20_1330 VDD VSS sg13g2_decap_8
X_09410_ _14012_/D _09608_/A0 _14012_/Q _09434_/S VDD VSS sg13g2_mux2_1
XFILLER_168_1256 VDD VSS sg13g2_decap_8
XFILLER_25_428 VDD VSS sg13g2_decap_8
XFILLER_92_383 VDD VSS sg13g2_fill_2
XFILLER_53_748 VDD VSS sg13g2_fill_1
XFILLER_80_545 VDD VSS sg13g2_decap_8
X_09341_ _09441_/D _10037_/A _09606_/C VDD VSS sg13g2_nor2b_1
XFILLER_34_973 VDD VSS sg13g2_decap_8
XFILLER_90_1317 VDD VSS sg13g2_decap_8
X_09272_ _13881_/D _13881_/Q _09338_/A0 _09272_/S VDD VSS sg13g2_mux2_1
XFILLER_21_623 VDD VSS sg13g2_decap_8
XFILLER_138_308 VDD VSS sg13g2_decap_8
X_08223_ _08223_/X _08119_/X _08128_/X _08223_/S VDD VSS sg13g2_mux2_1
XFILLER_20_133 VDD VSS sg13g2_decap_8
XFILLER_165_105 VDD VSS sg13g2_decap_8
XFILLER_18_1281 VDD VSS sg13g2_decap_8
XFILLER_140_1120 VDD VSS sg13g2_fill_2
XFILLER_14_1134 VDD VSS sg13g2_decap_8
X_08154_ _08154_/Y _08154_/A _08174_/A _08659_/B _08484_/C VDD VSS sg13g2_nor4_1
XFILLER_140_1164 VDD VSS sg13g2_decap_8
XFILLER_101_1137 VDD VSS sg13g2_fill_2
XFILLER_88_1246 VDD VSS sg13g2_decap_8
X_13734__2445 _13734_/RESET_B VDD VSS sg13g2_tiehi
X_08085_ _08270_/C _08085_/A _08194_/B VDD VSS sg13g2_nand2_1
XFILLER_134_525 VDD VSS sg13g2_decap_8
X_14494__1685 _14494_/RESET_B VDD VSS sg13g2_tiehi
XFILLER_49_1219 VDD VSS sg13g2_decap_8
XFILLER_173_171 VDD VSS sg13g2_decap_4
XFILLER_164_28 VDD VSS sg13g2_decap_8
XFILLER_103_901 VDD VSS sg13g2_fill_1
XFILLER_161_366 VDD VSS sg13g2_decap_8
XFILLER_162_889 VDD VSS sg13g2_decap_8
XFILLER_114_293 VDD VSS sg13g2_fill_2
XFILLER_88_656 VDD VSS sg13g2_decap_8
XFILLER_102_444 VDD VSS sg13g2_decap_4
X_14114__2065 _14114_/RESET_B VDD VSS sg13g2_tiehi
XFILLER_103_989 VDD VSS sg13g2_decap_8
X_08987_ _08988_/C _12859_/A _10681_/A _10674_/A VDD VSS sg13g2_and3_1
XFILLER_5_1302 VDD VSS sg13g2_decap_8
X_07938_ _07938_/Y _07797_/D _07935_/Y _07937_/Y VDD VSS sg13g2_o21ai_1
XFILLER_25_1274 VDD VSS sg13g2_decap_8
XFILLER_56_531 VDD VSS sg13g2_decap_8
XFILLER_113_21 VDD VSS sg13g2_decap_8
XFILLER_151_1293 VDD VSS sg13g2_decap_4
XFILLER_21_1127 VDD VSS sg13g2_decap_8
XFILLER_112_1266 VDD VSS sg13g2_decap_8
X_07869_ _07869_/X _11428_/A _08201_/A VDD VSS sg13g2_or2_1
XFILLER_60_1198 VDD VSS sg13g2_decap_4
XFILLER_16_406 VDD VSS sg13g2_decap_8
XFILLER_44_715 VDD VSS sg13g2_decap_8
XFILLER_73_14 VDD VSS sg13g2_decap_8
XFILLER_56_586 VDD VSS sg13g2_fill_2
X_09608_ _14204_/D _09608_/A0 _14204_/Q _09632_/S VDD VSS sg13g2_mux2_1
X_15043__2539 _15043_/RESET_B VDD VSS sg13g2_tiehi
X_10880_ _10880_/Y _10897_/A _14754_/Q VDD VSS sg13g2_nor2b_1
XFILLER_3_1092 VDD VSS sg13g2_decap_8
X_13982__2197 _13982_/RESET_B VDD VSS sg13g2_tiehi
XFILLER_19_1001 VDD VSS sg13g2_decap_8
X_09539_ _14138_/D _09970_/A1 _14138_/Q _09539_/S VDD VSS sg13g2_mux2_1
XFILLER_58_1072 VDD VSS sg13g2_decap_8
XFILLER_12_623 VDD VSS sg13g2_decap_8
X_12550_ _12550_/X _13961_/Q _13993_/Q _14025_/Q _14057_/Q _12767_/S0 _12767_/S1 VDD
+ VSS sg13g2_mux4_1
XFILLER_145_1053 VDD VSS sg13g2_fill_1
XFILLER_169_455 VDD VSS sg13g2_decap_8
XFILLER_106_1015 VDD VSS sg13g2_decap_8
XFILLER_19_1078 VDD VSS sg13g2_decap_8
XFILLER_11_133 VDD VSS sg13g2_decap_8
X_11501_ _14964_/D _11483_/A _11501_/A2 _11500_/Y VDD VSS sg13g2_a21o_1
XFILLER_156_105 VDD VSS sg13g2_decap_8
XFILLER_8_616 VDD VSS sg13g2_decap_8
X_12481_ _12481_/X _12478_/X _12477_/X _12474_/X _12473_/X _12760_/S0 _12692_/S VDD
+ VSS sg13g2_mux4_1
XFILLER_138_831 VDD VSS sg13g2_fill_1
X_14220_ _14220_/Q clkload13/A _14220_/D _14220_/RESET_B VDD VSS sg13g2_dfrbpq_1
XFILLER_7_126 VDD VSS sg13g2_decap_8
X_11432_ _14961_/D _11428_/A _11248_/B _11431_/Y VDD VSS sg13g2_a21o_1
XFILLER_32_1267 VDD VSS sg13g2_decap_8
XFILLER_22_84 VDD VSS sg13g2_decap_8
XFILLER_118_0 VDD VSS sg13g2_decap_8
X_14151_ _14151_/Q _14735_/CLK _14151_/D _14151_/RESET_B VDD VSS sg13g2_dfrbpq_1
XFILLER_171_119 VDD VSS sg13g2_decap_8
X_11363_ _11363_/Y _11373_/A _14398_/Q _11366_/C VDD VSS sg13g2_a21oi_1
X_14324__1855 _14324_/RESET_B VDD VSS sg13g2_tiehi
XFILLER_164_182 VDD VSS sg13g2_decap_8
XFILLER_4_833 VDD VSS sg13g2_decap_8
X_13102_ _13104_/A _14913_/Q _13674_/Q VDD VSS sg13g2_xor2_1
XFILLER_125_558 VDD VSS sg13g2_decap_4
X_10314_ _10400_/A _14796_/Q _14797_/Q _10342_/A _10327_/B VDD VSS sg13g2_nand4_1
X_14082_ _14082_/Q clkload30/A _14082_/D _14082_/RESET_B VDD VSS sg13g2_dfrbpq_1
XFILLER_140_506 VDD VSS sg13g2_fill_2
X_11294_ _14958_/D _13602_/A _11341_/A2 _11293_/Y VDD VSS sg13g2_a21o_1
XFILLER_98_66 VDD VSS sg13g2_fill_1
XFILLER_3_343 VDD VSS sg13g2_decap_8
XFILLER_0_0 VDD VSS sg13g2_decap_8
XFILLER_98_88 VDD VSS sg13g2_fill_2
X_13033_ _13033_/Y input27/X _12997_/Y _12937_/Y VDD VSS sg13g2_o21ai_1
XFILLER_156_1160 VDD VSS sg13g2_fill_1
X_10245_ _14776_/D _10245_/A _10572_/B _10245_/C VDD VSS sg13g2_nor3_1
XFILLER_65_1043 VDD VSS sg13g2_fill_2
XFILLER_121_720 VDD VSS sg13g2_fill_1
Xfanout1100 _12128_/A _14983_/Q VDD VSS sg13g2_buf_1
XFILLER_79_645 VDD VSS sg13g2_decap_8
XFILLER_105_293 VDD VSS sg13g2_decap_4
Xfanout1111 _08591_/A3 _11983_/A VDD VSS sg13g2_buf_1
XFILLER_152_1035 VDD VSS sg13g2_decap_4
Xfanout1122 _11865_/A _14976_/Q VDD VSS sg13g2_buf_1
X_10176_ _10176_/Y _13613_/B _10174_/Y _10175_/Y VDD VSS sg13g2_a21oi_1
XFILLER_65_1087 VDD VSS sg13g2_decap_8
Xfanout1133 _11726_/A _14972_/Q VDD VSS sg13g2_buf_1
XFILLER_26_1049 VDD VSS sg13g2_decap_8
Xfanout1144 _08306_/C _14968_/Q VDD VSS sg13g2_buf_1
Xfanout1155 _11483_/A _08860_/A1 VDD VSS sg13g2_buf_1
Xfanout1166 _11384_/A _14960_/Q VDD VSS sg13g2_buf_1
X_14984_ _14984_/Q _14984_/CLK _14984_/D _14984_/RESET_B VDD VSS sg13g2_dfrbpq_1
Xfanout1177 _07903_/B _11249_/A VDD VSS sg13g2_buf_1
XFILLER_94_648 VDD VSS sg13g2_decap_8
XFILLER_43_1363 VDD VSS sg13g2_fill_1
Xfanout190 _10160_/A1 fanout191/X VDD VSS sg13g2_buf_1
Xfanout1188 _12957_/A _14904_/Q VDD VSS sg13g2_buf_1
XFILLER_93_136 VDD VSS sg13g2_decap_8
XFILLER_59_380 VDD VSS sg13g2_fill_2
Xfanout1199 _10558_/C _14857_/Q VDD VSS sg13g2_buf_1
XFILLER_130_1355 VDD VSS sg13g2_fill_1
X_13935_ _13935_/Q _14703_/CLK _13935_/D _13935_/RESET_B VDD VSS sg13g2_dfrbpq_1
XFILLER_47_70 VDD VSS sg13g2_fill_2
X_14793__2920 _14793_/RESET_B VDD VSS sg13g2_tiehi
XFILLER_74_361 VDD VSS sg13g2_fill_1
XFILLER_19_266 VDD VSS sg13g2_decap_8
X_13866_ _13866_/Q _14730_/CLK _13866_/D _13866_/RESET_B VDD VSS sg13g2_dfrbpq_1
X_12817_ _12817_/Y _14864_/Q _12895_/B VDD VSS sg13g2_nand2_1
X_13812__2367 _13812_/RESET_B VDD VSS sg13g2_tiehi
XFILLER_37_1101 VDD VSS sg13g2_fill_1
XFILLER_16_973 VDD VSS sg13g2_decap_8
XFILLER_50_718 VDD VSS sg13g2_fill_2
X_13797_ _13797_/Q clkload6/A _13797_/D _13797_/RESET_B VDD VSS sg13g2_dfrbpq_1
XFILLER_62_589 VDD VSS sg13g2_decap_8
XFILLER_128_1251 VDD VSS sg13g2_fill_1
XFILLER_31_921 VDD VSS sg13g2_decap_8
XFILLER_15_483 VDD VSS sg13g2_decap_8
XFILLER_37_1145 VDD VSS sg13g2_decap_8
X_12748_ _12748_/X _12746_/X _12747_/X _12790_/S VDD VSS sg13g2_mux2_1
XFILLER_124_1115 VDD VSS sg13g2_decap_8
X_12679_ _12680_/B _13670_/Q _12707_/A2 _12678_/X _12679_/B2 _12707_/C1 VDD VSS sg13g2_a221oi_1
XFILLER_8_42 VDD VSS sg13g2_decap_8
X_14418_ _14418_/Q _14706_/CLK _14418_/D _14418_/RESET_B VDD VSS sg13g2_dfrbpq_1
XFILLER_129_897 VDD VSS sg13g2_decap_8
XFILLER_162_119 VDD VSS sg13g2_decap_8
XFILLER_156_683 VDD VSS sg13g2_fill_2
X_14349_ _14349_/Q clkload10/A _14349_/D _14349_/RESET_B VDD VSS sg13g2_dfrbpq_1
XFILLER_144_834 VDD VSS sg13g2_decap_8
XFILLER_143_322 VDD VSS sg13g2_fill_1
XFILLER_7_693 VDD VSS sg13g2_decap_8
XFILLER_143_333 VDD VSS sg13g2_decap_8
XFILLER_171_642 VDD VSS sg13g2_decap_8
XFILLER_144_867 VDD VSS sg13g2_fill_1
XFILLER_143_344 VDD VSS sg13g2_fill_2
XFILLER_98_910 VDD VSS sg13g2_decap_4
XFILLER_83_1121 VDD VSS sg13g2_fill_1
XFILLER_103_219 VDD VSS sg13g2_decap_8
X_08910_ _08910_/Y _13608_/A1 _08835_/B _16872_/A VDD VSS sg13g2_a21oi_1
X_09890_ _14476_/D _09923_/A1 _14476_/Q _09892_/S VDD VSS sg13g2_mux2_1
XFILLER_174_1260 VDD VSS sg13g2_decap_8
XFILLER_112_731 VDD VSS sg13g2_decap_8
XFILLER_170_196 VDD VSS sg13g2_decap_8
XFILLER_174_1271 VDD VSS sg13g2_decap_8
XFILLER_33_0 VDD VSS sg13g2_decap_8
XFILLER_112_753 VDD VSS sg13g2_fill_1
X_08841_ _08841_/Y _08860_/S _08840_/Y _08836_/Y VDD VSS sg13g2_o21ai_1
X_14479__1700 _14479_/RESET_B VDD VSS sg13g2_tiehi
XFILLER_44_1149 VDD VSS sg13g2_fill_1
XFILLER_69_166 VDD VSS sg13g2_decap_8
X_08772_ _08772_/Y _13676_/Q _08775_/B VDD VSS sg13g2_nor2_1
X_07723_ _07726_/B _13427_/C _15095_/Q _15091_/Q _15090_/Q VDD VSS sg13g2_nor4_1
XFILLER_72_309 VDD VSS sg13g2_fill_1
XFILLER_66_884 VDD VSS sg13g2_decap_8
XFILLER_38_586 VDD VSS sg13g2_fill_1
XFILLER_25_203 VDD VSS sg13g2_decap_8
X_07654_ _07654_/Y _07654_/A VDD VSS sg13g2_inv_1
XFILLER_26_759 VDD VSS sg13g2_decap_8
XFILLER_168_1086 VDD VSS sg13g2_decap_8
XFILLER_94_1250 VDD VSS sg13g2_fill_2
XFILLER_0_1276 VDD VSS sg13g2_decap_8
XFILLER_55_1212 VDD VSS sg13g2_decap_8
X_14402__1777 _14402_/RESET_B VDD VSS sg13g2_tiehi
XFILLER_90_1103 VDD VSS sg13g2_decap_8
XFILLER_43_28 VDD VSS sg13g2_decap_8
XFILLER_146_1351 VDD VSS sg13g2_fill_1
X_09324_ _13931_/D _09922_/A1 _13931_/Q _09330_/S VDD VSS sg13g2_mux2_1
XFILLER_80_397 VDD VSS sg13g2_decap_8
XFILLER_159_28 VDD VSS sg13g2_decap_8
XFILLER_22_943 VDD VSS sg13g2_fill_2
XFILLER_21_420 VDD VSS sg13g2_decap_8
XFILLER_16_1218 VDD VSS sg13g2_decap_8
XFILLER_167_937 VDD VSS sg13g2_decap_8
XFILLER_22_976 VDD VSS sg13g2_decap_8
XFILLER_142_1237 VDD VSS sg13g2_fill_2
X_09255_ _13864_/D _13864_/Q _09919_/A1 _09264_/S VDD VSS sg13g2_mux2_1
X_08206_ _08211_/B _15104_/Q _15091_/Q _08247_/A VDD VSS sg13g2_o21ai_1
XFILLER_154_609 VDD VSS sg13g2_decap_8
X_13967__2212 _13967_/RESET_B VDD VSS sg13g2_tiehi
XFILLER_21_497 VDD VSS sg13g2_decap_8
XFILLER_166_469 VDD VSS sg13g2_decap_8
X_09186_ _13802_/D _13802_/Q _10153_/A1 _09189_/S VDD VSS sg13g2_mux2_1
XFILLER_153_119 VDD VSS sg13g2_decap_8
XFILLER_135_823 VDD VSS sg13g2_decap_4
X_08137_ _08138_/A _08142_/C _07879_/A _08137_/A2 _11249_/A _08137_/S0 _08207_/S1
+ VDD VSS sg13g2_mux4_1
XFILLER_111_7 VDD VSS sg13g2_decap_8
XFILLER_107_536 VDD VSS sg13g2_fill_1
XFILLER_162_631 VDD VSS sg13g2_decap_8
X_14863__2818 _14863_/RESET_B VDD VSS sg13g2_tiehi
XFILLER_107_558 VDD VSS sg13g2_decap_8
X_08068_ _08068_/Y _08029_/Y _08066_/Y _08256_/A _08340_/A _08067_/Y VDD VSS sg13g2_a221oi_1
XFILLER_134_377 VDD VSS sg13g2_decap_8
XFILLER_89_921 VDD VSS sg13g2_fill_2
XFILLER_68_14 VDD VSS sg13g2_decap_8
XFILLER_150_837 VDD VSS sg13g2_decap_8
Xclkbuf_4_0_0_clk_i clkbuf_4_0_0_clk_i/X clkbuf_0_clk_i/X VDD VSS sg13g2_buf_8
XFILLER_1_847 VDD VSS sg13g2_decap_8
XFILLER_161_196 VDD VSS sg13g2_decap_8
X_10030_ _14612_/D _10096_/A0 _14612_/Q _10030_/S VDD VSS sg13g2_mux2_1
XFILLER_102_230 VDD VSS sg13g2_decap_8
XFILLER_89_976 VDD VSS sg13g2_decap_8
XFILLER_0_357 VDD VSS sg13g2_decap_8
XFILLER_49_829 VDD VSS sg13g2_fill_2
XFILLER_27_1369 VDD VSS sg13g2_decap_8
XFILLER_130_572 VDD VSS sg13g2_decap_4
XFILLER_48_317 VDD VSS sg13g2_decap_8
XFILLER_124_42 VDD VSS sg13g2_decap_8
XFILLER_102_296 VDD VSS sg13g2_decap_8
XFILLER_25_1071 VDD VSS sg13g2_decap_8
XFILLER_84_35 VDD VSS sg13g2_decap_8
XFILLER_57_862 VDD VSS sg13g2_fill_2
X_11981_ _12012_/A _11983_/A _13671_/Q VDD VSS sg13g2_nand2_1
X_14947__2650 _14947_/RESET_B VDD VSS sg13g2_tiehi
XFILLER_91_629 VDD VSS sg13g2_fill_1
XFILLER_90_106 VDD VSS sg13g2_decap_8
XFILLER_5_1176 VDD VSS sg13g2_decap_8
XFILLER_99_1172 VDD VSS sg13g2_fill_1
XFILLER_16_203 VDD VSS sg13g2_decap_8
X_13720_ _16882_/A clkload54/A _13720_/D _13720_/RESET_B VDD VSS sg13g2_dfrbpq_1
XFILLER_72_821 VDD VSS sg13g2_decap_8
XFILLER_1_1029 VDD VSS sg13g2_decap_8
X_10932_ _10948_/D _10946_/B _10932_/B VDD VSS sg13g2_nand2_1
XFILLER_90_128 VDD VSS sg13g2_decap_8
X_13651_ _15117_/D _15186_/D _15117_/Q _13652_/S VDD VSS sg13g2_mux2_1
XFILLER_95_1069 VDD VSS sg13g2_decap_8
XFILLER_17_84 VDD VSS sg13g2_decap_8
X_10863_ _10863_/X _10871_/A _14753_/Q VDD VSS sg13g2_and2_1
XFILLER_13_910 VDD VSS sg13g2_decap_8
XFILLER_32_729 VDD VSS sg13g2_decap_8
XFILLER_25_770 VDD VSS sg13g2_decap_8
X_12602_ _12602_/X _13965_/Q _13997_/Q _14029_/Q _14061_/Q _12660_/S0 _12660_/S1 VDD
+ VSS sg13g2_mux4_1
XFILLER_73_1334 VDD VSS sg13g2_decap_8
XFILLER_12_420 VDD VSS sg13g2_decap_8
X_13582_ _15159_/D _13584_/B _13580_/Y _13581_/Y VDD VSS sg13g2_a21oi_1
X_10794_ _11205_/A _14956_/Q _10794_/A2 _10793_/X VDD VSS sg13g2_a21oi_1
XFILLER_9_903 VDD VSS sg13g2_decap_8
XFILLER_24_280 VDD VSS sg13g2_decap_8
XFILLER_169_252 VDD VSS sg13g2_decap_8
XFILLER_34_1318 VDD VSS sg13g2_decap_8
XFILLER_73_1378 VDD VSS sg13g2_fill_2
X_12533_ _12533_/X _14568_/Q _14600_/Q _14632_/Q _14664_/Q _12674_/S0 _12674_/S1 VDD
+ VSS sg13g2_mux4_1
XFILLER_40_762 VDD VSS sg13g2_fill_1
XFILLER_13_987 VDD VSS sg13g2_decap_8
XFILLER_8_413 VDD VSS sg13g2_decap_8
XFILLER_173_907 VDD VSS sg13g2_decap_8
XFILLER_12_497 VDD VSS sg13g2_decap_8
XFILLER_71_1080 VDD VSS sg13g2_fill_1
X_12464_ _12464_/X _13731_/Q _14083_/Q _14435_/Q _14531_/Q _12546_/S0 _12546_/S1 VDD
+ VSS sg13g2_mux4_1
X_14557__1622 _14557_/RESET_B VDD VSS sg13g2_tiehi
XFILLER_71_1091 VDD VSS sg13g2_decap_8
X_14203_ _14203_/Q clkload46/A _14203_/D _14203_/RESET_B VDD VSS sg13g2_dfrbpq_1
XFILLER_166_992 VDD VSS sg13g2_decap_8
X_11415_ _11415_/X _14111_/Q _14143_/Q _11418_/A VDD VSS sg13g2_mux2_1
XFILLER_32_1075 VDD VSS sg13g2_decap_8
XFILLER_172_428 VDD VSS sg13g2_decap_8
XFILLER_126_834 VDD VSS sg13g2_decap_4
X_15183_ _15183_/Q _15183_/CLK _15183_/D _15183_/RESET_B VDD VSS sg13g2_dfrbpq_1
X_12395_ _12395_/X _14366_/Q _14398_/Q _14462_/Q _14494_/Q _12396_/S0 _12396_/S1 VDD
+ VSS sg13g2_mux4_1
XFILLER_67_1105 VDD VSS sg13g2_decap_8
XFILLER_126_856 VDD VSS sg13g2_decap_8
XFILLER_4_630 VDD VSS sg13g2_decap_8
XFILLER_125_344 VDD VSS sg13g2_decap_8
X_14134_ _14134_/Q clkload26/A _14134_/D _14134_/RESET_B VDD VSS sg13g2_dfrbpq_1
XFILLER_10_1351 VDD VSS sg13g2_decap_8
X_11346_ _11346_/Y _11342_/Y _11343_/Y _11345_/Y _11344_/Y _11881_/C1 VDD VSS sg13g2_a221oi_1
XFILLER_3_140 VDD VSS sg13g2_decap_8
XFILLER_98_217 VDD VSS sg13g2_decap_8
XFILLER_140_314 VDD VSS sg13g2_decap_8
XFILLER_152_174 VDD VSS sg13g2_decap_8
XFILLER_141_848 VDD VSS sg13g2_decap_8
X_14065_ _14065_/Q clkload0/A _14065_/D _14065_/RESET_B VDD VSS sg13g2_dfrbpq_1
X_11277_ _11277_/X _14108_/Q _14140_/Q _11277_/S VDD VSS sg13g2_mux2_1
XFILLER_80_1305 VDD VSS sg13g2_decap_4
X_13016_ _13016_/Y _13013_/Y _13014_/Y _13015_/Y VDD VSS sg13g2_a21oi_1
X_10228_ _10228_/Y _10237_/A _10237_/C _10441_/C VDD VSS sg13g2_o21ai_1
XFILLER_39_306 VDD VSS sg13g2_decap_8
XFILLER_95_935 VDD VSS sg13g2_decap_8
XFILLER_39_317 VDD VSS sg13g2_fill_1
XFILLER_94_412 VDD VSS sg13g2_decap_8
XFILLER_121_583 VDD VSS sg13g2_fill_2
XFILLER_0_891 VDD VSS sg13g2_decap_8
X_10159_ _14736_/D _14736_/Q _10159_/A1 _10160_/S VDD VSS sg13g2_mux2_1
XFILLER_39_339 VDD VSS sg13g2_decap_8
XFILLER_66_147 VDD VSS sg13g2_fill_2
X_14967_ _14967_/Q _15015_/CLK _14967_/D _14967_/RESET_B VDD VSS sg13g2_dfrbpq_1
XFILLER_63_821 VDD VSS sg13g2_fill_1
X_13918_ _13918_/Q clkload38/A _13918_/D _13918_/RESET_B VDD VSS sg13g2_dfrbpq_1
XFILLER_78_1245 VDD VSS sg13g2_decap_8
XFILLER_169_1373 VDD VSS sg13g2_fill_2
X_14898_ _14898_/Q clkload61/A _14898_/D _14898_/RESET_B VDD VSS sg13g2_dfrbpq_1
XFILLER_63_854 VDD VSS sg13g2_decap_4
XFILLER_39_1218 VDD VSS sg13g2_fill_1
XFILLER_35_556 VDD VSS sg13g2_fill_2
X_13849_ _13849_/Q _14745_/CLK _13849_/D _13849_/RESET_B VDD VSS sg13g2_dfrbpq_1
XFILLER_63_887 VDD VSS sg13g2_fill_1
XFILLER_16_770 VDD VSS sg13g2_decap_8
XFILLER_90_695 VDD VSS sg13g2_decap_8
XFILLER_22_217 VDD VSS sg13g2_decap_8
XFILLER_50_537 VDD VSS sg13g2_decap_4
XFILLER_15_280 VDD VSS sg13g2_decap_8
XFILLER_128_1070 VDD VSS sg13g2_fill_2
XFILLER_31_740 VDD VSS sg13g2_fill_1
XFILLER_31_751 VDD VSS sg13g2_decap_8
X_14196__1983 _14196_/RESET_B VDD VSS sg13g2_tiehi
X_09040_ _10716_/B _09100_/B _15034_/Q _09039_/Y VDD VSS sg13g2_o21ai_1
XFILLER_50_1120 VDD VSS sg13g2_fill_1
XFILLER_163_406 VDD VSS sg13g2_decap_8
XFILLER_102_1221 VDD VSS sg13g2_decap_4
XFILLER_129_672 VDD VSS sg13g2_fill_1
XFILLER_15_1295 VDD VSS sg13g2_decap_8
XFILLER_8_980 VDD VSS sg13g2_decap_8
XFILLER_89_1352 VDD VSS sg13g2_fill_1
XFILLER_11_1148 VDD VSS sg13g2_decap_8
XFILLER_172_951 VDD VSS sg13g2_fill_2
XFILLER_7_490 VDD VSS sg13g2_decap_8
XFILLER_132_815 VDD VSS sg13g2_decap_8
XFILLER_104_517 VDD VSS sg13g2_fill_1
X_09942_ _14526_/D _14526_/Q _10074_/A0 _09968_/S VDD VSS sg13g2_mux2_1
Xfanout904 _11243_/C _13289_/C VDD VSS sg13g2_buf_1
Xfanout915 _07737_/B _12542_/A2 VDD VSS sg13g2_buf_1
XFILLER_48_1071 VDD VSS sg13g2_decap_8
Xfanout926 _13533_/B _13566_/C VDD VSS sg13g2_buf_1
XFILLER_98_762 VDD VSS sg13g2_fill_2
XFILLER_86_902 VDD VSS sg13g2_decap_8
Xfanout937 _13389_/B _10201_/A1 VDD VSS sg13g2_buf_1
X_09873_ _14459_/D _09906_/A1 _14459_/Q _09898_/S VDD VSS sg13g2_mux2_1
XFILLER_58_604 VDD VSS sg13g2_decap_8
Xfanout948 _13162_/B1 _13013_/B VDD VSS sg13g2_buf_1
XFILLER_140_881 VDD VSS sg13g2_decap_8
Xfanout959 _13068_/B _13051_/B VDD VSS sg13g2_buf_1
XFILLER_58_626 VDD VSS sg13g2_decap_8
XFILLER_38_28 VDD VSS sg13g2_decap_8
XFILLER_100_723 VDD VSS sg13g2_fill_2
XFILLER_112_583 VDD VSS sg13g2_decap_8
XFILLER_140_892 VDD VSS sg13g2_fill_2
X_08824_ _08824_/Y _13482_/A _15190_/Q VDD VSS sg13g2_nand2_1
XFILLER_86_946 VDD VSS sg13g2_decap_8
XFILLER_86_968 VDD VSS sg13g2_fill_1
XFILLER_57_136 VDD VSS sg13g2_fill_1
XFILLER_39_840 VDD VSS sg13g2_fill_1
XFILLER_73_607 VDD VSS sg13g2_fill_1
XFILLER_22_1233 VDD VSS sg13g2_decap_8
X_08755_ _08755_/Y _13670_/Q _08761_/B VDD VSS sg13g2_nor2_1
XFILLER_73_629 VDD VSS sg13g2_decap_8
XFILLER_2_1316 VDD VSS sg13g2_decap_8
XFILLER_85_489 VDD VSS sg13g2_fill_2
XFILLER_113_1383 VDD VSS sg13g2_fill_1
XFILLER_39_895 VDD VSS sg13g2_decap_8
X_07706_ _07708_/B _13602_/A _15201_/Q _13601_/A VDD VSS sg13g2_a21oi_1
XFILLER_26_523 VDD VSS sg13g2_decap_4
X_14635__1544 _14635_/RESET_B VDD VSS sg13g2_tiehi
X_08686_ _08686_/X _08692_/B _08673_/B _08653_/B _08686_/A3 _08686_/S0 _08686_/S1
+ VDD VSS sg13g2_mux4_1
XFILLER_53_320 VDD VSS sg13g2_decap_4
XFILLER_65_191 VDD VSS sg13g2_decap_4
XFILLER_14_707 VDD VSS sg13g2_decap_8
XFILLER_54_49 VDD VSS sg13g2_fill_2
X_07637_ _10237_/A _14771_/Q VDD VSS sg13g2_inv_1
XFILLER_0_1073 VDD VSS sg13g2_decap_8
XFILLER_13_217 VDD VSS sg13g2_decap_8
XFILLER_159_7 VDD VSS sg13g2_decap_8
XFILLER_41_548 VDD VSS sg13g2_decap_8
XFILLER_55_1053 VDD VSS sg13g2_decap_8
XFILLER_139_414 VDD VSS sg13g2_decap_8
XFILLER_16_1015 VDD VSS sg13g2_decap_8
X_09307_ _09339_/S _09938_/D _09307_/B VDD VSS sg13g2_or2_1
XFILLER_142_1034 VDD VSS sg13g2_fill_1
XFILLER_22_773 VDD VSS sg13g2_decap_8
XFILLER_10_924 VDD VSS sg13g2_decap_8
XFILLER_22_784 VDD VSS sg13g2_fill_2
X_09238_ _13849_/D _09338_/A0 _13849_/Q _09238_/S VDD VSS sg13g2_mux2_1
XFILLER_33_1351 VDD VSS sg13g2_decap_8
XFILLER_21_294 VDD VSS sg13g2_decap_8
XFILLER_166_266 VDD VSS sg13g2_decap_8
XFILLER_6_917 VDD VSS sg13g2_decap_8
X_15003__2584 _15003_/RESET_B VDD VSS sg13g2_tiehi
XFILLER_126_119 VDD VSS sg13g2_decap_4
X_09169_ _09938_/D _09441_/A _09806_/B _09441_/C VDD VSS sg13g2_nand3_1
XFILLER_5_427 VDD VSS sg13g2_decap_8
XFILLER_107_322 VDD VSS sg13g2_decap_8
XFILLER_163_940 VDD VSS sg13g2_fill_2
XFILLER_107_333 VDD VSS sg13g2_fill_2
X_11200_ _11201_/B _10785_/Y _11185_/B _11171_/B VDD VSS sg13g2_o21ai_1
X_12180_ _12181_/A _14262_/Q _14294_/Q _14326_/Q _14358_/Q _12212_/S0 _12212_/S1 VDD
+ VSS sg13g2_mux4_1
XFILLER_79_35 VDD VSS sg13g2_decap_8
XFILLER_108_889 VDD VSS sg13g2_decap_8
XFILLER_123_815 VDD VSS sg13g2_fill_2
XFILLER_79_68 VDD VSS sg13g2_decap_8
X_11131_ _11131_/Y _11109_/B _10769_/X _11154_/B1 VDD VSS sg13g2_o21ai_1
XFILLER_1_644 VDD VSS sg13g2_decap_8
X_11062_ _11062_/Y _11185_/A _11078_/A _11061_/Y VDD VSS sg13g2_a21oi_1
XFILLER_66_1182 VDD VSS sg13g2_fill_2
XFILLER_135_63 VDD VSS sg13g2_decap_8
XFILLER_150_689 VDD VSS sg13g2_decap_8
XFILLER_153_1141 VDD VSS sg13g2_decap_8
XFILLER_0_154 VDD VSS sg13g2_decap_8
Xhold3060 input24/A mem_axi_rdata[28] VDD VSS sg13g2_dlygate4sd3_1
XFILLER_118_1283 VDD VSS sg13g2_decap_8
XFILLER_27_1166 VDD VSS sg13g2_decap_8
Xhold3071 hold3071/X input12/X VDD VSS sg13g2_dlygate4sd3_1
X_10013_ _14595_/D _10079_/A0 _14595_/Q _10035_/S VDD VSS sg13g2_mux2_1
Xhold3082 input13/A mem_axi_rdata[18] VDD VSS sg13g2_dlygate4sd3_1
Xhold3093 hold3093/X mem_axi_rdata[9] VDD VSS sg13g2_dlygate4sd3_1
XFILLER_95_56 VDD VSS sg13g2_decap_8
XFILLER_153_1196 VDD VSS sg13g2_fill_1
XFILLER_114_1158 VDD VSS sg13g2_fill_2
X_14821_ _14821_/Q _14886_/CLK _14821_/D _14821_/RESET_B VDD VSS sg13g2_dfrbpq_1
XFILLER_92_938 VDD VSS sg13g2_decap_4
XFILLER_40_1366 VDD VSS sg13g2_decap_8
X_14752_ _14752_/Q clkload55/A _14752_/D _14752_/RESET_B VDD VSS sg13g2_dfrbpq_1
X_11964_ _11964_/X _11964_/A _11964_/B VDD VSS sg13g2_and2_1
X_13703_ _16865_/A clkload58/A _13703_/D _13703_/RESET_B VDD VSS sg13g2_dfrbpq_1
X_10915_ _10946_/A _10936_/C _15119_/Q VDD VSS sg13g2_nand2_1
XFILLER_17_567 VDD VSS sg13g2_decap_8
X_14683_ _14683_/Q clkload46/A _14683_/D _14683_/RESET_B VDD VSS sg13g2_dfrbpq_1
X_11895_ _11897_/A _11893_/S _14190_/Q VDD VSS sg13g2_nand2b_1
X_13634_ _13742_/D _13634_/A VDD VSS sg13g2_buf_1
XFILLER_44_397 VDD VSS sg13g2_decap_8
X_10846_ _10846_/Y _10845_/Y _10897_/D _13307_/B VDD VSS sg13g2_a21oi_1
XFILLER_38_1262 VDD VSS sg13g2_decap_8
XFILLER_9_700 VDD VSS sg13g2_decap_8
X_13565_ _15153_/D _15153_/Q _13564_/Y _13565_/S VDD VSS sg13g2_mux2_1
XFILLER_13_784 VDD VSS sg13g2_decap_8
X_10777_ _11164_/B _14952_/Q _08943_/A _10776_/X VDD VSS sg13g2_a21oi_1
XFILLER_8_210 VDD VSS sg13g2_decap_8
XFILLER_157_244 VDD VSS sg13g2_decap_4
X_12516_ _12516_/X _14695_/Q _14727_/Q _13767_/Q _13799_/Q _12522_/S0 _12522_/S1 VDD
+ VSS sg13g2_mux4_1
XFILLER_118_609 VDD VSS sg13g2_decap_8
XFILLER_12_294 VDD VSS sg13g2_decap_8
XFILLER_158_789 VDD VSS sg13g2_decap_8
X_13496_ _15126_/D _13494_/Y _13495_/Y _13493_/Y VDD VSS sg13g2_o21ai_1
XFILLER_9_777 VDD VSS sg13g2_decap_8
XFILLER_74_7 VDD VSS sg13g2_decap_8
X_14073__2106 _14073_/RESET_B VDD VSS sg13g2_tiehi
XFILLER_172_203 VDD VSS sg13g2_decap_8
X_15235_ _15235_/Q clkload57/A _15235_/D _15235_/RESET_B VDD VSS sg13g2_dfrbpq_1
XFILLER_126_620 VDD VSS sg13g2_decap_4
X_12447_ _12447_/X _13826_/Q _13858_/Q _13890_/Q _13922_/Q _12452_/S0 _12452_/S1 VDD
+ VSS sg13g2_mux4_1
XFILLER_8_287 VDD VSS sg13g2_decap_8
XFILLER_138_480 VDD VSS sg13g2_fill_1
XFILLER_138_491 VDD VSS sg13g2_fill_2
X_15166_ _15166_/Q clkload70/A _15166_/D _15166_/RESET_B VDD VSS sg13g2_dfrbpq_1
XFILLER_5_21 VDD VSS sg13g2_decap_8
X_12378_ _12378_/X _14685_/Q _14717_/Q _13757_/Q _13789_/Q _12396_/S0 _12396_/S1 VDD
+ VSS sg13g2_mux4_1
XFILLER_153_461 VDD VSS sg13g2_decap_8
XFILLER_141_623 VDD VSS sg13g2_decap_8
X_14117_ _14117_/Q _14725_/CLK _14117_/D _14117_/RESET_B VDD VSS sg13g2_dfrbpq_1
XFILLER_5_994 VDD VSS sg13g2_decap_8
X_11329_ _11329_/Y _11327_/Y _11326_/Y _11329_/B1 _11328_/X VDD VSS sg13g2_a22oi_1
XFILLER_119_1036 VDD VSS sg13g2_fill_1
X_15097_ _15097_/Q clkload67/A _15097_/D _15097_/RESET_B VDD VSS sg13g2_dfrbpq_1
XFILLER_113_336 VDD VSS sg13g2_decap_8
XFILLER_158_1096 VDD VSS sg13g2_decap_8
X_14713__1466 _14713_/RESET_B VDD VSS sg13g2_tiehi
XFILLER_84_1260 VDD VSS sg13g2_fill_1
XFILLER_5_98 VDD VSS sg13g2_decap_8
X_14048_ _14048_/Q _14721_/CLK _14048_/D _14048_/RESET_B VDD VSS sg13g2_dfrbpq_1
XFILLER_80_1124 VDD VSS sg13g2_decap_4
XFILLER_84_1293 VDD VSS sg13g2_decap_8
XFILLER_140_177 VDD VSS sg13g2_decap_4
XFILLER_122_892 VDD VSS sg13g2_decap_8
XFILLER_80_1146 VDD VSS sg13g2_decap_8
XFILLER_132_1225 VDD VSS sg13g2_decap_8
XFILLER_68_968 VDD VSS sg13g2_decap_8
XFILLER_67_445 VDD VSS sg13g2_decap_8
XFILLER_171_1285 VDD VSS sg13g2_decap_8
XFILLER_45_1299 VDD VSS sg13g2_decap_4
XFILLER_95_765 VDD VSS sg13g2_decap_8
XFILLER_94_253 VDD VSS sg13g2_decap_8
XFILLER_83_927 VDD VSS sg13g2_decap_8
XFILLER_82_415 VDD VSS sg13g2_fill_2
X_08540_ _08545_/B _08621_/A _08538_/X _08539_/Y VDD VSS sg13g2_o21ai_1
XFILLER_36_832 VDD VSS sg13g2_decap_8
XFILLER_82_448 VDD VSS sg13g2_decap_8
XFILLER_36_843 VDD VSS sg13g2_fill_2
XFILLER_36_854 VDD VSS sg13g2_decap_8
XFILLER_165_1001 VDD VSS sg13g2_fill_2
X_08471_ _08494_/A _15008_/Q _08471_/B VDD VSS sg13g2_nor2_1
XFILLER_23_504 VDD VSS sg13g2_decap_8
XFILLER_39_1037 VDD VSS sg13g2_decap_8
XFILLER_165_1078 VDD VSS sg13g2_decap_8
XFILLER_17_1302 VDD VSS sg13g2_decap_8
XFILLER_91_1242 VDD VSS sg13g2_fill_1
XFILLER_104_1305 VDD VSS sg13g2_decap_8
XFILLER_91_1286 VDD VSS sg13g2_decap_4
X_14931__2682 _14931_/RESET_B VDD VSS sg13g2_tiehi
XFILLER_17_1379 VDD VSS sg13g2_fill_1
XFILLER_148_266 VDD VSS sg13g2_decap_8
XFILLER_163_203 VDD VSS sg13g2_decap_8
XFILLER_164_726 VDD VSS sg13g2_decap_8
X_09023_ _09024_/C _10702_/A _09030_/D _12957_/A VDD VSS sg13g2_a21o_1
X_14049__2130 _14049_/RESET_B VDD VSS sg13g2_tiehi
XFILLER_15_1092 VDD VSS sg13g2_decap_8
XFILLER_102_1062 VDD VSS sg13g2_decap_4
XFILLER_116_130 VDD VSS sg13g2_decap_8
XFILLER_105_815 VDD VSS sg13g2_fill_2
XFILLER_117_675 VDD VSS sg13g2_decap_8
XFILLER_137_1103 VDD VSS sg13g2_fill_2
XFILLER_131_122 VDD VSS sg13g2_decap_8
XFILLER_104_347 VDD VSS sg13g2_decap_8
XFILLER_131_133 VDD VSS sg13g2_fill_1
Xfanout701 _11549_/B _11443_/A VDD VSS sg13g2_buf_1
Xfanout712 fanout712/X _11227_/S VDD VSS sg13g2_buf_1
X_09925_ _14510_/D _14510_/Q _09925_/A1 _09931_/S VDD VSS sg13g2_mux2_1
XFILLER_49_49 VDD VSS sg13g2_decap_8
Xfanout723 _12015_/B _11739_/B VDD VSS sg13g2_buf_1
XFILLER_172_28 VDD VSS sg13g2_decap_8
XFILLER_113_870 VDD VSS sg13g2_decap_4
XFILLER_59_924 VDD VSS sg13g2_decap_8
Xfanout734 _13483_/A2 _07653_/Y VDD VSS sg13g2_buf_1
X_13771__2408 _13771_/RESET_B VDD VSS sg13g2_tiehi
Xfanout745 _08223_/S fanout750/X VDD VSS sg13g2_buf_1
XFILLER_59_935 VDD VSS sg13g2_fill_1
Xfanout756 _08452_/C _08110_/C VDD VSS sg13g2_buf_1
Xfanout767 _11109_/B _10510_/B VDD VSS sg13g2_buf_1
X_09856_ _14443_/D _14443_/Q _10121_/A0 _09862_/S VDD VSS sg13g2_mux2_1
Xfanout778 _12398_/S1 _12789_/S1 VDD VSS sg13g2_buf_1
Xfanout789 _12706_/S _12790_/S VDD VSS sg13g2_buf_1
XFILLER_86_765 VDD VSS sg13g2_decap_8
X_08807_ _08808_/B _13687_/Q _08826_/B VDD VSS sg13g2_nor2_1
XFILLER_105_77 VDD VSS sg13g2_decap_8
XFILLER_6_1260 VDD VSS sg13g2_decap_8
X_09787_ _14376_/D _10151_/A1 _14376_/Q _09796_/S VDD VSS sg13g2_mux2_1
XFILLER_74_938 VDD VSS sg13g2_decap_8
XFILLER_2_1113 VDD VSS sg13g2_decap_8
XFILLER_73_437 VDD VSS sg13g2_decap_8
X_08738_ _13664_/D _08765_/A1 _08736_/Y _08737_/Y VDD VSS sg13g2_a21oi_1
XFILLER_54_640 VDD VSS sg13g2_decap_8
XFILLER_121_21 VDD VSS sg13g2_decap_8
X_14151__2028 _14151_/RESET_B VDD VSS sg13g2_tiehi
XFILLER_82_960 VDD VSS sg13g2_decap_8
XFILLER_96_1164 VDD VSS sg13g2_decap_8
XFILLER_82_971 VDD VSS sg13g2_fill_1
XFILLER_26_353 VDD VSS sg13g2_fill_1
XFILLER_14_504 VDD VSS sg13g2_decap_8
X_08669_ _08669_/Y _08048_/A _12278_/A _08669_/B1 VDD VSS sg13g2_a21oi_1
XFILLER_92_1006 VDD VSS sg13g2_decap_8
XFILLER_42_813 VDD VSS sg13g2_fill_1
XFILLER_148_1254 VDD VSS sg13g2_fill_1
XFILLER_26_375 VDD VSS sg13g2_decap_8
XFILLER_81_14 VDD VSS sg13g2_decap_8
XFILLER_148_1265 VDD VSS sg13g2_fill_2
X_10700_ _14902_/D _07705_/B _10897_/A _10699_/Y VDD VSS sg13g2_o21ai_1
XFILLER_148_1276 VDD VSS sg13g2_decap_4
XFILLER_144_1118 VDD VSS sg13g2_fill_2
X_11680_ _11680_/Y _11975_/A _11679_/X _11625_/C VDD VSS sg13g2_a21oi_1
X_14259__1920 _14259_/RESET_B VDD VSS sg13g2_tiehi
XFILLER_41_356 VDD VSS sg13g2_decap_8
X_10631_ _10633_/B _14885_/Q _10630_/B VDD VSS sg13g2_nor2b_1
XFILLER_14_63 VDD VSS sg13g2_decap_8
XFILLER_70_1337 VDD VSS sg13g2_fill_1
XFILLER_10_721 VDD VSS sg13g2_decap_8
XFILLER_167_553 VDD VSS sg13g2_decap_8
X_13350_ _13351_/D _15181_/D _15182_/D VDD VSS sg13g2_or2_1
X_10562_ _10565_/B _14868_/Q _14867_/Q _14856_/Q _14855_/Q VDD VSS sg13g2_nand4_1
XFILLER_155_715 VDD VSS sg13g2_decap_8
XFILLER_6_714 VDD VSS sg13g2_decap_8
XFILLER_127_428 VDD VSS sg13g2_fill_1
X_12301_ _12301_/Y _12299_/Y _12300_/Y _11664_/A VDD VSS sg13g2_a21oi_1
X_13281_ _15053_/D _13281_/A _13507_/A _13281_/C VDD VSS sg13g2_nor3_1
XFILLER_10_798 VDD VSS sg13g2_decap_8
X_10493_ _14851_/D _10493_/A _10492_/Y VDD VSS sg13g2_nor2b_1
XFILLER_154_247 VDD VSS sg13g2_decap_4
XFILLER_5_224 VDD VSS sg13g2_decap_8
X_15020_ _15020_/Q clkload61/A _15020_/D _15020_/RESET_B VDD VSS sg13g2_dfrbpq_1
XFILLER_136_962 VDD VSS sg13g2_decap_8
X_12232_ _12232_/X _14136_/Q _14168_/Q _12235_/A VDD VSS sg13g2_mux2_1
XFILLER_100_0 VDD VSS sg13g2_decap_8
XFILLER_108_686 VDD VSS sg13g2_decap_8
XFILLER_135_461 VDD VSS sg13g2_decap_8
XFILLER_68_1244 VDD VSS sg13g2_decap_8
XFILLER_151_932 VDD VSS sg13g2_fill_2
XFILLER_30_84 VDD VSS sg13g2_decap_8
X_12163_ _12163_/X _12163_/A _12246_/B VDD VSS sg13g2_and2_1
XFILLER_2_931 VDD VSS sg13g2_decap_8
XFILLER_123_645 VDD VSS sg13g2_decap_4
XFILLER_155_1247 VDD VSS sg13g2_decap_8
X_11114_ _11114_/X _11097_/Y _10764_/X _10769_/X VDD VSS sg13g2_a21o_1
XFILLER_1_441 VDD VSS sg13g2_decap_8
XFILLER_150_464 VDD VSS sg13g2_decap_4
XFILLER_110_306 VDD VSS sg13g2_decap_8
X_12094_ _12094_/Y _12094_/A _12253_/B VDD VSS sg13g2_nand2_1
XFILLER_110_317 VDD VSS sg13g2_fill_2
XFILLER_150_486 VDD VSS sg13g2_decap_8
XFILLER_122_199 VDD VSS sg13g2_decap_8
X_14361__1818 _14361_/RESET_B VDD VSS sg13g2_tiehi
X_11045_ _11046_/B _11052_/B _11045_/A2 _11045_/B1 VDD VSS sg13g2_a21oi_1
X_13747__2432 _13747_/RESET_B VDD VSS sg13g2_tiehi
XFILLER_76_220 VDD VSS sg13g2_decap_8
XFILLER_49_434 VDD VSS sg13g2_fill_2
XFILLER_77_754 VDD VSS sg13g2_decap_8
XFILLER_7_1057 VDD VSS sg13g2_decap_8
XFILLER_49_478 VDD VSS sg13g2_decap_8
XFILLER_65_938 VDD VSS sg13g2_fill_1
XFILLER_36_128 VDD VSS sg13g2_fill_1
X_14804_ _14804_/Q _14868_/CLK _14804_/D _14804_/RESET_B VDD VSS sg13g2_dfrbpq_1
XFILLER_149_1018 VDD VSS sg13g2_decap_8
X_12996_ _12996_/Y _12900_/A _12900_/C input7/X VDD VSS sg13g2_a21oi_1
XFILLER_45_640 VDD VSS sg13g2_fill_1
XFILLER_18_854 VDD VSS sg13g2_decap_8
XFILLER_91_267 VDD VSS sg13g2_fill_2
X_14735_ _14735_/Q _14735_/CLK _14735_/D _14735_/RESET_B VDD VSS sg13g2_dfrbpq_1
X_11947_ _11947_/Y _11944_/Y _11946_/X _11974_/B1 VDD VSS sg13g2_o21ai_1
XFILLER_17_364 VDD VSS sg13g2_decap_8
X_14127__2052 _14127_/RESET_B VDD VSS sg13g2_tiehi
XFILLER_75_1226 VDD VSS sg13g2_decap_4
XFILLER_33_835 VDD VSS sg13g2_fill_2
XFILLER_72_481 VDD VSS sg13g2_fill_1
XFILLER_162_1207 VDD VSS sg13g2_decap_8
X_14666_ _14666_/Q _14666_/CLK _14666_/D _14666_/RESET_B VDD VSS sg13g2_dfrbpq_1
X_11878_ _11878_/Y _11217_/S _14606_/Q _11878_/B1 VDD VSS sg13g2_a21oi_1
XFILLER_33_879 VDD VSS sg13g2_decap_4
X_13617_ _13725_/D _13617_/A VDD VSS sg13g2_buf_1
X_10829_ _10831_/C _10818_/A _10818_/B _10823_/C VDD VSS sg13g2_o21ai_1
XFILLER_20_518 VDD VSS sg13g2_decap_8
X_14597_ _14597_/Q clkload5/A _14597_/D _14597_/RESET_B VDD VSS sg13g2_dfrbpq_1
XFILLER_13_581 VDD VSS sg13g2_decap_8
XFILLER_125_1062 VDD VSS sg13g2_fill_2
XFILLER_119_918 VDD VSS sg13g2_decap_8
X_13548_ _15147_/D _13565_/S _13546_/Y _13547_/Y VDD VSS sg13g2_a21oi_1
XFILLER_9_574 VDD VSS sg13g2_decap_8
XFILLER_173_512 VDD VSS sg13g2_decap_4
X_13995__2184 _13995_/RESET_B VDD VSS sg13g2_tiehi
XFILLER_12_1232 VDD VSS sg13g2_decap_8
X_13479_ _15180_/D hold3046/X _15180_/Q _13479_/S VDD VSS sg13g2_mux2_1
XFILLER_86_1300 VDD VSS sg13g2_decap_8
X_15218_ _15218_/Q clkload61/A _15218_/D _15218_/RESET_B VDD VSS sg13g2_dfrbpq_1
XFILLER_173_567 VDD VSS sg13g2_decap_4
XFILLER_127_995 VDD VSS sg13g2_decap_8
XFILLER_160_217 VDD VSS sg13g2_decap_8
XFILLER_142_943 VDD VSS sg13g2_decap_8
X_15149_ _15149_/Q clkload60/A _15149_/D _15149_/RESET_B VDD VSS sg13g2_dfrbpq_1
X_14908__2728 _14908_/RESET_B VDD VSS sg13g2_tiehi
XFILLER_5_791 VDD VSS sg13g2_decap_8
XFILLER_173_1347 VDD VSS sg13g2_decap_8
XFILLER_134_1309 VDD VSS sg13g2_decap_4
X_07971_ _07971_/Y _15018_/Q _08653_/B VDD VSS sg13g2_nand2b_1
XFILLER_99_378 VDD VSS sg13g2_decap_8
XFILLER_45_1041 VDD VSS sg13g2_decap_4
X_09710_ _14301_/D _09908_/A1 _14301_/Q _09733_/S VDD VSS sg13g2_mux2_1
XFILLER_68_721 VDD VSS sg13g2_decap_8
X_14337__1842 _14337_/RESET_B VDD VSS sg13g2_tiehi
X_09641_ _09641_/X _15064_/Q _09740_/B _09707_/B _09641_/D VDD VSS sg13g2_or4_1
XFILLER_67_253 VDD VSS sg13g2_decap_4
XFILLER_68_787 VDD VSS sg13g2_decap_4
XFILLER_28_618 VDD VSS sg13g2_decap_4
XFILLER_110_895 VDD VSS sg13g2_fill_2
Xclkbuf_leaf_5_clk_i _14725_/CLK clkbuf_leaf_8_clk_i/A VDD VSS sg13g2_buf_8
XFILLER_132_1088 VDD VSS sg13g2_fill_1
XFILLER_83_746 VDD VSS sg13g2_decap_8
X_09572_ _14170_/D _10102_/A0 _14170_/Q _09572_/S VDD VSS sg13g2_mux2_1
X_15189__2789 _15189_/RESET_B VDD VSS sg13g2_tiehi
X_08523_ _08523_/Y _07956_/A _08591_/A3 _08674_/B1 VDD VSS sg13g2_o21ai_1
XFILLER_93_1304 VDD VSS sg13g2_fill_2
XFILLER_64_982 VDD VSS sg13g2_decap_4
XFILLER_42_109 VDD VSS sg13g2_decap_8
XFILLER_70_429 VDD VSS sg13g2_fill_2
XFILLER_23_301 VDD VSS sg13g2_decap_8
X_08454_ _08454_/X _15103_/Q _15090_/Q _08454_/C VDD VSS sg13g2_or3_1
XFILLER_1_1190 VDD VSS sg13g2_decap_8
XFILLER_50_131 VDD VSS sg13g2_fill_2
XFILLER_51_665 VDD VSS sg13g2_fill_2
XFILLER_11_518 VDD VSS sg13g2_decap_8
XFILLER_51_687 VDD VSS sg13g2_decap_8
XFILLER_23_378 VDD VSS sg13g2_decap_8
X_08385_ _08385_/Y _15103_/Q _15090_/Q _08385_/C VDD VSS sg13g2_nor3_1
XFILLER_108_1260 VDD VSS sg13g2_decap_8
XFILLER_51_28 VDD VSS sg13g2_decap_8
XFILLER_104_1113 VDD VSS sg13g2_decap_4
XFILLER_167_28 VDD VSS sg13g2_decap_8
XFILLER_17_1176 VDD VSS sg13g2_decap_8
XFILLER_136_203 VDD VSS sg13g2_decap_8
XFILLER_13_1029 VDD VSS sg13g2_decap_8
XFILLER_30_1310 VDD VSS sg13g2_decap_8
XFILLER_104_1157 VDD VSS sg13g2_decap_4
X_13825__2354 _13825_/RESET_B VDD VSS sg13g2_tiehi
X_14585__1594 _14585_/RESET_B VDD VSS sg13g2_tiehi
XFILLER_164_567 VDD VSS sg13g2_decap_8
X_09006_ _09006_/Y _09006_/A _09006_/B _09022_/D VDD VSS sg13g2_nor3_1
XFILLER_117_472 VDD VSS sg13g2_decap_8
XFILLER_3_728 VDD VSS sg13g2_decap_8
XFILLER_133_954 VDD VSS sg13g2_decap_8
XFILLER_4_7 VDD VSS sg13g2_decap_8
XFILLER_2_238 VDD VSS sg13g2_decap_8
XFILLER_116_21 VDD VSS sg13g2_decap_8
XFILLER_105_689 VDD VSS sg13g2_decap_8
XFILLER_120_615 VDD VSS sg13g2_fill_2
XFILLER_133_998 VDD VSS sg13g2_decap_8
Xfanout520 _12223_/A _11236_/C VDD VSS sg13g2_buf_1
Xfanout531 _10104_/A0 _10138_/A1 VDD VSS sg13g2_buf_1
XFILLER_76_14 VDD VSS sg13g2_decap_8
Xfanout542 _13608_/A1 _08833_/Y VDD VSS sg13g2_buf_1
X_09908_ _14493_/D _14493_/Q _09908_/A1 _09931_/S VDD VSS sg13g2_mux2_1
XFILLER_8_1344 VDD VSS sg13g2_decap_8
XFILLER_59_743 VDD VSS sg13g2_decap_8
Xfanout553 _08539_/B1 _08035_/X VDD VSS sg13g2_buf_1
XFILLER_150_1122 VDD VSS sg13g2_fill_1
XFILLER_154_1291 VDD VSS sg13g2_fill_2
Xfanout564 _13236_/B1 _13297_/A0 VDD VSS sg13g2_buf_1
XFILLER_28_1294 VDD VSS sg13g2_decap_8
Xfanout575 _13561_/S _12793_/Y VDD VSS sg13g2_buf_1
Xfanout586 _11170_/B _10941_/B VDD VSS sg13g2_buf_1
Xfanout597 _10757_/A _10747_/A VDD VSS sg13g2_buf_1
X_09839_ wire331/A _09938_/A _10105_/C _09839_/C _09839_/D VDD VSS sg13g2_nor4_1
XFILLER_74_713 VDD VSS sg13g2_decap_8
XFILLER_101_884 VDD VSS sg13g2_decap_8
XFILLER_24_1169 VDD VSS sg13g2_decap_8
XFILLER_100_361 VDD VSS sg13g2_fill_2
XFILLER_47_949 VDD VSS sg13g2_decap_8
XFILLER_98_1248 VDD VSS sg13g2_decap_8
XFILLER_58_297 VDD VSS sg13g2_fill_1
XFILLER_150_1199 VDD VSS sg13g2_fill_2
X_12850_ _12850_/X _12846_/Y _12848_/X _12849_/Y VDD VSS sg13g2_a21o_1
X_11801_ _11801_/X _14124_/Q _14156_/Q _11804_/A VDD VSS sg13g2_mux2_1
XFILLER_73_267 VDD VSS sg13g2_decap_8
XFILLER_27_662 VDD VSS sg13g2_fill_2
X_12781_ _12781_/X _13978_/Q _14010_/Q _14042_/Q _14074_/Q _12783_/S0 _12783_/S1 VDD
+ VSS sg13g2_mux4_1
XFILLER_14_301 VDD VSS sg13g2_decap_8
XFILLER_26_161 VDD VSS sg13g2_decap_8
X_14520_ _14520_/Q _14979_/CLK _14520_/D _14520_/RESET_B VDD VSS sg13g2_dfrbpq_1
X_11732_ _11732_/Y _11749_/A1 _14186_/Q VDD VSS sg13g2_nand2b_1
XFILLER_54_492 VDD VSS sg13g2_decap_8
XFILLER_15_868 VDD VSS sg13g2_decap_8
XFILLER_148_0 VDD VSS sg13g2_decap_8
X_14451_ _14451_/Q clkload22/A _14451_/D _14451_/RESET_B VDD VSS sg13g2_dfrbpq_1
XFILLER_25_84 VDD VSS sg13g2_decap_8
XFILLER_14_378 VDD VSS sg13g2_decap_8
X_11663_ _11663_/Y _11663_/A _11663_/B _11773_/B VDD VSS sg13g2_nand3_1
XFILLER_74_1281 VDD VSS sg13g2_fill_2
X_13402_ _15088_/D _13396_/D _13433_/A _13400_/Y VDD VSS sg13g2_o21ai_1
X_10614_ _10622_/C _10614_/A _10614_/B VDD VSS sg13g2_nor2_1
XFILLER_167_350 VDD VSS sg13g2_decap_8
X_14382_ _14382_/Q clkload39/A _14382_/D _14382_/RESET_B VDD VSS sg13g2_dfrbpq_1
X_11594_ _11594_/X _14118_/Q _14150_/Q _11597_/A VDD VSS sg13g2_mux2_1
X_13333_ _15171_/D hold3031/X _15171_/Q _13336_/S VDD VSS sg13g2_mux2_1
XFILLER_70_1189 VDD VSS sg13g2_decap_4
XFILLER_6_511 VDD VSS sg13g2_decap_8
X_10545_ _10548_/C _14864_/Q _10544_/B VDD VSS sg13g2_nor2b_1
XFILLER_122_1279 VDD VSS sg13g2_decap_4
XFILLER_127_247 VDD VSS sg13g2_fill_2
X_14415__1764 _14415_/RESET_B VDD VSS sg13g2_tiehi
XFILLER_10_595 VDD VSS sg13g2_decap_8
X_15052__2521 _15052_/RESET_B VDD VSS sg13g2_tiehi
XFILLER_155_578 VDD VSS sg13g2_decap_4
XFILLER_170_504 VDD VSS sg13g2_decap_8
X_13264_ _13264_/X input27/X _13272_/A2 _13264_/B1 VDD VSS sg13g2_a21o_1
XFILLER_108_461 VDD VSS sg13g2_decap_8
XFILLER_109_984 VDD VSS sg13g2_fill_2
X_10476_ _10478_/B _10486_/D _10492_/C _14847_/Q VDD VSS sg13g2_a21oi_1
X_15003_ _15003_/Q clkload59/A _15003_/D _15003_/RESET_B VDD VSS sg13g2_dfrbpq_1
XFILLER_6_588 VDD VSS sg13g2_decap_8
X_12215_ _12215_/X _13975_/Q _14007_/Q _14039_/Q _14071_/Q _12215_/S0 _12215_/S1 VDD
+ VSS sg13g2_mux4_1
XFILLER_108_494 VDD VSS sg13g2_fill_2
XFILLER_124_943 VDD VSS sg13g2_decap_8
X_13195_ _13196_/C _14824_/Q _13206_/B _13249_/B _14888_/Q VDD VSS sg13g2_a22oi_1
XFILLER_123_431 VDD VSS sg13g2_decap_8
XFILLER_124_976 VDD VSS sg13g2_decap_8
X_12146_ _12146_/Y _13200_/A _11655_/B _12156_/A VDD VSS sg13g2_a21oi_1
XFILLER_29_1058 VDD VSS sg13g2_fill_2
XFILLER_111_615 VDD VSS sg13g2_decap_4
XFILLER_37_7 VDD VSS sg13g2_decap_8
XFILLER_46_1350 VDD VSS sg13g2_fill_2
XFILLER_116_1039 VDD VSS sg13g2_decap_8
XFILLER_46_1361 VDD VSS sg13g2_decap_8
XFILLER_110_136 VDD VSS sg13g2_decap_8
X_12077_ _12077_/Y _12223_/A _12077_/B VDD VSS sg13g2_nor2_1
XFILLER_81_1263 VDD VSS sg13g2_fill_1
XFILLER_133_1353 VDD VSS sg13g2_fill_2
X_11028_ _11029_/B _11052_/A _11052_/D _11027_/Y VDD VSS sg13g2_o21ai_1
XFILLER_2_77 VDD VSS sg13g2_decap_8
XFILLER_65_757 VDD VSS sg13g2_decap_8
XFILLER_64_234 VDD VSS sg13g2_fill_1
XFILLER_66_91 VDD VSS sg13g2_decap_8
XFILLER_18_651 VDD VSS sg13g2_decap_8
X_13903__2276 _13903_/RESET_B VDD VSS sg13g2_tiehi
XFILLER_80_727 VDD VSS sg13g2_fill_2
X_12979_ _12979_/Y _12976_/Y _12977_/Y _12978_/Y VDD VSS sg13g2_a21oi_1
XFILLER_75_1023 VDD VSS sg13g2_decap_8
XFILLER_17_161 VDD VSS sg13g2_decap_8
XFILLER_127_1102 VDD VSS sg13g2_decap_8
X_14718_ _14718_/Q clkload39/A _14718_/D _14718_/RESET_B VDD VSS sg13g2_dfrbpq_1
XFILLER_166_1173 VDD VSS sg13g2_decap_8
XFILLER_21_805 VDD VSS sg13g2_decap_8
X_14649_ _14649_/Q _14649_/CLK _14649_/D _14649_/RESET_B VDD VSS sg13g2_dfrbpq_1
XFILLER_20_315 VDD VSS sg13g2_decap_8
XANTENNA_16 _16884_/A VDD VSS sg13g2_antennanp
XFILLER_60_495 VDD VSS sg13g2_fill_2
XANTENNA_27 _16867_/A VDD VSS sg13g2_antennanp
XFILLER_159_862 VDD VSS sg13g2_fill_1
X_08170_ _08170_/X _08044_/X _08052_/Y _08167_/B _08397_/B _08241_/A _08014_/B VDD
+ VSS sg13g2_mux4_1
XFILLER_14_1316 VDD VSS sg13g2_decap_8
XFILLER_158_361 VDD VSS sg13g2_fill_2
XFILLER_158_372 VDD VSS sg13g2_decap_8
XFILLER_174_821 VDD VSS sg13g2_decap_8
X_15080__2833 _15080_/RESET_B VDD VSS sg13g2_tiehi
XFILLER_9_371 VDD VSS sg13g2_decap_8
XFILLER_63_0 VDD VSS sg13g2_decap_8
XFILLER_173_364 VDD VSS sg13g2_decap_8
XFILLER_127_770 VDD VSS sg13g2_decap_4
Xoutput101 mem_axi_awvalid _07766_/Y VDD VSS sg13g2_buf_1
XFILLER_161_526 VDD VSS sg13g2_decap_8
Xoutput112 mem_axi_wdata[17] _15149_/Q VDD VSS sg13g2_buf_1
XFILLER_173_397 VDD VSS sg13g2_decap_8
Xoutput123 mem_axi_wdata[27] _15159_/Q VDD VSS sg13g2_buf_1
XFILLER_86_1152 VDD VSS sg13g2_decap_4
Xoutput134 mem_axi_wdata[8] _15140_/Q VDD VSS sg13g2_buf_1
XFILLER_138_1242 VDD VSS sg13g2_fill_2
XFILLER_88_805 VDD VSS sg13g2_decap_8
XFILLER_0_709 VDD VSS sg13g2_decap_8
XFILLER_88_816 VDD VSS sg13g2_fill_1
XFILLER_86_1185 VDD VSS sg13g2_decap_4
XFILLER_142_773 VDD VSS sg13g2_decap_8
XFILLER_82_1038 VDD VSS sg13g2_decap_4
XFILLER_138_1286 VDD VSS sg13g2_decap_8
XFILLER_88_849 VDD VSS sg13g2_decap_4
XFILLER_102_637 VDD VSS sg13g2_fill_1
X_07954_ _07954_/Y _08553_/A _07954_/B _07954_/C VDD VSS sg13g2_nor3_1
XFILLER_87_348 VDD VSS sg13g2_decap_4
XFILLER_96_882 VDD VSS sg13g2_decap_4
X_07885_ _07926_/A _13545_/A _08219_/A VDD VSS sg13g2_nor2b_1
XFILLER_21_1309 VDD VSS sg13g2_decap_8
XFILLER_68_595 VDD VSS sg13g2_decap_8
XFILLER_46_28 VDD VSS sg13g2_decap_8
X_09624_ _14220_/D _09624_/A0 _14220_/Q _09632_/S VDD VSS sg13g2_mux2_1
XFILLER_55_267 VDD VSS sg13g2_fill_1
XFILLER_43_407 VDD VSS sg13g2_decap_8
X_09555_ _14153_/D _09621_/A0 _14153_/Q _09571_/S VDD VSS sg13g2_mux2_1
XFILLER_55_278 VDD VSS sg13g2_decap_8
XFILLER_3_1274 VDD VSS sg13g2_decap_8
XFILLER_97_1270 VDD VSS sg13g2_fill_2
XFILLER_24_610 VDD VSS sg13g2_fill_1
XFILLER_97_1292 VDD VSS sg13g2_decap_8
XFILLER_93_1123 VDD VSS sg13g2_decap_4
XFILLER_64_790 VDD VSS sg13g2_fill_2
XFILLER_58_1243 VDD VSS sg13g2_fill_2
X_08506_ _08506_/Y _08502_/Y _08503_/Y _08505_/Y VDD VSS sg13g2_o21ai_1
XFILLER_93_1134 VDD VSS sg13g2_fill_1
X_09486_ _14086_/D _09950_/A1 _14086_/Q _09497_/S VDD VSS sg13g2_mux2_1
XFILLER_12_805 VDD VSS sg13g2_decap_8
XFILLER_24_676 VDD VSS sg13g2_decap_8
X_08437_ _08437_/Y _15005_/Q _07946_/B _08663_/B VDD VSS sg13g2_a21oi_1
XFILLER_141_7 VDD VSS sg13g2_decap_8
XFILLER_169_659 VDD VSS sg13g2_decap_8
XFILLER_11_315 VDD VSS sg13g2_decap_8
XFILLER_23_175 VDD VSS sg13g2_decap_8
XFILLER_168_147 VDD VSS sg13g2_decap_8
X_14672__1507 _14672_/RESET_B VDD VSS sg13g2_tiehi
X_08368_ _08369_/A _07797_/C _08350_/B _07935_/Y VDD VSS sg13g2_o21ai_1
XFILLER_7_308 VDD VSS sg13g2_decap_8
XFILLER_108_1090 VDD VSS sg13g2_decap_8
XFILLER_149_372 VDD VSS sg13g2_fill_1
XFILLER_165_821 VDD VSS sg13g2_decap_8
XFILLER_137_534 VDD VSS sg13g2_fill_2
XFILLER_149_394 VDD VSS sg13g2_decap_8
XFILLER_20_882 VDD VSS sg13g2_decap_8
X_08299_ _08312_/D _08318_/C _08297_/Y _08298_/Y VDD VSS sg13g2_a21oi_1
XFILLER_109_247 VDD VSS sg13g2_decap_8
X_10330_ _10331_/B _14798_/Q _14803_/Q _10342_/C _10345_/C VDD VSS sg13g2_nand4_1
XFILLER_164_364 VDD VSS sg13g2_decap_8
XFILLER_118_770 VDD VSS sg13g2_decap_8
XFILLER_11_42 VDD VSS sg13g2_decap_8
XFILLER_106_921 VDD VSS sg13g2_decap_8
XFILLER_106_932 VDD VSS sg13g2_fill_1
XFILLER_124_228 VDD VSS sg13g2_fill_1
XFILLER_69_1350 VDD VSS sg13g2_fill_2
XFILLER_3_525 VDD VSS sg13g2_decap_8
XFILLER_30_1184 VDD VSS sg13g2_decap_8
XFILLER_105_420 VDD VSS sg13g2_decap_8
XFILLER_117_280 VDD VSS sg13g2_decap_8
XFILLER_127_42 VDD VSS sg13g2_decap_4
X_10261_ _10261_/Y _14782_/Q _10268_/D _10423_/C VDD VSS sg13g2_o21ai_1
XFILLER_117_291 VDD VSS sg13g2_fill_1
XFILLER_156_1331 VDD VSS sg13g2_decap_8
Xclkbuf_leaf_106_clk_i _14682_/CLK clkbuf_leaf_77_clk_i/A VDD VSS sg13g2_buf_8
XFILLER_69_1383 VDD VSS sg13g2_fill_1
XFILLER_106_965 VDD VSS sg13g2_decap_8
XFILLER_106_976 VDD VSS sg13g2_fill_1
XFILLER_121_902 VDD VSS sg13g2_fill_2
X_12000_ _12001_/B _12000_/A _12000_/B VDD VSS sg13g2_nor2_1
XFILLER_106_987 VDD VSS sg13g2_decap_8
Xpicorv32_macro_1422 mem_axi_awprot[2] VDD VSS sg13g2_tielo
X_10192_ _14753_/D _15196_/D _14753_/Q _10194_/S VDD VSS sg13g2_mux2_1
XFILLER_87_57 VDD VSS sg13g2_fill_2
XFILLER_105_497 VDD VSS sg13g2_decap_8
Xfanout1304 _11997_/S0 fanout1308/X VDD VSS sg13g2_buf_1
Xfanout1315 _12238_/S0 fanout1316/X VDD VSS sg13g2_buf_1
Xfanout1326 _11350_/A1 _11229_/S0 VDD VSS sg13g2_buf_1
Xfanout1337 _12316_/S0 fanout1346/X VDD VSS sg13g2_buf_1
XFILLER_8_1141 VDD VSS sg13g2_decap_8
Xfanout350 _09634_/S wire352/X VDD VSS sg13g2_buf_1
Xfanout1348 _11651_/S0 _12138_/S0 VDD VSS sg13g2_buf_1
Xfanout361 _09338_/S _09325_/S VDD VSS sg13g2_buf_1
XFILLER_87_860 VDD VSS sg13g2_fill_2
XFILLER_28_1091 VDD VSS sg13g2_decap_8
Xfanout1359 _11715_/S0 _12288_/S0 VDD VSS sg13g2_buf_1
XFILLER_47_702 VDD VSS sg13g2_fill_1
Xfanout372 _09267_/S _09273_/S VDD VSS sg13g2_buf_1
X_13951_ _13951_/Q clkload10/A _13951_/D _13951_/RESET_B VDD VSS sg13g2_dfrbpq_1
Xfanout383 _09316_/A0 _09013_/Y VDD VSS sg13g2_buf_1
XFILLER_98_1001 VDD VSS sg13g2_decap_8
Xfanout394 _10107_/A0 _10140_/A1 VDD VSS sg13g2_buf_1
XFILLER_74_510 VDD VSS sg13g2_fill_2
XFILLER_101_681 VDD VSS sg13g2_decap_8
XFILLER_143_96 VDD VSS sg13g2_fill_1
X_12902_ _12902_/Y _12902_/A _12902_/B _12902_/C VDD VSS sg13g2_nand3_1
XFILLER_86_392 VDD VSS sg13g2_fill_2
XFILLER_19_448 VDD VSS sg13g2_decap_8
XFILLER_100_180 VDD VSS sg13g2_fill_1
X_13882_ _13882_/Q _14746_/CLK _13882_/D _13882_/RESET_B VDD VSS sg13g2_dfrbpq_1
XFILLER_46_234 VDD VSS sg13g2_decap_8
X_14872__2800 _14872_/RESET_B VDD VSS sg13g2_tiehi
XFILLER_62_716 VDD VSS sg13g2_decap_8
X_12833_ _12833_/Y _12835_/A _13691_/Q VDD VSS sg13g2_nand2_1
XFILLER_62_727 VDD VSS sg13g2_fill_1
XFILLER_34_429 VDD VSS sg13g2_decap_4
XFILLER_27_470 VDD VSS sg13g2_decap_8
XFILLER_62_749 VDD VSS sg13g2_decap_4
X_12764_ _15018_/D _12764_/A _12764_/B VDD VSS sg13g2_nor2_1
XFILLER_15_665 VDD VSS sg13g2_decap_8
XFILLER_163_1346 VDD VSS sg13g2_decap_8
X_14503_ _14503_/Q _14703_/CLK _14503_/D _14503_/RESET_B VDD VSS sg13g2_dfrbpq_1
X_11715_ _11715_/X _14249_/Q _14281_/Q _14313_/Q _14345_/Q _11715_/S0 _11715_/S1 VDD
+ VSS sg13g2_mux4_1
X_13697__2482 _13697_/RESET_B VDD VSS sg13g2_tiehi
XFILLER_43_996 VDD VSS sg13g2_decap_8
XFILLER_42_473 VDD VSS sg13g2_decap_8
XFILLER_14_175 VDD VSS sg13g2_decap_8
X_12695_ _12708_/A _12765_/A1 _12765_/A2 _15014_/Q VDD VSS sg13g2_a21oi_1
XFILLER_42_484 VDD VSS sg13g2_decap_8
XFILLER_159_147 VDD VSS sg13g2_decap_8
XFILLER_163_1368 VDD VSS sg13g2_fill_2
X_14434_ _14434_/Q clkload30/A _14434_/D _14434_/RESET_B VDD VSS sg13g2_dfrbpq_1
X_11646_ _11646_/X _14567_/Q _14599_/Q _14631_/Q _14663_/Q _11651_/S0 _11651_/S1 VDD
+ VSS sg13g2_mux4_1
XFILLER_122_1010 VDD VSS sg13g2_fill_1
X_14648__1531 _14648_/RESET_B VDD VSS sg13g2_tiehi
XFILLER_161_1081 VDD VSS sg13g2_decap_8
Xinput14 input14/X input14/A VDD VSS sg13g2_buf_1
XFILLER_11_882 VDD VSS sg13g2_decap_8
XFILLER_122_1043 VDD VSS sg13g2_decap_4
XFILLER_128_534 VDD VSS sg13g2_decap_8
XFILLER_161_1092 VDD VSS sg13g2_fill_2
X_14365_ _14365_/Q clkload45/A _14365_/D _14365_/RESET_B VDD VSS sg13g2_dfrbpq_1
Xinput25 input25/X input25/A VDD VSS sg13g2_buf_1
XFILLER_122_1054 VDD VSS sg13g2_fill_1
XFILLER_128_545 VDD VSS sg13g2_decap_8
Xinput36 input36/X input36/A VDD VSS sg13g2_buf_1
X_11577_ _11577_/X _14117_/Q _14149_/Q _14181_/Q _14213_/Q _11997_/S0 _11997_/S1 VDD
+ VSS sg13g2_mux4_1
XFILLER_10_392 VDD VSS sg13g2_decap_8
X_13316_ _13316_/X _15062_/Q _13600_/C _13316_/C VDD VSS sg13g2_and3_1
X_10528_ _10529_/B _10558_/B _10558_/C _10531_/D VDD VSS sg13g2_nand3_1
XFILLER_7_875 VDD VSS sg13g2_decap_8
XFILLER_109_770 VDD VSS sg13g2_decap_8
XFILLER_170_301 VDD VSS sg13g2_decap_8
X_14296_ _14296_/Q _14979_/CLK _14296_/D _14296_/RESET_B VDD VSS sg13g2_dfrbpq_1
XFILLER_155_386 VDD VSS sg13g2_fill_2
XFILLER_109_781 VDD VSS sg13g2_fill_1
XFILLER_6_385 VDD VSS sg13g2_decap_8
X_13247_ _13247_/Y _13247_/A _13247_/B _13247_/C _13271_/C VDD VSS sg13g2_nand4_1
X_10459_ _10471_/D _10538_/A _10459_/B _10459_/C _10512_/A VDD VSS sg13g2_nor4_1
XFILLER_171_868 VDD VSS sg13g2_fill_1
X_15188__2799 _15188_/RESET_B VDD VSS sg13g2_tiehi
XFILLER_83_1314 VDD VSS sg13g2_fill_2
XFILLER_170_378 VDD VSS sg13g2_decap_8
X_13178_ _13178_/X input20/X _13272_/A2 _13272_/B1 VDD VSS sg13g2_a21o_1
XFILLER_97_624 VDD VSS sg13g2_decap_8
XFILLER_124_795 VDD VSS sg13g2_decap_4
X_15016__2571 _15016_/RESET_B VDD VSS sg13g2_tiehi
X_12129_ _12198_/C _12061_/A _13190_/B _13668_/Q _12084_/A VDD VSS sg13g2_a22oi_1
Xclkbuf_leaf_70_clk_i _15213_/CLK clkbuf_leaf_73_clk_i/A VDD VSS sg13g2_buf_8
XFILLER_81_1071 VDD VSS sg13g2_decap_8
XFILLER_46_1191 VDD VSS sg13g2_decap_4
X_14825__2888 _14825_/RESET_B VDD VSS sg13g2_tiehi
XFILLER_78_882 VDD VSS sg13g2_fill_2
XFILLER_65_510 VDD VSS sg13g2_decap_4
XFILLER_37_223 VDD VSS sg13g2_fill_1
X_07670_ _07670_/Y _13283_/A _13613_/B _13613_/C VDD VSS sg13g2_nand3_1
XFILLER_93_852 VDD VSS sg13g2_decap_8
X_16868_ _16868_/X _16868_/A VDD VSS sg13g2_buf_1
XFILLER_93_863 VDD VSS sg13g2_fill_2
XFILLER_93_874 VDD VSS sg13g2_decap_8
XFILLER_37_256 VDD VSS sg13g2_decap_4
XFILLER_25_407 VDD VSS sg13g2_decap_8
XFILLER_168_1246 VDD VSS sg13g2_fill_2
Xclkbuf_leaf_85_clk_i _14868_/CLK clkbuf_leaf_87_clk_i/A VDD VSS sg13g2_buf_8
X_09340_ _09606_/C _09938_/B _09905_/A VDD VSS sg13g2_nor2b_1
XFILLER_33_440 VDD VSS sg13g2_fill_2
XFILLER_21_602 VDD VSS sg13g2_decap_8
X_09271_ _13880_/D _13880_/Q _10100_/A0 _09271_/S VDD VSS sg13g2_mux2_1
X_14287__1892 _14287_/RESET_B VDD VSS sg13g2_tiehi
XFILLER_60_270 VDD VSS sg13g2_decap_8
XFILLER_20_112 VDD VSS sg13g2_decap_8
X_08222_ _08233_/C _08142_/A _08247_/B _08217_/X _08110_/D _08221_/Y VDD VSS sg13g2_a221oi_1
XFILLER_18_1260 VDD VSS sg13g2_decap_8
XFILLER_14_1113 VDD VSS sg13g2_decap_8
XFILLER_159_670 VDD VSS sg13g2_fill_1
XFILLER_21_679 VDD VSS sg13g2_decap_8
X_08153_ _08484_/C _08103_/B _08151_/X _08152_/Y VDD VSS sg13g2_o21ai_1
XFILLER_20_189 VDD VSS sg13g2_decap_8
XFILLER_147_865 VDD VSS sg13g2_fill_1
XFILLER_105_1285 VDD VSS sg13g2_fill_1
XFILLER_107_707 VDD VSS sg13g2_decap_8
XFILLER_119_567 VDD VSS sg13g2_decap_8
XFILLER_162_802 VDD VSS sg13g2_fill_2
XFILLER_147_887 VDD VSS sg13g2_decap_8
Xclkbuf_leaf_23_clk_i clkload22/A clkbuf_leaf_36_clk_i/A VDD VSS sg13g2_buf_8
XFILLER_140_1187 VDD VSS sg13g2_decap_8
X_08084_ _08085_/A _07812_/B _08541_/B _07861_/B _07859_/B _08009_/S _08124_/S1 VDD
+ VSS sg13g2_mux4_1
XFILLER_88_1269 VDD VSS sg13g2_fill_1
XFILLER_173_194 VDD VSS sg13g2_fill_1
XFILLER_161_345 VDD VSS sg13g2_decap_8
XFILLER_115_773 VDD VSS sg13g2_decap_4
XFILLER_88_602 VDD VSS sg13g2_fill_1
XFILLER_114_272 VDD VSS sg13g2_fill_1
XFILLER_130_721 VDD VSS sg13g2_decap_4
XFILLER_138_1072 VDD VSS sg13g2_decap_8
XFILLER_0_539 VDD VSS sg13g2_decap_8
XFILLER_102_423 VDD VSS sg13g2_decap_8
XFILLER_138_1083 VDD VSS sg13g2_fill_1
Xclkbuf_leaf_38_clk_i clkload29/A clkbuf_leaf_44_clk_i/A VDD VSS sg13g2_buf_8
XFILLER_103_968 VDD VSS sg13g2_decap_4
X_08986_ _08988_/B _10681_/A _10674_/A _12859_/A VDD VSS sg13g2_a21oi_1
XFILLER_87_145 VDD VSS sg13g2_decap_8
XFILLER_76_808 VDD VSS sg13g2_fill_1
XFILLER_64_1280 VDD VSS sg13g2_fill_2
XFILLER_130_787 VDD VSS sg13g2_decap_8
XFILLER_64_1291 VDD VSS sg13g2_decap_8
XFILLER_57_49 VDD VSS sg13g2_decap_8
X_07937_ _07937_/Y _08414_/C _07936_/Y _07793_/Y VDD VSS sg13g2_a21oi_1
XFILLER_25_1253 VDD VSS sg13g2_decap_8
XFILLER_56_510 VDD VSS sg13g2_decap_8
XFILLER_21_1106 VDD VSS sg13g2_decap_8
XFILLER_99_1332 VDD VSS sg13g2_decap_8
XFILLER_84_830 VDD VSS sg13g2_decap_8
XFILLER_68_381 VDD VSS sg13g2_decap_4
XFILLER_5_1358 VDD VSS sg13g2_decap_8
XFILLER_112_1245 VDD VSS sg13g2_decap_8
X_07868_ _08183_/B _07912_/B _13533_/A VDD VSS sg13g2_nor2_1
XFILLER_60_1188 VDD VSS sg13g2_decap_4
X_14726__1453 _14726_/RESET_B VDD VSS sg13g2_tiehi
XFILLER_99_1376 VDD VSS sg13g2_decap_8
XFILLER_28_256 VDD VSS sg13g2_decap_8
X_09607_ _14203_/D _09774_/A0 _14203_/Q _09632_/S VDD VSS sg13g2_mux2_1
XFILLER_56_598 VDD VSS sg13g2_decap_4
XFILLER_3_1071 VDD VSS sg13g2_decap_8
X_07799_ _07799_/X _15006_/Q _07945_/B VDD VSS sg13g2_and2_1
XFILLER_147_1319 VDD VSS sg13g2_decap_8
X_09538_ _14137_/D _10068_/A0 _14137_/Q _09538_/S VDD VSS sg13g2_mux2_1
XFILLER_71_557 VDD VSS sg13g2_fill_1
XFILLER_12_602 VDD VSS sg13g2_decap_8
XFILLER_169_434 VDD VSS sg13g2_decap_8
X_09469_ _14070_/D _10098_/A0 _14070_/Q _09469_/S VDD VSS sg13g2_mux2_1
XFILLER_19_1057 VDD VSS sg13g2_decap_8
XFILLER_11_112 VDD VSS sg13g2_decap_8
X_11500_ _11500_/Y _11499_/Y _11498_/Y _11485_/Y _11500_/B2 _11501_/A2 VDD VSS sg13g2_a221oi_1
X_12480_ _12480_/X _14692_/Q _14724_/Q _13764_/Q _13796_/Q _12716_/S0 _12716_/S1 VDD
+ VSS sg13g2_mux4_1
XFILLER_138_810 VDD VSS sg13g2_decap_8
XFILLER_12_679 VDD VSS sg13g2_decap_8
XFILLER_7_105 VDD VSS sg13g2_decap_8
X_11431_ _11431_/Y _07684_/B _11430_/Y _11425_/Y _11426_/Y _11248_/B VDD VSS sg13g2_a221oi_1
XFILLER_11_189 VDD VSS sg13g2_decap_8
XFILLER_137_331 VDD VSS sg13g2_fill_2
XFILLER_22_63 VDD VSS sg13g2_decap_8
X_14150_ _14150_/Q clkload2/A _14150_/D _14150_/RESET_B VDD VSS sg13g2_dfrbpq_1
X_11362_ _11362_/Y _11373_/A _14366_/Q VDD VSS sg13g2_nand2b_1
XFILLER_138_63 VDD VSS sg13g2_decap_4
XFILLER_153_824 VDD VSS sg13g2_fill_1
XFILLER_164_161 VDD VSS sg13g2_decap_8
XFILLER_165_684 VDD VSS sg13g2_decap_8
XFILLER_4_812 VDD VSS sg13g2_decap_8
X_13101_ _13116_/A _14913_/Q _13674_/Q VDD VSS sg13g2_nand2_1
X_10313_ _10313_/X _14796_/Q _14797_/Q _10342_/A _10327_/B VDD VSS sg13g2_and4_1
X_14081_ _14081_/Q _14681_/CLK _14081_/D _14081_/RESET_B VDD VSS sg13g2_dfrbpq_1
XFILLER_3_322 VDD VSS sg13g2_decap_8
X_11293_ _11293_/Y _07684_/B _11292_/Y _11287_/Y _11289_/Y _11248_/B VDD VSS sg13g2_a221oi_1
X_13032_ _13032_/Y _13045_/A1 _12900_/C input9/X VDD VSS sg13g2_a21oi_1
X_10244_ _10245_/A _14775_/Q _14776_/Q wire525/X VDD VSS sg13g2_and3_1
XFILLER_4_889 VDD VSS sg13g2_decap_8
XFILLER_105_261 VDD VSS sg13g2_decap_4
XFILLER_133_570 VDD VSS sg13g2_fill_2
XFILLER_140_529 VDD VSS sg13g2_decap_8
XFILLER_79_624 VDD VSS sg13g2_decap_8
XFILLER_133_592 VDD VSS sg13g2_decap_8
Xfanout1101 _07859_/B _08620_/A2 VDD VSS sg13g2_buf_1
XFILLER_78_123 VDD VSS sg13g2_decap_8
XFILLER_3_399 VDD VSS sg13g2_decap_8
Xfanout1112 _11983_/A _14979_/Q VDD VSS sg13g2_buf_1
XFILLER_26_1028 VDD VSS sg13g2_decap_8
X_10175_ _10175_/Y _13613_/A _13613_/B _13613_/C VDD VSS sg13g2_nor3_1
XFILLER_67_808 VDD VSS sg13g2_decap_8
XFILLER_154_84 VDD VSS sg13g2_decap_8
Xfanout1123 _07949_/C _08493_/B2 VDD VSS sg13g2_buf_1
Xfanout1134 _08384_/A1 _14972_/Q VDD VSS sg13g2_buf_1
Xfanout1145 _11591_/A _14968_/Q VDD VSS sg13g2_buf_1
XFILLER_94_616 VDD VSS sg13g2_decap_4
Xfanout1156 _08219_/A _08860_/A1 VDD VSS sg13g2_buf_1
Xfanout1167 _07879_/A _14959_/Q VDD VSS sg13g2_buf_1
X_14983_ _14983_/Q clkload52/A _14983_/D _14983_/RESET_B VDD VSS sg13g2_dfrbpq_1
Xfanout180 _09930_/A1 fanout182/X VDD VSS sg13g2_buf_1
XFILLER_102_990 VDD VSS sg13g2_decap_8
Xfanout1178 _11249_/A _14957_/Q VDD VSS sg13g2_buf_1
Xfanout191 fanout191/X _09105_/Y VDD VSS sg13g2_buf_1
Xfanout1189 _10702_/A _14903_/Q VDD VSS sg13g2_buf_1
X_13934_ _13934_/Q _14734_/CLK _13934_/D _13934_/RESET_B VDD VSS sg13g2_dfrbpq_1
XFILLER_75_852 VDD VSS sg13g2_decap_8
XFILLER_75_863 VDD VSS sg13g2_fill_2
XFILLER_19_245 VDD VSS sg13g2_decap_8
XFILLER_75_896 VDD VSS sg13g2_decap_8
XFILLER_74_373 VDD VSS sg13g2_decap_8
X_13865_ _13865_/Q clkload20/A _13865_/D _13865_/RESET_B VDD VSS sg13g2_dfrbpq_1
XFILLER_47_598 VDD VSS sg13g2_fill_1
XFILLER_62_535 VDD VSS sg13g2_decap_8
XFILLER_90_855 VDD VSS sg13g2_fill_2
XFILLER_16_952 VDD VSS sg13g2_decap_8
X_12816_ _12816_/Y _12914_/A _12814_/Y _12815_/Y VDD VSS sg13g2_o21ai_1
X_13796_ _13796_/Q clkload17/A _13796_/D _13796_/RESET_B VDD VSS sg13g2_dfrbpq_1
XFILLER_43_760 VDD VSS sg13g2_decap_8
XFILLER_31_900 VDD VSS sg13g2_decap_8
XFILLER_76_1173 VDD VSS sg13g2_decap_8
XFILLER_72_1004 VDD VSS sg13g2_decap_8
XFILLER_37_1124 VDD VSS sg13g2_decap_8
XFILLER_128_1241 VDD VSS sg13g2_fill_1
XFILLER_15_462 VDD VSS sg13g2_decap_8
XFILLER_76_1184 VDD VSS sg13g2_fill_1
X_12747_ _12747_/X _12741_/X _12745_/X _12740_/X _12744_/X _12762_/S _12789_/S0 VDD
+ VSS sg13g2_mux4_1
X_14836__2872 _14836_/RESET_B VDD VSS sg13g2_tiehi
XFILLER_63_92 VDD VSS sg13g2_decap_4
XFILLER_8_21 VDD VSS sg13g2_decap_8
X_12678_ _12678_/X _12676_/X _12677_/X _12678_/S VDD VSS sg13g2_mux2_1
XFILLER_31_977 VDD VSS sg13g2_decap_8
XFILLER_31_999 VDD VSS sg13g2_decap_8
X_14164__2015 _14164_/RESET_B VDD VSS sg13g2_tiehi
X_14417_ _14417_/Q _14667_/CLK _14417_/D _14417_/RESET_B VDD VSS sg13g2_dfrbpq_1
X_11629_ _11629_/Y _14905_/Q _12267_/A2 _11625_/Y _11628_/Y VDD VSS sg13g2_a22oi_1
XFILLER_129_854 VDD VSS sg13g2_decap_4
XFILLER_129_865 VDD VSS sg13g2_fill_2
XFILLER_156_662 VDD VSS sg13g2_decap_8
XFILLER_8_98 VDD VSS sg13g2_decap_8
X_14348_ _14348_/Q clkload35/A _14348_/D _14348_/RESET_B VDD VSS sg13g2_dfrbpq_1
XFILLER_7_672 VDD VSS sg13g2_decap_8
XFILLER_116_537 VDD VSS sg13g2_decap_8
XFILLER_155_172 VDD VSS sg13g2_decap_8
XFILLER_171_621 VDD VSS sg13g2_decap_8
XFILLER_13_1190 VDD VSS sg13g2_decap_8
X_14279_ _14279_/Q _14735_/CLK _14279_/D _14279_/RESET_B VDD VSS sg13g2_dfrbpq_1
XFILLER_6_182 VDD VSS sg13g2_decap_8
XFILLER_143_367 VDD VSS sg13g2_decap_8
XFILLER_100_1182 VDD VSS sg13g2_fill_1
XFILLER_143_378 VDD VSS sg13g2_fill_2
XFILLER_87_1291 VDD VSS sg13g2_decap_8
XFILLER_112_710 VDD VSS sg13g2_decap_8
XFILLER_170_175 VDD VSS sg13g2_decap_8
XFILLER_124_581 VDD VSS sg13g2_decap_8
XFILLER_170_1103 VDD VSS sg13g2_fill_2
XFILLER_135_1223 VDD VSS sg13g2_decap_8
X_08840_ _08840_/Y _15023_/Q _10669_/S _10805_/B VDD VSS sg13g2_a21oi_1
XFILLER_48_1286 VDD VSS sg13g2_fill_1
XFILLER_69_145 VDD VSS sg13g2_decap_8
XFILLER_26_0 VDD VSS sg13g2_decap_8
XFILLER_170_1158 VDD VSS sg13g2_fill_2
XFILLER_85_627 VDD VSS sg13g2_decap_8
X_08771_ _13675_/D _08728_/Y _08770_/Y _08769_/Y VDD VSS sg13g2_a21oi_1
XFILLER_97_498 VDD VSS sg13g2_fill_1
X_14971__2616 _14971_/RESET_B VDD VSS sg13g2_tiehi
X_07722_ _07726_/A _15109_/Q _15104_/Q _15103_/Q _15100_/Q VDD VSS sg13g2_nor4_1
XFILLER_38_543 VDD VSS sg13g2_decap_8
XFILLER_38_554 VDD VSS sg13g2_fill_2
XFILLER_81_800 VDD VSS sg13g2_fill_2
XFILLER_26_716 VDD VSS sg13g2_decap_4
XFILLER_168_1021 VDD VSS sg13g2_decap_8
X_07653_ _07653_/Y _10510_/B VDD VSS sg13g2_inv_1
XFILLER_81_833 VDD VSS sg13g2_fill_2
XFILLER_26_738 VDD VSS sg13g2_decap_8
X_14374__1805 _14374_/RESET_B VDD VSS sg13g2_tiehi
XFILLER_20_1183 VDD VSS sg13g2_decap_8
XFILLER_0_1255 VDD VSS sg13g2_decap_8
XFILLER_25_259 VDD VSS sg13g2_decap_8
XFILLER_34_760 VDD VSS sg13g2_fill_1
X_09323_ _13930_/D _10153_/A1 _13930_/Q _09325_/S VDD VSS sg13g2_mux2_1
XFILLER_80_376 VDD VSS sg13g2_decap_8
XFILLER_167_916 VDD VSS sg13g2_decap_8
XFILLER_22_955 VDD VSS sg13g2_decap_8
X_09254_ _13863_/D _13863_/Q _09720_/A0 _09272_/S VDD VSS sg13g2_mux2_1
XFILLER_139_629 VDD VSS sg13g2_fill_2
X_08205_ _08211_/C _07888_/B _14995_/Q _08204_/Y VDD VSS sg13g2_o21ai_1
XFILLER_21_476 VDD VSS sg13g2_decap_8
XFILLER_166_448 VDD VSS sg13g2_decap_8
X_09185_ _13801_/D _13801_/Q _10152_/A1 _09201_/S VDD VSS sg13g2_mux2_1
XFILLER_147_651 VDD VSS sg13g2_fill_2
XFILLER_5_609 VDD VSS sg13g2_decap_8
X_08136_ _08145_/B _08402_/C _08133_/X _08135_/Y VDD VSS sg13g2_o21ai_1
XFILLER_105_1093 VDD VSS sg13g2_decap_8
XFILLER_119_386 VDD VSS sg13g2_decap_8
XFILLER_146_172 VDD VSS sg13g2_decap_8
XFILLER_4_119 VDD VSS sg13g2_decap_8
XFILLER_108_11 VDD VSS sg13g2_fill_2
X_08067_ _08067_/Y _08402_/C _08064_/X _08397_/A VDD VSS sg13g2_o21ai_1
XFILLER_104_7 VDD VSS sg13g2_decap_8
XFILLER_88_1088 VDD VSS sg13g2_fill_2
XFILLER_150_816 VDD VSS sg13g2_decap_8
XFILLER_153_1301 VDD VSS sg13g2_decap_8
XFILLER_161_175 VDD VSS sg13g2_decap_8
XFILLER_1_826 VDD VSS sg13g2_decap_8
XFILLER_103_721 VDD VSS sg13g2_decap_8
X_13862__2317 _13862_/RESET_B VDD VSS sg13g2_tiehi
XFILLER_89_955 VDD VSS sg13g2_decap_8
XFILLER_103_743 VDD VSS sg13g2_decap_8
XFILLER_0_336 VDD VSS sg13g2_decap_8
XFILLER_49_808 VDD VSS sg13g2_decap_8
XFILLER_27_1348 VDD VSS sg13g2_decap_8
XFILLER_153_1356 VDD VSS sg13g2_decap_8
XFILLER_124_21 VDD VSS sg13g2_decap_8
X_08969_ _08969_/X _08969_/A _09141_/A _10697_/B VDD VSS sg13g2_and3_1
XFILLER_25_1050 VDD VSS sg13g2_decap_8
XFILLER_84_14 VDD VSS sg13g2_decap_8
XFILLER_75_148 VDD VSS sg13g2_decap_8
X_11980_ _12006_/A _11980_/A _11983_/A VDD VSS sg13g2_nand2_1
XFILLER_75_159 VDD VSS sg13g2_fill_2
XFILLER_5_1155 VDD VSS sg13g2_decap_8
XFILLER_1_1008 VDD VSS sg13g2_decap_8
X_10931_ _10932_/B _14757_/Q _10954_/B VDD VSS sg13g2_nand2b_1
XFILLER_112_1086 VDD VSS sg13g2_decap_8
XFILLER_99_1184 VDD VSS sg13g2_fill_2
XFILLER_72_833 VDD VSS sg13g2_fill_2
XFILLER_17_749 VDD VSS sg13g2_decap_8
XFILLER_147_1116 VDD VSS sg13g2_decap_8
XFILLER_95_1048 VDD VSS sg13g2_fill_1
XFILLER_17_63 VDD VSS sg13g2_decap_8
XFILLER_140_42 VDD VSS sg13g2_decap_8
XFILLER_147_1127 VDD VSS sg13g2_fill_1
XFILLER_16_259 VDD VSS sg13g2_decap_8
X_13650_ _15116_/D _15185_/D _15116_/Q _13652_/S VDD VSS sg13g2_mux2_1
X_10862_ _10862_/Y _10862_/A _10862_/B VDD VSS sg13g2_nand2_1
XFILLER_32_708 VDD VSS sg13g2_decap_8
XFILLER_71_354 VDD VSS sg13g2_fill_2
X_12601_ _12601_/X _14125_/Q _14157_/Q _14189_/Q _14221_/Q _12601_/S0 _12601_/S1 VDD
+ VSS sg13g2_mux4_1
X_13581_ _13581_/Y _13581_/A _13584_/B VDD VSS sg13g2_nor2_1
XFILLER_169_231 VDD VSS sg13g2_decap_8
X_10793_ _10793_/X _10793_/A _10793_/B _10793_/C VDD VSS sg13g2_and3_1
XFILLER_13_966 VDD VSS sg13g2_decap_8
X_12532_ _12532_/X _14248_/Q _14280_/Q _14312_/Q _14344_/Q _12674_/S0 _12674_/S1 VDD
+ VSS sg13g2_mux4_1
XFILLER_160_1338 VDD VSS sg13g2_decap_8
XFILLER_12_476 VDD VSS sg13g2_decap_8
XFILLER_130_0 VDD VSS sg13g2_decap_8
XFILLER_9_959 VDD VSS sg13g2_decap_8
XFILLER_33_84 VDD VSS sg13g2_decap_8
X_12463_ _12463_/X _14563_/Q _14595_/Q _14627_/Q _14659_/Q _12546_/S0 _12546_/S1 VDD
+ VSS sg13g2_mux4_1
XFILLER_8_469 VDD VSS sg13g2_decap_8
XFILLER_32_1054 VDD VSS sg13g2_decap_8
XFILLER_172_407 VDD VSS sg13g2_decap_8
XFILLER_126_813 VDD VSS sg13g2_decap_8
X_14202_ _14202_/Q clkload44/A _14202_/D _14202_/RESET_B VDD VSS sg13g2_dfrbpq_1
X_11414_ _11424_/C _11411_/Y _11413_/X _12000_/A VDD VSS sg13g2_o21ai_1
X_15182_ _15182_/Q clkload66/A _15182_/D _15182_/RESET_B VDD VSS sg13g2_dfrbpq_1
X_12394_ _12394_/X _13950_/Q _13982_/Q _14014_/Q _14046_/Q _12592_/S0 _12592_/S1 VDD
+ VSS sg13g2_mux4_1
XFILLER_125_323 VDD VSS sg13g2_decap_8
XFILLER_10_1330 VDD VSS sg13g2_decap_8
X_14133_ _14133_/Q _14677_/CLK _14133_/D _14133_/RESET_B VDD VSS sg13g2_dfrbpq_1
X_11345_ _11345_/Y _11350_/A1 _13918_/Q _11894_/B VDD VSS sg13g2_a21oi_1
XFILLER_158_1267 VDD VSS sg13g2_fill_1
XFILLER_119_1229 VDD VSS sg13g2_decap_8
X_14064_ _14064_/Q clkload7/A _14064_/D _14064_/RESET_B VDD VSS sg13g2_dfrbpq_1
X_11276_ _11276_/Y _11275_/X _11266_/B _11274_/Y VDD VSS sg13g2_a21oi_1
XFILLER_4_686 VDD VSS sg13g2_decap_8
X_13015_ _13015_/Y _14780_/Q _13208_/A2 _13181_/B1 VDD VSS sg13g2_o21ai_1
X_14452__1727 _14452_/RESET_B VDD VSS sg13g2_tiehi
X_10227_ _14770_/D _10234_/D _13324_/A _10227_/C VDD VSS sg13g2_nor3_1
XFILLER_3_196 VDD VSS sg13g2_decap_8
X_13838__2341 _13838_/RESET_B VDD VSS sg13g2_tiehi
X_14598__1581 _14598_/RESET_B VDD VSS sg13g2_tiehi
XFILLER_80_1328 VDD VSS sg13g2_decap_8
XFILLER_80_1339 VDD VSS sg13g2_fill_1
XFILLER_79_465 VDD VSS sg13g2_fill_2
XFILLER_0_870 VDD VSS sg13g2_decap_8
X_10158_ _14735_/D _14735_/Q _09091_/Y _10160_/S VDD VSS sg13g2_mux2_1
XFILLER_43_1183 VDD VSS sg13g2_fill_1
X_14966_ _14966_/Q clkload28/A _14966_/D _14966_/RESET_B VDD VSS sg13g2_dfrbpq_1
X_10089_ _14669_/D _10123_/A0 _14669_/Q _10093_/S VDD VSS sg13g2_mux2_1
XFILLER_82_619 VDD VSS sg13g2_fill_2
XFILLER_48_885 VDD VSS sg13g2_fill_1
XFILLER_48_896 VDD VSS sg13g2_decap_8
X_13917_ _13917_/Q clkload45/A _13917_/D _13917_/RESET_B VDD VSS sg13g2_dfrbpq_1
XFILLER_169_1352 VDD VSS sg13g2_decap_8
XFILLER_75_693 VDD VSS sg13g2_decap_8
XFILLER_130_1197 VDD VSS sg13g2_decap_4
X_14897_ _14897_/Q clkload62/A _14897_/D _14897_/RESET_B VDD VSS sg13g2_dfrbpq_1
X_13848_ _13848_/Q _14744_/CLK _13848_/D _13848_/RESET_B VDD VSS sg13g2_dfrbpq_1
XFILLER_50_505 VDD VSS sg13g2_decap_4
XFILLER_62_398 VDD VSS sg13g2_decap_8
X_13779_ _13779_/Q clkload24/A _13779_/D _13779_/RESET_B VDD VSS sg13g2_dfrbpq_1
XFILLER_31_730 VDD VSS sg13g2_fill_2
XFILLER_149_916 VDD VSS sg13g2_decap_8
X_13940__2239 _13940_/RESET_B VDD VSS sg13g2_tiehi
XFILLER_102_1200 VDD VSS sg13g2_decap_8
XFILLER_164_919 VDD VSS sg13g2_fill_1
XFILLER_89_1320 VDD VSS sg13g2_fill_1
XFILLER_15_1274 VDD VSS sg13g2_decap_8
XFILLER_157_982 VDD VSS sg13g2_decap_8
XFILLER_116_301 VDD VSS sg13g2_decap_8
XFILLER_117_835 VDD VSS sg13g2_decap_8
XFILLER_11_1127 VDD VSS sg13g2_decap_8
XFILLER_128_183 VDD VSS sg13g2_fill_1
XFILLER_144_643 VDD VSS sg13g2_decap_8
XFILLER_116_345 VDD VSS sg13g2_fill_1
XFILLER_116_367 VDD VSS sg13g2_decap_4
X_09941_ _14525_/D _14525_/Q _10107_/A0 _09968_/S VDD VSS sg13g2_mux2_1
XFILLER_132_849 VDD VSS sg13g2_decap_8
XFILLER_125_890 VDD VSS sg13g2_decap_8
XFILLER_171_495 VDD VSS sg13g2_decap_8
Xfanout905 _13289_/C _15208_/Q VDD VSS sg13g2_buf_1
XFILLER_135_1020 VDD VSS sg13g2_decap_8
Xfanout916 _12542_/A2 _15206_/Q VDD VSS sg13g2_buf_1
XFILLER_131_359 VDD VSS sg13g2_decap_8
Xfanout927 _13566_/C _13563_/C VDD VSS sg13g2_buf_1
X_09872_ _09904_/S _09905_/A _09938_/B _10070_/A _10037_/B VDD VSS sg13g2_nand4_1
XFILLER_140_860 VDD VSS sg13g2_decap_8
X_14428__1751 _14428_/RESET_B VDD VSS sg13g2_tiehi
Xfanout938 _10201_/A1 _15182_/Q VDD VSS sg13g2_buf_1
XFILLER_112_562 VDD VSS sg13g2_decap_8
Xfanout949 _13028_/B _13013_/B VDD VSS sg13g2_buf_1
X_08823_ _13691_/D _08821_/Y _08820_/Y _08822_/Y VDD VSS sg13g2_a21oi_1
XFILLER_85_413 VDD VSS sg13g2_decap_8
XFILLER_57_104 VDD VSS sg13g2_decap_8
XFILLER_112_595 VDD VSS sg13g2_decap_8
XFILLER_135_1097 VDD VSS sg13g2_decap_8
X_13666__2540 _13666_/RESET_B VDD VSS sg13g2_tiehi
XFILLER_22_1212 VDD VSS sg13g2_decap_8
XFILLER_100_768 VDD VSS sg13g2_fill_2
X_08754_ _08754_/Y _08760_/A1 _08754_/A2 _15192_/Q VDD VSS sg13g2_o21ai_1
XFILLER_38_340 VDD VSS sg13g2_decap_8
X_07705_ _15201_/D _07705_/A _07705_/B _07705_/C VDD VSS sg13g2_nand3_1
XFILLER_66_671 VDD VSS sg13g2_fill_1
X_08685_ _15248_/D _08395_/A _08684_/X _08676_/Y VDD VSS sg13g2_o21ai_1
XFILLER_66_693 VDD VSS sg13g2_decap_8
XFILLER_38_395 VDD VSS sg13g2_decap_4
XFILLER_22_1289 VDD VSS sg13g2_decap_8
XFILLER_54_28 VDD VSS sg13g2_decap_8
X_14917__2710 _14917_/RESET_B VDD VSS sg13g2_tiehi
X_07636_ _07636_/Y _15009_/Q VDD VSS sg13g2_inv_1
XFILLER_0_1052 VDD VSS sg13g2_decap_8
XFILLER_80_173 VDD VSS sg13g2_decap_8
XFILLER_41_527 VDD VSS sg13g2_decap_8
XFILLER_55_1043 VDD VSS sg13g2_decap_4
X_09306_ _13914_/D _13914_/Q _10169_/A1 _09306_/S VDD VSS sg13g2_mux2_1
XFILLER_22_752 VDD VSS sg13g2_decap_8
XFILLER_10_903 VDD VSS sg13g2_decap_8
XFILLER_167_746 VDD VSS sg13g2_decap_8
XFILLER_107_1166 VDD VSS sg13g2_decap_8
X_14530__1649 _14530_/RESET_B VDD VSS sg13g2_tiehi
X_09237_ _13848_/D _10100_/A0 _13848_/Q _09237_/S VDD VSS sg13g2_mux2_1
XFILLER_33_1330 VDD VSS sg13g2_decap_8
XFILLER_21_273 VDD VSS sg13g2_decap_8
XFILLER_166_245 VDD VSS sg13g2_decap_8
X_13916__2263 _13916_/RESET_B VDD VSS sg13g2_tiehi
XFILLER_108_802 VDD VSS sg13g2_decap_8
XFILLER_119_21 VDD VSS sg13g2_decap_8
XFILLER_5_406 VDD VSS sg13g2_decap_8
X_09168_ _10070_/B _09441_/A _10004_/B _09441_/C VDD VSS sg13g2_and3_1
X_14784__2929 _14784_/RESET_B VDD VSS sg13g2_tiehi
XFILLER_135_643 VDD VSS sg13g2_decap_8
X_08119_ _08119_/X _08470_/B _08519_/A2 _08559_/A3 _08591_/A3 _13509_/A1 _13510_/A1
+ VDD VSS sg13g2_mux4_1
XFILLER_79_14 VDD VSS sg13g2_decap_8
XFILLER_108_868 VDD VSS sg13g2_fill_1
X_09099_ _13776_/D _13776_/Q _10159_/A1 _09106_/S VDD VSS sg13g2_mux2_1
X_14820__2893 _14820_/RESET_B VDD VSS sg13g2_tiehi
X_11130_ _11130_/Y _11129_/Y _11127_/Y _11114_/X _11117_/Y _11207_/A2 VDD VSS sg13g2_a221oi_1
XFILLER_134_175 VDD VSS sg13g2_fill_2
XFILLER_116_890 VDD VSS sg13g2_decap_8
XFILLER_150_635 VDD VSS sg13g2_decap_8
XFILLER_162_495 VDD VSS sg13g2_decap_8
XFILLER_1_623 VDD VSS sg13g2_decap_8
XFILLER_66_1161 VDD VSS sg13g2_decap_8
XFILLER_135_42 VDD VSS sg13g2_decap_8
XFILLER_150_668 VDD VSS sg13g2_decap_8
XFILLER_153_1120 VDD VSS sg13g2_decap_8
X_11061_ _11061_/Y _11068_/C _11061_/A2 _14760_/Q _11033_/B VDD VSS sg13g2_a22oi_1
XFILLER_0_133 VDD VSS sg13g2_decap_8
XFILLER_89_763 VDD VSS sg13g2_fill_1
XFILLER_131_860 VDD VSS sg13g2_decap_4
XFILLER_62_1025 VDD VSS sg13g2_fill_2
XFILLER_27_1145 VDD VSS sg13g2_decap_8
XFILLER_103_562 VDD VSS sg13g2_decap_8
Xhold3050 hold3050/X input35/X VDD VSS sg13g2_dlygate4sd3_1
Xhold3061 hold3061/X input24/X VDD VSS sg13g2_dlygate4sd3_1
X_10012_ _14594_/D _10012_/A0 _14594_/Q _10032_/S VDD VSS sg13g2_mux2_1
XFILLER_135_86 VDD VSS sg13g2_fill_1
X_15128__2703 _15128_/RESET_B VDD VSS sg13g2_tiehi
Xhold3072 input16/A mem_axi_rdata[20] VDD VSS sg13g2_dlygate4sd3_1
XFILLER_95_35 VDD VSS sg13g2_decap_8
XFILLER_7_1239 VDD VSS sg13g2_decap_8
XFILLER_48_104 VDD VSS sg13g2_decap_4
Xhold3083 hold3083/X input13/X VDD VSS sg13g2_dlygate4sd3_1
Xhold3094 input36/A mem_axi_rvalid VDD VSS sg13g2_dlygate4sd3_1
X_14820_ _14820_/Q _14886_/CLK _14820_/D _14820_/RESET_B VDD VSS sg13g2_dfrbpq_1
XFILLER_29_340 VDD VSS sg13g2_decap_4
XFILLER_40_1345 VDD VSS sg13g2_decap_8
XFILLER_57_682 VDD VSS sg13g2_decap_8
XFILLER_28_84 VDD VSS sg13g2_decap_8
XFILLER_151_63 VDD VSS sg13g2_decap_8
X_14751_ _14751_/Q clkload65/A _14751_/D _14751_/RESET_B VDD VSS sg13g2_dfrbpq_1
X_11963_ _11964_/A _14256_/Q _14288_/Q _14320_/Q _14352_/Q _11963_/S0 _11970_/C VDD
+ VSS sg13g2_mux4_1
XFILLER_151_85 VDD VSS sg13g2_decap_8
XFILLER_17_546 VDD VSS sg13g2_decap_8
X_13702_ _16864_/A clkload57/A _13702_/D _13702_/RESET_B VDD VSS sg13g2_dfrbpq_1
X_15231__2999 _15231_/RESET_B VDD VSS sg13g2_tiehi
XFILLER_44_343 VDD VSS sg13g2_decap_8
X_10914_ _10914_/Y _10914_/A _11021_/B VDD VSS sg13g2_nand2_1
XFILLER_45_877 VDD VSS sg13g2_fill_1
X_14682_ _14682_/Q _14682_/CLK _14682_/D _14682_/RESET_B VDD VSS sg13g2_dfrbpq_1
X_11894_ _11898_/A _11893_/X _11894_/B VDD VSS sg13g2_nand2b_1
X_13633_ _13741_/D _13633_/A VDD VSS sg13g2_buf_1
X_10845_ _10845_/Y _10876_/D _10876_/A _10843_/C VDD VSS sg13g2_a21oi_1
XFILLER_60_847 VDD VSS sg13g2_decap_8
XFILLER_13_763 VDD VSS sg13g2_decap_8
XFILLER_164_1282 VDD VSS sg13g2_decap_4
X_13564_ _13564_/Y _07910_/A _13567_/A2 _13563_/Y VDD VSS sg13g2_a21oi_1
X_10776_ _10776_/X _10776_/A _10781_/B _10776_/C VDD VSS sg13g2_and3_1
XFILLER_38_1296 VDD VSS sg13g2_decap_4
XFILLER_34_1127 VDD VSS sg13g2_decap_8
XFILLER_160_1135 VDD VSS sg13g2_decap_8
XFILLER_12_273 VDD VSS sg13g2_decap_8
XFILLER_146_908 VDD VSS sg13g2_decap_8
X_12515_ _12515_/X _13831_/Q _13863_/Q _13895_/Q _13927_/Q _12522_/S0 _12522_/S1 VDD
+ VSS sg13g2_mux4_1
XFILLER_146_919 VDD VSS sg13g2_fill_1
X_13495_ _13495_/Y _15129_/Q _15071_/Q _08826_/B VDD VSS sg13g2_o21ai_1
XFILLER_9_756 VDD VSS sg13g2_decap_8
XFILLER_139_971 VDD VSS sg13g2_decap_8
XFILLER_145_407 VDD VSS sg13g2_decap_8
X_14506__1673 _14506_/RESET_B VDD VSS sg13g2_tiehi
X_15234_ _15234_/Q clkload57/A _15234_/D _15234_/RESET_B VDD VSS sg13g2_dfrbpq_1
X_12446_ _12446_/X _13730_/Q _14082_/Q _14434_/Q _14530_/Q _12450_/S0 _12450_/S1 VDD
+ VSS sg13g2_mux4_1
XFILLER_8_266 VDD VSS sg13g2_decap_8
XFILLER_67_7 VDD VSS sg13g2_decap_8
XFILLER_172_248 VDD VSS sg13g2_fill_1
XFILLER_125_120 VDD VSS sg13g2_decap_8
XFILLER_126_654 VDD VSS sg13g2_decap_8
XFILLER_153_440 VDD VSS sg13g2_fill_2
X_15165_ _15165_/Q clkload70/A _15165_/D _15165_/RESET_B VDD VSS sg13g2_dfrbpq_1
X_12377_ _12377_/X _13821_/Q _13853_/Q _13885_/Q _13917_/Q _12396_/S0 _12396_/S1 VDD
+ VSS sg13g2_mux4_1
XFILLER_126_687 VDD VSS sg13g2_decap_8
XFILLER_5_973 VDD VSS sg13g2_decap_8
X_14116_ _14116_/Q clkload17/A _14116_/D _14116_/RESET_B VDD VSS sg13g2_dfrbpq_1
X_11328_ _11328_/X _13949_/Q _13981_/Q _14013_/Q _14045_/Q _11328_/S0 _11328_/S1 VDD
+ VSS sg13g2_mux4_1
XFILLER_99_527 VDD VSS sg13g2_decap_4
XFILLER_140_101 VDD VSS sg13g2_decap_8
XFILLER_158_1075 VDD VSS sg13g2_decap_8
X_15096_ _15096_/Q clkload67/A _15096_/D _15096_/RESET_B VDD VSS sg13g2_dfrbpq_1
XFILLER_5_77 VDD VSS sg13g2_decap_8
XFILLER_4_483 VDD VSS sg13g2_decap_8
XFILLER_119_1048 VDD VSS sg13g2_decap_8
XFILLER_45_1212 VDD VSS sg13g2_decap_8
X_14047_ _14047_/Q clkload9/A _14047_/D _14047_/RESET_B VDD VSS sg13g2_dfrbpq_1
X_11259_ _11259_/Y _12326_/A1 _13820_/Q VDD VSS sg13g2_nand2b_1
XFILLER_171_1220 VDD VSS sg13g2_fill_2
XFILLER_136_1351 VDD VSS sg13g2_decap_8
XFILLER_141_679 VDD VSS sg13g2_decap_4
XFILLER_79_240 VDD VSS sg13g2_fill_2
XFILLER_171_1242 VDD VSS sg13g2_fill_2
XFILLER_122_871 VDD VSS sg13g2_decap_4
XFILLER_80_1136 VDD VSS sg13g2_fill_1
XFILLER_136_1373 VDD VSS sg13g2_decap_8
XFILLER_95_722 VDD VSS sg13g2_fill_2
XFILLER_68_936 VDD VSS sg13g2_decap_8
XFILLER_45_1278 VDD VSS sg13g2_decap_8
XFILLER_39_137 VDD VSS sg13g2_decap_8
XFILLER_55_608 VDD VSS sg13g2_fill_2
XFILLER_94_287 VDD VSS sg13g2_decap_8
XFILLER_82_427 VDD VSS sg13g2_decap_8
XFILLER_85_90 VDD VSS sg13g2_fill_2
XFILLER_48_682 VDD VSS sg13g2_decap_8
X_14949_ _14949_/Q clkload42/A _14949_/D _14949_/RESET_B VDD VSS sg13g2_dfrbpq_1
XFILLER_48_693 VDD VSS sg13g2_fill_2
XFILLER_63_630 VDD VSS sg13g2_fill_2
X_08470_ _08475_/B _08541_/A _08470_/B _15008_/Q VDD VSS sg13g2_and3_1
XFILLER_63_663 VDD VSS sg13g2_decap_4
XFILLER_78_1087 VDD VSS sg13g2_decap_8
XFILLER_1_1372 VDD VSS sg13g2_decap_8
XFILLER_1_1383 VDD VSS sg13g2_fill_1
XFILLER_165_1057 VDD VSS sg13g2_decap_8
XFILLER_51_847 VDD VSS sg13g2_decap_4
XFILLER_93_0 VDD VSS sg13g2_decap_8
XFILLER_17_1358 VDD VSS sg13g2_decap_8
XFILLER_104_1317 VDD VSS sg13g2_decap_4
XFILLER_148_245 VDD VSS sg13g2_decap_8
XFILLER_164_705 VDD VSS sg13g2_decap_8
XFILLER_136_407 VDD VSS sg13g2_fill_1
X_09022_ _09024_/B _12957_/A _10702_/A _14902_/Q _09022_/D VDD VSS sg13g2_nand4_1
XFILLER_15_1071 VDD VSS sg13g2_decap_8
XFILLER_117_643 VDD VSS sg13g2_decap_8
XFILLER_163_259 VDD VSS sg13g2_decap_8
XFILLER_144_484 VDD VSS sg13g2_fill_1
XFILLER_160_944 VDD VSS sg13g2_decap_8
XFILLER_137_1137 VDD VSS sg13g2_fill_2
XFILLER_49_28 VDD VSS sg13g2_decap_8
XFILLER_160_966 VDD VSS sg13g2_decap_4
XFILLER_120_808 VDD VSS sg13g2_fill_2
XFILLER_160_977 VDD VSS sg13g2_decap_8
Xfanout702 _12290_/S0 _11443_/A VDD VSS sg13g2_buf_1
X_09924_ _14509_/D _14509_/Q _09924_/A1 _09928_/S VDD VSS sg13g2_mux2_1
XFILLER_132_679 VDD VSS sg13g2_fill_1
Xfanout713 _11329_/B1 _11881_/C1 VDD VSS sg13g2_buf_1
XFILLER_59_903 VDD VSS sg13g2_decap_8
Xfanout724 _11739_/B _07654_/Y VDD VSS sg13g2_buf_1
Xfanout735 _11145_/A _11185_/A VDD VSS sg13g2_buf_1
Xfanout746 _08254_/S _08431_/D VDD VSS sg13g2_buf_1
Xfanout757 _08110_/C _07629_/Y VDD VSS sg13g2_buf_1
X_09855_ _14442_/D _14442_/Q _10086_/A0 _09862_/S VDD VSS sg13g2_mux2_1
Xfanout768 _11044_/C _11029_/C VDD VSS sg13g2_buf_1
XFILLER_86_744 VDD VSS sg13g2_decap_8
XFILLER_63_1378 VDD VSS sg13g2_fill_2
XFILLER_58_435 VDD VSS sg13g2_fill_1
Xfanout779 _12789_/S1 fanout783/X VDD VSS sg13g2_buf_1
XFILLER_100_543 VDD VSS sg13g2_fill_2
XFILLER_105_56 VDD VSS sg13g2_decap_8
X_08806_ _08808_/A _10797_/A _14752_/Q _08727_/X _15195_/Q _08825_/C1 VDD VSS sg13g2_a221oi_1
X_09786_ _14375_/D _09918_/A1 _14375_/Q _09800_/S VDD VSS sg13g2_mux2_1
XFILLER_27_800 VDD VSS sg13g2_fill_2
XFILLER_67_991 VDD VSS sg13g2_decap_4
X_08737_ _08737_/Y _13664_/Q _08781_/B VDD VSS sg13g2_nor2_1
XFILLER_171_7 VDD VSS sg13g2_decap_8
XFILLER_66_490 VDD VSS sg13g2_decap_8
XFILLER_22_1086 VDD VSS sg13g2_decap_8
XFILLER_2_1169 VDD VSS sg13g2_decap_8
XFILLER_27_866 VDD VSS sg13g2_fill_2
X_08668_ _08668_/X _08668_/A _08668_/B VDD VSS sg13g2_or2_1
XFILLER_26_365 VDD VSS sg13g2_decap_4
XFILLER_96_1176 VDD VSS sg13g2_decap_8
XFILLER_81_460 VDD VSS sg13g2_decap_8
XFILLER_82_994 VDD VSS sg13g2_fill_2
XFILLER_57_1138 VDD VSS sg13g2_decap_8
XFILLER_92_1029 VDD VSS sg13g2_decap_8
XFILLER_53_173 VDD VSS sg13g2_fill_2
XFILLER_42_836 VDD VSS sg13g2_decap_8
X_07619_ _09011_/C _14900_/Q VDD VSS sg13g2_inv_1
X_08599_ _08600_/D _08599_/A _08599_/B _08599_/C VDD VSS sg13g2_nor3_1
X_10630_ _14884_/D _10630_/A _10630_/B _10630_/C VDD VSS sg13g2_and3_1
X_15157__2643 _15157_/RESET_B VDD VSS sg13g2_tiehi
XFILLER_14_42 VDD VSS sg13g2_decap_8
XFILLER_10_700 VDD VSS sg13g2_decap_8
XFILLER_167_532 VDD VSS sg13g2_decap_8
XFILLER_139_245 VDD VSS sg13g2_decap_8
X_10561_ _10653_/A _10561_/A _10561_/B _10561_/C _10561_/D VDD VSS sg13g2_nor4_1
X_12300_ _12300_/Y _12300_/A _13662_/Q VDD VSS sg13g2_xnor2_1
XFILLER_10_777 VDD VSS sg13g2_decap_8
X_13280_ _13281_/A _08831_/B _07752_/Y _13279_/Y VDD VSS sg13g2_a21oi_1
XFILLER_108_610 VDD VSS sg13g2_decap_8
XFILLER_155_749 VDD VSS sg13g2_decap_8
X_10492_ _10492_/Y _10513_/D _14850_/Q _10492_/C _10508_/C VDD VSS sg13g2_nand4_1
XFILLER_5_203 VDD VSS sg13g2_decap_8
XFILLER_33_1171 VDD VSS sg13g2_decap_8
X_12231_ _12231_/X _12231_/A _12231_/B VDD VSS sg13g2_xor2_1
XFILLER_135_440 VDD VSS sg13g2_decap_8
XFILLER_159_1340 VDD VSS sg13g2_decap_8
XFILLER_170_719 VDD VSS sg13g2_decap_8
XFILLER_163_771 VDD VSS sg13g2_decap_8
XFILLER_30_63 VDD VSS sg13g2_decap_8
XFILLER_123_624 VDD VSS sg13g2_decap_8
X_12162_ _12163_/A _13974_/Q _14006_/Q _14038_/Q _14070_/Q _12168_/A _12018_/C VDD
+ VSS sg13g2_mux4_1
XFILLER_2_910 VDD VSS sg13g2_decap_8
XFILLER_146_63 VDD VSS sg13g2_decap_8
XFILLER_68_1267 VDD VSS sg13g2_fill_1
XFILLER_162_292 VDD VSS sg13g2_decap_8
X_11113_ _11113_/Y _14950_/Q _11133_/B VDD VSS sg13g2_nand2_1
XFILLER_1_420 VDD VSS sg13g2_decap_8
XFILLER_123_679 VDD VSS sg13g2_decap_8
XFILLER_151_988 VDD VSS sg13g2_fill_1
X_12093_ _12094_/A _13972_/Q _14004_/Q _14036_/Q _14068_/Q _12100_/S0 _12091_/C VDD
+ VSS sg13g2_mux4_1
XFILLER_122_156 VDD VSS sg13g2_decap_8
XFILLER_77_700 VDD VSS sg13g2_decap_4
XFILLER_104_871 VDD VSS sg13g2_fill_2
XFILLER_2_987 VDD VSS sg13g2_decap_8
XFILLER_118_1070 VDD VSS sg13g2_decap_8
X_11044_ _11046_/A _11044_/A _11044_/B _11044_/C VDD VSS sg13g2_nand3_1
XFILLER_150_498 VDD VSS sg13g2_decap_8
XFILLER_7_1036 VDD VSS sg13g2_decap_8
XFILLER_1_497 VDD VSS sg13g2_decap_8
XFILLER_39_83 VDD VSS sg13g2_decap_4
XFILLER_49_457 VDD VSS sg13g2_decap_8
XFILLER_162_84 VDD VSS sg13g2_decap_8
X_14803_ _14803_/Q _14868_/CLK _14803_/D _14803_/RESET_B VDD VSS sg13g2_dfrbpq_1
XFILLER_64_427 VDD VSS sg13g2_decap_4
XFILLER_91_224 VDD VSS sg13g2_decap_8
XFILLER_18_833 VDD VSS sg13g2_decap_8
X_12995_ _13005_/A _13010_/A _13308_/A _12995_/C VDD VSS sg13g2_nand3_1
XFILLER_92_769 VDD VSS sg13g2_decap_8
XFILLER_166_1300 VDD VSS sg13g2_fill_2
XFILLER_17_343 VDD VSS sg13g2_decap_8
X_14734_ _14734_/Q _14734_/CLK _14734_/D _14734_/RESET_B VDD VSS sg13g2_dfrbpq_1
XFILLER_79_1374 VDD VSS sg13g2_decap_8
XFILLER_166_1333 VDD VSS sg13g2_fill_1
X_11946_ _11946_/X _11946_/A _11964_/B VDD VSS sg13g2_and2_1
XFILLER_91_279 VDD VSS sg13g2_fill_1
XFILLER_33_814 VDD VSS sg13g2_decap_8
XFILLER_60_622 VDD VSS sg13g2_decap_8
XFILLER_75_1249 VDD VSS sg13g2_decap_8
XFILLER_127_1328 VDD VSS sg13g2_decap_8
X_13788__2391 _13788_/RESET_B VDD VSS sg13g2_tiehi
X_14665_ _14665_/Q clkload21/A _14665_/D _14665_/RESET_B VDD VSS sg13g2_dfrbpq_1
XFILLER_72_493 VDD VSS sg13g2_decap_4
XFILLER_127_1339 VDD VSS sg13g2_fill_1
X_11877_ _11877_/Y _11217_/S _14574_/Q VDD VSS sg13g2_nand2b_1
XFILLER_44_195 VDD VSS sg13g2_fill_2
X_15169__2491 _15169_/RESET_B VDD VSS sg13g2_tiehi
X_13616_ _13724_/D _13616_/A VDD VSS sg13g2_buf_1
Xclkbuf_5_16__f_clk_i clkbuf_leaf_99_clk_i/A clkbuf_4_8_0_clk_i/X VDD VSS sg13g2_buf_16
X_10828_ _10831_/B _10851_/D _12347_/B VDD VSS sg13g2_nand2_1
XFILLER_125_1030 VDD VSS sg13g2_fill_2
XFILLER_13_560 VDD VSS sg13g2_decap_8
X_14596_ _14596_/Q _14660_/CLK _14596_/D _14596_/RESET_B VDD VSS sg13g2_dfrbpq_1
X_14739__1440 _14739_/RESET_B VDD VSS sg13g2_tiehi
XFILLER_125_1041 VDD VSS sg13g2_decap_8
XFILLER_158_532 VDD VSS sg13g2_decap_8
XFILLER_158_543 VDD VSS sg13g2_fill_1
X_13547_ _13547_/Y _13547_/A _13565_/S VDD VSS sg13g2_nor2_1
XFILLER_125_1074 VDD VSS sg13g2_fill_2
X_10759_ _10759_/X _14948_/Q _10757_/A _10757_/Y VDD VSS sg13g2_a21o_1
XFILLER_9_553 VDD VSS sg13g2_decap_8
X_14022__2157 _14022_/RESET_B VDD VSS sg13g2_tiehi
XFILLER_12_1211 VDD VSS sg13g2_decap_8
XFILLER_146_738 VDD VSS sg13g2_decap_8
X_14901__2742 _14901_/RESET_B VDD VSS sg13g2_tiehi
X_13478_ _15113_/D _15179_/D _15113_/Q _13499_/A VDD VSS sg13g2_mux2_1
XFILLER_69_1009 VDD VSS sg13g2_fill_1
XFILLER_127_941 VDD VSS sg13g2_fill_2
XFILLER_161_708 VDD VSS sg13g2_decap_8
X_15217_ _15217_/Q clkload69/A _15217_/D _15217_/RESET_B VDD VSS sg13g2_dfrbpq_1
X_12429_ _12429_/Y _13688_/Q _12358_/Y _12428_/X _12791_/B2 _12443_/A2 VDD VSS sg13g2_a221oi_1
XFILLER_12_1288 VDD VSS sg13g2_decap_8
XFILLER_114_613 VDD VSS sg13g2_fill_2
XFILLER_5_770 VDD VSS sg13g2_decap_8
XFILLER_142_933 VDD VSS sg13g2_decap_4
X_15148_ _15148_/Q clkload60/A _15148_/D _15148_/RESET_B VDD VSS sg13g2_dfrbpq_1
XFILLER_47_1329 VDD VSS sg13g2_decap_8
XFILLER_153_292 VDD VSS sg13g2_decap_8
XFILLER_4_280 VDD VSS sg13g2_decap_8
X_14934__2676 _14934_/RESET_B VDD VSS sg13g2_tiehi
X_07970_ _07976_/A _08697_/B _07834_/A _07981_/C VDD VSS sg13g2_o21ai_1
XFILLER_142_988 VDD VSS sg13g2_decap_8
X_15079_ _15079_/Q clkload70/A _15079_/D _15079_/RESET_B VDD VSS sg13g2_dfrbpq_1
XFILLER_45_1020 VDD VSS sg13g2_decap_8
XFILLER_142_999 VDD VSS sg13g2_fill_1
X_13890__2289 _13890_/RESET_B VDD VSS sg13g2_tiehi
XFILLER_101_329 VDD VSS sg13g2_decap_8
XFILLER_113_189 VDD VSS sg13g2_fill_2
XFILLER_67_210 VDD VSS sg13g2_decap_8
XFILLER_68_766 VDD VSS sg13g2_decap_8
XFILLER_45_1086 VDD VSS sg13g2_decap_8
XFILLER_171_1083 VDD VSS sg13g2_decap_8
X_09640_ _09740_/B _09839_/C _09640_/B _09640_/C VDD VSS sg13g2_nand3b_1
XFILLER_171_1094 VDD VSS sg13g2_fill_1
XFILLER_110_874 VDD VSS sg13g2_decap_8
X_09571_ _14169_/D _10068_/A0 _14169_/Q _09571_/S VDD VSS sg13g2_mux2_1
XFILLER_55_449 VDD VSS sg13g2_fill_2
X_08522_ _08526_/B _08522_/A _08548_/B _08522_/C VDD VSS sg13g2_nand3_1
XFILLER_70_408 VDD VSS sg13g2_decap_8
XFILLER_64_961 VDD VSS sg13g2_decap_8
X_08453_ _08454_/C _07805_/B _08493_/B2 _08001_/A VDD VSS sg13g2_a21oi_1
X_14232__1947 _14232_/RESET_B VDD VSS sg13g2_tiehi
X_15112__2735 _15112_/RESET_B VDD VSS sg13g2_tiehi
XFILLER_35_195 VDD VSS sg13g2_decap_8
XFILLER_23_357 VDD VSS sg13g2_decap_8
XFILLER_168_329 VDD VSS sg13g2_decap_8
XFILLER_56_1160 VDD VSS sg13g2_fill_2
X_08384_ _08385_/C _08384_/A1 _08383_/B _08001_/A VDD VSS sg13g2_a21oi_1
XFILLER_143_1141 VDD VSS sg13g2_fill_2
XFILLER_17_1155 VDD VSS sg13g2_decap_8
XFILLER_149_554 VDD VSS sg13g2_fill_2
XFILLER_13_1008 VDD VSS sg13g2_decap_8
XFILLER_143_1174 VDD VSS sg13g2_fill_1
XFILLER_149_587 VDD VSS sg13g2_decap_8
XFILLER_164_546 VDD VSS sg13g2_decap_8
X_09005_ _09022_/D _09011_/B _09011_/C _09011_/D VDD VSS sg13g2_nor3_1
XFILLER_3_707 VDD VSS sg13g2_decap_8
XFILLER_30_1366 VDD VSS sg13g2_decap_8
XFILLER_2_217 VDD VSS sg13g2_decap_8
X_15230__2998 _15230_/RESET_B VDD VSS sg13g2_tiehi
XFILLER_144_281 VDD VSS sg13g2_decap_4
X_14177__2002 _14177_/RESET_B VDD VSS sg13g2_tiehi
XFILLER_104_145 VDD VSS sg13g2_fill_1
XFILLER_133_988 VDD VSS sg13g2_decap_4
Xfanout510 _13584_/B _13570_/S VDD VSS sg13g2_buf_1
XFILLER_160_785 VDD VSS sg13g2_decap_8
X_13720__2459 _13720_/RESET_B VDD VSS sg13g2_tiehi
Xfanout521 _12001_/A _11236_/C VDD VSS sg13g2_buf_1
XFILLER_8_1323 VDD VSS sg13g2_decap_8
X_14480__1699 _14480_/RESET_B VDD VSS sg13g2_tiehi
Xfanout532 _09774_/A0 _09906_/A1 VDD VSS sg13g2_buf_1
X_09907_ _14492_/D _14492_/Q _09907_/A1 _09931_/S VDD VSS sg13g2_mux2_1
XFILLER_59_722 VDD VSS sg13g2_decap_8
XFILLER_120_649 VDD VSS sg13g2_fill_1
Xfanout543 _08775_/B _08761_/B VDD VSS sg13g2_buf_1
XFILLER_28_1273 VDD VSS sg13g2_decap_8
Xfanout554 _08637_/B _08110_/D VDD VSS sg13g2_buf_1
XFILLER_58_221 VDD VSS sg13g2_decap_8
Xfanout565 _13140_/B2 _13275_/B1 VDD VSS sg13g2_buf_1
XFILLER_63_1175 VDD VSS sg13g2_decap_8
XFILLER_101_852 VDD VSS sg13g2_decap_8
XFILLER_63_1186 VDD VSS sg13g2_fill_1
XFILLER_47_906 VDD VSS sg13g2_fill_2
Xfanout576 _11792_/B _11904_/A2 VDD VSS sg13g2_buf_1
Xfanout587 _10941_/B _10670_/Y VDD VSS sg13g2_buf_1
X_09838_ _14426_/D _09937_/A1 _14426_/Q _09838_/S VDD VSS sg13g2_mux2_1
XFILLER_24_1148 VDD VSS sg13g2_decap_8
Xfanout598 _10767_/A _10747_/A VDD VSS sg13g2_buf_1
XFILLER_58_265 VDD VSS sg13g2_decap_4
XFILLER_98_1227 VDD VSS sg13g2_decap_8
XFILLER_59_799 VDD VSS sg13g2_decap_8
XFILLER_132_21 VDD VSS sg13g2_decap_8
X_09769_ _14359_/D _14359_/Q _09934_/A1 _09769_/S VDD VSS sg13g2_mux2_1
XFILLER_73_246 VDD VSS sg13g2_decap_8
XFILLER_132_65 VDD VSS sg13g2_fill_1
XFILLER_92_14 VDD VSS sg13g2_decap_8
XFILLER_27_641 VDD VSS sg13g2_decap_8
X_14100__2079 _14100_/RESET_B VDD VSS sg13g2_tiehi
X_11800_ _11800_/Y _12056_/A _11800_/B VDD VSS sg13g2_xnor2_1
XFILLER_92_25 VDD VSS sg13g2_fill_2
XFILLER_132_87 VDD VSS sg13g2_decap_8
XFILLER_26_140 VDD VSS sg13g2_decap_8
X_12780_ _12780_/X _14138_/Q _14170_/Q _14202_/Q _14234_/Q _12783_/S0 _12783_/S1 VDD
+ VSS sg13g2_mux4_1
XFILLER_27_674 VDD VSS sg13g2_fill_2
XFILLER_15_847 VDD VSS sg13g2_decap_8
X_11731_ _11731_/Y _11749_/A1 _14154_/Q _11897_/C VDD VSS sg13g2_a21oi_1
X_14208__1971 _14208_/RESET_B VDD VSS sg13g2_tiehi
XFILLER_25_63 VDD VSS sg13g2_decap_8
XFILLER_14_357 VDD VSS sg13g2_decap_8
XFILLER_42_666 VDD VSS sg13g2_fill_1
XFILLER_159_329 VDD VSS sg13g2_decap_8
X_14450_ _14450_/Q _14706_/CLK _14450_/D _14450_/RESET_B VDD VSS sg13g2_dfrbpq_1
X_14984__2603 _14984_/RESET_B VDD VSS sg13g2_tiehi
X_11662_ _11664_/B _11663_/A _11663_/B _11773_/B VDD VSS sg13g2_a21oi_1
XFILLER_109_1069 VDD VSS sg13g2_decap_8
X_13401_ _13433_/A _13396_/C _13401_/B _13401_/C VDD VSS sg13g2_nand3b_1
XFILLER_126_1372 VDD VSS sg13g2_decap_8
XFILLER_161_1252 VDD VSS sg13g2_fill_2
X_10613_ _10625_/D _10613_/A _10614_/B VDD VSS sg13g2_nor2_1
X_14381_ _14381_/Q clkload10/A _14381_/D _14381_/RESET_B VDD VSS sg13g2_dfrbpq_1
X_11593_ _11593_/Y _11636_/C _11593_/B VDD VSS sg13g2_xnor2_1
XFILLER_122_1225 VDD VSS sg13g2_fill_2
XFILLER_127_204 VDD VSS sg13g2_decap_4
X_13332_ _15175_/D hold3025/X _15175_/Q _13477_/S VDD VSS sg13g2_mux2_1
X_10544_ _14863_/D _10544_/A _10544_/B _10557_/C VDD VSS sg13g2_and3_1
XFILLER_10_574 VDD VSS sg13g2_decap_8
XFILLER_108_440 VDD VSS sg13g2_fill_2
X_13263_ _13263_/Y _13260_/Y _13261_/Y _13262_/Y VDD VSS sg13g2_a21oi_1
X_10475_ _14846_/D _10486_/D _10492_/C _10474_/Y VDD VSS sg13g2_a21oi_1
XFILLER_6_567 VDD VSS sg13g2_decap_8
XFILLER_157_84 VDD VSS sg13g2_decap_8
XFILLER_136_782 VDD VSS sg13g2_decap_8
X_15002_ _15002_/Q _15247_/CLK _15002_/D _15002_/RESET_B VDD VSS sg13g2_dfrbpq_1
XFILLER_68_1031 VDD VSS sg13g2_decap_4
X_12214_ _12214_/Y _12213_/X _12214_/B VDD VSS sg13g2_nand2b_1
X_13194_ _13196_/B _14856_/Q _13234_/B VDD VSS sg13g2_nand2_1
XFILLER_159_1181 VDD VSS sg13g2_decap_8
X_12145_ _12145_/Y _12192_/A _12141_/X _12144_/Y VDD VSS sg13g2_o21ai_1
XFILLER_151_774 VDD VSS sg13g2_decap_8
XFILLER_116_1018 VDD VSS sg13g2_decap_4
XFILLER_124_999 VDD VSS sg13g2_decap_8
XFILLER_2_784 VDD VSS sg13g2_decap_8
X_14310__1869 _14310_/RESET_B VDD VSS sg13g2_tiehi
X_12076_ _12076_/X _12073_/X _12072_/X _12069_/X _12068_/X _12188_/C _12265_/B1 VDD
+ VSS sg13g2_mux4_1
XFILLER_172_1370 VDD VSS sg13g2_decap_8
XFILLER_42_1215 VDD VSS sg13g2_decap_4
XFILLER_81_1275 VDD VSS sg13g2_decap_8
XFILLER_1_294 VDD VSS sg13g2_decap_8
X_11027_ _11027_/Y _11052_/D _11052_/A _11027_/B1 VDD VSS sg13g2_a21oi_1
XFILLER_2_56 VDD VSS sg13g2_decap_8
X_16884_ _16884_/X _16884_/A VDD VSS sg13g2_buf_1
XFILLER_38_928 VDD VSS sg13g2_decap_4
XFILLER_49_298 VDD VSS sg13g2_decap_8
XFILLER_18_630 VDD VSS sg13g2_decap_8
X_13875__2304 _13875_/RESET_B VDD VSS sg13g2_tiehi
XFILLER_52_408 VDD VSS sg13g2_fill_2
XFILLER_17_140 VDD VSS sg13g2_decap_8
X_12978_ _12978_/Y _14778_/Q _13236_/A2 _13236_/B1 VDD VSS sg13g2_o21ai_1
XFILLER_46_983 VDD VSS sg13g2_fill_2
XFILLER_73_780 VDD VSS sg13g2_decap_8
X_14717_ _14717_/Q clkload47/A _14717_/D _14717_/RESET_B VDD VSS sg13g2_dfrbpq_1
X_11929_ _11929_/Y _12001_/A _11929_/B VDD VSS sg13g2_nor2_1
XFILLER_53_1300 VDD VSS sg13g2_decap_8
XFILLER_33_677 VDD VSS sg13g2_fill_2
X_14648_ _14648_/Q _14984_/CLK _14648_/D _14648_/RESET_B VDD VSS sg13g2_dfrbpq_1
XFILLER_60_474 VDD VSS sg13g2_decap_8
XFILLER_127_1169 VDD VSS sg13g2_fill_2
XFILLER_32_176 VDD VSS sg13g2_fill_1
XANTENNA_17 _09805_/S VDD VSS sg13g2_antennanp
XFILLER_32_187 VDD VSS sg13g2_fill_2
XANTENNA_28 _16867_/A VDD VSS sg13g2_antennanp
XFILLER_140_1303 VDD VSS sg13g2_decap_8
XFILLER_158_340 VDD VSS sg13g2_decap_8
X_14579_ _14579_/Q clkload22/A _14579_/D _14579_/RESET_B VDD VSS sg13g2_dfrbpq_1
XFILLER_174_811 VDD VSS sg13g2_decap_4
XFILLER_9_350 VDD VSS sg13g2_decap_8
XFILLER_146_524 VDD VSS sg13g2_decap_8
XFILLER_173_343 VDD VSS sg13g2_decap_8
Xoutput102 mem_axi_bready _07661_/Y VDD VSS sg13g2_buf_1
XFILLER_86_1131 VDD VSS sg13g2_decap_8
XFILLER_12_1085 VDD VSS sg13g2_decap_8
XFILLER_133_229 VDD VSS sg13g2_decap_8
Xoutput113 mem_axi_wdata[18] _15150_/Q VDD VSS sg13g2_buf_1
XFILLER_56_0 VDD VSS sg13g2_decap_8
Xoutput124 mem_axi_wdata[28] _15160_/Q VDD VSS sg13g2_buf_1
X_15141__2675 _15141_/RESET_B VDD VSS sg13g2_tiehi
Xoutput135 mem_axi_wdata[9] _15141_/Q VDD VSS sg13g2_buf_1
XFILLER_47_1126 VDD VSS sg13g2_decap_8
XFILLER_138_1254 VDD VSS sg13g2_decap_8
XFILLER_99_154 VDD VSS sg13g2_fill_2
XFILLER_102_605 VDD VSS sg13g2_decap_8
XFILLER_138_1265 VDD VSS sg13g2_decap_8
XFILLER_99_187 VDD VSS sg13g2_decap_4
X_07953_ _07954_/C _07818_/Y _07952_/Y _07951_/Y VDD VSS sg13g2_a21oi_1
XFILLER_60_1315 VDD VSS sg13g2_fill_1
X_07884_ _07884_/Y _07884_/A _08063_/B VDD VSS sg13g2_xnor2_1
XFILLER_68_563 VDD VSS sg13g2_fill_1
XFILLER_56_725 VDD VSS sg13g2_decap_8
XFILLER_56_736 VDD VSS sg13g2_fill_1
X_09623_ _14219_/D _09623_/A0 _14219_/Q _09629_/S VDD VSS sg13g2_mux2_1
XFILLER_28_449 VDD VSS sg13g2_decap_4
XFILLER_56_769 VDD VSS sg13g2_decap_8
XFILLER_55_246 VDD VSS sg13g2_decap_8
XFILLER_37_950 VDD VSS sg13g2_decap_8
XFILLER_3_1253 VDD VSS sg13g2_decap_8
XFILLER_23_1181 VDD VSS sg13g2_decap_8
X_14465__1714 _14465_/RESET_B VDD VSS sg13g2_tiehi
X_09554_ _14152_/D _09853_/A1 _14152_/Q _09563_/S VDD VSS sg13g2_mux2_1
XFILLER_36_460 VDD VSS sg13g2_fill_1
X_08505_ _08505_/Y _07822_/A _08495_/Y _08504_/Y VDD VSS sg13g2_o21ai_1
XFILLER_145_1203 VDD VSS sg13g2_decap_8
XFILLER_36_493 VDD VSS sg13g2_decap_8
X_09485_ _14085_/D _10048_/A0 _14085_/Q _09497_/S VDD VSS sg13g2_mux2_1
XFILLER_93_1146 VDD VSS sg13g2_fill_2
XFILLER_169_616 VDD VSS sg13g2_decap_4
XFILLER_62_28 VDD VSS sg13g2_decap_8
XFILLER_58_1277 VDD VSS sg13g2_decap_8
XFILLER_19_1239 VDD VSS sg13g2_decap_8
X_08436_ _08436_/Y _08421_/Y _08436_/B VDD VSS sg13g2_nand2b_1
XFILLER_52_986 VDD VSS sg13g2_decap_8
XFILLER_23_154 VDD VSS sg13g2_decap_8
XFILLER_168_126 VDD VSS sg13g2_decap_8
XFILLER_145_1269 VDD VSS sg13g2_decap_4
X_08367_ _08367_/Y _08411_/A _08411_/C _08366_/X VDD VSS sg13g2_o21ai_1
XFILLER_109_204 VDD VSS sg13g2_fill_1
XFILLER_20_861 VDD VSS sg13g2_decap_8
XFILLER_109_215 VDD VSS sg13g2_decap_8
X_08298_ _08298_/Y _08318_/C _08297_/Y _08000_/X VDD VSS sg13g2_o21ai_1
XFILLER_164_343 VDD VSS sg13g2_decap_8
XFILLER_11_21 VDD VSS sg13g2_decap_8
XFILLER_3_504 VDD VSS sg13g2_decap_8
XFILLER_30_1163 VDD VSS sg13g2_decap_8
XFILLER_127_21 VDD VSS sg13g2_decap_8
X_10260_ _14781_/D _10265_/A _10265_/D _10259_/Y VDD VSS sg13g2_a21oi_1
XFILLER_69_1362 VDD VSS sg13g2_decap_8
XFILLER_11_98 VDD VSS sg13g2_decap_8
X_13953__2226 _13953_/RESET_B VDD VSS sg13g2_tiehi
XFILLER_87_14 VDD VSS sg13g2_fill_2
XFILLER_79_806 VDD VSS sg13g2_decap_4
X_10191_ _15196_/D hold3052/X _15196_/Q _13479_/S VDD VSS sg13g2_mux2_1
XFILLER_117_1316 VDD VSS sg13g2_decap_8
XFILLER_132_251 VDD VSS sg13g2_decap_4
XFILLER_160_560 VDD VSS sg13g2_decap_8
XFILLER_78_305 VDD VSS sg13g2_decap_8
XFILLER_120_402 VDD VSS sg13g2_decap_8
XFILLER_132_273 VDD VSS sg13g2_decap_4
XFILLER_152_1218 VDD VSS sg13g2_fill_2
Xfanout1305 _11963_/S0 fanout1308/X VDD VSS sg13g2_buf_1
XFILLER_117_1349 VDD VSS sg13g2_decap_8
Xfanout1316 fanout1316/X _13657_/Q VDD VSS sg13g2_buf_1
XFILLER_8_1120 VDD VSS sg13g2_decap_8
Xfanout1327 _11328_/S0 _11320_/S0 VDD VSS sg13g2_buf_1
Xfanout340 _09737_/S _09739_/S VDD VSS sg13g2_buf_1
Xfanout1338 _12252_/S0 _12250_/A1 VDD VSS sg13g2_buf_1
XFILLER_87_850 VDD VSS sg13g2_fill_2
XFILLER_28_1070 VDD VSS sg13g2_decap_8
Xfanout351 _09637_/S wire352/X VDD VSS sg13g2_buf_1
Xfanout1349 _12140_/S0 _12138_/S0 VDD VSS sg13g2_buf_1
XFILLER_115_1040 VDD VSS sg13g2_decap_8
XFILLER_143_42 VDD VSS sg13g2_decap_4
Xfanout362 _09325_/S _09339_/S VDD VSS sg13g2_buf_1
X_13950_ _13950_/Q _14686_/CLK _13950_/D _13950_/RESET_B VDD VSS sg13g2_dfrbpq_1
Xfanout373 _09193_/S _09189_/S VDD VSS sg13g2_buf_1
Xfanout384 _09913_/A1 _10045_/A0 VDD VSS sg13g2_buf_1
Xfanout395 _10140_/A1 wire398/X VDD VSS sg13g2_buf_1
XFILLER_8_1197 VDD VSS sg13g2_decap_8
XFILLER_19_427 VDD VSS sg13g2_decap_8
X_12901_ _12902_/A input32/X _12841_/B _12803_/X input9/X VDD VSS sg13g2_a22oi_1
XFILLER_115_1095 VDD VSS sg13g2_fill_1
X_13881_ _13881_/Q _14745_/CLK _13881_/D _13881_/RESET_B VDD VSS sg13g2_dfrbpq_1
X_12832_ _12832_/Y _12829_/Y _12830_/Y _12831_/Y VDD VSS sg13g2_a21oi_1
XFILLER_74_588 VDD VSS sg13g2_fill_1
XFILLER_76_1322 VDD VSS sg13g2_decap_8
XFILLER_28_994 VDD VSS sg13g2_fill_2
XFILLER_160_0 VDD VSS sg13g2_decap_8
XFILLER_76_1333 VDD VSS sg13g2_fill_2
XFILLER_55_791 VDD VSS sg13g2_fill_1
XFILLER_36_84 VDD VSS sg13g2_decap_8
XFILLER_15_644 VDD VSS sg13g2_decap_8
X_12763_ _12764_/B _13664_/Q _12763_/A2 _12762_/X _12415_/A _12763_/C1 VDD VSS sg13g2_a221oi_1
XFILLER_54_290 VDD VSS sg13g2_decap_8
XFILLER_70_750 VDD VSS sg13g2_decap_4
XFILLER_42_441 VDD VSS sg13g2_decap_8
X_14502_ _14502_/Q clkload11/A _14502_/D _14502_/RESET_B VDD VSS sg13g2_dfrbpq_1
XFILLER_42_452 VDD VSS sg13g2_decap_8
XFILLER_14_154 VDD VSS sg13g2_decap_8
X_11714_ _11714_/X _14377_/Q _14409_/Q _14473_/Q _14505_/Q _11715_/S0 _11715_/S1 VDD
+ VSS sg13g2_mux4_1
XFILLER_159_126 VDD VSS sg13g2_decap_8
X_12694_ _15013_/D _12694_/A _12694_/B VDD VSS sg13g2_nor2_1
XFILLER_35_1030 VDD VSS sg13g2_decap_8
X_14433_ _14433_/Q _14681_/CLK _14433_/D _14433_/RESET_B VDD VSS sg13g2_dfrbpq_1
XFILLER_35_1041 VDD VSS sg13g2_fill_2
X_11645_ _11645_/X _13831_/Q _13863_/Q _13895_/Q _13927_/Q _11651_/S0 _11651_/S1 VDD
+ VSS sg13g2_mux4_1
XFILLER_128_502 VDD VSS sg13g2_decap_8
XFILLER_161_1060 VDD VSS sg13g2_fill_2
XFILLER_11_861 VDD VSS sg13g2_decap_8
XFILLER_156_833 VDD VSS sg13g2_decap_8
XFILLER_35_1085 VDD VSS sg13g2_fill_1
X_14364_ _14364_/Q _14854_/CLK _14364_/D _14364_/RESET_B VDD VSS sg13g2_dfrbpq_1
Xinput15 input15/X input15/A VDD VSS sg13g2_buf_1
Xinput26 input26/X input26/A VDD VSS sg13g2_buf_1
X_11576_ _11576_/X _14693_/Q _14725_/Q _13765_/Q _13797_/Q _11997_/S0 _11997_/S1 VDD
+ VSS sg13g2_mux4_1
XFILLER_35_1096 VDD VSS sg13g2_fill_2
XFILLER_10_371 VDD VSS sg13g2_decap_8
Xinput37 input37/X input37/A VDD VSS sg13g2_buf_1
XFILLER_7_854 VDD VSS sg13g2_decap_8
XFILLER_122_1077 VDD VSS sg13g2_decap_8
X_13315_ _15061_/D _15079_/Q _07694_/Y _13314_/X VDD VSS sg13g2_a21o_1
XFILLER_171_803 VDD VSS sg13g2_fill_2
XFILLER_156_888 VDD VSS sg13g2_decap_8
Xclkbuf_leaf_4_clk_i clkload7/A clkbuf_leaf_4_clk_i/A VDD VSS sg13g2_buf_8
X_10527_ _10529_/A _10558_/C _10531_/D _10558_/B VDD VSS sg13g2_a21o_1
XFILLER_13_1372 VDD VSS sg13g2_decap_8
X_14295_ _14295_/Q _15015_/CLK _14295_/D _14295_/RESET_B VDD VSS sg13g2_dfrbpq_1
XFILLER_6_364 VDD VSS sg13g2_decap_8
XFILLER_100_1331 VDD VSS sg13g2_decap_8
XFILLER_13_1383 VDD VSS sg13g2_fill_1
XFILLER_157_1129 VDD VSS sg13g2_fill_1
X_13246_ _13247_/C _14922_/Q _13665_/Q _13246_/C VDD VSS sg13g2_nand3_1
X_10458_ _10512_/A _14842_/Q _14841_/Q _14840_/Q _14839_/Q VDD VSS sg13g2_nand4_1
XFILLER_108_292 VDD VSS sg13g2_decap_4
XFILLER_170_357 VDD VSS sg13g2_decap_8
X_14543__1636 _14543_/RESET_B VDD VSS sg13g2_tiehi
XFILLER_112_914 VDD VSS sg13g2_decap_8
XFILLER_123_251 VDD VSS sg13g2_decap_8
XFILLER_124_774 VDD VSS sg13g2_decap_8
X_13177_ _13177_/X _13225_/A _13188_/A VDD VSS sg13g2_xor2_1
X_13929__2250 _13929_/RESET_B VDD VSS sg13g2_tiehi
X_10389_ _14820_/D _10378_/D _10387_/X _10388_/Y VDD VSS sg13g2_a21oi_1
XFILLER_97_614 VDD VSS sg13g2_decap_4
X_14689__1490 _14689_/RESET_B VDD VSS sg13g2_tiehi
XFILLER_96_102 VDD VSS sg13g2_decap_8
X_12128_ _12198_/B _12128_/A _13667_/Q VDD VSS sg13g2_xnor2_1
XFILLER_2_581 VDD VSS sg13g2_decap_8
X_15083__2827 _15083_/RESET_B VDD VSS sg13g2_tiehi
XFILLER_111_446 VDD VSS sg13g2_decap_8
XFILLER_81_1050 VDD VSS sg13g2_fill_2
XFILLER_78_850 VDD VSS sg13g2_decap_4
X_14797__2916 _14797_/RESET_B VDD VSS sg13g2_tiehi
X_12059_ _12062_/B _12054_/Y _11986_/Y _11913_/A _12056_/C _12058_/Y VDD VSS sg13g2_a221oi_1
XFILLER_120_980 VDD VSS sg13g2_decap_8
XFILLER_42_1056 VDD VSS sg13g2_decap_8
XFILLER_93_831 VDD VSS sg13g2_decap_8
XFILLER_38_736 VDD VSS sg13g2_fill_2
XFILLER_168_1203 VDD VSS sg13g2_fill_2
X_16867_ _16867_/X _16867_/A VDD VSS sg13g2_buf_1
Xclkbuf_5_31__f_clk_i clkbuf_leaf_61_clk_i/A clkbuf_4_15_0_clk_i/X VDD VSS sg13g2_buf_16
XFILLER_129_1209 VDD VSS sg13g2_decap_4
XFILLER_92_385 VDD VSS sg13g2_fill_1
XFILLER_20_1365 VDD VSS sg13g2_decap_8
XFILLER_19_994 VDD VSS sg13g2_decap_8
XFILLER_61_761 VDD VSS sg13g2_decap_8
X_09270_ _13879_/D _13879_/Q _09703_/A0 _09271_/S VDD VSS sg13g2_mux2_1
XFILLER_61_772 VDD VSS sg13g2_fill_2
X_08221_ _08221_/Y _08220_/X _08238_/B _08319_/A VDD VSS sg13g2_a21oi_1
XFILLER_53_1130 VDD VSS sg13g2_fill_1
XFILLER_21_658 VDD VSS sg13g2_decap_8
XFILLER_144_1280 VDD VSS sg13g2_decap_8
X_08152_ _08152_/Y _08033_/A _08402_/B _08103_/B VDD VSS sg13g2_o21ai_1
XFILLER_53_1174 VDD VSS sg13g2_decap_8
XFILLER_53_1185 VDD VSS sg13g2_fill_2
XFILLER_20_168 VDD VSS sg13g2_decap_8
XFILLER_119_535 VDD VSS sg13g2_decap_8
XFILLER_146_321 VDD VSS sg13g2_fill_2
XFILLER_174_630 VDD VSS sg13g2_decap_8
XFILLER_174_641 VDD VSS sg13g2_decap_8
XFILLER_14_1169 VDD VSS sg13g2_decap_8
XFILLER_107_719 VDD VSS sg13g2_decap_8
X_08083_ _08086_/B _08493_/B2 _08470_/B _08519_/A2 _07818_/B _08083_/S0 _08235_/S0
+ VDD VSS sg13g2_mux4_1
XFILLER_173_140 VDD VSS sg13g2_decap_8
XFILLER_162_825 VDD VSS sg13g2_decap_8
XFILLER_106_218 VDD VSS sg13g2_fill_2
XFILLER_161_324 VDD VSS sg13g2_decap_8
X_14182__1997 _14182_/RESET_B VDD VSS sg13g2_tiehi
XFILLER_127_590 VDD VSS sg13g2_fill_1
XFILLER_138_1051 VDD VSS sg13g2_decap_8
XFILLER_88_614 VDD VSS sg13g2_decap_8
XFILLER_0_518 VDD VSS sg13g2_decap_8
XFILLER_103_936 VDD VSS sg13g2_decap_8
X_14519__1660 _14519_/RESET_B VDD VSS sg13g2_tiehi
X_08985_ _08985_/X _15025_/Q _15222_/Q _09009_/S VDD VSS sg13g2_mux2_1
XFILLER_57_28 VDD VSS sg13g2_decap_8
XFILLER_25_1232 VDD VSS sg13g2_decap_8
XFILLER_102_468 VDD VSS sg13g2_decap_4
X_07936_ _07936_/Y _15003_/Q _07790_/A VDD VSS sg13g2_nor2b_1
XFILLER_151_1251 VDD VSS sg13g2_fill_2
XFILLER_5_1337 VDD VSS sg13g2_decap_8
XFILLER_112_1224 VDD VSS sg13g2_decap_8
XFILLER_29_758 VDD VSS sg13g2_fill_2
X_07867_ _07905_/D _07969_/A _08678_/A _08650_/A _07867_/D VDD VSS sg13g2_or4_1
XFILLER_28_235 VDD VSS sg13g2_decap_8
XFILLER_56_555 VDD VSS sg13g2_fill_1
X_09606_ wire352/A _10070_/A _10070_/B _09606_/C VDD VSS sg13g2_nand3_1
XFILLER_3_1050 VDD VSS sg13g2_decap_8
XFILLER_71_503 VDD VSS sg13g2_decap_8
XFILLER_71_514 VDD VSS sg13g2_fill_2
X_07798_ _07798_/X _15006_/Q _07945_/B VDD VSS sg13g2_or2_1
X_09537_ _14136_/D _09636_/A0 _14136_/Q _09539_/S VDD VSS sg13g2_mux2_1
XFILLER_169_413 VDD VSS sg13g2_decap_8
XFILLER_25_975 VDD VSS sg13g2_decap_8
XFILLER_19_1036 VDD VSS sg13g2_decap_8
X_09468_ _14069_/D _10097_/A0 _14069_/Q _09469_/S VDD VSS sg13g2_mux2_1
XFILLER_24_474 VDD VSS sg13g2_fill_1
XFILLER_51_260 VDD VSS sg13g2_fill_2
XFILLER_24_485 VDD VSS sg13g2_decap_4
XFILLER_40_945 VDD VSS sg13g2_fill_1
X_14621__1558 _14621_/RESET_B VDD VSS sg13g2_tiehi
X_08419_ _08419_/Y _08419_/A VDD VSS sg13g2_inv_1
XFILLER_12_658 VDD VSS sg13g2_decap_8
XFILLER_145_1088 VDD VSS sg13g2_decap_8
X_09399_ _14002_/D _09630_/A0 _14002_/Q _09407_/S VDD VSS sg13g2_mux2_1
XFILLER_71_1252 VDD VSS sg13g2_decap_4
XFILLER_36_1372 VDD VSS sg13g2_decap_8
XFILLER_36_1383 VDD VSS sg13g2_fill_1
XFILLER_11_168 VDD VSS sg13g2_decap_8
X_11430_ _11430_/Y _11430_/A _11430_/B VDD VSS sg13g2_xnor2_1
XFILLER_71_1274 VDD VSS sg13g2_decap_8
XFILLER_22_42 VDD VSS sg13g2_decap_8
XFILLER_138_42 VDD VSS sg13g2_decap_8
XFILLER_164_140 VDD VSS sg13g2_decap_8
XFILLER_165_663 VDD VSS sg13g2_decap_8
X_11361_ _11361_/Y _11231_/S _11361_/B VDD VSS sg13g2_nand2b_1
XFILLER_138_899 VDD VSS sg13g2_decap_8
X_13100_ _15039_/D _13093_/Y _13099_/Y _13141_/A VDD VSS sg13g2_a21oi_1
X_10312_ _14797_/D _10572_/B _10312_/B _10342_/C VDD VSS sg13g2_nor3_1
XFILLER_3_301 VDD VSS sg13g2_decap_8
XFILLER_137_398 VDD VSS sg13g2_fill_1
XFILLER_152_324 VDD VSS sg13g2_decap_8
X_14080_ _14080_/Q clkload29/A _14080_/D _14080_/RESET_B VDD VSS sg13g2_dfrbpq_1
X_11292_ _11292_/Y _11292_/A _11292_/B VDD VSS sg13g2_xnor2_1
XFILLER_118_590 VDD VSS sg13g2_decap_8
XFILLER_152_357 VDD VSS sg13g2_decap_8
XFILLER_4_868 VDD VSS sg13g2_decap_8
X_13031_ _13031_/Y _13028_/Y _13029_/Y _13030_/Y VDD VSS sg13g2_a21oi_1
X_10243_ _10245_/C _14775_/Q wire525/X _14776_/Q VDD VSS sg13g2_a21oi_1
XFILLER_106_774 VDD VSS sg13g2_fill_2
XFILLER_79_603 VDD VSS sg13g2_decap_8
XFILLER_156_1151 VDD VSS sg13g2_decap_8
XFILLER_65_1045 VDD VSS sg13g2_fill_1
XFILLER_3_378 VDD VSS sg13g2_decap_8
XFILLER_106_796 VDD VSS sg13g2_decap_8
XFILLER_156_1173 VDD VSS sg13g2_decap_8
XFILLER_26_1007 VDD VSS sg13g2_decap_8
XFILLER_117_1135 VDD VSS sg13g2_decap_8
Xfanout1102 _08620_/A2 _12084_/A VDD VSS sg13g2_buf_1
X_10174_ _10174_/Y _15055_/Q _15054_/Q _14748_/Q VDD VSS sg13g2_nor3_1
XFILLER_154_63 VDD VSS sg13g2_decap_8
Xfanout1113 _07818_/B _08559_/A3 VDD VSS sg13g2_buf_1
XFILLER_117_1157 VDD VSS sg13g2_decap_8
XFILLER_121_755 VDD VSS sg13g2_fill_1
Xfanout1124 _08493_/B2 _11843_/A VDD VSS sg13g2_buf_1
Xfanout1135 _07790_/A _14971_/Q VDD VSS sg13g2_buf_1
XFILLER_43_1321 VDD VSS sg13g2_decap_8
XFILLER_117_1179 VDD VSS sg13g2_decap_8
Xfanout1146 _08276_/A _08300_/A1 VDD VSS sg13g2_buf_1
X_14982_ _14982_/Q _14984_/CLK _14982_/D _14982_/RESET_B VDD VSS sg13g2_dfrbpq_1
Xfanout1157 _08860_/A1 _14964_/Q VDD VSS sg13g2_buf_1
Xfanout170 _09932_/A1 _10131_/A0 VDD VSS sg13g2_buf_1
Xfanout1168 _11335_/A _14959_/Q VDD VSS sg13g2_buf_1
XFILLER_43_1354 VDD VSS sg13g2_decap_8
Xfanout181 _09332_/A0 fanout182/X VDD VSS sg13g2_buf_1
Xfanout1179 _12883_/A _13601_/A VDD VSS sg13g2_buf_1
Xfanout192 _10091_/A0 _09959_/A1 VDD VSS sg13g2_buf_1
XFILLER_130_1335 VDD VSS sg13g2_decap_8
X_13933_ _13933_/Q _14733_/CLK _13933_/D _13933_/RESET_B VDD VSS sg13g2_dfrbpq_1
XFILLER_59_393 VDD VSS sg13g2_decap_8
XFILLER_19_224 VDD VSS sg13g2_decap_8
XFILLER_47_72 VDD VSS sg13g2_fill_1
XFILLER_47_83 VDD VSS sg13g2_decap_8
XFILLER_35_706 VDD VSS sg13g2_fill_2
XFILLER_74_352 VDD VSS sg13g2_decap_8
XFILLER_47_577 VDD VSS sg13g2_decap_8
X_13864_ _13864_/Q _14644_/CLK _13864_/D _13864_/RESET_B VDD VSS sg13g2_dfrbpq_1
XFILLER_170_84 VDD VSS sg13g2_decap_8
XFILLER_16_931 VDD VSS sg13g2_decap_8
XFILLER_34_227 VDD VSS sg13g2_fill_1
X_12815_ _12815_/Y input15/X _12841_/B _12803_/X input35/X _12813_/X VDD VSS sg13g2_a221oi_1
XFILLER_34_249 VDD VSS sg13g2_decap_8
X_13795_ _13795_/Q clkload19/A _13795_/D _13795_/RESET_B VDD VSS sg13g2_dfrbpq_1
XFILLER_62_569 VDD VSS sg13g2_fill_1
XFILLER_15_441 VDD VSS sg13g2_decap_8
X_12746_ _12746_/X _12739_/X _12743_/X _12738_/X _12742_/X _12762_/S _12789_/S0 VDD
+ VSS sg13g2_mux4_1
XFILLER_163_1144 VDD VSS sg13g2_fill_1
XFILLER_97_7 VDD VSS sg13g2_decap_4
XFILLER_43_794 VDD VSS sg13g2_decap_8
XFILLER_31_956 VDD VSS sg13g2_decap_8
X_12677_ _12677_/X _12675_/X _12674_/X _12668_/X _12669_/X _12761_/S0 _12761_/S1 VDD
+ VSS sg13g2_mux4_1
XFILLER_128_310 VDD VSS sg13g2_decap_8
X_14416_ _14416_/Q _14512_/CLK _14416_/D _14416_/RESET_B VDD VSS sg13g2_dfrbpq_1
X_11628_ _11628_/Y _11626_/Y _11627_/Y _12001_/A VDD VSS sg13g2_a21oi_1
XFILLER_168_490 VDD VSS sg13g2_decap_8
XFILLER_8_77 VDD VSS sg13g2_decap_8
XFILLER_50_1347 VDD VSS sg13g2_fill_2
XFILLER_11_1309 VDD VSS sg13g2_decap_8
XFILLER_128_354 VDD VSS sg13g2_fill_2
XFILLER_144_814 VDD VSS sg13g2_decap_8
XFILLER_155_140 VDD VSS sg13g2_decap_8
X_14347_ _14347_/Q clkload4/A _14347_/D _14347_/RESET_B VDD VSS sg13g2_dfrbpq_1
XFILLER_7_651 VDD VSS sg13g2_decap_8
X_11559_ _11559_/Y _11557_/Y _11559_/B _11559_/C VDD VSS sg13g2_nand3b_1
XFILLER_171_600 VDD VSS sg13g2_decap_8
XFILLER_116_516 VDD VSS sg13g2_decap_4
XFILLER_156_685 VDD VSS sg13g2_fill_1
XFILLER_143_313 VDD VSS sg13g2_decap_8
XFILLER_156_696 VDD VSS sg13g2_decap_8
XFILLER_6_161 VDD VSS sg13g2_decap_8
X_14278_ _14278_/Q clkload11/A _14278_/D _14278_/RESET_B VDD VSS sg13g2_dfrbpq_1
XFILLER_48_1210 VDD VSS sg13g2_decap_8
XFILLER_100_1161 VDD VSS sg13g2_decap_8
XFILLER_170_154 VDD VSS sg13g2_decap_8
X_13229_ _13232_/A _13188_/A _13225_/X _13228_/Y VDD VSS sg13g2_a21oi_1
XFILLER_97_422 VDD VSS sg13g2_decap_8
XFILLER_69_124 VDD VSS sg13g2_decap_8
XFILLER_98_978 VDD VSS sg13g2_decap_8
XFILLER_83_1178 VDD VSS sg13g2_decap_8
XFILLER_112_766 VDD VSS sg13g2_decap_8
XFILLER_170_1137 VDD VSS sg13g2_decap_8
XFILLER_98_989 VDD VSS sg13g2_fill_1
XFILLER_85_606 VDD VSS sg13g2_decap_8
X_08770_ _08770_/Y _07720_/C _15118_/Q _15187_/Q _07719_/X VDD VSS sg13g2_a22oi_1
XFILLER_38_511 VDD VSS sg13g2_decap_4
X_07721_ _07735_/B _07721_/A _07721_/B wire660/A VDD VSS sg13g2_nand3_1
XFILLER_19_0 VDD VSS sg13g2_decap_8
XFILLER_168_1000 VDD VSS sg13g2_decap_8
XFILLER_93_672 VDD VSS sg13g2_decap_4
XFILLER_81_812 VDD VSS sg13g2_fill_2
X_07652_ _07652_/Y _11202_/A VDD VSS sg13g2_inv_1
XFILLER_20_1162 VDD VSS sg13g2_decap_8
XFILLER_19_791 VDD VSS sg13g2_decap_8
XFILLER_0_1234 VDD VSS sg13g2_decap_8
XFILLER_25_238 VDD VSS sg13g2_decap_8
XFILLER_129_1028 VDD VSS sg13g2_decap_8
XFILLER_168_1077 VDD VSS sg13g2_decap_4
XFILLER_92_193 VDD VSS sg13g2_decap_8
XFILLER_81_867 VDD VSS sg13g2_decap_8
XFILLER_129_1039 VDD VSS sg13g2_fill_2
XFILLER_81_878 VDD VSS sg13g2_fill_1
XFILLER_80_355 VDD VSS sg13g2_decap_8
XFILLER_146_1320 VDD VSS sg13g2_fill_2
Xclkbuf_leaf_105_clk_i clkload44/A clkbuf_leaf_77_clk_i/A VDD VSS sg13g2_buf_8
X_09322_ _13929_/D _09920_/A1 _13929_/Q _09334_/S VDD VSS sg13g2_mux2_1
XFILLER_40_219 VDD VSS sg13g2_decap_8
XFILLER_33_260 VDD VSS sg13g2_decap_8
XFILLER_107_1315 VDD VSS sg13g2_decap_8
XFILLER_55_1258 VDD VSS sg13g2_decap_8
XFILLER_107_1326 VDD VSS sg13g2_fill_2
XFILLER_139_608 VDD VSS sg13g2_fill_2
X_09253_ _13862_/D _13862_/Q _09917_/A1 _09264_/S VDD VSS sg13g2_mux2_1
XFILLER_142_1239 VDD VSS sg13g2_fill_1
XFILLER_21_455 VDD VSS sg13g2_decap_8
XFILLER_166_427 VDD VSS sg13g2_decap_8
X_08204_ _08204_/Y _08001_/A _08247_/A _08001_/C VDD VSS sg13g2_o21ai_1
XFILLER_119_310 VDD VSS sg13g2_decap_4
X_09184_ _13800_/D _13800_/Q _09919_/A1 _09193_/S VDD VSS sg13g2_mux2_1
XFILLER_105_1072 VDD VSS sg13g2_decap_8
X_08135_ _08135_/Y _08154_/A _08131_/Y _08134_/Y VDD VSS sg13g2_a21oi_1
XFILLER_119_365 VDD VSS sg13g2_decap_8
XFILLER_146_151 VDD VSS sg13g2_decap_8
XFILLER_134_313 VDD VSS sg13g2_decap_8
XFILLER_147_696 VDD VSS sg13g2_decap_8
X_08066_ _08066_/Y _08066_/A VDD VSS sg13g2_inv_1
XFILLER_88_1067 VDD VSS sg13g2_decap_8
XFILLER_161_154 VDD VSS sg13g2_decap_8
XFILLER_1_805 VDD VSS sg13g2_decap_8
XFILLER_89_923 VDD VSS sg13g2_fill_1
XFILLER_108_78 VDD VSS sg13g2_decap_8
XFILLER_89_934 VDD VSS sg13g2_decap_8
XFILLER_0_315 VDD VSS sg13g2_decap_8
XFILLER_115_582 VDD VSS sg13g2_decap_4
XFILLER_102_210 VDD VSS sg13g2_fill_1
X_14035__2144 _14035_/RESET_B VDD VSS sg13g2_tiehi
XFILLER_68_49 VDD VSS sg13g2_fill_1
XFILLER_27_1327 VDD VSS sg13g2_decap_8
XFILLER_153_1335 VDD VSS sg13g2_decap_8
XFILLER_142_390 VDD VSS sg13g2_decap_8
XFILLER_62_1229 VDD VSS sg13g2_decap_8
XFILLER_88_466 VDD VSS sg13g2_fill_1
XFILLER_103_777 VDD VSS sg13g2_decap_8
X_08968_ _08969_/A _15021_/Q _15218_/Q _09009_/S VDD VSS sg13g2_mux2_1
XFILLER_29_500 VDD VSS sg13g2_fill_2
XFILLER_9_1281 VDD VSS sg13g2_decap_8
XFILLER_88_499 VDD VSS sg13g2_decap_8
XFILLER_5_1134 VDD VSS sg13g2_decap_8
XFILLER_116_1190 VDD VSS sg13g2_decap_4
XFILLER_124_77 VDD VSS sg13g2_decap_4
X_07919_ _07919_/Y _08160_/B _08160_/C _07871_/X VDD VSS sg13g2_o21ai_1
XFILLER_29_533 VDD VSS sg13g2_decap_8
XFILLER_68_190 VDD VSS sg13g2_fill_1
XFILLER_112_1043 VDD VSS sg13g2_decap_4
X_08899_ _08899_/Y _08897_/Y _08898_/Y _08931_/S VDD VSS sg13g2_a21oi_1
XFILLER_57_864 VDD VSS sg13g2_fill_1
XFILLER_56_341 VDD VSS sg13g2_decap_8
XFILLER_56_352 VDD VSS sg13g2_fill_1
X_10930_ _10946_/B _10936_/B _14757_/Q VDD VSS sg13g2_nand2_1
XFILLER_95_1005 VDD VSS sg13g2_decap_4
XFILLER_17_728 VDD VSS sg13g2_decap_8
XFILLER_84_683 VDD VSS sg13g2_decap_8
XFILLER_57_897 VDD VSS sg13g2_fill_2
XFILLER_44_514 VDD VSS sg13g2_decap_4
XFILLER_95_1027 VDD VSS sg13g2_fill_2
XFILLER_84_694 VDD VSS sg13g2_fill_2
XFILLER_17_42 VDD VSS sg13g2_decap_8
XFILLER_140_21 VDD VSS sg13g2_decap_8
XFILLER_95_1038 VDD VSS sg13g2_fill_1
XFILLER_16_238 VDD VSS sg13g2_decap_8
XFILLER_71_333 VDD VSS sg13g2_decap_8
X_10861_ _14931_/D _10860_/Y _10859_/Y _10850_/Y VDD VSS sg13g2_o21ai_1
X_12600_ _12600_/X _13741_/Q _14093_/Q _14445_/Q _14541_/Q _12601_/S0 _12601_/S1 VDD
+ VSS sg13g2_mux4_1
XFILLER_169_210 VDD VSS sg13g2_decap_8
X_13580_ _13580_/Y _15000_/Q _13566_/B _13569_/S _15016_/Q _13529_/X VDD VSS sg13g2_a221oi_1
X_10792_ _10792_/Y _14925_/Q _11196_/B VDD VSS sg13g2_nand2_1
XFILLER_25_794 VDD VSS sg13g2_decap_8
XFILLER_13_945 VDD VSS sg13g2_decap_8
X_12531_ _12531_/X _14376_/Q _14408_/Q _14472_/Q _14504_/Q _12703_/S0 _12703_/S1 VDD
+ VSS sg13g2_mux4_1
XFILLER_12_455 VDD VSS sg13g2_decap_8
XFILLER_169_287 VDD VSS sg13g2_decap_8
XFILLER_9_938 VDD VSS sg13g2_decap_8
XFILLER_33_63 VDD VSS sg13g2_decap_8
X_15250_ _15250_/Q clkload72/A _15250_/D _15250_/RESET_B VDD VSS sg13g2_dfrbpq_1
XFILLER_32_1011 VDD VSS sg13g2_fill_1
X_12462_ _12462_/X _14243_/Q _14275_/Q _14307_/Q _14339_/Q _12715_/S0 _12715_/S1 VDD
+ VSS sg13g2_mux4_1
XFILLER_71_1071 VDD VSS sg13g2_fill_1
XFILLER_8_448 VDD VSS sg13g2_decap_8
XFILLER_32_1033 VDD VSS sg13g2_decap_8
XFILLER_123_0 VDD VSS sg13g2_decap_8
X_14201_ _14201_/Q clkload21/A _14201_/D _14201_/RESET_B VDD VSS sg13g2_dfrbpq_1
XFILLER_123_1172 VDD VSS sg13g2_decap_8
X_11413_ _11413_/X _11413_/A _11745_/B VDD VSS sg13g2_and2_1
X_14245__1934 _14245_/RESET_B VDD VSS sg13g2_tiehi
X_15181_ _15181_/Q clkload66/A _15181_/D _15181_/RESET_B VDD VSS sg13g2_dfrbpq_1
XFILLER_138_685 VDD VSS sg13g2_decap_8
X_12393_ _12393_/X _14110_/Q _14142_/Q _14174_/Q _14206_/Q _12592_/S0 _12592_/S1 VDD
+ VSS sg13g2_mux4_1
XFILLER_125_302 VDD VSS sg13g2_decap_8
XFILLER_153_633 VDD VSS sg13g2_decap_8
XFILLER_158_1224 VDD VSS sg13g2_decap_4
X_14132_ _14132_/Q _14516_/CLK _14132_/D _14132_/RESET_B VDD VSS sg13g2_dfrbpq_1
X_11344_ _11344_/Y _11350_/A1 _13886_/Q VDD VSS sg13g2_nand2b_1
Xclkbuf_leaf_84_clk_i _14867_/CLK clkbuf_leaf_87_clk_i/A VDD VSS sg13g2_buf_8
X_14839__2866 _14839_/RESET_B VDD VSS sg13g2_tiehi
XFILLER_4_665 VDD VSS sg13g2_decap_8
XFILLER_125_379 VDD VSS sg13g2_decap_8
X_14063_ _14063_/Q clkload6/A _14063_/D _14063_/RESET_B VDD VSS sg13g2_dfrbpq_1
X_11275_ _11275_/X _14236_/Q _14268_/Q _14300_/Q _14332_/Q _11275_/S0 _11262_/B VDD
+ VSS sg13g2_mux4_1
XFILLER_165_84 VDD VSS sg13g2_decap_8
XFILLER_106_582 VDD VSS sg13g2_decap_8
XFILLER_3_175 VDD VSS sg13g2_decap_8
XFILLER_140_338 VDD VSS sg13g2_decap_8
X_13014_ _13014_/Y _14812_/Q _13014_/A2 _13150_/B _14844_/Q _13207_/C1 VDD VSS sg13g2_a221oi_1
X_10226_ _10237_/C _14767_/Q _14768_/Q _14769_/Q _14770_/Q VDD VSS sg13g2_nand4_1
XFILLER_79_433 VDD VSS sg13g2_fill_2
XFILLER_95_904 VDD VSS sg13g2_decap_8
XFILLER_67_617 VDD VSS sg13g2_decap_8
Xclkbuf_leaf_99_clk_i _14686_/CLK clkbuf_leaf_99_clk_i/A VDD VSS sg13g2_buf_8
X_10157_ _14734_/D _14734_/Q _10157_/A1 _10163_/S VDD VSS sg13g2_mux2_1
XFILLER_121_585 VDD VSS sg13g2_fill_1
XFILLER_95_959 VDD VSS sg13g2_decap_8
XFILLER_12_7 VDD VSS sg13g2_decap_8
XFILLER_134_1290 VDD VSS sg13g2_decap_8
X_14965_ _14965_/Q _15015_/CLK _14965_/D _14965_/RESET_B VDD VSS sg13g2_dfrbpq_1
X_10088_ _14668_/D _10088_/A0 _14668_/Q _10096_/S VDD VSS sg13g2_mux2_1
XFILLER_48_864 VDD VSS sg13g2_decap_8
XFILLER_169_1331 VDD VSS sg13g2_decap_8
X_13916_ _13916_/Q clkload49/A _13916_/D _13916_/RESET_B VDD VSS sg13g2_dfrbpq_1
XFILLER_78_1225 VDD VSS sg13g2_decap_8
X_14896_ _14896_/Q clkload62/A _14896_/D _14896_/RESET_B VDD VSS sg13g2_dfrbpq_1
Xclkbuf_leaf_22_clk_i clkload25/A clkbuf_leaf_22_clk_i/A VDD VSS sg13g2_buf_8
XFILLER_47_385 VDD VSS sg13g2_decap_8
X_13733__2446 _13733_/RESET_B VDD VSS sg13g2_tiehi
X_14493__1686 _14493_/RESET_B VDD VSS sg13g2_tiehi
XFILLER_62_333 VDD VSS sg13g2_fill_1
X_13847_ _13847_/Q clkload34/A _13847_/D _13847_/RESET_B VDD VSS sg13g2_dfrbpq_1
XFILLER_35_558 VDD VSS sg13g2_fill_1
XFILLER_63_878 VDD VSS sg13g2_decap_8
XFILLER_165_1239 VDD VSS sg13g2_fill_2
XFILLER_62_355 VDD VSS sg13g2_decap_8
X_13778_ _13778_/Q _14706_/CLK _13778_/D _13778_/RESET_B VDD VSS sg13g2_dfrbpq_1
XFILLER_128_1050 VDD VSS sg13g2_fill_2
XFILLER_43_591 VDD VSS sg13g2_decap_8
X_12729_ _12729_/X _13750_/Q _14102_/Q _14454_/Q _14550_/Q _12731_/S0 _12731_/S1 VDD
+ VSS sg13g2_mux4_1
Xclkbuf_leaf_37_clk_i _14722_/CLK clkbuf_leaf_44_clk_i/A VDD VSS sg13g2_buf_8
X_14113__2066 _14113_/RESET_B VDD VSS sg13g2_tiehi
XFILLER_31_786 VDD VSS sg13g2_decap_8
XFILLER_50_1111 VDD VSS sg13g2_fill_2
XFILLER_15_1253 VDD VSS sg13g2_decap_8
XFILLER_106_1370 VDD VSS sg13g2_fill_1
XFILLER_11_1106 VDD VSS sg13g2_decap_8
XFILLER_50_1155 VDD VSS sg13g2_decap_8
XFILLER_117_825 VDD VSS sg13g2_decap_4
XFILLER_156_460 VDD VSS sg13g2_fill_1
XFILLER_102_1245 VDD VSS sg13g2_decap_4
XFILLER_128_162 VDD VSS sg13g2_decap_8
XFILLER_144_622 VDD VSS sg13g2_decap_8
XFILLER_156_482 VDD VSS sg13g2_fill_1
XFILLER_50_1188 VDD VSS sg13g2_decap_8
XFILLER_89_1365 VDD VSS sg13g2_decap_8
XFILLER_156_493 VDD VSS sg13g2_decap_4
XFILLER_128_195 VDD VSS sg13g2_decap_8
XFILLER_102_1289 VDD VSS sg13g2_decap_8
X_09940_ _14524_/D _14524_/Q _10072_/A0 _09968_/S VDD VSS sg13g2_mux2_1
XFILLER_171_474 VDD VSS sg13g2_decap_8
X_13981__2198 _13981_/RESET_B VDD VSS sg13g2_tiehi
Xfanout906 _13303_/A _13238_/B2 VDD VSS sg13g2_buf_1
Xfanout917 _13300_/C _13293_/C VDD VSS sg13g2_buf_1
X_09871_ _14458_/D _14458_/Q _09970_/A1 _09871_/S VDD VSS sg13g2_mux2_1
XFILLER_174_1070 VDD VSS sg13g2_fill_1
Xfanout928 _13563_/C _15202_/Q VDD VSS sg13g2_buf_1
XFILLER_98_764 VDD VSS sg13g2_fill_1
Xfanout939 _13401_/C _10199_/A1 VDD VSS sg13g2_buf_1
XFILLER_174_1092 VDD VSS sg13g2_decap_8
XFILLER_97_252 VDD VSS sg13g2_decap_8
X_08822_ _08822_/Y _13691_/Q _08826_/B VDD VSS sg13g2_nor2_1
XFILLER_100_747 VDD VSS sg13g2_decap_8
XFILLER_26_1371 VDD VSS sg13g2_decap_8
XFILLER_26_1382 VDD VSS sg13g2_fill_2
X_08753_ _13669_/D _08762_/A1 _08751_/Y _08752_/Y VDD VSS sg13g2_a21oi_1
XFILLER_113_1352 VDD VSS sg13g2_fill_2
XFILLER_94_970 VDD VSS sg13g2_decap_8
X_07704_ _07705_/A _15080_/Q _07694_/Y _15201_/Q _07697_/A VDD VSS sg13g2_a22oi_1
XFILLER_22_1268 VDD VSS sg13g2_decap_8
X_08684_ _08684_/X _08684_/A _08684_/B VDD VSS sg13g2_xor2_1
XFILLER_96_1336 VDD VSS sg13g2_decap_8
XFILLER_93_480 VDD VSS sg13g2_decap_8
XFILLER_0_1031 VDD VSS sg13g2_decap_8
X_14323__1856 _14323_/RESET_B VDD VSS sg13g2_tiehi
X_07635_ _07910_/A _14994_/Q VDD VSS sg13g2_inv_1
XFILLER_96_1369 VDD VSS sg13g2_decap_8
X_13709__2470 _13709_/RESET_B VDD VSS sg13g2_tiehi
XFILLER_80_152 VDD VSS sg13g2_decap_8
XFILLER_59_1180 VDD VSS sg13g2_decap_8
XFILLER_55_1022 VDD VSS sg13g2_decap_8
XFILLER_53_399 VDD VSS sg13g2_fill_2
XFILLER_22_731 VDD VSS sg13g2_fill_2
XFILLER_110_46 VDD VSS sg13g2_decap_8
X_09305_ _13913_/D _13913_/Q _09338_/A0 _09305_/S VDD VSS sg13g2_mux2_1
XFILLER_166_224 VDD VSS sg13g2_decap_8
XFILLER_21_252 VDD VSS sg13g2_decap_8
X_09236_ _13847_/D _09934_/A1 _13847_/Q _09237_/S VDD VSS sg13g2_mux2_1
XFILLER_72_1380 VDD VSS sg13g2_decap_4
XFILLER_22_797 VDD VSS sg13g2_decap_8
XFILLER_148_950 VDD VSS sg13g2_fill_1
XFILLER_167_769 VDD VSS sg13g2_fill_1
XFILLER_10_959 VDD VSS sg13g2_decap_8
XFILLER_120_1323 VDD VSS sg13g2_decap_8
X_09167_ _13786_/D _13786_/Q _10169_/A1 _09167_/S VDD VSS sg13g2_mux2_1
XFILLER_120_1345 VDD VSS sg13g2_fill_2
XFILLER_135_622 VDD VSS sg13g2_decap_8
XFILLER_108_858 VDD VSS sg13g2_fill_1
X_08118_ _08145_/A _07904_/B _08116_/Y _08117_/Y VDD VSS sg13g2_o21ai_1
X_14792__2921 _14792_/RESET_B VDD VSS sg13g2_tiehi
XFILLER_135_655 VDD VSS sg13g2_decap_8
X_09098_ _09098_/Y _09111_/A1 _10747_/B _09097_/X VDD VSS sg13g2_o21ai_1
XFILLER_123_817 VDD VSS sg13g2_fill_1
XFILLER_150_614 VDD VSS sg13g2_decap_8
XFILLER_162_474 VDD VSS sg13g2_decap_8
XFILLER_163_997 VDD VSS sg13g2_fill_2
X_08049_ _08397_/B _08049_/A _08692_/B VDD VSS sg13g2_nor2b_1
XFILLER_1_602 VDD VSS sg13g2_decap_8
XFILLER_66_1140 VDD VSS sg13g2_decap_8
XFILLER_135_21 VDD VSS sg13g2_decap_8
X_13811__2368 _13811_/RESET_B VDD VSS sg13g2_tiehi
XFILLER_0_112 VDD VSS sg13g2_decap_8
XFILLER_134_198 VDD VSS sg13g2_fill_1
X_11060_ _11060_/X _11064_/C _11064_/D VDD VSS sg13g2_and2_1
XFILLER_89_742 VDD VSS sg13g2_decap_8
XFILLER_62_1004 VDD VSS sg13g2_decap_8
XFILLER_115_390 VDD VSS sg13g2_decap_4
X_15164__2517 _15164_/RESET_B VDD VSS sg13g2_tiehi
XFILLER_27_1124 VDD VSS sg13g2_decap_8
XFILLER_103_541 VDD VSS sg13g2_decap_8
Xhold3040 input9/A mem_axi_rdata[14] VDD VSS sg13g2_dlygate4sd3_1
Xhold3051 input23/A mem_axi_rdata[27] VDD VSS sg13g2_dlygate4sd3_1
X_10011_ _14593_/D _10077_/A0 _14593_/Q _10032_/S VDD VSS sg13g2_mux2_1
XFILLER_95_14 VDD VSS sg13g2_decap_8
XFILLER_7_1218 VDD VSS sg13g2_decap_8
XFILLER_1_679 VDD VSS sg13g2_decap_8
XFILLER_103_574 VDD VSS sg13g2_decap_4
XFILLER_131_883 VDD VSS sg13g2_decap_8
Xhold3062 input18/A mem_axi_rdata[22] VDD VSS sg13g2_dlygate4sd3_1
XFILLER_49_628 VDD VSS sg13g2_decap_8
XFILLER_131_894 VDD VSS sg13g2_fill_2
Xhold3073 hold3073/X input16/X VDD VSS sg13g2_dlygate4sd3_1
XFILLER_76_414 VDD VSS sg13g2_decap_8
XFILLER_130_371 VDD VSS sg13g2_decap_8
Xhold3084 input17/A mem_axi_rdata[21] VDD VSS sg13g2_dlygate4sd3_1
XFILLER_0_189 VDD VSS sg13g2_decap_8
XFILLER_153_1187 VDD VSS sg13g2_decap_8
Xhold3095 _14765_/D _10217_/Y VDD VSS sg13g2_dlygate4sd3_1
XFILLER_77_959 VDD VSS sg13g2_decap_4
XFILLER_92_907 VDD VSS sg13g2_decap_8
XFILLER_48_149 VDD VSS sg13g2_decap_8
XFILLER_76_469 VDD VSS sg13g2_decap_8
XFILLER_28_63 VDD VSS sg13g2_decap_8
XFILLER_151_42 VDD VSS sg13g2_decap_8
X_14750_ _14750_/Q _15214_/CLK _14750_/D _14750_/RESET_B VDD VSS sg13g2_dfrbpq_1
X_11962_ _11962_/Y _11958_/Y _11959_/Y _11961_/Y _11960_/Y _12239_/B VDD VSS sg13g2_a221oi_1
XFILLER_17_525 VDD VSS sg13g2_decap_8
X_13701_ _16863_/A clkload57/A _13701_/D _13701_/RESET_B VDD VSS sg13g2_dfrbpq_1
XFILLER_56_182 VDD VSS sg13g2_decap_4
XFILLER_44_322 VDD VSS sg13g2_decap_4
X_10913_ _14935_/D _10912_/Y _10911_/Y _10903_/Y VDD VSS sg13g2_o21ai_1
X_14681_ _14681_/Q _14681_/CLK _14681_/D _14681_/RESET_B VDD VSS sg13g2_dfrbpq_1
X_11893_ _11893_/X _14126_/Q _14158_/Q _11893_/S VDD VSS sg13g2_mux2_1
X_13632_ _13740_/D _13632_/A VDD VSS sg13g2_buf_1
X_10844_ _10897_/D _10844_/A _10844_/B _10851_/D _10851_/C VDD VSS sg13g2_nand4_1
XFILLER_32_539 VDD VSS sg13g2_decap_8
XFILLER_73_1133 VDD VSS sg13g2_decap_4
XFILLER_71_196 VDD VSS sg13g2_decap_8
XFILLER_13_742 VDD VSS sg13g2_decap_8
XFILLER_164_1261 VDD VSS sg13g2_decap_8
XFILLER_44_84 VDD VSS sg13g2_decap_8
X_13563_ _13563_/Y _15010_/Q _13563_/B _13563_/C VDD VSS sg13g2_nor3_1
XFILLER_44_95 VDD VSS sg13g2_fill_2
XFILLER_38_1275 VDD VSS sg13g2_decap_8
XFILLER_34_1106 VDD VSS sg13g2_decap_8
X_10775_ _14920_/D _11207_/B1 _11163_/A _10774_/Y VDD VSS sg13g2_o21ai_1
XFILLER_125_1245 VDD VSS sg13g2_decap_8
XFILLER_12_252 VDD VSS sg13g2_decap_8
XFILLER_158_747 VDD VSS sg13g2_decap_8
XFILLER_73_1188 VDD VSS sg13g2_fill_2
XFILLER_125_1256 VDD VSS sg13g2_fill_2
X_12514_ _12527_/A _12751_/A1 _12542_/A2 _08351_/B VDD VSS sg13g2_a21oi_1
XFILLER_9_735 VDD VSS sg13g2_decap_8
X_14478__1701 _14478_/RESET_B VDD VSS sg13g2_tiehi
X_13494_ _13494_/Y _15071_/Q _13494_/B VDD VSS sg13g2_nor2_1
XFILLER_8_245 VDD VSS sg13g2_decap_8
X_15233_ _15233_/Q clkload58/A _15233_/D _15233_/RESET_B VDD VSS sg13g2_dfrbpq_1
X_12445_ _12445_/X _14562_/Q _14594_/Q _14626_/Q _14658_/Q _12450_/S0 _12450_/S1 VDD
+ VSS sg13g2_mux4_1
XFILLER_60_83 VDD VSS sg13g2_decap_8
XFILLER_126_633 VDD VSS sg13g2_decap_8
X_15164_ _15164_/Q clkload70/A _15164_/D _15164_/RESET_B VDD VSS sg13g2_dfrbpq_1
X_12376_ _12376_/X _13725_/Q _14077_/Q _14429_/Q _14525_/Q _12396_/S0 _12396_/S1 VDD
+ VSS sg13g2_mux4_1
XFILLER_114_806 VDD VSS sg13g2_decap_8
XFILLER_158_1032 VDD VSS sg13g2_decap_8
XFILLER_5_952 VDD VSS sg13g2_decap_8
XFILLER_158_1043 VDD VSS sg13g2_fill_2
XFILLER_99_506 VDD VSS sg13g2_decap_8
XFILLER_141_603 VDD VSS sg13g2_fill_2
XFILLER_154_986 VDD VSS sg13g2_decap_8
X_14115_ _14115_/Q _14659_/CLK _14115_/D _14115_/RESET_B VDD VSS sg13g2_dfrbpq_1
X_11327_ _11327_/Y _11322_/Y _11323_/Y _11329_/B1 VDD VSS sg13g2_a21oi_1
X_15095_ _15095_/Q _15159_/CLK _15095_/D _15095_/RESET_B VDD VSS sg13g2_dfrbpq_1
XFILLER_5_56 VDD VSS sg13g2_decap_8
XFILLER_4_462 VDD VSS sg13g2_decap_8
XFILLER_10_1183 VDD VSS sg13g2_decap_8
XFILLER_119_1027 VDD VSS sg13g2_decap_8
XFILLER_84_1240 VDD VSS sg13g2_fill_2
XFILLER_136_1330 VDD VSS sg13g2_decap_8
X_14046_ _14046_/Q _14686_/CLK _14046_/D _14046_/RESET_B VDD VSS sg13g2_dfrbpq_1
X_14401__1778 _14401_/RESET_B VDD VSS sg13g2_tiehi
X_11258_ _11258_/Y _11256_/Y _11255_/Y _11266_/B _11257_/X VDD VSS sg13g2_a22oi_1
XFILLER_122_850 VDD VSS sg13g2_fill_2
XFILLER_140_146 VDD VSS sg13g2_decap_8
XFILLER_95_701 VDD VSS sg13g2_decap_8
XFILLER_45_1246 VDD VSS sg13g2_decap_8
X_10209_ _14762_/D _13021_/A _10209_/B _10209_/C VDD VSS sg13g2_nor3_1
XFILLER_45_1268 VDD VSS sg13g2_decap_4
X_11189_ _11189_/Y _11190_/C _11190_/A _11199_/B VDD VSS sg13g2_o21ai_1
XFILLER_0_690 VDD VSS sg13g2_fill_1
X_13966__2213 _13966_/RESET_B VDD VSS sg13g2_tiehi
X_14948_ _14948_/Q clkload41/A _14948_/D _14948_/RESET_B VDD VSS sg13g2_dfrbpq_1
XFILLER_47_160 VDD VSS sg13g2_decap_8
XFILLER_91_940 VDD VSS sg13g2_fill_2
XFILLER_78_1044 VDD VSS sg13g2_decap_8
XFILLER_63_642 VDD VSS sg13g2_decap_8
XFILLER_165_1003 VDD VSS sg13g2_fill_1
XFILLER_169_1172 VDD VSS sg13g2_decap_8
XFILLER_35_344 VDD VSS sg13g2_fill_1
X_14879_ _14879_/Q clkload48/A _14879_/D _14879_/RESET_B VDD VSS sg13g2_dfrbpq_1
XFILLER_91_973 VDD VSS sg13g2_fill_2
XFILLER_39_1017 VDD VSS sg13g2_decap_4
XFILLER_1_1351 VDD VSS sg13g2_decap_8
XFILLER_165_1036 VDD VSS sg13g2_decap_8
XFILLER_91_995 VDD VSS sg13g2_fill_1
XFILLER_23_539 VDD VSS sg13g2_decap_4
XFILLER_50_336 VDD VSS sg13g2_fill_2
X_13669__2534 _13669_/RESET_B VDD VSS sg13g2_tiehi
XFILLER_50_369 VDD VSS sg13g2_decap_4
XFILLER_148_202 VDD VSS sg13g2_fill_1
XFILLER_17_1337 VDD VSS sg13g2_decap_8
XFILLER_91_1277 VDD VSS sg13g2_decap_4
XFILLER_148_224 VDD VSS sg13g2_decap_8
XFILLER_86_0 VDD VSS sg13g2_decap_8
XFILLER_149_758 VDD VSS sg13g2_decap_8
XFILLER_15_1050 VDD VSS sg13g2_decap_8
X_09021_ _09021_/X _15031_/Q _15228_/Q _09107_/B VDD VSS sg13g2_mux2_1
XFILLER_117_600 VDD VSS sg13g2_fill_1
XFILLER_117_622 VDD VSS sg13g2_decap_8
XFILLER_117_633 VDD VSS sg13g2_fill_2
XFILLER_129_493 VDD VSS sg13g2_fill_2
XFILLER_163_238 VDD VSS sg13g2_decap_8
XFILLER_89_1151 VDD VSS sg13g2_decap_8
XFILLER_89_1162 VDD VSS sg13g2_fill_1
XFILLER_105_817 VDD VSS sg13g2_fill_1
XFILLER_144_463 VDD VSS sg13g2_decap_8
XFILLER_89_1195 VDD VSS sg13g2_decap_4
XFILLER_172_772 VDD VSS sg13g2_decap_4
XFILLER_137_1105 VDD VSS sg13g2_fill_1
XFILLER_116_165 VDD VSS sg13g2_decap_8
XFILLER_160_923 VDD VSS sg13g2_decap_8
XFILLER_171_282 VDD VSS sg13g2_decap_8
X_09923_ _14508_/D _14508_/Q _09923_/A1 _09931_/S VDD VSS sg13g2_mux2_1
Xfanout703 _12246_/B _12190_/B VDD VSS sg13g2_buf_1
Xfanout714 _11881_/C1 _11227_/S VDD VSS sg13g2_buf_1
XFILLER_131_168 VDD VSS sg13g2_decap_4
Xfanout725 _11894_/B _12304_/B VDD VSS sg13g2_buf_1
Xfanout736 _11185_/A _07652_/Y VDD VSS sg13g2_buf_1
Xfanout747 _08431_/D fanout750/X VDD VSS sg13g2_buf_1
X_09854_ _14441_/D _14441_/Q _09953_/A1 _09870_/S VDD VSS sg13g2_mux2_1
XFILLER_86_723 VDD VSS sg13g2_decap_8
XFILLER_63_1357 VDD VSS sg13g2_decap_8
Xfanout758 _08079_/S _07627_/Y VDD VSS sg13g2_buf_1
XFILLER_85_200 VDD VSS sg13g2_fill_1
XFILLER_100_522 VDD VSS sg13g2_decap_8
Xfanout769 _11029_/C _10510_/B VDD VSS sg13g2_buf_1
XFILLER_105_35 VDD VSS sg13g2_decap_8
X_08805_ _13686_/D _08805_/A _08805_/B VDD VSS sg13g2_nor2_1
X_09785_ _14374_/D _09884_/A0 _14374_/Q _09796_/S VDD VSS sg13g2_mux2_1
XFILLER_74_918 VDD VSS sg13g2_fill_1
XFILLER_65_28 VDD VSS sg13g2_decap_4
X_14556__1623 _14556_/RESET_B VDD VSS sg13g2_tiehi
X_08736_ _08736_/Y _07720_/A _11288_/A _15198_/Q VDD VSS sg13g2_o21ai_1
XFILLER_85_288 VDD VSS sg13g2_decap_4
XFILLER_113_1171 VDD VSS sg13g2_decap_4
XFILLER_6_1295 VDD VSS sg13g2_decap_8
XFILLER_113_1182 VDD VSS sg13g2_decap_8
XFILLER_38_171 VDD VSS sg13g2_decap_8
XFILLER_27_834 VDD VSS sg13g2_decap_8
XFILLER_22_1065 VDD VSS sg13g2_decap_8
XFILLER_38_182 VDD VSS sg13g2_fill_2
XFILLER_2_1148 VDD VSS sg13g2_decap_8
XFILLER_96_1144 VDD VSS sg13g2_decap_8
X_08667_ _15247_/D _08667_/A1 _08666_/X _08661_/X VDD VSS sg13g2_o21ai_1
XFILLER_26_344 VDD VSS sg13g2_decap_8
XFILLER_164_7 VDD VSS sg13g2_decap_8
XFILLER_42_804 VDD VSS sg13g2_fill_1
XFILLER_54_675 VDD VSS sg13g2_decap_8
XFILLER_54_686 VDD VSS sg13g2_fill_2
XFILLER_121_67 VDD VSS sg13g2_fill_2
X_07618_ _09011_/B _14901_/Q VDD VSS sg13g2_inv_1
XFILLER_14_539 VDD VSS sg13g2_decap_8
XFILLER_81_483 VDD VSS sg13g2_fill_2
X_08598_ _08599_/C _08620_/A1 _08620_/A2 _08620_/A3 _08598_/A3 _08686_/S0 _08686_/S1
+ VDD VSS sg13g2_mux4_1
XFILLER_53_185 VDD VSS sg13g2_decap_8
XFILLER_14_21 VDD VSS sg13g2_decap_8
XFILLER_139_202 VDD VSS sg13g2_fill_1
XFILLER_167_511 VDD VSS sg13g2_decap_8
XFILLER_139_224 VDD VSS sg13g2_decap_8
XFILLER_50_881 VDD VSS sg13g2_fill_2
X_10560_ _10561_/D _14868_/Q _14867_/Q _14866_/Q _14865_/Q VDD VSS sg13g2_nand4_1
XFILLER_22_594 VDD VSS sg13g2_decap_8
XFILLER_10_756 VDD VSS sg13g2_decap_8
XFILLER_14_98 VDD VSS sg13g2_decap_8
XFILLER_167_588 VDD VSS sg13g2_decap_8
X_09219_ _13830_/D _09917_/A1 _13830_/Q _09230_/S VDD VSS sg13g2_mux2_1
X_10491_ _10493_/A _10513_/D _10498_/D _10619_/B VDD VSS sg13g2_o21ai_1
XFILLER_6_749 VDD VSS sg13g2_decap_8
XFILLER_120_1142 VDD VSS sg13g2_decap_8
X_12230_ _12231_/B _12272_/A _12204_/A _12274_/A VDD VSS sg13g2_o21ai_1
XFILLER_159_1330 VDD VSS sg13g2_fill_2
XFILLER_108_655 VDD VSS sg13g2_decap_4
XFILLER_120_1164 VDD VSS sg13g2_fill_2
XFILLER_163_750 VDD VSS sg13g2_decap_8
XFILLER_30_42 VDD VSS sg13g2_decap_8
XFILLER_5_259 VDD VSS sg13g2_decap_8
XFILLER_123_603 VDD VSS sg13g2_decap_8
XFILLER_151_912 VDD VSS sg13g2_decap_8
XFILLER_146_42 VDD VSS sg13g2_decap_8
X_12161_ _12161_/Y _12157_/Y _12158_/Y _12160_/Y _12159_/Y _12246_/B VDD VSS sg13g2_a221oi_1
XFILLER_150_411 VDD VSS sg13g2_decap_4
XFILLER_29_1219 VDD VSS sg13g2_decap_8
XFILLER_135_496 VDD VSS sg13g2_fill_2
XFILLER_162_271 VDD VSS sg13g2_decap_8
XFILLER_155_1227 VDD VSS sg13g2_decap_8
X_11112_ _14949_/D _11111_/Y _11110_/Y _11102_/Y VDD VSS sg13g2_o21ai_1
XFILLER_146_97 VDD VSS sg13g2_fill_2
X_12092_ _12092_/Y _12092_/A _12092_/B _12092_/C VDD VSS sg13g2_nand3_1
XFILLER_2_966 VDD VSS sg13g2_decap_8
X_14756__2960 _14756_/RESET_B VDD VSS sg13g2_tiehi
XFILLER_77_712 VDD VSS sg13g2_fill_2
X_11043_ _11044_/B _11043_/A _11043_/B _11078_/D VDD VSS sg13g2_nand3_1
XFILLER_7_1015 VDD VSS sg13g2_decap_8
XFILLER_1_476 VDD VSS sg13g2_decap_8
XFILLER_89_583 VDD VSS sg13g2_decap_8
XFILLER_76_200 VDD VSS sg13g2_decap_8
XFILLER_49_425 VDD VSS sg13g2_decap_4
XFILLER_77_745 VDD VSS sg13g2_fill_1
XFILLER_130_190 VDD VSS sg13g2_fill_1
XFILLER_162_63 VDD VSS sg13g2_decap_8
X_14195__1984 _14195_/RESET_B VDD VSS sg13g2_tiehi
XFILLER_92_704 VDD VSS sg13g2_decap_8
XFILLER_40_1110 VDD VSS sg13g2_fill_1
XFILLER_65_929 VDD VSS sg13g2_decap_8
XFILLER_58_970 VDD VSS sg13g2_decap_8
X_14802_ _14802_/Q _14867_/CLK _14802_/D _14802_/RESET_B VDD VSS sg13g2_dfrbpq_1
XFILLER_18_812 VDD VSS sg13g2_decap_8
XFILLER_91_214 VDD VSS sg13g2_fill_2
X_12994_ _13010_/A _12994_/A _13058_/D VDD VSS sg13g2_nand2_1
XFILLER_92_748 VDD VSS sg13g2_decap_8
XFILLER_45_631 VDD VSS sg13g2_decap_8
XFILLER_17_322 VDD VSS sg13g2_decap_8
XFILLER_40_1176 VDD VSS sg13g2_fill_1
X_14733_ _14733_/Q _14733_/CLK _14733_/D _14733_/RESET_B VDD VSS sg13g2_dfrbpq_1
X_11945_ _11946_/A _13968_/Q _14000_/Q _14032_/Q _14064_/Q _11963_/S0 _11970_/C VDD
+ VSS sg13g2_mux4_1
XFILLER_73_962 VDD VSS sg13g2_decap_8
XFILLER_73_973 VDD VSS sg13g2_fill_2
XFILLER_55_72 VDD VSS sg13g2_decap_8
XFILLER_18_889 VDD VSS sg13g2_decap_8
XFILLER_72_472 VDD VSS sg13g2_decap_8
XFILLER_45_686 VDD VSS sg13g2_decap_8
X_14664_ _14664_/Q _14728_/CLK _14664_/D _14664_/RESET_B VDD VSS sg13g2_dfrbpq_1
X_11876_ _11876_/Y _11873_/Y _11875_/X _12332_/B1 VDD VSS sg13g2_o21ai_1
XFILLER_17_399 VDD VSS sg13g2_decap_8
X_13615_ _13723_/D _13615_/A VDD VSS sg13g2_buf_1
X_10827_ _10831_/A _12347_/B _10827_/B VDD VSS sg13g2_nand2b_1
XFILLER_60_667 VDD VSS sg13g2_decap_8
XFILLER_38_1061 VDD VSS sg13g2_decap_8
XFILLER_158_511 VDD VSS sg13g2_decap_8
X_14595_ _14595_/Q clkload19/A _14595_/D _14595_/RESET_B VDD VSS sg13g2_dfrbpq_1
XFILLER_164_1091 VDD VSS sg13g2_decap_8
X_13546_ _13546_/Y _14996_/Q _13563_/C _08383_/B _13546_/B2 VDD VSS sg13g2_a22oi_1
XFILLER_9_532 VDD VSS sg13g2_decap_8
XFILLER_119_909 VDD VSS sg13g2_decap_4
X_10758_ _11115_/A _14948_/Q _10757_/A _10757_/Y VDD VSS sg13g2_a21oi_1
XFILLER_146_717 VDD VSS sg13g2_fill_2
XFILLER_125_1086 VDD VSS sg13g2_decap_4
XFILLER_118_419 VDD VSS sg13g2_decap_8
XFILLER_125_1097 VDD VSS sg13g2_decap_4
X_13477_ _15179_/D hold3027/X _15179_/Q _13477_/S VDD VSS sg13g2_mux2_1
X_10689_ _10689_/Y _14899_/Q _10862_/B VDD VSS sg13g2_nand2_1
XFILLER_173_536 VDD VSS sg13g2_fill_1
X_15216_ _15216_/Q clkload68/A _15216_/D _15216_/RESET_B VDD VSS sg13g2_dfrbpq_1
X_12428_ _12428_/X _12426_/X _12427_/X _12776_/S VDD VSS sg13g2_mux2_1
XFILLER_12_1267 VDD VSS sg13g2_decap_8
XFILLER_154_750 VDD VSS sg13g2_decap_8
XFILLER_86_1335 VDD VSS sg13g2_decap_4
XFILLER_142_923 VDD VSS sg13g2_fill_2
X_14634__1545 _14634_/RESET_B VDD VSS sg13g2_tiehi
X_15147_ _15147_/Q clkload60/A _15147_/D _15147_/RESET_B VDD VSS sg13g2_dfrbpq_1
X_12359_ _12359_/Y _15119_/Q _12348_/A _12777_/A2 _15123_/Q _13282_/A1 VDD VSS sg13g2_a221oi_1
XFILLER_47_1308 VDD VSS sg13g2_decap_8
XFILLER_153_271 VDD VSS sg13g2_decap_8
XFILLER_173_1316 VDD VSS sg13g2_decap_8
XFILLER_114_647 VDD VSS sg13g2_fill_2
X_15078_ _15078_/Q clkload70/A _15078_/D _15078_/RESET_B VDD VSS sg13g2_dfrbpq_1
XFILLER_113_146 VDD VSS sg13g2_decap_8
XFILLER_141_466 VDD VSS sg13g2_decap_8
XFILLER_101_308 VDD VSS sg13g2_decap_8
X_14029_ _14029_/Q clkload4/A _14029_/D _14029_/RESET_B VDD VSS sg13g2_dfrbpq_1
XFILLER_171_1062 VDD VSS sg13g2_decap_8
XFILLER_83_715 VDD VSS sg13g2_decap_8
XFILLER_49_970 VDD VSS sg13g2_fill_2
XFILLER_110_897 VDD VSS sg13g2_fill_1
XFILLER_132_1079 VDD VSS sg13g2_decap_8
X_09570_ _14168_/D _09636_/A0 _14168_/Q _09572_/S VDD VSS sg13g2_mux2_1
XFILLER_55_428 VDD VSS sg13g2_decap_8
XFILLER_27_119 VDD VSS sg13g2_decap_8
XFILLER_23_1363 VDD VSS sg13g2_decap_8
XFILLER_110_1322 VDD VSS sg13g2_decap_8
X_15002__2585 _15002_/RESET_B VDD VSS sg13g2_tiehi
XFILLER_83_759 VDD VSS sg13g2_fill_1
XFILLER_36_631 VDD VSS sg13g2_decap_4
X_08521_ _08521_/X _08279_/A _08362_/X _08457_/X _08597_/C _08597_/B _08617_/A VDD
+ VSS sg13g2_mux4_1
XFILLER_82_247 VDD VSS sg13g2_decap_8
XFILLER_36_675 VDD VSS sg13g2_fill_2
X_08452_ _08461_/A _08452_/A _08544_/B _08452_/C _08452_/D VDD VSS sg13g2_nand4_1
XFILLER_91_792 VDD VSS sg13g2_decap_8
XFILLER_23_336 VDD VSS sg13g2_decap_8
XFILLER_168_308 VDD VSS sg13g2_decap_8
XFILLER_50_133 VDD VSS sg13g2_fill_1
XFILLER_149_500 VDD VSS sg13g2_fill_1
XFILLER_51_667 VDD VSS sg13g2_fill_1
X_08383_ _08412_/B _08383_/A _08383_/B VDD VSS sg13g2_nor2_1
XFILLER_143_1120 VDD VSS sg13g2_fill_2
XFILLER_50_155 VDD VSS sg13g2_decap_8
XFILLER_149_522 VDD VSS sg13g2_decap_8
XFILLER_17_1134 VDD VSS sg13g2_decap_8
XFILLER_91_1085 VDD VSS sg13g2_decap_8
XFILLER_164_525 VDD VSS sg13g2_decap_8
X_09004_ _09006_/B _14900_/Q _08993_/X _14901_/Q VDD VSS sg13g2_a21oi_1
XFILLER_30_1345 VDD VSS sg13g2_decap_8
XFILLER_152_709 VDD VSS sg13g2_decap_8
XFILLER_144_260 VDD VSS sg13g2_decap_8
XFILLER_145_783 VDD VSS sg13g2_decap_8
XFILLER_172_580 VDD VSS sg13g2_decap_8
XFILLER_172_591 VDD VSS sg13g2_fill_1
XFILLER_105_658 VDD VSS sg13g2_decap_8
XFILLER_160_764 VDD VSS sg13g2_decap_8
XFILLER_104_157 VDD VSS sg13g2_decap_8
Xfanout500 _13655_/S _13654_/S VDD VSS sg13g2_buf_1
XFILLER_8_1302 VDD VSS sg13g2_decap_8
XFILLER_104_168 VDD VSS sg13g2_fill_2
XFILLER_120_617 VDD VSS sg13g2_fill_1
Xfanout511 _13593_/B _13570_/S VDD VSS sg13g2_buf_1
Xfanout522 _11236_/C _11235_/X VDD VSS sg13g2_buf_1
X_09906_ _14491_/D _14491_/Q _09906_/A1 _09931_/S VDD VSS sg13g2_mux2_1
XFILLER_59_712 VDD VSS sg13g2_decap_4
XFILLER_28_1252 VDD VSS sg13g2_decap_8
Xfanout533 _09906_/A1 _10138_/A1 VDD VSS sg13g2_buf_1
XFILLER_63_1154 VDD VSS sg13g2_fill_1
XFILLER_101_831 VDD VSS sg13g2_decap_8
XFILLER_116_78 VDD VSS sg13g2_decap_8
Xfanout544 _08781_/B _08761_/B VDD VSS sg13g2_buf_1
Xfanout555 _08110_/D _08034_/Y VDD VSS sg13g2_buf_1
Xfanout566 _13275_/B1 _13297_/A0 VDD VSS sg13g2_buf_1
XFILLER_24_1127 VDD VSS sg13g2_decap_8
XFILLER_115_1255 VDD VSS sg13g2_decap_8
Xfanout577 _12267_/A2 _11904_/A2 VDD VSS sg13g2_buf_1
X_09837_ _14425_/D _09936_/A1 _14425_/Q _09837_/S VDD VSS sg13g2_mux2_1
Xfanout588 _10862_/B _13294_/B VDD VSS sg13g2_buf_1
XFILLER_8_1379 VDD VSS sg13g2_decap_4
XFILLER_47_918 VDD VSS sg13g2_decap_8
XFILLER_19_609 VDD VSS sg13g2_decap_8
XFILLER_98_1206 VDD VSS sg13g2_decap_8
XFILLER_150_1157 VDD VSS sg13g2_fill_2
Xfanout599 _10747_/A _10794_/A2 VDD VSS sg13g2_buf_1
XFILLER_100_363 VDD VSS sg13g2_fill_1
XFILLER_111_1119 VDD VSS sg13g2_fill_1
XFILLER_18_119 VDD VSS sg13g2_decap_8
XFILLER_100_385 VDD VSS sg13g2_decap_8
X_09768_ _14358_/D _14358_/Q _09768_/A1 _09768_/S VDD VSS sg13g2_mux2_1
XFILLER_100_396 VDD VSS sg13g2_fill_2
X_14072__2107 _14072_/RESET_B VDD VSS sg13g2_tiehi
XFILLER_6_1092 VDD VSS sg13g2_decap_8
X_08719_ _15192_/D hold3079/X _15192_/Q _10203_/S VDD VSS sg13g2_mux2_1
X_09699_ _14291_/D _09930_/A1 _14291_/Q _09705_/S VDD VSS sg13g2_mux2_1
XFILLER_27_664 VDD VSS sg13g2_fill_1
XFILLER_15_826 VDD VSS sg13g2_decap_8
XFILLER_42_612 VDD VSS sg13g2_decap_8
X_11730_ _11730_/Y _11749_/A1 _14122_/Q VDD VSS sg13g2_nand2b_1
XFILLER_148_1053 VDD VSS sg13g2_decap_8
XFILLER_82_792 VDD VSS sg13g2_decap_8
XFILLER_42_623 VDD VSS sg13g2_decap_8
XFILLER_25_42 VDD VSS sg13g2_decap_8
XFILLER_14_336 VDD VSS sg13g2_decap_8
XFILLER_26_196 VDD VSS sg13g2_decap_8
XFILLER_159_308 VDD VSS sg13g2_decap_8
X_14712__1467 _14712_/RESET_B VDD VSS sg13g2_tiehi
XFILLER_41_133 VDD VSS sg13g2_decap_8
XFILLER_109_1048 VDD VSS sg13g2_fill_1
X_11661_ _11773_/B _11661_/A _13680_/Q VDD VSS sg13g2_xnor2_1
XFILLER_35_1201 VDD VSS sg13g2_fill_2
XFILLER_42_678 VDD VSS sg13g2_decap_8
XFILLER_168_831 VDD VSS sg13g2_decap_8
X_15173__2949 _15173_/RESET_B VDD VSS sg13g2_tiehi
X_13400_ _13400_/Y _13427_/A _13469_/A _15088_/Q VDD VSS sg13g2_nand3_1
XFILLER_74_1283 VDD VSS sg13g2_fill_1
X_10612_ _10614_/B _14880_/Q _14879_/Q VDD VSS sg13g2_nand2_1
X_14380_ _14380_/Q clkload35/A _14380_/D _14380_/RESET_B VDD VSS sg13g2_dfrbpq_1
XFILLER_74_1294 VDD VSS sg13g2_decap_8
XFILLER_122_1204 VDD VSS sg13g2_decap_8
X_11592_ _11593_/B _11570_/A _13683_/Q _11571_/Y VDD VSS sg13g2_a21oi_1
XFILLER_35_1256 VDD VSS sg13g2_decap_4
XFILLER_155_503 VDD VSS sg13g2_fill_1
XFILLER_168_886 VDD VSS sg13g2_decap_8
XFILLER_128_728 VDD VSS sg13g2_decap_8
X_13331_ _15173_/D _13502_/B VDD VSS sg13g2_inv_1
XFILLER_35_1289 VDD VSS sg13g2_fill_1
XFILLER_10_553 VDD VSS sg13g2_decap_8
X_10543_ _10544_/B _14863_/Q _10566_/D _10543_/C _10543_/D VDD VSS sg13g2_nand4_1
XFILLER_155_525 VDD VSS sg13g2_decap_8
XFILLER_161_1297 VDD VSS sg13g2_decap_4
XFILLER_167_385 VDD VSS sg13g2_decap_8
XFILLER_155_536 VDD VSS sg13g2_fill_1
XFILLER_41_63 VDD VSS sg13g2_decap_8
XFILLER_109_942 VDD VSS sg13g2_decap_4
XFILLER_41_74 VDD VSS sg13g2_fill_2
X_13262_ _13262_/Y _14797_/Q _13275_/A2 _13297_/A0 VDD VSS sg13g2_o21ai_1
XFILLER_6_546 VDD VSS sg13g2_decap_8
XFILLER_157_63 VDD VSS sg13g2_decap_8
X_10474_ _10474_/Y _10486_/D _10492_/C _10619_/B VDD VSS sg13g2_o21ai_1
XFILLER_68_1010 VDD VSS sg13g2_decap_8
XFILLER_109_986 VDD VSS sg13g2_fill_1
XFILLER_136_761 VDD VSS sg13g2_decap_8
X_15001_ _15001_/Q clkload59/A _15001_/D _15001_/RESET_B VDD VSS sg13g2_dfrbpq_1
X_12213_ _12213_/X _14135_/Q _14167_/Q _14199_/Q _14231_/Q _12215_/S0 _12213_/S1 VDD
+ VSS sg13g2_mux4_1
XFILLER_142_219 VDD VSS sg13g2_decap_8
XFILLER_170_539 VDD VSS sg13g2_decap_8
X_13193_ _13196_/A _14792_/Q _13248_/B VDD VSS sg13g2_nand2_1
XFILLER_108_496 VDD VSS sg13g2_fill_1
XFILLER_135_271 VDD VSS sg13g2_decap_8
XFILLER_68_1054 VDD VSS sg13g2_fill_1
X_12144_ _12144_/Y _12292_/A _12144_/B VDD VSS sg13g2_nor2_1
XFILLER_97_807 VDD VSS sg13g2_decap_8
XFILLER_151_764 VDD VSS sg13g2_decap_4
XFILLER_123_466 VDD VSS sg13g2_decap_8
XFILLER_2_763 VDD VSS sg13g2_decap_8
XFILLER_155_1068 VDD VSS sg13g2_decap_8
XFILLER_110_105 VDD VSS sg13g2_decap_4
XFILLER_155_1079 VDD VSS sg13g2_fill_2
XFILLER_46_1352 VDD VSS sg13g2_fill_1
X_12075_ _12077_/B _12291_/A _12075_/B VDD VSS sg13g2_nor2_1
XFILLER_1_273 VDD VSS sg13g2_decap_8
XFILLER_173_84 VDD VSS sg13g2_decap_8
X_14904__2736 _14904_/RESET_B VDD VSS sg13g2_tiehi
XFILLER_2_35 VDD VSS sg13g2_decap_8
X_11026_ _11029_/A _11022_/Y _11064_/B _11025_/Y VDD VSS sg13g2_o21ai_1
XFILLER_133_1355 VDD VSS sg13g2_fill_1
X_16883_ _16883_/X _16883_/A VDD VSS sg13g2_buf_1
XFILLER_49_277 VDD VSS sg13g2_decap_8
XFILLER_66_60 VDD VSS sg13g2_fill_2
XFILLER_64_225 VDD VSS sg13g2_decap_8
X_14048__2131 _14048_/RESET_B VDD VSS sg13g2_tiehi
X_12977_ _12977_/Y _14810_/Q _13014_/A2 _13013_/B _14874_/Q _13207_/C1 VDD VSS sg13g2_a221oi_1
XFILLER_166_1120 VDD VSS sg13g2_fill_2
XFILLER_46_995 VDD VSS sg13g2_decap_8
XFILLER_18_686 VDD VSS sg13g2_decap_8
XFILLER_79_1183 VDD VSS sg13g2_decap_8
XFILLER_33_612 VDD VSS sg13g2_decap_4
X_14716_ _14716_/Q _14746_/CLK _14716_/D _14716_/RESET_B VDD VSS sg13g2_dfrbpq_1
X_11928_ _11928_/X _11920_/X _11921_/X _11923_/X _11922_/X _11964_/B _11974_/B1 VDD
+ VSS sg13g2_mux4_1
XFILLER_45_483 VDD VSS sg13g2_decap_8
XFILLER_33_634 VDD VSS sg13g2_fill_1
XFILLER_17_196 VDD VSS sg13g2_decap_8
XFILLER_162_1006 VDD VSS sg13g2_decap_8
XFILLER_33_656 VDD VSS sg13g2_decap_8
XFILLER_32_133 VDD VSS sg13g2_decap_8
X_14647_ _14647_/Q clkload33/A _14647_/D _14647_/RESET_B VDD VSS sg13g2_dfrbpq_1
XFILLER_60_453 VDD VSS sg13g2_decap_8
X_11859_ _11859_/Y _11975_/A _11857_/X _11858_/Y VDD VSS sg13g2_o21ai_1
XFILLER_32_155 VDD VSS sg13g2_decap_8
XFILLER_61_998 VDD VSS sg13g2_decap_8
XFILLER_53_1334 VDD VSS sg13g2_decap_8
XANTENNA_18 wire504/X VDD VSS sg13g2_antennanp
XANTENNA_29 _16880_/A VDD VSS sg13g2_antennanp
X_14578_ _14578_/Q _14706_/CLK _14578_/D _14578_/RESET_B VDD VSS sg13g2_dfrbpq_1
XFILLER_119_706 VDD VSS sg13g2_decap_4
X_13770__2409 _13770_/RESET_B VDD VSS sg13g2_tiehi
XFILLER_158_363 VDD VSS sg13g2_fill_1
XFILLER_118_205 VDD VSS sg13g2_decap_8
X_13529_ _13529_/X _13529_/A _13533_/B VDD VSS sg13g2_and2_1
XFILLER_173_322 VDD VSS sg13g2_decap_8
XFILLER_146_558 VDD VSS sg13g2_decap_8
XFILLER_127_750 VDD VSS sg13g2_decap_8
XFILLER_115_901 VDD VSS sg13g2_fill_2
XFILLER_12_1064 VDD VSS sg13g2_decap_8
X_15115__2729 _15115_/RESET_B VDD VSS sg13g2_tiehi
XFILLER_86_1110 VDD VSS sg13g2_decap_8
XFILLER_115_923 VDD VSS sg13g2_decap_4
Xoutput103 mem_axi_rready _07658_/X VDD VSS sg13g2_buf_1
Xoutput114 mem_axi_wdata[19] _15151_/Q VDD VSS sg13g2_buf_1
X_14150__2029 _14150_/RESET_B VDD VSS sg13g2_tiehi
Xoutput125 mem_axi_wdata[29] _15161_/Q VDD VSS sg13g2_buf_1
XFILLER_47_1105 VDD VSS sg13g2_decap_8
Xoutput136 mem_axi_wstrb[0] _15164_/Q VDD VSS sg13g2_buf_1
X_15166__2509 _15166_/RESET_B VDD VSS sg13g2_tiehi
XFILLER_99_133 VDD VSS sg13g2_decap_8
XFILLER_49_0 VDD VSS sg13g2_decap_8
XFILLER_115_978 VDD VSS sg13g2_decap_8
XFILLER_141_230 VDD VSS sg13g2_fill_2
XFILLER_173_1135 VDD VSS sg13g2_fill_2
XFILLER_114_466 VDD VSS sg13g2_decap_4
XFILLER_130_915 VDD VSS sg13g2_decap_8
XFILLER_99_166 VDD VSS sg13g2_decap_8
XFILLER_134_1108 VDD VSS sg13g2_decap_8
XFILLER_102_628 VDD VSS sg13g2_decap_8
XFILLER_114_499 VDD VSS sg13g2_decap_8
X_07952_ _07952_/Y _15009_/Q _07821_/B VDD VSS sg13g2_nor2b_1
XFILLER_101_116 VDD VSS sg13g2_decap_8
X_14258__1921 _14258_/RESET_B VDD VSS sg13g2_tiehi
XFILLER_60_1305 VDD VSS sg13g2_fill_2
X_07883_ _08073_/C _08033_/A _08063_/B VDD VSS sg13g2_nand2_1
XFILLER_56_704 VDD VSS sg13g2_decap_8
XFILLER_110_672 VDD VSS sg13g2_decap_8
X_09622_ _14218_/D _09622_/A0 _14218_/Q _09632_/S VDD VSS sg13g2_mux2_1
XFILLER_28_428 VDD VSS sg13g2_decap_8
XFILLER_83_534 VDD VSS sg13g2_decap_4
XFILLER_3_1232 VDD VSS sg13g2_decap_8
XFILLER_23_1160 VDD VSS sg13g2_decap_8
X_09553_ _14151_/D _10083_/A0 _14151_/Q _09567_/S VDD VSS sg13g2_mux2_1
XFILLER_102_14 VDD VSS sg13g2_decap_8
XFILLER_71_718 VDD VSS sg13g2_decap_8
XFILLER_102_25 VDD VSS sg13g2_fill_2
XFILLER_37_984 VDD VSS sg13g2_decap_8
XFILLER_24_601 VDD VSS sg13g2_decap_8
X_08504_ _08504_/Y _15009_/Q _07821_/B _08497_/A VDD VSS sg13g2_a21oi_1
XFILLER_97_1283 VDD VSS sg13g2_fill_2
XFILLER_70_217 VDD VSS sg13g2_decap_8
XFILLER_52_921 VDD VSS sg13g2_fill_2
XFILLER_64_792 VDD VSS sg13g2_fill_1
X_09484_ _14084_/D _10047_/A0 _14084_/Q _09502_/S VDD VSS sg13g2_mux2_1
XFILLER_70_239 VDD VSS sg13g2_decap_4
XFILLER_19_1218 VDD VSS sg13g2_decap_8
XFILLER_23_133 VDD VSS sg13g2_decap_8
XFILLER_168_105 VDD VSS sg13g2_decap_8
X_08435_ _08435_/Y _08435_/A _08442_/B VDD VSS sg13g2_nand2_1
XFILLER_169_639 VDD VSS sg13g2_fill_2
XFILLER_145_1259 VDD VSS sg13g2_decap_4
X_08366_ _08366_/X _08414_/D _08414_/A _08414_/B _08366_/D VDD VSS sg13g2_or4_1
XFILLER_20_840 VDD VSS sg13g2_decap_8
XFILLER_108_1081 VDD VSS sg13g2_fill_1
XFILLER_149_363 VDD VSS sg13g2_decap_8
X_14360__1819 _14360_/RESET_B VDD VSS sg13g2_tiehi
X_13746__2433 _13746_/RESET_B VDD VSS sg13g2_tiehi
X_08297_ _08297_/Y _08369_/B _08294_/Y _08296_/Y _08295_/Y VDD VSS sg13g2_a22oi_1
XFILLER_127_7 VDD VSS sg13g2_decap_8
XFILLER_164_322 VDD VSS sg13g2_decap_8
XFILLER_165_867 VDD VSS sg13g2_fill_1
XFILLER_30_1142 VDD VSS sg13g2_decap_8
XFILLER_69_1330 VDD VSS sg13g2_decap_8
XFILLER_121_1281 VDD VSS sg13g2_decap_8
XFILLER_121_1292 VDD VSS sg13g2_fill_2
XFILLER_156_1300 VDD VSS sg13g2_decap_8
XFILLER_133_720 VDD VSS sg13g2_fill_2
XFILLER_145_580 VDD VSS sg13g2_decap_8
XFILLER_164_399 VDD VSS sg13g2_decap_8
XFILLER_11_77 VDD VSS sg13g2_decap_8
X_14126__2053 _14126_/RESET_B VDD VSS sg13g2_tiehi
XFILLER_132_230 VDD VSS sg13g2_decap_8
X_10190_ _14752_/D _15195_/D _14752_/Q _10194_/S VDD VSS sg13g2_mux2_1
XFILLER_127_77 VDD VSS sg13g2_decap_4
XFILLER_87_59 VDD VSS sg13g2_fill_1
Xfanout1306 _11925_/S0 fanout1308/X VDD VSS sg13g2_buf_1
Xfanout1317 _11804_/A _11358_/S0 VDD VSS sg13g2_buf_1
Xfanout330 _09870_/S wire331/X VDD VSS sg13g2_buf_1
Xfanout1328 _11310_/A1 _11320_/S0 VDD VSS sg13g2_buf_1
XFILLER_143_21 VDD VSS sg13g2_decap_8
Xfanout341 _09733_/S _09739_/S VDD VSS sg13g2_buf_1
Xfanout1339 _12250_/A1 fanout1346/X VDD VSS sg13g2_buf_1
XFILLER_101_650 VDD VSS sg13g2_fill_1
Xfanout363 _09297_/S _09292_/S VDD VSS sg13g2_buf_1
Xfanout374 _09201_/S _09189_/S VDD VSS sg13g2_buf_1
XFILLER_8_1176 VDD VSS sg13g2_decap_8
Xfanout385 _10145_/A1 _10045_/A0 VDD VSS sg13g2_buf_1
XFILLER_19_406 VDD VSS sg13g2_decap_8
X_12900_ _12902_/B _12900_/A _12900_/B _12900_/C input18/X VDD VSS sg13g2_nand4_1
Xfanout396 _09908_/A1 wire398/X VDD VSS sg13g2_buf_1
XFILLER_74_512 VDD VSS sg13g2_fill_1
XFILLER_4_1029 VDD VSS sg13g2_decap_8
X_13880_ _13880_/Q _14984_/CLK _13880_/D _13880_/RESET_B VDD VSS sg13g2_dfrbpq_1
XFILLER_74_545 VDD VSS sg13g2_decap_8
X_13994__2185 _13994_/RESET_B VDD VSS sg13g2_tiehi
X_12831_ _12831_/Y _14769_/Q _13275_/A2 _13140_/B2 VDD VSS sg13g2_o21ai_1
XFILLER_74_567 VDD VSS sg13g2_decap_8
XFILLER_28_962 VDD VSS sg13g2_fill_1
XFILLER_76_1301 VDD VSS sg13g2_decap_8
XFILLER_36_63 VDD VSS sg13g2_decap_8
XFILLER_15_623 VDD VSS sg13g2_decap_8
X_12762_ _12762_/X _12760_/X _12761_/X _12762_/S VDD VSS sg13g2_mux2_1
XFILLER_43_943 VDD VSS sg13g2_decap_8
XFILLER_42_420 VDD VSS sg13g2_decap_8
X_14501_ _14501_/Q clkload7/A _14501_/D _14501_/RESET_B VDD VSS sg13g2_dfrbpq_1
XFILLER_14_133 VDD VSS sg13g2_decap_8
XFILLER_153_0 VDD VSS sg13g2_decap_8
XFILLER_159_105 VDD VSS sg13g2_decap_8
X_11713_ _11713_/X _13961_/Q _13993_/Q _14025_/Q _14057_/Q _12282_/S0 _12282_/S1 VDD
+ VSS sg13g2_mux4_1
XFILLER_37_1329 VDD VSS sg13g2_decap_8
X_12693_ _12694_/B _13190_/B _12721_/A2 _12692_/X _12721_/B2 _12777_/C1 VDD VSS sg13g2_a221oi_1
X_14432_ _14432_/Q clkload29/A _14432_/D _14432_/RESET_B VDD VSS sg13g2_dfrbpq_1
X_11644_ _11644_/X _14695_/Q _14727_/Q _13767_/Q _13799_/Q _11651_/S0 _11651_/S1 VDD
+ VSS sg13g2_mux4_1
XFILLER_11_840 VDD VSS sg13g2_decap_8
XFILLER_35_1053 VDD VSS sg13g2_decap_4
XFILLER_174_108 VDD VSS sg13g2_decap_8
XFILLER_174_119 VDD VSS sg13g2_decap_8
X_14363_ _14363_/Q _14885_/CLK _14363_/D _14363_/RESET_B VDD VSS sg13g2_dfrbpq_1
XFILLER_10_350 VDD VSS sg13g2_decap_8
X_14336__1843 _14336_/RESET_B VDD VSS sg13g2_tiehi
Xinput16 input16/X input16/A VDD VSS sg13g2_buf_1
X_11575_ _11575_/X _13829_/Q _13861_/Q _13893_/Q _13925_/Q _11997_/S0 _11997_/S1 VDD
+ VSS sg13g2_mux4_1
Xinput27 input27/X input27/A VDD VSS sg13g2_buf_1
XFILLER_7_833 VDD VSS sg13g2_decap_8
XFILLER_167_182 VDD VSS sg13g2_decap_8
XFILLER_168_84 VDD VSS sg13g2_decap_8
XFILLER_156_867 VDD VSS sg13g2_fill_2
X_13314_ _13314_/X _15061_/Q _13600_/C _13316_/C VDD VSS sg13g2_and3_1
Xinput38 input38/X rst_ni VDD VSS sg13g2_buf_1
X_10526_ _14857_/D _10558_/C _10531_/D _10525_/Y VDD VSS sg13g2_a21oi_1
XFILLER_13_1351 VDD VSS sg13g2_decap_8
XFILLER_155_355 VDD VSS sg13g2_decap_4
X_14294_ _14294_/Q clkload28/A _14294_/D _14294_/RESET_B VDD VSS sg13g2_dfrbpq_1
XFILLER_6_343 VDD VSS sg13g2_decap_8
XFILLER_100_1310 VDD VSS sg13g2_decap_8
XFILLER_171_815 VDD VSS sg13g2_decap_4
XFILLER_157_1108 VDD VSS sg13g2_decap_8
XFILLER_155_388 VDD VSS sg13g2_fill_1
X_13245_ _13245_/X _13245_/A _13665_/Q _13246_/C VDD VSS sg13g2_and3_1
XFILLER_108_271 VDD VSS sg13g2_decap_8
X_10457_ _10460_/C _14841_/Q _10462_/D _14842_/Q VDD VSS sg13g2_a21oi_1
XFILLER_170_336 VDD VSS sg13g2_decap_8
XFILLER_83_1316 VDD VSS sg13g2_fill_1
XFILLER_123_230 VDD VSS sg13g2_decap_8
XFILLER_124_753 VDD VSS sg13g2_decap_8
X_13176_ _13188_/A _13176_/A _13176_/B _13176_/C VDD VSS sg13g2_nand3_1
XFILLER_42_7 VDD VSS sg13g2_decap_8
X_10388_ _10388_/Y _14820_/Q _10386_/C _10392_/B VDD VSS sg13g2_o21ai_1
XFILLER_83_1349 VDD VSS sg13g2_decap_8
XFILLER_2_560 VDD VSS sg13g2_decap_8
X_12127_ _12155_/A _12128_/A _13667_/Q VDD VSS sg13g2_nand2_1
XFILLER_112_959 VDD VSS sg13g2_decap_8
XFILLER_46_1171 VDD VSS sg13g2_fill_1
X_12058_ _12058_/Y _12012_/A _12008_/Y _12010_/B VDD VSS sg13g2_o21ai_1
XFILLER_38_715 VDD VSS sg13g2_decap_8
XFILLER_38_726 VDD VSS sg13g2_fill_1
X_11009_ _11010_/C _11009_/A _11009_/B _11009_/C _11009_/D VDD VSS sg13g2_nand4_1
XFILLER_37_214 VDD VSS sg13g2_decap_8
X_16866_ _16866_/X _16866_/A VDD VSS sg13g2_buf_1
X_15144__2669 _15144_/RESET_B VDD VSS sg13g2_tiehi
X_13824__2355 _13824_/RESET_B VDD VSS sg13g2_tiehi
XFILLER_168_1237 VDD VSS sg13g2_fill_2
X_14584__1595 _14584_/RESET_B VDD VSS sg13g2_tiehi
XFILLER_92_364 VDD VSS sg13g2_decap_4
XFILLER_20_1344 VDD VSS sg13g2_decap_8
XFILLER_19_973 VDD VSS sg13g2_decap_8
XFILLER_46_770 VDD VSS sg13g2_fill_2
XFILLER_18_483 VDD VSS sg13g2_decap_8
XFILLER_33_442 VDD VSS sg13g2_fill_1
XFILLER_33_453 VDD VSS sg13g2_decap_8
XFILLER_34_987 VDD VSS sg13g2_fill_1
X_08220_ _08220_/X _08860_/A1 _13545_/A _08432_/A2 VDD VSS sg13g2_a21o_1
XFILLER_33_486 VDD VSS sg13g2_decap_8
XFILLER_21_637 VDD VSS sg13g2_decap_8
XFILLER_159_650 VDD VSS sg13g2_decap_8
XFILLER_166_609 VDD VSS sg13g2_decap_8
XFILLER_147_801 VDD VSS sg13g2_fill_1
XFILLER_92_1191 VDD VSS sg13g2_decap_8
XFILLER_159_661 VDD VSS sg13g2_fill_2
XFILLER_20_147 VDD VSS sg13g2_decap_8
XFILLER_147_823 VDD VSS sg13g2_fill_2
XFILLER_159_683 VDD VSS sg13g2_decap_8
XFILLER_165_119 VDD VSS sg13g2_decap_8
X_08151_ _08151_/X _07912_/B _11335_/A _11384_/A _08063_/B _08235_/S0 _07900_/B VDD
+ VSS sg13g2_mux4_1
XFILLER_18_1295 VDD VSS sg13g2_decap_8
XFILLER_14_1148 VDD VSS sg13g2_decap_8
XFILLER_158_182 VDD VSS sg13g2_decap_8
XFILLER_146_344 VDD VSS sg13g2_decap_4
X_08082_ _08082_/X _08081_/X _08079_/X _08194_/B VDD VSS sg13g2_mux2_1
XFILLER_161_303 VDD VSS sg13g2_decap_8
XFILLER_134_539 VDD VSS sg13g2_decap_8
XFILLER_115_797 VDD VSS sg13g2_decap_8
X_08984_ _13758_/D _13758_/Q _10074_/A0 _09167_/S VDD VSS sg13g2_mux2_1
XFILLER_69_840 VDD VSS sg13g2_decap_8
XFILLER_25_1211 VDD VSS sg13g2_decap_8
X_07935_ _07935_/Y _08414_/D _07934_/Y _07933_/Y VDD VSS sg13g2_a21oi_1
XFILLER_64_1282 VDD VSS sg13g2_fill_1
XFILLER_75_309 VDD VSS sg13g2_decap_4
XFILLER_60_1124 VDD VSS sg13g2_decap_8
XFILLER_111_970 VDD VSS sg13g2_fill_2
XFILLER_112_1203 VDD VSS sg13g2_decap_8
XFILLER_5_1316 VDD VSS sg13g2_decap_8
XFILLER_96_692 VDD VSS sg13g2_decap_4
XFILLER_28_214 VDD VSS sg13g2_decap_8
X_07866_ _07866_/Y _07969_/A _08678_/A _08650_/A _07867_/D VDD VSS sg13g2_nor4_1
XFILLER_25_1288 VDD VSS sg13g2_decap_8
X_09605_ _14202_/D _14202_/Q _09772_/A1 _09605_/S VDD VSS sg13g2_mux2_1
XFILLER_84_876 VDD VSS sg13g2_fill_1
XFILLER_56_567 VDD VSS sg13g2_decap_8
X_14414__1765 _14414_/RESET_B VDD VSS sg13g2_tiehi
X_07797_ _07797_/X _07797_/A _07797_/B _07797_/C _07797_/D VDD VSS sg13g2_or4_1
XFILLER_73_28 VDD VSS sg13g2_decap_8
X_09536_ _14135_/D _10099_/A0 _14135_/Q _09538_/S VDD VSS sg13g2_mux2_1
XFILLER_58_1042 VDD VSS sg13g2_fill_2
XFILLER_58_1053 VDD VSS sg13g2_fill_2
XFILLER_52_740 VDD VSS sg13g2_fill_1
XFILLER_19_1015 VDD VSS sg13g2_decap_8
X_09467_ _14068_/D _09632_/A0 _14068_/Q _09467_/S VDD VSS sg13g2_mux2_1
XFILLER_58_1086 VDD VSS sg13g2_decap_8
XFILLER_12_637 VDD VSS sg13g2_decap_8
X_13979__2200 _13979_/RESET_B VDD VSS sg13g2_tiehi
X_08418_ _08419_/A _08418_/A _08418_/B VDD VSS sg13g2_and2_1
XFILLER_169_469 VDD VSS sg13g2_decap_8
XFILLER_106_1029 VDD VSS sg13g2_decap_8
X_09398_ _14001_/D _09629_/A0 _14001_/Q _09398_/S VDD VSS sg13g2_mux2_1
XFILLER_71_1231 VDD VSS sg13g2_decap_8
XFILLER_36_1351 VDD VSS sg13g2_decap_8
XFILLER_11_147 VDD VSS sg13g2_decap_8
XFILLER_156_119 VDD VSS sg13g2_decap_8
X_08349_ _08353_/A _08414_/A _08366_/D _08348_/Y VDD VSS sg13g2_o21ai_1
XFILLER_22_21 VDD VSS sg13g2_decap_8
XFILLER_137_344 VDD VSS sg13g2_decap_8
XFILLER_138_21 VDD VSS sg13g2_decap_8
X_11360_ _11360_/Y _11357_/Y _11359_/Y _11224_/A VDD VSS sg13g2_a21oi_1
XFILLER_22_98 VDD VSS sg13g2_decap_8
X_10311_ _10342_/C _10311_/A _10311_/B _10311_/C _10327_/C VDD VSS sg13g2_and4_1
XFILLER_98_14 VDD VSS sg13g2_decap_8
XFILLER_98_25 VDD VSS sg13g2_decap_4
XFILLER_153_859 VDD VSS sg13g2_fill_1
X_11291_ _11292_/B _11291_/A _12836_/B VDD VSS sg13g2_xnor2_1
XFILLER_164_196 VDD VSS sg13g2_decap_8
XFILLER_4_847 VDD VSS sg13g2_decap_8
X_13030_ _13030_/Y _14781_/Q _13152_/A2 _13181_/B1 VDD VSS sg13g2_o21ai_1
X_13902__2277 _13902_/RESET_B VDD VSS sg13g2_tiehi
XFILLER_106_753 VDD VSS sg13g2_decap_8
X_10242_ _14775_/D _14775_/Q wire525/X _10241_/Y VDD VSS sg13g2_a21oi_1
XFILLER_69_1182 VDD VSS sg13g2_decap_8
XFILLER_133_550 VDD VSS sg13g2_decap_8
XFILLER_3_357 VDD VSS sg13g2_decap_8
XFILLER_133_572 VDD VSS sg13g2_fill_1
XFILLER_161_881 VDD VSS sg13g2_fill_2
XFILLER_154_42 VDD VSS sg13g2_decap_8
XFILLER_65_1057 VDD VSS sg13g2_decap_8
Xfanout1103 _12084_/A _14982_/Q VDD VSS sg13g2_buf_1
X_10173_ _10173_/Y _10185_/B _13508_/C _10178_/A VDD VSS sg13g2_nand3_1
XFILLER_79_659 VDD VSS sg13g2_fill_2
Xfanout1114 _08559_/A3 _11936_/A VDD VSS sg13g2_buf_1
XFILLER_43_1311 VDD VSS sg13g2_decap_4
Xfanout1125 _11843_/A _14975_/Q VDD VSS sg13g2_buf_1
Xfanout1136 _11706_/A _14971_/Q VDD VSS sg13g2_buf_1
Xfanout1147 _08300_/A1 _14967_/Q VDD VSS sg13g2_buf_1
XFILLER_66_309 VDD VSS sg13g2_fill_2
X_14981_ _14981_/Q _14984_/CLK _14981_/D _14981_/RESET_B VDD VSS sg13g2_dfrbpq_1
Xfanout160 _10166_/A1 fanout162/X VDD VSS sg13g2_buf_1
Xfanout1158 _11461_/A _07888_/B VDD VSS sg13g2_buf_1
Xfanout171 _10131_/A0 _09131_/X VDD VSS sg13g2_buf_1
XFILLER_87_670 VDD VSS sg13g2_fill_1
XFILLER_130_1314 VDD VSS sg13g2_decap_8
Xfanout1169 _08063_/B _08137_/A2 VDD VSS sg13g2_buf_1
XFILLER_19_203 VDD VSS sg13g2_decap_8
Xfanout182 fanout182/X _09118_/Y VDD VSS sg13g2_buf_1
X_13932_ _13932_/Q clkload35/A _13932_/D _13932_/RESET_B VDD VSS sg13g2_dfrbpq_1
Xfanout193 _09959_/A1 _09091_/Y VDD VSS sg13g2_buf_1
X_15199__2741 _15199_/RESET_B VDD VSS sg13g2_tiehi
XFILLER_75_843 VDD VSS sg13g2_decap_4
XFILLER_75_876 VDD VSS sg13g2_decap_4
XFILLER_170_63 VDD VSS sg13g2_decap_8
X_13863_ _13863_/Q _14727_/CLK _13863_/D _13863_/RESET_B VDD VSS sg13g2_dfrbpq_1
XFILLER_16_910 VDD VSS sg13g2_decap_8
XFILLER_34_206 VDD VSS sg13g2_decap_8
XFILLER_28_770 VDD VSS sg13g2_fill_1
X_12814_ _12814_/Y _12900_/B input12/X _12867_/C VDD VSS sg13g2_nand3_1
XFILLER_90_846 VDD VSS sg13g2_fill_2
XFILLER_62_548 VDD VSS sg13g2_decap_8
XFILLER_15_420 VDD VSS sg13g2_decap_8
X_13794_ _13794_/Q _14722_/CLK _13794_/D _13794_/RESET_B VDD VSS sg13g2_dfrbpq_1
XFILLER_128_1232 VDD VSS sg13g2_decap_8
XFILLER_16_987 VDD VSS sg13g2_decap_8
X_12745_ _12745_/X _14263_/Q _14295_/Q _14327_/Q _14359_/Q _12745_/S0 _12745_/S1 VDD
+ VSS sg13g2_mux4_1
XFILLER_163_1123 VDD VSS sg13g2_decap_8
XFILLER_43_773 VDD VSS sg13g2_decap_8
XFILLER_31_935 VDD VSS sg13g2_decap_8
XFILLER_128_1276 VDD VSS sg13g2_decap_8
XFILLER_163_1156 VDD VSS sg13g2_decap_4
XFILLER_37_1159 VDD VSS sg13g2_decap_8
XFILLER_15_497 VDD VSS sg13g2_decap_8
X_12676_ _12676_/X _12673_/X _12672_/X _12671_/X _12670_/X _12761_/S0 _12776_/S VDD
+ VSS sg13g2_mux4_1
X_14569__1610 _14569_/RESET_B VDD VSS sg13g2_tiehi
XFILLER_124_1129 VDD VSS sg13g2_decap_8
XFILLER_147_119 VDD VSS sg13g2_decap_8
X_14415_ _14415_/Q clkload8/A _14415_/D _14415_/RESET_B VDD VSS sg13g2_dfrbpq_1
X_11627_ _11627_/Y _11622_/X _11747_/A _11625_/C VDD VSS sg13g2_a21oi_1
XFILLER_8_56 VDD VSS sg13g2_decap_8
XFILLER_7_630 VDD VSS sg13g2_decap_8
X_14346_ _14346_/Q clkload12/A _14346_/D _14346_/RESET_B VDD VSS sg13g2_dfrbpq_1
X_11558_ _11559_/B _11547_/Y _11549_/X _12174_/A VDD VSS sg13g2_o21ai_1
XFILLER_6_140 VDD VSS sg13g2_decap_8
X_10509_ _10521_/D _10512_/A _10509_/B _10509_/C _10509_/D VDD VSS sg13g2_nor4_1
XFILLER_128_399 VDD VSS sg13g2_fill_1
XFILLER_144_848 VDD VSS sg13g2_decap_8
X_14277_ _14277_/Q _14725_/CLK _14277_/D _14277_/RESET_B VDD VSS sg13g2_dfrbpq_1
X_11489_ _11489_/X _14370_/Q _14402_/Q _14466_/Q _14498_/Q _11489_/S0 _11489_/S1 VDD
+ VSS sg13g2_mux4_1
XFILLER_100_1151 VDD VSS sg13g2_fill_1
XFILLER_171_656 VDD VSS sg13g2_decap_4
XFILLER_170_133 VDD VSS sg13g2_decap_8
X_13228_ _13228_/Y _13228_/A _13228_/B _13228_/C VDD VSS sg13g2_nand3_1
XFILLER_87_1282 VDD VSS sg13g2_fill_1
XFILLER_124_561 VDD VSS sg13g2_fill_2
XFILLER_98_924 VDD VSS sg13g2_fill_2
XFILLER_83_1135 VDD VSS sg13g2_fill_1
X_13159_ _13159_/Y _13174_/A _13158_/B _13170_/D VDD VSS sg13g2_a21oi_1
XFILLER_88_80 VDD VSS sg13g2_decap_8
XFILLER_174_1296 VDD VSS sg13g2_decap_8
XFILLER_111_244 VDD VSS sg13g2_decap_4
XFILLER_97_478 VDD VSS sg13g2_decap_8
X_14671__1508 _14671_/RESET_B VDD VSS sg13g2_tiehi
X_07720_ _15217_/D _07720_/A _11288_/A _07720_/C VDD VSS sg13g2_or3_1
XFILLER_66_843 VDD VSS sg13g2_decap_8
XFILLER_65_320 VDD VSS sg13g2_fill_2
XFILLER_66_854 VDD VSS sg13g2_fill_1
XFILLER_66_865 VDD VSS sg13g2_fill_1
XFILLER_93_651 VDD VSS sg13g2_decap_8
X_07651_ _11023_/A _15118_/Q VDD VSS sg13g2_inv_1
XFILLER_92_150 VDD VSS sg13g2_fill_2
XFILLER_19_770 VDD VSS sg13g2_decap_8
XFILLER_0_1213 VDD VSS sg13g2_decap_8
XFILLER_25_217 VDD VSS sg13g2_decap_8
XFILLER_20_1141 VDD VSS sg13g2_decap_8
XFILLER_129_1007 VDD VSS sg13g2_decap_8
XFILLER_92_172 VDD VSS sg13g2_decap_8
XFILLER_18_280 VDD VSS sg13g2_decap_8
XFILLER_59_1362 VDD VSS sg13g2_decap_8
X_09321_ _13928_/D _09919_/A1 _13928_/Q _09330_/S VDD VSS sg13g2_mux2_1
XFILLER_94_1264 VDD VSS sg13g2_decap_8
XFILLER_55_1226 VDD VSS sg13g2_decap_8
XFILLER_90_1117 VDD VSS sg13g2_decap_8
XFILLER_90_1128 VDD VSS sg13g2_fill_2
XFILLER_61_581 VDD VSS sg13g2_decap_8
X_09252_ _13861_/D _13861_/Q _09318_/A0 _09264_/S VDD VSS sg13g2_mux2_1
XFILLER_61_592 VDD VSS sg13g2_fill_1
XFILLER_21_434 VDD VSS sg13g2_decap_8
XFILLER_166_406 VDD VSS sg13g2_decap_8
XFILLER_138_108 VDD VSS sg13g2_fill_1
X_08203_ _08247_/A _08203_/A _08203_/B VDD VSS sg13g2_nor2_1
X_09183_ _13799_/D _13799_/Q _09720_/A0 _09201_/S VDD VSS sg13g2_mux2_1
XFILLER_18_1092 VDD VSS sg13g2_decap_8
XFILLER_119_344 VDD VSS sg13g2_decap_8
XFILLER_146_130 VDD VSS sg13g2_decap_8
XFILLER_147_653 VDD VSS sg13g2_fill_1
X_15054__2515 _15054_/RESET_B VDD VSS sg13g2_tiehi
X_08134_ _08134_/Y _08030_/Y _08132_/X _08397_/A VDD VSS sg13g2_o21ai_1
XFILLER_147_664 VDD VSS sg13g2_fill_2
XFILLER_174_450 VDD VSS sg13g2_decap_8
XFILLER_162_601 VDD VSS sg13g2_fill_2
XFILLER_174_461 VDD VSS sg13g2_decap_8
XFILLER_107_528 VDD VSS sg13g2_fill_2
XFILLER_135_837 VDD VSS sg13g2_decap_8
X_08065_ _08066_/A _11461_/A _11502_/A _11454_/A _11483_/A _08235_/S0 _13550_/A1 VDD
+ VSS sg13g2_mux4_1
XFILLER_31_1281 VDD VSS sg13g2_decap_8
XFILLER_161_133 VDD VSS sg13g2_decap_8
XFILLER_68_28 VDD VSS sg13g2_decap_8
XFILLER_27_1306 VDD VSS sg13g2_decap_8
XFILLER_88_412 VDD VSS sg13g2_fill_2
XFILLER_62_1208 VDD VSS sg13g2_decap_8
XFILLER_102_222 VDD VSS sg13g2_decap_4
XFILLER_102_244 VDD VSS sg13g2_decap_4
XFILLER_130_553 VDD VSS sg13g2_decap_8
X_13696__2483 _13696_/RESET_B VDD VSS sg13g2_tiehi
X_08967_ _08967_/Y _09141_/A _09016_/C VDD VSS sg13g2_nand2_1
XFILLER_9_1260 VDD VSS sg13g2_decap_8
XFILLER_88_478 VDD VSS sg13g2_decap_8
XFILLER_75_106 VDD VSS sg13g2_decap_8
XFILLER_5_1113 VDD VSS sg13g2_decap_8
XFILLER_124_56 VDD VSS sg13g2_decap_8
Xpicorv32_macro mem_axi_araddr[0] VDD VSS sg13g2_tielo
XFILLER_29_512 VDD VSS sg13g2_fill_2
X_07918_ _07918_/Y _07893_/Y _07916_/Y _07917_/B VDD VSS sg13g2_a21oi_1
XFILLER_112_1022 VDD VSS sg13g2_decap_8
X_14647__1532 _14647_/RESET_B VDD VSS sg13g2_tiehi
XFILLER_57_843 VDD VSS sg13g2_fill_1
X_08898_ _08898_/Y _10735_/A _14942_/Q VDD VSS sg13g2_nand2_1
XFILLER_25_1085 VDD VSS sg13g2_decap_8
XFILLER_84_49 VDD VSS sg13g2_decap_8
XFILLER_84_662 VDD VSS sg13g2_decap_8
XFILLER_17_707 VDD VSS sg13g2_decap_8
X_07849_ _07849_/X _15016_/Q _08012_/B VDD VSS sg13g2_and2_1
XFILLER_56_364 VDD VSS sg13g2_fill_2
XFILLER_17_21 VDD VSS sg13g2_decap_8
Xclkbuf_leaf_3_clk_i _14662_/CLK clkbuf_leaf_3_clk_i/A VDD VSS sg13g2_buf_8
XFILLER_16_217 VDD VSS sg13g2_decap_8
XFILLER_72_835 VDD VSS sg13g2_fill_1
XFILLER_44_537 VDD VSS sg13g2_fill_1
X_10860_ _10860_/Y _10873_/A1 _10691_/X _07753_/B VDD VSS sg13g2_o21ai_1
XFILLER_72_857 VDD VSS sg13g2_decap_8
XFILLER_71_356 VDD VSS sg13g2_fill_1
X_09519_ _14118_/D _10149_/A1 _14118_/Q _09530_/S VDD VSS sg13g2_mux2_1
XFILLER_17_98 VDD VSS sg13g2_decap_8
X_10791_ _14924_/D _11045_/B1 _11199_/B _10790_/Y VDD VSS sg13g2_o21ai_1
XFILLER_13_924 VDD VSS sg13g2_decap_8
XFILLER_52_570 VDD VSS sg13g2_fill_2
X_12530_ _12530_/X _13960_/Q _13992_/Q _14024_/Q _14056_/Q _12674_/S0 _12674_/S1 VDD
+ VSS sg13g2_mux4_1
XFILLER_73_1348 VDD VSS sg13g2_decap_8
XFILLER_12_434 VDD VSS sg13g2_decap_8
X_15015__2572 _15015_/RESET_B VDD VSS sg13g2_tiehi
XFILLER_9_917 VDD VSS sg13g2_decap_8
XFILLER_33_42 VDD VSS sg13g2_decap_8
XFILLER_24_294 VDD VSS sg13g2_decap_8
XFILLER_169_266 VDD VSS sg13g2_decap_8
XFILLER_149_42 VDD VSS sg13g2_decap_8
X_12461_ _12461_/X _14371_/Q _14403_/Q _14467_/Q _14499_/Q _12717_/S0 _12717_/S1 VDD
+ VSS sg13g2_mux4_1
XFILLER_8_427 VDD VSS sg13g2_decap_8
XFILLER_166_951 VDD VSS sg13g2_decap_8
X_14200_ _14200_/Q _14728_/CLK _14200_/D _14200_/RESET_B VDD VSS sg13g2_dfrbpq_1
X_14824__2889 _14824_/RESET_B VDD VSS sg13g2_tiehi
X_11412_ _11413_/A _14239_/Q _14271_/Q _14303_/Q _14335_/Q _11418_/A _11419_/C VDD
+ VSS sg13g2_mux4_1
X_14832__2880 _14832_/RESET_B VDD VSS sg13g2_tiehi
X_15180_ _15180_/Q clkload65/A _15180_/D _15180_/RESET_B VDD VSS sg13g2_dfrbpq_1
XFILLER_138_664 VDD VSS sg13g2_decap_8
X_12392_ _12392_/X _13726_/Q _14078_/Q _14430_/Q _14526_/Q _12590_/S0 _12590_/S1 VDD
+ VSS sg13g2_mux4_1
XFILLER_137_152 VDD VSS sg13g2_fill_2
XFILLER_153_612 VDD VSS sg13g2_decap_8
XFILLER_116_0 VDD VSS sg13g2_decap_8
X_14131_ _14131_/Q clkload16/A _14131_/D _14131_/RESET_B VDD VSS sg13g2_dfrbpq_1
XFILLER_32_1089 VDD VSS sg13g2_decap_8
XFILLER_165_483 VDD VSS sg13g2_decap_8
X_11343_ _11343_/Y _11350_/A1 _13854_/Q _11366_/C VDD VSS sg13g2_a21oi_1
XFILLER_152_122 VDD VSS sg13g2_decap_8
XFILLER_67_1119 VDD VSS sg13g2_fill_2
XFILLER_4_644 VDD VSS sg13g2_decap_8
XFILLER_125_358 VDD VSS sg13g2_decap_8
XFILLER_141_807 VDD VSS sg13g2_decap_8
XFILLER_153_667 VDD VSS sg13g2_decap_8
XFILLER_10_1365 VDD VSS sg13g2_decap_8
X_14062_ _14062_/Q clkload36/A _14062_/D _14062_/RESET_B VDD VSS sg13g2_dfrbpq_1
XFILLER_165_63 VDD VSS sg13g2_decap_8
X_11274_ _11274_/Y _11270_/Y _11271_/Y _11273_/Y _11272_/Y _11266_/B VDD VSS sg13g2_a221oi_1
XFILLER_3_154 VDD VSS sg13g2_decap_8
XFILLER_152_188 VDD VSS sg13g2_fill_1
X_13013_ _13013_/Y _14876_/Q _13013_/B VDD VSS sg13g2_nand2_1
X_10225_ _10234_/D _14767_/Q _14768_/Q _14769_/Q _14770_/Q VDD VSS sg13g2_and4_1
XFILLER_133_391 VDD VSS sg13g2_decap_8
X_14286__1893 _14286_/RESET_B VDD VSS sg13g2_tiehi
X_10156_ _14733_/D _14733_/Q _10156_/A1 _10156_/S VDD VSS sg13g2_mux2_1
XFILLER_58_50 VDD VSS sg13g2_decap_4
XFILLER_95_949 VDD VSS sg13g2_decap_4
XFILLER_66_106 VDD VSS sg13g2_decap_8
XFILLER_48_832 VDD VSS sg13g2_decap_8
XFILLER_43_1152 VDD VSS sg13g2_decap_8
XFILLER_130_1122 VDD VSS sg13g2_decap_8
X_14964_ _14964_/Q clkload58/A _14964_/D _14964_/RESET_B VDD VSS sg13g2_dfrbpq_1
X_10087_ _14667_/D _10121_/A0 _14667_/Q _10093_/S VDD VSS sg13g2_mux2_1
XFILLER_59_180 VDD VSS sg13g2_decap_8
XFILLER_47_320 VDD VSS sg13g2_decap_8
XFILLER_130_1133 VDD VSS sg13g2_fill_1
XFILLER_78_1204 VDD VSS sg13g2_decap_8
XFILLER_75_662 VDD VSS sg13g2_decap_4
X_13915_ _13915_/Q _14885_/CLK _13915_/D _13915_/RESET_B VDD VSS sg13g2_dfrbpq_1
XFILLER_130_1166 VDD VSS sg13g2_decap_8
XFILLER_47_364 VDD VSS sg13g2_fill_2
X_14895_ _14895_/Q clkload69/A _14895_/D _14895_/RESET_B VDD VSS sg13g2_dfrbpq_1
XFILLER_90_610 VDD VSS sg13g2_decap_4
XFILLER_75_684 VDD VSS sg13g2_fill_2
XFILLER_90_621 VDD VSS sg13g2_decap_8
XFILLER_78_1259 VDD VSS sg13g2_decap_4
X_13846_ _13846_/Q clkload26/A _13846_/D _13846_/RESET_B VDD VSS sg13g2_dfrbpq_1
X_13777_ _13777_/Q _14725_/CLK _13777_/D _13777_/RESET_B VDD VSS sg13g2_dfrbpq_1
XFILLER_16_784 VDD VSS sg13g2_decap_8
X_10989_ _10989_/Y _10995_/B _15116_/Q VDD VSS sg13g2_nand2b_1
XFILLER_43_570 VDD VSS sg13g2_decap_8
XFILLER_15_294 VDD VSS sg13g2_decap_8
X_12728_ _12728_/X _14582_/Q _14614_/Q _14646_/Q _14678_/Q _12757_/S0 _12757_/S1 VDD
+ VSS sg13g2_mux4_1
XFILLER_31_765 VDD VSS sg13g2_decap_8
XFILLER_90_70 VDD VSS sg13g2_fill_1
XFILLER_30_253 VDD VSS sg13g2_decap_8
X_12659_ _12659_/X _14705_/Q _14737_/Q _13777_/Q _13809_/Q _12661_/S0 _12661_/S1 VDD
+ VSS sg13g2_mux4_1
XFILLER_129_631 VDD VSS sg13g2_decap_4
XFILLER_15_1232 VDD VSS sg13g2_decap_8
XFILLER_90_92 VDD VSS sg13g2_decap_8
XFILLER_106_1360 VDD VSS sg13g2_fill_1
XFILLER_117_804 VDD VSS sg13g2_decap_8
XFILLER_144_601 VDD VSS sg13g2_decap_8
XFILLER_8_994 VDD VSS sg13g2_decap_8
X_14329_ _14329_/Q clkload22/A _14329_/D _14329_/RESET_B VDD VSS sg13g2_dfrbpq_1
X_14725__1454 _14725_/RESET_B VDD VSS sg13g2_tiehi
XFILLER_116_336 VDD VSS sg13g2_decap_8
XFILLER_171_453 VDD VSS sg13g2_decap_8
XFILLER_99_90 VDD VSS sg13g2_decap_8
XFILLER_132_829 VDD VSS sg13g2_decap_8
XFILLER_144_689 VDD VSS sg13g2_decap_8
XFILLER_131_317 VDD VSS sg13g2_decap_8
Xfanout907 _13160_/B _13238_/B2 VDD VSS sg13g2_buf_1
X_09870_ _14457_/D _14457_/Q _10068_/A0 _09870_/S VDD VSS sg13g2_mux2_1
XFILLER_124_380 VDD VSS sg13g2_decap_8
Xfanout918 _13293_/C _15206_/Q VDD VSS sg13g2_buf_1
XFILLER_31_0 VDD VSS sg13g2_decap_8
Xclkbuf_5_7__f_clk_i clkbuf_5_7__f_clk_i/X clkbuf_4_3_0_clk_i/X VDD VSS sg13g2_buf_16
Xfanout929 _12899_/C _12844_/C VDD VSS sg13g2_buf_1
XFILLER_48_1085 VDD VSS sg13g2_decap_8
X_08821_ _08821_/Y _13279_/B _15121_/Q _08727_/D _15178_/Q _08825_/C1 VDD VSS sg13g2_a221oi_1
XFILLER_86_916 VDD VSS sg13g2_fill_1
XFILLER_26_1350 VDD VSS sg13g2_decap_8
XFILLER_113_1320 VDD VSS sg13g2_decap_8
X_08752_ _08752_/Y _13669_/Q _08761_/B VDD VSS sg13g2_nor2_1
X_07703_ _07703_/Y _10647_/A _10441_/C VDD VSS sg13g2_nand2_1
XFILLER_22_1247 VDD VSS sg13g2_decap_8
X_08683_ _08684_/B _08548_/A _08697_/A _08682_/Y VDD VSS sg13g2_o21ai_1
XFILLER_65_150 VDD VSS sg13g2_fill_2
XFILLER_0_1010 VDD VSS sg13g2_decap_8
XFILLER_54_846 VDD VSS sg13g2_decap_8
XFILLER_53_312 VDD VSS sg13g2_fill_2
X_07634_ _07909_/B _11454_/A VDD VSS sg13g2_inv_1
XFILLER_53_334 VDD VSS sg13g2_fill_2
XFILLER_4_1190 VDD VSS sg13g2_decap_8
XFILLER_81_665 VDD VSS sg13g2_fill_2
XFILLER_53_378 VDD VSS sg13g2_decap_8
XFILLER_110_14 VDD VSS sg13g2_decap_8
XFILLER_0_1087 VDD VSS sg13g2_decap_8
XFILLER_146_1151 VDD VSS sg13g2_fill_1
X_09304_ _13912_/D _13912_/Q _09935_/A1 _09305_/S VDD VSS sg13g2_mux2_1
XFILLER_107_1124 VDD VSS sg13g2_decap_8
XFILLER_167_726 VDD VSS sg13g2_decap_8
XFILLER_55_1067 VDD VSS sg13g2_decap_8
XFILLER_21_231 VDD VSS sg13g2_decap_8
XFILLER_166_203 VDD VSS sg13g2_decap_8
XFILLER_16_1029 VDD VSS sg13g2_decap_8
XFILLER_139_428 VDD VSS sg13g2_decap_8
X_09235_ _13846_/D _10165_/A1 _13846_/Q _09237_/S VDD VSS sg13g2_mux2_1
XFILLER_10_938 VDD VSS sg13g2_decap_8
XFILLER_154_409 VDD VSS sg13g2_decap_4
X_09166_ _09166_/Y _09162_/A _09165_/Y _09162_/Y VDD VSS sg13g2_a21oi_1
XFILLER_33_1365 VDD VSS sg13g2_decap_8
XFILLER_163_921 VDD VSS sg13g2_decap_8
XFILLER_108_837 VDD VSS sg13g2_decap_4
X_08117_ _08117_/Y _07904_/B _08116_/Y _08039_/A VDD VSS sg13g2_a21oi_1
X_09097_ _09097_/X _09137_/A _09097_/B _09136_/B VDD VSS sg13g2_or3_1
XFILLER_134_133 VDD VSS sg13g2_decap_8
XFILLER_162_453 VDD VSS sg13g2_decap_8
X_08048_ _08048_/Y _08048_/A _08048_/B VDD VSS sg13g2_nand2_1
XFILLER_89_721 VDD VSS sg13g2_decap_8
X_14809__2904 _14809_/RESET_B VDD VSS sg13g2_tiehi
XFILLER_27_1103 VDD VSS sg13g2_decap_8
XFILLER_150_659 VDD VSS sg13g2_decap_4
Xhold3030 input26/A mem_axi_rdata[2] VDD VSS sg13g2_dlygate4sd3_1
XFILLER_1_658 VDD VSS sg13g2_decap_8
Xhold3041 hold3041/X input9/X VDD VSS sg13g2_dlygate4sd3_1
X_10010_ _14592_/D _10043_/A0 _14592_/Q _10032_/S VDD VSS sg13g2_mux2_1
XFILLER_77_916 VDD VSS sg13g2_fill_2
XFILLER_49_607 VDD VSS sg13g2_decap_8
XFILLER_118_1264 VDD VSS sg13g2_fill_1
Xhold3052 hold3052/X input23/X VDD VSS sg13g2_dlygate4sd3_1
XFILLER_130_350 VDD VSS sg13g2_decap_8
XFILLER_135_77 VDD VSS sg13g2_decap_8
XFILLER_153_1155 VDD VSS sg13g2_decap_4
Xhold3063 hold3063/X input18/X VDD VSS sg13g2_dlygate4sd3_1
XFILLER_0_168 VDD VSS sg13g2_decap_8
Xhold3074 input28/A mem_axi_rdata[31] VDD VSS sg13g2_dlygate4sd3_1
X_09999_ _14582_/D _10098_/A0 _14582_/Q _09999_/S VDD VSS sg13g2_mux2_1
XFILLER_89_798 VDD VSS sg13g2_decap_8
XFILLER_62_1049 VDD VSS sg13g2_fill_1
XFILLER_118_1297 VDD VSS sg13g2_decap_4
XFILLER_103_597 VDD VSS sg13g2_decap_8
XFILLER_114_1139 VDD VSS sg13g2_fill_1
Xhold3085 hold3085/X input17/X VDD VSS sg13g2_dlygate4sd3_1
Xhold3096 input1/A mem_axi_arready VDD VSS sg13g2_dlygate4sd3_1
X_14163__2016 _14163_/RESET_B VDD VSS sg13g2_tiehi
XFILLER_28_42 VDD VSS sg13g2_decap_8
XFILLER_151_21 VDD VSS sg13g2_decap_8
XFILLER_85_971 VDD VSS sg13g2_decap_8
X_11961_ _11961_/Y _11969_/A _14512_/Q _11690_/B VDD VSS sg13g2_a21oi_1
XFILLER_17_504 VDD VSS sg13g2_decap_8
X_13700_ _16862_/A _15226_/CLK _13700_/D _13700_/RESET_B VDD VSS sg13g2_dfrbpq_1
X_10912_ _10912_/Y _10912_/A1 _10936_/D _07753_/B VDD VSS sg13g2_o21ai_1
X_14680_ _14680_/Q _14984_/CLK _14680_/D _14680_/RESET_B VDD VSS sg13g2_dfrbpq_1
X_11892_ _11892_/Y _11889_/Y _11891_/X _11224_/A VDD VSS sg13g2_o21ai_1
XFILLER_72_665 VDD VSS sg13g2_fill_1
X_13631_ _13739_/D _13631_/A VDD VSS sg13g2_buf_1
X_10843_ _10843_/Y _10841_/Y _10843_/B _10843_/C VDD VSS sg13g2_nand3b_1
XFILLER_38_1232 VDD VSS sg13g2_fill_1
XFILLER_13_721 VDD VSS sg13g2_decap_8
XFILLER_164_1240 VDD VSS sg13g2_decap_8
XFILLER_44_63 VDD VSS sg13g2_decap_8
X_13562_ _15152_/D _15152_/Q _13561_/X _13565_/S VDD VSS sg13g2_mux2_1
XFILLER_73_1145 VDD VSS sg13g2_fill_1
X_10774_ _10774_/Y _10774_/A _11196_/B VDD VSS sg13g2_nand2_1
XFILLER_12_231 VDD VSS sg13g2_decap_8
XFILLER_158_726 VDD VSS sg13g2_decap_8
XFILLER_9_714 VDD VSS sg13g2_decap_8
XFILLER_40_551 VDD VSS sg13g2_decap_8
X_12513_ _15000_/D _12513_/A _12513_/B VDD VSS sg13g2_nor2_1
X_13493_ _13493_/Y _13412_/B _13493_/A2 _15126_/Q VDD VSS sg13g2_o21ai_1
XFILLER_13_798 VDD VSS sg13g2_decap_8
XFILLER_8_224 VDD VSS sg13g2_decap_8
X_15232_ _15232_/Q clkload58/A _15232_/D _15232_/RESET_B VDD VSS sg13g2_dfrbpq_1
X_12444_ _12457_/A _10213_/A _07737_/B _13545_/A VDD VSS sg13g2_a21oi_1
X_14970__2617 _14970_/RESET_B VDD VSS sg13g2_tiehi
XFILLER_172_217 VDD VSS sg13g2_decap_8
XFILLER_172_228 VDD VSS sg13g2_fill_2
X_15163_ _15163_/Q clkload70/A _15163_/D _15163_/RESET_B VDD VSS sg13g2_dfrbpq_1
XFILLER_154_943 VDD VSS sg13g2_decap_8
XFILLER_158_1011 VDD VSS sg13g2_decap_8
XFILLER_165_280 VDD VSS sg13g2_decap_8
X_12375_ _12375_/X _14557_/Q _14589_/Q _14621_/Q _14653_/Q _12396_/S0 _12396_/S1 VDD
+ VSS sg13g2_mux4_1
XFILLER_5_931 VDD VSS sg13g2_decap_8
X_14114_ _14114_/Q _14722_/CLK _14114_/D _14114_/RESET_B VDD VSS sg13g2_dfrbpq_1
X_11326_ _11326_/Y _11326_/A _11326_/B VDD VSS sg13g2_nand2_1
XFILLER_5_35 VDD VSS sg13g2_decap_8
XFILLER_4_441 VDD VSS sg13g2_decap_8
XFILLER_119_1006 VDD VSS sg13g2_decap_8
XFILLER_125_155 VDD VSS sg13g2_fill_2
X_15094_ _15094_/Q clkload69/A _15094_/D _15094_/RESET_B VDD VSS sg13g2_dfrbpq_1
XFILLER_10_1162 VDD VSS sg13g2_decap_8
XFILLER_141_615 VDD VSS sg13g2_decap_4
XFILLER_84_1230 VDD VSS sg13g2_fill_2
XFILLER_141_637 VDD VSS sg13g2_decap_8
X_14373__1806 _14373_/RESET_B VDD VSS sg13g2_tiehi
XFILLER_107_892 VDD VSS sg13g2_decap_8
X_13759__2420 _13759_/RESET_B VDD VSS sg13g2_tiehi
X_14045_ _14045_/Q clkload47/A _14045_/D _14045_/RESET_B VDD VSS sg13g2_dfrbpq_1
XFILLER_140_125 VDD VSS sg13g2_decap_8
Xclkbuf_leaf_104_clk_i clkload40/A clkbuf_leaf_98_clk_i/A VDD VSS sg13g2_buf_8
X_11257_ _11257_/X _13724_/Q _14076_/Q _14428_/Q _14524_/Q _12303_/S _12307_/C VDD
+ VSS sg13g2_mux4_1
XFILLER_171_1211 VDD VSS sg13g2_decap_4
X_10208_ _10209_/B _14765_/Q _14749_/Q VDD VSS sg13g2_nand2b_1
X_11188_ _11188_/Y _11186_/B _11187_/Y _11186_/Y _11197_/B _11188_/C1 VDD VSS sg13g2_a221oi_1
XFILLER_94_212 VDD VSS sg13g2_fill_2
XFILLER_132_1239 VDD VSS sg13g2_decap_8
X_10139_ _14716_/D _14716_/Q _10139_/A1 _10163_/S VDD VSS sg13g2_mux2_1
XFILLER_67_459 VDD VSS sg13g2_decap_8
XFILLER_171_1299 VDD VSS sg13g2_decap_8
X_14139__2040 _14139_/RESET_B VDD VSS sg13g2_tiehi
Xclkbuf_leaf_119_clk_i clkload14/A clkbuf_5_5__f_clk_i/X VDD VSS sg13g2_buf_8
X_14947_ _14947_/Q clkload42/A _14947_/D _14947_/RESET_B VDD VSS sg13g2_dfrbpq_1
XFILLER_48_673 VDD VSS sg13g2_decap_4
XFILLER_85_92 VDD VSS sg13g2_fill_1
XFILLER_1_1330 VDD VSS sg13g2_decap_8
XFILLER_169_1162 VDD VSS sg13g2_decap_4
XFILLER_36_868 VDD VSS sg13g2_decap_8
X_14878_ _14878_/Q clkload48/A _14878_/D _14878_/RESET_B VDD VSS sg13g2_dfrbpq_1
XFILLER_91_963 VDD VSS sg13g2_decap_4
XFILLER_62_131 VDD VSS sg13g2_decap_8
XFILLER_78_1067 VDD VSS sg13g2_decap_8
XFILLER_51_816 VDD VSS sg13g2_fill_1
XFILLER_23_518 VDD VSS sg13g2_decap_8
X_13829_ _13829_/Q _14725_/CLK _13829_/D _13829_/RESET_B VDD VSS sg13g2_dfrbpq_1
XFILLER_50_315 VDD VSS sg13g2_decap_8
XFILLER_16_581 VDD VSS sg13g2_decap_8
XFILLER_56_1354 VDD VSS sg13g2_fill_2
XFILLER_50_348 VDD VSS sg13g2_decap_8
XFILLER_17_1316 VDD VSS sg13g2_decap_8
XFILLER_149_715 VDD VSS sg13g2_decap_8
X_13861__2318 _13861_/RESET_B VDD VSS sg13g2_tiehi
XFILLER_31_562 VDD VSS sg13g2_decap_8
X_09020_ _13764_/D _13764_/Q _10147_/A1 _09160_/S VDD VSS sg13g2_mux2_1
XFILLER_79_0 VDD VSS sg13g2_decap_8
XFILLER_163_217 VDD VSS sg13g2_decap_8
XFILLER_102_1032 VDD VSS sg13g2_decap_8
XFILLER_129_472 VDD VSS sg13g2_decap_8
XFILLER_102_1043 VDD VSS sg13g2_fill_1
XFILLER_116_100 VDD VSS sg13g2_decap_8
XFILLER_145_932 VDD VSS sg13g2_decap_8
XFILLER_144_420 VDD VSS sg13g2_decap_8
XFILLER_8_791 VDD VSS sg13g2_decap_8
XFILLER_145_965 VDD VSS sg13g2_decap_8
X_14946__2652 _14946_/RESET_B VDD VSS sg13g2_tiehi
XFILLER_116_144 VDD VSS sg13g2_decap_8
XFILLER_85_1027 VDD VSS sg13g2_decap_8
XFILLER_117_689 VDD VSS sg13g2_decap_8
XFILLER_145_998 VDD VSS sg13g2_fill_2
XFILLER_171_261 VDD VSS sg13g2_decap_8
XFILLER_137_1139 VDD VSS sg13g2_fill_1
XFILLER_160_957 VDD VSS sg13g2_decap_4
X_09922_ _14507_/D _14507_/Q _09922_/A1 _09928_/S VDD VSS sg13g2_mux2_1
X_14349__1830 _14349_/RESET_B VDD VSS sg13g2_tiehi
Xfanout704 _12190_/B _11443_/A VDD VSS sg13g2_buf_1
Xfanout715 _11266_/B _12324_/B VDD VSS sg13g2_buf_1
XFILLER_98_551 VDD VSS sg13g2_decap_8
XFILLER_113_862 VDD VSS sg13g2_decap_4
Xfanout726 _11325_/B1 _12304_/B VDD VSS sg13g2_buf_1
XFILLER_63_1336 VDD VSS sg13g2_decap_8
Xfanout737 _11151_/A _11188_/C1 VDD VSS sg13g2_buf_1
X_09853_ _14440_/D _14440_/Q _09853_/A1 _09862_/S VDD VSS sg13g2_mux2_1
XFILLER_24_1309 VDD VSS sg13g2_decap_8
XFILLER_105_14 VDD VSS sg13g2_decap_8
Xfanout748 _08452_/D fanout750/X VDD VSS sg13g2_buf_1
Xfanout759 _07913_/A _07627_/Y VDD VSS sg13g2_buf_1
XFILLER_150_1328 VDD VSS sg13g2_decap_4
X_08804_ _08805_/B _13686_/Q _08818_/B VDD VSS sg13g2_nor2_1
X_09784_ _14373_/D _09916_/A1 _14373_/Q _09796_/S VDD VSS sg13g2_mux2_1
XFILLER_22_1011 VDD VSS sg13g2_decap_8
XFILLER_86_779 VDD VSS sg13g2_fill_2
XFILLER_22_1022 VDD VSS sg13g2_fill_1
X_08735_ _13663_/D _08765_/A1 _08733_/Y _08734_/Y VDD VSS sg13g2_a21oi_1
XFILLER_6_1274 VDD VSS sg13g2_decap_8
XFILLER_39_673 VDD VSS sg13g2_decap_8
XFILLER_27_813 VDD VSS sg13g2_decap_8
XFILLER_22_1044 VDD VSS sg13g2_decap_8
XFILLER_26_301 VDD VSS sg13g2_decap_4
X_15124__2711 _15124_/RESET_B VDD VSS sg13g2_tiehi
XFILLER_96_1112 VDD VSS sg13g2_decap_8
XFILLER_2_1127 VDD VSS sg13g2_decap_8
X_08666_ _08666_/X _08678_/A _08666_/B VDD VSS sg13g2_xor2_1
XFILLER_27_857 VDD VSS sg13g2_fill_1
XFILLER_57_1107 VDD VSS sg13g2_fill_1
XFILLER_54_654 VDD VSS sg13g2_decap_8
XFILLER_53_131 VDD VSS sg13g2_decap_8
Xclkbuf_leaf_83_clk_i _15113_/CLK clkbuf_leaf_83_clk_i/A VDD VSS sg13g2_buf_8
X_07617_ _09011_/A _14902_/Q VDD VSS sg13g2_inv_1
XFILLER_53_153 VDD VSS sg13g2_decap_4
XFILLER_14_518 VDD VSS sg13g2_decap_8
X_08597_ _08600_/C _08599_/A _08597_/B _08597_/C VDD VSS sg13g2_nor3_1
XFILLER_26_389 VDD VSS sg13g2_decap_8
XFILLER_157_7 VDD VSS sg13g2_decap_8
XFILLER_81_28 VDD VSS sg13g2_decap_8
X_14451__1728 _14451_/RESET_B VDD VSS sg13g2_tiehi
X_13837__2342 _13837_/RESET_B VDD VSS sg13g2_tiehi
X_14597__1582 _14597_/RESET_B VDD VSS sg13g2_tiehi
XFILLER_22_573 VDD VSS sg13g2_decap_8
XFILLER_14_77 VDD VSS sg13g2_decap_8
XFILLER_10_735 VDD VSS sg13g2_decap_8
Xclkbuf_leaf_98_clk_i clkload38/A clkbuf_leaf_98_clk_i/A VDD VSS sg13g2_buf_8
XFILLER_167_567 VDD VSS sg13g2_decap_8
X_09218_ _13829_/D _09318_/A0 _13829_/Q _09230_/S VDD VSS sg13g2_mux2_1
XFILLER_139_269 VDD VSS sg13g2_fill_2
XFILLER_154_206 VDD VSS sg13g2_decap_4
X_10490_ _14850_/D _10490_/A _10490_/B _10498_/D VDD VSS sg13g2_nor3_1
XFILLER_148_781 VDD VSS sg13g2_decap_8
XFILLER_6_728 VDD VSS sg13g2_decap_8
XFILLER_33_1184 VDD VSS sg13g2_fill_1
XFILLER_108_634 VDD VSS sg13g2_decap_8
X_09149_ _09151_/B _09157_/C _09157_/D _14923_/Q VDD VSS sg13g2_a21o_1
XFILLER_30_21 VDD VSS sg13g2_decap_8
XFILLER_135_420 VDD VSS sg13g2_decap_8
XFILLER_68_1214 VDD VSS sg13g2_fill_2
XFILLER_5_238 VDD VSS sg13g2_decap_8
XFILLER_136_976 VDD VSS sg13g2_decap_8
XFILLER_146_21 VDD VSS sg13g2_decap_8
Xclkbuf_leaf_21_clk_i clkload24/A clkbuf_leaf_22_clk_i/A VDD VSS sg13g2_buf_8
X_12160_ _12160_/Y _12168_/A _14230_/Q _12233_/B VDD VSS sg13g2_a21oi_1
XFILLER_135_475 VDD VSS sg13g2_decap_8
XFILLER_163_784 VDD VSS sg13g2_decap_8
XFILLER_122_114 VDD VSS sg13g2_decap_8
X_11111_ _11111_/Y _11109_/B _10764_/X _11154_/B1 VDD VSS sg13g2_o21ai_1
XFILLER_30_98 VDD VSS sg13g2_decap_8
XFILLER_150_434 VDD VSS sg13g2_decap_8
XFILLER_2_945 VDD VSS sg13g2_decap_8
X_12091_ _12092_/B _12091_/A _12091_/B _12091_/C VDD VSS sg13g2_nand3_1
XFILLER_150_445 VDD VSS sg13g2_fill_2
XFILLER_118_1050 VDD VSS sg13g2_decap_4
X_11042_ _11078_/D _11042_/A _11042_/B _11042_/C _11042_/D VDD VSS sg13g2_nand4_1
XFILLER_1_455 VDD VSS sg13g2_decap_8
XFILLER_77_735 VDD VSS sg13g2_fill_2
Xclkbuf_leaf_36_clk_i _14681_/CLK clkbuf_leaf_36_clk_i/A VDD VSS sg13g2_buf_8
XFILLER_39_63 VDD VSS sg13g2_decap_8
XFILLER_162_42 VDD VSS sg13g2_decap_8
XFILLER_77_768 VDD VSS sg13g2_decap_8
XFILLER_76_245 VDD VSS sg13g2_fill_2
X_14801_ _14801_/Q _14867_/CLK _14801_/D _14801_/RESET_B VDD VSS sg13g2_dfrbpq_1
XFILLER_64_418 VDD VSS sg13g2_decap_4
X_12993_ _12995_/C _13058_/D _12993_/B _12993_/C VDD VSS sg13g2_nand3b_1
XFILLER_17_301 VDD VSS sg13g2_decap_8
XFILLER_79_1332 VDD VSS sg13g2_decap_8
X_14732_ _14732_/Q clkload13/A _14732_/D _14732_/RESET_B VDD VSS sg13g2_dfrbpq_1
X_11944_ _11944_/Y _11940_/Y _11941_/Y _11943_/Y _11942_/Y _11964_/B VDD VSS sg13g2_a221oi_1
XFILLER_18_868 VDD VSS sg13g2_decap_8
XFILLER_75_1207 VDD VSS sg13g2_fill_1
XFILLER_44_131 VDD VSS sg13g2_decap_4
XFILLER_17_378 VDD VSS sg13g2_decap_8
X_14663_ _14663_/Q _14727_/CLK _14663_/D _14663_/RESET_B VDD VSS sg13g2_dfrbpq_1
X_11875_ _11875_/X _11875_/A _11875_/B VDD VSS sg13g2_and2_1
XFILLER_44_197 VDD VSS sg13g2_fill_1
XFILLER_38_1040 VDD VSS sg13g2_decap_8
XFILLER_32_337 VDD VSS sg13g2_decap_8
X_13614_ _15168_/D _08842_/S _16854_/A _13613_/Y VDD VSS sg13g2_a21o_1
X_10826_ _10841_/A _12347_/B _10851_/D VDD VSS sg13g2_nor2_1
X_14594_ _14594_/Q clkload29/A _14594_/D _14594_/RESET_B VDD VSS sg13g2_dfrbpq_1
XFILLER_164_1070 VDD VSS sg13g2_decap_8
XFILLER_9_511 VDD VSS sg13g2_decap_8
X_13545_ _13545_/X _13545_/A _13563_/C VDD VSS sg13g2_and2_1
X_14427__1752 _14427_/RESET_B VDD VSS sg13g2_tiehi
X_10757_ _10757_/Y _10757_/A _10757_/B VDD VSS sg13g2_nor2_1
X_15056__2507 _15056_/RESET_B VDD VSS sg13g2_tiehi
XFILLER_13_595 VDD VSS sg13g2_decap_8
XFILLER_125_1076 VDD VSS sg13g2_fill_1
XFILLER_146_707 VDD VSS sg13g2_decap_4
XFILLER_158_578 VDD VSS sg13g2_decap_8
X_13476_ _15112_/D _15178_/D _15112_/Q _13499_/A VDD VSS sg13g2_mux2_1
XFILLER_72_7 VDD VSS sg13g2_decap_8
X_10688_ _10851_/C _08992_/B _10691_/S _08852_/Y VDD VSS sg13g2_a21o_1
XFILLER_9_588 VDD VSS sg13g2_decap_8
X_15215_ _15215_/Q clkload67/A _15215_/D _15215_/RESET_B VDD VSS sg13g2_dfrbpq_1
X_12427_ _12427_/X _12425_/X _12424_/X _12421_/X _12420_/X _12760_/S0 _12553_/S VDD
+ VSS sg13g2_mux4_1
XFILLER_173_548 VDD VSS sg13g2_decap_4
XFILLER_12_1246 VDD VSS sg13g2_decap_8
XFILLER_86_1325 VDD VSS sg13g2_fill_2
XFILLER_154_762 VDD VSS sg13g2_fill_1
XFILLER_153_250 VDD VSS sg13g2_decap_8
XFILLER_154_773 VDD VSS sg13g2_fill_1
X_15146_ _15146_/Q clkload60/A _15146_/D _15146_/RESET_B VDD VSS sg13g2_dfrbpq_1
X_12358_ _12358_/Y _15217_/Q _12358_/B VDD VSS sg13g2_nand2b_1
XFILLER_114_615 VDD VSS sg13g2_fill_1
XFILLER_99_315 VDD VSS sg13g2_decap_8
XFILLER_142_957 VDD VSS sg13g2_fill_1
X_11309_ _11309_/Y _11310_/A1 _14429_/Q VDD VSS sg13g2_nand2b_1
X_15077_ _15077_/Q clkload67/A _15077_/D _15077_/RESET_B VDD VSS sg13g2_dfrbpq_1
Xclkbuf_5_25__f_clk_i clkbuf_leaf_73_clk_i/A clkbuf_4_12_0_clk_i/X VDD VSS sg13g2_buf_16
X_12289_ _12289_/X _12283_/X _12284_/X _12287_/X _12288_/X _12290_/S0 _12290_/S1 VDD
+ VSS sg13g2_mux4_1
X_14028_ _14028_/Q clkload14/A _14028_/D _14028_/RESET_B VDD VSS sg13g2_dfrbpq_1
XFILLER_68_702 VDD VSS sg13g2_decap_8
XFILLER_49_1191 VDD VSS sg13g2_decap_8
XFILLER_136_1172 VDD VSS sg13g2_decap_8
XFILLER_68_735 VDD VSS sg13g2_fill_1
XFILLER_132_1036 VDD VSS sg13g2_decap_8
XFILLER_132_1058 VDD VSS sg13g2_decap_8
X_13915__2264 _13915_/RESET_B VDD VSS sg13g2_tiehi
XFILLER_55_407 VDD VSS sg13g2_decap_8
XFILLER_23_1342 VDD VSS sg13g2_decap_8
XFILLER_82_204 VDD VSS sg13g2_decap_8
X_08520_ _08520_/X _08457_/X _08597_/C _08597_/B VDD VSS sg13g2_mux2_1
X_08451_ _08462_/B _08201_/A _08087_/X _08688_/C VDD VSS sg13g2_o21ai_1
XFILLER_23_315 VDD VSS sg13g2_decap_8
X_08382_ _08382_/X _08383_/A _08383_/B VDD VSS sg13g2_and2_1
XFILLER_17_1113 VDD VSS sg13g2_decap_8
XFILLER_147_1290 VDD VSS sg13g2_decap_4
XFILLER_91_1053 VDD VSS sg13g2_decap_8
XFILLER_56_1173 VDD VSS sg13g2_decap_8
XFILLER_52_1004 VDD VSS sg13g2_fill_1
XFILLER_52_1026 VDD VSS sg13g2_decap_8
XFILLER_32_893 VDD VSS sg13g2_decap_8
XFILLER_108_1274 VDD VSS sg13g2_decap_8
XFILLER_31_370 VDD VSS sg13g2_decap_8
XFILLER_137_707 VDD VSS sg13g2_decap_8
XFILLER_31_381 VDD VSS sg13g2_fill_1
XFILLER_137_718 VDD VSS sg13g2_fill_1
XFILLER_164_504 VDD VSS sg13g2_decap_8
XFILLER_136_217 VDD VSS sg13g2_decap_4
X_15153__2651 _15153_/RESET_B VDD VSS sg13g2_tiehi
X_09003_ _09003_/X _15028_/Q _15225_/Q _09009_/S VDD VSS sg13g2_mux2_1
XFILLER_118_932 VDD VSS sg13g2_decap_4
XFILLER_30_1324 VDD VSS sg13g2_decap_8
XFILLER_117_420 VDD VSS sg13g2_decap_8
XFILLER_117_431 VDD VSS sg13g2_fill_2
XFILLER_118_976 VDD VSS sg13g2_decap_8
XFILLER_145_762 VDD VSS sg13g2_decap_4
XFILLER_105_604 VDD VSS sg13g2_fill_1
XFILLER_118_987 VDD VSS sg13g2_fill_1
XFILLER_133_913 VDD VSS sg13g2_decap_8
XFILLER_118_998 VDD VSS sg13g2_fill_2
XFILLER_132_401 VDD VSS sg13g2_fill_2
XFILLER_117_486 VDD VSS sg13g2_decap_8
XFILLER_160_721 VDD VSS sg13g2_decap_8
XFILLER_133_968 VDD VSS sg13g2_decap_8
XFILLER_116_35 VDD VSS sg13g2_decap_8
Xfanout501 _13654_/S _10194_/S VDD VSS sg13g2_buf_1
XFILLER_99_860 VDD VSS sg13g2_fill_2
XFILLER_28_1231 VDD VSS sg13g2_decap_8
Xfanout512 _13570_/S _13508_/X VDD VSS sg13g2_buf_1
X_09905_ _09905_/X _09905_/A _09938_/B _10070_/A _10070_/B VDD VSS sg13g2_and4_1
XFILLER_132_489 VDD VSS sg13g2_decap_4
XFILLER_113_670 VDD VSS sg13g2_decap_8
Xfanout534 _10138_/A1 _08969_/X VDD VSS sg13g2_buf_1
XFILLER_99_893 VDD VSS sg13g2_decap_8
Xfanout545 _08761_/B _13482_/B VDD VSS sg13g2_buf_1
XFILLER_86_521 VDD VSS sg13g2_decap_4
XFILLER_76_28 VDD VSS sg13g2_decap_8
XFILLER_24_1106 VDD VSS sg13g2_decap_8
Xfanout556 _08246_/A1 _08381_/A VDD VSS sg13g2_buf_1
XFILLER_8_1358 VDD VSS sg13g2_decap_8
XFILLER_59_757 VDD VSS sg13g2_decap_8
Xfanout567 _13297_/A0 _12808_/Y VDD VSS sg13g2_buf_1
X_09836_ _14424_/D _09935_/A1 _14424_/Q _09837_/S VDD VSS sg13g2_mux2_1
XFILLER_86_543 VDD VSS sg13g2_decap_8
Xfanout578 _11655_/B _11433_/B VDD VSS sg13g2_buf_1
Xfanout589 _10837_/B _13294_/B VDD VSS sg13g2_buf_1
XFILLER_86_565 VDD VSS sg13g2_decap_8
XFILLER_101_898 VDD VSS sg13g2_decap_8
X_14505__1674 _14505_/RESET_B VDD VSS sg13g2_tiehi
X_09767_ _14357_/D _14357_/Q _09932_/A1 _09771_/S VDD VSS sg13g2_mux2_1
XFILLER_6_1071 VDD VSS sg13g2_decap_8
XFILLER_39_470 VDD VSS sg13g2_decap_4
X_08718_ _15212_/D _08717_/X _15121_/Q _13655_/S VDD VSS sg13g2_mux2_1
X_09698_ _14290_/D _10061_/A0 _14290_/Q _09706_/S VDD VSS sg13g2_mux2_1
XFILLER_15_805 VDD VSS sg13g2_decap_8
X_08649_ _08650_/B _08662_/B _08647_/Y _08649_/S VDD VSS sg13g2_mux2_1
XFILLER_27_687 VDD VSS sg13g2_decap_8
XFILLER_25_21 VDD VSS sg13g2_decap_8
XFILLER_14_315 VDD VSS sg13g2_decap_8
XFILLER_26_175 VDD VSS sg13g2_decap_8
X_11660_ _11771_/A _11661_/A _13680_/Q VDD VSS sg13g2_nor2_1
XFILLER_42_657 VDD VSS sg13g2_fill_2
XFILLER_168_810 VDD VSS sg13g2_decap_8
XFILLER_161_1210 VDD VSS sg13g2_decap_8
X_10611_ _14879_/D _10611_/A _10630_/C _10611_/C VDD VSS sg13g2_and3_1
XFILLER_25_98 VDD VSS sg13g2_decap_8
XFILLER_41_178 VDD VSS sg13g2_decap_8
XFILLER_35_1235 VDD VSS sg13g2_decap_8
X_11591_ _11636_/C _11591_/A _13682_/Q VDD VSS sg13g2_xor2_1
XFILLER_41_189 VDD VSS sg13g2_fill_1
XFILLER_161_1254 VDD VSS sg13g2_fill_1
XFILLER_168_865 VDD VSS sg13g2_decap_8
XFILLER_50_690 VDD VSS sg13g2_decap_8
XFILLER_10_532 VDD VSS sg13g2_decap_8
X_13330_ _13502_/B hold3048/X _13336_/S _13329_/Y VDD VSS sg13g2_o21ai_1
XFILLER_22_392 VDD VSS sg13g2_decap_8
XFILLER_122_1227 VDD VSS sg13g2_fill_1
XFILLER_167_364 VDD VSS sg13g2_decap_8
X_10542_ _10544_/A _10566_/D _10547_/D _14863_/Q VDD VSS sg13g2_a21o_1
XFILLER_41_42 VDD VSS sg13g2_decap_8
XFILLER_6_525 VDD VSS sg13g2_decap_8
XFILLER_157_42 VDD VSS sg13g2_decap_8
X_13261_ _13261_/Y _14829_/Q _13206_/B _13249_/B _14893_/Q _13274_/C1 VDD VSS sg13g2_a221oi_1
X_10473_ _10484_/D _10486_/D _14845_/Q _10500_/A _10473_/D VDD VSS sg13g2_and4_1
XFILLER_108_442 VDD VSS sg13g2_fill_1
XFILLER_109_965 VDD VSS sg13g2_decap_4
X_15000_ _15000_/Q clkload32/A _15000_/D _15000_/RESET_B VDD VSS sg13g2_dfrbpq_1
X_12212_ _12212_/X _13751_/Q _14103_/Q _14455_/Q _14551_/Q _12212_/S0 _12212_/S1 VDD
+ VSS sg13g2_mux4_1
XFILLER_124_913 VDD VSS sg13g2_decap_8
XFILLER_170_518 VDD VSS sg13g2_decap_8
X_13192_ _13192_/X input21/X _13272_/A2 _13272_/B1 VDD VSS sg13g2_a21o_1
XFILLER_123_412 VDD VSS sg13g2_decap_8
XFILLER_163_581 VDD VSS sg13g2_decap_8
X_12143_ _12144_/B _12291_/A _12143_/B VDD VSS sg13g2_nor2_1
XFILLER_124_968 VDD VSS sg13g2_decap_4
XFILLER_9_0 VDD VSS sg13g2_decap_8
XFILLER_123_445 VDD VSS sg13g2_decap_8
XFILLER_2_742 VDD VSS sg13g2_decap_8
XFILLER_150_242 VDD VSS sg13g2_decap_8
XFILLER_155_1058 VDD VSS sg13g2_fill_1
X_12074_ _12075_/B _12071_/X _12070_/X _12067_/X _12066_/X _12188_/C _12265_/B1 VDD
+ VSS sg13g2_mux4_1
XFILLER_1_252 VDD VSS sg13g2_decap_8
XFILLER_104_670 VDD VSS sg13g2_decap_8
XFILLER_173_63 VDD VSS sg13g2_decap_8
XFILLER_172_1350 VDD VSS sg13g2_fill_2
XFILLER_49_212 VDD VSS sg13g2_decap_8
XFILLER_46_1375 VDD VSS sg13g2_decap_4
XFILLER_2_14 VDD VSS sg13g2_decap_8
X_11025_ _11025_/Y _11022_/Y _11064_/B _11043_/A VDD VSS sg13g2_a21oi_1
XFILLER_49_223 VDD VSS sg13g2_fill_1
XFILLER_103_180 VDD VSS sg13g2_decap_8
XFILLER_103_191 VDD VSS sg13g2_decap_8
X_16882_ _16882_/X _16882_/A VDD VSS sg13g2_buf_1
X_14930__2684 _14930_/RESET_B VDD VSS sg13g2_tiehi
XFILLER_49_256 VDD VSS sg13g2_decap_8
XFILLER_77_587 VDD VSS sg13g2_fill_2
XFILLER_37_418 VDD VSS sg13g2_decap_8
X_12976_ _12976_/Y _14842_/Q _13273_/B VDD VSS sg13g2_nand2_1
XFILLER_46_974 VDD VSS sg13g2_fill_2
XFILLER_18_665 VDD VSS sg13g2_decap_8
X_14715_ _14715_/Q clkload46/A _14715_/D _14715_/RESET_B VDD VSS sg13g2_dfrbpq_1
X_11927_ _11929_/B _12174_/A _11927_/B VDD VSS sg13g2_nor2_1
XFILLER_75_1037 VDD VSS sg13g2_decap_8
XFILLER_17_175 VDD VSS sg13g2_decap_8
XFILLER_72_281 VDD VSS sg13g2_decap_8
XFILLER_32_112 VDD VSS sg13g2_decap_8
XFILLER_127_1116 VDD VSS sg13g2_decap_8
XFILLER_60_432 VDD VSS sg13g2_decap_8
XFILLER_61_966 VDD VSS sg13g2_fill_1
XFILLER_127_1138 VDD VSS sg13g2_fill_2
XFILLER_166_1187 VDD VSS sg13g2_decap_8
X_14646_ _14646_/Q clkload26/A _14646_/D _14646_/RESET_B VDD VSS sg13g2_dfrbpq_1
X_11858_ _11858_/Y _12001_/A _11858_/B VDD VSS sg13g2_nor2_1
XFILLER_21_819 VDD VSS sg13g2_decap_8
XFILLER_33_679 VDD VSS sg13g2_fill_1
XANTENNA_19 _12791_/C1 VDD VSS sg13g2_antennanp
XFILLER_14_882 VDD VSS sg13g2_decap_8
X_10809_ _10809_/Y _10869_/A _10809_/B VDD VSS sg13g2_nor2_1
XFILLER_20_329 VDD VSS sg13g2_decap_8
X_14577_ _14577_/Q _14737_/CLK _14577_/D _14577_/RESET_B VDD VSS sg13g2_dfrbpq_1
X_11789_ _11789_/X _11781_/X _11782_/X _11785_/X _11786_/X _11743_/C _11999_/S1 VDD
+ VSS sg13g2_mux4_1
XFILLER_159_876 VDD VSS sg13g2_decap_4
XFILLER_13_392 VDD VSS sg13g2_decap_8
X_14089__2090 _14089_/RESET_B VDD VSS sg13g2_tiehi
XFILLER_119_729 VDD VSS sg13g2_fill_2
X_13528_ _15142_/D _13535_/B _13526_/Y _13527_/Y VDD VSS sg13g2_a21oi_1
XFILLER_173_301 VDD VSS sg13g2_decap_8
XFILLER_16_1190 VDD VSS sg13g2_decap_8
XFILLER_9_385 VDD VSS sg13g2_decap_8
XFILLER_174_857 VDD VSS sg13g2_decap_8
X_13459_ _13459_/Y _15196_/Q _15200_/Q _13459_/C _13459_/D VDD VSS sg13g2_nand4_1
XFILLER_12_1043 VDD VSS sg13g2_decap_8
XFILLER_51_1092 VDD VSS sg13g2_decap_8
XFILLER_161_507 VDD VSS sg13g2_fill_1
XFILLER_173_378 VDD VSS sg13g2_decap_8
Xoutput104 mem_axi_wdata[0] _15132_/Q VDD VSS sg13g2_buf_1
Xoutput115 mem_axi_wdata[1] _15133_/Q VDD VSS sg13g2_buf_1
XFILLER_173_389 VDD VSS sg13g2_fill_1
XFILLER_99_101 VDD VSS sg13g2_decap_8
Xoutput126 mem_axi_wdata[2] _15134_/Q VDD VSS sg13g2_buf_1
XFILLER_115_957 VDD VSS sg13g2_decap_8
Xoutput137 mem_axi_wstrb[1] _15165_/Q VDD VSS sg13g2_buf_1
X_15129_ _15129_/Q clkload65/A _15129_/D _15129_/RESET_B VDD VSS sg13g2_dfrbpq_1
XFILLER_142_765 VDD VSS sg13g2_fill_2
XFILLER_141_242 VDD VSS sg13g2_fill_2
X_07951_ _07951_/Y _15010_/Q _07818_/B VDD VSS sg13g2_nor2b_1
XFILLER_68_532 VDD VSS sg13g2_fill_2
X_07882_ _07882_/Y _07913_/A _13609_/A VDD VSS sg13g2_nor2_1
XFILLER_96_863 VDD VSS sg13g2_decap_8
XFILLER_68_554 VDD VSS sg13g2_decap_8
X_09621_ _14217_/D _09621_/A0 _14217_/Q _09637_/S VDD VSS sg13g2_mux2_1
XFILLER_3_1211 VDD VSS sg13g2_decap_8
XFILLER_55_237 VDD VSS sg13g2_fill_1
X_09552_ _14150_/D _10149_/A1 _14150_/Q _09563_/S VDD VSS sg13g2_mux2_1
XFILLER_58_1202 VDD VSS sg13g2_fill_2
XFILLER_110_1153 VDD VSS sg13g2_decap_8
X_08503_ _08503_/Y _07821_/B _07636_/Y _08497_/A VDD VSS sg13g2_o21ai_1
XFILLER_3_1288 VDD VSS sg13g2_decap_8
X_09483_ _14083_/D _10079_/A0 _14083_/Q _09505_/S VDD VSS sg13g2_mux2_1
XFILLER_110_1186 VDD VSS sg13g2_fill_1
X_14299__1880 _14299_/RESET_B VDD VSS sg13g2_tiehi
XFILLER_52_944 VDD VSS sg13g2_decap_8
XFILLER_23_112 VDD VSS sg13g2_decap_8
XFILLER_93_1148 VDD VSS sg13g2_fill_1
X_08434_ _08442_/B _08574_/B _08434_/B VDD VSS sg13g2_nand2b_1
XFILLER_52_966 VDD VSS sg13g2_fill_2
XFILLER_169_629 VDD VSS sg13g2_fill_2
XFILLER_93_1159 VDD VSS sg13g2_decap_8
XFILLER_51_443 VDD VSS sg13g2_decap_8
XFILLER_145_1238 VDD VSS sg13g2_decap_8
XFILLER_12_819 VDD VSS sg13g2_decap_8
X_08365_ _08411_/C _07782_/A _15002_/Q _08376_/A3 _08351_/B VDD VSS sg13g2_a22oi_1
XFILLER_11_329 VDD VSS sg13g2_decap_8
XFILLER_23_189 VDD VSS sg13g2_decap_8
XFILLER_149_342 VDD VSS sg13g2_decap_8
XFILLER_164_301 VDD VSS sg13g2_decap_8
X_08296_ _08296_/Y _08276_/A _08276_/B _08369_/B VDD VSS sg13g2_a21oi_1
XFILLER_165_835 VDD VSS sg13g2_decap_8
XFILLER_30_1121 VDD VSS sg13g2_decap_8
XFILLER_20_896 VDD VSS sg13g2_decap_8
XFILLER_121_1260 VDD VSS sg13g2_fill_2
XFILLER_139_1009 VDD VSS sg13g2_fill_1
XFILLER_164_378 VDD VSS sg13g2_decap_8
XFILLER_118_784 VDD VSS sg13g2_decap_8
XFILLER_11_56 VDD VSS sg13g2_decap_8
XFILLER_3_539 VDD VSS sg13g2_decap_8
XFILLER_30_1198 VDD VSS sg13g2_decap_8
XFILLER_132_220 VDD VSS sg13g2_fill_2
XFILLER_133_743 VDD VSS sg13g2_decap_8
XFILLER_133_754 VDD VSS sg13g2_decap_8
XFILLER_87_16 VDD VSS sg13g2_fill_1
XFILLER_156_1345 VDD VSS sg13g2_fill_2
XFILLER_2_7 VDD VSS sg13g2_decap_8
X_13787__2392 _13787_/RESET_B VDD VSS sg13g2_tiehi
Xfanout1307 _11966_/S fanout1308/X VDD VSS sg13g2_buf_1
Xfanout1318 _11814_/S0 _11358_/S0 VDD VSS sg13g2_buf_1
Xfanout1329 _11300_/S0 _11320_/S0 VDD VSS sg13g2_buf_1
Xfanout342 _09697_/S _09706_/S VDD VSS sg13g2_buf_1
X_14738__1441 _14738_/RESET_B VDD VSS sg13g2_tiehi
Xfanout353 _09497_/S _09494_/S VDD VSS sg13g2_buf_1
XFILLER_8_1155 VDD VSS sg13g2_decap_8
Xfanout364 _09301_/S _09305_/S VDD VSS sg13g2_buf_1
Xfanout375 _09200_/S _09189_/S VDD VSS sg13g2_buf_1
XFILLER_87_874 VDD VSS sg13g2_decap_8
XFILLER_87_885 VDD VSS sg13g2_fill_2
XFILLER_4_1008 VDD VSS sg13g2_decap_8
Xfanout386 _10012_/A0 _10078_/A0 VDD VSS sg13g2_buf_1
Xfanout397 _09310_/A0 wire398/X VDD VSS sg13g2_buf_1
X_09819_ _14407_/D _09918_/A1 _14407_/Q _09831_/S VDD VSS sg13g2_mux2_1
XFILLER_59_587 VDD VSS sg13g2_decap_8
XFILLER_46_204 VDD VSS sg13g2_decap_8
XFILLER_74_524 VDD VSS sg13g2_decap_8
XFILLER_46_215 VDD VSS sg13g2_fill_1
X_14021__2158 _14021_/RESET_B VDD VSS sg13g2_tiehi
XFILLER_41_1261 VDD VSS sg13g2_decap_8
X_12830_ _12830_/Y _14801_/Q _12851_/B _07728_/B _14833_/Q _13248_/B VDD VSS sg13g2_a221oi_1
XFILLER_46_248 VDD VSS sg13g2_decap_4
XFILLER_36_42 VDD VSS sg13g2_decap_8
XFILLER_27_451 VDD VSS sg13g2_fill_1
XFILLER_15_602 VDD VSS sg13g2_decap_8
XFILLER_43_922 VDD VSS sg13g2_decap_8
XFILLER_28_996 VDD VSS sg13g2_fill_1
X_12761_ _12761_/X _12759_/X _12758_/X _12755_/X _12754_/X _12761_/S0 _12761_/S1 VDD
+ VSS sg13g2_mux4_1
XFILLER_76_1346 VDD VSS sg13g2_fill_2
XFILLER_14_112 VDD VSS sg13g2_decap_8
XFILLER_37_1308 VDD VSS sg13g2_decap_8
XFILLER_163_1316 VDD VSS sg13g2_decap_8
X_14500_ _14500_/Q _14672_/CLK _14500_/D _14500_/RESET_B VDD VSS sg13g2_dfrbpq_1
X_11712_ _11712_/X _14121_/Q _14153_/Q _14185_/Q _14217_/Q _12282_/S0 _12282_/S1 VDD
+ VSS sg13g2_mux4_1
X_12692_ _12692_/X _12691_/X _12690_/X _12692_/S VDD VSS sg13g2_mux2_1
XFILLER_15_679 VDD VSS sg13g2_decap_8
XFILLER_30_616 VDD VSS sg13g2_decap_4
XFILLER_146_0 VDD VSS sg13g2_decap_8
X_14431_ _14431_/Q _14733_/CLK _14431_/D _14431_/RESET_B VDD VSS sg13g2_dfrbpq_1
X_11643_ _11643_/Y _11643_/A _11643_/B VDD VSS sg13g2_xnor2_1
XFILLER_39_1190 VDD VSS sg13g2_decap_8
XFILLER_14_189 VDD VSS sg13g2_decap_8
XFILLER_30_638 VDD VSS sg13g2_fill_1
X_14362_ _14362_/Q _14682_/CLK _14362_/D _14362_/RESET_B VDD VSS sg13g2_dfrbpq_1
X_11574_ _11574_/X _13733_/Q _14085_/Q _14437_/Q _14533_/Q _11997_/S0 _11997_/S1 VDD
+ VSS sg13g2_mux4_1
XFILLER_167_161 VDD VSS sg13g2_decap_8
XFILLER_168_63 VDD VSS sg13g2_decap_8
XFILLER_7_812 VDD VSS sg13g2_decap_8
Xinput17 input17/X input17/A VDD VSS sg13g2_buf_1
Xinput28 input28/X input28/A VDD VSS sg13g2_buf_1
XFILLER_35_1098 VDD VSS sg13g2_fill_1
XFILLER_11_896 VDD VSS sg13g2_decap_8
XFILLER_13_1330 VDD VSS sg13g2_decap_8
X_13313_ _13316_/C _07691_/Y _07677_/B _13312_/Y VDD VSS sg13g2_a21oi_1
X_10525_ _10525_/Y _10558_/C _10531_/D _10535_/C VDD VSS sg13g2_o21ai_1
XFILLER_128_559 VDD VSS sg13g2_decap_8
X_14293_ _14293_/Q clkload16/A _14293_/D _14293_/RESET_B VDD VSS sg13g2_dfrbpq_1
XFILLER_6_322 VDD VSS sg13g2_decap_8
X_13244_ _13247_/B _13232_/A _13244_/B _13246_/C VDD VSS sg13g2_nand3b_1
XFILLER_7_889 VDD VSS sg13g2_decap_8
XFILLER_108_250 VDD VSS sg13g2_decap_8
XFILLER_170_315 VDD VSS sg13g2_decap_8
X_10456_ _14841_/D _14841_/Q _10453_/X _10455_/Y VDD VSS sg13g2_a21oi_1
XFILLER_136_581 VDD VSS sg13g2_decap_8
XFILLER_124_732 VDD VSS sg13g2_decap_8
XFILLER_6_399 VDD VSS sg13g2_decap_8
XFILLER_100_1366 VDD VSS sg13g2_decap_4
X_13175_ _13176_/C _14917_/Q _13670_/Q _13145_/A _13169_/Y _13174_/Y VDD VSS sg13g2_a221oi_1
X_10387_ _10387_/X _14818_/Q _14819_/Q _14820_/Q _10396_/C VDD VSS sg13g2_and4_1
X_14231__1948 _14231_/RESET_B VDD VSS sg13g2_tiehi
X_12126_ _12149_/A _12126_/A _12128_/A VDD VSS sg13g2_nand2_1
XFILLER_97_638 VDD VSS sg13g2_decap_8
XFILLER_35_7 VDD VSS sg13g2_decap_8
XFILLER_123_297 VDD VSS sg13g2_fill_1
XFILLER_81_1052 VDD VSS sg13g2_fill_1
X_12057_ _12062_/A _11778_/A _11778_/B _12056_/X VDD VSS sg13g2_o21ai_1
XFILLER_81_1063 VDD VSS sg13g2_fill_1
XFILLER_77_82 VDD VSS sg13g2_decap_8
XFILLER_133_1164 VDD VSS sg13g2_fill_2
X_11008_ _11010_/B _10974_/Y _10989_/Y _10988_/Y VDD VSS sg13g2_a21o_1
X_16865_ _16865_/X _16865_/A VDD VSS sg13g2_buf_1
XFILLER_38_749 VDD VSS sg13g2_decap_8
XFILLER_168_1205 VDD VSS sg13g2_fill_1
XFILLER_20_1323 VDD VSS sg13g2_decap_8
XFILLER_19_952 VDD VSS sg13g2_decap_8
XFILLER_18_462 VDD VSS sg13g2_decap_8
XFILLER_46_782 VDD VSS sg13g2_fill_2
XFILLER_80_538 VDD VSS sg13g2_decap_8
X_12959_ _12959_/X _14903_/Q _13684_/Q _12945_/Y VDD VSS sg13g2_a21o_1
X_14176__2003 _14176_/RESET_B VDD VSS sg13g2_tiehi
XFILLER_21_616 VDD VSS sg13g2_decap_8
XFILLER_53_1110 VDD VSS sg13g2_decap_4
X_14629_ _14629_/Q clkload5/A _14629_/D _14629_/RESET_B VDD VSS sg13g2_dfrbpq_1
XFILLER_92_1170 VDD VSS sg13g2_decap_8
XFILLER_57_1290 VDD VSS sg13g2_decap_4
XFILLER_53_1121 VDD VSS sg13g2_decap_8
XFILLER_60_284 VDD VSS sg13g2_fill_2
XFILLER_20_126 VDD VSS sg13g2_decap_8
XFILLER_105_1211 VDD VSS sg13g2_fill_1
X_08150_ _08150_/X _08013_/X _08146_/A _08397_/B _08011_/X _08223_/S _08241_/A VDD
+ VSS sg13g2_mux4_1
XFILLER_18_1274 VDD VSS sg13g2_decap_8
XFILLER_140_1113 VDD VSS sg13g2_decap_8
XFILLER_14_1127 VDD VSS sg13g2_decap_8
XFILLER_158_161 VDD VSS sg13g2_fill_2
XFILLER_146_323 VDD VSS sg13g2_fill_1
XFILLER_147_846 VDD VSS sg13g2_decap_8
XFILLER_140_1157 VDD VSS sg13g2_fill_2
X_08081_ _08081_/X _08620_/A1 _08635_/A1 _08686_/A3 _08010_/B _08009_/S _08124_/S1
+ VDD VSS sg13g2_mux4_1
XFILLER_9_182 VDD VSS sg13g2_decap_8
XFILLER_134_507 VDD VSS sg13g2_fill_1
XFILLER_61_0 VDD VSS sg13g2_decap_8
XFILLER_134_518 VDD VSS sg13g2_decap_8
XFILLER_173_164 VDD VSS sg13g2_decap_8
XFILLER_173_175 VDD VSS sg13g2_fill_1
XFILLER_115_743 VDD VSS sg13g2_fill_2
XFILLER_161_359 VDD VSS sg13g2_decap_8
X_14207__1972 _14207_/RESET_B VDD VSS sg13g2_tiehi
X_08983_ _08983_/X _09057_/A _08980_/X _08982_/Y VDD VSS sg13g2_a21o_1
XFILLER_102_437 VDD VSS sg13g2_decap_8
X_14983__2604 _14983_/RESET_B VDD VSS sg13g2_tiehi
XFILLER_102_448 VDD VSS sg13g2_fill_2
XFILLER_151_1220 VDD VSS sg13g2_fill_1
X_07934_ _07934_/Y _08351_/B _07786_/A VDD VSS sg13g2_nor2b_1
XFILLER_87_159 VDD VSS sg13g2_decap_4
XFILLER_151_1231 VDD VSS sg13g2_decap_8
XFILLER_151_1242 VDD VSS sg13g2_fill_1
XFILLER_99_1302 VDD VSS sg13g2_fill_2
XFILLER_68_362 VDD VSS sg13g2_fill_1
XFILLER_29_727 VDD VSS sg13g2_decap_4
XFILLER_25_1267 VDD VSS sg13g2_decap_8
X_07865_ _07867_/D _08641_/A _08641_/B _08641_/C _08641_/D VDD VSS sg13g2_nand4_1
XFILLER_113_14 VDD VSS sg13g2_decap_8
XFILLER_56_524 VDD VSS sg13g2_decap_8
XFILLER_99_1346 VDD VSS sg13g2_fill_2
XFILLER_84_844 VDD VSS sg13g2_fill_2
XFILLER_83_321 VDD VSS sg13g2_fill_2
XFILLER_68_395 VDD VSS sg13g2_fill_2
XFILLER_151_1297 VDD VSS sg13g2_fill_1
XFILLER_112_1259 VDD VSS sg13g2_decap_8
X_09604_ _14201_/D _14201_/Q _10068_/A0 _09604_/S VDD VSS sg13g2_mux2_1
XFILLER_44_708 VDD VSS sg13g2_decap_8
X_07796_ _07796_/Y _07796_/A _07796_/B _07797_/D VDD VSS sg13g2_nor3_1
X_15051__2523 _15051_/RESET_B VDD VSS sg13g2_tiehi
X_09535_ _14134_/D _09900_/A0 _14134_/Q _09535_/S VDD VSS sg13g2_mux2_1
XFILLER_97_1070 VDD VSS sg13g2_fill_1
XFILLER_3_1085 VDD VSS sg13g2_decap_8
XFILLER_24_432 VDD VSS sg13g2_decap_8
X_09466_ _14067_/D _09666_/A0 _14067_/Q _09469_/S VDD VSS sg13g2_mux2_1
XFILLER_58_1065 VDD VSS sg13g2_decap_8
XFILLER_149_1193 VDD VSS sg13g2_decap_8
XFILLER_12_616 VDD VSS sg13g2_decap_8
XFILLER_169_448 VDD VSS sg13g2_decap_8
XFILLER_51_262 VDD VSS sg13g2_fill_1
XFILLER_106_1008 VDD VSS sg13g2_decap_8
X_08417_ _08417_/Y _08418_/B _08417_/B VDD VSS sg13g2_nand2_1
XFILLER_36_1330 VDD VSS sg13g2_decap_8
X_09397_ _14000_/D _09696_/A0 _14000_/Q _09407_/S VDD VSS sg13g2_mux2_1
XFILLER_11_126 VDD VSS sg13g2_decap_8
XFILLER_8_609 VDD VSS sg13g2_decap_8
XFILLER_123_1322 VDD VSS sg13g2_decap_4
X_08348_ _08348_/Y _07786_/A _08351_/B _08497_/A VDD VSS sg13g2_a21oi_1
XFILLER_138_824 VDD VSS sg13g2_decap_8
XFILLER_162_1382 VDD VSS sg13g2_fill_2
XFILLER_7_119 VDD VSS sg13g2_decap_8
X_08279_ _08279_/X _08279_/A _08279_/B VDD VSS sg13g2_and2_1
XFILLER_20_693 VDD VSS sg13g2_decap_8
XFILLER_22_77 VDD VSS sg13g2_decap_8
X_10310_ _10327_/C _14796_/Q _14797_/Q VDD VSS sg13g2_and2_1
XFILLER_164_175 VDD VSS sg13g2_decap_8
XFILLER_165_698 VDD VSS sg13g2_decap_8
X_11290_ _11338_/A _11291_/A _12836_/B VDD VSS sg13g2_nor2_1
XFILLER_4_826 VDD VSS sg13g2_decap_8
X_13874__2305 _13874_/RESET_B VDD VSS sg13g2_tiehi
X_10241_ _10241_/Y _14775_/Q wire525/X _10334_/C VDD VSS sg13g2_o21ai_1
XFILLER_3_336 VDD VSS sg13g2_decap_8
XFILLER_106_776 VDD VSS sg13g2_fill_1
XFILLER_117_1104 VDD VSS sg13g2_fill_1
XFILLER_121_702 VDD VSS sg13g2_decap_4
XFILLER_154_21 VDD VSS sg13g2_decap_8
X_10172_ _10185_/B _10172_/A _14766_/Q _10172_/C _13600_/A VDD VSS sg13g2_or4_1
XFILLER_79_638 VDD VSS sg13g2_decap_8
Xfanout1104 _07861_/B _12061_/A VDD VSS sg13g2_buf_1
XFILLER_105_297 VDD VSS sg13g2_fill_2
Xfanout1115 _11936_/A _14978_/Q VDD VSS sg13g2_buf_1
XFILLER_152_1039 VDD VSS sg13g2_fill_1
Xfanout1126 _07945_/B _08487_/A3 VDD VSS sg13g2_buf_1
X_14980_ _14980_/Q _14984_/CLK _14980_/D _14980_/RESET_B VDD VSS sg13g2_dfrbpq_1
Xfanout1137 _11661_/A _08405_/A1 VDD VSS sg13g2_buf_1
XFILLER_82_1383 VDD VSS sg13g2_fill_1
XFILLER_102_960 VDD VSS sg13g2_decap_8
XFILLER_154_98 VDD VSS sg13g2_decap_8
Xfanout150 _10101_/A0 _10168_/A1 VDD VSS sg13g2_buf_1
Xfanout1148 _11570_/A _14967_/Q VDD VSS sg13g2_buf_1
Xfanout161 _09967_/A1 fanout162/X VDD VSS sg13g2_buf_1
Xfanout1159 _07888_/B _14963_/Q VDD VSS sg13g2_buf_1
Xfanout172 _09898_/A0 _10096_/A0 VDD VSS sg13g2_buf_1
XFILLER_59_362 VDD VSS sg13g2_decap_8
X_13931_ _13931_/Q clkload2/A _13931_/D _13931_/RESET_B VDD VSS sg13g2_dfrbpq_1
Xfanout183 _09630_/A0 _10061_/A0 VDD VSS sg13g2_buf_1
Xfanout194 _10125_/A0 _09926_/A1 VDD VSS sg13g2_buf_1
XFILLER_47_63 VDD VSS sg13g2_decap_8
XFILLER_170_42 VDD VSS sg13g2_decap_8
XFILLER_86_192 VDD VSS sg13g2_decap_8
X_13862_ _13862_/Q _14310_/CLK _13862_/D _13862_/RESET_B VDD VSS sg13g2_dfrbpq_1
XFILLER_35_708 VDD VSS sg13g2_fill_1
XFILLER_19_259 VDD VSS sg13g2_decap_8
XFILLER_41_1091 VDD VSS sg13g2_decap_8
X_12813_ _12813_/X _12883_/A _12900_/C _12899_/C input21/X VDD VSS sg13g2_and4_1
XFILLER_74_387 VDD VSS sg13g2_decap_4
X_13793_ _13793_/Q _14721_/CLK _13793_/D _13793_/RESET_B VDD VSS sg13g2_dfrbpq_1
XFILLER_103_80 VDD VSS sg13g2_decap_8
XFILLER_163_1102 VDD VSS sg13g2_decap_8
XFILLER_16_966 VDD VSS sg13g2_decap_8
X_12744_ _12744_/X _14391_/Q _14423_/Q _14487_/Q _14519_/Q _12745_/S0 _12745_/S1 VDD
+ VSS sg13g2_mux4_1
XFILLER_31_914 VDD VSS sg13g2_decap_8
XFILLER_37_1138 VDD VSS sg13g2_decap_8
XFILLER_15_476 VDD VSS sg13g2_decap_8
XFILLER_70_571 VDD VSS sg13g2_decap_8
XFILLER_124_1108 VDD VSS sg13g2_decap_8
X_12675_ _12675_/X _13970_/Q _14002_/Q _14034_/Q _14066_/Q _12758_/S0 _12758_/S1 VDD
+ VSS sg13g2_mux4_1
X_14414_ _14414_/Q clkload39/A _14414_/D _14414_/RESET_B VDD VSS sg13g2_dfrbpq_1
XFILLER_8_35 VDD VSS sg13g2_decap_8
X_11626_ _11626_/Y _11606_/Y _11608_/X _11975_/A VDD VSS sg13g2_o21ai_1
XFILLER_156_643 VDD VSS sg13g2_fill_2
XFILLER_50_1349 VDD VSS sg13g2_fill_1
X_14345_ _14345_/Q _14505_/CLK _14345_/D _14345_/RESET_B VDD VSS sg13g2_dfrbpq_1
XFILLER_11_693 VDD VSS sg13g2_decap_8
X_11557_ _11557_/Y _11533_/Y _11535_/Y _12174_/A VDD VSS sg13g2_a21oi_1
XFILLER_156_676 VDD VSS sg13g2_decap_8
XFILLER_128_389 VDD VSS sg13g2_fill_2
X_10508_ _10509_/D _10513_/D _14850_/Q _10508_/C VDD VSS sg13g2_nand3_1
XFILLER_100_1130 VDD VSS sg13g2_decap_8
X_14276_ _14276_/Q _14703_/CLK _14276_/D _14276_/RESET_B VDD VSS sg13g2_dfrbpq_1
X_11488_ _11488_/X _14242_/Q _14274_/Q _14306_/Q _14338_/Q _11489_/S0 _11489_/S1 VDD
+ VSS sg13g2_mux4_1
XFILLER_7_686 VDD VSS sg13g2_decap_8
XFILLER_137_890 VDD VSS sg13g2_decap_8
XFILLER_155_186 VDD VSS sg13g2_fill_2
XFILLER_170_112 VDD VSS sg13g2_decap_8
XFILLER_171_635 VDD VSS sg13g2_decap_8
X_14464__1715 _14464_/RESET_B VDD VSS sg13g2_tiehi
X_13227_ _13228_/C _14921_/Q _13666_/Q _13199_/X VDD VSS sg13g2_o21ai_1
X_10439_ _10459_/B _14836_/Q _14835_/Q _14834_/Q _14833_/Q VDD VSS sg13g2_nand4_1
XFILLER_6_196 VDD VSS sg13g2_decap_8
XFILLER_139_1340 VDD VSS sg13g2_fill_1
XFILLER_98_914 VDD VSS sg13g2_fill_1
XFILLER_135_1204 VDD VSS sg13g2_fill_2
XFILLER_48_1256 VDD VSS sg13g2_fill_2
XFILLER_174_1253 VDD VSS sg13g2_decap_8
XFILLER_170_189 VDD VSS sg13g2_decap_8
XFILLER_112_724 VDD VSS sg13g2_decap_8
X_13158_ _13160_/C _13174_/A _13158_/B _13170_/D VDD VSS sg13g2_nand3_1
XFILLER_135_1237 VDD VSS sg13g2_fill_2
X_12109_ _12109_/Y _12250_/A1 _13844_/Q VDD VSS sg13g2_nand2b_1
X_13089_ _13112_/A _14912_/Q _13675_/Q VDD VSS sg13g2_xnor2_1
XFILLER_69_159 VDD VSS sg13g2_decap_8
XFILLER_66_811 VDD VSS sg13g2_fill_1
X_07650_ _10818_/A _15122_/Q VDD VSS sg13g2_inv_1
XFILLER_66_877 VDD VSS sg13g2_decap_8
XFILLER_81_814 VDD VSS sg13g2_fill_1
XFILLER_20_1120 VDD VSS sg13g2_decap_8
XFILLER_168_1035 VDD VSS sg13g2_fill_1
XFILLER_4_1372 VDD VSS sg13g2_decap_8
XFILLER_80_313 VDD VSS sg13g2_fill_1
XFILLER_111_1270 VDD VSS sg13g2_decap_4
XFILLER_59_1330 VDD VSS sg13g2_decap_8
XFILLER_111_1281 VDD VSS sg13g2_fill_2
XFILLER_94_1232 VDD VSS sg13g2_decap_8
X_09320_ _13927_/D _09720_/A0 _13927_/Q _09334_/S VDD VSS sg13g2_mux2_1
XFILLER_20_1197 VDD VSS sg13g2_decap_8
XFILLER_0_1269 VDD VSS sg13g2_decap_8
XFILLER_55_1205 VDD VSS sg13g2_fill_2
XFILLER_146_1333 VDD VSS sg13g2_decap_4
XFILLER_33_240 VDD VSS sg13g2_fill_2
XFILLER_146_1344 VDD VSS sg13g2_decap_8
X_13952__2227 _13952_/RESET_B VDD VSS sg13g2_tiehi
XFILLER_22_914 VDD VSS sg13g2_decap_8
X_09251_ _13860_/D _13860_/Q _09750_/A1 _09272_/S VDD VSS sg13g2_mux2_1
XFILLER_22_936 VDD VSS sg13g2_decap_8
XFILLER_21_413 VDD VSS sg13g2_decap_8
X_08202_ _08211_/D _08452_/C _08198_/X _08201_/Y VDD VSS sg13g2_o21ai_1
XFILLER_22_969 VDD VSS sg13g2_decap_8
X_09182_ _13798_/D _13798_/Q _10082_/A0 _09193_/S VDD VSS sg13g2_mux2_1
XFILLER_18_1071 VDD VSS sg13g2_decap_8
XFILLER_159_492 VDD VSS sg13g2_fill_1
XFILLER_105_1052 VDD VSS sg13g2_decap_8
X_08133_ _08133_/X _08142_/C _07910_/B _07912_/B _07888_/B _08207_/S1 _13517_/A VDD
+ VSS sg13g2_mux4_1
XFILLER_135_816 VDD VSS sg13g2_decap_8
XFILLER_135_827 VDD VSS sg13g2_fill_1
X_08064_ _08064_/X _11291_/A _11384_/A _11335_/A _11428_/A _07884_/A _07900_/B VDD
+ VSS sg13g2_mux4_1
XFILLER_31_1260 VDD VSS sg13g2_decap_8
XFILLER_162_624 VDD VSS sg13g2_decap_8
X_14871__2802 _14871_/RESET_B VDD VSS sg13g2_tiehi
XFILLER_161_112 VDD VSS sg13g2_decap_8
XFILLER_88_1058 VDD VSS sg13g2_fill_2
XFILLER_115_551 VDD VSS sg13g2_decap_4
XFILLER_89_914 VDD VSS sg13g2_decap_8
XFILLER_66_1345 VDD VSS sg13g2_fill_2
XFILLER_153_1315 VDD VSS sg13g2_fill_2
XFILLER_161_189 VDD VSS sg13g2_decap_8
XFILLER_89_969 VDD VSS sg13g2_decap_8
XFILLER_103_757 VDD VSS sg13g2_decap_8
X_08966_ _08966_/Y _10793_/A _10697_/B VDD VSS sg13g2_nor2b_1
XFILLER_124_35 VDD VSS sg13g2_decap_8
XFILLER_57_811 VDD VSS sg13g2_decap_8
X_07917_ _08160_/C _07917_/A _07917_/B _07917_/C VDD VSS sg13g2_nor3_1
XFILLER_151_1061 VDD VSS sg13g2_decap_8
XFILLER_25_1064 VDD VSS sg13g2_decap_8
X_08897_ _08897_/Y _10776_/C _10781_/B _15038_/Q VDD VSS sg13g2_nand3_1
XFILLER_99_1132 VDD VSS sg13g2_decap_8
XFILLER_84_641 VDD VSS sg13g2_decap_8
XFILLER_84_28 VDD VSS sg13g2_decap_8
XFILLER_57_855 VDD VSS sg13g2_decap_8
XFILLER_5_1169 VDD VSS sg13g2_decap_8
XFILLER_29_568 VDD VSS sg13g2_fill_2
X_07848_ _08643_/C _15016_/Q _08012_/B VDD VSS sg13g2_or2_1
XFILLER_71_302 VDD VSS sg13g2_decap_8
XFILLER_95_1029 VDD VSS sg13g2_fill_1
X_07779_ _07779_/Y _08318_/C _08318_/D VDD VSS sg13g2_nor2_1
XFILLER_17_77 VDD VSS sg13g2_decap_8
X_09518_ _14117_/D _09949_/A1 _14117_/Q _09530_/S VDD VSS sg13g2_mux2_1
XFILLER_13_903 VDD VSS sg13g2_decap_8
X_10790_ _10790_/Y _14924_/Q _11021_/B VDD VSS sg13g2_nand2_1
XFILLER_25_763 VDD VSS sg13g2_decap_8
XFILLER_73_1327 VDD VSS sg13g2_decap_8
X_14542__1637 _14542_/RESET_B VDD VSS sg13g2_tiehi
XFILLER_12_413 VDD VSS sg13g2_decap_8
X_13928__2251 _13928_/RESET_B VDD VSS sg13g2_tiehi
XFILLER_24_273 VDD VSS sg13g2_decap_8
XFILLER_169_245 VDD VSS sg13g2_decap_8
X_14688__1491 _14688_/RESET_B VDD VSS sg13g2_tiehi
X_09449_ _14050_/D _10078_/A0 _14050_/Q _09469_/S VDD VSS sg13g2_mux2_1
XFILLER_52_593 VDD VSS sg13g2_fill_2
XFILLER_33_21 VDD VSS sg13g2_decap_8
XFILLER_149_21 VDD VSS sg13g2_decap_8
XFILLER_8_406 VDD VSS sg13g2_decap_8
X_12460_ _12460_/X _14691_/Q _14723_/Q _13763_/Q _13795_/Q _12546_/S0 _12546_/S1 VDD
+ VSS sg13g2_mux4_1
XFILLER_71_1062 VDD VSS sg13g2_decap_8
X_14796__2917 _14796_/RESET_B VDD VSS sg13g2_tiehi
XFILLER_33_98 VDD VSS sg13g2_decap_8
XFILLER_21_980 VDD VSS sg13g2_decap_8
X_11411_ _11411_/Y _11407_/Y _11408_/Y _11410_/Y _11409_/Y _11745_/B VDD VSS sg13g2_a221oi_1
X_12391_ _12391_/X _14558_/Q _14590_/Q _14622_/Q _14654_/Q _12590_/S0 _12590_/S1 VDD
+ VSS sg13g2_mux4_1
XFILLER_32_1068 VDD VSS sg13g2_decap_8
XFILLER_20_490 VDD VSS sg13g2_decap_8
XFILLER_126_827 VDD VSS sg13g2_decap_8
XFILLER_165_462 VDD VSS sg13g2_decap_8
XFILLER_158_1204 VDD VSS sg13g2_decap_8
X_14130_ _14130_/Q _14512_/CLK _14130_/D _14130_/RESET_B VDD VSS sg13g2_dfrbpq_1
X_11342_ _11342_/Y _11373_/A _13822_/Q VDD VSS sg13g2_nand2b_1
XFILLER_126_838 VDD VSS sg13g2_fill_1
XFILLER_125_337 VDD VSS sg13g2_decap_8
XFILLER_4_623 VDD VSS sg13g2_decap_8
XFILLER_10_1344 VDD VSS sg13g2_decap_8
XFILLER_109_0 VDD VSS sg13g2_decap_8
XFILLER_165_42 VDD VSS sg13g2_decap_8
X_14061_ _14061_/Q clkload4/A _14061_/D _14061_/RESET_B VDD VSS sg13g2_dfrbpq_1
X_11273_ _11273_/Y _11275_/S0 _14492_/Q _12304_/B VDD VSS sg13g2_a21oi_1
XFILLER_3_133 VDD VSS sg13g2_decap_8
X_13012_ _13012_/Y _13012_/A _13026_/C VDD VSS sg13g2_nor2_1
X_10224_ _10227_/C _14769_/Q _10219_/X _14770_/Q VDD VSS sg13g2_a21oi_1
XFILLER_133_381 VDD VSS sg13g2_decap_4
XFILLER_80_1309 VDD VSS sg13g2_fill_1
X_10155_ _14732_/D _14732_/Q _10155_/A1 _10163_/S VDD VSS sg13g2_mux2_1
XFILLER_94_405 VDD VSS sg13g2_decap_8
XFILLER_79_479 VDD VSS sg13g2_fill_2
XFILLER_43_1120 VDD VSS sg13g2_fill_1
XFILLER_48_811 VDD VSS sg13g2_decap_8
XFILLER_0_884 VDD VSS sg13g2_decap_8
XFILLER_130_1101 VDD VSS sg13g2_decap_8
X_14963_ _14963_/Q _15228_/CLK _14963_/D _14963_/RESET_B VDD VSS sg13g2_dfrbpq_1
X_10086_ _14666_/D _10086_/A0 _14666_/Q _10096_/S VDD VSS sg13g2_mux2_1
X_13914_ _13914_/Q _14746_/CLK _13914_/D _13914_/RESET_B VDD VSS sg13g2_dfrbpq_1
X_14894_ _14894_/Q _14894_/CLK _14894_/D _14894_/RESET_B VDD VSS sg13g2_dfrbpq_1
XFILLER_75_674 VDD VSS sg13g2_fill_1
XFILLER_63_814 VDD VSS sg13g2_decap_8
XFILLER_169_1366 VDD VSS sg13g2_decap_8
X_13845_ _13845_/Q clkload18/A _13845_/D _13845_/RESET_B VDD VSS sg13g2_dfrbpq_1
XFILLER_63_847 VDD VSS sg13g2_decap_8
XFILLER_63_858 VDD VSS sg13g2_fill_2
XFILLER_35_549 VDD VSS sg13g2_decap_8
X_14181__1998 _14181_/RESET_B VDD VSS sg13g2_tiehi
XFILLER_16_763 VDD VSS sg13g2_decap_8
X_13776_ _13776_/Q clkload8/A _13776_/D _13776_/RESET_B VDD VSS sg13g2_dfrbpq_1
XFILLER_90_688 VDD VSS sg13g2_decap_8
X_10988_ _10988_/Y _15116_/Q _10995_/B VDD VSS sg13g2_nor2b_1
XFILLER_31_700 VDD VSS sg13g2_decap_8
XFILLER_15_273 VDD VSS sg13g2_decap_8
X_12727_ _12727_/X _13974_/Q _14006_/Q _14038_/Q _14070_/Q _12727_/S0 _12727_/S1 VDD
+ VSS sg13g2_mux4_1
X_14518__1661 _14518_/RESET_B VDD VSS sg13g2_tiehi
XFILLER_30_232 VDD VSS sg13g2_decap_8
XFILLER_129_610 VDD VSS sg13g2_decap_8
XFILLER_15_1211 VDD VSS sg13g2_decap_8
X_12658_ _12658_/X _13841_/Q _13873_/Q _13905_/Q _13937_/Q _12658_/S0 _12658_/S1 VDD
+ VSS sg13g2_mux4_1
XFILLER_54_1282 VDD VSS sg13g2_decap_8
XFILLER_12_980 VDD VSS sg13g2_decap_8
XFILLER_157_952 VDD VSS sg13g2_decap_8
X_11609_ _11609_/Y _11597_/A _14374_/Q VDD VSS sg13g2_nand2b_1
XFILLER_30_298 VDD VSS sg13g2_decap_8
XFILLER_102_1214 VDD VSS sg13g2_decap_8
XFILLER_102_1225 VDD VSS sg13g2_fill_2
XFILLER_11_490 VDD VSS sg13g2_decap_8
XFILLER_128_142 VDD VSS sg13g2_decap_8
X_12589_ _12589_/X _14572_/Q _14604_/Q _14636_/Q _14668_/Q _12590_/S0 _12590_/S1 VDD
+ VSS sg13g2_mux4_1
XFILLER_15_1288 VDD VSS sg13g2_decap_8
XFILLER_8_973 VDD VSS sg13g2_decap_8
XFILLER_172_911 VDD VSS sg13g2_decap_4
XFILLER_157_996 VDD VSS sg13g2_decap_4
XFILLER_89_1345 VDD VSS sg13g2_decap_8
XFILLER_116_315 VDD VSS sg13g2_decap_4
X_14328_ _14328_/Q _14979_/CLK _14328_/D _14328_/RESET_B VDD VSS sg13g2_dfrbpq_1
XFILLER_117_849 VDD VSS sg13g2_fill_2
XFILLER_102_1269 VDD VSS sg13g2_decap_4
XFILLER_7_483 VDD VSS sg13g2_decap_8
XFILLER_171_432 VDD VSS sg13g2_decap_8
XFILLER_132_808 VDD VSS sg13g2_decap_8
XFILLER_144_668 VDD VSS sg13g2_decap_4
X_14259_ _14259_/Q _14660_/CLK _14259_/D _14259_/RESET_B VDD VSS sg13g2_dfrbpq_1
XFILLER_98_700 VDD VSS sg13g2_fill_1
XFILLER_172_999 VDD VSS sg13g2_decap_4
XFILLER_98_711 VDD VSS sg13g2_decap_8
XFILLER_143_189 VDD VSS sg13g2_decap_8
XFILLER_152_690 VDD VSS sg13g2_fill_1
Xfanout908 _12878_/D _13300_/A VDD VSS sg13g2_buf_1
XFILLER_48_1064 VDD VSS sg13g2_decap_8
Xfanout919 _10647_/A _13304_/B VDD VSS sg13g2_buf_1
XFILLER_174_1083 VDD VSS sg13g2_fill_1
X_08820_ _08820_/Y _13482_/A _15191_/Q VDD VSS sg13g2_nand2_1
XFILLER_140_874 VDD VSS sg13g2_decap_8
XFILLER_58_619 VDD VSS sg13g2_decap_8
XFILLER_100_716 VDD VSS sg13g2_decap_8
XFILLER_112_576 VDD VSS sg13g2_decap_8
XFILLER_86_939 VDD VSS sg13g2_decap_8
X_14620__1559 _14620_/RESET_B VDD VSS sg13g2_tiehi
XFILLER_24_0 VDD VSS sg13g2_decap_8
XFILLER_85_427 VDD VSS sg13g2_decap_4
XFILLER_152_1370 VDD VSS sg13g2_fill_1
X_08751_ _08751_/Y _08760_/A1 _08754_/A2 _15193_/Q VDD VSS sg13g2_o21ai_1
XFILLER_39_833 VDD VSS sg13g2_decap_8
XFILLER_66_630 VDD VSS sg13g2_fill_1
XFILLER_22_1226 VDD VSS sg13g2_decap_8
X_07702_ _07702_/X _10647_/A _10441_/C VDD VSS sg13g2_and2_1
XFILLER_2_1309 VDD VSS sg13g2_decap_8
XFILLER_96_1305 VDD VSS sg13g2_fill_2
X_08682_ _08682_/Y _08678_/Y _08647_/Y _08681_/Y VDD VSS sg13g2_o21ai_1
XFILLER_39_888 VDD VSS sg13g2_decap_8
XFILLER_93_460 VDD VSS sg13g2_decap_8
XFILLER_65_162 VDD VSS sg13g2_decap_8
XFILLER_81_622 VDD VSS sg13g2_fill_1
XFILLER_26_527 VDD VSS sg13g2_fill_1
X_07633_ _08203_/B _14995_/Q VDD VSS sg13g2_inv_1
XFILLER_26_549 VDD VSS sg13g2_fill_2
XFILLER_65_195 VDD VSS sg13g2_fill_2
XFILLER_0_91 VDD VSS sg13g2_decap_8
XFILLER_0_1066 VDD VSS sg13g2_decap_8
XFILLER_81_688 VDD VSS sg13g2_fill_2
XFILLER_34_560 VDD VSS sg13g2_fill_2
XFILLER_146_1130 VDD VSS sg13g2_fill_2
X_09303_ _13911_/D _13911_/Q _09703_/A0 _09305_/S VDD VSS sg13g2_mux2_1
XFILLER_80_187 VDD VSS sg13g2_fill_1
XFILLER_94_1095 VDD VSS sg13g2_fill_2
XFILLER_22_733 VDD VSS sg13g2_fill_1
XFILLER_21_210 VDD VSS sg13g2_decap_8
XFILLER_16_1008 VDD VSS sg13g2_decap_8
XFILLER_139_407 VDD VSS sg13g2_decap_8
XFILLER_22_766 VDD VSS sg13g2_decap_8
XFILLER_10_917 VDD VSS sg13g2_decap_8
XFILLER_142_1027 VDD VSS sg13g2_decap_8
X_09234_ _13845_/D _10164_/A1 _13845_/Q _09238_/S VDD VSS sg13g2_mux2_1
XFILLER_33_1344 VDD VSS sg13g2_decap_8
XFILLER_21_287 VDD VSS sg13g2_decap_8
XFILLER_166_259 VDD VSS sg13g2_decap_8
X_09165_ _09165_/Y _09157_/C _09164_/X _14925_/Q _09158_/C VDD VSS sg13g2_a22oi_1
XFILLER_148_985 VDD VSS sg13g2_fill_2
XFILLER_119_35 VDD VSS sg13g2_decap_8
X_08116_ _08116_/Y _13427_/C _07916_/Y _08115_/Y VDD VSS sg13g2_a21oi_1
XFILLER_120_1347 VDD VSS sg13g2_fill_1
XFILLER_163_933 VDD VSS sg13g2_fill_2
X_09096_ _09136_/B _14915_/Q _09103_/C _09103_/D VDD VSS sg13g2_and3_1
XFILLER_174_270 VDD VSS sg13g2_decap_8
XFILLER_134_112 VDD VSS sg13g2_decap_8
XFILLER_174_281 VDD VSS sg13g2_decap_8
XFILLER_162_432 VDD VSS sg13g2_decap_8
XFILLER_163_955 VDD VSS sg13g2_fill_1
XFILLER_79_28 VDD VSS sg13g2_decap_8
XFILLER_123_808 VDD VSS sg13g2_decap_8
XFILLER_163_977 VDD VSS sg13g2_fill_1
X_08047_ _08047_/Y _08046_/B _08010_/B _08046_/Y VDD VSS sg13g2_o21ai_1
XFILLER_102_7 VDD VSS sg13g2_decap_8
XFILLER_116_860 VDD VSS sg13g2_decap_4
XFILLER_134_156 VDD VSS sg13g2_fill_1
XFILLER_163_988 VDD VSS sg13g2_decap_4
XFILLER_1_637 VDD VSS sg13g2_decap_8
XFILLER_143_690 VDD VSS sg13g2_decap_8
Xhold3020 input33/A mem_axi_rdata[7] VDD VSS sg13g2_dlygate4sd3_1
Xhold3031 hold3031/X input26/X VDD VSS sg13g2_dlygate4sd3_1
XFILLER_66_1175 VDD VSS sg13g2_decap_8
XFILLER_135_56 VDD VSS sg13g2_decap_8
XFILLER_153_1134 VDD VSS sg13g2_decap_8
Xhold3042 input2/A mem_axi_awready VDD VSS sg13g2_dlygate4sd3_1
XFILLER_88_243 VDD VSS sg13g2_decap_8
XFILLER_0_147 VDD VSS sg13g2_decap_8
Xhold3053 input10/A mem_axi_rdata[15] VDD VSS sg13g2_dlygate4sd3_1
XFILLER_27_1159 VDD VSS sg13g2_decap_8
X_14835__2874 _14835_/RESET_B VDD VSS sg13g2_tiehi
Xhold3064 _15191_/D _08717_/X VDD VSS sg13g2_dlygate4sd3_1
X_09998_ _14581_/D _10031_/A0 _14581_/Q _09999_/S VDD VSS sg13g2_mux2_1
Xhold3075 hold3075/X input28/X VDD VSS sg13g2_dlygate4sd3_1
XFILLER_114_1129 VDD VSS sg13g2_decap_4
Xhold3086 _15190_/D _08715_/X VDD VSS sg13g2_dlygate4sd3_1
XFILLER_95_49 VDD VSS sg13g2_decap_8
Xhold3097 hold3097/X _10211_/Y VDD VSS sg13g2_dlygate4sd3_1
X_08949_ _08949_/Y _10720_/A _14955_/Q VDD VSS sg13g2_nand2_1
XFILLER_28_21 VDD VSS sg13g2_decap_8
XFILLER_57_641 VDD VSS sg13g2_decap_4
X_11960_ _11960_/Y _11969_/A _14480_/Q VDD VSS sg13g2_nand2b_1
XFILLER_40_1359 VDD VSS sg13g2_decap_8
XFILLER_29_376 VDD VSS sg13g2_fill_1
XFILLER_57_696 VDD VSS sg13g2_decap_8
XFILLER_28_98 VDD VSS sg13g2_decap_8
XFILLER_151_77 VDD VSS sg13g2_decap_4
X_10911_ _10911_/Y _10910_/Y _10908_/Y _10907_/Y _11027_/B1 _13412_/C VDD VSS sg13g2_a221oi_1
XFILLER_72_622 VDD VSS sg13g2_decap_8
XFILLER_44_313 VDD VSS sg13g2_decap_4
XFILLER_72_633 VDD VSS sg13g2_fill_1
XFILLER_71_110 VDD VSS sg13g2_decap_4
X_11891_ _11891_/X _11891_/A _11900_/B VDD VSS sg13g2_and2_1
X_13630_ _13738_/D _13630_/A VDD VSS sg13g2_buf_1
XFILLER_71_143 VDD VSS sg13g2_fill_1
X_10842_ _10843_/B _10841_/A _10841_/C _10841_/B VDD VSS sg13g2_o21ai_1
XFILLER_13_700 VDD VSS sg13g2_decap_8
XFILLER_44_42 VDD VSS sg13g2_decap_8
XFILLER_32_519 VDD VSS sg13g2_decap_4
XFILLER_53_891 VDD VSS sg13g2_decap_8
XFILLER_25_582 VDD VSS sg13g2_decap_8
XFILLER_12_210 VDD VSS sg13g2_decap_8
X_13561_ _13561_/X _07911_/A _15009_/Q _13561_/S VDD VSS sg13g2_mux2_1
X_10773_ _11164_/A _14951_/Q _08943_/A _10772_/X VDD VSS sg13g2_a21oi_1
XFILLER_73_1168 VDD VSS sg13g2_fill_2
X_12512_ _12513_/B _13682_/Q _12763_/A2 _12511_/X _12415_/A _12624_/C1 VDD VSS sg13g2_a221oi_1
XFILLER_13_777 VDD VSS sg13g2_decap_8
XFILLER_8_203 VDD VSS sg13g2_decap_8
X_13492_ _15125_/D _13492_/A VDD VSS sg13g2_inv_1
XFILLER_157_237 VDD VSS sg13g2_decap_8
XFILLER_160_1149 VDD VSS sg13g2_decap_4
XFILLER_157_248 VDD VSS sg13g2_fill_2
XFILLER_12_287 VDD VSS sg13g2_decap_8
X_15231_ _15231_/Q clkload58/A _15231_/D _15231_/RESET_B VDD VSS sg13g2_dfrbpq_1
XFILLER_173_708 VDD VSS sg13g2_fill_2
X_12443_ _14995_/D _08203_/B _12443_/A2 _12442_/Y VDD VSS sg13g2_a21oi_1
XFILLER_154_900 VDD VSS sg13g2_decap_8
XFILLER_139_985 VDD VSS sg13g2_decap_8
XFILLER_166_771 VDD VSS sg13g2_fill_2
XFILLER_138_473 VDD VSS sg13g2_decap_8
XFILLER_139_996 VDD VSS sg13g2_fill_1
XFILLER_5_910 VDD VSS sg13g2_decap_8
X_15162_ _15162_/Q clkload70/A _15162_/D _15162_/RESET_B VDD VSS sg13g2_dfrbpq_1
X_12374_ _14990_/D _07913_/A _12443_/A2 _12373_/Y _12372_/Y VDD VSS sg13g2_a22oi_1
XFILLER_5_14 VDD VSS sg13g2_decap_8
XFILLER_4_420 VDD VSS sg13g2_decap_8
X_14113_ _14113_/Q _14681_/CLK _14113_/D _14113_/RESET_B VDD VSS sg13g2_dfrbpq_1
XFILLER_10_1141 VDD VSS sg13g2_decap_8
X_11325_ _11326_/A _11328_/S0 _14205_/Q _11325_/B1 VDD VSS sg13g2_a21oi_1
XFILLER_141_605 VDD VSS sg13g2_fill_1
X_15093_ _15093_/Q clkload69/A _15093_/D _15093_/RESET_B VDD VSS sg13g2_dfrbpq_1
XFILLER_84_1220 VDD VSS sg13g2_decap_4
XFILLER_5_987 VDD VSS sg13g2_decap_8
XFILLER_158_1089 VDD VSS sg13g2_decap_8
X_14044_ _14044_/Q clkload44/A _14044_/D _14044_/RESET_B VDD VSS sg13g2_dfrbpq_1
X_11256_ _11256_/Y _11251_/Y _11252_/Y _11266_/B VDD VSS sg13g2_a21oi_1
XFILLER_84_1242 VDD VSS sg13g2_fill_1
XFILLER_84_1253 VDD VSS sg13g2_decap_8
XFILLER_4_497 VDD VSS sg13g2_decap_8
XFILLER_122_841 VDD VSS sg13g2_fill_1
X_10207_ _10207_/Y hold3043/X _07661_/Y _14762_/Q VDD VSS sg13g2_a21oi_1
XFILLER_84_1286 VDD VSS sg13g2_decap_8
XFILLER_80_1117 VDD VSS sg13g2_decap_8
XFILLER_171_1234 VDD VSS sg13g2_decap_4
X_11187_ _11187_/Y _11171_/B _11181_/A _11197_/B VDD VSS sg13g2_a21oi_1
XFILLER_121_362 VDD VSS sg13g2_fill_2
XFILLER_132_1218 VDD VSS sg13g2_decap_8
X_10138_ _14715_/D _14715_/Q _10138_/A1 _10163_/S VDD VSS sg13g2_mux2_1
XFILLER_171_1278 VDD VSS sg13g2_decap_8
XFILLER_95_758 VDD VSS sg13g2_decap_8
XFILLER_94_246 VDD VSS sg13g2_decap_8
XFILLER_48_652 VDD VSS sg13g2_decap_8
X_14946_ _14946_/Q clkload42/A _14946_/D _14946_/RESET_B VDD VSS sg13g2_dfrbpq_1
X_10069_ _14650_/D _10102_/A0 _14650_/Q _10069_/S VDD VSS sg13g2_mux2_1
XFILLER_82_408 VDD VSS sg13g2_decap_8
XFILLER_78_1013 VDD VSS sg13g2_fill_2
XFILLER_36_825 VDD VSS sg13g2_decap_8
XFILLER_169_1141 VDD VSS sg13g2_decap_8
X_14877_ _14877_/Q clkload48/A _14877_/D _14877_/RESET_B VDD VSS sg13g2_dfrbpq_1
XFILLER_21_1281 VDD VSS sg13g2_decap_8
XFILLER_91_975 VDD VSS sg13g2_fill_1
X_13828_ _13828_/Q _14703_/CLK _13828_/D _13828_/RESET_B VDD VSS sg13g2_dfrbpq_1
XFILLER_56_1300 VDD VSS sg13g2_fill_1
XFILLER_16_560 VDD VSS sg13g2_decap_8
XFILLER_91_1202 VDD VSS sg13g2_decap_4
XFILLER_91_1235 VDD VSS sg13g2_decap_8
XFILLER_50_338 VDD VSS sg13g2_fill_1
X_13759_ _13759_/Q clkload9/A _13759_/D _13759_/RESET_B VDD VSS sg13g2_dfrbpq_1
XFILLER_31_530 VDD VSS sg13g2_decap_8
X_14034__2145 _14034_/RESET_B VDD VSS sg13g2_tiehi
XFILLER_31_596 VDD VSS sg13g2_decap_8
XFILLER_148_259 VDD VSS sg13g2_decap_8
XFILLER_164_719 VDD VSS sg13g2_decap_8
XFILLER_129_451 VDD VSS sg13g2_decap_8
XFILLER_145_900 VDD VSS sg13g2_decap_8
XFILLER_15_1085 VDD VSS sg13g2_decap_8
XFILLER_8_770 VDD VSS sg13g2_decap_8
XFILLER_102_1055 VDD VSS sg13g2_decap_8
XFILLER_116_123 VDD VSS sg13g2_decap_8
XFILLER_7_280 VDD VSS sg13g2_decap_8
Xclkbuf_leaf_2_clk_i _14667_/CLK clkbuf_leaf_2_clk_i/A VDD VSS sg13g2_buf_8
XFILLER_171_240 VDD VSS sg13g2_decap_8
XFILLER_144_498 VDD VSS sg13g2_decap_8
X_09921_ _14506_/D _14506_/Q _09921_/A1 _09931_/S VDD VSS sg13g2_mux2_1
XFILLER_63_1304 VDD VSS sg13g2_decap_4
Xfanout705 _11443_/A fanout706/X VDD VSS sg13g2_buf_1
Xfanout716 _12324_/B _11227_/S VDD VSS sg13g2_buf_1
Xfanout727 _12304_/B _12328_/B1 VDD VSS sg13g2_buf_1
X_09852_ _14439_/D _14439_/Q _09984_/A0 _09867_/S VDD VSS sg13g2_mux2_1
XFILLER_59_917 VDD VSS sg13g2_decap_8
XFILLER_113_874 VDD VSS sg13g2_fill_2
Xfanout738 _11043_/A _11188_/C1 VDD VSS sg13g2_buf_1
Xfanout749 _08138_/B fanout750/X VDD VSS sg13g2_buf_1
X_08803_ _08805_/A _10797_/A _14753_/Q _08727_/X _15196_/Q _13490_/B VDD VSS sg13g2_a221oi_1
XFILLER_112_395 VDD VSS sg13g2_decap_8
X_09783_ _14372_/D _09915_/A1 _14372_/Q _09800_/S VDD VSS sg13g2_mux2_1
XFILLER_86_758 VDD VSS sg13g2_decap_8
XFILLER_39_641 VDD VSS sg13g2_decap_4
XFILLER_6_1253 VDD VSS sg13g2_decap_8
X_08734_ _08734_/Y _13663_/Q _08775_/B VDD VSS sg13g2_nor2_1
XFILLER_38_140 VDD VSS sg13g2_decap_8
XFILLER_2_1106 VDD VSS sg13g2_decap_8
XFILLER_61_1094 VDD VSS sg13g2_fill_2
XFILLER_54_611 VDD VSS sg13g2_decap_4
X_14244__1935 _14244_/RESET_B VDD VSS sg13g2_tiehi
XFILLER_54_633 VDD VSS sg13g2_decap_8
XFILLER_121_14 VDD VSS sg13g2_decap_8
X_08665_ _08666_/B _08663_/X _08662_/Y _08678_/B _08664_/Y VDD VSS sg13g2_a22oi_1
XFILLER_93_290 VDD VSS sg13g2_decap_8
XFILLER_82_953 VDD VSS sg13g2_decap_8
XFILLER_96_1157 VDD VSS sg13g2_decap_8
X_07616_ _07616_/Y _14944_/Q VDD VSS sg13g2_inv_1
XFILLER_148_1247 VDD VSS sg13g2_decap_8
XFILLER_109_1209 VDD VSS sg13g2_decap_4
X_08596_ _15243_/D _08596_/A _08596_/B _08596_/C _08596_/D VDD VSS sg13g2_nand4_1
XFILLER_81_485 VDD VSS sg13g2_fill_1
XFILLER_81_496 VDD VSS sg13g2_decap_8
XFILLER_41_349 VDD VSS sg13g2_decap_8
XFILLER_10_714 VDD VSS sg13g2_decap_8
XFILLER_14_56 VDD VSS sg13g2_decap_8
XFILLER_167_546 VDD VSS sg13g2_decap_8
XFILLER_155_708 VDD VSS sg13g2_decap_8
X_09217_ _13828_/D _09750_/A1 _13828_/Q _09238_/S VDD VSS sg13g2_mux2_1
XFILLER_120_1100 VDD VSS sg13g2_decap_4
XFILLER_6_707 VDD VSS sg13g2_decap_8
X_09148_ _09148_/Y _09072_/B _15050_/Q _09147_/Y VDD VSS sg13g2_o21ai_1
XFILLER_5_217 VDD VSS sg13g2_decap_8
XFILLER_135_454 VDD VSS sg13g2_decap_8
XFILLER_159_1354 VDD VSS sg13g2_decap_4
X_09079_ _09079_/Y _09072_/B _15040_/Q _09078_/Y VDD VSS sg13g2_o21ai_1
XFILLER_68_1237 VDD VSS sg13g2_decap_8
XFILLER_108_679 VDD VSS sg13g2_decap_8
XFILLER_159_1365 VDD VSS sg13g2_fill_1
X_13732__2447 _13732_/RESET_B VDD VSS sg13g2_tiehi
XFILLER_30_77 VDD VSS sg13g2_decap_8
X_14492__1687 _14492_/RESET_B VDD VSS sg13g2_tiehi
X_11110_ _11110_/Y _11106_/Y _11104_/Y _11109_/Y VDD VSS sg13g2_a21oi_1
XFILLER_123_638 VDD VSS sg13g2_decap_8
XFILLER_2_924 VDD VSS sg13g2_decap_8
X_12090_ _12091_/B _12090_/A _14228_/Q VDD VSS sg13g2_nand2_1
XFILLER_123_649 VDD VSS sg13g2_fill_2
XFILLER_150_457 VDD VSS sg13g2_decap_8
XFILLER_1_434 VDD VSS sg13g2_decap_8
XFILLER_104_852 VDD VSS sg13g2_fill_2
X_11041_ _11068_/A _11052_/A _11052_/B _11052_/D VDD VSS sg13g2_nor3_1
XFILLER_118_1040 VDD VSS sg13g2_fill_2
XFILLER_150_468 VDD VSS sg13g2_fill_1
XFILLER_150_479 VDD VSS sg13g2_decap_8
XFILLER_39_42 VDD VSS sg13g2_decap_8
XFILLER_131_671 VDD VSS sg13g2_decap_8
XFILLER_162_21 VDD VSS sg13g2_decap_8
XFILLER_103_373 VDD VSS sg13g2_decap_8
X_14112__2067 _14112_/RESET_B VDD VSS sg13g2_tiehi
X_14800_ _14800_/Q _14867_/CLK _14800_/D _14800_/RESET_B VDD VSS sg13g2_dfrbpq_1
XFILLER_162_98 VDD VSS sg13g2_decap_8
X_12992_ _12994_/A _12993_/B _12993_/C VDD VSS sg13g2_nand2_1
XFILLER_40_1145 VDD VSS sg13g2_fill_2
XFILLER_73_931 VDD VSS sg13g2_decap_8
X_14731_ _14731_/Q clkload0/A _14731_/D _14731_/RESET_B VDD VSS sg13g2_dfrbpq_1
XFILLER_91_238 VDD VSS sg13g2_decap_4
XFILLER_29_173 VDD VSS sg13g2_decap_8
XFILLER_18_847 VDD VSS sg13g2_decap_8
X_11943_ _11943_/Y _11963_/S0 _14224_/Q _11690_/B VDD VSS sg13g2_a21oi_1
XFILLER_73_942 VDD VSS sg13g2_fill_2
XFILLER_17_357 VDD VSS sg13g2_decap_8
XFILLER_75_1219 VDD VSS sg13g2_decap_8
X_14662_ _14662_/Q _14662_/CLK _14662_/D _14662_/RESET_B VDD VSS sg13g2_dfrbpq_1
X_11874_ _11875_/A _14702_/Q _14734_/Q _13774_/Q _13806_/Q _12090_/A _12091_/C VDD
+ VSS sg13g2_mux4_1
XFILLER_33_828 VDD VSS sg13g2_decap_8
XFILLER_26_880 VDD VSS sg13g2_fill_1
X_13613_ _13613_/Y _13613_/A _13613_/B _13613_/C _13613_/D VDD VSS sg13g2_nor4_1
X_10825_ _14928_/D _14928_/Q _10837_/B _10824_/Y VDD VSS sg13g2_a21o_1
X_13980__2199 _13980_/RESET_B VDD VSS sg13g2_tiehi
X_14593_ _14593_/Q _14681_/CLK _14593_/D _14593_/RESET_B VDD VSS sg13g2_dfrbpq_1
X_13544_ _15146_/D _13543_/B _13542_/Y _13543_/Y VDD VSS sg13g2_a21oi_1
XFILLER_13_574 VDD VSS sg13g2_decap_8
X_10756_ _14916_/D _10756_/A VDD VSS sg13g2_inv_1
XFILLER_71_62 VDD VSS sg13g2_decap_4
XFILLER_125_1055 VDD VSS sg13g2_decap_8
XFILLER_146_719 VDD VSS sg13g2_fill_1
X_13475_ _15178_/D hold3050/X _15178_/Q _13477_/S VDD VSS sg13g2_mux2_1
XFILLER_9_567 VDD VSS sg13g2_decap_8
XFILLER_173_505 VDD VSS sg13g2_decap_8
XFILLER_127_911 VDD VSS sg13g2_decap_8
XFILLER_16_1372 VDD VSS sg13g2_decap_8
X_10687_ _10876_/A _08992_/B _10691_/S _08852_/Y VDD VSS sg13g2_a21oi_1
XFILLER_173_516 VDD VSS sg13g2_fill_2
XFILLER_16_1383 VDD VSS sg13g2_fill_1
X_13665__2542 _13665_/RESET_B VDD VSS sg13g2_tiehi
XFILLER_12_1225 VDD VSS sg13g2_decap_8
X_15214_ _15214_/Q _15214_/CLK _15214_/D _15214_/RESET_B VDD VSS sg13g2_dfrbpq_1
XFILLER_139_793 VDD VSS sg13g2_fill_1
X_12426_ _12426_/X _12423_/X _12422_/X _12419_/X _12418_/X _12760_/S0 _12553_/S VDD
+ VSS sg13g2_mux4_1
XFILLER_103_1353 VDD VSS sg13g2_fill_2
XFILLER_126_421 VDD VSS sg13g2_decap_4
XFILLER_65_7 VDD VSS sg13g2_decap_8
X_15145_ _15145_/Q clkload60/A _15145_/D _15145_/RESET_B VDD VSS sg13g2_dfrbpq_1
X_12357_ _12358_/B _12348_/A _15126_/Q VDD VSS sg13g2_nand2b_1
X_14322__1857 _14322_/RESET_B VDD VSS sg13g2_tiehi
XFILLER_5_784 VDD VSS sg13g2_decap_8
X_13708__2471 _13708_/RESET_B VDD VSS sg13g2_tiehi
X_14916__2712 _14916_/RESET_B VDD VSS sg13g2_tiehi
X_11308_ _11308_/Y _11310_/A1 _14077_/Q _11328_/S1 VDD VSS sg13g2_a21oi_1
X_15076_ _15076_/Q _15159_/CLK _15076_/D _15076_/RESET_B VDD VSS sg13g2_dfrbpq_1
X_12288_ _12288_/X _14265_/Q _14297_/Q _14329_/Q _14361_/Q _12288_/S0 _12288_/S1 VDD
+ VSS sg13g2_mux4_1
XFILLER_4_294 VDD VSS sg13g2_decap_8
X_14027_ _14027_/Q clkload1/A _14027_/D _14027_/RESET_B VDD VSS sg13g2_dfrbpq_1
XFILLER_84_1072 VDD VSS sg13g2_decap_8
X_11239_ _11239_/Y _11249_/A _15123_/Q _11340_/A1 VDD VSS sg13g2_o21ai_1
XFILLER_45_1034 VDD VSS sg13g2_decap_8
XFILLER_136_1151 VDD VSS sg13g2_decap_8
XFILLER_122_682 VDD VSS sg13g2_fill_2
XFILLER_110_833 VDD VSS sg13g2_decap_4
XFILLER_67_246 VDD VSS sg13g2_decap_8
X_14949__2646 _14949_/RESET_B VDD VSS sg13g2_tiehi
XFILLER_23_1321 VDD VSS sg13g2_decap_8
XFILLER_67_257 VDD VSS sg13g2_fill_2
XFILLER_110_888 VDD VSS sg13g2_decap_8
XFILLER_110_1302 VDD VSS sg13g2_fill_1
XFILLER_95_599 VDD VSS sg13g2_decap_8
X_14929_ _14929_/Q clkload61/A _14929_/D _14929_/RESET_B VDD VSS sg13g2_dfrbpq_1
XFILLER_64_942 VDD VSS sg13g2_fill_2
XFILLER_110_1357 VDD VSS sg13g2_fill_1
X_14791__2922 _14791_/RESET_B VDD VSS sg13g2_tiehi
XFILLER_64_975 VDD VSS sg13g2_decap_8
X_08450_ _08462_/A _07948_/A _08448_/Y _08449_/Y VDD VSS sg13g2_o21ai_1
XFILLER_64_986 VDD VSS sg13g2_fill_1
XFILLER_36_677 VDD VSS sg13g2_fill_1
XFILLER_1_1183 VDD VSS sg13g2_decap_8
X_08381_ _08381_/Y _08381_/A _08688_/D _08688_/A _08688_/B VDD VSS sg13g2_nand4_1
X_13810__2369 _13810_/RESET_B VDD VSS sg13g2_tiehi
XFILLER_91_1032 VDD VSS sg13g2_decap_8
XFILLER_91_0 VDD VSS sg13g2_decap_8
XFILLER_147_1280 VDD VSS sg13g2_decap_4
XFILLER_32_872 VDD VSS sg13g2_decap_8
XFILLER_108_1253 VDD VSS sg13g2_decap_8
XFILLER_104_1106 VDD VSS sg13g2_decap_8
XFILLER_104_1117 VDD VSS sg13g2_fill_1
XFILLER_17_1169 VDD VSS sg13g2_decap_8
X_15127__2705 _15127_/RESET_B VDD VSS sg13g2_tiehi
XFILLER_31_393 VDD VSS sg13g2_fill_2
XFILLER_30_1303 VDD VSS sg13g2_decap_8
X_09002_ _13761_/D _13761_/Q _10144_/A1 _09153_/S VDD VSS sg13g2_mux2_1
XFILLER_145_741 VDD VSS sg13g2_decap_8
XFILLER_117_465 VDD VSS sg13g2_decap_8
XFILLER_160_700 VDD VSS sg13g2_decap_8
XFILLER_105_638 VDD VSS sg13g2_fill_2
XFILLER_116_14 VDD VSS sg13g2_decap_8
XFILLER_28_1210 VDD VSS sg13g2_decap_8
XFILLER_120_608 VDD VSS sg13g2_decap_8
Xfanout502 _10194_/S _07989_/Y VDD VSS sg13g2_buf_1
X_09904_ _14490_/D _09937_/A1 _14490_/Q _09904_/S VDD VSS sg13g2_mux2_1
XFILLER_63_1112 VDD VSS sg13g2_decap_8
XFILLER_99_872 VDD VSS sg13g2_decap_8
XFILLER_67_1292 VDD VSS sg13g2_decap_8
XFILLER_101_800 VDD VSS sg13g2_decap_8
Xfanout524 _10870_/A _10691_/X VDD VSS sg13g2_buf_1
Xfanout535 _09111_/A1 _09117_/A VDD VSS sg13g2_buf_1
XFILLER_8_1337 VDD VSS sg13g2_decap_8
Xfanout546 _08818_/B _13482_/B VDD VSS sg13g2_buf_1
XFILLER_59_736 VDD VSS sg13g2_decap_8
Xfanout557 _08381_/A _08004_/Y VDD VSS sg13g2_buf_1
X_09835_ _14423_/D _09934_/A1 _14423_/Q _09837_/S VDD VSS sg13g2_mux2_1
XFILLER_28_1287 VDD VSS sg13g2_decap_8
XFILLER_100_321 VDD VSS sg13g2_decap_8
XFILLER_112_181 VDD VSS sg13g2_fill_2
Xfanout568 _12900_/A _13045_/A1 VDD VSS sg13g2_buf_1
XFILLER_100_332 VDD VSS sg13g2_fill_2
Xfanout579 _11433_/B _11904_/A2 VDD VSS sg13g2_buf_1
X_14477__1702 _14477_/RESET_B VDD VSS sg13g2_tiehi
XFILLER_74_706 VDD VSS sg13g2_decap_8
XFILLER_150_1159 VDD VSS sg13g2_fill_1
XFILLER_6_1050 VDD VSS sg13g2_decap_8
X_09766_ _14356_/D _14356_/Q _09898_/A0 _09766_/S VDD VSS sg13g2_mux2_1
XFILLER_67_780 VDD VSS sg13g2_decap_8
XFILLER_27_611 VDD VSS sg13g2_decap_8
XFILLER_27_622 VDD VSS sg13g2_fill_2
X_08717_ _08717_/X hold3063/X _15191_/Q _08721_/S VDD VSS sg13g2_mux2_1
X_09697_ _14289_/D _09928_/A1 _14289_/Q _09697_/S VDD VSS sg13g2_mux2_1
XFILLER_27_655 VDD VSS sg13g2_decap_8
XFILLER_148_1033 VDD VSS sg13g2_decap_4
X_08648_ _08662_/B _07867_/D _07960_/Y _07969_/D VDD VSS sg13g2_o21ai_1
XFILLER_54_463 VDD VSS sg13g2_fill_2
XFILLER_26_154 VDD VSS sg13g2_decap_8
XFILLER_109_1028 VDD VSS sg13g2_decap_4
X_08579_ _08579_/Y _08641_/D _08578_/Y _08667_/A1 VDD VSS sg13g2_a21oi_1
XFILLER_39_1372 VDD VSS sg13g2_decap_8
XFILLER_35_1203 VDD VSS sg13g2_fill_1
XFILLER_25_77 VDD VSS sg13g2_decap_8
X_14400__1779 _14400_/RESET_B VDD VSS sg13g2_tiehi
Xclkbuf_leaf_103_clk_i clkload39/A clkbuf_leaf_98_clk_i/A VDD VSS sg13g2_buf_8
X_10610_ _10611_/A _14879_/Q _14878_/Q _14877_/Q _10610_/D VDD VSS sg13g2_nand4_1
XFILLER_35_1225 VDD VSS sg13g2_fill_1
XFILLER_126_1342 VDD VSS sg13g2_fill_2
XFILLER_70_1116 VDD VSS sg13g2_decap_8
X_11590_ _11590_/Y _11591_/A _13682_/Q VDD VSS sg13g2_nor2_1
XFILLER_10_511 VDD VSS sg13g2_decap_8
XFILLER_70_1127 VDD VSS sg13g2_fill_2
XFILLER_22_371 VDD VSS sg13g2_decap_8
XFILLER_167_343 VDD VSS sg13g2_decap_8
XFILLER_70_1149 VDD VSS sg13g2_decap_8
X_10541_ _14862_/D _10566_/D _10547_/D _10540_/Y VDD VSS sg13g2_a21oi_1
XFILLER_41_21 VDD VSS sg13g2_decap_8
XFILLER_6_504 VDD VSS sg13g2_decap_8
XFILLER_157_21 VDD VSS sg13g2_decap_8
X_13260_ _13260_/Y _14861_/Q _13273_/B VDD VSS sg13g2_nand2_1
XFILLER_10_588 VDD VSS sg13g2_decap_8
X_10472_ _14845_/D _10492_/C _10490_/A _10472_/C VDD VSS sg13g2_nor3_1
X_13965__2214 _13965_/RESET_B VDD VSS sg13g2_tiehi
Xclkbuf_leaf_118_clk_i clkload13/A clkbuf_5_5__f_clk_i/X VDD VSS sg13g2_buf_8
XFILLER_109_977 VDD VSS sg13g2_decap_8
X_12211_ _12211_/X _14583_/Q _14615_/Q _14647_/Q _14679_/Q _12212_/S0 _12212_/S1 VDD
+ VSS sg13g2_mux4_1
XFILLER_108_454 VDD VSS sg13g2_decap_8
XFILLER_163_560 VDD VSS sg13g2_decap_8
X_13191_ _13191_/Y _13191_/A _13202_/A _13191_/C _13271_/C VDD VSS sg13g2_nand4_1
XFILLER_157_98 VDD VSS sg13g2_decap_8
XFILLER_108_487 VDD VSS sg13g2_decap_8
XFILLER_151_722 VDD VSS sg13g2_decap_8
X_12142_ _12143_/B _12133_/X _12134_/X _12139_/X _12140_/X _11549_/B _11559_/C VDD
+ VSS sg13g2_mux4_1
XFILLER_2_721 VDD VSS sg13g2_decap_8
XFILLER_155_1026 VDD VSS sg13g2_decap_4
XFILLER_111_608 VDD VSS sg13g2_decap_8
XFILLER_1_231 VDD VSS sg13g2_decap_8
XFILLER_173_42 VDD VSS sg13g2_decap_8
XFILLER_151_788 VDD VSS sg13g2_decap_4
X_12073_ _12073_/X _14707_/Q _14739_/Q _13779_/Q _13811_/Q _12073_/S0 _12073_/S1 VDD
+ VSS sg13g2_mux4_1
XFILLER_81_1223 VDD VSS sg13g2_decap_4
XFILLER_2_798 VDD VSS sg13g2_decap_8
X_11024_ _11064_/B _15118_/Q _11052_/A VDD VSS sg13g2_xnor2_1
X_16881_ _16881_/X _16881_/A VDD VSS sg13g2_buf_1
XFILLER_81_1289 VDD VSS sg13g2_fill_2
XFILLER_106_80 VDD VSS sg13g2_decap_8
XFILLER_106_91 VDD VSS sg13g2_fill_2
XFILLER_65_717 VDD VSS sg13g2_decap_4
XFILLER_92_514 VDD VSS sg13g2_fill_1
XFILLER_66_62 VDD VSS sg13g2_fill_1
X_12975_ _12975_/X _12988_/D _12975_/B VDD VSS sg13g2_xor2_1
XFILLER_18_644 VDD VSS sg13g2_decap_8
X_14714_ _14714_/Q _14746_/CLK _14714_/D _14714_/RESET_B VDD VSS sg13g2_dfrbpq_1
X_11926_ _11927_/B _11918_/X _11919_/X _11924_/X _11925_/X _11964_/B _11999_/S1 VDD
+ VSS sg13g2_mux4_1
XFILLER_17_154 VDD VSS sg13g2_decap_8
XFILLER_75_1016 VDD VSS sg13g2_decap_8
XFILLER_72_260 VDD VSS sg13g2_decap_8
XFILLER_73_794 VDD VSS sg13g2_fill_2
XFILLER_60_411 VDD VSS sg13g2_decap_8
X_14645_ _14645_/Q _14659_/CLK _14645_/D _14645_/RESET_B VDD VSS sg13g2_dfrbpq_1
X_11857_ _11857_/X _11849_/X _11850_/X _11853_/X _11854_/X _11763_/B _11625_/C VDD
+ VSS sg13g2_mux4_1
XFILLER_159_822 VDD VSS sg13g2_decap_8
XFILLER_14_861 VDD VSS sg13g2_decap_8
X_10808_ _10809_/B _12346_/A _10807_/B _10807_/C VDD VSS sg13g2_a21oi_1
XFILLER_92_1374 VDD VSS sg13g2_decap_4
XFILLER_20_308 VDD VSS sg13g2_decap_8
X_14576_ _14576_/Q _14672_/CLK _14576_/D _14576_/RESET_B VDD VSS sg13g2_dfrbpq_1
XFILLER_60_488 VDD VSS sg13g2_decap_8
X_11788_ _11788_/X _13963_/Q _13995_/Q _14027_/Q _14059_/Q _11848_/S0 _11851_/S1 VDD
+ VSS sg13g2_mux4_1
XFILLER_13_371 VDD VSS sg13g2_decap_8
XFILLER_14_1309 VDD VSS sg13g2_decap_8
XFILLER_158_354 VDD VSS sg13g2_decap_8
X_13527_ _13527_/Y _13527_/A _13535_/B VDD VSS sg13g2_nor2_1
XFILLER_174_803 VDD VSS sg13g2_decap_4
X_10739_ _11052_/B _07616_/Y _09079_/Y _10743_/S VDD VSS sg13g2_mux2_1
XFILLER_140_1339 VDD VSS sg13g2_decap_8
XFILLER_9_364 VDD VSS sg13g2_decap_8
XFILLER_158_398 VDD VSS sg13g2_fill_1
XFILLER_174_847 VDD VSS sg13g2_decap_4
XFILLER_12_1022 VDD VSS sg13g2_decap_8
X_13458_ _13458_/Y _13412_/B _13412_/C _07729_/B VDD VSS sg13g2_o21ai_1
XFILLER_174_869 VDD VSS sg13g2_fill_2
XFILLER_103_1161 VDD VSS sg13g2_decap_4
XFILLER_127_741 VDD VSS sg13g2_decap_4
X_14555__1624 _14555_/RESET_B VDD VSS sg13g2_tiehi
XFILLER_173_357 VDD VSS sg13g2_decap_8
XFILLER_115_903 VDD VSS sg13g2_fill_1
XFILLER_127_763 VDD VSS sg13g2_decap_8
X_12409_ _12409_/X _13727_/Q _14079_/Q _14431_/Q _14527_/Q _12507_/S0 _12507_/S1 VDD
+ VSS sg13g2_mux4_1
XFILLER_161_519 VDD VSS sg13g2_decap_8
XFILLER_103_1194 VDD VSS sg13g2_decap_8
XFILLER_138_1202 VDD VSS sg13g2_decap_8
X_13389_ _13389_/Y _13389_/A _13389_/B _13396_/C _13391_/C VDD VSS sg13g2_nor4_1
Xoutput105 mem_axi_wdata[10] _15142_/Q VDD VSS sg13g2_buf_1
Xoutput116 mem_axi_wdata[20] _15152_/Q VDD VSS sg13g2_buf_1
XFILLER_86_1145 VDD VSS sg13g2_decap_8
XFILLER_12_1099 VDD VSS sg13g2_decap_8
XFILLER_142_722 VDD VSS sg13g2_decap_8
Xoutput127 mem_axi_wdata[30] _15162_/Q VDD VSS sg13g2_buf_1
XFILLER_138_1224 VDD VSS sg13g2_decap_8
X_15128_ _15128_/Q _15183_/CLK _15128_/D _15128_/RESET_B VDD VSS sg13g2_dfrbpq_1
Xoutput138 mem_axi_wstrb[2] _15166_/Q VDD VSS sg13g2_buf_1
XFILLER_86_1156 VDD VSS sg13g2_fill_2
XFILLER_114_435 VDD VSS sg13g2_decap_8
XFILLER_138_1235 VDD VSS sg13g2_decap_8
XFILLER_142_744 VDD VSS sg13g2_decap_4
XFILLER_5_581 VDD VSS sg13g2_decap_8
XFILLER_173_1115 VDD VSS sg13g2_fill_2
Xclkbuf_leaf_82_clk_i _15064_/CLK clkbuf_leaf_82_clk_i/A VDD VSS sg13g2_buf_8
XFILLER_86_1189 VDD VSS sg13g2_fill_2
XFILLER_138_1279 VDD VSS sg13g2_decap_8
X_15059_ _15059_/Q _15064_/CLK _15059_/D _15059_/RESET_B VDD VSS sg13g2_dfrbpq_1
X_07950_ _07950_/Y _07950_/A _07950_/B _07950_/C VDD VSS sg13g2_nand3_1
XFILLER_123_980 VDD VSS sg13g2_fill_1
X_15156__2645 _15156_/RESET_B VDD VSS sg13g2_tiehi
XFILLER_96_842 VDD VSS sg13g2_decap_8
X_07881_ _08073_/A _08079_/S _13609_/A VDD VSS sg13g2_nand2_1
XFILLER_96_875 VDD VSS sg13g2_decap_8
X_09620_ _14216_/D _10084_/A0 _14216_/Q _09629_/S VDD VSS sg13g2_mux2_1
XFILLER_95_352 VDD VSS sg13g2_fill_1
Xclkbuf_leaf_97_clk_i clkload47/A clkbuf_leaf_97_clk_i/A VDD VSS sg13g2_buf_8
XFILLER_49_780 VDD VSS sg13g2_decap_8
X_09551_ _14149_/D _09949_/A1 _14149_/Q _09563_/S VDD VSS sg13g2_mux2_1
XFILLER_37_964 VDD VSS sg13g2_fill_1
XFILLER_3_1267 VDD VSS sg13g2_decap_8
XFILLER_23_1195 VDD VSS sg13g2_decap_8
X_08502_ _08502_/Y _07636_/Y _07821_/B _08434_/B _07829_/B _07950_/Y VDD VSS sg13g2_a221oi_1
XFILLER_97_1263 VDD VSS sg13g2_decap_8
XFILLER_58_1214 VDD VSS sg13g2_fill_2
XFILLER_52_901 VDD VSS sg13g2_fill_2
X_09482_ _14082_/D _10012_/A0 _14082_/Q _09502_/S VDD VSS sg13g2_mux2_1
XFILLER_93_1116 VDD VSS sg13g2_decap_8
Xclkbuf_leaf_20_clk_i _14660_/CLK clkbuf_leaf_22_clk_i/A VDD VSS sg13g2_buf_8
XFILLER_93_1127 VDD VSS sg13g2_fill_1
XFILLER_145_1217 VDD VSS sg13g2_fill_1
X_08433_ _08441_/A _07799_/X _08142_/A _08432_/Y _07798_/X _08431_/X VDD VSS sg13g2_a221oi_1
XFILLER_11_308 VDD VSS sg13g2_decap_8
XFILLER_23_168 VDD VSS sg13g2_decap_8
X_14755__2961 _14755_/RESET_B VDD VSS sg13g2_tiehi
X_08364_ _08373_/B _08637_/B _08363_/X _08361_/Y VDD VSS sg13g2_a21oi_1
XFILLER_32_680 VDD VSS sg13g2_decap_8
Xclkbuf_leaf_35_clk_i clkload21/A clkbuf_leaf_35_clk_i/A VDD VSS sg13g2_buf_8
X_08295_ _08295_/Y _08276_/A _08276_/B _08289_/Y VDD VSS sg13g2_o21ai_1
XFILLER_30_1100 VDD VSS sg13g2_decap_8
XFILLER_20_875 VDD VSS sg13g2_decap_8
XFILLER_109_229 VDD VSS sg13g2_fill_1
X_14194__1985 _14194_/RESET_B VDD VSS sg13g2_tiehi
XFILLER_34_1291 VDD VSS sg13g2_fill_2
XFILLER_164_357 VDD VSS sg13g2_decap_8
XFILLER_106_903 VDD VSS sg13g2_decap_8
XFILLER_118_763 VDD VSS sg13g2_decap_8
XFILLER_11_35 VDD VSS sg13g2_decap_8
XFILLER_106_914 VDD VSS sg13g2_decap_8
XFILLER_69_1343 VDD VSS sg13g2_decap_8
XFILLER_105_402 VDD VSS sg13g2_decap_8
XFILLER_3_518 VDD VSS sg13g2_decap_8
XFILLER_30_1177 VDD VSS sg13g2_decap_8
XFILLER_105_413 VDD VSS sg13g2_decap_8
XFILLER_117_273 VDD VSS sg13g2_decap_8
XFILLER_127_35 VDD VSS sg13g2_decap_8
XFILLER_133_733 VDD VSS sg13g2_fill_2
XFILLER_156_1324 VDD VSS sg13g2_decap_8
XFILLER_69_1376 VDD VSS sg13g2_decap_8
XFILLER_160_530 VDD VSS sg13g2_decap_8
XFILLER_160_541 VDD VSS sg13g2_fill_1
Xpicorv32_macro_1415 mem_axi_araddr[1] VDD VSS sg13g2_tielo
XFILLER_160_574 VDD VSS sg13g2_decap_4
XFILLER_120_416 VDD VSS sg13g2_decap_4
Xfanout310 _10093_/S _10098_/S VDD VSS sg13g2_buf_1
Xfanout1308 fanout1308/X fanout1316/X VDD VSS sg13g2_buf_1
XFILLER_28_1040 VDD VSS sg13g2_fill_1
Xfanout321 _09936_/S _09937_/S VDD VSS sg13g2_buf_1
Xfanout1319 _11353_/S _11358_/S0 VDD VSS sg13g2_buf_1
XFILLER_59_511 VDD VSS sg13g2_fill_1
Xfanout332 _09763_/S _09772_/S VDD VSS sg13g2_buf_1
Xfanout343 _09700_/S _09706_/S VDD VSS sg13g2_buf_1
XFILLER_8_1134 VDD VSS sg13g2_decap_8
XFILLER_119_1190 VDD VSS sg13g2_decap_8
Xfanout354 _09504_/S _09494_/S VDD VSS sg13g2_buf_1
XFILLER_28_1084 VDD VSS sg13g2_decap_8
Xfanout365 _09305_/S _09292_/S VDD VSS sg13g2_buf_1
Xfanout376 _09189_/S wire378/X VDD VSS sg13g2_buf_1
Xfanout387 _10078_/A0 _10045_/A0 VDD VSS sg13g2_buf_1
X_09818_ _14406_/D _09884_/A0 _14406_/Q _09829_/S VDD VSS sg13g2_mux2_1
XFILLER_101_674 VDD VSS sg13g2_decap_8
XFILLER_41_1240 VDD VSS sg13g2_decap_8
XFILLER_98_1049 VDD VSS sg13g2_decap_4
X_14900__2744 _14900_/RESET_B VDD VSS sg13g2_tiehi
X_09749_ _14339_/D _14339_/Q _09914_/A1 _09771_/S VDD VSS sg13g2_mux2_1
XFILLER_36_21 VDD VSS sg13g2_decap_8
XFILLER_41_1295 VDD VSS sg13g2_decap_8
XFILLER_27_463 VDD VSS sg13g2_decap_8
X_12760_ _12760_/X _12757_/X _12756_/X _12753_/X _12752_/X _12760_/S0 _12761_/S1 VDD
+ VSS sg13g2_mux4_1
X_14633__1546 _14633_/RESET_B VDD VSS sg13g2_tiehi
X_11711_ _11711_/X _14697_/Q _14729_/Q _13769_/Q _13801_/Q _11715_/S0 _11715_/S1 VDD
+ VSS sg13g2_mux4_1
XFILLER_36_98 VDD VSS sg13g2_decap_4
XFILLER_15_658 VDD VSS sg13g2_decap_8
X_12691_ _12691_/X _12683_/X _12687_/X _12682_/X _12686_/X _12761_/S1 _12760_/S0 VDD
+ VSS sg13g2_mux4_1
XFILLER_163_1339 VDD VSS sg13g2_decap_8
XFILLER_43_989 VDD VSS sg13g2_decap_8
XFILLER_42_466 VDD VSS sg13g2_decap_8
XFILLER_14_168 VDD VSS sg13g2_decap_8
X_14430_ _14430_/Q clkload36/A _14430_/D _14430_/RESET_B VDD VSS sg13g2_dfrbpq_1
X_14933__2678 _14933_/RESET_B VDD VSS sg13g2_tiehi
X_11642_ _11663_/B _11643_/B _11643_/A VDD VSS sg13g2_nand2_1
XFILLER_52_42 VDD VSS sg13g2_decap_8
XFILLER_156_803 VDD VSS sg13g2_decap_4
XFILLER_122_1003 VDD VSS sg13g2_decap_8
XFILLER_139_0 VDD VSS sg13g2_decap_8
XFILLER_161_1052 VDD VSS sg13g2_fill_2
XFILLER_167_140 VDD VSS sg13g2_decap_8
XFILLER_168_42 VDD VSS sg13g2_decap_8
X_14361_ _14361_/Q _14745_/CLK _14361_/D _14361_/RESET_B VDD VSS sg13g2_dfrbpq_1
X_11573_ _11573_/X _14565_/Q _14597_/Q _14629_/Q _14661_/Q _11925_/S0 _11925_/S1 VDD
+ VSS sg13g2_mux4_1
XFILLER_128_516 VDD VSS sg13g2_decap_4
XFILLER_161_1074 VDD VSS sg13g2_decap_8
XFILLER_11_875 VDD VSS sg13g2_decap_8
Xinput18 input18/X input18/A VDD VSS sg13g2_buf_1
X_13312_ _13312_/Y _13312_/A _15205_/Q VDD VSS sg13g2_nor2b_1
XFILLER_6_301 VDD VSS sg13g2_decap_8
Xinput29 input29/X input29/A VDD VSS sg13g2_buf_1
X_10524_ _10543_/C _10538_/A _10538_/B _10567_/A VDD VSS sg13g2_nor3_1
X_14292_ _14292_/Q clkload15/A _14292_/D _14292_/RESET_B VDD VSS sg13g2_dfrbpq_1
XFILLER_10_385 VDD VSS sg13g2_decap_8
XFILLER_7_868 VDD VSS sg13g2_decap_8
XFILLER_143_508 VDD VSS sg13g2_fill_2
XFILLER_108_240 VDD VSS sg13g2_fill_2
XFILLER_109_763 VDD VSS sg13g2_decap_8
X_13243_ _13243_/Y _13244_/B _13246_/C VDD VSS sg13g2_nand2_1
X_15001__2586 _15001_/RESET_B VDD VSS sg13g2_tiehi
X_10455_ _10455_/Y _14841_/Q _10462_/D _10619_/B VDD VSS sg13g2_o21ai_1
XFILLER_124_711 VDD VSS sg13g2_decap_8
XFILLER_6_378 VDD VSS sg13g2_decap_8
XFILLER_100_1345 VDD VSS sg13g2_fill_1
X_15196__2761 _15196_/RESET_B VDD VSS sg13g2_tiehi
X_13174_ _13174_/Y _13174_/A _13174_/B VDD VSS sg13g2_nor2_1
X_10386_ _14819_/D _10643_/A _10386_/B _10386_/C VDD VSS sg13g2_nor3_1
X_12125_ _14982_/D _12125_/A _12125_/B VDD VSS sg13g2_nor2_1
XFILLER_111_405 VDD VSS sg13g2_decap_4
XFILLER_123_265 VDD VSS sg13g2_fill_1
XFILLER_124_788 VDD VSS sg13g2_decap_8
X_15111__2737 _15111_/RESET_B VDD VSS sg13g2_tiehi
XFILLER_2_595 VDD VSS sg13g2_decap_8
XFILLER_137_1290 VDD VSS sg13g2_decap_8
X_12056_ _12056_/X _12056_/A _12056_/B _12056_/C VDD VSS sg13g2_and3_1
XFILLER_89_190 VDD VSS sg13g2_decap_4
XFILLER_46_1184 VDD VSS sg13g2_decap_8
XFILLER_28_7 VDD VSS sg13g2_decap_8
XFILLER_172_1181 VDD VSS sg13g2_fill_2
XFILLER_77_352 VDD VSS sg13g2_decap_8
XFILLER_46_1195 VDD VSS sg13g2_fill_2
X_11007_ _11010_/A _11007_/A _11007_/B VDD VSS sg13g2_or2_1
XFILLER_93_812 VDD VSS sg13g2_decap_8
XFILLER_65_503 VDD VSS sg13g2_decap_8
X_16864_ _16864_/X _16864_/A VDD VSS sg13g2_buf_1
XFILLER_92_300 VDD VSS sg13g2_decap_4
XFILLER_77_374 VDD VSS sg13g2_decap_8
XFILLER_65_514 VDD VSS sg13g2_fill_1
XFILLER_120_994 VDD VSS sg13g2_decap_8
XFILLER_93_845 VDD VSS sg13g2_decap_8
XFILLER_65_536 VDD VSS sg13g2_decap_8
XFILLER_20_1302 VDD VSS sg13g2_decap_8
XFILLER_19_931 VDD VSS sg13g2_decap_8
XFILLER_37_249 VDD VSS sg13g2_decap_8
XFILLER_18_441 VDD VSS sg13g2_decap_8
X_12958_ _12961_/C _14903_/Q _12942_/B _12945_/Y VDD VSS sg13g2_a21oi_1
XFILLER_20_1379 VDD VSS sg13g2_decap_4
XFILLER_93_93 VDD VSS sg13g2_decap_4
X_11909_ _11913_/A _11864_/Y _11908_/Y _11907_/X VDD VSS sg13g2_o21ai_1
XFILLER_33_433 VDD VSS sg13g2_decap_8
X_14609__1570 _14609_/RESET_B VDD VSS sg13g2_tiehi
X_12889_ _12889_/Y _12874_/A _12877_/C _12872_/X VDD VSS sg13g2_a21oi_1
X_14628_ _14628_/Q clkload23/A _14628_/D _14628_/RESET_B VDD VSS sg13g2_dfrbpq_1
XFILLER_60_263 VDD VSS sg13g2_decap_8
XFILLER_20_105 VDD VSS sg13g2_decap_8
XFILLER_18_1253 VDD VSS sg13g2_decap_8
XFILLER_14_1106 VDD VSS sg13g2_decap_8
XFILLER_158_140 VDD VSS sg13g2_decap_8
X_14559_ _14559_/Q _14733_/CLK _14559_/D _14559_/RESET_B VDD VSS sg13g2_dfrbpq_1
XFILLER_144_1294 VDD VSS sg13g2_fill_2
XFILLER_9_161 VDD VSS sg13g2_decap_8
XFILLER_140_1147 VDD VSS sg13g2_decap_4
X_08080_ _08080_/Y _08048_/A _08686_/A3 _08079_/S VDD VSS sg13g2_a21oi_1
XFILLER_174_666 VDD VSS sg13g2_decap_8
XFILLER_174_677 VDD VSS sg13g2_fill_1
XFILLER_173_154 VDD VSS sg13g2_decap_4
X_14071__2108 _14071_/RESET_B VDD VSS sg13g2_tiehi
XFILLER_162_839 VDD VSS sg13g2_decap_8
XFILLER_115_722 VDD VSS sg13g2_decap_8
XFILLER_54_0 VDD VSS sg13g2_decap_8
XFILLER_173_187 VDD VSS sg13g2_decap_8
XFILLER_161_338 VDD VSS sg13g2_decap_8
XFILLER_115_777 VDD VSS sg13g2_fill_2
XFILLER_130_714 VDD VSS sg13g2_decap_8
XFILLER_138_1065 VDD VSS sg13g2_decap_8
XFILLER_88_628 VDD VSS sg13g2_decap_8
XFILLER_130_725 VDD VSS sg13g2_fill_1
X_08982_ _08982_/Y _10681_/A _10674_/A _08981_/Y VDD VSS sg13g2_a21oi_1
X_14711__1468 _14711_/RESET_B VDD VSS sg13g2_tiehi
X_07933_ _07933_/Y _15002_/Q _07782_/A VDD VSS sg13g2_nor2b_1
XFILLER_116_1341 VDD VSS sg13g2_decap_8
XFILLER_64_1273 VDD VSS sg13g2_decap_8
XFILLER_111_950 VDD VSS sg13g2_fill_1
XFILLER_25_1246 VDD VSS sg13g2_decap_8
XFILLER_96_661 VDD VSS sg13g2_fill_1
XFILLER_56_503 VDD VSS sg13g2_decap_8
XFILLER_111_983 VDD VSS sg13g2_decap_4
X_07864_ _07864_/Y _08608_/A _08608_/B _08641_/C VDD VSS sg13g2_o21ai_1
XFILLER_84_823 VDD VSS sg13g2_decap_8
XFILLER_68_374 VDD VSS sg13g2_decap_8
XFILLER_3_91 VDD VSS sg13g2_decap_8
XFILLER_111_994 VDD VSS sg13g2_decap_4
XFILLER_68_385 VDD VSS sg13g2_fill_2
XFILLER_112_1238 VDD VSS sg13g2_decap_8
XFILLER_151_1287 VDD VSS sg13g2_fill_2
X_09603_ _14200_/D _14200_/Q _09636_/A0 _09603_/S VDD VSS sg13g2_mux2_1
XFILLER_28_249 VDD VSS sg13g2_decap_8
X_07795_ _07797_/D _07795_/A _08414_/C VDD VSS sg13g2_nand2_1
XFILLER_37_750 VDD VSS sg13g2_decap_8
X_09534_ _14133_/D _10031_/A0 _14133_/Q _09535_/S VDD VSS sg13g2_mux2_1
XFILLER_3_1064 VDD VSS sg13g2_decap_8
XFILLER_36_260 VDD VSS sg13g2_decap_8
XFILLER_24_411 VDD VSS sg13g2_decap_8
XFILLER_149_1161 VDD VSS sg13g2_decap_4
X_09465_ _14066_/D _09630_/A0 _14066_/Q _09473_/S VDD VSS sg13g2_mux2_1
XFILLER_169_427 VDD VSS sg13g2_decap_8
X_08416_ _08575_/A _08418_/B _08417_/B VDD VSS sg13g2_and2_1
XFILLER_11_105 VDD VSS sg13g2_decap_8
X_09396_ _13999_/D _09959_/A1 _13999_/Q _09398_/S VDD VSS sg13g2_mux2_1
XFILLER_138_803 VDD VSS sg13g2_decap_8
X_08347_ _08347_/Y _08381_/A _08336_/Y _08341_/Y _08637_/B _08346_/Y VDD VSS sg13g2_a221oi_1
XFILLER_132_7 VDD VSS sg13g2_decap_8
XFILLER_149_151 VDD VSS sg13g2_decap_8
XFILLER_137_324 VDD VSS sg13g2_decap_8
XFILLER_138_847 VDD VSS sg13g2_decap_4
XFILLER_71_1288 VDD VSS sg13g2_decap_8
XFILLER_71_1299 VDD VSS sg13g2_fill_2
XFILLER_20_672 VDD VSS sg13g2_decap_8
X_08278_ _08279_/A _08300_/A1 _08258_/C _07929_/B _08219_/A _13518_/A1 _13522_/A1
+ VDD VSS sg13g2_mux4_1
XFILLER_22_56 VDD VSS sg13g2_decap_8
XFILLER_138_56 VDD VSS sg13g2_decap_8
XFILLER_153_817 VDD VSS sg13g2_decap_8
XFILLER_164_154 VDD VSS sg13g2_decap_8
XFILLER_165_677 VDD VSS sg13g2_decap_8
XFILLER_4_805 VDD VSS sg13g2_decap_8
XFILLER_125_519 VDD VSS sg13g2_decap_4
XFILLER_146_880 VDD VSS sg13g2_decap_8
X_14047__2132 _14047_/RESET_B VDD VSS sg13g2_tiehi
XFILLER_3_315 VDD VSS sg13g2_decap_8
XFILLER_152_338 VDD VSS sg13g2_fill_1
X_10240_ _10250_/D _14775_/Q wire525/X VDD VSS sg13g2_and2_1
XFILLER_105_254 VDD VSS sg13g2_decap_8
X_10171_ _10178_/A _15054_/Q _10172_/A _14766_/Q _10171_/D VDD VSS sg13g2_or4_1
XFILLER_79_617 VDD VSS sg13g2_decap_8
XFILLER_105_265 VDD VSS sg13g2_fill_1
XFILLER_161_883 VDD VSS sg13g2_fill_1
XFILLER_133_585 VDD VSS sg13g2_decap_8
XFILLER_121_736 VDD VSS sg13g2_decap_8
XFILLER_156_1187 VDD VSS sg13g2_decap_4
Xfanout1105 _08620_/A3 _12061_/A VDD VSS sg13g2_buf_1
XFILLER_160_393 VDD VSS sg13g2_decap_8
Xfanout1116 _07821_/B _08510_/A1 VDD VSS sg13g2_buf_1
XFILLER_154_77 VDD VSS sg13g2_decap_8
Xfanout1127 _08487_/A3 _11798_/A VDD VSS sg13g2_buf_1
XFILLER_78_149 VDD VSS sg13g2_decap_4
Xfanout1138 _07782_/A _08405_/A1 VDD VSS sg13g2_buf_1
XFILLER_94_609 VDD VSS sg13g2_decap_8
Xfanout151 _10168_/A1 _09159_/Y VDD VSS sg13g2_buf_1
Xfanout1149 _11526_/A _08867_/A1 VDD VSS sg13g2_buf_1
Xfanout162 fanout162/X _09145_/Y VDD VSS sg13g2_buf_1
XFILLER_87_661 VDD VSS sg13g2_decap_8
XFILLER_59_352 VDD VSS sg13g2_decap_4
X_13930_ _13930_/Q clkload12/A _13930_/D _13930_/RESET_B VDD VSS sg13g2_dfrbpq_1
XFILLER_102_983 VDD VSS sg13g2_decap_8
Xfanout173 _10096_/A0 _10163_/A1 VDD VSS sg13g2_buf_1
Xfanout184 _10061_/A0 _09111_/Y VDD VSS sg13g2_buf_1
XFILLER_47_42 VDD VSS sg13g2_decap_8
XFILLER_170_21 VDD VSS sg13g2_decap_8
Xfanout195 _09926_/A1 _09091_/Y VDD VSS sg13g2_buf_1
XFILLER_19_238 VDD VSS sg13g2_decap_8
X_13861_ _13861_/Q _14725_/CLK _13861_/D _13861_/RESET_B VDD VSS sg13g2_dfrbpq_1
XFILLER_74_366 VDD VSS sg13g2_decap_8
XFILLER_47_97 VDD VSS sg13g2_decap_8
X_12812_ _15021_/D _13239_/A _12812_/B VDD VSS sg13g2_nor2_1
X_13792_ _13792_/Q clkload34/A _13792_/D _13792_/RESET_B VDD VSS sg13g2_dfrbpq_1
XFILLER_90_848 VDD VSS sg13g2_fill_1
XFILLER_170_98 VDD VSS sg13g2_decap_8
XFILLER_16_945 VDD VSS sg13g2_decap_8
X_15019__2568 _15019_/RESET_B VDD VSS sg13g2_tiehi
X_12743_ _12743_/X _13975_/Q _14007_/Q _14039_/Q _14071_/Q _12752_/S0 _12752_/S1 VDD
+ VSS sg13g2_mux4_1
X_15140__2677 _15140_/RESET_B VDD VSS sg13g2_tiehi
XFILLER_167_1272 VDD VSS sg13g2_fill_1
XFILLER_43_753 VDD VSS sg13g2_decap_8
XFILLER_15_455 VDD VSS sg13g2_decap_8
XFILLER_76_1166 VDD VSS sg13g2_decap_8
XFILLER_37_1117 VDD VSS sg13g2_decap_8
XFILLER_63_85 VDD VSS sg13g2_decap_8
X_12674_ _12674_/X _14130_/Q _14162_/Q _14194_/Q _14226_/Q _12674_/S0 _12674_/S1 VDD
+ VSS sg13g2_mux4_1
XFILLER_63_96 VDD VSS sg13g2_fill_1
XFILLER_42_274 VDD VSS sg13g2_fill_1
XFILLER_8_14 VDD VSS sg13g2_decap_8
X_14413_ _14413_/Q clkload10/A _14413_/D _14413_/RESET_B VDD VSS sg13g2_dfrbpq_1
X_14257__1922 _14257_/RESET_B VDD VSS sg13g2_tiehi
X_11625_ _11625_/Y _11623_/Y _11625_/B _11625_/C VDD VSS sg13g2_nand3b_1
XFILLER_50_1306 VDD VSS sg13g2_fill_2
XFILLER_129_847 VDD VSS sg13g2_decap_8
XFILLER_11_672 VDD VSS sg13g2_decap_8
XFILLER_128_324 VDD VSS sg13g2_fill_2
XFILLER_156_633 VDD VSS sg13g2_fill_1
X_14344_ _14344_/Q _14666_/CLK _14344_/D _14344_/RESET_B VDD VSS sg13g2_dfrbpq_1
X_11556_ _11556_/X _11549_/B _11555_/X _11554_/Y VDD VSS sg13g2_a21o_1
XFILLER_156_655 VDD VSS sg13g2_decap_8
XFILLER_10_182 VDD VSS sg13g2_decap_8
XFILLER_144_828 VDD VSS sg13g2_fill_2
X_10507_ _10509_/C _14852_/Q _14845_/Q _10514_/A _10507_/D VDD VSS sg13g2_nand4_1
XFILLER_7_665 VDD VSS sg13g2_decap_8
XFILLER_155_165 VDD VSS sg13g2_decap_8
X_14275_ _14275_/Q _14659_/CLK _14275_/D _14275_/RESET_B VDD VSS sg13g2_dfrbpq_1
X_14877__2790 _14877_/RESET_B VDD VSS sg13g2_tiehi
XFILLER_171_614 VDD VSS sg13g2_decap_8
X_11487_ _11487_/X _14690_/Q _14722_/Q _13762_/Q _13794_/Q _11493_/S0 _11493_/S1 VDD
+ VSS sg13g2_mux4_1
XFILLER_13_1183 VDD VSS sg13g2_decap_8
XFILLER_6_175 VDD VSS sg13g2_decap_8
XFILLER_155_198 VDD VSS sg13g2_decap_8
X_13226_ _13228_/B _13202_/B _13226_/B VDD VSS sg13g2_nand2b_1
X_10438_ _10441_/A _14835_/Q _10443_/D _14836_/Q VDD VSS sg13g2_a21o_1
XFILLER_48_1224 VDD VSS sg13g2_decap_4
XFILLER_112_703 VDD VSS sg13g2_fill_2
XFILLER_124_563 VDD VSS sg13g2_fill_1
XFILLER_170_168 VDD VSS sg13g2_decap_8
XFILLER_124_574 VDD VSS sg13g2_decap_8
XFILLER_152_883 VDD VSS sg13g2_decap_8
X_13157_ _13170_/D _14917_/Q _13670_/Q VDD VSS sg13g2_xnor2_1
X_10369_ _10370_/A _10400_/A _10400_/B _10400_/C VDD VSS sg13g2_nor3_1
XFILLER_48_1279 VDD VSS sg13g2_decap_8
XFILLER_3_882 VDD VSS sg13g2_decap_8
XFILLER_111_213 VDD VSS sg13g2_decap_4
XFILLER_97_436 VDD VSS sg13g2_fill_2
X_12108_ _12108_/X _12108_/A _12253_/B VDD VSS sg13g2_and2_1
XFILLER_69_138 VDD VSS sg13g2_decap_8
X_13088_ _13088_/X _13088_/A _13675_/Q VDD VSS sg13g2_and2_1
XFILLER_2_392 VDD VSS sg13g2_decap_8
XFILLER_84_108 VDD VSS sg13g2_decap_8
X_12039_ _12039_/Y _12040_/A1 _14194_/Q VDD VSS sg13g2_nand2b_1
XFILLER_93_620 VDD VSS sg13g2_decap_8
X_13745__2434 _13745_/RESET_B VDD VSS sg13g2_tiehi
XFILLER_65_322 VDD VSS sg13g2_fill_1
XFILLER_26_709 VDD VSS sg13g2_decap_8
XFILLER_168_1014 VDD VSS sg13g2_decap_8
XFILLER_4_1351 VDD VSS sg13g2_decap_8
XFILLER_81_826 VDD VSS sg13g2_decap_8
XFILLER_111_1260 VDD VSS sg13g2_fill_2
XFILLER_20_1176 VDD VSS sg13g2_decap_8
XFILLER_0_1248 VDD VSS sg13g2_decap_8
X_14125__2054 _14125_/RESET_B VDD VSS sg13g2_tiehi
X_09250_ _13859_/D _13859_/Q _09316_/A0 _09272_/S VDD VSS sg13g2_mux2_1
XFILLER_33_274 VDD VSS sg13g2_fill_1
XFILLER_167_909 VDD VSS sg13g2_decap_8
X_08201_ _08201_/Y _08201_/A wire660/X _08201_/C _08201_/D VDD VSS sg13g2_nor4_1
XFILLER_18_1050 VDD VSS sg13g2_decap_8
X_09181_ _13797_/D _13797_/Q _09318_/A0 _09193_/S VDD VSS sg13g2_mux2_1
XFILLER_21_469 VDD VSS sg13g2_decap_8
X_08132_ _08132_/X _08219_/A _08258_/C _07929_/B _08276_/A _13522_/A1 _13517_/A VDD
+ VSS sg13g2_mux4_1
XFILLER_105_1086 VDD VSS sg13g2_decap_8
XFILLER_147_677 VDD VSS sg13g2_fill_2
XFILLER_162_603 VDD VSS sg13g2_fill_1
XFILLER_119_379 VDD VSS sg13g2_decap_8
XFILLER_146_165 VDD VSS sg13g2_decap_8
XFILLER_147_688 VDD VSS sg13g2_fill_2
X_08063_ _08063_/Y _08063_/A _08063_/B VDD VSS sg13g2_nand2_1
X_13993__2186 _13993_/RESET_B VDD VSS sg13g2_tiehi
XFILLER_150_809 VDD VSS sg13g2_decap_8
XFILLER_161_168 VDD VSS sg13g2_decap_8
XFILLER_1_819 VDD VSS sg13g2_decap_8
XFILLER_103_714 VDD VSS sg13g2_decap_8
XFILLER_89_948 VDD VSS sg13g2_decap_8
XFILLER_0_329 VDD VSS sg13g2_decap_8
XFILLER_170_691 VDD VSS sg13g2_decap_8
XFILLER_153_1349 VDD VSS sg13g2_decap_8
X_08965_ wire405/A _09839_/C _09707_/B _10137_/B _09707_/C VDD VSS sg13g2_nor4_1
XFILLER_124_14 VDD VSS sg13g2_decap_8
XFILLER_25_1021 VDD VSS sg13g2_fill_1
XFILLER_64_1081 VDD VSS sg13g2_decap_8
X_07916_ _07916_/Y _07914_/Y _07904_/C _07878_/Y VDD VSS sg13g2_o21ai_1
XFILLER_25_1043 VDD VSS sg13g2_decap_8
XFILLER_69_683 VDD VSS sg13g2_fill_2
XFILLER_111_780 VDD VSS sg13g2_fill_2
X_08896_ _13707_/D _16869_/A _08895_/X _08932_/S VDD VSS sg13g2_mux2_1
XFILLER_9_1295 VDD VSS sg13g2_decap_8
XFILLER_5_1148 VDD VSS sg13g2_decap_8
X_14335__1844 _14335_/RESET_B VDD VSS sg13g2_tiehi
X_07847_ _07847_/Y _08678_/B _08678_/C _08678_/A VDD VSS sg13g2_a21oi_1
XFILLER_83_141 VDD VSS sg13g2_decap_8
XFILLER_72_815 VDD VSS sg13g2_fill_1
XFILLER_99_1177 VDD VSS sg13g2_decap_8
XFILLER_112_1079 VDD VSS sg13g2_decap_8
XFILLER_147_1109 VDD VSS sg13g2_decap_8
X_07778_ _08318_/D _08276_/A _08276_/B VDD VSS sg13g2_xor2_1
XFILLER_17_56 VDD VSS sg13g2_decap_8
XFILLER_140_35 VDD VSS sg13g2_decap_8
X_09517_ _14116_/D _09517_/A0 _14116_/Q _09535_/S VDD VSS sg13g2_mux2_1
XFILLER_71_347 VDD VSS sg13g2_decap_8
XFILLER_25_742 VDD VSS sg13g2_decap_8
XFILLER_140_68 VDD VSS sg13g2_decap_4
XFILLER_24_252 VDD VSS sg13g2_decap_8
XFILLER_169_224 VDD VSS sg13g2_decap_8
X_09448_ _14049_/D _09448_/A0 _14049_/Q _09469_/S VDD VSS sg13g2_mux2_1
XFILLER_158_909 VDD VSS sg13g2_fill_1
XFILLER_52_583 VDD VSS sg13g2_fill_2
XFILLER_13_959 VDD VSS sg13g2_decap_8
XFILLER_12_469 VDD VSS sg13g2_decap_8
X_15082__2829 _15082_/RESET_B VDD VSS sg13g2_tiehi
X_09379_ _13982_/D _09610_/A0 _13982_/Q _09401_/S VDD VSS sg13g2_mux2_1
XFILLER_71_1041 VDD VSS sg13g2_decap_8
XFILLER_33_77 VDD VSS sg13g2_decap_8
XFILLER_138_622 VDD VSS sg13g2_decap_4
X_11410_ _11410_/Y _11804_/A _14495_/Q _11802_/B VDD VSS sg13g2_a21oi_1
XFILLER_71_1085 VDD VSS sg13g2_fill_2
X_12390_ _12390_/X _13822_/Q _13854_/Q _13886_/Q _13918_/Q _12396_/S0 _12396_/S1 VDD
+ VSS sg13g2_mux4_1
XFILLER_165_441 VDD VSS sg13g2_decap_8
XFILLER_32_1047 VDD VSS sg13g2_decap_8
XFILLER_149_99 VDD VSS sg13g2_decap_8
XFILLER_123_1186 VDD VSS sg13g2_fill_2
XFILLER_166_986 VDD VSS sg13g2_fill_1
X_11341_ _14959_/D _11335_/A _11341_/A2 _11340_/Y VDD VSS sg13g2_a21o_1
XFILLER_138_699 VDD VSS sg13g2_decap_8
XFILLER_4_602 VDD VSS sg13g2_decap_8
XFILLER_10_1323 VDD VSS sg13g2_decap_8
XFILLER_125_316 VDD VSS sg13g2_decap_8
X_13823__2356 _13823_/RESET_B VDD VSS sg13g2_tiehi
XFILLER_165_21 VDD VSS sg13g2_decap_8
X_14583__1596 _14583_/RESET_B VDD VSS sg13g2_tiehi
X_14060_ _14060_/Q clkload14/A _14060_/D _14060_/RESET_B VDD VSS sg13g2_dfrbpq_1
XFILLER_3_112 VDD VSS sg13g2_decap_8
X_11272_ _11272_/Y _11275_/S0 _14460_/Q VDD VSS sg13g2_nand2b_1
X_13011_ _13012_/A _13009_/A _13010_/B _13308_/A VDD VSS sg13g2_o21ai_1
XFILLER_4_679 VDD VSS sg13g2_decap_8
X_10223_ _14769_/D _14769_/Q _10219_/X _10222_/Y VDD VSS sg13g2_a21oi_1
XFILLER_133_360 VDD VSS sg13g2_decap_8
XFILLER_165_98 VDD VSS sg13g2_decap_8
XFILLER_106_596 VDD VSS sg13g2_decap_8
XFILLER_3_189 VDD VSS sg13g2_decap_8
X_10154_ _14731_/D _14731_/Q _10154_/A1 _10160_/S VDD VSS sg13g2_mux2_1
XFILLER_95_918 VDD VSS sg13g2_decap_4
XFILLER_0_863 VDD VSS sg13g2_decap_8
XFILLER_47_1290 VDD VSS sg13g2_fill_2
X_14962_ _14962_/Q _15228_/CLK _14962_/D _14962_/RESET_B VDD VSS sg13g2_dfrbpq_1
X_10085_ _14665_/D _10085_/A0 _14665_/Q _10101_/S VDD VSS sg13g2_mux2_1
XFILLER_169_1312 VDD VSS sg13g2_decap_4
X_13913_ _13913_/Q _14745_/CLK _13913_/D _13913_/RESET_B VDD VSS sg13g2_dfrbpq_1
X_14893_ _14893_/Q _14894_/CLK _14893_/D _14893_/RESET_B VDD VSS sg13g2_dfrbpq_1
XFILLER_48_878 VDD VSS sg13g2_decap_8
XFILLER_74_152 VDD VSS sg13g2_decap_8
XFILLER_169_1345 VDD VSS sg13g2_decap_8
X_13844_ _13844_/Q _14516_/CLK _13844_/D _13844_/RESET_B VDD VSS sg13g2_dfrbpq_1
XFILLER_47_399 VDD VSS sg13g2_decap_8
XFILLER_16_742 VDD VSS sg13g2_decap_8
X_13775_ _13775_/Q _14703_/CLK _13775_/D _13775_/RESET_B VDD VSS sg13g2_dfrbpq_1
XFILLER_50_509 VDD VSS sg13g2_fill_2
X_10987_ _10987_/Y _10987_/A _11021_/B VDD VSS sg13g2_nand2_1
XFILLER_62_369 VDD VSS sg13g2_decap_4
XFILLER_15_252 VDD VSS sg13g2_decap_8
XFILLER_71_870 VDD VSS sg13g2_decap_4
X_12726_ _12726_/X _14134_/Q _14166_/Q _14198_/Q _14230_/Q _12727_/S0 _12727_/S1 VDD
+ VSS sg13g2_mux4_1
XFILLER_95_7 VDD VSS sg13g2_decap_8
XFILLER_70_380 VDD VSS sg13g2_decap_8
XFILLER_130_90 VDD VSS sg13g2_decap_4
X_12657_ _12657_/X _13969_/Q _14001_/Q _14033_/Q _14065_/Q _12661_/S0 _12661_/S1 VDD
+ VSS sg13g2_mux4_1
XFILLER_169_780 VDD VSS sg13g2_fill_2
Xclkbuf_5_19__f_clk_i clkbuf_leaf_77_clk_i/A clkbuf_4_9_0_clk_i/X VDD VSS sg13g2_buf_16
X_11608_ _11608_/X _11608_/A _11973_/B VDD VSS sg13g2_and2_1
XFILLER_128_121 VDD VSS sg13g2_decap_8
XFILLER_156_430 VDD VSS sg13g2_fill_2
X_12588_ _12588_/X _14252_/Q _14284_/Q _14316_/Q _14348_/Q _12592_/S0 _12592_/S1 VDD
+ VSS sg13g2_mux4_1
XFILLER_8_952 VDD VSS sg13g2_decap_8
XFILLER_89_1313 VDD VSS sg13g2_decap_8
XFILLER_157_975 VDD VSS sg13g2_decap_8
XFILLER_15_1267 VDD VSS sg13g2_decap_8
XFILLER_172_901 VDD VSS sg13g2_fill_1
X_14327_ _14327_/Q _15015_/CLK _14327_/D _14327_/RESET_B VDD VSS sg13g2_dfrbpq_1
X_11539_ _11539_/Y _11531_/A _14660_/Q _12023_/B VDD VSS sg13g2_a21oi_1
XFILLER_7_462 VDD VSS sg13g2_decap_8
XFILLER_128_176 VDD VSS sg13g2_decap_8
XFILLER_89_1357 VDD VSS sg13g2_decap_4
XFILLER_171_411 VDD VSS sg13g2_decap_8
XFILLER_144_636 VDD VSS sg13g2_decap_8
XFILLER_89_1379 VDD VSS sg13g2_fill_1
X_14413__1766 _14413_/RESET_B VDD VSS sg13g2_tiehi
X_14258_ _14258_/Q _14632_/CLK _14258_/D _14258_/RESET_B VDD VSS sg13g2_dfrbpq_1
XFILLER_99_70 VDD VSS sg13g2_fill_2
X_13209_ _13209_/Y _13206_/Y _13207_/Y _13208_/Y VDD VSS sg13g2_a21oi_1
XFILLER_48_1032 VDD VSS sg13g2_decap_8
XFILLER_125_883 VDD VSS sg13g2_decap_8
XFILLER_87_1092 VDD VSS sg13g2_fill_2
XFILLER_48_1043 VDD VSS sg13g2_fill_2
XFILLER_171_488 VDD VSS sg13g2_decap_8
XFILLER_135_1002 VDD VSS sg13g2_fill_2
X_14189_ _14189_/Q clkload3/A _14189_/D _14189_/RESET_B VDD VSS sg13g2_dfrbpq_1
XFILLER_135_1013 VDD VSS sg13g2_decap_8
XFILLER_152_680 VDD VSS sg13g2_fill_2
XFILLER_97_211 VDD VSS sg13g2_decap_8
XFILLER_174_1062 VDD VSS sg13g2_decap_4
Xfanout909 _13300_/A _13308_/A VDD VSS sg13g2_buf_1
XFILLER_140_853 VDD VSS sg13g2_decap_8
XFILLER_112_555 VDD VSS sg13g2_decap_8
X_13978__2201 _13978_/RESET_B VDD VSS sg13g2_tiehi
X_08750_ _13668_/D _08765_/A1 _08748_/Y _08749_/Y VDD VSS sg13g2_a21oi_1
XFILLER_38_311 VDD VSS sg13g2_fill_1
XFILLER_22_1205 VDD VSS sg13g2_decap_8
X_07701_ _07705_/C _15085_/Q _07701_/B VDD VSS sg13g2_nand2_1
XFILLER_17_0 VDD VSS sg13g2_decap_8
XFILLER_61_1287 VDD VSS sg13g2_decap_4
XFILLER_38_333 VDD VSS sg13g2_decap_8
X_08681_ _08681_/Y _08698_/B _08681_/B VDD VSS sg13g2_nor2_1
XFILLER_54_815 VDD VSS sg13g2_fill_2
XFILLER_94_995 VDD VSS sg13g2_decap_8
X_07632_ _08203_/A _07888_/B VDD VSS sg13g2_inv_1
XFILLER_80_100 VDD VSS sg13g2_fill_1
XFILLER_53_314 VDD VSS sg13g2_fill_1
XFILLER_38_388 VDD VSS sg13g2_decap_8
XFILLER_93_494 VDD VSS sg13g2_decap_8
XFILLER_38_399 VDD VSS sg13g2_fill_1
XFILLER_53_336 VDD VSS sg13g2_fill_1
XFILLER_0_70 VDD VSS sg13g2_decap_8
XFILLER_0_1045 VDD VSS sg13g2_decap_8
XFILLER_111_1090 VDD VSS sg13g2_fill_2
X_13901__2278 _13901_/RESET_B VDD VSS sg13g2_tiehi
X_09302_ _13910_/D _13910_/Q _09768_/A1 _09305_/S VDD VSS sg13g2_mux2_1
XFILLER_80_166 VDD VSS sg13g2_decap_8
XFILLER_59_1194 VDD VSS sg13g2_decap_4
XFILLER_34_572 VDD VSS sg13g2_fill_2
XFILLER_55_1036 VDD VSS sg13g2_decap_8
XFILLER_55_1047 VDD VSS sg13g2_fill_2
XFILLER_22_745 VDD VSS sg13g2_decap_8
X_09233_ _13844_/D _09931_/A1 _13844_/Q _09233_/S VDD VSS sg13g2_mux2_1
XFILLER_33_1323 VDD VSS sg13g2_decap_8
XFILLER_21_266 VDD VSS sg13g2_decap_8
XFILLER_148_942 VDD VSS sg13g2_fill_2
XFILLER_166_238 VDD VSS sg13g2_decap_8
X_09164_ _09164_/X _14923_/Q _13245_/A _09164_/C _09164_/D VDD VSS sg13g2_and4_1
XFILLER_119_14 VDD VSS sg13g2_decap_8
X_08115_ _08115_/Y _13427_/C _08115_/B VDD VSS sg13g2_nor2_1
XFILLER_120_1337 VDD VSS sg13g2_fill_2
XFILLER_119_176 VDD VSS sg13g2_decap_4
X_15198__2753 _15198_/RESET_B VDD VSS sg13g2_tiehi
X_09095_ _09097_/B _09103_/C _09103_/D _14915_/Q VDD VSS sg13g2_a21oi_1
XFILLER_135_636 VDD VSS sg13g2_decap_8
XFILLER_162_411 VDD VSS sg13g2_decap_8
X_08046_ _08046_/Y _12278_/A _08046_/B VDD VSS sg13g2_nand2b_1
XFILLER_135_669 VDD VSS sg13g2_decap_4
XFILLER_116_883 VDD VSS sg13g2_decap_8
XFILLER_150_628 VDD VSS sg13g2_decap_8
XFILLER_162_488 VDD VSS sg13g2_decap_8
XFILLER_1_616 VDD VSS sg13g2_decap_8
XFILLER_118_1222 VDD VSS sg13g2_decap_8
XFILLER_66_1154 VDD VSS sg13g2_decap_8
XFILLER_135_35 VDD VSS sg13g2_decap_8
XFILLER_153_1113 VDD VSS sg13g2_decap_8
XFILLER_0_126 VDD VSS sg13g2_decap_8
Xhold3021 hold3021/X input33/X VDD VSS sg13g2_dlygate4sd3_1
XFILLER_89_756 VDD VSS sg13g2_decap_8
XFILLER_88_222 VDD VSS sg13g2_decap_8
XFILLER_131_853 VDD VSS sg13g2_decap_8
XFILLER_157_1293 VDD VSS sg13g2_decap_8
Xhold3032 input4/A mem_axi_rdata[0] VDD VSS sg13g2_dlygate4sd3_1
XFILLER_62_1018 VDD VSS sg13g2_decap_8
Xhold3043 hold3043/X input2/X VDD VSS sg13g2_dlygate4sd3_1
XFILLER_27_1138 VDD VSS sg13g2_decap_8
XFILLER_103_555 VDD VSS sg13g2_decap_8
Xhold3054 hold3054/X input10/X VDD VSS sg13g2_dlygate4sd3_1
X_09997_ _14580_/D _10096_/A0 _14580_/Q _09997_/S VDD VSS sg13g2_mux2_1
XFILLER_77_918 VDD VSS sg13g2_fill_1
Xhold3065 input25/A mem_axi_rdata[29] VDD VSS sg13g2_dlygate4sd3_1
XFILLER_95_28 VDD VSS sg13g2_decap_8
X_14568__1611 _14568_/RESET_B VDD VSS sg13g2_tiehi
Xhold3076 input22/A mem_axi_rdata[26] VDD VSS sg13g2_dlygate4sd3_1
Xhold3087 input11/A mem_axi_rdata[16] VDD VSS sg13g2_dlygate4sd3_1
X_08948_ _08948_/Y _10776_/C _10793_/B _15051_/Q VDD VSS sg13g2_nand3_1
Xhold3098 _13616_/A _13724_/Q VDD VSS sg13g2_dlygate4sd3_1
XFILLER_9_1092 VDD VSS sg13g2_decap_8
XFILLER_29_333 VDD VSS sg13g2_decap_8
XFILLER_29_344 VDD VSS sg13g2_fill_1
X_08879_ _08879_/X _08878_/X _11635_/A _08891_/S VDD VSS sg13g2_mux2_1
XFILLER_28_77 VDD VSS sg13g2_decap_8
XFILLER_151_56 VDD VSS sg13g2_decap_8
XFILLER_57_675 VDD VSS sg13g2_decap_8
X_10910_ _10910_/Y _10936_/A _10936_/D _11027_/B1 VDD VSS sg13g2_a21oi_1
X_11890_ _11891_/A _14254_/Q _14286_/Q _14318_/Q _14350_/Q _11893_/S _11897_/C VDD
+ VSS sg13g2_mux4_1
XFILLER_17_539 VDD VSS sg13g2_decap_8
XFILLER_44_336 VDD VSS sg13g2_decap_8
X_10841_ _10841_/Y _10841_/A _10841_/B _10841_/C VDD VSS sg13g2_nor3_1
XFILLER_44_21 VDD VSS sg13g2_decap_8
XFILLER_38_1212 VDD VSS sg13g2_decap_8
XFILLER_53_870 VDD VSS sg13g2_decap_8
X_13560_ _15151_/D _15151_/Q _13559_/Y _13565_/S VDD VSS sg13g2_mux2_1
XFILLER_77_1294 VDD VSS sg13g2_decap_8
X_10772_ _10772_/X _10772_/A _10781_/B _10776_/C VDD VSS sg13g2_and3_1
XFILLER_129_1373 VDD VSS sg13g2_fill_2
XFILLER_125_1215 VDD VSS sg13g2_fill_2
XFILLER_13_756 VDD VSS sg13g2_decap_8
XFILLER_164_1275 VDD VSS sg13g2_decap_8
X_12511_ _12511_/X _12510_/X _12509_/X _12664_/S VDD VSS sg13g2_mux2_1
XFILLER_38_1289 VDD VSS sg13g2_decap_8
X_13491_ _13492_/A _15125_/Q _13440_/A _13414_/Y _15129_/Q _13490_/Y VDD VSS sg13g2_a221oi_1
XFILLER_12_266 VDD VSS sg13g2_decap_8
X_15230_ _15230_/Q _15247_/CLK _15230_/D _15230_/RESET_B VDD VSS sg13g2_dfrbpq_1
XFILLER_9_749 VDD VSS sg13g2_decap_8
X_12442_ _12442_/Y _13687_/Q _12358_/Y _12441_/X _12791_/B2 _12443_/A2 VDD VSS sg13g2_a221oi_1
XFILLER_100_93 VDD VSS sg13g2_decap_8
XFILLER_60_42 VDD VSS sg13g2_fill_2
X_14670__1509 _14670_/RESET_B VDD VSS sg13g2_tiehi
XFILLER_121_0 VDD VSS sg13g2_decap_8
XFILLER_8_259 VDD VSS sg13g2_decap_8
X_15161_ _15161_/Q clkload70/A _15161_/D _15161_/RESET_B VDD VSS sg13g2_dfrbpq_1
XFILLER_60_75 VDD VSS sg13g2_decap_4
X_12373_ _12373_/Y _12346_/A _12348_/A _12777_/A2 _12836_/B _13282_/A1 VDD VSS sg13g2_a221oi_1
XFILLER_60_97 VDD VSS sg13g2_decap_4
XFILLER_10_1120 VDD VSS sg13g2_decap_8
XFILLER_126_647 VDD VSS sg13g2_decap_8
X_14112_ _14112_/Q clkload29/A _14112_/D _14112_/RESET_B VDD VSS sg13g2_dfrbpq_1
X_11324_ _11326_/B _11328_/S0 _14173_/Q VDD VSS sg13g2_nand2b_1
X_15092_ _15092_/Q clkload67/A _15092_/D _15092_/RESET_B VDD VSS sg13g2_dfrbpq_1
XFILLER_153_455 VDD VSS sg13g2_fill_2
XFILLER_5_966 VDD VSS sg13g2_decap_8
XFILLER_125_157 VDD VSS sg13g2_fill_1
XFILLER_158_1068 VDD VSS sg13g2_decap_8
X_14043_ _14043_/Q _14653_/CLK _14043_/D _14043_/RESET_B VDD VSS sg13g2_dfrbpq_1
XFILLER_84_1232 VDD VSS sg13g2_fill_1
X_11255_ _11255_/Y _11255_/A _11255_/B VDD VSS sg13g2_nand2_1
XFILLER_4_476 VDD VSS sg13g2_decap_8
XFILLER_10_1197 VDD VSS sg13g2_decap_8
XFILLER_45_1205 VDD VSS sg13g2_decap_8
XFILLER_84_1265 VDD VSS sg13g2_fill_1
XFILLER_136_1344 VDD VSS sg13g2_decap_8
X_10206_ _14761_/D _15200_/D _11061_/A2 _13346_/A VDD VSS sg13g2_mux2_1
XFILLER_79_233 VDD VSS sg13g2_decap_8
XFILLER_122_864 VDD VSS sg13g2_decap_8
X_11186_ _11186_/Y _11186_/A _11186_/B VDD VSS sg13g2_nand2_1
XFILLER_122_875 VDD VSS sg13g2_fill_1
XFILLER_68_929 VDD VSS sg13g2_decap_8
X_10137_ _10169_/S _15065_/Q _10137_/B _10137_/C VDD VSS sg13g2_nor3_1
XFILLER_94_214 VDD VSS sg13g2_fill_1
XFILLER_10_7 VDD VSS sg13g2_decap_8
X_14945_ _14945_/Q clkload42/A _14945_/D _14945_/RESET_B VDD VSS sg13g2_dfrbpq_1
X_10068_ _14649_/D _10068_/A0 _14649_/Q _10068_/S VDD VSS sg13g2_mux2_1
XFILLER_85_61 VDD VSS sg13g2_fill_1
XFILLER_169_1120 VDD VSS sg13g2_decap_8
XFILLER_85_83 VDD VSS sg13g2_decap_8
XFILLER_75_461 VDD VSS sg13g2_fill_1
XFILLER_76_995 VDD VSS sg13g2_decap_8
XFILLER_63_612 VDD VSS sg13g2_decap_8
XFILLER_47_174 VDD VSS sg13g2_decap_8
X_14876_ _14876_/Q clkload48/A _14876_/D _14876_/RESET_B VDD VSS sg13g2_dfrbpq_1
XFILLER_21_1260 VDD VSS sg13g2_decap_8
XFILLER_63_656 VDD VSS sg13g2_decap_8
XFILLER_169_1186 VDD VSS sg13g2_decap_4
XFILLER_63_667 VDD VSS sg13g2_fill_1
X_13827_ _13827_/Q _14505_/CLK _13827_/D _13827_/RESET_B VDD VSS sg13g2_dfrbpq_1
XFILLER_1_1365 VDD VSS sg13g2_decap_8
XFILLER_63_678 VDD VSS sg13g2_decap_4
XFILLER_95_1383 VDD VSS sg13g2_fill_1
XFILLER_44_881 VDD VSS sg13g2_fill_1
X_13758_ _13758_/Q clkload39/A _13758_/D _13758_/RESET_B VDD VSS sg13g2_dfrbpq_1
XFILLER_44_892 VDD VSS sg13g2_decap_8
X_12709_ _12722_/A _12709_/A1 _12737_/A2 _15015_/Q VDD VSS sg13g2_a21oi_1
X_13689_ _13689_/Q clkload65/A _13689_/D _13689_/RESET_B VDD VSS sg13g2_dfrbpq_1
X_13695__2484 _13695_/RESET_B VDD VSS sg13g2_tiehi
XFILLER_148_238 VDD VSS sg13g2_decap_8
XFILLER_129_430 VDD VSS sg13g2_decap_8
XFILLER_141_1050 VDD VSS sg13g2_fill_2
XFILLER_15_1064 VDD VSS sg13g2_decap_8
XFILLER_89_1121 VDD VSS sg13g2_decap_8
X_14646__1533 _14646_/RESET_B VDD VSS sg13g2_tiehi
XFILLER_141_1094 VDD VSS sg13g2_decap_8
XFILLER_105_809 VDD VSS sg13g2_fill_2
XFILLER_144_477 VDD VSS sg13g2_decap_8
X_09920_ _14505_/D _14505_/Q _09920_/A1 _09936_/S VDD VSS sg13g2_mux2_1
XFILLER_116_179 VDD VSS sg13g2_decap_4
XFILLER_132_628 VDD VSS sg13g2_decap_4
XFILLER_160_937 VDD VSS sg13g2_decap_8
XFILLER_125_691 VDD VSS sg13g2_fill_2
XFILLER_171_296 VDD VSS sg13g2_decap_8
Xfanout706 fanout706/X _07655_/Y VDD VSS sg13g2_buf_1
Xfanout717 _11227_/S _12216_/S VDD VSS sg13g2_buf_1
X_09851_ _14438_/D _14438_/Q _09950_/A1 _09862_/S VDD VSS sg13g2_mux2_1
Xfanout728 _12328_/B1 _07654_/Y VDD VSS sg13g2_buf_1
Xfanout739 _11188_/C1 _10869_/A VDD VSS sg13g2_buf_1
X_08802_ _13685_/D _08802_/A _08802_/B VDD VSS sg13g2_nor2_1
XFILLER_140_683 VDD VSS sg13g2_decap_4
X_15014__2573 _15014_/RESET_B VDD VSS sg13g2_tiehi
XFILLER_86_737 VDD VSS sg13g2_decap_8
X_09782_ _14371_/D _09914_/A1 _14371_/Q _09800_/S VDD VSS sg13g2_mux2_1
XFILLER_105_49 VDD VSS sg13g2_decap_8
XFILLER_6_1232 VDD VSS sg13g2_decap_8
X_08733_ _08733_/Y _07720_/A _11288_/A _15199_/Q VDD VSS sg13g2_o21ai_1
XFILLER_26_1182 VDD VSS sg13g2_decap_8
X_08664_ _08664_/Y _08647_/Y _08678_/C _08698_/B VDD VSS sg13g2_a21oi_1
XFILLER_82_932 VDD VSS sg13g2_fill_1
XFILLER_66_483 VDD VSS sg13g2_decap_8
XFILLER_113_1196 VDD VSS sg13g2_decap_8
XFILLER_27_848 VDD VSS sg13g2_fill_1
XFILLER_22_1079 VDD VSS sg13g2_decap_8
XFILLER_81_431 VDD VSS sg13g2_decap_8
X_07615_ _07615_/Y _14945_/Q VDD VSS sg13g2_inv_1
XFILLER_148_1237 VDD VSS sg13g2_decap_4
XFILLER_26_358 VDD VSS sg13g2_decap_8
X_08595_ _08596_/D _08637_/B _08592_/X _08590_/Y VDD VSS sg13g2_a21oi_1
XFILLER_82_987 VDD VSS sg13g2_decap_8
XFILLER_26_369 VDD VSS sg13g2_fill_2
XFILLER_42_829 VDD VSS sg13g2_decap_8
X_14838__2868 _14838_/RESET_B VDD VSS sg13g2_tiehi
XFILLER_53_199 VDD VSS sg13g2_decap_8
XFILLER_70_1309 VDD VSS sg13g2_fill_2
XFILLER_14_35 VDD VSS sg13g2_decap_8
XFILLER_167_525 VDD VSS sg13g2_decap_8
XFILLER_139_238 VDD VSS sg13g2_decap_8
X_14285__1894 _14285_/RESET_B VDD VSS sg13g2_tiehi
X_09216_ _13827_/D _10146_/A1 _13827_/Q _09238_/S VDD VSS sg13g2_mux2_1
XFILLER_124_1270 VDD VSS sg13g2_fill_1
X_09147_ _09147_/Y _15247_/Q _09154_/B VDD VSS sg13g2_nand2b_1
XFILLER_147_271 VDD VSS sg13g2_decap_8
XFILLER_163_742 VDD VSS sg13g2_decap_4
XFILLER_68_1216 VDD VSS sg13g2_fill_1
XFILLER_163_764 VDD VSS sg13g2_decap_8
X_09078_ _09078_/Y _15237_/Q _09161_/S VDD VSS sg13g2_nand2b_1
XFILLER_30_56 VDD VSS sg13g2_decap_8
XFILLER_162_252 VDD VSS sg13g2_decap_8
XFILLER_2_903 VDD VSS sg13g2_decap_8
XFILLER_123_617 VDD VSS sg13g2_decap_8
XFILLER_146_56 VDD VSS sg13g2_decap_8
X_08029_ _08029_/Y _08340_/A _08254_/S VDD VSS sg13g2_nor2_1
XFILLER_162_285 VDD VSS sg13g2_decap_8
XFILLER_1_413 VDD VSS sg13g2_decap_8
XFILLER_104_831 VDD VSS sg13g2_decap_8
XFILLER_118_1030 VDD VSS sg13g2_fill_1
XFILLER_122_149 VDD VSS sg13g2_decap_8
X_11040_ _11042_/C _11040_/A _11052_/B VDD VSS sg13g2_nor2_1
XFILLER_89_553 VDD VSS sg13g2_fill_2
XFILLER_39_21 VDD VSS sg13g2_decap_8
XFILLER_131_650 VDD VSS sg13g2_decap_8
XFILLER_103_352 VDD VSS sg13g2_decap_8
XFILLER_7_1029 VDD VSS sg13g2_decap_8
XFILLER_130_160 VDD VSS sg13g2_decap_8
XFILLER_89_597 VDD VSS sg13g2_decap_8
XFILLER_76_214 VDD VSS sg13g2_fill_2
XFILLER_39_87 VDD VSS sg13g2_fill_2
XFILLER_162_77 VDD VSS sg13g2_decap_8
X_12991_ _12993_/C _14905_/Q _13682_/Q _12959_/X _12987_/Y _12990_/X VDD VSS sg13g2_a221oi_1
XFILLER_58_984 VDD VSS sg13g2_fill_2
XFILLER_18_826 VDD VSS sg13g2_decap_8
X_14730_ _14730_/Q _14730_/CLK _14730_/D _14730_/RESET_B VDD VSS sg13g2_dfrbpq_1
X_11942_ _11942_/Y _11963_/S0 _14192_/Q VDD VSS sg13g2_nand2b_1
XFILLER_85_792 VDD VSS sg13g2_fill_2
XFILLER_131_1296 VDD VSS sg13g2_decap_8
XFILLER_55_42 VDD VSS sg13g2_decap_8
XFILLER_79_1367 VDD VSS sg13g2_decap_8
XFILLER_55_53 VDD VSS sg13g2_fill_2
XFILLER_17_336 VDD VSS sg13g2_decap_8
X_14724__1455 _14724_/RESET_B VDD VSS sg13g2_tiehi
X_14661_ _14661_/Q clkload5/A _14661_/D _14661_/RESET_B VDD VSS sg13g2_dfrbpq_1
XFILLER_33_807 VDD VSS sg13g2_decap_8
XFILLER_169_0 VDD VSS sg13g2_decap_8
X_11873_ _11873_/Y _11869_/Y _11870_/Y _11872_/Y _11871_/Y _12253_/B VDD VSS sg13g2_a221oi_1
XFILLER_55_86 VDD VSS sg13g2_decap_4
X_13612_ _13613_/D _15054_/Q _15053_/Q _13508_/C VDD VSS sg13g2_o21ai_1
XFILLER_72_486 VDD VSS sg13g2_decap_8
X_10824_ _10824_/Y _10818_/B _10801_/Y _10823_/Y _10815_/Y _13279_/D VDD VSS sg13g2_a221oi_1
XFILLER_72_497 VDD VSS sg13g2_fill_2
XFILLER_44_188 VDD VSS sg13g2_decap_8
XFILLER_26_892 VDD VSS sg13g2_decap_8
X_14592_ _14592_/Q clkload29/A _14592_/D _14592_/RESET_B VDD VSS sg13g2_dfrbpq_1
XFILLER_125_1001 VDD VSS sg13g2_decap_8
XFILLER_13_553 VDD VSS sg13g2_decap_8
X_13543_ _13543_/Y _13543_/A _13543_/B VDD VSS sg13g2_nor2_1
XFILLER_158_525 VDD VSS sg13g2_decap_8
X_10755_ _10756_/A _13142_/A _11133_/B _11154_/B1 _10754_/X VDD VSS sg13g2_a22oi_1
XFILLER_38_1086 VDD VSS sg13g2_fill_2
XFILLER_41_895 VDD VSS sg13g2_fill_1
XFILLER_9_546 VDD VSS sg13g2_decap_8
XFILLER_16_1351 VDD VSS sg13g2_decap_8
X_13474_ _15111_/D _15177_/D _15111_/Q _13499_/A VDD VSS sg13g2_mux2_1
X_10686_ _14898_/D _07705_/B _10827_/B _10685_/Y VDD VSS sg13g2_o21ai_1
XFILLER_71_96 VDD VSS sg13g2_decap_8
XFILLER_12_1204 VDD VSS sg13g2_decap_8
XFILLER_139_772 VDD VSS sg13g2_decap_8
X_15213_ _15213_/Q _15213_/CLK _15213_/D _15213_/RESET_B VDD VSS sg13g2_dfrbpq_1
X_12425_ _12425_/X _14688_/Q _14720_/Q _13760_/Q _13792_/Q _12742_/S0 _12742_/S1 VDD
+ VSS sg13g2_mux4_1
XFILLER_127_934 VDD VSS sg13g2_decap_8
XFILLER_154_731 VDD VSS sg13g2_fill_2
X_13691__2490 _13691_/RESET_B VDD VSS sg13g2_tiehi
X_15144_ _15144_/Q clkload60/A _15144_/D _15144_/RESET_B VDD VSS sg13g2_dfrbpq_1
XFILLER_86_1316 VDD VSS sg13g2_fill_2
X_12356_ _12356_/Y _12400_/A _12356_/B VDD VSS sg13g2_nand2_1
XFILLER_114_606 VDD VSS sg13g2_decap_8
XFILLER_5_763 VDD VSS sg13g2_decap_8
XFILLER_58_7 VDD VSS sg13g2_decap_8
XFILLER_142_937 VDD VSS sg13g2_fill_1
X_11307_ _11307_/Y _11310_/A1 _13725_/Q VDD VSS sg13g2_nand2b_1
X_15075_ _15075_/Q clkload67/A _15075_/D _15075_/RESET_B VDD VSS sg13g2_dfrbpq_1
XFILLER_153_285 VDD VSS sg13g2_decap_8
X_12287_ _12287_/X _14393_/Q _14425_/Q _14489_/Q _14521_/Q _12288_/S0 _12288_/S1 VDD
+ VSS sg13g2_mux4_1
XFILLER_4_273 VDD VSS sg13g2_decap_8
XFILLER_84_1040 VDD VSS sg13g2_decap_8
XFILLER_49_1160 VDD VSS sg13g2_decap_4
X_14026_ _14026_/Q _14730_/CLK _14026_/D _14026_/RESET_B VDD VSS sg13g2_dfrbpq_1
X_14942__2660 _14942_/RESET_B VDD VSS sg13g2_tiehi
X_11238_ _11292_/A _11249_/A _15123_/Q VDD VSS sg13g2_nand2_1
XFILLER_122_661 VDD VSS sg13g2_decap_8
XFILLER_110_812 VDD VSS sg13g2_decap_8
XFILLER_150_981 VDD VSS sg13g2_decap_4
XFILLER_1_980 VDD VSS sg13g2_decap_8
XFILLER_122_694 VDD VSS sg13g2_decap_8
X_11169_ _14953_/D _11168_/X _11167_/Y _11156_/Y VDD VSS sg13g2_o21ai_1
XFILLER_68_748 VDD VSS sg13g2_fill_2
XFILLER_68_759 VDD VSS sg13g2_decap_8
XFILLER_23_1300 VDD VSS sg13g2_decap_8
XFILLER_171_1076 VDD VSS sg13g2_decap_8
XFILLER_0_490 VDD VSS sg13g2_decap_8
XFILLER_110_867 VDD VSS sg13g2_decap_8
XFILLER_95_578 VDD VSS sg13g2_decap_8
XFILLER_64_921 VDD VSS sg13g2_decap_8
XFILLER_23_1377 VDD VSS sg13g2_decap_8
XFILLER_110_1336 VDD VSS sg13g2_fill_2
X_14928_ _14928_/Q clkload69/A _14928_/D _14928_/RESET_B VDD VSS sg13g2_dfrbpq_1
XFILLER_64_954 VDD VSS sg13g2_fill_2
XFILLER_63_431 VDD VSS sg13g2_fill_2
X_15179__2851 _15179_/RESET_B VDD VSS sg13g2_tiehi
X_14859_ _14859_/Q clkload49/A _14859_/D _14859_/RESET_B VDD VSS sg13g2_dfrbpq_1
XFILLER_1_1162 VDD VSS sg13g2_decap_8
XFILLER_51_626 VDD VSS sg13g2_fill_2
XFILLER_35_177 VDD VSS sg13g2_fill_1
XFILLER_56_1120 VDD VSS sg13g2_decap_8
XFILLER_35_188 VDD VSS sg13g2_decap_8
X_08380_ _08380_/Y _08621_/A _08378_/Y _08379_/Y VDD VSS sg13g2_o21ai_1
XFILLER_56_1142 VDD VSS sg13g2_decap_8
X_14808__2905 _14808_/RESET_B VDD VSS sg13g2_tiehi
XFILLER_32_851 VDD VSS sg13g2_decap_8
XFILLER_143_1134 VDD VSS sg13g2_decap_8
XFILLER_50_169 VDD VSS sg13g2_fill_1
XFILLER_149_547 VDD VSS sg13g2_decap_8
XFILLER_56_1197 VDD VSS sg13g2_decap_8
XFILLER_17_1148 VDD VSS sg13g2_decap_8
XFILLER_84_0 VDD VSS sg13g2_decap_8
X_09001_ _09001_/X _09006_/A _08998_/X _09000_/Y VDD VSS sg13g2_a21o_1
XFILLER_129_271 VDD VSS sg13g2_decap_8
XFILLER_164_539 VDD VSS sg13g2_decap_8
X_14162__2017 _14162_/RESET_B VDD VSS sg13g2_tiehi
XFILLER_129_282 VDD VSS sg13g2_fill_2
Xclkbuf_4_13_0_clk_i clkbuf_4_13_0_clk_i/X clkbuf_0_clk_i/X VDD VSS sg13g2_buf_8
XFILLER_30_1359 VDD VSS sg13g2_decap_8
XFILLER_144_252 VDD VSS sg13g2_decap_4
XFILLER_144_274 VDD VSS sg13g2_decap_8
XFILLER_145_797 VDD VSS sg13g2_decap_8
XFILLER_133_948 VDD VSS sg13g2_fill_2
XFILLER_6_91 VDD VSS sg13g2_decap_8
X_09903_ _14489_/D _09936_/A1 _14489_/Q _09903_/S VDD VSS sg13g2_mux2_1
XFILLER_160_778 VDD VSS sg13g2_decap_8
Xfanout503 _11241_/A _07672_/X VDD VSS sg13g2_buf_1
XFILLER_99_862 VDD VSS sg13g2_fill_1
XFILLER_113_650 VDD VSS sg13g2_decap_4
XFILLER_154_1241 VDD VSS sg13g2_decap_4
Xfanout514 _12841_/B _12798_/Y VDD VSS sg13g2_buf_1
XFILLER_8_1316 VDD VSS sg13g2_decap_8
XFILLER_141_981 VDD VSS sg13g2_decap_8
Xfanout536 _09090_/A _09117_/A VDD VSS sg13g2_buf_1
XFILLER_28_1266 VDD VSS sg13g2_decap_8
Xfanout547 _13482_/B _08723_/Y VDD VSS sg13g2_buf_1
X_09834_ _14422_/D _09900_/A0 _14422_/Q _09837_/S VDD VSS sg13g2_mux2_1
XFILLER_98_383 VDD VSS sg13g2_decap_4
XFILLER_63_1168 VDD VSS sg13g2_fill_2
XFILLER_101_845 VDD VSS sg13g2_decap_8
XFILLER_154_1285 VDD VSS sg13g2_fill_1
Xfanout558 _13205_/B1 _13264_/B1 VDD VSS sg13g2_buf_1
Xfanout569 _13045_/A1 _13567_/A2 VDD VSS sg13g2_buf_1
XFILLER_101_867 VDD VSS sg13g2_decap_8
XFILLER_115_1269 VDD VSS sg13g2_decap_4
XFILLER_58_258 VDD VSS sg13g2_decap_8
X_09765_ _14355_/D _14355_/Q _09930_/A1 _09771_/S VDD VSS sg13g2_mux2_1
XFILLER_132_14 VDD VSS sg13g2_decap_8
X_08716_ _15211_/D _08715_/X _12346_/A _13654_/S VDD VSS sg13g2_mux2_1
XFILLER_73_228 VDD VSS sg13g2_fill_1
X_09696_ _14288_/D _09696_/A0 _14288_/Q _09706_/S VDD VSS sg13g2_mux2_1
XFILLER_73_239 VDD VSS sg13g2_decap_8
XFILLER_27_634 VDD VSS sg13g2_decap_8
XFILLER_54_442 VDD VSS sg13g2_decap_8
XFILLER_26_133 VDD VSS sg13g2_decap_8
X_08647_ _08647_/Y _08576_/Y _08641_/Y _08646_/Y VDD VSS sg13g2_a21oi_1
XFILLER_162_7 VDD VSS sg13g2_decap_8
XFILLER_70_935 VDD VSS sg13g2_fill_1
XFILLER_148_1067 VDD VSS sg13g2_decap_4
XFILLER_42_637 VDD VSS sg13g2_decap_8
X_08578_ _08578_/Y _08649_/S _08576_/Y _08577_/Y VDD VSS sg13g2_a21oi_1
XFILLER_39_1351 VDD VSS sg13g2_decap_8
XFILLER_25_56 VDD VSS sg13g2_decap_8
X_14372__1807 _14372_/RESET_B VDD VSS sg13g2_tiehi
X_13758__2421 _13758_/RESET_B VDD VSS sg13g2_tiehi
XFILLER_70_979 VDD VSS sg13g2_fill_2
XFILLER_126_1321 VDD VSS sg13g2_decap_8
XFILLER_168_845 VDD VSS sg13g2_fill_2
XFILLER_22_350 VDD VSS sg13g2_decap_8
XFILLER_161_1245 VDD VSS sg13g2_decap_8
XFILLER_167_322 VDD VSS sg13g2_decap_8
XFILLER_126_1365 VDD VSS sg13g2_decap_8
X_10540_ _10540_/Y _10566_/D _10547_/D _10557_/C VDD VSS sg13g2_o21ai_1
XFILLER_122_1218 VDD VSS sg13g2_decap_8
XFILLER_161_1267 VDD VSS sg13g2_fill_1
XFILLER_127_208 VDD VSS sg13g2_fill_2
XFILLER_10_567 VDD VSS sg13g2_decap_8
XFILLER_108_411 VDD VSS sg13g2_fill_1
XFILLER_167_399 VDD VSS sg13g2_decap_8
X_10471_ _10492_/C _14845_/Q _10500_/A _10471_/C _10471_/D VDD VSS sg13g2_and4_1
XFILLER_108_433 VDD VSS sg13g2_decap_8
X_14138__2041 _14138_/RESET_B VDD VSS sg13g2_tiehi
X_12210_ _12217_/B _12219_/S _12210_/B VDD VSS sg13g2_nor2_1
XFILLER_157_77 VDD VSS sg13g2_decap_8
X_13190_ _13191_/C _14918_/Q _13190_/B _13225_/B VDD VSS sg13g2_nand3_1
XFILLER_68_1024 VDD VSS sg13g2_decap_8
XFILLER_136_775 VDD VSS sg13g2_decap_8
XFILLER_151_701 VDD VSS sg13g2_decap_8
XFILLER_68_1035 VDD VSS sg13g2_fill_1
XFILLER_2_700 VDD VSS sg13g2_decap_8
X_12141_ _12141_/X _12135_/X _12136_/X _12138_/X _12137_/X _11549_/B _11559_/C VDD
+ VSS sg13g2_mux4_1
XFILLER_11_1281 VDD VSS sg13g2_decap_8
XFILLER_159_1174 VDD VSS sg13g2_decap_8
XFILLER_1_210 VDD VSS sg13g2_decap_8
XFILLER_173_21 VDD VSS sg13g2_decap_8
XFILLER_81_1202 VDD VSS sg13g2_decap_8
X_12072_ _12072_/X _13843_/Q _13875_/Q _13907_/Q _13939_/Q _12073_/S0 _12073_/S1 VDD
+ VSS sg13g2_mux4_1
XFILLER_96_309 VDD VSS sg13g2_decap_4
XFILLER_2_777 VDD VSS sg13g2_decap_8
XFILLER_172_1352 VDD VSS sg13g2_fill_1
X_11023_ _11023_/Y _11023_/A _11052_/A VDD VSS sg13g2_nor2_1
XFILLER_172_1363 VDD VSS sg13g2_decap_8
X_13668__2536 _13668_/RESET_B VDD VSS sg13g2_tiehi
X_13860__2319 _13860_/RESET_B VDD VSS sg13g2_tiehi
XFILLER_42_1208 VDD VSS sg13g2_decap_8
X_16880_ _16880_/X _16880_/A VDD VSS sg13g2_buf_1
XFILLER_81_1268 VDD VSS sg13g2_decap_8
XFILLER_42_1219 VDD VSS sg13g2_fill_1
XFILLER_1_287 VDD VSS sg13g2_decap_8
XFILLER_173_98 VDD VSS sg13g2_decap_8
XFILLER_2_49 VDD VSS sg13g2_decap_8
XFILLER_92_504 VDD VSS sg13g2_decap_4
XFILLER_77_589 VDD VSS sg13g2_fill_1
XFILLER_92_526 VDD VSS sg13g2_fill_2
XFILLER_18_623 VDD VSS sg13g2_decap_8
XFILLER_131_1071 VDD VSS sg13g2_decap_8
X_12974_ _12975_/B _12957_/A _13683_/Q _12960_/Y VDD VSS sg13g2_a21oi_1
X_14919__2706 _14919_/RESET_B VDD VSS sg13g2_tiehi
XFILLER_17_133 VDD VSS sg13g2_decap_8
X_14713_ _14713_/Q _14745_/CLK _14713_/D _14713_/RESET_B VDD VSS sg13g2_dfrbpq_1
X_11925_ _11925_/X _13967_/Q _13999_/Q _14031_/Q _14063_/Q _11925_/S0 _11925_/S1 VDD
+ VSS sg13g2_mux4_1
XFILLER_73_773 VDD VSS sg13g2_decap_8
Xclkbuf_leaf_1_clk_i _14737_/CLK clkbuf_leaf_2_clk_i/A VDD VSS sg13g2_buf_8
XFILLER_79_1197 VDD VSS sg13g2_decap_4
X_14644_ _14644_/Q _14644_/CLK _14644_/D _14644_/RESET_B VDD VSS sg13g2_dfrbpq_1
X_11856_ _11858_/B _12000_/A _11856_/B VDD VSS sg13g2_nor2_1
XFILLER_14_840 VDD VSS sg13g2_decap_8
X_14348__1831 _14348_/RESET_B VDD VSS sg13g2_tiehi
X_10807_ _10807_/Y _12346_/A _10807_/B _10807_/C VDD VSS sg13g2_nand3_1
XFILLER_60_467 VDD VSS sg13g2_decap_8
X_14575_ _14575_/Q _14607_/CLK _14575_/D _14575_/RESET_B VDD VSS sg13g2_dfrbpq_1
XFILLER_32_169 VDD VSS sg13g2_decap_8
XFILLER_13_350 VDD VSS sg13g2_decap_8
X_11787_ _11787_/X _14123_/Q _14155_/Q _14187_/Q _14219_/Q _11848_/S0 _11851_/S1 VDD
+ VSS sg13g2_mux4_1
XFILLER_158_333 VDD VSS sg13g2_decap_8
XFILLER_53_1348 VDD VSS sg13g2_fill_1
X_13526_ _13526_/Y _13525_/A _13533_/B _08276_/B _13546_/B2 VDD VSS sg13g2_a22oi_1
X_10738_ _14912_/D _09204_/C _11052_/A _10737_/Y VDD VSS sg13g2_o21ai_1
XFILLER_9_343 VDD VSS sg13g2_decap_8
XFILLER_140_1329 VDD VSS sg13g2_fill_1
XFILLER_174_815 VDD VSS sg13g2_fill_2
XFILLER_146_517 VDD VSS sg13g2_decap_8
XFILLER_12_1001 VDD VSS sg13g2_decap_8
X_13457_ _15105_/D _13449_/X _13456_/X _13446_/Y VDD VSS sg13g2_o21ai_1
X_10669_ _10807_/B _14926_/Q _08971_/X _10669_/S VDD VSS sg13g2_mux2_1
XFILLER_103_1140 VDD VSS sg13g2_decap_8
XFILLER_139_591 VDD VSS sg13g2_decap_8
XFILLER_173_336 VDD VSS sg13g2_decap_8
X_12408_ _12408_/X _14559_/Q _14591_/Q _14623_/Q _14655_/Q _12507_/S0 _12507_/S1 VDD
+ VSS sg13g2_mux4_1
X_13388_ _13391_/C _15127_/Q _13507_/B VDD VSS sg13g2_nand2_1
Xoutput106 mem_axi_wdata[11] _15143_/Q VDD VSS sg13g2_buf_1
XFILLER_86_1124 VDD VSS sg13g2_decap_8
XFILLER_12_1078 VDD VSS sg13g2_decap_8
Xoutput117 mem_axi_wdata[21] _15153_/Q VDD VSS sg13g2_buf_1
XFILLER_5_560 VDD VSS sg13g2_decap_8
X_15127_ _15127_/Q clkload65/A _15127_/D _15127_/RESET_B VDD VSS sg13g2_dfrbpq_1
Xoutput128 mem_axi_wdata[31] _15163_/Q VDD VSS sg13g2_buf_1
X_12339_ _12340_/A _12339_/A1 _12338_/Y _12298_/B VDD VSS sg13g2_o21ai_1
Xoutput139 mem_axi_wstrb[3] _15167_/Q VDD VSS sg13g2_buf_1
XFILLER_47_1119 VDD VSS sg13g2_decap_8
XFILLER_99_147 VDD VSS sg13g2_decap_8
X_15058_ _15058_/Q clkload72/A _15058_/D _15058_/RESET_B VDD VSS sg13g2_dfrbpq_1
XFILLER_87_309 VDD VSS sg13g2_decap_4
XFILLER_96_810 VDD VSS sg13g2_decap_4
X_14009_ _14009_/Q _14649_/CLK _14009_/D _14009_/RESET_B VDD VSS sg13g2_dfrbpq_1
XFILLER_68_523 VDD VSS sg13g2_fill_1
X_07880_ _08090_/B _08033_/A _08063_/B VDD VSS sg13g2_nor2_1
X_14450__1729 _14450_/RESET_B VDD VSS sg13g2_tiehi
X_13836__2343 _13836_/RESET_B VDD VSS sg13g2_tiehi
XFILLER_95_331 VDD VSS sg13g2_decap_8
X_14596__1583 _14596_/RESET_B VDD VSS sg13g2_tiehi
XFILLER_56_718 VDD VSS sg13g2_decap_8
XFILLER_62_1190 VDD VSS sg13g2_fill_2
X_09550_ _14148_/D _10047_/A0 _14148_/Q _09567_/S VDD VSS sg13g2_mux2_1
XFILLER_3_1246 VDD VSS sg13g2_decap_8
XFILLER_37_943 VDD VSS sg13g2_decap_8
XFILLER_23_1174 VDD VSS sg13g2_decap_8
XFILLER_110_1133 VDD VSS sg13g2_fill_2
XFILLER_64_740 VDD VSS sg13g2_decap_8
XFILLER_48_291 VDD VSS sg13g2_fill_2
XFILLER_149_1310 VDD VSS sg13g2_decap_8
X_08501_ _15238_/D _08501_/A _08501_/B _08501_/C _08501_/D VDD VSS sg13g2_nand4_1
X_09481_ _14081_/D _10077_/A0 _14081_/Q _09502_/S VDD VSS sg13g2_mux2_1
XFILLER_64_762 VDD VSS sg13g2_fill_1
XFILLER_91_570 VDD VSS sg13g2_fill_2
XFILLER_37_998 VDD VSS sg13g2_decap_8
XFILLER_36_486 VDD VSS sg13g2_decap_8
X_08432_ _08432_/Y _07799_/X _08432_/A2 _08001_/C VDD VSS sg13g2_o21ai_1
XFILLER_93_1139 VDD VSS sg13g2_decap_8
XFILLER_169_609 VDD VSS sg13g2_decap_8
XFILLER_24_648 VDD VSS sg13g2_fill_2
XFILLER_52_968 VDD VSS sg13g2_fill_1
XFILLER_23_147 VDD VSS sg13g2_decap_8
XFILLER_168_119 VDD VSS sg13g2_decap_8
X_08363_ _08363_/X _08207_/X _08362_/X _08452_/A _08279_/A _08363_/S0 _08194_/B VDD
+ VSS sg13g2_mux4_1
XFILLER_108_1073 VDD VSS sg13g2_fill_2
X_08294_ _08294_/Y _08318_/D _08286_/Y _07777_/Y VDD VSS sg13g2_o21ai_1
XFILLER_20_854 VDD VSS sg13g2_decap_8
XFILLER_109_208 VDD VSS sg13g2_decap_8
XFILLER_164_336 VDD VSS sg13g2_decap_8
XFILLER_11_14 VDD VSS sg13g2_decap_8
XFILLER_121_1262 VDD VSS sg13g2_fill_1
XFILLER_30_1156 VDD VSS sg13g2_decap_8
XFILLER_127_14 VDD VSS sg13g2_decap_8
XFILLER_117_252 VDD VSS sg13g2_decap_8
XFILLER_145_594 VDD VSS sg13g2_decap_8
XFILLER_117_1309 VDD VSS sg13g2_decap_8
XFILLER_132_244 VDD VSS sg13g2_decap_8
Xpicorv32_macro_1416 mem_axi_arprot[0] VDD VSS sg13g2_tielo
XFILLER_121_929 VDD VSS sg13g2_decap_4
Xfanout300 _10141_/A1 fanout301/X VDD VSS sg13g2_buf_1
Xfanout311 _10101_/S _10098_/S VDD VSS sg13g2_buf_1
XFILLER_132_277 VDD VSS sg13g2_fill_2
Xfanout1309 _11969_/A _12040_/A1 VDD VSS sg13g2_buf_1
XFILLER_8_1113 VDD VSS sg13g2_decap_8
Xfanout322 _09935_/S _09937_/S VDD VSS sg13g2_buf_1
Xfanout333 _09766_/S _09772_/S VDD VSS sg13g2_buf_1
XFILLER_87_832 VDD VSS sg13g2_decap_8
XFILLER_115_1022 VDD VSS sg13g2_decap_8
Xfanout344 _09706_/S _09702_/S VDD VSS sg13g2_buf_1
XFILLER_143_35 VDD VSS sg13g2_decap_8
XFILLER_154_1082 VDD VSS sg13g2_decap_8
Xfanout355 _09494_/S _09506_/S VDD VSS sg13g2_buf_1
XFILLER_86_331 VDD VSS sg13g2_decap_8
Xfanout366 _09292_/S _09306_/S VDD VSS sg13g2_buf_1
XFILLER_143_46 VDD VSS sg13g2_fill_2
X_14426__1753 _14426_/RESET_B VDD VSS sg13g2_tiehi
Xfanout377 _09202_/S wire378/A VDD VSS sg13g2_buf_1
X_09817_ _14405_/D _09916_/A1 _14405_/Q _09829_/S VDD VSS sg13g2_mux2_1
XFILLER_100_141 VDD VSS sg13g2_decap_8
Xfanout388 _10045_/A0 _09007_/X VDD VSS sg13g2_buf_1
XFILLER_100_152 VDD VSS sg13g2_fill_1
Xfanout399 _09106_/S _09112_/S VDD VSS sg13g2_buf_1
X_09748_ _14338_/D _14338_/Q _09913_/A1 _09771_/S VDD VSS sg13g2_mux2_1
XFILLER_39_280 VDD VSS sg13g2_fill_1
XFILLER_27_442 VDD VSS sg13g2_decap_8
XFILLER_55_762 VDD VSS sg13g2_fill_2
X_09679_ _14271_/D _09877_/A0 _14271_/Q _09697_/S VDD VSS sg13g2_mux2_1
XFILLER_55_784 VDD VSS sg13g2_decap_8
XFILLER_36_77 VDD VSS sg13g2_decap_8
X_11710_ _11710_/X _13833_/Q _13865_/Q _13897_/Q _13929_/Q _11715_/S0 _11715_/S1 VDD
+ VSS sg13g2_mux4_1
XFILLER_76_1348 VDD VSS sg13g2_fill_1
XFILLER_15_637 VDD VSS sg13g2_decap_8
XFILLER_54_283 VDD VSS sg13g2_decap_8
X_12690_ _12690_/X _12685_/X _12689_/X _12684_/X _12688_/X _12776_/S _12760_/S0 VDD
+ VSS sg13g2_mux4_1
XFILLER_42_434 VDD VSS sg13g2_decap_8
XFILLER_14_147 VDD VSS sg13g2_decap_8
XFILLER_159_119 VDD VSS sg13g2_decap_8
X_11641_ _11643_/B _11506_/B _11776_/A _11774_/A VDD VSS sg13g2_a21o_1
XFILLER_52_21 VDD VSS sg13g2_decap_8
XFILLER_161_1020 VDD VSS sg13g2_fill_2
XFILLER_168_21 VDD VSS sg13g2_decap_8
X_14360_ _14360_/Q _14979_/CLK _14360_/D _14360_/RESET_B VDD VSS sg13g2_dfrbpq_1
XFILLER_74_1094 VDD VSS sg13g2_fill_2
X_11572_ _11572_/X _11572_/A _11638_/C VDD VSS sg13g2_xor2_1
XFILLER_11_854 VDD VSS sg13g2_decap_8
X_13311_ _15060_/D _08992_/A _13308_/Y _07987_/Y _13310_/Y _13266_/A VDD VSS sg13g2_a221oi_1
XFILLER_52_98 VDD VSS sg13g2_decap_8
Xinput19 input19/X input19/A VDD VSS sg13g2_buf_1
X_10523_ _10567_/A _10558_/C _14856_/Q _14855_/Q VDD VSS sg13g2_nand3_1
XFILLER_155_325 VDD VSS sg13g2_fill_2
X_14291_ _14291_/Q _14660_/CLK _14291_/D _14291_/RESET_B VDD VSS sg13g2_dfrbpq_1
XFILLER_10_364 VDD VSS sg13g2_decap_8
XFILLER_156_859 VDD VSS sg13g2_fill_2
XFILLER_7_847 VDD VSS sg13g2_decap_8
XFILLER_52_1381 VDD VSS sg13g2_fill_2
XFILLER_167_196 VDD VSS sg13g2_decap_8
XFILLER_168_98 VDD VSS sg13g2_decap_8
X_13914__2265 _13914_/RESET_B VDD VSS sg13g2_tiehi
XFILLER_108_230 VDD VSS sg13g2_fill_2
X_13242_ _13247_/A _13242_/A _13242_/B VDD VSS sg13g2_nand2_1
XFILLER_13_1365 VDD VSS sg13g2_decap_8
X_10454_ _14840_/D _14840_/Q _10450_/C _10452_/Y VDD VSS sg13g2_a21oi_1
XFILLER_6_357 VDD VSS sg13g2_decap_8
XFILLER_100_1324 VDD VSS sg13g2_decap_8
XFILLER_164_870 VDD VSS sg13g2_decap_8
X_13173_ _13176_/B _13066_/A _13066_/C _13172_/X VDD VSS sg13g2_o21ai_1
XFILLER_108_285 VDD VSS sg13g2_decap_8
X_10385_ _10386_/C _14818_/Q _14819_/Q _10391_/C _10396_/C VDD VSS sg13g2_and4_1
XFILLER_112_907 VDD VSS sg13g2_decap_8
XFILLER_123_244 VDD VSS sg13g2_decap_8
XFILLER_124_767 VDD VSS sg13g2_decap_8
X_12124_ _12125_/B _12086_/X _11868_/A _12123_/Y VDD VSS sg13g2_a21oi_1
XFILLER_97_607 VDD VSS sg13g2_fill_1
XFILLER_97_618 VDD VSS sg13g2_fill_2
XFILLER_85_1190 VDD VSS sg13g2_fill_1
XFILLER_2_574 VDD VSS sg13g2_decap_8
X_12055_ _12056_/C _12055_/A _12055_/B _12055_/C _12055_/D VDD VSS sg13g2_nor4_1
XFILLER_81_1043 VDD VSS sg13g2_decap_8
XFILLER_133_1111 VDD VSS sg13g2_decap_4
XFILLER_78_843 VDD VSS sg13g2_decap_8
XFILLER_120_940 VDD VSS sg13g2_fill_1
XFILLER_78_854 VDD VSS sg13g2_fill_1
XFILLER_77_331 VDD VSS sg13g2_decap_8
X_11006_ _11012_/C _10893_/A _10893_/B _11005_/X VDD VSS sg13g2_a21oi_1
XFILLER_81_1087 VDD VSS sg13g2_fill_1
XFILLER_120_973 VDD VSS sg13g2_decap_8
X_16863_ _16863_/X _16863_/A VDD VSS sg13g2_buf_1
XFILLER_42_1049 VDD VSS sg13g2_decap_8
XFILLER_133_1166 VDD VSS sg13g2_fill_1
XFILLER_93_824 VDD VSS sg13g2_decap_8
XFILLER_37_206 VDD VSS sg13g2_decap_4
XFILLER_19_910 VDD VSS sg13g2_decap_8
XFILLER_18_420 VDD VSS sg13g2_decap_8
XFILLER_20_1358 VDD VSS sg13g2_decap_8
XFILLER_19_987 VDD VSS sg13g2_decap_8
X_12957_ _12988_/C _12957_/A _13683_/Q VDD VSS sg13g2_xnor2_1
XFILLER_73_581 VDD VSS sg13g2_decap_8
XFILLER_33_412 VDD VSS sg13g2_decap_8
XFILLER_73_592 VDD VSS sg13g2_fill_1
XFILLER_18_497 VDD VSS sg13g2_decap_8
X_11908_ _11908_/Y _11843_/A _13675_/Q _13674_/Q _11865_/A VDD VSS sg13g2_a22oi_1
X_15159__2639 _15159_/RESET_B VDD VSS sg13g2_tiehi
XFILLER_60_220 VDD VSS sg13g2_decap_8
X_12888_ _15026_/D _12878_/Y _12887_/Y _13239_/A VDD VSS sg13g2_a21oi_1
XFILLER_61_754 VDD VSS sg13g2_decap_8
XFILLER_33_467 VDD VSS sg13g2_fill_2
X_14627_ _14627_/Q _14659_/CLK _14627_/D _14627_/RESET_B VDD VSS sg13g2_dfrbpq_1
X_11839_ _14974_/D _11839_/A _11839_/B VDD VSS sg13g2_nor2_1
XFILLER_18_1232 VDD VSS sg13g2_decap_8
XFILLER_60_286 VDD VSS sg13g2_fill_1
XFILLER_109_1371 VDD VSS sg13g2_fill_2
XFILLER_60_297 VDD VSS sg13g2_decap_8
XFILLER_109_1382 VDD VSS sg13g2_fill_2
XFILLER_53_1145 VDD VSS sg13g2_fill_2
XFILLER_144_1273 VDD VSS sg13g2_decap_8
X_14558_ _14558_/Q clkload36/A _14558_/D _14558_/RESET_B VDD VSS sg13g2_dfrbpq_1
XFILLER_158_163 VDD VSS sg13g2_fill_1
XFILLER_9_140 VDD VSS sg13g2_decap_8
XFILLER_174_612 VDD VSS sg13g2_decap_8
XFILLER_105_1246 VDD VSS sg13g2_decap_4
XFILLER_119_528 VDD VSS sg13g2_decap_8
XFILLER_146_314 VDD VSS sg13g2_decap_8
XFILLER_159_697 VDD VSS sg13g2_decap_8
XFILLER_174_623 VDD VSS sg13g2_decap_8
X_13509_ _15132_/D _15132_/Q _13509_/A1 _13519_/B VDD VSS sg13g2_mux2_1
XFILLER_140_1159 VDD VSS sg13g2_fill_1
X_14489_ _14489_/Q clkload22/A _14489_/D _14489_/RESET_B VDD VSS sg13g2_dfrbpq_1
XFILLER_173_133 VDD VSS sg13g2_decap_8
X_14504__1675 _14504_/RESET_B VDD VSS sg13g2_tiehi
XFILLER_162_818 VDD VSS sg13g2_decap_8
XFILLER_161_317 VDD VSS sg13g2_decap_8
XFILLER_127_583 VDD VSS sg13g2_decap_8
XFILLER_138_1000 VDD VSS sg13g2_decap_8
XFILLER_155_892 VDD VSS sg13g2_decap_8
XFILLER_173_199 VDD VSS sg13g2_decap_8
XFILLER_115_745 VDD VSS sg13g2_fill_1
XFILLER_138_1022 VDD VSS sg13g2_decap_8
XFILLER_138_1044 VDD VSS sg13g2_decap_8
XFILLER_114_244 VDD VSS sg13g2_fill_1
XFILLER_88_607 VDD VSS sg13g2_decap_8
XFILLER_47_0 VDD VSS sg13g2_decap_8
XFILLER_170_873 VDD VSS sg13g2_decap_8
X_08981_ _08981_/Y _10681_/A _10674_/A _09024_/A VDD VSS sg13g2_o21ai_1
XFILLER_103_929 VDD VSS sg13g2_decap_8
XFILLER_115_789 VDD VSS sg13g2_fill_1
XFILLER_102_417 VDD VSS sg13g2_fill_2
XFILLER_69_810 VDD VSS sg13g2_decap_8
XFILLER_142_597 VDD VSS sg13g2_fill_2
X_07932_ _07932_/Y _08286_/A _08286_/B VDD VSS sg13g2_nor2_1
XFILLER_151_1211 VDD VSS sg13g2_decap_8
Xclkbuf_leaf_102_clk_i clkload37/A clkbuf_leaf_99_clk_i/A VDD VSS sg13g2_buf_8
XFILLER_60_1105 VDD VSS sg13g2_fill_1
XFILLER_25_1225 VDD VSS sg13g2_decap_8
XFILLER_3_70 VDD VSS sg13g2_decap_8
X_07863_ _08641_/D _08608_/A _08608_/B VDD VSS sg13g2_or2_1
XFILLER_60_1138 VDD VSS sg13g2_decap_4
XFILLER_112_1217 VDD VSS sg13g2_decap_8
XFILLER_96_673 VDD VSS sg13g2_fill_1
XFILLER_69_898 VDD VSS sg13g2_fill_2
X_09602_ _14199_/D _14199_/Q _10099_/A0 _09604_/S VDD VSS sg13g2_mux2_1
XFILLER_99_1348 VDD VSS sg13g2_fill_1
XFILLER_84_846 VDD VSS sg13g2_fill_1
XFILLER_68_397 VDD VSS sg13g2_fill_1
XFILLER_28_228 VDD VSS sg13g2_decap_8
X_07794_ _08414_/C _08383_/A _08383_/B VDD VSS sg13g2_xnor2_1
XFILLER_84_868 VDD VSS sg13g2_decap_4
XFILLER_7_1190 VDD VSS sg13g2_decap_8
XFILLER_3_1043 VDD VSS sg13g2_decap_8
Xclkbuf_leaf_117_clk_i clkload12/A clkbuf_5_5__f_clk_i/X VDD VSS sg13g2_buf_8
X_09533_ _14132_/D _09931_/A1 _14132_/Q _09533_/S VDD VSS sg13g2_mux2_1
XFILLER_83_367 VDD VSS sg13g2_fill_2
XFILLER_25_913 VDD VSS sg13g2_fill_2
X_09464_ _14065_/D _09629_/A0 _14065_/Q _09464_/S VDD VSS sg13g2_mux2_1
XFILLER_145_1004 VDD VSS sg13g2_decap_4
XFILLER_169_406 VDD VSS sg13g2_decap_8
X_08415_ _08417_/B _08415_/A _08415_/B VDD VSS sg13g2_nand2_1
XFILLER_19_1029 VDD VSS sg13g2_decap_8
XFILLER_51_253 VDD VSS sg13g2_decap_8
X_09395_ _13998_/D _09760_/A1 _13998_/Q _09401_/S VDD VSS sg13g2_mux2_1
XFILLER_24_489 VDD VSS sg13g2_fill_2
XFILLER_162_1351 VDD VSS sg13g2_decap_4
X_08346_ _08346_/Y _08346_/A _08346_/B _08346_/C VDD VSS sg13g2_nand3_1
XFILLER_71_1245 VDD VSS sg13g2_decap_8
XFILLER_36_1365 VDD VSS sg13g2_decap_8
XFILLER_165_612 VDD VSS sg13g2_decap_4
X_14903__2738 _14903_/RESET_B VDD VSS sg13g2_tiehi
XFILLER_71_1267 VDD VSS sg13g2_decap_8
XFILLER_20_651 VDD VSS sg13g2_decap_8
XFILLER_22_35 VDD VSS sg13g2_decap_8
X_08277_ _08277_/Y _08318_/D _08522_/C _08404_/B1 _08276_/X _08275_/Y VDD VSS sg13g2_a221oi_1
XFILLER_125_7 VDD VSS sg13g2_decap_8
XFILLER_123_1379 VDD VSS sg13g2_fill_1
XFILLER_165_656 VDD VSS sg13g2_decap_8
XFILLER_137_358 VDD VSS sg13g2_decap_4
XFILLER_138_35 VDD VSS sg13g2_decap_8
XFILLER_164_133 VDD VSS sg13g2_decap_8
XFILLER_106_701 VDD VSS sg13g2_decap_8
XFILLER_152_317 VDD VSS sg13g2_decap_8
XFILLER_121_1092 VDD VSS sg13g2_decap_8
XFILLER_105_211 VDD VSS sg13g2_fill_2
XFILLER_106_767 VDD VSS sg13g2_decap_8
XFILLER_156_1144 VDD VSS sg13g2_decap_8
XFILLER_133_564 VDD VSS sg13g2_fill_2
X_10170_ _10185_/A _14747_/Q _14748_/Q _13508_/C VDD VSS sg13g2_nand3_1
XFILLER_65_1038 VDD VSS sg13g2_fill_1
XFILLER_106_789 VDD VSS sg13g2_decap_8
XFILLER_117_1128 VDD VSS sg13g2_decap_8
XFILLER_160_372 VDD VSS sg13g2_decap_8
XFILLER_154_56 VDD VSS sg13g2_decap_8
X_14659__1520 _14659_/RESET_B VDD VSS sg13g2_tiehi
Xfanout1106 _12061_/A _14981_/Q VDD VSS sg13g2_buf_1
Xfanout1117 _08519_/A2 _08510_/A1 VDD VSS sg13g2_buf_1
Xfanout1128 _11798_/A _14974_/Q VDD VSS sg13g2_buf_1
XFILLER_59_331 VDD VSS sg13g2_decap_8
Xfanout1139 _08405_/A1 _14970_/Q VDD VSS sg13g2_buf_1
Xfanout152 _09935_/A1 _09902_/A0 VDD VSS sg13g2_buf_1
Xfanout163 _10098_/A0 _09900_/A0 VDD VSS sg13g2_buf_1
XFILLER_43_1347 VDD VSS sg13g2_decap_8
Xfanout174 _09632_/A0 _10163_/A1 VDD VSS sg13g2_buf_1
XFILLER_86_150 VDD VSS sg13g2_decap_8
XFILLER_47_21 VDD VSS sg13g2_decap_8
Xfanout185 _10128_/A0 _10161_/A1 VDD VSS sg13g2_buf_1
X_14088__2091 _14088_/RESET_B VDD VSS sg13g2_tiehi
XFILLER_59_386 VDD VSS sg13g2_decap_8
XFILLER_19_217 VDD VSS sg13g2_decap_8
XFILLER_130_1328 VDD VSS sg13g2_decap_8
Xfanout196 _10378_/D _10370_/A VDD VSS sg13g2_buf_1
X_14803__2910 _14803_/RESET_B VDD VSS sg13g2_tiehi
X_13860_ _13860_/Q _14672_/CLK _13860_/D _13860_/RESET_B VDD VSS sg13g2_dfrbpq_1
XFILLER_74_345 VDD VSS sg13g2_decap_8
XFILLER_90_805 VDD VSS sg13g2_fill_2
XFILLER_170_77 VDD VSS sg13g2_decap_8
X_12811_ _12812_/B _13303_/A _15123_/Q _12805_/Y _07683_/A _12810_/Y VDD VSS sg13g2_a221oi_1
XFILLER_16_924 VDD VSS sg13g2_decap_8
X_13791_ _13791_/Q clkload9/A _13791_/D _13791_/RESET_B VDD VSS sg13g2_dfrbpq_1
X_15027__2560 _15027_/RESET_B VDD VSS sg13g2_tiehi
XFILLER_43_732 VDD VSS sg13g2_decap_8
XFILLER_128_1213 VDD VSS sg13g2_decap_8
XFILLER_15_434 VDD VSS sg13g2_decap_8
X_12742_ _12742_/X _14135_/Q _14167_/Q _14199_/Q _14231_/Q _12742_/S0 _12742_/S1 VDD
+ VSS sg13g2_mux4_1
XFILLER_63_42 VDD VSS sg13g2_fill_1
XFILLER_63_53 VDD VSS sg13g2_decap_4
XFILLER_151_0 VDD VSS sg13g2_decap_8
Xclkbuf_leaf_81_clk_i _15188_/CLK clkbuf_leaf_82_clk_i/A VDD VSS sg13g2_buf_8
XFILLER_163_1137 VDD VSS sg13g2_decap_8
X_12673_ _12673_/X _13746_/Q _14098_/Q _14450_/Q _14546_/Q _12727_/S0 _12727_/S1 VDD
+ VSS sg13g2_mux4_1
XFILLER_43_787 VDD VSS sg13g2_decap_8
XFILLER_31_949 VDD VSS sg13g2_decap_8
X_14412_ _14412_/Q clkload35/A _14412_/D _14412_/RESET_B VDD VSS sg13g2_dfrbpq_1
X_11624_ _11625_/B _11613_/Y _11615_/X _12000_/A VDD VSS sg13g2_o21ai_1
XFILLER_30_448 VDD VSS sg13g2_decap_4
XFILLER_11_651 VDD VSS sg13g2_decap_8
XFILLER_128_303 VDD VSS sg13g2_decap_8
XFILLER_156_612 VDD VSS sg13g2_decap_8
XFILLER_168_483 VDD VSS sg13g2_decap_8
X_14343_ _14343_/Q _14703_/CLK _14343_/D _14343_/RESET_B VDD VSS sg13g2_dfrbpq_1
X_11555_ _11555_/X _14692_/Q _14724_/Q _13764_/Q _13796_/Q _11649_/S0 _12138_/S1 VDD
+ VSS sg13g2_mux4_1
XFILLER_10_161 VDD VSS sg13g2_decap_8
Xclkbuf_leaf_96_clk_i _14653_/CLK clkbuf_leaf_98_clk_i/A VDD VSS sg13g2_buf_8
XFILLER_155_133 VDD VSS sg13g2_decap_8
XFILLER_7_644 VDD VSS sg13g2_decap_8
XFILLER_144_807 VDD VSS sg13g2_decap_8
X_10506_ _10575_/C _10538_/A _10654_/A VDD VSS sg13g2_nor2_1
XFILLER_116_509 VDD VSS sg13g2_decap_8
X_14274_ _14274_/Q _14745_/CLK _14274_/D _14274_/RESET_B VDD VSS sg13g2_dfrbpq_1
XFILLER_13_1162 VDD VSS sg13g2_decap_8
XFILLER_143_306 VDD VSS sg13g2_decap_8
X_11486_ _11486_/X _13826_/Q _13858_/Q _13890_/Q _13922_/Q _11489_/S0 _11489_/S1 VDD
+ VSS sg13g2_mux4_1
XFILLER_6_154 VDD VSS sg13g2_decap_8
X_13225_ _13225_/X _13225_/A _13225_/B _13226_/B VDD VSS sg13g2_and3_1
X_10437_ _14835_/D _14835_/Q _10443_/D _10436_/Y VDD VSS sg13g2_a21oi_1
XFILLER_152_851 VDD VSS sg13g2_decap_8
XFILLER_170_147 VDD VSS sg13g2_decap_8
XFILLER_152_862 VDD VSS sg13g2_decap_8
X_14298__1881 _14298_/RESET_B VDD VSS sg13g2_tiehi
X_13156_ _13174_/B _14917_/Q _13670_/Q VDD VSS sg13g2_nor2_1
XFILLER_88_50 VDD VSS sg13g2_decap_8
XFILLER_40_7 VDD VSS sg13g2_decap_8
X_10368_ _10391_/C _10400_/A _10397_/B _10395_/A _10400_/C VDD VSS sg13g2_nor4_1
XFILLER_88_61 VDD VSS sg13g2_fill_2
XFILLER_3_861 VDD VSS sg13g2_decap_8
XFILLER_97_415 VDD VSS sg13g2_decap_8
XFILLER_69_117 VDD VSS sg13g2_decap_8
X_12107_ _12108_/A _14260_/Q _14292_/Q _14324_/Q _14356_/Q _12252_/S0 _12312_/B1 VDD
+ VSS sg13g2_mux4_1
XFILLER_2_371 VDD VSS sg13g2_decap_8
XFILLER_112_759 VDD VSS sg13g2_decap_8
X_13087_ _15038_/D _13155_/A _13087_/B VDD VSS sg13g2_nor2_1
X_10299_ _10299_/Y _10299_/A _10299_/B _10299_/C VDD VSS sg13g2_nor3_1
XFILLER_78_651 VDD VSS sg13g2_decap_8
X_12038_ _12038_/Y _11969_/A _14162_/Q _12038_/B1 VDD VSS sg13g2_a21oi_1
XFILLER_38_504 VDD VSS sg13g2_decap_8
XFILLER_38_515 VDD VSS sg13g2_fill_1
Xclkbuf_leaf_34_clk_i clkload20/A clkbuf_leaf_35_clk_i/A VDD VSS sg13g2_buf_8
XFILLER_4_1330 VDD VSS sg13g2_decap_8
XFILLER_93_665 VDD VSS sg13g2_decap_8
XFILLER_93_676 VDD VSS sg13g2_fill_1
XFILLER_53_507 VDD VSS sg13g2_fill_1
XFILLER_65_389 VDD VSS sg13g2_fill_1
XFILLER_0_1227 VDD VSS sg13g2_decap_8
X_13989_ _13989_/Q clkload5/A _13989_/D _13989_/RESET_B VDD VSS sg13g2_dfrbpq_1
XFILLER_81_849 VDD VSS sg13g2_fill_2
XFILLER_20_1155 VDD VSS sg13g2_decap_8
XFILLER_19_784 VDD VSS sg13g2_decap_8
XFILLER_94_1223 VDD VSS sg13g2_decap_4
XFILLER_92_186 VDD VSS sg13g2_decap_8
XFILLER_111_1294 VDD VSS sg13g2_decap_8
XFILLER_18_294 VDD VSS sg13g2_decap_8
Xclkbuf_leaf_49_clk_i _15247_/CLK clkbuf_leaf_52_clk_i/A VDD VSS sg13g2_buf_8
XFILLER_59_1376 VDD VSS sg13g2_decap_4
XFILLER_61_551 VDD VSS sg13g2_fill_2
XFILLER_33_253 VDD VSS sg13g2_decap_8
XFILLER_94_1289 VDD VSS sg13g2_decap_4
XFILLER_107_1308 VDD VSS sg13g2_decap_8
X_13786__2393 _13786_/RESET_B VDD VSS sg13g2_tiehi
X_08200_ _08201_/D _08200_/A _08338_/B _08200_/C VDD VSS sg13g2_nor3_1
X_09180_ _13796_/D _13796_/Q _10147_/A1 _09201_/S VDD VSS sg13g2_mux2_1
XFILLER_21_448 VDD VSS sg13g2_decap_8
XFILLER_159_450 VDD VSS sg13g2_decap_8
XFILLER_105_1032 VDD VSS sg13g2_decap_8
XFILLER_119_314 VDD VSS sg13g2_fill_2
X_14737__1442 _14737_/RESET_B VDD VSS sg13g2_tiehi
X_08131_ _08131_/Y _08279_/B _08128_/X _08130_/Y VDD VSS sg13g2_o21ai_1
XFILLER_105_1065 VDD VSS sg13g2_decap_8
XFILLER_119_358 VDD VSS sg13g2_decap_8
X_08062_ _08256_/A _08254_/S _08059_/X _08061_/Y VDD VSS sg13g2_o21ai_1
X_14020__2159 _14020_/RESET_B VDD VSS sg13g2_tiehi
XFILLER_174_486 VDD VSS sg13g2_decap_8
XFILLER_174_497 VDD VSS sg13g2_decap_8
XFILLER_115_520 VDD VSS sg13g2_decap_8
XFILLER_31_1295 VDD VSS sg13g2_decap_8
XFILLER_115_531 VDD VSS sg13g2_fill_2
XFILLER_161_147 VDD VSS sg13g2_decap_8
XFILLER_0_308 VDD VSS sg13g2_decap_8
XFILLER_115_586 VDD VSS sg13g2_fill_1
XFILLER_153_1328 VDD VSS sg13g2_decap_8
XFILLER_88_437 VDD VSS sg13g2_fill_2
X_08964_ _09839_/D _10004_/B _09441_/C _09441_/A VDD VSS sg13g2_nand3b_1
XFILLER_69_651 VDD VSS sg13g2_decap_8
XFILLER_29_1191 VDD VSS sg13g2_decap_8
XFILLER_151_1030 VDD VSS sg13g2_decap_8
X_07915_ _07917_/C _07884_/Y _07900_/Y _07914_/Y VDD VSS sg13g2_a21oi_1
XFILLER_9_1274 VDD VSS sg13g2_decap_8
X_08895_ _08895_/X _08894_/X _11770_/A _08904_/S VDD VSS sg13g2_mux2_1
XFILLER_116_1172 VDD VSS sg13g2_fill_2
XFILLER_99_1112 VDD VSS sg13g2_decap_8
XFILLER_5_1127 VDD VSS sg13g2_decap_8
XFILLER_112_1014 VDD VSS sg13g2_fill_2
XFILLER_116_1183 VDD VSS sg13g2_decap_8
XFILLER_69_695 VDD VSS sg13g2_decap_8
XFILLER_29_526 VDD VSS sg13g2_decap_8
XFILLER_116_1194 VDD VSS sg13g2_fill_1
XFILLER_112_1036 VDD VSS sg13g2_decap_8
X_07846_ _08650_/A _08678_/B _08678_/C VDD VSS sg13g2_and2_1
XFILLER_83_120 VDD VSS sg13g2_fill_2
XFILLER_56_334 VDD VSS sg13g2_decap_8
XFILLER_25_1099 VDD VSS sg13g2_decap_8
XFILLER_95_1009 VDD VSS sg13g2_fill_1
XFILLER_84_676 VDD VSS sg13g2_decap_8
XFILLER_44_507 VDD VSS sg13g2_decap_8
XFILLER_44_518 VDD VSS sg13g2_fill_1
XFILLER_17_35 VDD VSS sg13g2_decap_8
XFILLER_140_14 VDD VSS sg13g2_decap_8
X_07777_ _07777_/Y _08276_/B _08276_/A VDD VSS sg13g2_nand2b_1
XFILLER_71_326 VDD VSS sg13g2_decap_8
X_09516_ _14115_/D _09615_/A0 _14115_/Q _09535_/S VDD VSS sg13g2_mux2_1
XFILLER_24_231 VDD VSS sg13g2_decap_8
XFILLER_169_203 VDD VSS sg13g2_decap_8
XFILLER_73_1307 VDD VSS sg13g2_fill_2
XFILLER_73_1318 VDD VSS sg13g2_fill_1
X_09447_ _14048_/D _10076_/A0 _14048_/Q _09469_/S VDD VSS sg13g2_mux2_1
XFILLER_13_938 VDD VSS sg13g2_decap_8
X_14230__1949 _14230_/RESET_B VDD VSS sg13g2_tiehi
XFILLER_71_1020 VDD VSS sg13g2_decap_4
XFILLER_12_448 VDD VSS sg13g2_decap_8
X_09378_ _13981_/D _09609_/A0 _13981_/Q _09401_/S VDD VSS sg13g2_mux2_1
XFILLER_33_56 VDD VSS sg13g2_decap_8
XFILLER_32_1004 VDD VSS sg13g2_decap_8
XFILLER_137_100 VDD VSS sg13g2_fill_1
XFILLER_149_56 VDD VSS sg13g2_decap_4
X_08329_ _08329_/Y _08329_/A _08329_/B VDD VSS sg13g2_nand2_1
XFILLER_36_1184 VDD VSS sg13g2_decap_8
XFILLER_165_420 VDD VSS sg13g2_decap_8
XFILLER_32_1026 VDD VSS sg13g2_decap_8
XFILLER_123_1165 VDD VSS sg13g2_decap_8
XFILLER_166_965 VDD VSS sg13g2_fill_2
X_11340_ _11340_/Y _11340_/A1 _11339_/Y _11332_/Y _11333_/Y _11341_/A2 VDD VSS sg13g2_a221oi_1
XFILLER_138_678 VDD VSS sg13g2_decap_8
XFILLER_10_1302 VDD VSS sg13g2_decap_8
XFILLER_123_1198 VDD VSS sg13g2_decap_8
XFILLER_153_626 VDD VSS sg13g2_decap_8
XFILLER_158_1217 VDD VSS sg13g2_decap_8
XFILLER_165_497 VDD VSS sg13g2_decap_8
X_11271_ _11271_/Y _11275_/S0 _14396_/Q _11262_/B VDD VSS sg13g2_a21oi_1
XFILLER_152_136 VDD VSS sg13g2_fill_1
XFILLER_118_391 VDD VSS sg13g2_decap_8
X_13010_ _13026_/C _13010_/A _13010_/B VDD VSS sg13g2_nor2_1
X_14847__2850 _14847_/RESET_B VDD VSS sg13g2_tiehi
XFILLER_4_658 VDD VSS sg13g2_decap_8
XFILLER_10_1379 VDD VSS sg13g2_fill_1
X_10222_ _10222_/Y _14769_/Q _10219_/X _10441_/C VDD VSS sg13g2_o21ai_1
XFILLER_165_77 VDD VSS sg13g2_decap_8
XFILLER_79_404 VDD VSS sg13g2_decap_4
XFILLER_3_168 VDD VSS sg13g2_decap_8
XFILLER_79_426 VDD VSS sg13g2_decap_8
X_10153_ _14730_/D _14730_/Q _10153_/A1 _10156_/S VDD VSS sg13g2_mux2_1
X_14175__2004 _14175_/RESET_B VDD VSS sg13g2_tiehi
XFILLER_0_842 VDD VSS sg13g2_decap_8
XFILLER_88_960 VDD VSS sg13g2_fill_2
XFILLER_82_1160 VDD VSS sg13g2_fill_1
XFILLER_43_1111 VDD VSS sg13g2_decap_8
XFILLER_134_1250 VDD VSS sg13g2_decap_8
X_14961_ _14961_/Q _15228_/CLK _14961_/D _14961_/RESET_B VDD VSS sg13g2_dfrbpq_1
X_10084_ _14664_/D _10084_/A0 _14664_/Q _10093_/S VDD VSS sg13g2_mux2_1
XFILLER_58_97 VDD VSS sg13g2_decap_8
XFILLER_134_1283 VDD VSS sg13g2_decap_8
XFILLER_87_481 VDD VSS sg13g2_decap_8
XFILLER_43_1166 VDD VSS sg13g2_decap_4
X_13912_ _13912_/Q _14744_/CLK _13912_/D _13912_/RESET_B VDD VSS sg13g2_dfrbpq_1
XFILLER_48_857 VDD VSS sg13g2_decap_8
XFILLER_59_194 VDD VSS sg13g2_decap_4
X_14892_ _14892_/Q _14894_/CLK _14892_/D _14892_/RESET_B VDD VSS sg13g2_dfrbpq_1
XFILLER_43_1199 VDD VSS sg13g2_decap_8
XFILLER_78_1218 VDD VSS sg13g2_decap_8
X_13843_ _13843_/Q clkload24/A _13843_/D _13843_/RESET_B VDD VSS sg13g2_dfrbpq_1
XFILLER_47_378 VDD VSS sg13g2_decap_8
XFILLER_35_518 VDD VSS sg13g2_decap_4
XFILLER_90_635 VDD VSS sg13g2_fill_2
XFILLER_16_721 VDD VSS sg13g2_decap_8
XFILLER_62_348 VDD VSS sg13g2_decap_8
X_13774_ _13774_/Q _14734_/CLK _13774_/D _13774_/RESET_B VDD VSS sg13g2_dfrbpq_1
X_10986_ _14940_/D _10985_/X _10984_/Y _10973_/Y VDD VSS sg13g2_o21ai_1
XFILLER_90_668 VDD VSS sg13g2_decap_4
XFILLER_15_231 VDD VSS sg13g2_decap_8
XFILLER_128_1032 VDD VSS sg13g2_decap_8
X_12725_ _12725_/X _14390_/Q _14422_/Q _14486_/Q _14518_/Q _12752_/S0 _12752_/S1 VDD
+ VSS sg13g2_mux4_1
XFILLER_16_798 VDD VSS sg13g2_decap_8
XFILLER_43_584 VDD VSS sg13g2_decap_8
XFILLER_128_1087 VDD VSS sg13g2_fill_1
X_14206__1973 _14206_/RESET_B VDD VSS sg13g2_tiehi
X_12656_ _12656_/X _14129_/Q _14161_/Q _14193_/Q _14225_/Q _12661_/S0 _12661_/S1 VDD
+ VSS sg13g2_mux4_1
X_14982__2605 _14982_/RESET_B VDD VSS sg13g2_tiehi
XFILLER_88_7 VDD VSS sg13g2_decap_8
XFILLER_54_1262 VDD VSS sg13g2_decap_8
XFILLER_31_779 VDD VSS sg13g2_decap_8
XFILLER_128_100 VDD VSS sg13g2_decap_8
XFILLER_169_792 VDD VSS sg13g2_decap_8
XFILLER_141_1232 VDD VSS sg13g2_fill_1
X_11607_ _11608_/A _13734_/Q _14086_/Q _14438_/Q _14534_/Q _11993_/S0 _11996_/S1 VDD
+ VSS sg13g2_mux4_1
XFILLER_15_1246 VDD VSS sg13g2_decap_8
XFILLER_168_280 VDD VSS sg13g2_decap_8
X_12587_ _12587_/X _14380_/Q _14412_/Q _14476_/Q _14508_/Q _12592_/S0 _12592_/S1 VDD
+ VSS sg13g2_mux4_1
XFILLER_8_931 VDD VSS sg13g2_decap_8
XFILLER_50_1148 VDD VSS sg13g2_decap_8
XFILLER_117_818 VDD VSS sg13g2_decap_8
XFILLER_128_155 VDD VSS sg13g2_decap_8
X_14326_ _14326_/Q clkload28/A _14326_/D _14326_/RESET_B VDD VSS sg13g2_dfrbpq_1
XFILLER_7_441 VDD VSS sg13g2_decap_8
XFILLER_117_829 VDD VSS sg13g2_fill_2
XFILLER_144_615 VDD VSS sg13g2_fill_2
X_11538_ _11538_/Y _11531_/A _14628_/Q VDD VSS sg13g2_nand2b_1
XFILLER_128_188 VDD VSS sg13g2_decap_8
XFILLER_156_497 VDD VSS sg13g2_fill_2
X_14257_ _14257_/Q _14667_/CLK _14257_/D _14257_/RESET_B VDD VSS sg13g2_dfrbpq_1
X_11469_ _11469_/X _14369_/Q _14401_/Q _14465_/Q _14497_/Q _11469_/S0 _11469_/S1 VDD
+ VSS sg13g2_mux4_1
XFILLER_87_1071 VDD VSS sg13g2_decap_8
XFILLER_171_467 VDD VSS sg13g2_decap_8
X_13208_ _13208_/Y _14793_/Q _13208_/A2 _13208_/B1 VDD VSS sg13g2_o21ai_1
X_14188_ _14188_/Q clkload13/A _14188_/D _14188_/RESET_B VDD VSS sg13g2_dfrbpq_1
XFILLER_124_394 VDD VSS sg13g2_decap_8
X_13139_ _13139_/Y _13139_/A _13139_/B VDD VSS sg13g2_nand2_1
XFILLER_97_245 VDD VSS sg13g2_decap_8
XFILLER_61_1222 VDD VSS sg13g2_decap_8
XFILLER_79_993 VDD VSS sg13g2_decap_8
XFILLER_26_1364 VDD VSS sg13g2_decap_8
X_07700_ _15202_/D _07700_/A _07700_/B _07700_/C VDD VSS sg13g2_nand3_1
XFILLER_78_481 VDD VSS sg13g2_decap_4
XFILLER_113_1345 VDD VSS sg13g2_decap_8
X_08680_ _08681_/B _08678_/C _08654_/A _07841_/Y VDD VSS sg13g2_o21ai_1
XFILLER_94_963 VDD VSS sg13g2_decap_8
XFILLER_39_868 VDD VSS sg13g2_fill_2
XFILLER_96_1307 VDD VSS sg13g2_fill_1
X_07631_ _07631_/Y _08377_/B VDD VSS sg13g2_inv_1
XFILLER_96_1329 VDD VSS sg13g2_decap_8
XFILLER_93_473 VDD VSS sg13g2_decap_8
XFILLER_19_581 VDD VSS sg13g2_decap_8
XFILLER_0_1024 VDD VSS sg13g2_decap_8
X_13873__2306 _13873_/RESET_B VDD VSS sg13g2_tiehi
XFILLER_146_1110 VDD VSS sg13g2_decap_4
X_09301_ _13909_/D _13909_/Q _10164_/A1 _09301_/S VDD VSS sg13g2_mux2_1
XFILLER_59_1173 VDD VSS sg13g2_decap_8
XFILLER_146_1132 VDD VSS sg13g2_fill_1
XFILLER_55_1015 VDD VSS sg13g2_decap_8
XFILLER_110_28 VDD VSS sg13g2_decap_8
XFILLER_110_39 VDD VSS sg13g2_decap_8
XFILLER_22_724 VDD VSS sg13g2_decap_8
X_09232_ _13843_/D _09332_/A0 _13843_/Q _09237_/S VDD VSS sg13g2_mux2_1
XFILLER_107_1138 VDD VSS sg13g2_decap_4
XFILLER_72_1340 VDD VSS sg13g2_decap_8
XFILLER_33_1302 VDD VSS sg13g2_decap_8
XFILLER_21_245 VDD VSS sg13g2_decap_8
XFILLER_166_217 VDD VSS sg13g2_decap_8
XFILLER_72_1373 VDD VSS sg13g2_decap_8
X_09163_ _09164_/D _14925_/Q _14924_/Q VDD VSS sg13g2_nor2b_1
XFILLER_159_280 VDD VSS sg13g2_decap_8
XFILLER_9_91 VDD VSS sg13g2_decap_8
XFILLER_148_976 VDD VSS sg13g2_fill_1
X_08114_ _08115_/B _07879_/A _08377_/B _08113_/Y VDD VSS sg13g2_a21oi_1
XFILLER_33_1379 VDD VSS sg13g2_decap_4
X_09094_ _10747_/B _09140_/S _15042_/Q _09093_/Y VDD VSS sg13g2_o21ai_1
XFILLER_135_615 VDD VSS sg13g2_decap_8
XFILLER_163_935 VDD VSS sg13g2_fill_1
XFILLER_119_199 VDD VSS sg13g2_decap_8
X_08045_ _08045_/Y _08177_/S _08044_/X _08043_/Y VDD VSS sg13g2_o21ai_1
XFILLER_163_968 VDD VSS sg13g2_decap_4
XFILLER_31_1092 VDD VSS sg13g2_decap_8
XFILLER_134_147 VDD VSS sg13g2_decap_4
XFILLER_162_467 VDD VSS sg13g2_decap_8
XFILLER_66_1133 VDD VSS sg13g2_decap_8
XFILLER_135_14 VDD VSS sg13g2_decap_8
XFILLER_131_821 VDD VSS sg13g2_decap_4
XFILLER_0_105 VDD VSS sg13g2_decap_8
XFILLER_153_1103 VDD VSS sg13g2_fill_1
XFILLER_157_1272 VDD VSS sg13g2_decap_8
XFILLER_89_735 VDD VSS sg13g2_decap_8
XFILLER_103_523 VDD VSS sg13g2_fill_2
XFILLER_115_383 VDD VSS sg13g2_decap_8
Xhold3022 input7/A mem_axi_rdata[12] VDD VSS sg13g2_dlygate4sd3_1
XFILLER_27_1117 VDD VSS sg13g2_decap_8
XFILLER_103_534 VDD VSS sg13g2_fill_2
XFILLER_115_394 VDD VSS sg13g2_fill_2
Xhold3033 hold3033/X input4/X VDD VSS sg13g2_dlygate4sd3_1
Xhold3044 _10209_/C _10207_/Y VDD VSS sg13g2_dlygate4sd3_1
X_09996_ _14579_/D _10095_/A0 _14579_/Q _09999_/S VDD VSS sg13g2_mux2_1
XFILLER_131_876 VDD VSS sg13g2_decap_8
Xhold3055 input21/A mem_axi_rdata[25] VDD VSS sg13g2_dlygate4sd3_1
Xhold3066 hold3066/X input25/X VDD VSS sg13g2_dlygate4sd3_1
XFILLER_88_267 VDD VSS sg13g2_fill_2
XFILLER_76_407 VDD VSS sg13g2_decap_8
XFILLER_103_578 VDD VSS sg13g2_fill_2
XFILLER_130_364 VDD VSS sg13g2_decap_8
Xhold3077 hold3077/X input22/X VDD VSS sg13g2_dlygate4sd3_1
Xhold3088 hold3088/X input11/X VDD VSS sg13g2_dlygate4sd3_1
X_08947_ _13720_/D _08956_/S _08945_/Y _08946_/Y VDD VSS sg13g2_a21oi_1
XFILLER_9_1071 VDD VSS sg13g2_decap_8
Xhold3099 _13633_/A _13741_/Q VDD VSS sg13g2_dlygate4sd3_1
XFILLER_29_312 VDD VSS sg13g2_fill_2
X_08878_ _08878_/X _15033_/Q _10694_/S _08877_/Y VDD VSS sg13g2_a21o_1
XFILLER_28_56 VDD VSS sg13g2_decap_8
XFILLER_151_35 VDD VSS sg13g2_decap_8
XFILLER_85_985 VDD VSS sg13g2_fill_2
XFILLER_17_518 VDD VSS sg13g2_decap_8
X_07829_ _07906_/B _07829_/A _07829_/B VDD VSS sg13g2_and2_1
XFILLER_56_175 VDD VSS sg13g2_decap_8
XFILLER_56_186 VDD VSS sg13g2_fill_2
XFILLER_38_890 VDD VSS sg13g2_decap_8
X_10840_ _10841_/C _10851_/D _12347_/B _10821_/C _10821_/A _10818_/Y VDD VSS sg13g2_a221oi_1
X_14463__1716 _14463_/RESET_B VDD VSS sg13g2_tiehi
X_13849__2330 _13849_/RESET_B VDD VSS sg13g2_tiehi
X_10771_ _14919_/D _11207_/B1 _11147_/A _10770_/Y VDD VSS sg13g2_o21ai_1
XFILLER_73_1126 VDD VSS sg13g2_fill_2
XFILLER_38_1246 VDD VSS sg13g2_fill_2
XFILLER_13_735 VDD VSS sg13g2_decap_8
XFILLER_164_1254 VDD VSS sg13g2_decap_8
XFILLER_73_1137 VDD VSS sg13g2_fill_1
XFILLER_44_77 VDD VSS sg13g2_decap_8
XFILLER_158_707 VDD VSS sg13g2_decap_4
X_12510_ _12510_/X _12506_/X _12505_/X _12504_/X _12503_/X _12608_/S1 _12539_/S VDD
+ VSS sg13g2_mux4_1
XFILLER_40_532 VDD VSS sg13g2_decap_4
X_13490_ _13490_/Y _15198_/Q _13490_/B _13490_/C _13490_/D VDD VSS sg13g2_nor4_1
XFILLER_125_1238 VDD VSS sg13g2_decap_8
XFILLER_12_245 VDD VSS sg13g2_decap_8
XFILLER_160_1129 VDD VSS sg13g2_fill_1
XFILLER_9_728 VDD VSS sg13g2_decap_8
X_12441_ _12441_/X _12439_/X _12440_/X _12776_/S VDD VSS sg13g2_mux2_1
XFILLER_60_21 VDD VSS sg13g2_decap_8
XFILLER_8_238 VDD VSS sg13g2_decap_8
XFILLER_166_751 VDD VSS sg13g2_fill_1
XFILLER_138_453 VDD VSS sg13g2_fill_2
XFILLER_166_773 VDD VSS sg13g2_fill_1
X_15160_ _15160_/Q clkload70/A _15160_/D _15160_/RESET_B VDD VSS sg13g2_dfrbpq_1
X_12372_ _12372_/Y _12400_/A _12372_/B VDD VSS sg13g2_nand2_1
XFILLER_114_0 VDD VSS sg13g2_decap_8
X_14111_ _14111_/Q clkload10/A _14111_/D _14111_/RESET_B VDD VSS sg13g2_dfrbpq_1
X_11323_ _11323_/Y _11328_/S0 _14141_/Q _11328_/S1 VDD VSS sg13g2_a21oi_1
XFILLER_154_957 VDD VSS sg13g2_decap_4
XFILLER_158_1025 VDD VSS sg13g2_decap_8
XFILLER_165_294 VDD VSS sg13g2_decap_8
X_15091_ _15091_/Q _15159_/CLK _15091_/D _15091_/RESET_B VDD VSS sg13g2_dfrbpq_1
XFILLER_5_945 VDD VSS sg13g2_decap_8
XFILLER_154_979 VDD VSS sg13g2_decap_8
XFILLER_107_851 VDD VSS sg13g2_decap_8
XFILLER_5_49 VDD VSS sg13g2_decap_8
XFILLER_4_455 VDD VSS sg13g2_decap_8
X_14042_ _14042_/Q _14734_/CLK _14042_/D _14042_/RESET_B VDD VSS sg13g2_dfrbpq_1
X_11254_ _11255_/A _12330_/S0 _14652_/Q _11325_/B1 VDD VSS sg13g2_a21oi_1
XFILLER_10_1176 VDD VSS sg13g2_decap_8
XFILLER_136_1301 VDD VSS sg13g2_fill_1
XFILLER_122_821 VDD VSS sg13g2_decap_4
XFILLER_106_383 VDD VSS sg13g2_fill_2
XFILLER_122_832 VDD VSS sg13g2_decap_8
XFILLER_136_1323 VDD VSS sg13g2_decap_8
X_10205_ _15200_/D hold3075/X _13448_/B _13336_/S VDD VSS sg13g2_mux2_1
XFILLER_140_139 VDD VSS sg13g2_decap_8
X_13951__2228 _13951_/RESET_B VDD VSS sg13g2_tiehi
X_11185_ _11197_/B _11185_/A _11185_/B VDD VSS sg13g2_xnor2_1
X_10136_ _14714_/D _10169_/A1 _14714_/Q _10136_/S VDD VSS sg13g2_mux2_1
XFILLER_0_672 VDD VSS sg13g2_decap_8
XFILLER_48_632 VDD VSS sg13g2_decap_8
X_14944_ _14944_/Q clkload42/A _14944_/D _14944_/RESET_B VDD VSS sg13g2_dfrbpq_1
X_10067_ _14648_/D _10100_/A0 _14648_/Q _10068_/S VDD VSS sg13g2_mux2_1
XFILLER_76_952 VDD VSS sg13g2_decap_8
XFILLER_76_963 VDD VSS sg13g2_fill_1
XFILLER_47_153 VDD VSS sg13g2_decap_8
XFILLER_78_1015 VDD VSS sg13g2_fill_1
X_14875_ _14875_/Q clkload48/A _14875_/D _14875_/RESET_B VDD VSS sg13g2_dfrbpq_1
XFILLER_90_410 VDD VSS sg13g2_decap_8
XFILLER_78_1037 VDD VSS sg13g2_decap_8
XFILLER_62_112 VDD VSS sg13g2_fill_1
XFILLER_1_1344 VDD VSS sg13g2_decap_8
X_13826_ _13826_/Q clkload31/A _13826_/D _13826_/RESET_B VDD VSS sg13g2_dfrbpq_1
XFILLER_62_145 VDD VSS sg13g2_decap_8
XFILLER_62_156 VDD VSS sg13g2_decap_4
X_14439__1740 _14439_/RESET_B VDD VSS sg13g2_tiehi
X_13757_ _13757_/Q clkload47/A _13757_/D _13757_/RESET_B VDD VSS sg13g2_dfrbpq_1
XFILLER_50_329 VDD VSS sg13g2_decap_8
X_10969_ _10969_/Y _10969_/A _11109_/B VDD VSS sg13g2_nand2_1
XFILLER_16_595 VDD VSS sg13g2_decap_8
X_12708_ _15014_/D _12708_/A _12708_/B VDD VSS sg13g2_nor2_1
XFILLER_149_729 VDD VSS sg13g2_fill_2
X_13688_ _13688_/Q clkload62/A _13688_/D _13688_/RESET_B VDD VSS sg13g2_dfrbpq_1
XFILLER_19_1190 VDD VSS sg13g2_decap_8
X_12639_ _12652_/A _12709_/A1 _12737_/A2 _15010_/Q VDD VSS sg13g2_a21oi_1
XFILLER_15_1043 VDD VSS sg13g2_decap_8
XFILLER_89_1144 VDD VSS sg13g2_decap_8
XFILLER_129_486 VDD VSS sg13g2_decap_8
XFILLER_116_114 VDD VSS sg13g2_decap_4
XFILLER_145_946 VDD VSS sg13g2_decap_8
XFILLER_144_434 VDD VSS sg13g2_decap_4
X_14309_ _14309_/Q _14725_/CLK _14309_/D _14309_/RESET_B VDD VSS sg13g2_dfrbpq_1
XFILLER_145_979 VDD VSS sg13g2_decap_4
XFILLER_144_456 VDD VSS sg13g2_decap_8
XFILLER_116_158 VDD VSS sg13g2_decap_8
XFILLER_160_916 VDD VSS sg13g2_fill_2
XFILLER_89_1199 VDD VSS sg13g2_fill_2
XFILLER_98_510 VDD VSS sg13g2_decap_4
XFILLER_171_275 VDD VSS sg13g2_decap_8
XFILLER_98_532 VDD VSS sg13g2_fill_2
Xfanout707 _11875_/B fanout712/X VDD VSS sg13g2_buf_1
X_09850_ _14437_/D _14437_/Q _09949_/A1 _09862_/S VDD VSS sg13g2_mux2_1
Xfanout718 _12216_/S _07655_/Y VDD VSS sg13g2_buf_1
X_14541__1638 _14541_/RESET_B VDD VSS sg13g2_tiehi
Xfanout729 _11207_/A2 _11045_/A2 VDD VSS sg13g2_buf_1
X_13927__2252 _13927_/RESET_B VDD VSS sg13g2_tiehi
XFILLER_86_716 VDD VSS sg13g2_fill_2
X_14687__1492 _14687_/RESET_B VDD VSS sg13g2_tiehi
X_08801_ _08802_/B _13685_/Q _08818_/B VDD VSS sg13g2_nor2_1
XFILLER_100_515 VDD VSS sg13g2_decap_8
XFILLER_105_28 VDD VSS sg13g2_decap_8
X_09781_ _14370_/D _09913_/A1 _14370_/Q _09800_/S VDD VSS sg13g2_mux2_1
XFILLER_6_1211 VDD VSS sg13g2_decap_8
XFILLER_26_1161 VDD VSS sg13g2_decap_8
X_14795__2918 _14795_/RESET_B VDD VSS sg13g2_tiehi
X_08732_ _13662_/D _08765_/A1 _08730_/Y _08731_/Y VDD VSS sg13g2_a21oi_1
XFILLER_82_900 VDD VSS sg13g2_fill_1
XFILLER_113_1164 VDD VSS sg13g2_decap_8
X_14831__2882 _14831_/RESET_B VDD VSS sg13g2_tiehi
XFILLER_6_1288 VDD VSS sg13g2_decap_8
X_08663_ _08663_/X _08663_/A _08663_/B VDD VSS sg13g2_and2_1
XFILLER_39_687 VDD VSS sg13g2_decap_4
XFILLER_38_164 VDD VSS sg13g2_decap_8
XFILLER_27_827 VDD VSS sg13g2_decap_8
XFILLER_22_1058 VDD VSS sg13g2_decap_8
XFILLER_96_1126 VDD VSS sg13g2_decap_8
XFILLER_96_1137 VDD VSS sg13g2_decap_8
XFILLER_26_337 VDD VSS sg13g2_decap_8
X_07614_ _07614_/Y _14955_/Q VDD VSS sg13g2_inv_1
X_08594_ _08596_/C _08672_/A _07858_/X _07857_/X _08593_/Y VDD VSS sg13g2_a22oi_1
XFILLER_82_977 VDD VSS sg13g2_fill_1
XFILLER_54_668 VDD VSS sg13g2_decap_8
XFILLER_81_476 VDD VSS sg13g2_decap_8
XFILLER_35_893 VDD VSS sg13g2_fill_1
XFILLER_14_14 VDD VSS sg13g2_decap_8
XFILLER_22_532 VDD VSS sg13g2_decap_8
XFILLER_167_504 VDD VSS sg13g2_decap_8
XFILLER_139_217 VDD VSS sg13g2_decap_8
XFILLER_50_874 VDD VSS sg13g2_decap_8
X_09215_ _13826_/D _10145_/A1 _13826_/Q _09238_/S VDD VSS sg13g2_mux2_1
XFILLER_22_587 VDD VSS sg13g2_decap_8
XFILLER_33_1132 VDD VSS sg13g2_decap_8
XFILLER_10_749 VDD VSS sg13g2_decap_8
X_09146_ _13783_/D _13783_/Q _10166_/A1 wire404/X VDD VSS sg13g2_mux2_1
XFILLER_124_1282 VDD VSS sg13g2_decap_8
XFILLER_136_924 VDD VSS sg13g2_decap_8
XFILLER_120_1135 VDD VSS sg13g2_decap_8
XFILLER_135_412 VDD VSS sg13g2_fill_2
XFILLER_148_795 VDD VSS sg13g2_decap_4
XFILLER_108_648 VDD VSS sg13g2_decap_8
XFILLER_30_35 VDD VSS sg13g2_decap_8
XFILLER_108_659 VDD VSS sg13g2_fill_1
X_09077_ _13773_/D _13773_/Q _09924_/A1 _09112_/S VDD VSS sg13g2_mux2_1
XFILLER_162_231 VDD VSS sg13g2_decap_8
XFILLER_68_1228 VDD VSS sg13g2_decap_4
XFILLER_146_35 VDD VSS sg13g2_decap_8
X_08028_ _08031_/C _11428_/A _07910_/B _11461_/A _11483_/A _08253_/S0 _08033_/A VDD
+ VSS sg13g2_mux4_1
XFILLER_150_404 VDD VSS sg13g2_decap_8
XFILLER_135_489 VDD VSS sg13g2_decap_8
XFILLER_150_415 VDD VSS sg13g2_fill_2
XFILLER_163_798 VDD VSS sg13g2_decap_8
X_14180__1999 _14180_/RESET_B VDD VSS sg13g2_tiehi
XFILLER_2_959 VDD VSS sg13g2_decap_8
XFILLER_115_191 VDD VSS sg13g2_fill_1
XFILLER_7_1008 VDD VSS sg13g2_decap_8
XFILLER_89_576 VDD VSS sg13g2_decap_8
XFILLER_1_469 VDD VSS sg13g2_decap_8
X_14517__1662 _14517_/RESET_B VDD VSS sg13g2_tiehi
X_09979_ _14562_/D _10078_/A0 _14562_/Q _09999_/S VDD VSS sg13g2_mux2_1
XFILLER_39_77 VDD VSS sg13g2_fill_2
XFILLER_162_56 VDD VSS sg13g2_decap_8
XFILLER_40_1103 VDD VSS sg13g2_decap_8
X_12990_ _12990_/X _12990_/A _13683_/Q _14904_/Q VDD VSS sg13g2_and3_1
XFILLER_18_805 VDD VSS sg13g2_decap_8
XFILLER_85_771 VDD VSS sg13g2_decap_8
X_11941_ _11941_/Y _11963_/S0 _14160_/Q _11970_/C VDD VSS sg13g2_a21oi_1
XFILLER_55_21 VDD VSS sg13g2_decap_8
XFILLER_40_1169 VDD VSS sg13g2_decap_8
XFILLER_17_315 VDD VSS sg13g2_decap_8
XFILLER_73_955 VDD VSS sg13g2_decap_8
XFILLER_84_292 VDD VSS sg13g2_decap_4
XFILLER_72_432 VDD VSS sg13g2_decap_8
X_14660_ _14660_/Q _14660_/CLK _14660_/D _14660_/RESET_B VDD VSS sg13g2_dfrbpq_1
XFILLER_72_443 VDD VSS sg13g2_fill_1
XFILLER_55_65 VDD VSS sg13g2_decap_8
X_11872_ _11872_/Y _12090_/A _13934_/Q _11894_/B VDD VSS sg13g2_a21oi_1
XFILLER_72_465 VDD VSS sg13g2_decap_8
XFILLER_45_679 VDD VSS sg13g2_decap_8
XFILLER_32_307 VDD VSS sg13g2_fill_1
X_13611_ _15167_/D _13610_/Y _13611_/A2 _13608_/Y VDD VSS sg13g2_a21oi_1
X_10823_ _10823_/Y _10823_/A _10843_/C _10823_/C VDD VSS sg13g2_nand3_1
X_14591_ _14591_/Q _14733_/CLK _14591_/D _14591_/RESET_B VDD VSS sg13g2_dfrbpq_1
XFILLER_77_1081 VDD VSS sg13g2_decap_8
XFILLER_13_532 VDD VSS sg13g2_decap_8
XFILLER_38_1054 VDD VSS sg13g2_decap_8
X_13542_ _13542_/Y _14995_/Q _13566_/C _15003_/Q _13546_/B2 VDD VSS sg13g2_a22oi_1
XFILLER_41_852 VDD VSS sg13g2_decap_8
X_10754_ _10754_/X _14947_/Q _10757_/A _10752_/Y VDD VSS sg13g2_a21o_1
XFILLER_164_1084 VDD VSS sg13g2_decap_8
XFILLER_40_351 VDD VSS sg13g2_decap_8
XFILLER_16_1330 VDD VSS sg13g2_decap_8
XFILLER_9_525 VDD VSS sg13g2_decap_8
X_13473_ _15177_/D hold3039/X _15177_/Q _13477_/S VDD VSS sg13g2_mux2_1
X_10685_ _10685_/Y _12859_/A _10862_/B VDD VSS sg13g2_nand2_1
XFILLER_90_1270 VDD VSS sg13g2_fill_1
X_15212_ _15212_/Q _15214_/CLK _15212_/D _15212_/RESET_B VDD VSS sg13g2_dfrbpq_1
X_12424_ _12424_/X _13824_/Q _13856_/Q _13888_/Q _13920_/Q _12452_/S0 _12452_/S1 VDD
+ VSS sg13g2_mux4_1
XFILLER_173_529 VDD VSS sg13g2_decap_8
XFILLER_154_721 VDD VSS sg13g2_decap_4
XFILLER_103_1355 VDD VSS sg13g2_fill_1
XFILLER_166_581 VDD VSS sg13g2_decap_8
X_15143_ _15143_/Q clkload60/A _15143_/D _15143_/RESET_B VDD VSS sg13g2_dfrbpq_1
X_12355_ _12356_/B _12353_/X _12354_/X _12567_/S VDD VSS sg13g2_mux2_1
XFILLER_5_742 VDD VSS sg13g2_decap_8
XFILLER_153_264 VDD VSS sg13g2_decap_8
X_11306_ _11306_/Y _11302_/Y _11303_/Y _11305_/Y _11304_/Y _11329_/B1 VDD VSS sg13g2_a221oi_1
XFILLER_173_1309 VDD VSS sg13g2_decap_8
X_15074_ _15074_/Q _15159_/CLK _15074_/D _15074_/RESET_B VDD VSS sg13g2_dfrbpq_1
X_12286_ _12286_/X _13977_/Q _14009_/Q _14041_/Q _14073_/Q _12286_/S0 _12286_/S1 VDD
+ VSS sg13g2_mux4_1
XFILLER_99_329 VDD VSS sg13g2_decap_4
XFILLER_4_252 VDD VSS sg13g2_decap_8
XFILLER_141_437 VDD VSS sg13g2_fill_2
XFILLER_113_139 VDD VSS sg13g2_decap_8
X_14025_ _14025_/Q clkload20/A _14025_/D _14025_/RESET_B VDD VSS sg13g2_dfrbpq_1
X_11237_ _11237_/Y _12217_/A _11231_/X _11236_/Y VDD VSS sg13g2_o21ai_1
XFILLER_171_1011 VDD VSS sg13g2_fill_1
XFILLER_171_1022 VDD VSS sg13g2_decap_8
XFILLER_171_1033 VDD VSS sg13g2_fill_1
XFILLER_171_1044 VDD VSS sg13g2_decap_8
XFILLER_122_684 VDD VSS sg13g2_fill_1
X_11168_ _11168_/X _11164_/C _13412_/C _11193_/B1 VDD VSS sg13g2_a21o_1
XFILLER_171_1055 VDD VSS sg13g2_decap_8
XFILLER_121_161 VDD VSS sg13g2_decap_4
XFILLER_136_1186 VDD VSS sg13g2_decap_8
X_10119_ _14697_/D _10152_/A1 _14697_/Q _10135_/S VDD VSS sg13g2_mux2_1
XFILLER_95_557 VDD VSS sg13g2_decap_4
XFILLER_49_952 VDD VSS sg13g2_decap_8
X_11099_ _11099_/Y _11098_/Y _11096_/Y _11095_/Y _11139_/B1 _11207_/A2 VDD VSS sg13g2_a221oi_1
XFILLER_83_708 VDD VSS sg13g2_decap_8
XFILLER_64_900 VDD VSS sg13g2_decap_8
XFILLER_23_1356 VDD VSS sg13g2_decap_8
XFILLER_48_462 VDD VSS sg13g2_decap_8
X_14927_ _14927_/Q clkload69/A _14927_/D _14927_/RESET_B VDD VSS sg13g2_dfrbpq_1
XFILLER_75_270 VDD VSS sg13g2_decap_8
XFILLER_64_944 VDD VSS sg13g2_fill_1
XFILLER_36_635 VDD VSS sg13g2_fill_1
X_14858_ _14858_/Q clkload49/A _14858_/D _14858_/RESET_B VDD VSS sg13g2_dfrbpq_1
XFILLER_91_763 VDD VSS sg13g2_fill_2
XFILLER_36_668 VDD VSS sg13g2_decap_8
XFILLER_1_1141 VDD VSS sg13g2_decap_8
X_13809_ _13809_/Q _14737_/CLK _13809_/D _13809_/RESET_B VDD VSS sg13g2_dfrbpq_1
XFILLER_17_882 VDD VSS sg13g2_decap_8
XFILLER_23_329 VDD VSS sg13g2_decap_8
X_14789_ _14789_/Q _14894_/CLK _14789_/D _14789_/RESET_B VDD VSS sg13g2_dfrbpq_1
XFILLER_50_126 VDD VSS sg13g2_fill_1
XFILLER_32_830 VDD VSS sg13g2_decap_8
XFILLER_143_1102 VDD VSS sg13g2_decap_8
XFILLER_16_392 VDD VSS sg13g2_decap_8
XFILLER_143_1113 VDD VSS sg13g2_fill_2
XFILLER_17_1127 VDD VSS sg13g2_decap_8
XFILLER_91_1078 VDD VSS sg13g2_decap_8
XFILLER_108_1288 VDD VSS sg13g2_decap_4
X_09000_ _09000_/Y _14900_/Q _08993_/X _08999_/Y VDD VSS sg13g2_a21oi_1
XFILLER_164_518 VDD VSS sg13g2_decap_8
XFILLER_77_0 VDD VSS sg13g2_decap_8
XFILLER_129_250 VDD VSS sg13g2_decap_8
XFILLER_30_1338 VDD VSS sg13g2_decap_8
XFILLER_118_957 VDD VSS sg13g2_decap_4
X_15239__3007 _15239_/RESET_B VDD VSS sg13g2_tiehi
XFILLER_144_231 VDD VSS sg13g2_decap_8
XFILLER_172_540 VDD VSS sg13g2_decap_8
XFILLER_133_927 VDD VSS sg13g2_decap_4
XFILLER_6_70 VDD VSS sg13g2_decap_8
XFILLER_172_573 VDD VSS sg13g2_decap_8
XFILLER_160_735 VDD VSS sg13g2_fill_1
XFILLER_172_595 VDD VSS sg13g2_decap_8
XFILLER_160_757 VDD VSS sg13g2_fill_2
X_09902_ _14488_/D _09902_/A0 _14488_/Q _09903_/S VDD VSS sg13g2_mux2_1
XFILLER_116_49 VDD VSS sg13g2_decap_4
Xfanout515 _12707_/A2 _12721_/A2 VDD VSS sg13g2_buf_1
XFILLER_59_705 VDD VSS sg13g2_decap_8
XFILLER_28_1245 VDD VSS sg13g2_decap_8
XFILLER_59_716 VDD VSS sg13g2_fill_2
Xfanout526 _09608_/A0 _10072_/A0 VDD VSS sg13g2_buf_1
XFILLER_98_362 VDD VSS sg13g2_decap_8
Xfanout537 _09117_/A _09162_/A VDD VSS sg13g2_buf_1
X_09833_ _14421_/D _09932_/A1 _14421_/Q _09837_/S VDD VSS sg13g2_mux2_1
XFILLER_113_684 VDD VSS sg13g2_decap_4
XFILLER_154_1275 VDD VSS sg13g2_decap_4
Xfanout548 _13507_/B _08826_/B VDD VSS sg13g2_buf_1
XFILLER_140_481 VDD VSS sg13g2_fill_1
Xfanout559 _13272_/B1 _13264_/B1 VDD VSS sg13g2_buf_1
XFILLER_140_492 VDD VSS sg13g2_decap_8
XFILLER_112_194 VDD VSS sg13g2_decap_8
XFILLER_86_557 VDD VSS sg13g2_decap_4
X_09764_ _14354_/D _14354_/Q _10061_/A0 _09772_/S VDD VSS sg13g2_mux2_1
XFILLER_86_579 VDD VSS sg13g2_decap_4
X_08715_ _08715_/X hold3085/X _15190_/Q _08721_/S VDD VSS sg13g2_mux2_1
XFILLER_6_1085 VDD VSS sg13g2_decap_8
XFILLER_55_933 VDD VSS sg13g2_decap_8
X_09695_ _14287_/D _10125_/A0 _14287_/Q _09697_/S VDD VSS sg13g2_mux2_1
XFILLER_54_421 VDD VSS sg13g2_decap_8
XFILLER_26_112 VDD VSS sg13g2_decap_8
X_08646_ _08646_/Y _08646_/A _08646_/B _08646_/C VDD VSS sg13g2_nand3_1
XFILLER_55_977 VDD VSS sg13g2_fill_2
XFILLER_15_819 VDD VSS sg13g2_decap_8
XFILLER_82_763 VDD VSS sg13g2_decap_4
X_14759__2957 _14759_/RESET_B VDD VSS sg13g2_tiehi
XFILLER_42_605 VDD VSS sg13g2_decap_8
XFILLER_148_1046 VDD VSS sg13g2_decap_8
XFILLER_54_476 VDD VSS sg13g2_fill_2
XFILLER_25_35 VDD VSS sg13g2_decap_8
XFILLER_14_329 VDD VSS sg13g2_decap_8
XFILLER_26_189 VDD VSS sg13g2_decap_8
XFILLER_155_7 VDD VSS sg13g2_decap_8
X_08577_ _08577_/Y _08649_/S _08577_/B VDD VSS sg13g2_nor2_1
XFILLER_168_824 VDD VSS sg13g2_decap_8
Xclkbuf_5_0__f_clk_i clkbuf_leaf_2_clk_i/A clkbuf_4_0_0_clk_i/X VDD VSS sg13g2_buf_16
XFILLER_167_301 VDD VSS sg13g2_decap_8
XFILLER_161_1224 VDD VSS sg13g2_decap_8
XFILLER_161_1235 VDD VSS sg13g2_decap_4
XFILLER_35_1249 VDD VSS sg13g2_decap_8
XFILLER_168_879 VDD VSS sg13g2_decap_8
XFILLER_10_546 VDD VSS sg13g2_decap_8
XFILLER_167_378 VDD VSS sg13g2_decap_8
X_10470_ _10477_/C _14845_/Q _10500_/A _10471_/C _10471_/D VDD VSS sg13g2_and4_1
XFILLER_41_56 VDD VSS sg13g2_decap_8
XFILLER_109_935 VDD VSS sg13g2_fill_2
XFILLER_109_946 VDD VSS sg13g2_fill_2
XFILLER_6_539 VDD VSS sg13g2_decap_8
XFILLER_157_56 VDD VSS sg13g2_decap_8
X_09129_ _09129_/Y _13200_/A _09157_/C _09162_/A VDD VSS sg13g2_o21ai_1
XFILLER_68_1003 VDD VSS sg13g2_decap_8
X_13799__2380 _13799_/RESET_B VDD VSS sg13g2_tiehi
XFILLER_11_1260 VDD VSS sg13g2_decap_8
XFILLER_124_927 VDD VSS sg13g2_decap_4
XFILLER_159_1153 VDD VSS sg13g2_decap_4
X_12140_ _12140_/X _13973_/Q _14005_/Q _14037_/Q _14069_/Q _12140_/S0 _12140_/S1 VDD
+ VSS sg13g2_mux4_1
XFILLER_163_595 VDD VSS sg13g2_decap_4
X_12071_ _12071_/X _13747_/Q _14099_/Q _14451_/Q _14547_/Q _12073_/S0 _12073_/S1 VDD
+ VSS sg13g2_mux4_1
XFILLER_123_459 VDD VSS sg13g2_decap_8
XFILLER_151_768 VDD VSS sg13g2_fill_1
XFILLER_2_756 VDD VSS sg13g2_decap_8
XFILLER_85_1383 VDD VSS sg13g2_fill_1
XFILLER_110_109 VDD VSS sg13g2_fill_2
X_11022_ _11022_/Y _11022_/A _11022_/B VDD VSS sg13g2_nand2_1
XFILLER_1_266 VDD VSS sg13g2_decap_8
XFILLER_173_77 VDD VSS sg13g2_decap_8
X_14033__2146 _14033_/RESET_B VDD VSS sg13g2_tiehi
X_14912__2720 _14912_/RESET_B VDD VSS sg13g2_tiehi
XFILLER_2_28 VDD VSS sg13g2_decap_8
XFILLER_66_53 VDD VSS sg13g2_decap_8
XFILLER_18_602 VDD VSS sg13g2_decap_8
XFILLER_64_218 VDD VSS sg13g2_decap_8
XFILLER_58_782 VDD VSS sg13g2_decap_8
X_12973_ _12988_/D _14905_/Q _13682_/Q VDD VSS sg13g2_xnor2_1
XFILLER_92_549 VDD VSS sg13g2_decap_4
XFILLER_17_112 VDD VSS sg13g2_decap_8
X_14712_ _14712_/Q _14744_/CLK _14712_/D _14712_/RESET_B VDD VSS sg13g2_dfrbpq_1
X_11924_ _11924_/X _14127_/Q _14159_/Q _14191_/Q _14223_/Q _11925_/S0 _11925_/S1 VDD
+ VSS sg13g2_mux4_1
XFILLER_73_752 VDD VSS sg13g2_decap_8
X_14945__2654 _14945_/RESET_B VDD VSS sg13g2_tiehi
XFILLER_79_1165 VDD VSS sg13g2_fill_2
XFILLER_61_914 VDD VSS sg13g2_decap_4
XFILLER_33_605 VDD VSS sg13g2_decap_8
XFILLER_18_679 VDD VSS sg13g2_decap_8
XFILLER_45_476 VDD VSS sg13g2_decap_8
XFILLER_33_616 VDD VSS sg13g2_fill_1
XFILLER_122_81 VDD VSS sg13g2_decap_8
XFILLER_33_627 VDD VSS sg13g2_decap_8
X_14643_ _14643_/Q clkload22/A _14643_/D _14643_/RESET_B VDD VSS sg13g2_dfrbpq_1
X_11855_ _11856_/B _11847_/X _11848_/X _11851_/X _11852_/X _11973_/B _11999_/S1 VDD
+ VSS sg13g2_mux4_1
XFILLER_17_189 VDD VSS sg13g2_decap_8
XFILLER_72_295 VDD VSS sg13g2_decap_8
XFILLER_32_126 VDD VSS sg13g2_decap_8
XFILLER_82_63 VDD VSS sg13g2_fill_1
X_10806_ _10807_/C _15121_/Q _10813_/A VDD VSS sg13g2_xnor2_1
X_14574_ _14574_/Q clkload39/A _14574_/D _14574_/RESET_B VDD VSS sg13g2_dfrbpq_1
XFILLER_158_312 VDD VSS sg13g2_decap_8
X_11786_ _11786_/X _14379_/Q _14411_/Q _14475_/Q _14507_/Q _11848_/S0 _11851_/S1 VDD
+ VSS sg13g2_mux4_1
XFILLER_53_1327 VDD VSS sg13g2_decap_8
XFILLER_14_896 VDD VSS sg13g2_decap_8
X_13525_ _13525_/X _13525_/A _13533_/B VDD VSS sg13g2_and2_1
XFILLER_9_322 VDD VSS sg13g2_decap_8
X_10737_ _10737_/Y _13088_/A _11048_/B VDD VSS sg13g2_nand2_1
XFILLER_139_570 VDD VSS sg13g2_decap_8
X_13456_ _13456_/X _15190_/Q _15191_/Q _15192_/Q _13463_/D VDD VSS sg13g2_or4_1
XFILLER_70_7 VDD VSS sg13g2_decap_8
XFILLER_51_1051 VDD VSS sg13g2_fill_1
XFILLER_173_315 VDD VSS sg13g2_decap_8
XFILLER_103_1130 VDD VSS sg13g2_decap_4
X_10668_ _10802_/A _10781_/C _10697_/B _14926_/Q VDD VSS sg13g2_a21oi_1
XFILLER_9_399 VDD VSS sg13g2_decap_8
X_12407_ _12407_/X _14239_/Q _14271_/Q _14303_/Q _14335_/Q _12606_/S0 _12606_/S1 VDD
+ VSS sg13g2_mux4_1
XFILLER_154_540 VDD VSS sg13g2_decap_4
XFILLER_12_1057 VDD VSS sg13g2_decap_8
X_13387_ _15082_/D _13367_/Y _13378_/C _13386_/Y VDD VSS sg13g2_o21ai_1
X_15123__2713 _15123_/RESET_B VDD VSS sg13g2_tiehi
X_10599_ _14876_/D _10599_/A _10599_/B _10610_/D VDD VSS sg13g2_nor3_1
XFILLER_115_916 VDD VSS sg13g2_decap_8
X_14243__1936 _14243_/RESET_B VDD VSS sg13g2_tiehi
Xoutput107 mem_axi_wdata[12] _15144_/Q VDD VSS sg13g2_buf_1
XFILLER_115_927 VDD VSS sg13g2_fill_1
XFILLER_142_713 VDD VSS sg13g2_decap_4
X_14389__1790 _14389_/RESET_B VDD VSS sg13g2_tiehi
X_15126_ _15126_/Q clkload71/A _15126_/D _15126_/RESET_B VDD VSS sg13g2_dfrbpq_1
Xoutput118 mem_axi_wdata[22] _15154_/Q VDD VSS sg13g2_buf_1
XFILLER_138_1215 VDD VSS sg13g2_decap_4
XFILLER_154_584 VDD VSS sg13g2_decap_4
Xoutput129 mem_axi_wdata[3] _15135_/Q VDD VSS sg13g2_buf_1
X_12338_ _12338_/Y _14925_/Q _12338_/A2 _12334_/Y _12337_/Y VDD VSS sg13g2_a22oi_1
XFILLER_115_949 VDD VSS sg13g2_fill_1
XFILLER_108_990 VDD VSS sg13g2_fill_1
XFILLER_141_212 VDD VSS sg13g2_decap_8
XFILLER_99_126 VDD VSS sg13g2_decap_8
XFILLER_114_459 VDD VSS sg13g2_decap_8
XFILLER_130_908 VDD VSS sg13g2_decap_8
X_15057_ _15057_/Q clkload72/A _15057_/D _15057_/RESET_B VDD VSS sg13g2_dfrbpq_1
X_12269_ _12270_/B _12231_/X _12294_/B1 _12268_/Y VDD VSS sg13g2_a21oi_1
X_14008_ _14008_/Q _14744_/CLK _14008_/D _14008_/RESET_B VDD VSS sg13g2_dfrbpq_1
XFILLER_122_470 VDD VSS sg13g2_decap_8
X_14009__2170 _14009_/RESET_B VDD VSS sg13g2_tiehi
XFILLER_110_665 VDD VSS sg13g2_decap_8
XFILLER_7_1372 VDD VSS sg13g2_decap_8
XFILLER_110_698 VDD VSS sg13g2_decap_8
XFILLER_95_387 VDD VSS sg13g2_decap_4
XFILLER_3_1225 VDD VSS sg13g2_decap_8
XFILLER_37_922 VDD VSS sg13g2_decap_8
XFILLER_23_1153 VDD VSS sg13g2_decap_8
XFILLER_83_538 VDD VSS sg13g2_fill_1
XFILLER_55_229 VDD VSS sg13g2_decap_4
XFILLER_48_270 VDD VSS sg13g2_decap_8
XFILLER_76_590 VDD VSS sg13g2_decap_8
X_08500_ _08501_/B _08527_/B _08498_/Y _08499_/Y VDD VSS sg13g2_a21o_1
X_09480_ _14080_/D _10043_/A0 _14080_/Q _09502_/S VDD VSS sg13g2_mux2_1
XFILLER_52_903 VDD VSS sg13g2_fill_1
XFILLER_37_977 VDD VSS sg13g2_decap_8
XFILLER_110_1167 VDD VSS sg13g2_decap_4
XFILLER_52_914 VDD VSS sg13g2_decap_8
XFILLER_97_1276 VDD VSS sg13g2_decap_8
X_08431_ _08431_/X _08431_/A _08544_/B _08431_/C _08431_/D VDD VSS sg13g2_and4_1
X_13731__2448 _13731_/RESET_B VDD VSS sg13g2_tiehi
X_14491__1688 _14491_/RESET_B VDD VSS sg13g2_tiehi
XFILLER_23_126 VDD VSS sg13g2_decap_8
X_08362_ _08362_/X _07790_/A _07782_/A _07786_/A _07775_/A _13509_/A1 _13510_/A1 VDD
+ VSS sg13g2_mux4_1
XFILLER_108_1063 VDD VSS sg13g2_decap_4
X_08293_ _15228_/D _08293_/A _08293_/B VDD VSS sg13g2_nand2_1
XFILLER_20_833 VDD VSS sg13g2_decap_8
XFILLER_149_356 VDD VSS sg13g2_decap_8
XFILLER_34_1260 VDD VSS sg13g2_fill_2
XFILLER_164_315 VDD VSS sg13g2_decap_8
XFILLER_165_849 VDD VSS sg13g2_fill_2
X_14111__2068 _14111_/RESET_B VDD VSS sg13g2_tiehi
XFILLER_118_721 VDD VSS sg13g2_decap_8
XFILLER_121_1230 VDD VSS sg13g2_decap_8
XFILLER_121_1241 VDD VSS sg13g2_fill_2
XFILLER_30_1135 VDD VSS sg13g2_decap_8
XFILLER_117_231 VDD VSS sg13g2_decap_8
XFILLER_69_1323 VDD VSS sg13g2_decap_8
XFILLER_121_1274 VDD VSS sg13g2_decap_8
XFILLER_133_702 VDD VSS sg13g2_decap_8
XFILLER_145_573 VDD VSS sg13g2_decap_8
XFILLER_118_798 VDD VSS sg13g2_decap_8
X_14219__1960 _14219_/RESET_B VDD VSS sg13g2_tiehi
Xpicorv32_macro_1417 mem_axi_arprot[1] VDD VSS sg13g2_tielo
XFILLER_114_960 VDD VSS sg13g2_decap_8
Xfanout301 fanout301/X _08983_/X VDD VSS sg13g2_buf_1
Xfanout312 _10098_/S _10070_/Y VDD VSS sg13g2_buf_1
XFILLER_99_671 VDD VSS sg13g2_decap_8
XFILLER_67_1091 VDD VSS sg13g2_decap_8
XFILLER_115_1001 VDD VSS sg13g2_decap_8
Xfanout323 _09928_/S _09937_/S VDD VSS sg13g2_buf_1
XFILLER_154_1061 VDD VSS sg13g2_decap_8
Xfanout334 _09772_/S _09769_/S VDD VSS sg13g2_buf_1
XFILLER_119_1181 VDD VSS sg13g2_fill_1
XFILLER_143_14 VDD VSS sg13g2_decap_8
XFILLER_86_310 VDD VSS sg13g2_decap_8
XFILLER_101_632 VDD VSS sg13g2_decap_8
Xfanout345 _09705_/S _09703_/S VDD VSS sg13g2_buf_1
Xfanout356 _09502_/S _09505_/S VDD VSS sg13g2_buf_1
X_09816_ _14404_/D _09915_/A1 _14404_/Q _09831_/S VDD VSS sg13g2_mux2_1
XFILLER_8_1169 VDD VSS sg13g2_decap_8
Xfanout389 _09911_/A1 _08996_/Y VDD VSS sg13g2_buf_1
XFILLER_80_1291 VDD VSS sg13g2_decap_8
XFILLER_132_1370 VDD VSS sg13g2_fill_1
X_09747_ _14337_/D _14337_/Q _09780_/A0 _09771_/S VDD VSS sg13g2_mux2_1
XFILLER_74_538 VDD VSS sg13g2_decap_8
XFILLER_27_421 VDD VSS sg13g2_decap_8
XFILLER_39_292 VDD VSS sg13g2_decap_8
X_09678_ _14270_/D _09909_/A1 _14270_/Q _09700_/S VDD VSS sg13g2_mux2_1
XFILLER_36_56 VDD VSS sg13g2_decap_8
XFILLER_28_988 VDD VSS sg13g2_fill_2
XFILLER_70_700 VDD VSS sg13g2_decap_4
XFILLER_54_251 VDD VSS sg13g2_decap_8
XFILLER_15_616 VDD VSS sg13g2_decap_8
XFILLER_43_936 VDD VSS sg13g2_decap_8
X_08629_ _08629_/Y _08641_/B _08611_/Y _07966_/Y VDD VSS sg13g2_a21oi_1
XFILLER_14_126 VDD VSS sg13g2_decap_8
X_14321__1858 _14321_/RESET_B VDD VSS sg13g2_tiehi
X_13707__2472 _13707_/RESET_B VDD VSS sg13g2_tiehi
X_11640_ _11774_/A _11638_/X _11639_/Y _11590_/Y VDD VSS sg13g2_a21oi_1
XFILLER_35_1002 VDD VSS sg13g2_fill_1
XFILLER_126_1152 VDD VSS sg13g2_decap_8
XFILLER_11_833 VDD VSS sg13g2_decap_8
X_11571_ _11571_/Y _11638_/A _11638_/C _11571_/C VDD VSS sg13g2_nor3_1
XFILLER_161_1054 VDD VSS sg13g2_fill_1
XFILLER_35_1057 VDD VSS sg13g2_fill_1
X_13310_ _13310_/Y _15071_/Q _13305_/B _13307_/Y _13310_/B2 _13308_/Y VDD VSS sg13g2_a221oi_1
XFILLER_10_343 VDD VSS sg13g2_decap_8
XFILLER_168_698 VDD VSS sg13g2_decap_8
X_10522_ _14856_/D _13141_/A _10522_/B _10531_/D VDD VSS sg13g2_nor3_1
XFILLER_167_175 VDD VSS sg13g2_decap_8
XFILLER_168_77 VDD VSS sg13g2_decap_8
X_14290_ _14290_/Q _14632_/CLK _14290_/D _14290_/RESET_B VDD VSS sg13g2_dfrbpq_1
XFILLER_7_826 VDD VSS sg13g2_decap_8
XFILLER_13_1344 VDD VSS sg13g2_decap_8
XFILLER_100_1303 VDD VSS sg13g2_decap_8
X_13241_ _13242_/B _13245_/A _13665_/Q _13246_/C VDD VSS sg13g2_a21oi_1
X_10453_ _10453_/X _14840_/Q _14839_/Q _10453_/C _10514_/A VDD VSS sg13g2_and4_1
XFILLER_6_336 VDD VSS sg13g2_decap_8
XFILLER_124_702 VDD VSS sg13g2_fill_1
XFILLER_108_264 VDD VSS sg13g2_decap_8
XFILLER_109_798 VDD VSS sg13g2_decap_8
XFILLER_170_329 VDD VSS sg13g2_decap_8
X_13172_ _13172_/X _13172_/A _13172_/B _13172_/C _13172_/D VDD VSS sg13g2_and4_1
X_10384_ _10398_/D _14818_/Q _14819_/Q _10396_/C VDD VSS sg13g2_and3_1
X_14790__2923 _14790_/RESET_B VDD VSS sg13g2_tiehi
XFILLER_124_746 VDD VSS sg13g2_decap_8
XFILLER_123_223 VDD VSS sg13g2_decap_8
XFILLER_163_392 VDD VSS sg13g2_decap_8
X_12123_ _12123_/Y _12123_/A1 _12122_/Y _12082_/B VDD VSS sg13g2_o21ai_1
XFILLER_7_0 VDD VSS sg13g2_decap_8
XFILLER_2_553 VDD VSS sg13g2_decap_8
XFILLER_105_971 VDD VSS sg13g2_fill_1
XFILLER_46_1131 VDD VSS sg13g2_decap_4
X_12054_ _12054_/Y _12055_/C _12055_/D VDD VSS sg13g2_nor2_1
XFILLER_81_1022 VDD VSS sg13g2_decap_8
XFILLER_78_822 VDD VSS sg13g2_fill_2
XFILLER_105_993 VDD VSS sg13g2_decap_8
X_15091__2801 _15091_/RESET_B VDD VSS sg13g2_tiehi
XFILLER_42_1006 VDD VSS sg13g2_decap_4
X_11005_ _11005_/X _11005_/A _11007_/A VDD VSS sg13g2_or2_1
X_16862_ _16862_/X _16862_/A VDD VSS sg13g2_buf_1
XFILLER_38_708 VDD VSS sg13g2_decap_8
XFILLER_81_1099 VDD VSS sg13g2_fill_2
Xfanout890 _12452_/S0 _12437_/S0 VDD VSS sg13g2_buf_1
X_15152__2653 _15152_/RESET_B VDD VSS sg13g2_tiehi
XFILLER_92_357 VDD VSS sg13g2_decap_8
XFILLER_20_1337 VDD VSS sg13g2_decap_8
XFILLER_19_966 VDD VSS sg13g2_decap_8
X_12956_ _15030_/D _12956_/A _12956_/B VDD VSS sg13g2_and2_1
XFILLER_92_368 VDD VSS sg13g2_fill_1
X_15238__3006 _15238_/RESET_B VDD VSS sg13g2_tiehi
XFILLER_18_476 VDD VSS sg13g2_decap_8
X_11907_ _11907_/X _11907_/A _11907_/B _11910_/B _11910_/C VDD VSS sg13g2_or4_1
X_12887_ _12887_/Y _12886_/Y _07683_/A _12882_/Y VDD VSS sg13g2_a21oi_1
X_14626_ _14626_/Q clkload29/A _14626_/D _14626_/RESET_B VDD VSS sg13g2_dfrbpq_1
XFILLER_18_1211 VDD VSS sg13g2_decap_8
XFILLER_159_610 VDD VSS sg13g2_decap_8
X_11838_ _11839_/B _11800_/Y _12123_/A1 _11837_/Y VDD VSS sg13g2_a21oi_1
XFILLER_33_479 VDD VSS sg13g2_decap_8
XFILLER_144_1241 VDD VSS sg13g2_decap_8
XFILLER_92_1184 VDD VSS sg13g2_decap_8
XFILLER_14_693 VDD VSS sg13g2_decap_8
X_14557_ _14557_/Q _14653_/CLK _14557_/D _14557_/RESET_B VDD VSS sg13g2_dfrbpq_1
X_11769_ _14972_/D _11729_/Y _11768_/Y _11724_/Y VDD VSS sg13g2_a21oi_1
XFILLER_119_507 VDD VSS sg13g2_decap_4
XFILLER_18_1288 VDD VSS sg13g2_decap_8
XFILLER_144_1296 VDD VSS sg13g2_fill_1
X_13508_ _13508_/X _13613_/A _13508_/B _13508_/C VDD VSS sg13g2_and3_1
XFILLER_158_175 VDD VSS sg13g2_decap_8
X_14488_ _14488_/Q _14744_/CLK _14488_/D _14488_/RESET_B VDD VSS sg13g2_dfrbpq_1
X_14476__1703 _14476_/RESET_B VDD VSS sg13g2_tiehi
XFILLER_173_112 VDD VSS sg13g2_decap_8
XFILLER_146_348 VDD VSS sg13g2_fill_2
XFILLER_9_196 VDD VSS sg13g2_decap_8
X_13439_ _15101_/D _13435_/B _13438_/Y _13437_/Y VDD VSS sg13g2_o21ai_1
XFILLER_127_551 VDD VSS sg13g2_decap_8
XFILLER_155_871 VDD VSS sg13g2_decap_8
X_15109_ _15109_/Q clkload67/A _15109_/D _15109_/RESET_B VDD VSS sg13g2_dfrbpq_1
X_08980_ _08980_/X _15024_/Q _15221_/Q _13305_/A VDD VSS sg13g2_mux2_1
XFILLER_114_289 VDD VSS sg13g2_decap_4
XFILLER_138_1089 VDD VSS sg13g2_fill_1
X_07931_ _08286_/B _14998_/Q _08258_/C VDD VSS sg13g2_nor2b_1
XFILLER_116_1321 VDD VSS sg13g2_decap_8
XFILLER_151_1201 VDD VSS sg13g2_decap_4
XFILLER_64_1253 VDD VSS sg13g2_decap_8
XFILLER_29_1373 VDD VSS sg13g2_decap_8
XFILLER_25_1204 VDD VSS sg13g2_decap_8
XFILLER_60_1117 VDD VSS sg13g2_decap_8
XFILLER_111_963 VDD VSS sg13g2_decap_8
XFILLER_5_1309 VDD VSS sg13g2_decap_8
XFILLER_116_1365 VDD VSS sg13g2_decap_4
X_07862_ _07862_/Y _08608_/A _08608_/B VDD VSS sg13g2_nor2_1
XFILLER_96_685 VDD VSS sg13g2_decap_8
XFILLER_28_207 VDD VSS sg13g2_decap_8
X_09601_ _14198_/D _14198_/Q _09900_/A0 _09601_/S VDD VSS sg13g2_mux2_1
XFILLER_95_162 VDD VSS sg13g2_decap_8
XFILLER_96_696 VDD VSS sg13g2_fill_2
XFILLER_95_173 VDD VSS sg13g2_fill_2
XFILLER_113_28 VDD VSS sg13g2_fill_1
XFILLER_56_538 VDD VSS sg13g2_fill_1
X_07793_ _07793_/Y _08383_/B _08383_/A VDD VSS sg13g2_nor2b_1
XFILLER_56_549 VDD VSS sg13g2_fill_2
XFILLER_3_1022 VDD VSS sg13g2_decap_8
X_09532_ _14131_/D _09666_/A0 _14131_/Q _09535_/S VDD VSS sg13g2_mux2_1
X_13964__2215 _13964_/RESET_B VDD VSS sg13g2_tiehi
XFILLER_58_1035 VDD VSS sg13g2_decap_8
XFILLER_3_1099 VDD VSS sg13g2_decap_8
X_09463_ _14064_/D _09696_/A0 _14064_/Q _09473_/S VDD VSS sg13g2_mux2_1
XFILLER_19_1008 VDD VSS sg13g2_decap_8
XFILLER_24_446 VDD VSS sg13g2_fill_1
X_08414_ _08415_/B _08414_/A _08414_/B _08414_/C _08414_/D VDD VSS sg13g2_nor4_1
XFILLER_58_1079 VDD VSS sg13g2_decap_8
X_09394_ _13997_/D _09625_/A0 _13997_/Q _09398_/S VDD VSS sg13g2_mux2_1
XFILLER_145_1049 VDD VSS sg13g2_decap_4
XFILLER_162_1330 VDD VSS sg13g2_decap_8
XFILLER_71_1224 VDD VSS sg13g2_decap_8
XFILLER_36_1344 VDD VSS sg13g2_decap_8
XFILLER_123_1303 VDD VSS sg13g2_fill_2
X_08345_ _08346_/B _08270_/B _08177_/X _08344_/Y VDD VSS sg13g2_o21ai_1
XFILLER_20_630 VDD VSS sg13g2_decap_8
XFILLER_165_602 VDD VSS sg13g2_decap_4
XFILLER_22_14 VDD VSS sg13g2_decap_8
XFILLER_32_1219 VDD VSS sg13g2_decap_8
X_08276_ _08276_/X _08276_/A _08276_/B VDD VSS sg13g2_or2_1
XFILLER_165_635 VDD VSS sg13g2_fill_1
XFILLER_138_14 VDD VSS sg13g2_decap_8
XFILLER_164_112 VDD VSS sg13g2_decap_8
XFILLER_137_337 VDD VSS sg13g2_decap_8
XFILLER_118_551 VDD VSS sg13g2_decap_4
XFILLER_118_7 VDD VSS sg13g2_decap_8
XFILLER_121_1071 VDD VSS sg13g2_decap_8
XFILLER_164_189 VDD VSS sg13g2_decap_8
XFILLER_69_1153 VDD VSS sg13g2_fill_2
XFILLER_106_746 VDD VSS sg13g2_decap_8
XFILLER_133_543 VDD VSS sg13g2_decap_8
Xclkbuf_leaf_0_clk_i clkload0/A clkbuf_leaf_2_clk_i/A VDD VSS sg13g2_buf_8
XFILLER_0_7 VDD VSS sg13g2_decap_8
XFILLER_160_351 VDD VSS sg13g2_decap_8
XFILLER_161_874 VDD VSS sg13g2_decap_8
XFILLER_154_35 VDD VSS sg13g2_decap_8
Xfanout1107 _08541_/B _08598_/A3 VDD VSS sg13g2_buf_1
Xfanout1118 _08510_/A1 _11914_/A VDD VSS sg13g2_buf_1
XFILLER_43_1304 VDD VSS sg13g2_decap_8
Xfanout1129 _07946_/B _11770_/A VDD VSS sg13g2_buf_1
XFILLER_43_1315 VDD VSS sg13g2_fill_2
Xfanout142 _09970_/A1 _10102_/A0 VDD VSS sg13g2_buf_1
Xfanout153 _09636_/A0 _09902_/A0 VDD VSS sg13g2_buf_1
Xfanout164 _09900_/A0 _09138_/X VDD VSS sg13g2_buf_1
Xfanout175 _09931_/A1 _10163_/A1 VDD VSS sg13g2_buf_1
Xfanout186 _10161_/A1 _09111_/Y VDD VSS sg13g2_buf_1
XFILLER_59_376 VDD VSS sg13g2_decap_4
Xfanout197 _09696_/A0 _09828_/A0 VDD VSS sg13g2_buf_1
XFILLER_75_847 VDD VSS sg13g2_fill_1
XFILLER_75_869 VDD VSS sg13g2_decap_8
XFILLER_170_56 VDD VSS sg13g2_decap_8
X_12810_ _12810_/Y _12806_/Y _12807_/Y _12809_/Y VDD VSS sg13g2_a21oi_1
XFILLER_16_903 VDD VSS sg13g2_decap_8
XFILLER_90_817 VDD VSS sg13g2_fill_2
X_13790_ _13790_/Q _14653_/CLK _13790_/D _13790_/RESET_B VDD VSS sg13g2_dfrbpq_1
X_14554__1625 _14554_/RESET_B VDD VSS sg13g2_tiehi
XFILLER_90_839 VDD VSS sg13g2_decap_8
XFILLER_167_1230 VDD VSS sg13g2_decap_8
XFILLER_43_711 VDD VSS sg13g2_decap_8
XFILLER_15_413 VDD VSS sg13g2_decap_8
X_12741_ _12741_/X _14711_/Q _14743_/Q _13783_/Q _13815_/Q _12752_/S0 _12752_/S1 VDD
+ VSS sg13g2_mux4_1
XFILLER_63_21 VDD VSS sg13g2_decap_8
XFILLER_103_94 VDD VSS sg13g2_decap_4
XFILLER_128_1225 VDD VSS sg13g2_decap_8
XFILLER_163_1116 VDD VSS sg13g2_fill_2
XFILLER_128_1247 VDD VSS sg13g2_decap_4
X_12672_ _12672_/X _14578_/Q _14610_/Q _14642_/Q _14674_/Q _12758_/S0 _12758_/S1 VDD
+ VSS sg13g2_mux4_1
XFILLER_31_928 VDD VSS sg13g2_decap_8
XFILLER_163_1149 VDD VSS sg13g2_decap_8
XFILLER_128_1269 VDD VSS sg13g2_decap_8
XFILLER_70_585 VDD VSS sg13g2_decap_8
XFILLER_144_0 VDD VSS sg13g2_decap_8
X_14411_ _14411_/Q clkload4/A _14411_/D _14411_/RESET_B VDD VSS sg13g2_dfrbpq_1
X_11623_ _11623_/Y _11599_/Y _11601_/Y _12000_/A VDD VSS sg13g2_a21oi_1
XFILLER_11_630 VDD VSS sg13g2_decap_8
XFILLER_23_490 VDD VSS sg13g2_decap_8
XFILLER_168_462 VDD VSS sg13g2_decap_8
XFILLER_50_1308 VDD VSS sg13g2_fill_1
XFILLER_8_49 VDD VSS sg13g2_decap_8
XFILLER_50_1319 VDD VSS sg13g2_fill_1
X_14342_ _14342_/Q clkload11/A _14342_/D _14342_/RESET_B VDD VSS sg13g2_dfrbpq_1
XFILLER_10_140 VDD VSS sg13g2_decap_8
X_11554_ _11554_/Y _11550_/Y _11551_/Y _11553_/Y _11552_/Y _11549_/B VDD VSS sg13g2_a221oi_1
XFILLER_128_326 VDD VSS sg13g2_fill_1
XFILLER_155_112 VDD VSS sg13g2_decap_8
XFILLER_7_623 VDD VSS sg13g2_decap_8
XFILLER_13_1141 VDD VSS sg13g2_decap_8
X_10505_ _10654_/A _10514_/A _10505_/B _10505_/C _10505_/D VDD VSS sg13g2_nand4_1
X_14273_ _14273_/Q clkload31/A _14273_/D _14273_/RESET_B VDD VSS sg13g2_dfrbpq_1
XFILLER_6_133 VDD VSS sg13g2_decap_8
X_11485_ _11485_/Y _11485_/A _11485_/B VDD VSS sg13g2_xnor2_1
X_13224_ _13226_/B _13224_/A _13215_/A VDD VSS sg13g2_nor2b_1
X_10436_ _10436_/Y _14835_/Q _10443_/D _10441_/C VDD VSS sg13g2_o21ai_1
XFILLER_12_91 VDD VSS sg13g2_decap_8
XFILLER_170_126 VDD VSS sg13g2_decap_8
XFILLER_87_1253 VDD VSS sg13g2_fill_2
XFILLER_48_1204 VDD VSS sg13g2_fill_2
XFILLER_174_1201 VDD VSS sg13g2_decap_8
XFILLER_171_649 VDD VSS sg13g2_decap_8
XFILLER_3_840 VDD VSS sg13g2_decap_8
XFILLER_100_1188 VDD VSS sg13g2_fill_2
XFILLER_124_554 VDD VSS sg13g2_decap_8
X_13155_ _15043_/D _13155_/A _13155_/B VDD VSS sg13g2_nor2_1
XFILLER_112_705 VDD VSS sg13g2_fill_1
X_10367_ _10400_/C _14812_/Q _14813_/Q _14814_/Q VDD VSS sg13g2_nand3_1
XFILLER_88_73 VDD VSS sg13g2_decap_8
XFILLER_2_350 VDD VSS sg13g2_decap_8
XFILLER_152_896 VDD VSS sg13g2_decap_8
X_12106_ _12106_/Y _12102_/Y _12103_/Y _12105_/Y _12104_/Y _12253_/B VDD VSS sg13g2_a221oi_1
XFILLER_174_1278 VDD VSS sg13g2_decap_8
XFILLER_112_738 VDD VSS sg13g2_fill_2
XFILLER_97_438 VDD VSS sg13g2_fill_1
XFILLER_33_7 VDD VSS sg13g2_decap_8
XFILLER_112_749 VDD VSS sg13g2_decap_4
X_13086_ _13087_/B _13166_/A1 _13081_/X _13085_/Y _13140_/B2 _13080_/Y VDD VSS sg13g2_a221oi_1
X_10298_ _10299_/C _14791_/Q _14792_/Q _14793_/Q _10298_/D VDD VSS sg13g2_nand4_1
XFILLER_174_1289 VDD VSS sg13g2_decap_8
X_14754__2962 _14754_/RESET_B VDD VSS sg13g2_tiehi
X_12037_ _12037_/Y _11969_/A _14130_/Q VDD VSS sg13g2_nand2b_1
XFILLER_120_771 VDD VSS sg13g2_fill_2
XFILLER_78_696 VDD VSS sg13g2_decap_8
XFILLER_65_313 VDD VSS sg13g2_decap_8
X_14193__1986 _14193_/RESET_B VDD VSS sg13g2_tiehi
XFILLER_93_644 VDD VSS sg13g2_decap_8
XFILLER_65_335 VDD VSS sg13g2_decap_8
XFILLER_24_1281 VDD VSS sg13g2_decap_8
XFILLER_92_143 VDD VSS sg13g2_decap_8
XFILLER_0_1206 VDD VSS sg13g2_decap_8
XFILLER_20_1134 VDD VSS sg13g2_decap_8
XFILLER_19_763 VDD VSS sg13g2_decap_8
XFILLER_111_1262 VDD VSS sg13g2_fill_1
X_13988_ _13988_/Q clkload17/A _13988_/D _13988_/RESET_B VDD VSS sg13g2_dfrbpq_1
XFILLER_92_165 VDD VSS sg13g2_decap_8
XFILLER_46_582 VDD VSS sg13g2_decap_8
XFILLER_18_273 VDD VSS sg13g2_decap_8
X_12939_ _12939_/Y _12934_/Y _12938_/Y _12933_/Y VDD VSS sg13g2_o21ai_1
XFILLER_94_1246 VDD VSS sg13g2_decap_4
XFILLER_94_1257 VDD VSS sg13g2_decap_8
XFILLER_55_1219 VDD VSS sg13g2_decap_8
XFILLER_15_980 VDD VSS sg13g2_decap_8
XFILLER_21_427 VDD VSS sg13g2_decap_8
X_14609_ _14609_/Q _14737_/CLK _14609_/D _14609_/RESET_B VDD VSS sg13g2_dfrbpq_1
XFILLER_105_1000 VDD VSS sg13g2_decap_8
XFILLER_14_490 VDD VSS sg13g2_decap_8
XFILLER_105_1022 VDD VSS sg13g2_decap_4
XFILLER_109_1191 VDD VSS sg13g2_fill_2
X_08130_ _08130_/Y _08129_/X _08452_/D VDD VSS sg13g2_nand2b_1
XFILLER_18_1085 VDD VSS sg13g2_decap_8
XFILLER_30_983 VDD VSS sg13g2_fill_1
XFILLER_119_337 VDD VSS sg13g2_decap_8
XFILLER_174_432 VDD VSS sg13g2_decap_8
X_08061_ _08061_/Y _08060_/X _08254_/S VDD VSS sg13g2_nand2b_1
XFILLER_174_443 VDD VSS sg13g2_decap_8
XFILLER_162_616 VDD VSS sg13g2_fill_2
XFILLER_31_1274 VDD VSS sg13g2_decap_8
XFILLER_162_638 VDD VSS sg13g2_decap_8
XFILLER_161_126 VDD VSS sg13g2_decap_8
XFILLER_127_392 VDD VSS sg13g2_fill_2
XFILLER_89_928 VDD VSS sg13g2_fill_1
X_14632__1547 _14632_/RESET_B VDD VSS sg13g2_tiehi
XFILLER_88_405 VDD VSS sg13g2_decap_8
XFILLER_170_671 VDD VSS sg13g2_decap_8
XFILLER_102_215 VDD VSS sg13g2_decap_8
X_08963_ _10037_/B _10004_/B _09707_/C VDD VSS sg13g2_nor2_1
XFILLER_69_630 VDD VSS sg13g2_decap_8
XFILLER_102_237 VDD VSS sg13g2_decap_8
XFILLER_29_1170 VDD VSS sg13g2_decap_8
XFILLER_9_1253 VDD VSS sg13g2_decap_8
X_07914_ _07914_/Y _08105_/A _08103_/B _07913_/Y VDD VSS sg13g2_o21ai_1
XFILLER_5_1106 VDD VSS sg13g2_decap_8
X_08894_ _08894_/X _15037_/Q _10743_/S _08893_/Y VDD VSS sg13g2_a21o_1
XFILLER_111_771 VDD VSS sg13g2_decap_4
XFILLER_124_49 VDD VSS sg13g2_decap_8
XFILLER_84_622 VDD VSS sg13g2_decap_4
XFILLER_151_1075 VDD VSS sg13g2_fill_2
X_07845_ _08678_/C _15017_/Q _07972_/B VDD VSS sg13g2_nand2_1
XFILLER_25_1078 VDD VSS sg13g2_decap_8
XFILLER_110_292 VDD VSS sg13g2_decap_8
XFILLER_84_655 VDD VSS sg13g2_decap_8
XFILLER_17_14 VDD VSS sg13g2_decap_8
XFILLER_99_1168 VDD VSS sg13g2_decap_4
X_07776_ _07776_/Y _08276_/B _08276_/A VDD VSS sg13g2_nor2b_1
XFILLER_72_828 VDD VSS sg13g2_fill_1
X_15000__2587 _15000_/RESET_B VDD VSS sg13g2_tiehi
XFILLER_71_316 VDD VSS sg13g2_fill_2
X_09515_ _14114_/D _10012_/A0 _14114_/Q _09538_/S VDD VSS sg13g2_mux2_1
XFILLER_24_210 VDD VSS sg13g2_decap_8
XFILLER_80_850 VDD VSS sg13g2_decap_8
XFILLER_52_541 VDD VSS sg13g2_fill_1
XFILLER_80_861 VDD VSS sg13g2_fill_1
XFILLER_13_917 VDD VSS sg13g2_decap_8
X_09446_ _14047_/D _09611_/A0 _14047_/Q _09464_/S VDD VSS sg13g2_mux2_1
XFILLER_52_563 VDD VSS sg13g2_decap_8
XFILLER_25_777 VDD VSS sg13g2_fill_2
XFILLER_12_427 VDD VSS sg13g2_decap_8
XFILLER_24_287 VDD VSS sg13g2_decap_8
XFILLER_169_259 VDD VSS sg13g2_decap_8
XFILLER_33_35 VDD VSS sg13g2_decap_8
X_09377_ _13980_/D _09608_/A0 _13980_/Q _09401_/S VDD VSS sg13g2_mux2_1
XFILLER_127_1280 VDD VSS sg13g2_decap_8
XFILLER_149_35 VDD VSS sg13g2_decap_8
X_08328_ _08329_/A _08235_/X _08327_/X _08511_/S VDD VSS sg13g2_mux2_1
XFILLER_166_944 VDD VSS sg13g2_decap_8
XFILLER_162_1193 VDD VSS sg13g2_decap_8
XFILLER_21_994 VDD VSS sg13g2_decap_8
XFILLER_138_657 VDD VSS sg13g2_decap_8
XFILLER_71_1098 VDD VSS sg13g2_decap_8
XFILLER_153_605 VDD VSS sg13g2_fill_2
X_08259_ _08259_/Y _08315_/A _08238_/B _08258_/Y VDD VSS sg13g2_o21ai_1
XFILLER_119_860 VDD VSS sg13g2_fill_1
XFILLER_166_999 VDD VSS sg13g2_decap_4
XFILLER_165_476 VDD VSS sg13g2_decap_8
XFILLER_119_893 VDD VSS sg13g2_fill_2
X_11270_ _11270_/Y _11275_/S0 _14364_/Q VDD VSS sg13g2_nand2b_1
XFILLER_4_637 VDD VSS sg13g2_decap_8
XFILLER_10_1358 VDD VSS sg13g2_decap_8
XFILLER_134_852 VDD VSS sg13g2_fill_2
X_15237__3005 _15237_/RESET_B VDD VSS sg13g2_tiehi
XFILLER_165_56 VDD VSS sg13g2_decap_8
X_10221_ _14768_/D _14767_/Q _14768_/Q _10220_/Y VDD VSS sg13g2_a21oi_1
XFILLER_3_147 VDD VSS sg13g2_decap_8
XFILLER_121_502 VDD VSS sg13g2_decap_4
X_14608__1571 _14608_/RESET_B VDD VSS sg13g2_tiehi
X_10152_ _14729_/D _14729_/Q _10152_/A1 _10168_/S VDD VSS sg13g2_mux2_1
XFILLER_0_821 VDD VSS sg13g2_decap_8
XFILLER_58_21 VDD VSS sg13g2_decap_8
XFILLER_58_54 VDD VSS sg13g2_fill_2
XFILLER_134_1240 VDD VSS sg13g2_fill_1
X_14960_ _14960_/Q _15228_/CLK _14960_/D _14960_/RESET_B VDD VSS sg13g2_dfrbpq_1
X_10083_ _14663_/D _10083_/A0 _14663_/Q _10101_/S VDD VSS sg13g2_mux2_1
XFILLER_58_65 VDD VSS sg13g2_decap_4
XFILLER_121_579 VDD VSS sg13g2_fill_1
XFILLER_59_140 VDD VSS sg13g2_decap_4
XFILLER_87_460 VDD VSS sg13g2_decap_8
XFILLER_48_825 VDD VSS sg13g2_decap_8
XFILLER_0_898 VDD VSS sg13g2_decap_8
XFILLER_130_1115 VDD VSS sg13g2_decap_8
X_13911_ _13911_/Q clkload34/A _13911_/D _13911_/RESET_B VDD VSS sg13g2_dfrbpq_1
XFILLER_59_173 VDD VSS sg13g2_decap_8
XFILLER_47_313 VDD VSS sg13g2_decap_8
XFILLER_102_793 VDD VSS sg13g2_decap_8
X_14891_ _14891_/Q _14894_/CLK _14891_/D _14891_/RESET_B VDD VSS sg13g2_dfrbpq_1
XFILLER_130_1148 VDD VSS sg13g2_fill_2
XFILLER_47_346 VDD VSS sg13g2_fill_1
XFILLER_130_1159 VDD VSS sg13g2_decap_8
XFILLER_47_357 VDD VSS sg13g2_decap_8
X_13842_ _13842_/Q clkload23/A _13842_/D _13842_/RESET_B VDD VSS sg13g2_dfrbpq_1
XFILLER_90_603 VDD VSS sg13g2_decap_8
XFILLER_16_700 VDD VSS sg13g2_decap_8
XFILLER_90_614 VDD VSS sg13g2_fill_2
X_14070__2109 _14070_/RESET_B VDD VSS sg13g2_tiehi
XFILLER_15_210 VDD VSS sg13g2_decap_8
X_13773_ _13773_/Q clkload10/A _13773_/D _13773_/RESET_B VDD VSS sg13g2_dfrbpq_1
X_10985_ _10985_/X _10995_/A _13412_/C _11045_/B1 VDD VSS sg13g2_a21o_1
XFILLER_16_777 VDD VSS sg13g2_decap_8
X_12724_ _12724_/X _14262_/Q _14294_/Q _14326_/Q _14358_/Q _12752_/S0 _12752_/S1 VDD
+ VSS sg13g2_mux4_1
XFILLER_43_563 VDD VSS sg13g2_fill_2
XFILLER_31_714 VDD VSS sg13g2_fill_2
XFILLER_15_287 VDD VSS sg13g2_decap_8
X_12655_ _12655_/X _13745_/Q _14097_/Q _14449_/Q _14545_/Q _12655_/S0 _12655_/S1 VDD
+ VSS sg13g2_mux4_1
XFILLER_93_1290 VDD VSS sg13g2_decap_8
X_14710__1469 _14710_/RESET_B VDD VSS sg13g2_tiehi
XFILLER_31_758 VDD VSS sg13g2_decap_8
Xclkbuf_leaf_101_clk_i clkload36/A clkbuf_leaf_99_clk_i/A VDD VSS sg13g2_buf_8
XFILLER_30_246 VDD VSS sg13g2_decap_8
XFILLER_19_1372 VDD VSS sg13g2_decap_8
XFILLER_157_922 VDD VSS sg13g2_fill_1
XFILLER_106_1342 VDD VSS sg13g2_decap_8
XFILLER_129_624 VDD VSS sg13g2_decap_8
XFILLER_15_1225 VDD VSS sg13g2_decap_8
X_11606_ _11606_/Y _11602_/Y _11603_/Y _11605_/Y _11604_/Y _11973_/B VDD VSS sg13g2_a221oi_1
XFILLER_8_910 VDD VSS sg13g2_decap_8
XFILLER_129_635 VDD VSS sg13g2_fill_2
XFILLER_141_1244 VDD VSS sg13g2_fill_1
X_12586_ _12586_/X _13964_/Q _13996_/Q _14028_/Q _14060_/Q _12590_/S0 _12590_/S1 VDD
+ VSS sg13g2_mux4_1
XFILLER_54_1296 VDD VSS sg13g2_fill_2
XFILLER_12_994 VDD VSS sg13g2_decap_8
XFILLER_156_432 VDD VSS sg13g2_fill_1
XFILLER_157_966 VDD VSS sg13g2_decap_4
XFILLER_7_420 VDD VSS sg13g2_decap_8
XFILLER_129_668 VDD VSS sg13g2_decap_4
X_14325_ _14325_/Q clkload16/A _14325_/D _14325_/RESET_B VDD VSS sg13g2_dfrbpq_1
X_11537_ _11537_/Y _11531_/A _14596_/Q _12018_/C VDD VSS sg13g2_a21oi_1
XFILLER_8_987 VDD VSS sg13g2_decap_8
XFILLER_139_90 VDD VSS sg13g2_decap_8
XFILLER_116_329 VDD VSS sg13g2_decap_8
X_14256_ _14256_/Q _14662_/CLK _14256_/D _14256_/RESET_B VDD VSS sg13g2_dfrbpq_1
Xclkbuf_leaf_116_clk_i _14666_/CLK clkbuf_5_7__f_clk_i/X VDD VSS sg13g2_buf_8
X_11468_ _11468_/X _14241_/Q _14273_/Q _14305_/Q _14337_/Q _11489_/S0 _11489_/S1 VDD
+ VSS sg13g2_mux4_1
XFILLER_7_497 VDD VSS sg13g2_decap_8
XFILLER_171_446 VDD VSS sg13g2_decap_8
X_15050__2525 _15050_/RESET_B VDD VSS sg13g2_tiehi
XFILLER_99_83 VDD VSS sg13g2_decap_8
X_13207_ _13207_/Y _10558_/C _07727_/B _13028_/B _14889_/Q _13207_/C1 VDD VSS sg13g2_a221oi_1
XFILLER_125_863 VDD VSS sg13g2_fill_2
X_10419_ _10421_/B _14828_/Q _14829_/Q _10422_/D VDD VSS sg13g2_nand3_1
XFILLER_139_1151 VDD VSS sg13g2_decap_8
X_14187_ _14187_/Q clkload1/A _14187_/D _14187_/RESET_B VDD VSS sg13g2_dfrbpq_1
X_11399_ _11401_/A _11400_/A _14623_/Q VDD VSS sg13g2_nand2b_1
XFILLER_135_1004 VDD VSS sg13g2_fill_1
XFILLER_98_725 VDD VSS sg13g2_fill_1
XFILLER_124_373 VDD VSS sg13g2_decap_8
XFILLER_140_822 VDD VSS sg13g2_fill_1
XFILLER_152_682 VDD VSS sg13g2_fill_1
X_13138_ _13139_/B _14852_/Q _13150_/B _13207_/C1 _14788_/Q VDD VSS sg13g2_a22oi_1
XFILLER_48_1078 VDD VSS sg13g2_decap_8
XFILLER_86_909 VDD VSS sg13g2_decap_8
XFILLER_151_192 VDD VSS sg13g2_decap_8
Xclkbuf_5_28__f_clk_i clkbuf_leaf_82_clk_i/A clkbuf_4_14_0_clk_i/X VDD VSS sg13g2_buf_16
XFILLER_79_950 VDD VSS sg13g2_fill_2
XFILLER_140_888 VDD VSS sg13g2_decap_4
X_13069_ _13069_/Y _14847_/Q _13150_/B _13162_/B1 _14879_/Q _13082_/B VDD VSS sg13g2_a221oi_1
XFILLER_26_1343 VDD VSS sg13g2_decap_8
XFILLER_78_460 VDD VSS sg13g2_decap_8
XFILLER_94_920 VDD VSS sg13g2_fill_2
XFILLER_94_953 VDD VSS sg13g2_decap_4
XFILLER_93_430 VDD VSS sg13g2_decap_8
X_07630_ _08105_/A _07879_/A VDD VSS sg13g2_inv_1
XFILLER_19_560 VDD VSS sg13g2_decap_8
XFILLER_0_1003 VDD VSS sg13g2_decap_8
XFILLER_54_839 VDD VSS sg13g2_decap_8
XFILLER_4_1183 VDD VSS sg13g2_decap_8
XFILLER_59_1130 VDD VSS sg13g2_decap_8
XFILLER_80_124 VDD VSS sg13g2_fill_1
X_14046__2133 _14046_/RESET_B VDD VSS sg13g2_tiehi
XFILLER_81_658 VDD VSS sg13g2_decap_8
XFILLER_146_1100 VDD VSS sg13g2_decap_4
X_09300_ _13908_/D _13908_/Q _09931_/A1 _09300_/S VDD VSS sg13g2_mux2_1
XFILLER_62_850 VDD VSS sg13g2_fill_1
XFILLER_34_574 VDD VSS sg13g2_fill_1
XFILLER_146_1144 VDD VSS sg13g2_decap_8
X_09231_ _13842_/D _10128_/A0 _13842_/Q _09237_/S VDD VSS sg13g2_mux2_1
XFILLER_34_596 VDD VSS sg13g2_decap_8
XFILLER_21_224 VDD VSS sg13g2_decap_8
X_09162_ _09162_/Y _09162_/A _10793_/C VDD VSS sg13g2_nor2_1
XFILLER_9_70 VDD VSS sg13g2_decap_8
XFILLER_148_944 VDD VSS sg13g2_fill_1
XFILLER_33_1358 VDD VSS sg13g2_decap_8
XFILLER_147_443 VDD VSS sg13g2_fill_2
X_08113_ _08113_/Y _07913_/A _13609_/A _08105_/A _08138_/B _08090_/C VDD VSS sg13g2_a221oi_1
XFILLER_147_465 VDD VSS sg13g2_fill_2
XFILLER_163_914 VDD VSS sg13g2_decap_8
X_09093_ _09093_/Y _15239_/Q _09100_/B VDD VSS sg13g2_nand2b_1
XFILLER_120_1339 VDD VSS sg13g2_fill_1
XFILLER_107_329 VDD VSS sg13g2_decap_4
X_08044_ _08044_/X _08559_/A3 _08591_/A3 _08598_/A3 _07861_/B _08054_/B _08669_/B1
+ VDD VSS sg13g2_mux4_1
XFILLER_134_126 VDD VSS sg13g2_decap_8
XFILLER_162_446 VDD VSS sg13g2_decap_8
XFILLER_66_1112 VDD VSS sg13g2_decap_8
XFILLER_131_800 VDD VSS sg13g2_decap_8
X_15018__2569 _15018_/RESET_B VDD VSS sg13g2_tiehi
XFILLER_89_714 VDD VSS sg13g2_decap_8
XFILLER_103_502 VDD VSS sg13g2_decap_8
Xclkbuf_leaf_80_clk_i clkload50/A clkbuf_leaf_88_clk_i/A VDD VSS sg13g2_buf_8
Xhold3023 hold3023/X input7/X VDD VSS sg13g2_dlygate4sd3_1
XFILLER_170_490 VDD VSS sg13g2_decap_8
Xhold3034 input15/A mem_axi_rdata[1] VDD VSS sg13g2_dlygate4sd3_1
X_09995_ _14578_/D _10161_/A1 _14578_/Q _10003_/S VDD VSS sg13g2_mux2_1
XFILLER_142_192 VDD VSS sg13g2_decap_8
Xhold3045 input6/A mem_axi_rdata[11] VDD VSS sg13g2_dlygate4sd3_1
XFILLER_130_343 VDD VSS sg13g2_decap_8
XFILLER_153_1148 VDD VSS sg13g2_decap_8
Xhold3056 hold3056/X input21/X VDD VSS sg13g2_dlygate4sd3_1
XFILLER_153_1159 VDD VSS sg13g2_fill_2
Xhold3067 input20/A mem_axi_rdata[24] VDD VSS sg13g2_dlygate4sd3_1
X_08946_ _08946_/Y _13608_/A1 _08835_/B _16882_/A VDD VSS sg13g2_a21oi_1
XFILLER_9_1050 VDD VSS sg13g2_decap_8
Xhold3078 input19/A mem_axi_rdata[23] VDD VSS sg13g2_dlygate4sd3_1
Xhold3089 input14/A mem_axi_rdata[19] VDD VSS sg13g2_dlygate4sd3_1
X_14256__1923 _14256_/RESET_B VDD VSS sg13g2_tiehi
XFILLER_97_791 VDD VSS sg13g2_fill_2
XFILLER_28_35 VDD VSS sg13g2_decap_8
XFILLER_151_14 VDD VSS sg13g2_decap_8
X_08877_ _08877_/Y _10788_/S _14937_/Q VDD VSS sg13g2_nor2b_1
XFILLER_85_964 VDD VSS sg13g2_decap_8
Xclkbuf_leaf_95_clk_i clkload46/A clkbuf_leaf_97_clk_i/A VDD VSS sg13g2_buf_8
X_07828_ _07829_/B _08574_/A _08574_/B _07828_/C VDD VSS sg13g2_nor3_1
XFILLER_84_463 VDD VSS sg13g2_fill_1
X_07759_ _07759_/Y _13281_/C _07755_/Y _07758_/Y VDD VSS sg13g2_a21oi_1
XFILLER_77_1252 VDD VSS sg13g2_decap_8
XFILLER_13_714 VDD VSS sg13g2_decap_8
X_10770_ _10770_/Y _14919_/Q _11133_/B VDD VSS sg13g2_nand2_1
XFILLER_44_56 VDD VSS sg13g2_decap_8
XFILLER_40_511 VDD VSS sg13g2_decap_8
XFILLER_25_596 VDD VSS sg13g2_decap_8
XFILLER_12_224 VDD VSS sg13g2_decap_8
X_09429_ _14031_/D _09959_/A1 _14031_/Q _09431_/S VDD VSS sg13g2_mux2_1
XFILLER_38_1269 VDD VSS sg13g2_fill_1
XFILLER_158_719 VDD VSS sg13g2_decap_8
XFILLER_9_707 VDD VSS sg13g2_decap_8
XFILLER_138_410 VDD VSS sg13g2_decap_4
X_12440_ _12440_/X _12434_/X _12438_/X _12433_/X _12437_/X _12553_/S _12454_/S1 VDD
+ VSS sg13g2_mux4_1
XFILLER_8_217 VDD VSS sg13g2_decap_8
XFILLER_138_432 VDD VSS sg13g2_decap_8
X_13659__1427 _13659_/RESET_B VDD VSS sg13g2_tiehi
XFILLER_21_791 VDD VSS sg13g2_decap_8
XFILLER_154_914 VDD VSS sg13g2_decap_4
X_13744__2435 _13744_/RESET_B VDD VSS sg13g2_tiehi
Xclkbuf_leaf_33_clk_i _14649_/CLK clkbuf_leaf_35_clk_i/A VDD VSS sg13g2_buf_8
X_12371_ _12372_/B _12370_/X _12369_/X _12706_/S VDD VSS sg13g2_mux2_1
XFILLER_158_1004 VDD VSS sg13g2_decap_8
XFILLER_165_273 VDD VSS sg13g2_decap_8
X_14110_ _14110_/Q _14686_/CLK _14110_/D _14110_/RESET_B VDD VSS sg13g2_dfrbpq_1
XFILLER_5_924 VDD VSS sg13g2_decap_8
X_11322_ _11322_/Y _11328_/S0 _14109_/Q VDD VSS sg13g2_nand2b_1
X_15090_ _15090_/Q clkload68/A _15090_/D _15090_/RESET_B VDD VSS sg13g2_dfrbpq_1
XFILLER_107_830 VDD VSS sg13g2_decap_8
XFILLER_5_28 VDD VSS sg13g2_decap_8
XFILLER_4_434 VDD VSS sg13g2_decap_8
XFILLER_107_0 VDD VSS sg13g2_decap_8
XFILLER_10_1155 VDD VSS sg13g2_decap_8
X_14041_ _14041_/Q _14649_/CLK _14041_/D _14041_/RESET_B VDD VSS sg13g2_dfrbpq_1
X_11253_ _11255_/B _12303_/S _14620_/Q VDD VSS sg13g2_nand2b_1
XFILLER_49_1343 VDD VSS sg13g2_decap_4
XFILLER_107_885 VDD VSS sg13g2_decap_8
XFILLER_134_682 VDD VSS sg13g2_fill_1
XFILLER_140_118 VDD VSS sg13g2_decap_8
Xclkbuf_leaf_48_clk_i clkload52/A clkbuf_leaf_75_clk_i/A VDD VSS sg13g2_buf_8
X_10204_ _14759_/D _15183_/D _14759_/Q _13346_/A VDD VSS sg13g2_mux2_1
XFILLER_171_1204 VDD VSS sg13g2_decap_8
X_14124__2055 _14124_/RESET_B VDD VSS sg13g2_tiehi
X_11184_ _14954_/D _11183_/Y _11182_/Y _11170_/Y VDD VSS sg13g2_o21ai_1
XFILLER_0_651 VDD VSS sg13g2_decap_8
X_10135_ _14713_/D _10168_/A1 _14713_/Q _10135_/S VDD VSS sg13g2_mux2_1
XFILLER_122_899 VDD VSS sg13g2_decap_4
XFILLER_48_611 VDD VSS sg13g2_decap_8
XFILLER_88_791 VDD VSS sg13g2_decap_8
XFILLER_0_695 VDD VSS sg13g2_decap_8
X_14943_ _14943_/Q clkload43/A _14943_/D _14943_/RESET_B VDD VSS sg13g2_dfrbpq_1
X_10066_ _14647_/D _10099_/A0 _14647_/Q _10068_/S VDD VSS sg13g2_mux2_1
XFILLER_47_132 VDD VSS sg13g2_decap_8
XFILLER_48_666 VDD VSS sg13g2_decap_8
XFILLER_91_912 VDD VSS sg13g2_decap_8
XFILLER_48_677 VDD VSS sg13g2_fill_1
X_14874_ _14874_/Q _14874_/CLK _14874_/D _14874_/RESET_B VDD VSS sg13g2_dfrbpq_1
XFILLER_91_923 VDD VSS sg13g2_fill_1
XFILLER_48_699 VDD VSS sg13g2_fill_2
XFILLER_36_839 VDD VSS sg13g2_decap_4
XFILLER_91_934 VDD VSS sg13g2_fill_1
XFILLER_169_1155 VDD VSS sg13g2_decap_8
XFILLER_1_1323 VDD VSS sg13g2_decap_8
XFILLER_169_1166 VDD VSS sg13g2_fill_2
X_13825_ _13825_/Q clkload25/A _13825_/D _13825_/RESET_B VDD VSS sg13g2_dfrbpq_1
X_13992__2187 _13992_/RESET_B VDD VSS sg13g2_tiehi
X_14870__2804 _14870_/RESET_B VDD VSS sg13g2_tiehi
XFILLER_91_967 VDD VSS sg13g2_fill_1
XFILLER_62_124 VDD VSS sg13g2_decap_8
XFILLER_95_1341 VDD VSS sg13g2_decap_4
XFILLER_21_1295 VDD VSS sg13g2_decap_8
XFILLER_56_1314 VDD VSS sg13g2_decap_4
XFILLER_50_308 VDD VSS sg13g2_decap_8
X_13756_ _13756_/Q _14746_/CLK _13756_/D _13756_/RESET_B VDD VSS sg13g2_dfrbpq_1
XFILLER_44_872 VDD VSS sg13g2_decap_8
XFILLER_16_574 VDD VSS sg13g2_decap_8
X_10968_ _10969_/A _11015_/C _11015_/A _10966_/Y VDD VSS sg13g2_o21ai_1
XFILLER_17_1309 VDD VSS sg13g2_decap_8
X_12707_ _12708_/B _13668_/Q _12707_/A2 _12706_/X _12721_/B2 _12707_/C1 VDD VSS sg13g2_a221oi_1
XFILLER_43_393 VDD VSS sg13g2_decap_8
X_13687_ _13687_/Q clkload62/A _13687_/D _13687_/RESET_B VDD VSS sg13g2_dfrbpq_1
X_10899_ _10899_/Y _10936_/A _10898_/X _10912_/A1 VDD VSS sg13g2_o21ai_1
XFILLER_15_1022 VDD VSS sg13g2_decap_8
X_12638_ _15009_/D _07636_/Y _12777_/C1 _12637_/Y VDD VSS sg13g2_a21oi_1
XFILLER_106_1150 VDD VSS sg13g2_fill_2
XFILLER_12_791 VDD VSS sg13g2_decap_8
XFILLER_141_1052 VDD VSS sg13g2_fill_1
XFILLER_129_465 VDD VSS sg13g2_decap_8
XFILLER_145_914 VDD VSS sg13g2_fill_2
XFILLER_156_251 VDD VSS sg13g2_fill_1
X_12569_ _15004_/D _12569_/A _12569_/B VDD VSS sg13g2_nor2_1
XFILLER_102_1025 VDD VSS sg13g2_decap_8
XFILLER_145_925 VDD VSS sg13g2_decap_8
XFILLER_144_413 VDD VSS sg13g2_decap_8
XFILLER_157_796 VDD VSS sg13g2_decap_8
X_14334__1845 _14334_/RESET_B VDD VSS sg13g2_tiehi
XFILLER_15_1099 VDD VSS sg13g2_decap_8
X_14308_ _14308_/Q _14703_/CLK _14308_/D _14308_/RESET_B VDD VSS sg13g2_dfrbpq_1
XFILLER_8_784 VDD VSS sg13g2_decap_8
XFILLER_171_210 VDD VSS sg13g2_decap_8
XFILLER_145_958 VDD VSS sg13g2_decap_8
XFILLER_116_137 VDD VSS sg13g2_decap_8
XFILLER_7_294 VDD VSS sg13g2_decap_8
X_14239_ _14239_/Q clkload14/A _14239_/D _14239_/RESET_B VDD VSS sg13g2_dfrbpq_1
XFILLER_171_254 VDD VSS sg13g2_decap_8
XFILLER_113_811 VDD VSS sg13g2_decap_8
XFILLER_125_693 VDD VSS sg13g2_fill_1
XFILLER_131_129 VDD VSS sg13g2_decap_4
XFILLER_113_844 VDD VSS sg13g2_decap_8
Xfanout708 _11900_/B _11815_/B VDD VSS sg13g2_buf_1
XFILLER_63_1318 VDD VSS sg13g2_fill_2
XFILLER_113_855 VDD VSS sg13g2_decap_8
Xfanout719 _11802_/B _11739_/B VDD VSS sg13g2_buf_1
XFILLER_98_544 VDD VSS sg13g2_decap_8
XFILLER_63_1329 VDD VSS sg13g2_decap_8
XFILLER_140_641 VDD VSS sg13g2_decap_8
X_15176__2871 _15176_/RESET_B VDD VSS sg13g2_tiehi
X_08800_ _08802_/A _10797_/A _14754_/Q _08727_/X _15197_/Q _13490_/B VDD VSS sg13g2_a221oi_1
X_09780_ _14369_/D _09780_/A0 _14369_/Q _09804_/S VDD VSS sg13g2_mux2_1
XFILLER_26_1140 VDD VSS sg13g2_decap_8
XFILLER_39_611 VDD VSS sg13g2_fill_2
XFILLER_22_0 VDD VSS sg13g2_decap_8
XFILLER_113_1110 VDD VSS sg13g2_decap_8
X_08731_ _08731_/Y _13662_/Q _08775_/B VDD VSS sg13g2_nor2_1
XFILLER_22_1004 VDD VSS sg13g2_decap_8
XFILLER_6_1267 VDD VSS sg13g2_decap_8
XFILLER_39_666 VDD VSS sg13g2_fill_2
XFILLER_27_806 VDD VSS sg13g2_decap_8
Xfanout1290 _11469_/S1 fanout1291/X VDD VSS sg13g2_buf_1
X_08662_ _08662_/Y _08650_/A _08662_/B VDD VSS sg13g2_nand2b_1
XFILLER_26_305 VDD VSS sg13g2_fill_1
XFILLER_53_102 VDD VSS sg13g2_decap_4
X_07613_ _08992_/A _10781_/C VDD VSS sg13g2_inv_1
XFILLER_54_647 VDD VSS sg13g2_decap_8
XFILLER_121_28 VDD VSS sg13g2_decap_4
XFILLER_53_124 VDD VSS sg13g2_decap_8
X_13822__2357 _13822_/RESET_B VDD VSS sg13g2_tiehi
X_08593_ _08593_/Y _07858_/X _08623_/A2 _08654_/B VDD VSS sg13g2_o21ai_1
XFILLER_82_967 VDD VSS sg13g2_decap_4
X_14582__1597 _14582_/RESET_B VDD VSS sg13g2_tiehi
XFILLER_53_146 VDD VSS sg13g2_decap_8
XFILLER_42_809 VDD VSS sg13g2_decap_4
XFILLER_53_157 VDD VSS sg13g2_fill_2
X_15236__3004 _15236_/RESET_B VDD VSS sg13g2_tiehi
XFILLER_22_511 VDD VSS sg13g2_decap_8
X_09214_ _13825_/D _09780_/A0 _13825_/Q _09237_/S VDD VSS sg13g2_mux2_1
XFILLER_22_566 VDD VSS sg13g2_decap_8
XFILLER_33_1111 VDD VSS sg13g2_decap_8
XFILLER_10_728 VDD VSS sg13g2_decap_8
XFILLER_72_1193 VDD VSS sg13g2_decap_8
XFILLER_136_903 VDD VSS sg13g2_fill_2
X_09145_ _09145_/Y _09145_/A _09145_/B VDD VSS sg13g2_nand2_1
XFILLER_163_700 VDD VSS sg13g2_fill_2
XFILLER_108_627 VDD VSS sg13g2_decap_8
XFILLER_135_402 VDD VSS sg13g2_decap_8
XFILLER_30_14 VDD VSS sg13g2_decap_8
XFILLER_163_722 VDD VSS sg13g2_decap_4
XFILLER_162_210 VDD VSS sg13g2_decap_8
X_09076_ _09076_/Y _09111_/A1 _10735_/B _09075_/X VDD VSS sg13g2_o21ai_1
XFILLER_136_969 VDD VSS sg13g2_decap_8
XFILLER_146_14 VDD VSS sg13g2_decap_8
XFILLER_135_468 VDD VSS sg13g2_decap_8
X_08027_ _08027_/Y _07911_/A _08027_/B VDD VSS sg13g2_nand2b_1
XFILLER_100_7 VDD VSS sg13g2_decap_8
XFILLER_116_682 VDD VSS sg13g2_decap_8
XFILLER_150_427 VDD VSS sg13g2_decap_8
XFILLER_2_938 VDD VSS sg13g2_decap_8
XFILLER_115_170 VDD VSS sg13g2_fill_1
XFILLER_118_1021 VDD VSS sg13g2_decap_8
XFILLER_1_448 VDD VSS sg13g2_decap_8
X_09978_ _14561_/D _10077_/A0 _14561_/Q _09999_/S VDD VSS sg13g2_mux2_1
XFILLER_77_728 VDD VSS sg13g2_decap_8
XFILLER_39_56 VDD VSS sg13g2_decap_8
XFILLER_162_35 VDD VSS sg13g2_decap_8
XFILLER_76_216 VDD VSS sg13g2_fill_1
XFILLER_131_696 VDD VSS sg13g2_decap_8
XFILLER_76_227 VDD VSS sg13g2_decap_4
XFILLER_44_1251 VDD VSS sg13g2_fill_1
X_08929_ _13715_/D _16877_/A _08928_/X _08932_/S VDD VSS sg13g2_mux2_1
XFILLER_130_195 VDD VSS sg13g2_decap_8
XFILLER_131_1232 VDD VSS sg13g2_decap_8
XFILLER_85_750 VDD VSS sg13g2_fill_1
XFILLER_79_1303 VDD VSS sg13g2_fill_2
X_11940_ _11940_/Y _11963_/S0 _14128_/Q VDD VSS sg13g2_nand2b_1
XFILLER_57_485 VDD VSS sg13g2_decap_8
XFILLER_44_124 VDD VSS sg13g2_decap_8
X_11871_ _11871_/Y _12090_/A _13902_/Q VDD VSS sg13g2_nand2b_1
XFILLER_44_135 VDD VSS sg13g2_fill_1
X_14412__1767 _14412_/RESET_B VDD VSS sg13g2_tiehi
X_13610_ _13610_/Y _13609_/Y _13600_/Y _08830_/X VDD VSS sg13g2_o21ai_1
X_10822_ _10823_/A _10821_/A _10821_/B _10821_/C VDD VSS sg13g2_a21o_1
X_14590_ _14590_/Q clkload36/A _14590_/D _14590_/RESET_B VDD VSS sg13g2_dfrbpq_1
XFILLER_13_511 VDD VSS sg13g2_decap_8
XFILLER_53_680 VDD VSS sg13g2_decap_8
XFILLER_38_1033 VDD VSS sg13g2_decap_8
XFILLER_41_831 VDD VSS sg13g2_decap_8
X_13541_ _13541_/X _14995_/Q _13566_/C VDD VSS sg13g2_and2_1
XFILLER_71_21 VDD VSS sg13g2_decap_8
XFILLER_25_393 VDD VSS sg13g2_decap_8
XFILLER_164_1063 VDD VSS sg13g2_decap_8
X_10753_ _11097_/A _14947_/Q _10757_/A _10752_/Y VDD VSS sg13g2_a21oi_1
XFILLER_9_504 VDD VSS sg13g2_decap_8
XFILLER_38_1088 VDD VSS sg13g2_fill_1
XFILLER_13_588 VDD VSS sg13g2_decap_8
X_13472_ _15110_/D _15176_/D _15110_/Q _13499_/A VDD VSS sg13g2_mux2_1
X_13977__2202 _13977_/RESET_B VDD VSS sg13g2_tiehi
XFILLER_139_730 VDD VSS sg13g2_decap_8
X_10684_ _10851_/D _08985_/X _10684_/A2 _08848_/Y VDD VSS sg13g2_a21o_1
X_15211_ _15211_/Q clkload72/A _15211_/D _15211_/RESET_B VDD VSS sg13g2_dfrbpq_1
X_12423_ _12423_/X _13728_/Q _14080_/Q _14432_/Q _14528_/Q _12742_/S0 _12742_/S1 VDD
+ VSS sg13g2_mux4_1
XFILLER_127_925 VDD VSS sg13g2_decap_4
XFILLER_154_700 VDD VSS sg13g2_fill_2
XFILLER_166_560 VDD VSS sg13g2_decap_8
XFILLER_12_1239 VDD VSS sg13g2_decap_8
XFILLER_127_947 VDD VSS sg13g2_decap_8
X_15142_ _15142_/Q clkload59/A _15142_/D _15142_/RESET_B VDD VSS sg13g2_dfrbpq_1
X_12354_ _12354_/X _12342_/X _12343_/X _12352_/X _12351_/X _12398_/S0 _12706_/S VDD
+ VSS sg13g2_mux4_1
XFILLER_86_1307 VDD VSS sg13g2_decap_4
XFILLER_5_721 VDD VSS sg13g2_decap_8
XFILLER_153_243 VDD VSS sg13g2_decap_8
X_11305_ _11305_/Y _11310_/A1 _14653_/Q _11325_/B1 VDD VSS sg13g2_a21oi_1
XFILLER_4_231 VDD VSS sg13g2_decap_8
X_15073_ _15073_/Q _15159_/CLK _15073_/D _15073_/RESET_B VDD VSS sg13g2_dfrbpq_1
XFILLER_99_308 VDD VSS sg13g2_fill_2
X_12285_ _12285_/X _14137_/Q _14169_/Q _14201_/Q _14233_/Q _12286_/S0 _12286_/S1 VDD
+ VSS sg13g2_mux4_1
XFILLER_101_1091 VDD VSS sg13g2_decap_4
XFILLER_5_798 VDD VSS sg13g2_decap_8
X_14024_ _14024_/Q _14728_/CLK _14024_/D _14024_/RESET_B VDD VSS sg13g2_dfrbpq_1
XFILLER_107_693 VDD VSS sg13g2_decap_8
X_11236_ _11236_/Y _15209_/Q _13289_/C _11236_/C _11236_/D VDD VSS sg13g2_nor4_1
X_13900__2279 _13900_/RESET_B VDD VSS sg13g2_tiehi
XFILLER_20_91 VDD VSS sg13g2_decap_8
XFILLER_136_1132 VDD VSS sg13g2_fill_2
XFILLER_49_1184 VDD VSS sg13g2_decap_8
XFILLER_84_1086 VDD VSS sg13g2_fill_2
XFILLER_136_1165 VDD VSS sg13g2_decap_8
X_11167_ _11167_/Y _11161_/X _11158_/Y _11166_/Y VDD VSS sg13g2_a21oi_1
XFILLER_68_728 VDD VSS sg13g2_decap_8
XFILLER_62_1340 VDD VSS sg13g2_decap_8
X_10118_ _14696_/D _10151_/A1 _14696_/Q _10127_/S VDD VSS sg13g2_mux2_1
XFILLER_96_95 VDD VSS sg13g2_decap_8
X_11098_ _11098_/Y _11138_/B _10759_/X _11139_/B1 VDD VSS sg13g2_a21oi_1
XFILLER_23_1335 VDD VSS sg13g2_decap_8
X_14926_ _14926_/Q clkload69/A _14926_/D _14926_/RESET_B VDD VSS sg13g2_dfrbpq_1
X_10049_ _14630_/D _10082_/A0 _14630_/Q _10060_/S VDD VSS sg13g2_mux2_1
XFILLER_110_1338 VDD VSS sg13g2_fill_1
XFILLER_1_1120 VDD VSS sg13g2_decap_8
X_14857_ _14857_/Q clkload49/A _14857_/D _14857_/RESET_B VDD VSS sg13g2_dfrbpq_1
XFILLER_17_861 VDD VSS sg13g2_decap_8
XFILLER_23_308 VDD VSS sg13g2_decap_8
XFILLER_21_1092 VDD VSS sg13g2_decap_8
X_13808_ _13808_/Q clkload7/A _13808_/D _13808_/RESET_B VDD VSS sg13g2_dfrbpq_1
X_13660__2967 _13660_/RESET_B VDD VSS sg13g2_tiehi
X_14788_ _14788_/Q _14894_/CLK _14788_/D _14788_/RESET_B VDD VSS sg13g2_dfrbpq_1
XFILLER_16_371 VDD VSS sg13g2_decap_8
XFILLER_44_680 VDD VSS sg13g2_decap_8
XFILLER_1_1197 VDD VSS sg13g2_decap_8
X_13739_ _13739_/Q clkload1/A _13739_/D _13739_/RESET_B VDD VSS sg13g2_dfrbpq_1
XFILLER_17_1106 VDD VSS sg13g2_decap_8
XFILLER_91_1046 VDD VSS sg13g2_decap_8
XFILLER_32_886 VDD VSS sg13g2_decap_8
XFILLER_108_1267 VDD VSS sg13g2_decap_8
XFILLER_31_363 VDD VSS sg13g2_decap_8
X_14834__2876 _14834_/RESET_B VDD VSS sg13g2_tiehi
X_14567__1612 _14567_/RESET_B VDD VSS sg13g2_tiehi
XFILLER_118_903 VDD VSS sg13g2_fill_2
XFILLER_30_1317 VDD VSS sg13g2_decap_8
XFILLER_117_413 VDD VSS sg13g2_decap_8
XFILLER_8_581 VDD VSS sg13g2_decap_8
XFILLER_118_969 VDD VSS sg13g2_decap_8
XFILLER_145_755 VDD VSS sg13g2_decap_8
XFILLER_133_906 VDD VSS sg13g2_decap_8
XFILLER_117_479 VDD VSS sg13g2_fill_2
XFILLER_160_714 VDD VSS sg13g2_decap_8
XFILLER_133_939 VDD VSS sg13g2_fill_1
XFILLER_126_991 VDD VSS sg13g2_decap_8
X_09901_ _14487_/D _09934_/A1 _14487_/Q _09903_/S VDD VSS sg13g2_mux2_1
XFILLER_67_1251 VDD VSS sg13g2_fill_2
XFILLER_99_842 VDD VSS sg13g2_decap_8
XFILLER_116_28 VDD VSS sg13g2_decap_8
XFILLER_28_1224 VDD VSS sg13g2_decap_8
XFILLER_141_950 VDD VSS sg13g2_decap_4
Xfanout505 _13519_/B _13524_/A1 VDD VSS sg13g2_buf_1
Xfanout516 _12721_/A2 _12763_/A2 VDD VSS sg13g2_buf_1
Xfanout527 _10072_/A0 _10105_/A VDD VSS sg13g2_buf_1
X_09832_ _14420_/D _09898_/A0 _14420_/Q _09832_/S VDD VSS sg13g2_mux2_1
XFILLER_99_886 VDD VSS sg13g2_decap_8
Xfanout538 _09162_/A _09051_/A1 VDD VSS sg13g2_buf_1
XFILLER_140_460 VDD VSS sg13g2_decap_8
Xfanout549 _08826_/B _08723_/Y VDD VSS sg13g2_buf_1
XFILLER_150_1118 VDD VSS sg13g2_decap_4
XFILLER_86_536 VDD VSS sg13g2_decap_8
XFILLER_154_1298 VDD VSS sg13g2_fill_2
X_09763_ _14353_/D _14353_/Q _09928_/A1 _09763_/S VDD VSS sg13g2_mux2_1
X_13658__1426 _13658_/RESET_B VDD VSS sg13g2_tiehi
X_08714_ _15210_/D _15189_/D _15119_/Q _13656_/S VDD VSS sg13g2_mux2_1
XFILLER_6_1064 VDD VSS sg13g2_decap_8
X_09694_ _14286_/D _10157_/A1 _14286_/Q _09700_/S VDD VSS sg13g2_mux2_1
XFILLER_67_794 VDD VSS sg13g2_decap_8
X_08645_ _08645_/X _08646_/A _08646_/B _08646_/C VDD VSS sg13g2_and3_1
XFILLER_82_742 VDD VSS sg13g2_decap_8
XFILLER_14_308 VDD VSS sg13g2_decap_8
XFILLER_25_14 VDD VSS sg13g2_decap_8
XFILLER_26_168 VDD VSS sg13g2_decap_8
X_08576_ _08576_/Y _08421_/Y _08575_/B _08573_/Y VDD VSS sg13g2_o21ai_1
XFILLER_74_1211 VDD VSS sg13g2_decap_8
XFILLER_41_105 VDD VSS sg13g2_decap_8
XFILLER_74_1222 VDD VSS sg13g2_fill_2
XFILLER_54_499 VDD VSS sg13g2_decap_8
XFILLER_23_820 VDD VSS sg13g2_fill_1
XFILLER_148_7 VDD VSS sg13g2_decap_8
XFILLER_168_847 VDD VSS sg13g2_fill_1
XFILLER_23_875 VDD VSS sg13g2_fill_1
XFILLER_168_858 VDD VSS sg13g2_decap_8
Xclkbuf_4_7_0_clk_i clkbuf_4_7_0_clk_i/X clkbuf_0_clk_i/X VDD VSS sg13g2_buf_8
XFILLER_50_683 VDD VSS sg13g2_decap_8
XFILLER_10_525 VDD VSS sg13g2_decap_8
XFILLER_167_357 VDD VSS sg13g2_decap_8
XFILLER_22_385 VDD VSS sg13g2_decap_8
XFILLER_41_35 VDD VSS sg13g2_decap_8
XFILLER_6_518 VDD VSS sg13g2_decap_8
XFILLER_136_711 VDD VSS sg13g2_fill_2
XFILLER_157_35 VDD VSS sg13g2_decap_8
X_09128_ _10772_/A _15047_/Q _15244_/Q _09140_/S VDD VSS sg13g2_mux2_1
XFILLER_109_958 VDD VSS sg13g2_decap_8
XFILLER_159_1110 VDD VSS sg13g2_fill_1
XFILLER_109_969 VDD VSS sg13g2_fill_1
XFILLER_159_1132 VDD VSS sg13g2_decap_8
XFILLER_108_468 VDD VSS sg13g2_decap_4
XFILLER_123_405 VDD VSS sg13g2_decap_8
XFILLER_163_574 VDD VSS sg13g2_decap_8
X_09059_ _13770_/D _13770_/Q _10153_/A1 _09112_/S VDD VSS sg13g2_mux2_1
XFILLER_123_438 VDD VSS sg13g2_decap_8
XFILLER_2_735 VDD VSS sg13g2_decap_8
X_12070_ _12070_/X _14579_/Q _14611_/Q _14643_/Q _14675_/Q _12073_/S0 _12073_/S1 VDD
+ VSS sg13g2_mux4_1
XFILLER_104_630 VDD VSS sg13g2_fill_2
XFILLER_89_341 VDD VSS sg13g2_decap_8
XFILLER_46_1335 VDD VSS sg13g2_decap_4
XFILLER_1_245 VDD VSS sg13g2_decap_8
XFILLER_104_663 VDD VSS sg13g2_decap_8
XFILLER_132_972 VDD VSS sg13g2_fill_2
X_11021_ _11021_/X _14943_/Q _11021_/B VDD VSS sg13g2_and2_1
XFILLER_173_56 VDD VSS sg13g2_decap_8
XFILLER_172_1343 VDD VSS sg13g2_decap_8
XFILLER_77_503 VDD VSS sg13g2_fill_1
XFILLER_77_514 VDD VSS sg13g2_decap_4
XFILLER_49_205 VDD VSS sg13g2_decap_8
XFILLER_46_1368 VDD VSS sg13g2_decap_8
XFILLER_81_1259 VDD VSS sg13g2_decap_4
XFILLER_46_1379 VDD VSS sg13g2_fill_1
XFILLER_89_396 VDD VSS sg13g2_fill_2
XFILLER_77_547 VDD VSS sg13g2_fill_2
X_13694__2485 _13694_/RESET_B VDD VSS sg13g2_tiehi
XFILLER_66_21 VDD VSS sg13g2_decap_8
XFILLER_49_249 VDD VSS sg13g2_decap_8
XFILLER_58_761 VDD VSS sg13g2_fill_2
X_12972_ _12990_/A _14905_/Q _13682_/Q VDD VSS sg13g2_or2_1
X_14645__1534 _14645_/RESET_B VDD VSS sg13g2_tiehi
XFILLER_85_580 VDD VSS sg13g2_fill_2
XFILLER_66_98 VDD VSS sg13g2_decap_4
X_14711_ _14711_/Q clkload34/A _14711_/D _14711_/RESET_B VDD VSS sg13g2_dfrbpq_1
X_11923_ _11923_/X _14383_/Q _14415_/Q _14479_/Q _14511_/Q _11966_/S _11972_/S1 VDD
+ VSS sg13g2_mux4_1
XFILLER_174_0 VDD VSS sg13g2_decap_8
XFILLER_79_1155 VDD VSS sg13g2_decap_4
XFILLER_46_967 VDD VSS sg13g2_fill_2
XFILLER_18_658 VDD VSS sg13g2_decap_8
XFILLER_122_60 VDD VSS sg13g2_decap_8
X_14642_ _14642_/Q _14706_/CLK _14642_/D _14642_/RESET_B VDD VSS sg13g2_dfrbpq_1
XFILLER_17_168 VDD VSS sg13g2_decap_8
X_11854_ _11854_/X _14253_/Q _14285_/Q _14317_/Q _14349_/Q _11854_/S0 _07654_/A VDD
+ VSS sg13g2_mux4_1
XFILLER_32_105 VDD VSS sg13g2_decap_8
XFILLER_127_1109 VDD VSS sg13g2_decap_8
XFILLER_92_1311 VDD VSS sg13g2_decap_8
XFILLER_72_274 VDD VSS sg13g2_decap_8
XFILLER_60_425 VDD VSS sg13g2_decap_8
X_10805_ _10805_/Y _15121_/Q _10805_/B _10805_/C VDD VSS sg13g2_nor3_1
X_14573_ _14573_/Q clkload2/A _14573_/D _14573_/RESET_B VDD VSS sg13g2_dfrbpq_1
X_11785_ _11785_/X _14251_/Q _14283_/Q _14315_/Q _14347_/Q _11848_/S0 _11851_/S1 VDD
+ VSS sg13g2_mux4_1
XFILLER_41_650 VDD VSS sg13g2_fill_2
XFILLER_14_875 VDD VSS sg13g2_decap_8
XFILLER_9_301 VDD VSS sg13g2_decap_8
X_13524_ _15141_/D _13524_/A1 _13522_/Y _13523_/Y VDD VSS sg13g2_a21oi_1
X_10736_ _10736_/Y _14943_/Q _10735_/A _10735_/Y VDD VSS sg13g2_a21oi_1
XFILLER_159_869 VDD VSS sg13g2_decap_8
XFILLER_15_91 VDD VSS sg13g2_decap_8
XFILLER_13_385 VDD VSS sg13g2_decap_8
X_15013__2574 _15013_/RESET_B VDD VSS sg13g2_tiehi
XFILLER_158_379 VDD VSS sg13g2_fill_2
X_13455_ _13463_/D _13455_/A _13455_/B _13455_/C _13455_/D VDD VSS sg13g2_or4_1
XFILLER_174_828 VDD VSS sg13g2_decap_8
X_10667_ _14894_/D _10667_/A _10667_/B _10667_/C VDD VSS sg13g2_nor3_1
XFILLER_174_839 VDD VSS sg13g2_decap_4
XFILLER_167_880 VDD VSS sg13g2_fill_2
XFILLER_9_378 VDD VSS sg13g2_decap_8
XFILLER_142_1180 VDD VSS sg13g2_fill_2
XFILLER_16_1183 VDD VSS sg13g2_decap_8
X_12406_ _12406_/X _14367_/Q _14399_/Q _14463_/Q _14495_/Q _12590_/S0 _12590_/S1 VDD
+ VSS sg13g2_mux4_1
XFILLER_12_1036 VDD VSS sg13g2_decap_8
XFILLER_51_1085 VDD VSS sg13g2_decap_8
X_13386_ _13386_/Y _08723_/A _13493_/A2 _15082_/Q VDD VSS sg13g2_o21ai_1
XFILLER_63_7 VDD VSS sg13g2_decap_8
X_10598_ _10607_/D _14876_/Q _14875_/Q VDD VSS sg13g2_and2_1
XFILLER_103_1186 VDD VSS sg13g2_decap_4
X_15125_ _15125_/Q clkload69/A _15125_/D _15125_/RESET_B VDD VSS sg13g2_dfrbpq_1
Xoutput108 mem_axi_wdata[13] _15145_/Q VDD VSS sg13g2_buf_1
X_12337_ _12337_/Y _12335_/Y _12336_/Y _11235_/X VDD VSS sg13g2_a21oi_1
Xoutput119 mem_axi_wdata[23] _15155_/Q VDD VSS sg13g2_buf_1
X_15056_ _15056_/Q clkload71/A _15056_/D _15056_/RESET_B VDD VSS sg13g2_dfrbpq_1
XFILLER_5_595 VDD VSS sg13g2_decap_8
X_15235__3003 _15235_/RESET_B VDD VSS sg13g2_tiehi
X_12268_ _12268_/Y _11868_/A _12267_/Y _11724_/B VDD VSS sg13g2_o21ai_1
X_14007_ _14007_/Q clkload34/A _14007_/D _14007_/RESET_B VDD VSS sg13g2_dfrbpq_1
X_11219_ _11219_/X _11218_/X _11878_/B1 _11881_/C1 VDD VSS sg13g2_a21o_1
X_12199_ _12200_/A _12155_/A _12151_/Y _12153_/B VDD VSS sg13g2_o21ai_1
Xoutput90 mem_axi_awaddr[29] _16882_/X VDD VSS sg13g2_buf_1
XFILLER_96_856 VDD VSS sg13g2_decap_8
XFILLER_68_547 VDD VSS sg13g2_decap_8
XFILLER_7_1351 VDD VSS sg13g2_decap_8
X_14284__1895 _14284_/RESET_B VDD VSS sg13g2_tiehi
XFILLER_83_506 VDD VSS sg13g2_fill_2
XFILLER_62_1181 VDD VSS sg13g2_decap_4
XFILLER_37_901 VDD VSS sg13g2_decap_8
XFILLER_23_1132 VDD VSS sg13g2_decap_8
XFILLER_62_1192 VDD VSS sg13g2_fill_1
XFILLER_3_1204 VDD VSS sg13g2_decap_8
XFILLER_97_1200 VDD VSS sg13g2_decap_8
XFILLER_110_1135 VDD VSS sg13g2_fill_1
X_14909_ _14909_/Q clkload57/A _14909_/D _14909_/RESET_B VDD VSS sg13g2_dfrbpq_1
X_08430_ _08441_/D _08340_/A _08428_/X _08429_/Y VDD VSS sg13g2_o21ai_1
XFILLER_91_572 VDD VSS sg13g2_fill_1
XFILLER_97_1299 VDD VSS sg13g2_decap_8
XFILLER_23_105 VDD VSS sg13g2_decap_8
XFILLER_63_285 VDD VSS sg13g2_fill_1
X_08361_ _08361_/Y _08361_/A1 _08195_/Y _08360_/Y VDD VSS sg13g2_a21oi_1
XFILLER_20_812 VDD VSS sg13g2_decap_8
XFILLER_149_335 VDD VSS sg13g2_decap_8
X_08292_ _08293_/A _08318_/D _08290_/X _08291_/Y VDD VSS sg13g2_o21ai_1
XFILLER_32_694 VDD VSS sg13g2_decap_8
XFILLER_31_182 VDD VSS sg13g2_fill_2
XFILLER_108_1097 VDD VSS sg13g2_fill_2
XFILLER_165_828 VDD VSS sg13g2_decap_8
XFILLER_30_1114 VDD VSS sg13g2_decap_8
XFILLER_20_889 VDD VSS sg13g2_decap_8
XFILLER_117_210 VDD VSS sg13g2_decap_8
XFILLER_69_1302 VDD VSS sg13g2_decap_8
XFILLER_145_530 VDD VSS sg13g2_decap_4
XFILLER_118_777 VDD VSS sg13g2_decap_8
XFILLER_11_49 VDD VSS sg13g2_decap_8
XFILLER_145_552 VDD VSS sg13g2_decap_8
XFILLER_106_928 VDD VSS sg13g2_decap_4
XFILLER_105_427 VDD VSS sg13g2_fill_2
XFILLER_117_287 VDD VSS sg13g2_decap_4
X_14723__1456 _14723_/RESET_B VDD VSS sg13g2_tiehi
XFILLER_132_213 VDD VSS sg13g2_decap_8
XFILLER_156_1338 VDD VSS sg13g2_decap_8
XFILLER_172_393 VDD VSS sg13g2_decap_8
XFILLER_121_909 VDD VSS sg13g2_decap_4
Xpicorv32_macro_1418 mem_axi_awaddr[0] VDD VSS sg13g2_tielo
Xfanout302 _11052_/A _10736_/Y VDD VSS sg13g2_buf_1
Xfanout313 _10096_/S _10102_/S VDD VSS sg13g2_buf_1
XFILLER_119_1171 VDD VSS sg13g2_decap_4
Xfanout324 _09931_/S _09937_/S VDD VSS sg13g2_buf_1
Xfanout335 _09771_/S _09768_/S VDD VSS sg13g2_buf_1
Xfanout346 _09703_/S _09702_/S VDD VSS sg13g2_buf_1
Xfanout357 _09505_/S _09506_/S VDD VSS sg13g2_buf_1
X_09815_ _14403_/D _09914_/A1 _14403_/Q _09831_/S VDD VSS sg13g2_mux2_1
XFILLER_98_182 VDD VSS sg13g2_decap_8
XFILLER_8_1148 VDD VSS sg13g2_decap_8
XFILLER_87_867 VDD VSS sg13g2_decap_8
Xfanout368 _09264_/S _09260_/S VDD VSS sg13g2_buf_1
XFILLER_28_1098 VDD VSS sg13g2_decap_8
XFILLER_115_1057 VDD VSS sg13g2_fill_2
Xfanout379 _10079_/A0 _09316_/A0 VDD VSS sg13g2_buf_1
XFILLER_74_517 VDD VSS sg13g2_fill_2
XFILLER_101_688 VDD VSS sg13g2_decap_8
X_09746_ _14336_/D _14336_/Q _09911_/A1 _09771_/S VDD VSS sg13g2_mux2_1
X_15209__2977 _15209_/RESET_B VDD VSS sg13g2_tiehi
XFILLER_41_1254 VDD VSS sg13g2_decap_8
X_13664__2544 _13664_/RESET_B VDD VSS sg13g2_tiehi
XFILLER_55_731 VDD VSS sg13g2_decap_8
XFILLER_67_591 VDD VSS sg13g2_decap_4
XFILLER_41_1276 VDD VSS sg13g2_fill_2
XFILLER_36_35 VDD VSS sg13g2_decap_8
X_09677_ _14269_/D _10140_/A1 _14269_/Q _09700_/S VDD VSS sg13g2_mux2_1
XFILLER_54_230 VDD VSS sg13g2_decap_8
X_08628_ _08628_/Y _07855_/A _08610_/Y _08627_/Y VDD VSS sg13g2_o21ai_1
XFILLER_76_1339 VDD VSS sg13g2_decap_8
XFILLER_42_403 VDD VSS sg13g2_fill_2
XFILLER_27_477 VDD VSS sg13g2_fill_2
XFILLER_14_105 VDD VSS sg13g2_decap_8
X_14915__2714 _14915_/RESET_B VDD VSS sg13g2_tiehi
XFILLER_74_1030 VDD VSS sg13g2_fill_1
X_08559_ _08560_/C _07861_/B _08598_/A3 _08591_/A3 _08559_/A3 _08635_/S0 _08635_/S1
+ VDD VSS sg13g2_mux4_1
XFILLER_30_609 VDD VSS sg13g2_decap_8
XFILLER_126_1131 VDD VSS sg13g2_decap_8
XFILLER_165_1180 VDD VSS sg13g2_decap_8
XFILLER_11_812 VDD VSS sg13g2_decap_8
XFILLER_161_1022 VDD VSS sg13g2_fill_1
X_11570_ _11638_/C _11570_/A _13683_/Q VDD VSS sg13g2_xnor2_1
XFILLER_51_992 VDD VSS sg13g2_decap_8
XFILLER_168_655 VDD VSS sg13g2_decap_4
XFILLER_10_322 VDD VSS sg13g2_decap_8
XFILLER_50_491 VDD VSS sg13g2_decap_8
XFILLER_22_182 VDD VSS sg13g2_decap_8
XFILLER_167_154 VDD VSS sg13g2_decap_8
XFILLER_168_56 VDD VSS sg13g2_decap_8
X_10521_ _10531_/D _14856_/Q _14855_/Q _10521_/C _10521_/D VDD VSS sg13g2_and4_1
XFILLER_7_805 VDD VSS sg13g2_decap_8
XFILLER_52_1350 VDD VSS sg13g2_fill_1
XFILLER_161_1088 VDD VSS sg13g2_decap_4
XFILLER_11_889 VDD VSS sg13g2_decap_8
XFILLER_13_1323 VDD VSS sg13g2_decap_8
XFILLER_155_327 VDD VSS sg13g2_fill_1
X_14059__2120 _14059_/RESET_B VDD VSS sg13g2_tiehi
X_14948__2648 _14948_/RESET_B VDD VSS sg13g2_tiehi
XFILLER_6_315 VDD VSS sg13g2_decap_8
XFILLER_52_1383 VDD VSS sg13g2_fill_1
X_13240_ _13246_/C _14923_/Q _13664_/Q VDD VSS sg13g2_xor2_1
X_10452_ _10452_/Y _14840_/Q _10450_/C _10619_/B VDD VSS sg13g2_o21ai_1
XFILLER_10_399 VDD VSS sg13g2_decap_8
XFILLER_164_850 VDD VSS sg13g2_decap_8
XFILLER_109_777 VDD VSS sg13g2_decap_4
XFILLER_170_308 VDD VSS sg13g2_decap_8
XFILLER_164_883 VDD VSS sg13g2_decap_4
X_13171_ _13176_/A _13171_/A _13172_/D VDD VSS sg13g2_nand2_1
XFILLER_124_725 VDD VSS sg13g2_decap_8
XFILLER_151_500 VDD VSS sg13g2_fill_2
X_10383_ _10386_/B _10378_/D _10380_/X _14819_/Q VDD VSS sg13g2_a21oi_1
XFILLER_163_371 VDD VSS sg13g2_decap_8
X_12122_ _12122_/Y _14919_/Q _11792_/B _12118_/Y _12121_/Y VDD VSS sg13g2_a22oi_1
XFILLER_2_532 VDD VSS sg13g2_decap_8
XFILLER_46_1110 VDD VSS sg13g2_decap_8
XFILLER_85_1181 VDD VSS sg13g2_decap_8
X_12053_ _14980_/D _12053_/A _12053_/B VDD VSS sg13g2_nor2_1
XFILLER_104_460 VDD VSS sg13g2_decap_8
XFILLER_117_82 VDD VSS sg13g2_decap_8
XFILLER_77_300 VDD VSS sg13g2_decap_8
XFILLER_104_471 VDD VSS sg13g2_fill_1
X_14807__2906 _14807_/RESET_B VDD VSS sg13g2_tiehi
XFILLER_77_42 VDD VSS sg13g2_decap_8
XFILLER_104_482 VDD VSS sg13g2_decap_8
XFILLER_77_53 VDD VSS sg13g2_fill_1
X_11004_ _11007_/A _11004_/A _11004_/B _11009_/D _11009_/C VDD VSS sg13g2_nand4_1
X_16861_ _16861_/X _16861_/A VDD VSS sg13g2_buf_1
XFILLER_81_1078 VDD VSS sg13g2_decap_4
XFILLER_77_75 VDD VSS sg13g2_decap_8
X_15126__2707 _15126_/RESET_B VDD VSS sg13g2_tiehi
Xfanout880 _12715_/S0 _12717_/S0 VDD VSS sg13g2_buf_1
Xfanout891 _12450_/S0 _12437_/S0 VDD VSS sg13g2_buf_1
XFILLER_93_859 VDD VSS sg13g2_decap_4
XFILLER_20_1316 VDD VSS sg13g2_decap_8
XFILLER_19_945 VDD VSS sg13g2_decap_8
X_14161__2018 _14161_/RESET_B VDD VSS sg13g2_tiehi
X_12955_ _12956_/A _12945_/Y _12946_/Y _12954_/Y VDD VSS sg13g2_o21ai_1
XFILLER_18_455 VDD VSS sg13g2_decap_8
XFILLER_34_915 VDD VSS sg13g2_decap_4
XFILLER_73_561 VDD VSS sg13g2_fill_2
X_11906_ _14976_/D _11868_/Y _11905_/Y _11863_/Y VDD VSS sg13g2_a21oi_1
X_12886_ _12886_/Y _12914_/A _12884_/Y _12885_/Y VDD VSS sg13g2_o21ai_1
XFILLER_2_1281 VDD VSS sg13g2_decap_8
X_14269__1910 _14269_/RESET_B VDD VSS sg13g2_tiehi
X_14625_ _14625_/Q _14681_/CLK _14625_/D _14625_/RESET_B VDD VSS sg13g2_dfrbpq_1
X_11837_ _11837_/Y _12123_/A1 _11836_/Y _12082_/B VDD VSS sg13g2_o21ai_1
XFILLER_57_1250 VDD VSS sg13g2_decap_8
XFILLER_21_609 VDD VSS sg13g2_decap_8
XFILLER_92_1163 VDD VSS sg13g2_decap_8
XFILLER_53_1114 VDD VSS sg13g2_fill_1
XFILLER_14_672 VDD VSS sg13g2_decap_8
XFILLER_60_277 VDD VSS sg13g2_decap_8
XFILLER_57_1283 VDD VSS sg13g2_decap_8
X_14556_ _14556_/Q clkload44/A _14556_/D _14556_/RESET_B VDD VSS sg13g2_dfrbpq_1
XFILLER_57_1294 VDD VSS sg13g2_fill_1
XFILLER_20_119 VDD VSS sg13g2_decap_8
X_11768_ _11768_/Y _11767_/X _11664_/A _12271_/A VDD VSS sg13g2_a21oi_1
XFILLER_42_992 VDD VSS sg13g2_decap_8
XFILLER_18_1267 VDD VSS sg13g2_decap_8
XFILLER_13_182 VDD VSS sg13g2_decap_8
XFILLER_140_1106 VDD VSS sg13g2_decap_8
XFILLER_158_154 VDD VSS sg13g2_decap_8
X_13507_ _15131_/D _13507_/A _13507_/B _13507_/C VDD VSS sg13g2_nor3_1
X_10719_ _14907_/D _11193_/B1 _10954_/C _10718_/Y VDD VSS sg13g2_o21ai_1
X_14487_ _14487_/Q clkload28/A _14487_/D _14487_/RESET_B VDD VSS sg13g2_dfrbpq_1
X_11699_ _11699_/Y _11698_/Y _11688_/Y _11680_/Y _11672_/Y _12001_/A VDD VSS sg13g2_a221oi_1
XFILLER_9_175 VDD VSS sg13g2_decap_8
X_13438_ _13438_/Y _13440_/B _13438_/B _15130_/Q _13438_/D VDD VSS sg13g2_nand4_1
X_13657__1425 _13657_/RESET_B VDD VSS sg13g2_tiehi
X_13369_ _13369_/Y _13427_/A _13469_/A _15076_/Q VDD VSS sg13g2_nand3_1
XFILLER_6_882 VDD VSS sg13g2_decap_8
XFILLER_115_736 VDD VSS sg13g2_decap_8
XFILLER_170_831 VDD VSS sg13g2_decap_8
XFILLER_115_758 VDD VSS sg13g2_fill_2
X_15108_ _15108_/Q clkload63/A _15108_/D _15108_/RESET_B VDD VSS sg13g2_dfrbpq_1
XFILLER_5_392 VDD VSS sg13g2_decap_8
XFILLER_116_1300 VDD VSS sg13g2_decap_8
XFILLER_138_1079 VDD VSS sg13g2_decap_4
X_15039_ _15039_/Q clkload50/A _15039_/D _15039_/RESET_B VDD VSS sg13g2_dfrbpq_1
X_07930_ _08286_/A _07930_/A _08318_/B VDD VSS sg13g2_nor2_1
XFILLER_29_1352 VDD VSS sg13g2_decap_8
XFILLER_116_1311 VDD VSS sg13g2_fill_2
X_14371__1808 _14371_/RESET_B VDD VSS sg13g2_tiehi
XFILLER_123_780 VDD VSS sg13g2_fill_2
X_13757__2422 _13757_/RESET_B VDD VSS sg13g2_tiehi
XFILLER_151_1224 VDD VSS sg13g2_decap_8
XFILLER_68_333 VDD VSS sg13g2_decap_4
XFILLER_122_290 VDD VSS sg13g2_fill_2
X_07861_ _08608_/B _15013_/Q _07861_/B VDD VSS sg13g2_and2_1
XFILLER_64_1298 VDD VSS sg13g2_decap_8
XFILLER_68_355 VDD VSS sg13g2_decap_8
X_09600_ _14197_/D _14197_/Q _10097_/A0 _09601_/S VDD VSS sg13g2_mux2_1
XFILLER_56_517 VDD VSS sg13g2_decap_8
XFILLER_99_1339 VDD VSS sg13g2_decap_8
XFILLER_84_837 VDD VSS sg13g2_decap_8
XFILLER_3_1001 VDD VSS sg13g2_decap_8
X_07792_ _07795_/A _08391_/B _08412_/A VDD VSS sg13g2_nand2b_1
XFILLER_110_496 VDD VSS sg13g2_decap_8
X_09531_ _14130_/D _09630_/A0 _14130_/Q _09539_/S VDD VSS sg13g2_mux2_1
XFILLER_114_1090 VDD VSS sg13g2_fill_1
X_14137__2042 _14137_/RESET_B VDD VSS sg13g2_tiehi
XFILLER_97_1052 VDD VSS sg13g2_fill_1
XFILLER_37_764 VDD VSS sg13g2_decap_4
XFILLER_25_915 VDD VSS sg13g2_fill_1
XFILLER_97_1063 VDD VSS sg13g2_decap_8
XFILLER_3_1078 VDD VSS sg13g2_decap_8
XFILLER_25_926 VDD VSS sg13g2_fill_1
X_09462_ _14063_/D _09959_/A1 _14063_/Q _09464_/S VDD VSS sg13g2_mux2_1
XFILLER_24_425 VDD VSS sg13g2_decap_8
X_08413_ _08418_/B _08383_/A _08383_/B _08415_/A _08411_/Y _08412_/Y VDD VSS sg13g2_a221oi_1
XFILLER_12_609 VDD VSS sg13g2_decap_8
X_09393_ _13996_/D _09624_/A0 _13996_/Q _09401_/S VDD VSS sg13g2_mux2_1
XFILLER_36_1323 VDD VSS sg13g2_decap_8
XFILLER_33_970 VDD VSS sg13g2_fill_1
XFILLER_11_119 VDD VSS sg13g2_decap_8
X_08344_ _08344_/Y _08168_/Y _08270_/B _08027_/Y VDD VSS sg13g2_a21oi_1
XFILLER_33_992 VDD VSS sg13g2_fill_1
XFILLER_123_1315 VDD VSS sg13g2_decap_8
XFILLER_149_143 VDD VSS sg13g2_decap_4
XFILLER_138_817 VDD VSS sg13g2_decap_8
XFILLER_123_1337 VDD VSS sg13g2_decap_4
XFILLER_149_165 VDD VSS sg13g2_fill_1
X_08275_ _08275_/Y _08275_/A _08275_/B VDD VSS sg13g2_nor2_1
XFILLER_20_686 VDD VSS sg13g2_decap_8
XFILLER_4_819 VDD VSS sg13g2_decap_8
XFILLER_164_168 VDD VSS sg13g2_decap_8
XFILLER_145_360 VDD VSS sg13g2_fill_2
XFILLER_146_894 VDD VSS sg13g2_decap_8
XFILLER_156_1102 VDD VSS sg13g2_decap_4
XFILLER_3_329 VDD VSS sg13g2_decap_8
XFILLER_161_831 VDD VSS sg13g2_decap_8
XFILLER_145_393 VDD VSS sg13g2_decap_8
XFILLER_160_330 VDD VSS sg13g2_decap_8
XFILLER_154_14 VDD VSS sg13g2_decap_8
XFILLER_82_1321 VDD VSS sg13g2_decap_8
XFILLER_133_599 VDD VSS sg13g2_decap_8
Xfanout1108 _08598_/A3 _12009_/A VDD VSS sg13g2_buf_1
X_14347__1832 _14347_/RESET_B VDD VSS sg13g2_tiehi
Xfanout1119 _11914_/A _14977_/Q VDD VSS sg13g2_buf_1
XFILLER_102_953 VDD VSS sg13g2_decap_8
Xfanout143 _10102_/A0 _09772_/A1 VDD VSS sg13g2_buf_1
Xfanout154 _10167_/A1 _09902_/A0 VDD VSS sg13g2_buf_1
XFILLER_101_441 VDD VSS sg13g2_fill_2
Xfanout165 _09768_/A1 _10165_/A1 VDD VSS sg13g2_buf_1
Xfanout176 _10163_/A1 _09126_/Y VDD VSS sg13g2_buf_1
XFILLER_102_997 VDD VSS sg13g2_fill_1
Xfanout187 _09629_/A0 fanout191/X VDD VSS sg13g2_buf_1
Xfanout198 _09828_/A0 _09927_/A1 VDD VSS sg13g2_buf_1
XFILLER_86_185 VDD VSS sg13g2_decap_8
XFILLER_47_56 VDD VSS sg13g2_decap_8
XFILLER_170_35 VDD VSS sg13g2_decap_8
XFILLER_75_859 VDD VSS sg13g2_decap_4
XFILLER_41_1062 VDD VSS sg13g2_fill_2
X_09729_ _14320_/D _09828_/A0 _14320_/Q _09730_/S VDD VSS sg13g2_mux2_1
XFILLER_27_252 VDD VSS sg13g2_decap_8
X_12740_ _12740_/X _13847_/Q _13879_/Q _13911_/Q _13943_/Q _12752_/S0 _12752_/S1 VDD
+ VSS sg13g2_mux4_1
XFILLER_70_520 VDD VSS sg13g2_decap_8
XFILLER_42_211 VDD VSS sg13g2_decap_4
XFILLER_16_959 VDD VSS sg13g2_decap_8
XFILLER_82_380 VDD VSS sg13g2_decap_8
XFILLER_70_531 VDD VSS sg13g2_fill_1
X_12671_ _12671_/X _14706_/Q _14738_/Q _13778_/Q _13810_/Q _12758_/S0 _12758_/S1 VDD
+ VSS sg13g2_mux4_1
XFILLER_43_767 VDD VSS sg13g2_fill_2
XFILLER_31_907 VDD VSS sg13g2_decap_8
XFILLER_15_469 VDD VSS sg13g2_decap_8
XFILLER_70_564 VDD VSS sg13g2_decap_8
X_15234__3002 _15234_/RESET_B VDD VSS sg13g2_tiehi
X_14410_ _14410_/Q clkload12/A _14410_/D _14410_/RESET_B VDD VSS sg13g2_dfrbpq_1
X_11622_ _11622_/X _11763_/B _11621_/X _11620_/Y VDD VSS sg13g2_a21o_1
XFILLER_168_441 VDD VSS sg13g2_decap_8
XFILLER_8_28 VDD VSS sg13g2_decap_8
XFILLER_137_0 VDD VSS sg13g2_decap_8
X_14341_ _14341_/Q _14725_/CLK _14341_/D _14341_/RESET_B VDD VSS sg13g2_dfrbpq_1
X_15155__2647 _15155_/RESET_B VDD VSS sg13g2_tiehi
XFILLER_129_828 VDD VSS sg13g2_decap_4
XFILLER_169_997 VDD VSS sg13g2_decap_8
X_11553_ _11553_/Y _11649_/S0 _13924_/Q _12015_/B VDD VSS sg13g2_a21oi_1
XFILLER_7_602 VDD VSS sg13g2_decap_8
X_13835__2344 _13835_/RESET_B VDD VSS sg13g2_tiehi
X_14595__1584 _14595_/RESET_B VDD VSS sg13g2_tiehi
XFILLER_11_686 VDD VSS sg13g2_decap_8
XFILLER_13_1120 VDD VSS sg13g2_decap_8
X_10504_ _10505_/D _14854_/Q _14853_/Q _14846_/Q _14845_/Q VDD VSS sg13g2_and4_1
XFILLER_6_112 VDD VSS sg13g2_decap_8
X_14272_ _14272_/Q clkload31/A _14272_/D _14272_/RESET_B VDD VSS sg13g2_dfrbpq_1
XFILLER_156_669 VDD VSS sg13g2_decap_8
X_11484_ _11485_/B _11461_/A _13687_/Q _11463_/Y VDD VSS sg13g2_a21oi_1
XFILLER_10_196 VDD VSS sg13g2_decap_8
XFILLER_137_861 VDD VSS sg13g2_fill_2
X_13223_ _15048_/D _13216_/Y _13222_/Y _13021_/A VDD VSS sg13g2_a21oi_1
XFILLER_7_679 VDD VSS sg13g2_decap_8
XFILLER_100_1123 VDD VSS sg13g2_decap_8
XFILLER_124_500 VDD VSS sg13g2_fill_2
XFILLER_12_70 VDD VSS sg13g2_decap_8
XFILLER_155_179 VDD VSS sg13g2_decap_8
XFILLER_170_105 VDD VSS sg13g2_decap_8
X_10435_ _14834_/D _10572_/B _10435_/B _10443_/D VDD VSS sg13g2_nor3_1
XFILLER_87_1232 VDD VSS sg13g2_decap_8
XFILLER_171_628 VDD VSS sg13g2_decap_8
XFILLER_13_1197 VDD VSS sg13g2_decap_8
XFILLER_152_831 VDD VSS sg13g2_fill_1
XFILLER_6_189 VDD VSS sg13g2_decap_8
XFILLER_128_70 VDD VSS sg13g2_decap_8
X_13154_ _13155_/B _13166_/A1 _13149_/X _13148_/Y _13160_/B _13153_/Y VDD VSS sg13g2_a221oi_1
X_10366_ _10370_/C _14814_/Q _10365_/B VDD VSS sg13g2_nor2b_1
XFILLER_87_1298 VDD VSS sg13g2_decap_4
XFILLER_174_1246 VDD VSS sg13g2_fill_2
XFILLER_112_717 VDD VSS sg13g2_decap_8
X_12105_ _12105_/Y _12252_/S0 _14516_/Q _12233_/B VDD VSS sg13g2_a21oi_1
XFILLER_124_588 VDD VSS sg13g2_fill_2
X_13085_ _13085_/Y _13085_/A _13085_/B _13085_/C VDD VSS sg13g2_nand3_1
X_10297_ _10311_/B _10297_/A _10297_/B _10297_/C VDD VSS sg13g2_nor3_1
XFILLER_3_896 VDD VSS sg13g2_decap_8
X_12036_ _12036_/X _12036_/A _12036_/B VDD VSS sg13g2_and2_1
XFILLER_26_7 VDD VSS sg13g2_decap_8
XFILLER_120_794 VDD VSS sg13g2_decap_8
XFILLER_77_185 VDD VSS sg13g2_decap_4
XFILLER_66_859 VDD VSS sg13g2_fill_2
XFILLER_24_1260 VDD VSS sg13g2_decap_8
XFILLER_20_1113 VDD VSS sg13g2_decap_8
XFILLER_19_742 VDD VSS sg13g2_decap_8
XFILLER_111_1241 VDD VSS sg13g2_decap_8
XFILLER_168_1028 VDD VSS sg13g2_decap_8
XFILLER_4_1365 VDD VSS sg13g2_decap_8
X_13987_ _13987_/Q _14659_/CLK _13987_/D _13987_/RESET_B VDD VSS sg13g2_dfrbpq_1
XFILLER_46_550 VDD VSS sg13g2_fill_2
XFILLER_59_1323 VDD VSS sg13g2_decap_8
XFILLER_18_252 VDD VSS sg13g2_decap_8
X_12938_ _12938_/Y input20/X _12795_/Y _12937_/Y VDD VSS sg13g2_o21ai_1
XFILLER_59_1345 VDD VSS sg13g2_decap_4
XFILLER_146_1326 VDD VSS sg13g2_decap_8
XFILLER_34_756 VDD VSS sg13g2_decap_4
XFILLER_33_233 VDD VSS sg13g2_fill_2
XFILLER_146_1337 VDD VSS sg13g2_fill_2
X_12869_ _12869_/Y _12914_/A _12867_/Y _12868_/Y VDD VSS sg13g2_o21ai_1
XFILLER_21_406 VDD VSS sg13g2_decap_8
X_14608_ _14608_/Q _14672_/CLK _14608_/D _14608_/RESET_B VDD VSS sg13g2_dfrbpq_1
XFILLER_159_441 VDD VSS sg13g2_fill_1
XFILLER_18_1064 VDD VSS sg13g2_decap_8
X_14539_ _14539_/Q clkload0/A _14539_/D _14539_/RESET_B VDD VSS sg13g2_dfrbpq_1
XFILLER_105_1045 VDD VSS sg13g2_decap_8
X_14425__1754 _14425_/RESET_B VDD VSS sg13g2_tiehi
X_08060_ _08060_/X _11526_/A _11570_/A _11591_/A _11635_/A _08253_/S0 _08235_/S0 VDD
+ VSS sg13g2_mux4_1
XFILLER_135_809 VDD VSS sg13g2_decap_8
X_15208__2976 _15208_/RESET_B VDD VSS sg13g2_tiehi
XFILLER_31_1253 VDD VSS sg13g2_decap_8
XFILLER_146_179 VDD VSS sg13g2_fill_2
XFILLER_161_105 VDD VSS sg13g2_decap_8
XFILLER_143_820 VDD VSS sg13g2_fill_2
XFILLER_155_680 VDD VSS sg13g2_fill_2
XFILLER_52_0 VDD VSS sg13g2_decap_8
XFILLER_115_544 VDD VSS sg13g2_decap_8
XFILLER_66_1338 VDD VSS sg13g2_decap_8
XFILLER_153_1308 VDD VSS sg13g2_fill_2
XFILLER_103_728 VDD VSS sg13g2_fill_1
X_08962_ _09707_/C _09441_/A _09441_/C VDD VSS sg13g2_nand2_1
XFILLER_142_385 VDD VSS sg13g2_fill_1
XFILLER_9_1232 VDD VSS sg13g2_decap_8
X_07913_ _07913_/Y _07913_/A _08063_/B VDD VSS sg13g2_nand2_1
XFILLER_64_1062 VDD VSS sg13g2_fill_1
XFILLER_124_28 VDD VSS sg13g2_decap_8
X_08893_ _08893_/Y _08893_/A _14941_/Q VDD VSS sg13g2_nor2b_1
XFILLER_57_804 VDD VSS sg13g2_decap_8
XFILLER_84_601 VDD VSS sg13g2_decap_8
XFILLER_64_1095 VDD VSS sg13g2_fill_1
XFILLER_112_1005 VDD VSS sg13g2_fill_1
XFILLER_116_1174 VDD VSS sg13g2_fill_1
XFILLER_25_1057 VDD VSS sg13g2_decap_8
X_07844_ _07844_/X _15017_/Q _07972_/B VDD VSS sg13g2_and2_1
XFILLER_99_1125 VDD VSS sg13g2_decap_8
XFILLER_57_848 VDD VSS sg13g2_decap_8
XFILLER_83_122 VDD VSS sg13g2_fill_1
XFILLER_56_358 VDD VSS sg13g2_fill_1
X_13913__2266 _13913_/RESET_B VDD VSS sg13g2_tiehi
X_07775_ _08318_/C _07775_/A _08306_/B VDD VSS sg13g2_xor2_1
X_09514_ _14113_/D _10077_/A0 _14113_/Q _09535_/S VDD VSS sg13g2_mux2_1
XFILLER_140_49 VDD VSS sg13g2_fill_2
XFILLER_83_199 VDD VSS sg13g2_decap_8
XFILLER_25_756 VDD VSS sg13g2_decap_8
X_09445_ _14046_/D _09610_/A0 _14046_/Q _09467_/S VDD VSS sg13g2_mux2_1
XFILLER_12_406 VDD VSS sg13g2_decap_8
XFILLER_24_266 VDD VSS sg13g2_decap_8
XFILLER_169_238 VDD VSS sg13g2_decap_8
XFILLER_33_14 VDD VSS sg13g2_decap_8
X_15110__2739 _15110_/RESET_B VDD VSS sg13g2_tiehi
X_09376_ _13979_/D _09574_/A1 _13979_/Q _09401_/S VDD VSS sg13g2_mux2_1
XFILLER_71_1011 VDD VSS sg13g2_decap_4
XFILLER_36_1131 VDD VSS sg13g2_decap_8
XFILLER_149_14 VDD VSS sg13g2_decap_8
X_08327_ _08327_/X _11635_/A _11591_/A _11570_/A _11526_/A _08635_/S0 _08635_/S1 VDD
+ VSS sg13g2_mux4_1
XFILLER_130_7 VDD VSS sg13g2_decap_8
XFILLER_162_1172 VDD VSS sg13g2_decap_8
XFILLER_166_923 VDD VSS sg13g2_fill_2
XFILLER_71_1055 VDD VSS sg13g2_decap_8
XFILLER_21_973 VDD VSS sg13g2_decap_8
XFILLER_166_967 VDD VSS sg13g2_fill_1
X_08258_ _08258_/Y _08692_/A _14998_/Q _08258_/C VDD VSS sg13g2_nand3_1
XFILLER_20_483 VDD VSS sg13g2_decap_8
XFILLER_165_455 VDD VSS sg13g2_decap_8
XFILLER_4_616 VDD VSS sg13g2_decap_8
X_08189_ _08190_/B _07909_/B _07910_/A _08188_/Y VDD VSS sg13g2_a21oi_1
XFILLER_106_522 VDD VSS sg13g2_fill_2
XFILLER_10_1337 VDD VSS sg13g2_decap_8
XFILLER_165_35 VDD VSS sg13g2_decap_8
X_10220_ _10220_/Y _14767_/Q _14768_/Q _10334_/C VDD VSS sg13g2_o21ai_1
XFILLER_3_126 VDD VSS sg13g2_decap_8
XFILLER_161_661 VDD VSS sg13g2_fill_2
XFILLER_0_800 VDD VSS sg13g2_decap_8
XFILLER_106_577 VDD VSS sg13g2_fill_1
XFILLER_133_374 VDD VSS sg13g2_decap_8
X_10151_ _14728_/D _14728_/Q _10151_/A1 _10160_/S VDD VSS sg13g2_mux2_1
XFILLER_133_385 VDD VSS sg13g2_fill_2
XFILLER_160_182 VDD VSS sg13g2_decap_8
X_10082_ _14662_/D _10082_/A0 _14662_/Q _10093_/S VDD VSS sg13g2_mux2_1
XFILLER_88_962 VDD VSS sg13g2_fill_1
XFILLER_82_1173 VDD VSS sg13g2_decap_8
XFILLER_48_804 VDD VSS sg13g2_decap_8
XFILLER_0_877 VDD VSS sg13g2_decap_8
X_13910_ _13910_/Q clkload27/A _13910_/D _13910_/RESET_B VDD VSS sg13g2_dfrbpq_1
X_14890_ _14890_/Q _14890_/CLK _14890_/D _14890_/RESET_B VDD VSS sg13g2_dfrbpq_1
XFILLER_74_111 VDD VSS sg13g2_fill_2
XFILLER_169_1326 VDD VSS sg13g2_fill_1
XFILLER_63_807 VDD VSS sg13g2_decap_8
X_13841_ _13841_/Q _14662_/CLK _13841_/D _13841_/RESET_B VDD VSS sg13g2_dfrbpq_1
XFILLER_74_21 VDD VSS sg13g2_decap_8
X_14503__1676 _14503_/RESET_B VDD VSS sg13g2_tiehi
XFILLER_169_1359 VDD VSS sg13g2_decap_8
X_13772_ _13772_/Q clkload35/A _13772_/D _13772_/RESET_B VDD VSS sg13g2_dfrbpq_1
XFILLER_74_65 VDD VSS sg13g2_fill_1
X_10984_ _10984_/Y _10984_/A _10981_/Y VDD VSS sg13g2_nor2b_1
XFILLER_16_756 VDD VSS sg13g2_decap_8
XFILLER_71_851 VDD VSS sg13g2_decap_8
X_12723_ _12736_/A _12751_/A1 _12765_/A2 _15016_/Q VDD VSS sg13g2_a21oi_1
XFILLER_15_266 VDD VSS sg13g2_decap_8
XFILLER_71_884 VDD VSS sg13g2_decap_4
XFILLER_70_361 VDD VSS sg13g2_fill_1
XFILLER_128_1056 VDD VSS sg13g2_fill_1
X_12654_ _12654_/X _14577_/Q _14609_/Q _14641_/Q _14673_/Q _12661_/S0 _12661_/S1 VDD
+ VSS sg13g2_mux4_1
XFILLER_90_42 VDD VSS sg13g2_decap_8
XFILLER_19_1351 VDD VSS sg13g2_decap_8
XFILLER_106_1310 VDD VSS sg13g2_fill_2
XFILLER_157_901 VDD VSS sg13g2_fill_2
XFILLER_90_53 VDD VSS sg13g2_fill_2
XFILLER_70_394 VDD VSS sg13g2_fill_1
XFILLER_54_1242 VDD VSS sg13g2_fill_2
XFILLER_15_1204 VDD VSS sg13g2_decap_8
X_11605_ _11605_/Y _11597_/A _14662_/Q _11690_/B VDD VSS sg13g2_a21oi_1
XFILLER_106_1332 VDD VSS sg13g2_fill_1
XFILLER_12_973 VDD VSS sg13g2_decap_8
X_12585_ _12585_/X _14124_/Q _14156_/Q _14188_/Q _14220_/Q _12590_/S0 _12590_/S1 VDD
+ VSS sg13g2_mux4_1
XFILLER_157_945 VDD VSS sg13g2_decap_8
XFILLER_102_1207 VDD VSS sg13g2_decap_8
XFILLER_11_483 VDD VSS sg13g2_decap_8
XFILLER_128_135 VDD VSS sg13g2_decap_8
X_14324_ _14324_/Q clkload15/A _14324_/D _14324_/RESET_B VDD VSS sg13g2_dfrbpq_1
X_11536_ _11536_/Y _11531_/A _14564_/Q VDD VSS sg13g2_nand2b_1
XFILLER_8_966 VDD VSS sg13g2_decap_8
XFILLER_23_91 VDD VSS sg13g2_decap_8
XFILLER_157_989 VDD VSS sg13g2_decap_8
Xwire352 wire352/X wire352/A VDD VSS sg13g2_buf_4
XFILLER_89_1338 VDD VSS sg13g2_decap_8
XFILLER_116_308 VDD VSS sg13g2_decap_8
XFILLER_144_617 VDD VSS sg13g2_fill_1
X_14255_ _14255_/Q clkload6/A _14255_/D _14255_/RESET_B VDD VSS sg13g2_dfrbpq_1
XFILLER_7_476 VDD VSS sg13g2_decap_8
X_11467_ _11467_/X _13953_/Q _13985_/Q _14017_/Q _14049_/Q _12282_/S0 _12282_/S1 VDD
+ VSS sg13g2_mux4_1
XFILLER_171_425 VDD VSS sg13g2_decap_8
XFILLER_125_820 VDD VSS sg13g2_fill_2
XFILLER_137_680 VDD VSS sg13g2_fill_1
XFILLER_109_382 VDD VSS sg13g2_decap_4
XFILLER_87_1040 VDD VSS sg13g2_fill_2
X_13206_ _13206_/Y _14825_/Q _13206_/B VDD VSS sg13g2_nand2_1
X_10418_ _10420_/A _14828_/Q _10422_/D _14829_/Q VDD VSS sg13g2_a21o_1
X_14186_ _14186_/Q _14666_/CLK _14186_/D _14186_/RESET_B VDD VSS sg13g2_dfrbpq_1
XFILLER_139_1141 VDD VSS sg13g2_decap_4
X_11398_ _11398_/Y _11400_/A _14591_/Q _11419_/C VDD VSS sg13g2_a21oi_1
XFILLER_124_352 VDD VSS sg13g2_decap_8
XFILLER_174_1032 VDD VSS sg13g2_fill_1
XFILLER_125_897 VDD VSS sg13g2_decap_4
X_13137_ _13139_/A _14820_/Q _13068_/B _13162_/B1 _14884_/Q VDD VSS sg13g2_a22oi_1
X_10349_ _10350_/B _14809_/Q _10352_/C VDD VSS sg13g2_nand2_1
XFILLER_135_1027 VDD VSS sg13g2_fill_2
XFILLER_3_693 VDD VSS sg13g2_decap_8
XFILLER_140_867 VDD VSS sg13g2_decap_8
XFILLER_26_1322 VDD VSS sg13g2_decap_8
XFILLER_100_709 VDD VSS sg13g2_decap_8
XFILLER_112_569 VDD VSS sg13g2_decap_8
X_13068_ _13068_/Y _14815_/Q _13068_/B VDD VSS sg13g2_nand2_1
X_12019_ _12019_/Y _12019_/A _12019_/B _12188_/C VDD VSS sg13g2_nand3_1
XFILLER_22_1219 VDD VSS sg13g2_decap_8
XFILLER_38_347 VDD VSS sg13g2_fill_2
XFILLER_4_1162 VDD VSS sg13g2_decap_8
XFILLER_46_380 VDD VSS sg13g2_decap_8
XFILLER_0_84 VDD VSS sg13g2_decap_8
XFILLER_0_1059 VDD VSS sg13g2_decap_8
XFILLER_34_553 VDD VSS sg13g2_decap_8
X_09230_ _13841_/D _10160_/A1 _13841_/Q _09230_/S VDD VSS sg13g2_mux2_1
XFILLER_21_203 VDD VSS sg13g2_decap_8
XFILLER_142_1009 VDD VSS sg13g2_fill_2
XFILLER_22_759 VDD VSS sg13g2_decap_8
X_14658__1521 _14658_/RESET_B VDD VSS sg13g2_tiehi
X_09161_ _10793_/C _15052_/Q _15249_/Q _09161_/S VDD VSS sg13g2_mux2_1
XFILLER_33_1337 VDD VSS sg13g2_decap_8
X_08112_ _15220_/D _08112_/A _08112_/B _08112_/C _08112_/D VDD VSS sg13g2_nand4_1
XFILLER_108_809 VDD VSS sg13g2_fill_1
X_09092_ _13775_/D _13775_/Q _10125_/A0 _09106_/S VDD VSS sg13g2_mux2_1
XFILLER_119_146 VDD VSS sg13g2_fill_2
XFILLER_119_28 VDD VSS sg13g2_decap_8
X_14087__2092 _14087_/RESET_B VDD VSS sg13g2_tiehi
XFILLER_174_252 VDD VSS sg13g2_decap_8
X_14802__2911 _14802_/RESET_B VDD VSS sg13g2_tiehi
XFILLER_174_263 VDD VSS sg13g2_decap_8
XFILLER_134_105 VDD VSS sg13g2_decap_8
X_08043_ _08043_/Y _08042_/X _08177_/S VDD VSS sg13g2_nand2b_1
XFILLER_128_680 VDD VSS sg13g2_decap_4
XFILLER_162_425 VDD VSS sg13g2_decap_8
XFILLER_116_853 VDD VSS sg13g2_decap_8
XFILLER_157_1230 VDD VSS sg13g2_decap_4
XFILLER_116_864 VDD VSS sg13g2_fill_1
XFILLER_143_661 VDD VSS sg13g2_decap_8
XFILLER_118_1203 VDD VSS sg13g2_fill_2
X_15026__2561 _15026_/RESET_B VDD VSS sg13g2_tiehi
XFILLER_116_897 VDD VSS sg13g2_fill_1
XFILLER_103_525 VDD VSS sg13g2_fill_1
XFILLER_118_1236 VDD VSS sg13g2_fill_1
XFILLER_131_834 VDD VSS sg13g2_fill_2
XFILLER_142_171 VDD VSS sg13g2_decap_8
Xhold3024 input32/A mem_axi_rdata[6] VDD VSS sg13g2_dlygate4sd3_1
X_09994_ _14577_/D _10127_/A0 _14577_/Q _09994_/S VDD VSS sg13g2_mux2_1
XFILLER_66_1168 VDD VSS sg13g2_fill_1
XFILLER_103_536 VDD VSS sg13g2_fill_1
XFILLER_130_322 VDD VSS sg13g2_decap_8
XFILLER_135_49 VDD VSS sg13g2_decap_8
XFILLER_153_1127 VDD VSS sg13g2_decap_8
X_15233__3001 _15233_/RESET_B VDD VSS sg13g2_tiehi
Xhold3035 hold3035/X input15/X VDD VSS sg13g2_dlygate4sd3_1
XFILLER_88_236 VDD VSS sg13g2_decap_8
Xhold3046 hold3046/X input6/X VDD VSS sg13g2_dlygate4sd3_1
Xhold3057 _15194_/D _10187_/X VDD VSS sg13g2_dlygate4sd3_1
XFILLER_103_569 VDD VSS sg13g2_fill_1
Xhold3068 hold3068/X input20/X VDD VSS sg13g2_dlygate4sd3_1
X_08945_ _08945_/Y _12229_/A _08940_/S _08944_/Y VDD VSS sg13g2_a21oi_1
XFILLER_88_269 VDD VSS sg13g2_fill_1
Xhold3079 hold3079/X input19/X VDD VSS sg13g2_dlygate4sd3_1
XFILLER_85_910 VDD VSS sg13g2_decap_8
XFILLER_28_14 VDD VSS sg13g2_decap_8
XFILLER_29_314 VDD VSS sg13g2_fill_1
X_08876_ _13702_/D _16864_/A _08875_/X _08941_/S VDD VSS sg13g2_mux2_1
XFILLER_84_431 VDD VSS sg13g2_fill_1
XFILLER_57_645 VDD VSS sg13g2_fill_1
XFILLER_56_133 VDD VSS sg13g2_decap_4
X_07827_ _08574_/B _15005_/Q _07946_/B VDD VSS sg13g2_xor2_1
XFILLER_72_615 VDD VSS sg13g2_decap_8
XFILLER_57_689 VDD VSS sg13g2_decap_8
XFILLER_42_1190 VDD VSS sg13g2_decap_8
XFILLER_38_870 VDD VSS sg13g2_fill_1
XFILLER_71_103 VDD VSS sg13g2_decap_8
XFILLER_44_317 VDD VSS sg13g2_fill_1
X_14876__2792 _14876_/RESET_B VDD VSS sg13g2_tiehi
X_07758_ _07758_/Y wire649/X _13282_/A1 _07757_/Y VDD VSS sg13g2_o21ai_1
XFILLER_71_114 VDD VSS sg13g2_fill_2
XFILLER_77_1231 VDD VSS sg13g2_decap_8
XFILLER_44_35 VDD VSS sg13g2_decap_8
XFILLER_129_1332 VDD VSS sg13g2_decap_4
X_07689_ _07690_/A _13302_/C _13281_/C VDD VSS sg13g2_nand2_1
X_14297__1882 _14297_/RESET_B VDD VSS sg13g2_tiehi
XFILLER_53_884 VDD VSS sg13g2_decap_8
XFILLER_12_203 VDD VSS sg13g2_decap_8
XFILLER_73_1128 VDD VSS sg13g2_fill_1
X_09428_ _14030_/D _09760_/A1 _14030_/Q _09434_/S VDD VSS sg13g2_mux2_1
XFILLER_80_681 VDD VSS sg13g2_decap_8
XFILLER_52_383 VDD VSS sg13g2_decap_8
XFILLER_52_394 VDD VSS sg13g2_decap_8
XFILLER_139_923 VDD VSS sg13g2_fill_2
X_09359_ _13963_/D _09623_/A0 _13963_/Q _09365_/S VDD VSS sg13g2_mux2_1
XFILLER_100_63 VDD VSS sg13g2_fill_2
XFILLER_139_945 VDD VSS sg13g2_decap_4
XFILLER_21_770 VDD VSS sg13g2_decap_8
X_12370_ _12370_/X _12366_/X _12365_/X _12364_/X _12363_/X _12398_/S0 _12398_/S1 VDD
+ VSS sg13g2_mux4_1
XFILLER_139_978 VDD VSS sg13g2_decap_8
XFILLER_5_903 VDD VSS sg13g2_decap_8
XFILLER_20_280 VDD VSS sg13g2_decap_8
XFILLER_165_252 VDD VSS sg13g2_decap_8
XFILLER_166_786 VDD VSS sg13g2_decap_8
X_11321_ _11321_/Y _11319_/Y _11318_/Y _11329_/B1 _11320_/X VDD VSS sg13g2_a22oi_1
XFILLER_125_105 VDD VSS sg13g2_decap_8
XFILLER_119_680 VDD VSS sg13g2_decap_8
XFILLER_14_1281 VDD VSS sg13g2_decap_8
XFILLER_4_413 VDD VSS sg13g2_decap_8
XFILLER_125_127 VDD VSS sg13g2_fill_1
XFILLER_10_1134 VDD VSS sg13g2_decap_8
X_14040_ _14040_/Q _14744_/CLK _14040_/D _14040_/RESET_B VDD VSS sg13g2_dfrbpq_1
X_11252_ _11252_/Y _12303_/S _14588_/Q _12307_/C VDD VSS sg13g2_a21oi_1
XFILLER_84_1213 VDD VSS sg13g2_decap_8
XFILLER_69_21 VDD VSS sg13g2_decap_8
XFILLER_84_1224 VDD VSS sg13g2_fill_1
XFILLER_69_32 VDD VSS sg13g2_fill_1
XFILLER_134_661 VDD VSS sg13g2_decap_8
XFILLER_162_970 VDD VSS sg13g2_decap_8
X_10203_ _15183_/D hold3041/X _15183_/Q _10203_/S VDD VSS sg13g2_mux2_1
X_11183_ _11183_/Y _10956_/C _11181_/A _11183_/B1 VDD VSS sg13g2_o21ai_1
XFILLER_84_1279 VDD VSS sg13g2_decap_8
XFILLER_171_1227 VDD VSS sg13g2_decap_8
XFILLER_0_630 VDD VSS sg13g2_decap_8
XFILLER_136_1358 VDD VSS sg13g2_fill_2
X_10134_ _14712_/D _10167_/A1 _14712_/Q _10134_/S VDD VSS sg13g2_mux2_1
X_13785__2394 _13785_/RESET_B VDD VSS sg13g2_tiehi
XFILLER_95_718 VDD VSS sg13g2_decap_4
XFILLER_79_269 VDD VSS sg13g2_decap_4
XFILLER_88_770 VDD VSS sg13g2_decap_8
XFILLER_76_910 VDD VSS sg13g2_decap_4
X_14942_ _14942_/Q clkload43/A _14942_/D _14942_/RESET_B VDD VSS sg13g2_dfrbpq_1
X_10065_ _14646_/D _10098_/A0 _14646_/Q _10068_/S VDD VSS sg13g2_mux2_1
XFILLER_85_31 VDD VSS sg13g2_fill_2
XFILLER_102_591 VDD VSS sg13g2_decap_8
X_14736__1443 _14736_/RESET_B VDD VSS sg13g2_tiehi
XFILLER_48_645 VDD VSS sg13g2_decap_8
X_15053__2519 _15053_/RESET_B VDD VSS sg13g2_tiehi
XFILLER_36_818 VDD VSS sg13g2_decap_8
X_14873_ _14873_/Q _14874_/CLK _14873_/D _14873_/RESET_B VDD VSS sg13g2_dfrbpq_1
XFILLER_78_1006 VDD VSS sg13g2_decap_8
XFILLER_169_1134 VDD VSS sg13g2_decap_8
XFILLER_85_97 VDD VSS sg13g2_fill_1
XFILLER_48_689 VDD VSS sg13g2_decap_4
XFILLER_1_1302 VDD VSS sg13g2_decap_8
XFILLER_63_626 VDD VSS sg13g2_decap_4
X_15207__2975 _15207_/RESET_B VDD VSS sg13g2_tiehi
X_13824_ _13824_/Q _14721_/CLK _13824_/D _13824_/RESET_B VDD VSS sg13g2_dfrbpq_1
XFILLER_21_1274 VDD VSS sg13g2_decap_8
XFILLER_18_91 VDD VSS sg13g2_decap_8
XFILLER_44_840 VDD VSS sg13g2_decap_8
XFILLER_16_553 VDD VSS sg13g2_decap_8
XFILLER_1_1379 VDD VSS sg13g2_fill_1
X_13755_ _13755_/Q clkload46/A _13755_/D _13755_/RESET_B VDD VSS sg13g2_dfrbpq_1
X_10967_ _10995_/C _10967_/A _11015_/C VDD VSS sg13g2_nand2_1
XFILLER_91_1206 VDD VSS sg13g2_fill_2
XFILLER_56_1326 VDD VSS sg13g2_fill_1
XFILLER_143_1307 VDD VSS sg13g2_fill_1
X_12706_ _12706_/X _12705_/X _12704_/X _12706_/S VDD VSS sg13g2_mux2_1
XFILLER_31_523 VDD VSS sg13g2_decap_8
XFILLER_93_7 VDD VSS sg13g2_decap_8
X_13686_ _13686_/Q clkload55/A _13686_/D _13686_/RESET_B VDD VSS sg13g2_dfrbpq_1
X_10898_ _10898_/X _10923_/D _10923_/A _10898_/B1 VDD VSS sg13g2_a21o_1
XFILLER_15_1001 VDD VSS sg13g2_decap_8
X_12637_ _12637_/Y _13673_/Q _12707_/A2 _12636_/X _12679_/B2 _12707_/C1 VDD VSS sg13g2_a221oi_1
XFILLER_54_1072 VDD VSS sg13g2_decap_8
XFILLER_12_770 VDD VSS sg13g2_decap_8
XFILLER_141_1031 VDD VSS sg13g2_fill_2
XFILLER_54_1083 VDD VSS sg13g2_fill_2
XFILLER_129_444 VDD VSS sg13g2_decap_8
XFILLER_54_1094 VDD VSS sg13g2_decap_8
X_12568_ _12569_/B _13678_/Q _12721_/A2 _12567_/X _12721_/B2 _12763_/C1 VDD VSS sg13g2_a221oi_1
XFILLER_11_280 VDD VSS sg13g2_decap_8
XFILLER_15_1078 VDD VSS sg13g2_decap_8
XFILLER_8_763 VDD VSS sg13g2_decap_8
XFILLER_89_1135 VDD VSS sg13g2_decap_4
X_14307_ _14307_/Q _14505_/CLK _14307_/D _14307_/RESET_B VDD VSS sg13g2_dfrbpq_1
X_11519_ _11519_/Y _11559_/C _11517_/X _11518_/Y VDD VSS sg13g2_o21ai_1
XFILLER_102_1048 VDD VSS sg13g2_decap_8
XFILLER_129_499 VDD VSS sg13g2_decap_8
XFILLER_172_734 VDD VSS sg13g2_fill_1
X_12499_ _14999_/D _12499_/A _12499_/B VDD VSS sg13g2_nor2_1
XFILLER_7_273 VDD VSS sg13g2_decap_8
XFILLER_171_233 VDD VSS sg13g2_decap_8
X_14238_ _14238_/Q _14686_/CLK _14238_/D _14238_/RESET_B VDD VSS sg13g2_dfrbpq_1
XFILLER_172_789 VDD VSS sg13g2_fill_2
X_14169_ _14169_/Q clkload21/A _14169_/D _14169_/RESET_B VDD VSS sg13g2_dfrbpq_1
XFILLER_4_980 VDD VSS sg13g2_decap_8
XFILLER_140_620 VDD VSS sg13g2_decap_8
XFILLER_63_1308 VDD VSS sg13g2_fill_2
Xfanout709 _11815_/B fanout712/X VDD VSS sg13g2_buf_1
XFILLER_124_193 VDD VSS sg13g2_decap_8
XFILLER_3_490 VDD VSS sg13g2_decap_8
XFILLER_113_1100 VDD VSS sg13g2_decap_4
X_08730_ _08730_/Y _07720_/A _11288_/A _13448_/B VDD VSS sg13g2_o21ai_1
XFILLER_79_792 VDD VSS sg13g2_decap_8
XFILLER_117_1291 VDD VSS sg13g2_fill_1
XFILLER_6_1246 VDD VSS sg13g2_decap_8
XFILLER_15_0 VDD VSS sg13g2_decap_8
Xfanout1280 _12169_/C _12187_/C VDD VSS sg13g2_buf_1
XFILLER_94_751 VDD VSS sg13g2_decap_8
XFILLER_38_133 VDD VSS sg13g2_decap_8
XFILLER_26_1196 VDD VSS sg13g2_decap_8
Xfanout1291 fanout1291/X _12215_/S1 VDD VSS sg13g2_buf_1
X_08661_ _08661_/X _08661_/A _08661_/B _08661_/C _08661_/D VDD VSS sg13g2_and4_1
XFILLER_67_976 VDD VSS sg13g2_decap_4
XFILLER_66_453 VDD VSS sg13g2_decap_4
XFILLER_61_1087 VDD VSS sg13g2_decap_8
XFILLER_54_604 VDD VSS sg13g2_decap_8
XFILLER_54_615 VDD VSS sg13g2_fill_2
X_07612_ _08290_/S _08248_/A VDD VSS sg13g2_inv_1
XFILLER_54_626 VDD VSS sg13g2_decap_8
XFILLER_93_283 VDD VSS sg13g2_decap_8
XFILLER_82_946 VDD VSS sg13g2_decap_8
XFILLER_66_497 VDD VSS sg13g2_decap_8
XFILLER_148_1218 VDD VSS sg13g2_fill_2
X_08592_ _08592_/X _08337_/X _08427_/X _08510_/X _08591_/X _08511_/S _08329_/B VDD
+ VSS sg13g2_mux4_1
XFILLER_53_169 VDD VSS sg13g2_decap_4
XFILLER_35_873 VDD VSS sg13g2_fill_1
XFILLER_50_810 VDD VSS sg13g2_fill_2
XFILLER_90_990 VDD VSS sg13g2_decap_8
X_09213_ _13824_/D _10143_/A1 _13824_/Q _09237_/S VDD VSS sg13g2_mux2_1
XFILLER_10_707 VDD VSS sg13g2_decap_8
XFILLER_14_49 VDD VSS sg13g2_decap_8
X_14174__2005 _14174_/RESET_B VDD VSS sg13g2_tiehi
XFILLER_167_539 VDD VSS sg13g2_decap_8
XFILLER_72_1172 VDD VSS sg13g2_decap_8
XFILLER_124_1251 VDD VSS sg13g2_decap_8
X_09144_ _09145_/B _13245_/A _09137_/C _09143_/Y VDD VSS sg13g2_o21ai_1
XFILLER_147_230 VDD VSS sg13g2_decap_8
XFILLER_108_617 VDD VSS sg13g2_fill_2
XFILLER_33_1178 VDD VSS sg13g2_fill_1
XFILLER_135_414 VDD VSS sg13g2_fill_1
X_09075_ _09075_/X _13088_/A _09103_/C _09074_/Y VDD VSS sg13g2_a21o_1
XFILLER_135_447 VDD VSS sg13g2_decap_8
XFILLER_159_1347 VDD VSS sg13g2_decap_8
X_08026_ _08397_/A _08201_/A wire660/X VDD VSS sg13g2_nor2_1
XFILLER_159_1358 VDD VSS sg13g2_fill_2
XFILLER_163_778 VDD VSS sg13g2_fill_2
XFILLER_162_266 VDD VSS sg13g2_fill_1
XFILLER_2_917 VDD VSS sg13g2_decap_8
XFILLER_162_299 VDD VSS sg13g2_decap_8
XFILLER_1_427 VDD VSS sg13g2_decap_8
XFILLER_104_845 VDD VSS sg13g2_decap_8
XFILLER_115_182 VDD VSS sg13g2_decap_8
XFILLER_157_1082 VDD VSS sg13g2_decap_8
XFILLER_103_333 VDD VSS sg13g2_fill_2
XFILLER_131_664 VDD VSS sg13g2_decap_8
XFILLER_162_14 VDD VSS sg13g2_decap_8
XFILLER_39_35 VDD VSS sg13g2_decap_8
XFILLER_103_366 VDD VSS sg13g2_decap_8
X_09977_ _14560_/D _10043_/A0 _14560_/Q _09999_/S VDD VSS sg13g2_mux2_1
XFILLER_118_1077 VDD VSS sg13g2_decap_8
Xclkbuf_4_3_0_clk_i clkbuf_4_3_0_clk_i/X clkbuf_0_clk_i/X VDD VSS sg13g2_buf_8
X_14205__1974 _14205_/RESET_B VDD VSS sg13g2_tiehi
XFILLER_58_921 VDD VSS sg13g2_decap_8
XFILLER_130_174 VDD VSS sg13g2_fill_2
X_14981__2606 _14981_/RESET_B VDD VSS sg13g2_tiehi
Xclkbuf_leaf_100_clk_i clkload35/A clkbuf_leaf_99_clk_i/A VDD VSS sg13g2_buf_8
XFILLER_58_932 VDD VSS sg13g2_fill_1
X_08928_ _08928_/X _08927_/X _12061_/A _08931_/S VDD VSS sg13g2_mux2_1
XFILLER_170_1271 VDD VSS sg13g2_decap_4
XFILLER_170_1282 VDD VSS sg13g2_decap_8
X_08859_ _08859_/X _15028_/Q _14932_/Q _10675_/A VDD VSS sg13g2_mux2_1
XFILLER_73_924 VDD VSS sg13g2_decap_8
X_11870_ _11870_/Y _12090_/A _13870_/Q _12091_/C VDD VSS sg13g2_a21oi_1
Xclkbuf_leaf_115_clk_i _14730_/CLK clkbuf_5_5__f_clk_i/X VDD VSS sg13g2_buf_8
X_10821_ _10823_/C _10821_/A _10821_/B _10821_/C VDD VSS sg13g2_nand3_1
XFILLER_26_862 VDD VSS sg13g2_decap_8
XFILLER_38_1012 VDD VSS sg13g2_decap_8
XFILLER_164_1031 VDD VSS sg13g2_fill_2
XFILLER_81_990 VDD VSS sg13g2_decap_8
X_13540_ _15145_/D _13543_/B _13538_/Y _13539_/Y VDD VSS sg13g2_a21oi_1
X_10752_ _10752_/Y _10757_/A _10752_/B VDD VSS sg13g2_nor2_1
XFILLER_125_1015 VDD VSS sg13g2_decap_4
XFILLER_38_1078 VDD VSS sg13g2_decap_4
XFILLER_13_567 VDD VSS sg13g2_decap_8
XFILLER_158_539 VDD VSS sg13g2_decap_4
X_13471_ _15176_/D hold3021/X _15176_/Q _13477_/S VDD VSS sg13g2_mux2_1
XFILLER_71_55 VDD VSS sg13g2_decap_8
XFILLER_125_1048 VDD VSS sg13g2_decap_8
X_10683_ _10827_/B _08985_/X _10691_/S _08848_/Y VDD VSS sg13g2_a21oi_1
XFILLER_71_66 VDD VSS sg13g2_fill_2
X_15210_ _15210_/Q _15213_/CLK _15210_/D _15210_/RESET_B VDD VSS sg13g2_dfrbpq_1
X_12422_ _12422_/X _14560_/Q _14592_/Q _14624_/Q _14656_/Q _12742_/S0 _12742_/S1 VDD
+ VSS sg13g2_mux4_1
XFILLER_103_1313 VDD VSS sg13g2_fill_2
XFILLER_16_1365 VDD VSS sg13g2_decap_8
XFILLER_127_904 VDD VSS sg13g2_decap_8
XFILLER_138_241 VDD VSS sg13g2_decap_8
XFILLER_12_1218 VDD VSS sg13g2_decap_8
XFILLER_139_786 VDD VSS sg13g2_decap_8
XFILLER_5_700 VDD VSS sg13g2_decap_8
X_15141_ _15141_/Q clkload59/A _15141_/D _15141_/RESET_B VDD VSS sg13g2_dfrbpq_1
X_12353_ _12353_/X _12345_/X _12350_/X _12344_/X _12349_/X _12706_/S _12398_/S0 VDD
+ VSS sg13g2_mux4_1
XFILLER_153_222 VDD VSS sg13g2_decap_8
XFILLER_4_210 VDD VSS sg13g2_decap_8
X_11304_ _11304_/Y _11310_/A1 _14621_/Q VDD VSS sg13g2_nand2b_1
X_15072_ _15072_/Q _15159_/CLK _15072_/D _15072_/RESET_B VDD VSS sg13g2_dfrbpq_1
X_12284_ _12284_/X _14713_/Q _14745_/Q _13785_/Q _13817_/Q _12286_/S0 _12286_/S1 VDD
+ VSS sg13g2_mux4_1
XFILLER_5_777 VDD VSS sg13g2_decap_8
X_13872__2307 _13872_/RESET_B VDD VSS sg13g2_tiehi
X_14023_ _14023_/Q _14607_/CLK _14023_/D _14023_/RESET_B VDD VSS sg13g2_dfrbpq_1
X_11235_ _11235_/X _11232_/Y _11233_/Y _15217_/Q VDD VSS sg13g2_a21o_1
XFILLER_20_70 VDD VSS sg13g2_decap_8
XFILLER_153_299 VDD VSS sg13g2_decap_8
XFILLER_4_287 VDD VSS sg13g2_decap_8
XFILLER_171_1002 VDD VSS sg13g2_decap_8
XFILLER_106_182 VDD VSS sg13g2_decap_8
XFILLER_84_1065 VDD VSS sg13g2_decap_8
XFILLER_136_70 VDD VSS sg13g2_decap_8
XFILLER_150_951 VDD VSS sg13g2_decap_4
XFILLER_150_962 VDD VSS sg13g2_decap_8
XFILLER_45_1027 VDD VSS sg13g2_decap_8
X_11166_ _11166_/Y _11162_/Y _11165_/X _10956_/C VDD VSS sg13g2_o21ai_1
XFILLER_122_675 VDD VSS sg13g2_decap_8
XFILLER_110_826 VDD VSS sg13g2_decap_8
XFILLER_67_217 VDD VSS sg13g2_fill_2
XFILLER_110_837 VDD VSS sg13g2_fill_2
X_10117_ _14695_/D _10150_/A1 _14695_/Q _10135_/S VDD VSS sg13g2_mux2_1
XFILLER_1_994 VDD VSS sg13g2_decap_8
XFILLER_49_932 VDD VSS sg13g2_fill_2
X_11097_ _11097_/Y _11097_/A _11115_/A _11097_/C VDD VSS sg13g2_nor3_1
XFILLER_23_1314 VDD VSS sg13g2_decap_8
XFILLER_62_1374 VDD VSS sg13g2_decap_4
X_14957__2630 _14957_/RESET_B VDD VSS sg13g2_tiehi
XFILLER_48_442 VDD VSS sg13g2_decap_4
X_14925_ _14925_/Q clkload42/A _14925_/D _14925_/RESET_B VDD VSS sg13g2_dfrbpq_1
X_10048_ _14629_/D _10048_/A0 _14629_/Q _10060_/S VDD VSS sg13g2_mux2_1
XFILLER_63_401 VDD VSS sg13g2_decap_4
XFILLER_64_935 VDD VSS sg13g2_decap_8
XFILLER_152_91 VDD VSS sg13g2_decap_8
X_14856_ _14856_/Q clkload49/A _14856_/D _14856_/RESET_B VDD VSS sg13g2_dfrbpq_1
XFILLER_64_968 VDD VSS sg13g2_decap_8
XFILLER_17_840 VDD VSS sg13g2_decap_8
XFILLER_21_1071 VDD VSS sg13g2_decap_8
XFILLER_90_242 VDD VSS sg13g2_fill_1
X_13807_ _13807_/Q _14735_/CLK _13807_/D _13807_/RESET_B VDD VSS sg13g2_dfrbpq_1
XFILLER_91_776 VDD VSS sg13g2_fill_1
XFILLER_16_350 VDD VSS sg13g2_decap_8
X_14787_ _14787_/Q _14894_/CLK _14787_/D _14787_/RESET_B VDD VSS sg13g2_dfrbpq_1
XFILLER_1_1176 VDD VSS sg13g2_decap_8
X_11999_ _12000_/B _11997_/X _11996_/X _11991_/X _11990_/X _11743_/C _11999_/S1 VDD
+ VSS sg13g2_mux4_1
XFILLER_32_810 VDD VSS sg13g2_fill_2
XFILLER_91_1025 VDD VSS sg13g2_decap_8
XFILLER_90_297 VDD VSS sg13g2_decap_8
X_13738_ _13738_/Q _14310_/CLK _13738_/D _13738_/RESET_B VDD VSS sg13g2_dfrbpq_1
XFILLER_56_1156 VDD VSS sg13g2_decap_4
XFILLER_108_1246 VDD VSS sg13g2_decap_8
XFILLER_32_865 VDD VSS sg13g2_decap_8
XFILLER_31_342 VDD VSS sg13g2_decap_8
X_15232__3000 _15232_/RESET_B VDD VSS sg13g2_tiehi
X_13669_ _13669_/Q clkload63/A _13669_/D _13669_/RESET_B VDD VSS sg13g2_dfrbpq_1
XFILLER_31_386 VDD VSS sg13g2_decap_8
XFILLER_145_712 VDD VSS sg13g2_fill_2
XFILLER_8_560 VDD VSS sg13g2_decap_8
XFILLER_145_734 VDD VSS sg13g2_decap_8
Xclkbuf_leaf_94_clk_i _14885_/CLK clkbuf_leaf_97_clk_i/A VDD VSS sg13g2_buf_8
XFILLER_117_458 VDD VSS sg13g2_decap_8
XFILLER_126_970 VDD VSS sg13g2_decap_8
XFILLER_99_810 VDD VSS sg13g2_decap_8
X_09900_ _14486_/D _09900_/A0 _14486_/Q _09903_/S VDD VSS sg13g2_mux2_1
X_14462__1717 _14462_/RESET_B VDD VSS sg13g2_tiehi
XFILLER_28_1203 VDD VSS sg13g2_decap_8
XFILLER_119_1331 VDD VSS sg13g2_decap_8
X_13848__2331 _13848_/RESET_B VDD VSS sg13g2_tiehi
Xfanout506 _13535_/B _13524_/A1 VDD VSS sg13g2_buf_1
XFILLER_67_1285 VDD VSS sg13g2_decap_8
Xfanout517 _12763_/A2 _12777_/A2 VDD VSS sg13g2_buf_1
X_09831_ _14419_/D _09930_/A1 _14419_/Q _09831_/S VDD VSS sg13g2_mux2_1
XFILLER_98_353 VDD VSS sg13g2_decap_4
Xfanout528 _10139_/A1 _09907_/A1 VDD VSS sg13g2_buf_1
Xfanout539 _09024_/A _09051_/A1 VDD VSS sg13g2_buf_1
XFILLER_59_729 VDD VSS sg13g2_fill_2
XFILLER_100_314 VDD VSS sg13g2_decap_8
Xclkbuf_5_12__f_clk_i clkbuf_leaf_22_clk_i/A clkbuf_4_6_0_clk_i/X VDD VSS sg13g2_buf_16
XFILLER_112_174 VDD VSS sg13g2_decap_8
XFILLER_58_228 VDD VSS sg13g2_fill_1
X_09762_ _14352_/D _14352_/Q _09828_/A0 _09763_/S VDD VSS sg13g2_mux2_1
XFILLER_6_1043 VDD VSS sg13g2_decap_8
XFILLER_39_431 VDD VSS sg13g2_decap_8
XFILLER_39_442 VDD VSS sg13g2_fill_1
X_08713_ _15189_/D hold3073/X _15189_/Q _10203_/S VDD VSS sg13g2_mux2_1
XFILLER_132_28 VDD VSS sg13g2_decap_4
X_09693_ _14285_/D _09924_/A1 _14285_/Q _09697_/S VDD VSS sg13g2_mux2_1
XFILLER_67_773 VDD VSS sg13g2_decap_8
XFILLER_27_604 VDD VSS sg13g2_decap_8
Xclkbuf_leaf_32_clk_i _14745_/CLK clkbuf_leaf_36_clk_i/A VDD VSS sg13g2_buf_8
XFILLER_82_710 VDD VSS sg13g2_decap_8
XFILLER_54_401 VDD VSS sg13g2_fill_2
X_08644_ _08646_/C _15016_/Q _08012_/B _07855_/B VDD VSS sg13g2_o21ai_1
XFILLER_66_283 VDD VSS sg13g2_decap_8
XFILLER_27_648 VDD VSS sg13g2_decap_8
XFILLER_148_1015 VDD VSS sg13g2_fill_2
XFILLER_81_231 VDD VSS sg13g2_decap_8
XFILLER_55_979 VDD VSS sg13g2_fill_1
XFILLER_148_1026 VDD VSS sg13g2_decap_8
XFILLER_54_456 VDD VSS sg13g2_decap_8
XFILLER_26_147 VDD VSS sg13g2_decap_8
XFILLER_82_776 VDD VSS sg13g2_fill_2
X_08575_ _08575_/Y _08575_/A _08575_/B _08575_/C VDD VSS sg13g2_nor3_1
XFILLER_35_670 VDD VSS sg13g2_decap_4
XFILLER_63_990 VDD VSS sg13g2_fill_1
XFILLER_39_1365 VDD VSS sg13g2_decap_8
Xclkbuf_leaf_47_clk_i clkload28/A clkbuf_leaf_47_clk_i/A VDD VSS sg13g2_buf_8
XFILLER_126_1335 VDD VSS sg13g2_decap_8
X_13950__2229 _13950_/RESET_B VDD VSS sg13g2_tiehi
XFILLER_70_1109 VDD VSS sg13g2_decap_8
XFILLER_10_504 VDD VSS sg13g2_decap_8
XFILLER_22_364 VDD VSS sg13g2_decap_8
XFILLER_167_336 VDD VSS sg13g2_decap_8
XFILLER_126_1379 VDD VSS sg13g2_fill_1
XFILLER_41_14 VDD VSS sg13g2_decap_8
XFILLER_157_14 VDD VSS sg13g2_decap_8
XFILLER_109_937 VDD VSS sg13g2_fill_1
X_09127_ _13780_/D _13780_/Q _09898_/A0 _09167_/S VDD VSS sg13g2_mux2_1
XFILLER_124_1092 VDD VSS sg13g2_decap_4
XFILLER_135_211 VDD VSS sg13g2_fill_1
XFILLER_163_553 VDD VSS sg13g2_decap_8
X_15206__2974 _15206_/RESET_B VDD VSS sg13g2_tiehi
X_09058_ _09058_/Y _09024_/A _10725_/B _09057_/X VDD VSS sg13g2_o21ai_1
XFILLER_136_789 VDD VSS sg13g2_fill_1
XFILLER_151_715 VDD VSS sg13g2_decap_8
XFILLER_2_714 VDD VSS sg13g2_decap_8
X_08009_ _08009_/X _08673_/B _08692_/B _08009_/S VDD VSS sg13g2_mux2_1
XFILLER_11_1295 VDD VSS sg13g2_decap_8
XFILLER_1_224 VDD VSS sg13g2_decap_8
XFILLER_46_1325 VDD VSS sg13g2_fill_1
XFILLER_173_35 VDD VSS sg13g2_decap_8
XFILLER_172_1322 VDD VSS sg13g2_decap_8
X_14438__1741 _14438_/RESET_B VDD VSS sg13g2_tiehi
X_11020_ _14942_/D _11019_/Y _11018_/Y _11001_/Y VDD VSS sg13g2_o21ai_1
XFILLER_81_1216 VDD VSS sg13g2_decap_8
XFILLER_81_1227 VDD VSS sg13g2_fill_1
XFILLER_133_1306 VDD VSS sg13g2_fill_2
XFILLER_132_995 VDD VSS sg13g2_decap_4
XFILLER_172_1377 VDD VSS sg13g2_fill_2
XFILLER_106_73 VDD VSS sg13g2_decap_8
XFILLER_46_902 VDD VSS sg13g2_fill_2
X_12971_ _15031_/D _12962_/Y _12970_/Y _13266_/A VDD VSS sg13g2_a21oi_1
XFILLER_79_1112 VDD VSS sg13g2_decap_8
XFILLER_73_710 VDD VSS sg13g2_decap_8
X_14710_ _14710_/Q clkload27/A _14710_/D _14710_/RESET_B VDD VSS sg13g2_dfrbpq_1
XFILLER_18_637 VDD VSS sg13g2_decap_8
X_11922_ _11922_/X _14255_/Q _14287_/Q _14319_/Q _14351_/Q _11925_/S0 _11925_/S1 VDD
+ VSS sg13g2_mux4_1
XFILLER_85_592 VDD VSS sg13g2_decap_8
XFILLER_72_231 VDD VSS sg13g2_decap_8
XFILLER_17_147 VDD VSS sg13g2_decap_8
XFILLER_167_0 VDD VSS sg13g2_decap_8
X_14641_ _14641_/Q _14737_/CLK _14641_/D _14641_/RESET_B VDD VSS sg13g2_dfrbpq_1
XFILLER_82_21 VDD VSS sg13g2_decap_8
XFILLER_72_253 VDD VSS sg13g2_decap_8
X_11853_ _11853_/X _14381_/Q _14413_/Q _14477_/Q _14509_/Q _11854_/S0 _07654_/A VDD
+ VSS sg13g2_mux4_1
XFILLER_73_787 VDD VSS sg13g2_decap_8
XFILLER_60_404 VDD VSS sg13g2_decap_8
XFILLER_26_681 VDD VSS sg13g2_decap_8
X_10804_ _10804_/Y _10805_/B _10805_/C _15121_/Q VDD VSS sg13g2_o21ai_1
X_14572_ _14572_/Q clkload13/A _14572_/D _14572_/RESET_B VDD VSS sg13g2_dfrbpq_1
X_11784_ _11784_/X _13739_/Q _14091_/Q _14443_/Q _14539_/Q _11848_/S0 _11851_/S1 VDD
+ VSS sg13g2_mux4_1
XFILLER_14_854 VDD VSS sg13g2_decap_8
XFILLER_53_1307 VDD VSS sg13g2_decap_4
XFILLER_15_70 VDD VSS sg13g2_decap_8
X_13523_ _13523_/Y _13523_/A _13535_/B VDD VSS sg13g2_nor2_1
XFILLER_92_1378 VDD VSS sg13g2_fill_2
XFILLER_13_364 VDD VSS sg13g2_decap_8
X_14540__1639 _14540_/RESET_B VDD VSS sg13g2_tiehi
X_10735_ _10735_/Y _10735_/A _10735_/B VDD VSS sg13g2_nor2_1
X_13926__2253 _13926_/RESET_B VDD VSS sg13g2_tiehi
XFILLER_158_347 VDD VSS sg13g2_decap_8
X_14686__1493 _14686_/RESET_B VDD VSS sg13g2_tiehi
X_13454_ _13455_/D _15169_/Q _15170_/Q _13454_/C _13454_/D VDD VSS sg13g2_nand4_1
X_10666_ _10667_/C _14894_/Q _14893_/Q _14892_/Q _10666_/D VDD VSS sg13g2_and4_1
XFILLER_9_357 VDD VSS sg13g2_decap_8
XFILLER_16_1162 VDD VSS sg13g2_decap_8
XFILLER_12_1015 VDD VSS sg13g2_decap_8
X_14794__2919 _14794_/RESET_B VDD VSS sg13g2_tiehi
X_12405_ _12405_/X _13951_/Q _13983_/Q _14015_/Q _14047_/Q _12606_/S0 _12606_/S1 VDD
+ VSS sg13g2_mux4_1
XFILLER_127_734 VDD VSS sg13g2_decap_8
XFILLER_142_1192 VDD VSS sg13g2_decap_8
X_13385_ _15081_/D _13435_/A _13378_/C _13384_/Y VDD VSS sg13g2_o21ai_1
XFILLER_103_1154 VDD VSS sg13g2_decap_8
XFILLER_126_222 VDD VSS sg13g2_fill_2
XFILLER_127_745 VDD VSS sg13g2_fill_1
X_10597_ _10610_/D _14876_/Q _14875_/Q _14874_/Q _10597_/D VDD VSS sg13g2_and4_1
X_14830__2883 _14830_/RESET_B VDD VSS sg13g2_tiehi
X_15124_ _15124_/Q clkload65/A _15124_/D _15124_/RESET_B VDD VSS sg13g2_dfrbpq_1
Xoutput109 mem_axi_wdata[14] _15146_/Q VDD VSS sg13g2_buf_1
X_12336_ _12336_/Y _12331_/X _11957_/A _12334_/C VDD VSS sg13g2_a21oi_1
XFILLER_31_91 VDD VSS sg13g2_decap_8
XFILLER_86_1138 VDD VSS sg13g2_decap_8
XFILLER_56_7 VDD VSS sg13g2_decap_8
XFILLER_108_970 VDD VSS sg13g2_fill_2
XFILLER_5_574 VDD VSS sg13g2_decap_8
X_15055_ _15055_/Q clkload71/A _15055_/D _15055_/RESET_B VDD VSS sg13g2_dfrbpq_1
X_12267_ _12267_/Y _14923_/Q _12267_/A2 _12263_/Y _12266_/Y VDD VSS sg13g2_a22oi_1
X_14006_ _14006_/Q _14660_/CLK _14006_/D _14006_/RESET_B VDD VSS sg13g2_dfrbpq_1
X_11218_ _11218_/X _14619_/Q _14651_/Q _11277_/S VDD VSS sg13g2_mux2_1
X_12198_ _12200_/B _12198_/A _12198_/B _12198_/C _12198_/D VDD VSS sg13g2_nor4_1
XFILLER_68_504 VDD VSS sg13g2_fill_1
Xoutput80 mem_axi_awaddr[19] _16872_/X VDD VSS sg13g2_buf_1
XFILLER_150_781 VDD VSS sg13g2_decap_8
Xoutput91 mem_axi_awaddr[2] _16855_/X VDD VSS sg13g2_buf_1
XFILLER_96_835 VDD VSS sg13g2_decap_8
X_11149_ _11151_/B _11150_/B _11150_/A VDD VSS sg13g2_nor2_1
XFILLER_7_1330 VDD VSS sg13g2_decap_8
XFILLER_1_791 VDD VSS sg13g2_decap_8
XFILLER_95_345 VDD VSS sg13g2_decap_8
XFILLER_62_1160 VDD VSS sg13g2_decap_4
XFILLER_23_1111 VDD VSS sg13g2_decap_8
XFILLER_114_1261 VDD VSS sg13g2_fill_1
XFILLER_49_773 VDD VSS sg13g2_decap_8
XFILLER_83_529 VDD VSS sg13g2_fill_1
X_14908_ _14908_/Q clkload53/A _14908_/D _14908_/RESET_B VDD VSS sg13g2_dfrbpq_1
XFILLER_37_957 VDD VSS sg13g2_decap_8
XFILLER_23_1188 VDD VSS sg13g2_decap_8
XFILLER_97_1256 VDD VSS sg13g2_decap_8
XFILLER_64_754 VDD VSS sg13g2_decap_4
XFILLER_149_1324 VDD VSS sg13g2_decap_4
XFILLER_36_456 VDD VSS sg13g2_decap_4
XFILLER_93_1109 VDD VSS sg13g2_decap_8
XFILLER_63_253 VDD VSS sg13g2_decap_4
X_14839_ _14839_/Q _14874_/CLK _14839_/D _14839_/RESET_B VDD VSS sg13g2_dfrbpq_1
XFILLER_149_1368 VDD VSS sg13g2_fill_2
X_08360_ _08360_/Y _08200_/A _08198_/X _08397_/A VDD VSS sg13g2_o21ai_1
XFILLER_60_971 VDD VSS sg13g2_fill_2
X_08291_ _08291_/Y _08290_/X _08318_/D _08039_/A VDD VSS sg13g2_a21oi_1
XFILLER_32_673 VDD VSS sg13g2_decap_8
XFILLER_31_161 VDD VSS sg13g2_decap_8
X_14516__1663 _14516_/RESET_B VDD VSS sg13g2_tiehi
XFILLER_82_0 VDD VSS sg13g2_decap_8
XFILLER_20_868 VDD VSS sg13g2_decap_8
XFILLER_34_1262 VDD VSS sg13g2_fill_1
XFILLER_158_881 VDD VSS sg13g2_decap_4
XFILLER_34_1284 VDD VSS sg13g2_decap_8
XFILLER_118_745 VDD VSS sg13g2_decap_4
XFILLER_11_28 VDD VSS sg13g2_decap_8
XFILLER_127_28 VDD VSS sg13g2_decap_8
XFILLER_172_350 VDD VSS sg13g2_decap_8
XFILLER_117_266 VDD VSS sg13g2_decap_8
XFILLER_172_361 VDD VSS sg13g2_decap_8
XFILLER_133_726 VDD VSS sg13g2_decap_8
XFILLER_69_1369 VDD VSS sg13g2_decap_8
Xpicorv32_macro_1419 mem_axi_awaddr[1] VDD VSS sg13g2_tielo
XFILLER_67_1060 VDD VSS sg13g2_fill_1
XFILLER_160_567 VDD VSS sg13g2_decap_8
XFILLER_28_1022 VDD VSS sg13g2_fill_1
XFILLER_120_409 VDD VSS sg13g2_decap_8
XFILLER_160_578 VDD VSS sg13g2_fill_2
Xfanout303 _11040_/A _10736_/Y VDD VSS sg13g2_buf_1
XFILLER_28_1033 VDD VSS sg13g2_decap_8
Xfanout314 _10102_/S _10070_/Y VDD VSS sg13g2_buf_1
Xfanout325 _09937_/S _09905_/X VDD VSS sg13g2_buf_1
XFILLER_101_612 VDD VSS sg13g2_decap_8
XFILLER_98_161 VDD VSS sg13g2_decap_8
XFILLER_8_1127 VDD VSS sg13g2_decap_8
Xfanout336 _09768_/S _09769_/S VDD VSS sg13g2_buf_1
XFILLER_100_100 VDD VSS sg13g2_decap_8
Xfanout347 _09629_/S _09638_/S VDD VSS sg13g2_buf_1
X_09814_ _14402_/D _09913_/A1 _14402_/Q _09831_/S VDD VSS sg13g2_mux2_1
XFILLER_87_846 VDD VSS sg13g2_decap_4
XFILLER_28_1077 VDD VSS sg13g2_decap_8
Xfanout358 _09506_/S _09474_/X VDD VSS sg13g2_buf_1
XFILLER_115_1047 VDD VSS sg13g2_fill_2
XFILLER_154_1096 VDD VSS sg13g2_fill_2
Xfanout369 _09272_/S _09260_/S VDD VSS sg13g2_buf_1
XFILLER_101_667 VDD VSS sg13g2_decap_8
X_09745_ _14335_/D _14335_/Q _09877_/A0 _09763_/S VDD VSS sg13g2_mux2_1
XFILLER_41_1233 VDD VSS sg13g2_decap_8
XFILLER_28_924 VDD VSS sg13g2_fill_1
XFILLER_95_890 VDD VSS sg13g2_decap_8
XFILLER_36_14 VDD VSS sg13g2_decap_8
X_09676_ _14268_/D _10139_/A1 _14268_/Q _09700_/S VDD VSS sg13g2_mux2_1
X_13690__2492 _13690_/RESET_B VDD VSS sg13g2_tiehi
XFILLER_27_456 VDD VSS sg13g2_decap_8
X_08627_ _08627_/Y _15015_/Q _07853_/B _08663_/B VDD VSS sg13g2_a21oi_1
XFILLER_76_1329 VDD VSS sg13g2_decap_4
XFILLER_160_7 VDD VSS sg13g2_decap_8
XFILLER_54_297 VDD VSS sg13g2_decap_8
X_08558_ _08581_/C _08600_/A _08243_/Y _08557_/Y VDD VSS sg13g2_o21ai_1
XFILLER_42_459 VDD VSS sg13g2_decap_8
XFILLER_126_1110 VDD VSS sg13g2_decap_8
XFILLER_74_1042 VDD VSS sg13g2_decap_8
XFILLER_161_1012 VDD VSS sg13g2_fill_2
X_14941__2662 _14941_/RESET_B VDD VSS sg13g2_tiehi
XFILLER_52_35 VDD VSS sg13g2_decap_8
X_08489_ _08489_/Y _08599_/B _08406_/A _08560_/A VDD VSS sg13g2_a21oi_1
XFILLER_10_301 VDD VSS sg13g2_decap_8
XFILLER_50_470 VDD VSS sg13g2_decap_8
XFILLER_35_1037 VDD VSS sg13g2_decap_4
XFILLER_22_161 VDD VSS sg13g2_decap_8
XFILLER_161_1045 VDD VSS sg13g2_decap_8
XFILLER_167_133 VDD VSS sg13g2_decap_8
XFILLER_168_35 VDD VSS sg13g2_decap_8
XFILLER_156_807 VDD VSS sg13g2_fill_1
X_10520_ _10522_/B _14855_/Q _10579_/B _14856_/Q VDD VSS sg13g2_a21oi_1
XFILLER_128_509 VDD VSS sg13g2_decap_8
XFILLER_161_1067 VDD VSS sg13g2_fill_2
XFILLER_13_1302 VDD VSS sg13g2_decap_8
XFILLER_11_868 VDD VSS sg13g2_decap_8
XFILLER_109_712 VDD VSS sg13g2_fill_2
XFILLER_109_734 VDD VSS sg13g2_decap_8
X_10451_ _10462_/D _14840_/Q _14839_/Q _10453_/C _10514_/A VDD VSS sg13g2_and4_1
XFILLER_10_378 VDD VSS sg13g2_decap_8
XFILLER_109_745 VDD VSS sg13g2_fill_2
XFILLER_109_756 VDD VSS sg13g2_decap_8
XFILLER_13_1379 VDD VSS sg13g2_decap_4
X_13170_ _13172_/D _13170_/A _13170_/B _13170_/C _13170_/D VDD VSS sg13g2_nor4_1
XFILLER_100_1338 VDD VSS sg13g2_decap_8
XFILLER_163_350 VDD VSS sg13g2_decap_8
X_10382_ _14818_/D _10378_/D _10380_/X _10381_/Y VDD VSS sg13g2_a21oi_1
X_12121_ _12121_/Y _12119_/Y _12120_/Y _11235_/X VDD VSS sg13g2_a21oi_1
XFILLER_151_523 VDD VSS sg13g2_decap_8
XFILLER_2_511 VDD VSS sg13g2_decap_8
XFILLER_11_1092 VDD VSS sg13g2_decap_8
XFILLER_85_1160 VDD VSS sg13g2_decap_8
XFILLER_123_258 VDD VSS sg13g2_decap_8
XFILLER_151_567 VDD VSS sg13g2_fill_2
X_12052_ _12053_/B _12011_/X _12013_/Y _12051_/Y VDD VSS sg13g2_a21oi_1
XFILLER_78_802 VDD VSS sg13g2_decap_8
XFILLER_96_109 VDD VSS sg13g2_fill_2
XFILLER_77_21 VDD VSS sg13g2_decap_8
XFILLER_78_824 VDD VSS sg13g2_fill_1
XFILLER_2_588 VDD VSS sg13g2_decap_8
X_11003_ _11064_/A _15117_/Q _11042_/D VDD VSS sg13g2_xor2_1
XFILLER_137_1283 VDD VSS sg13g2_decap_8
X_16860_ _16860_/X _16860_/A VDD VSS sg13g2_buf_1
XFILLER_46_1177 VDD VSS sg13g2_decap_8
XFILLER_89_194 VDD VSS sg13g2_fill_1
XFILLER_77_345 VDD VSS sg13g2_decap_8
Xfanout870 _12617_/S0 _12352_/S0 VDD VSS sg13g2_buf_1
XFILLER_93_805 VDD VSS sg13g2_decap_8
XFILLER_120_987 VDD VSS sg13g2_decap_8
Xfanout881 _12717_/S0 fanout894/X VDD VSS sg13g2_buf_1
Xfanout892 _12742_/S0 _12437_/S0 VDD VSS sg13g2_buf_1
XFILLER_93_838 VDD VSS sg13g2_decap_8
XFILLER_19_924 VDD VSS sg13g2_decap_8
XFILLER_46_721 VDD VSS sg13g2_fill_1
XFILLER_58_592 VDD VSS sg13g2_fill_1
XFILLER_133_93 VDD VSS sg13g2_decap_8
X_12954_ _12954_/Y _12953_/Y _13048_/B _12950_/Y VDD VSS sg13g2_a21oi_1
XFILLER_18_434 VDD VSS sg13g2_decap_8
X_11905_ _11905_/Y _11904_/X _12296_/A1 _12126_/A VDD VSS sg13g2_a21oi_1
XFILLER_61_713 VDD VSS sg13g2_decap_4
XFILLER_2_1260 VDD VSS sg13g2_decap_8
X_12885_ _12885_/Y input31/X _12841_/B _12803_/X input8/X _12883_/X VDD VSS sg13g2_a221oi_1
XFILLER_93_97 VDD VSS sg13g2_fill_2
XFILLER_33_426 VDD VSS sg13g2_decap_8
X_14624_ _14624_/Q clkload29/A _14624_/D _14624_/RESET_B VDD VSS sg13g2_dfrbpq_1
X_11836_ _11836_/Y _14911_/Q _11792_/B _11832_/Y _11835_/Y VDD VSS sg13g2_a22oi_1
XFILLER_60_234 VDD VSS sg13g2_fill_2
XFILLER_61_768 VDD VSS sg13g2_decap_4
XFILLER_26_91 VDD VSS sg13g2_decap_8
XFILLER_14_651 VDD VSS sg13g2_decap_8
XFILLER_42_971 VDD VSS sg13g2_decap_8
X_14555_ _14555_/Q clkload40/A _14555_/D _14555_/RESET_B VDD VSS sg13g2_dfrbpq_1
XFILLER_18_1246 VDD VSS sg13g2_decap_8
XFILLER_109_1363 VDD VSS sg13g2_fill_2
XFILLER_159_645 VDD VSS sg13g2_fill_1
X_11767_ _11767_/X _14909_/Q _11433_/B _11766_/Y VDD VSS sg13g2_a21o_1
XFILLER_13_161 VDD VSS sg13g2_decap_8
XFILLER_158_133 VDD VSS sg13g2_decap_8
X_13506_ _13507_/C _13506_/A _07721_/B VDD VSS sg13g2_nor2b_1
XFILLER_144_1287 VDD VSS sg13g2_decap_8
X_10718_ _10718_/Y _14907_/Q _10941_/B VDD VSS sg13g2_nand2_1
X_14486_ _14486_/Q clkload26/A _14486_/D _14486_/RESET_B VDD VSS sg13g2_dfrbpq_1
X_11698_ _11698_/Y _11698_/A _11625_/C VDD VSS sg13g2_nor2b_1
XFILLER_9_154 VDD VSS sg13g2_decap_8
X_13437_ _13437_/Y _13440_/A _13440_/B _15101_/Q VDD VSS sg13g2_nand3_1
XFILLER_174_648 VDD VSS sg13g2_decap_8
X_10649_ _10652_/B _14874_/Q _10649_/B _14872_/Q _14871_/Q VDD VSS sg13g2_nand4_1
XFILLER_174_659 VDD VSS sg13g2_decap_8
XFILLER_173_147 VDD VSS sg13g2_decap_8
XFILLER_173_158 VDD VSS sg13g2_fill_2
XFILLER_6_861 VDD VSS sg13g2_decap_8
XFILLER_170_810 VDD VSS sg13g2_decap_8
X_13368_ _15075_/D _13361_/C _13367_/Y _13366_/Y VDD VSS sg13g2_o21ai_1
XFILLER_154_383 VDD VSS sg13g2_fill_2
X_15107_ _15107_/Q clkload63/A _15107_/D _15107_/RESET_B VDD VSS sg13g2_dfrbpq_1
XFILLER_5_371 VDD VSS sg13g2_decap_8
X_12319_ _12319_/Y _12321_/A1 _14426_/Q _12319_/B1 VDD VSS sg13g2_a21oi_1
X_14758__2958 _14758_/RESET_B VDD VSS sg13g2_tiehi
X_13299_ _13299_/Y _07988_/D _13298_/X _13297_/X VDD VSS sg13g2_a21oi_1
XFILLER_138_1058 VDD VSS sg13g2_decap_8
XFILLER_29_1331 VDD VSS sg13g2_decap_8
XFILLER_130_707 VDD VSS sg13g2_decap_8
X_15038_ _15038_/Q _15064_/CLK _15038_/D _15038_/RESET_B VDD VSS sg13g2_dfrbpq_1
XFILLER_64_1233 VDD VSS sg13g2_fill_1
XFILLER_69_824 VDD VSS sg13g2_fill_2
XFILLER_111_932 VDD VSS sg13g2_fill_1
XFILLER_116_1334 VDD VSS sg13g2_decap_8
X_07860_ _08608_/A _15013_/Q _07861_/B VDD VSS sg13g2_nor2_1
XFILLER_96_632 VDD VSS sg13g2_decap_8
XFILLER_96_654 VDD VSS sg13g2_fill_1
XFILLER_25_1239 VDD VSS sg13g2_decap_8
XFILLER_151_1247 VDD VSS sg13g2_decap_4
XFILLER_111_976 VDD VSS sg13g2_decap_8
XFILLER_99_1318 VDD VSS sg13g2_decap_4
XFILLER_84_816 VDD VSS sg13g2_decap_8
XFILLER_68_367 VDD VSS sg13g2_decap_8
XFILLER_3_84 VDD VSS sg13g2_decap_8
XFILLER_111_987 VDD VSS sg13g2_fill_2
X_07791_ _08415_/A _08391_/B _08412_/A VDD VSS sg13g2_nor2b_1
X_09530_ _14129_/D _09629_/A0 _14129_/Q _09530_/S VDD VSS sg13g2_mux2_1
XFILLER_37_743 VDD VSS sg13g2_decap_8
XFILLER_97_1031 VDD VSS sg13g2_decap_8
XFILLER_3_1057 VDD VSS sg13g2_decap_8
XFILLER_149_1121 VDD VSS sg13g2_decap_8
X_09461_ _14062_/D _09760_/A1 _14062_/Q _09467_/S VDD VSS sg13g2_mux2_1
XFILLER_92_871 VDD VSS sg13g2_decap_4
XFILLER_24_404 VDD VSS sg13g2_decap_8
X_13798__2381 _13798_/RESET_B VDD VSS sg13g2_tiehi
X_15205__2973 _15205_/RESET_B VDD VSS sg13g2_tiehi
XFILLER_92_893 VDD VSS sg13g2_decap_4
XFILLER_149_1154 VDD VSS sg13g2_decap_8
XFILLER_149_1165 VDD VSS sg13g2_fill_1
XFILLER_58_1048 VDD VSS sg13g2_fill_1
X_08412_ _08412_/Y _08412_/A _08412_/B VDD VSS sg13g2_nor2_1
X_09392_ _13995_/D _09623_/A0 _13995_/Q _09398_/S VDD VSS sg13g2_mux2_1
X_08343_ _08346_/C _08541_/A _07784_/B _08674_/A2 _07796_/A VDD VSS sg13g2_a22oi_1
XFILLER_123_1305 VDD VSS sg13g2_fill_1
X_13667__2538 _13667_/RESET_B VDD VSS sg13g2_tiehi
XFILLER_32_492 VDD VSS sg13g2_fill_2
X_14032__2147 _14032_/RESET_B VDD VSS sg13g2_tiehi
X_08274_ _08275_/A _08276_/A _08276_/B VDD VSS sg13g2_nand2_1
XFILLER_36_1379 VDD VSS sg13g2_decap_4
XFILLER_137_317 VDD VSS sg13g2_decap_8
XFILLER_20_665 VDD VSS sg13g2_decap_8
XFILLER_22_49 VDD VSS sg13g2_decap_8
XFILLER_121_1051 VDD VSS sg13g2_fill_1
XFILLER_138_49 VDD VSS sg13g2_decap_8
XFILLER_164_147 VDD VSS sg13g2_decap_8
XFILLER_121_1062 VDD VSS sg13g2_fill_1
XFILLER_146_873 VDD VSS sg13g2_decap_8
X_14918__2708 _14918_/RESET_B VDD VSS sg13g2_tiehi
XFILLER_133_501 VDD VSS sg13g2_decap_4
XFILLER_3_308 VDD VSS sg13g2_decap_8
XFILLER_118_597 VDD VSS sg13g2_fill_1
XFILLER_173_692 VDD VSS sg13g2_fill_2
XFILLER_156_1158 VDD VSS sg13g2_fill_2
XFILLER_121_718 VDD VSS sg13g2_fill_2
XFILLER_121_729 VDD VSS sg13g2_decap_8
XFILLER_160_386 VDD VSS sg13g2_decap_8
Xfanout1109 _12009_/A _14980_/Q VDD VSS sg13g2_buf_1
XFILLER_102_932 VDD VSS sg13g2_decap_8
XFILLER_82_1355 VDD VSS sg13g2_fill_1
XFILLER_114_792 VDD VSS sg13g2_decap_8
XFILLER_113_280 VDD VSS sg13g2_decap_8
Xfanout144 _09772_/A1 _09166_/Y VDD VSS sg13g2_buf_1
XFILLER_43_1328 VDD VSS sg13g2_decap_4
XFILLER_87_654 VDD VSS sg13g2_decap_8
XFILLER_59_345 VDD VSS sg13g2_decap_8
Xfanout155 _10100_/A0 _09902_/A0 VDD VSS sg13g2_buf_1
XFILLER_75_805 VDD VSS sg13g2_fill_2
Xfanout166 _10165_/A1 _09138_/X VDD VSS sg13g2_buf_1
XFILLER_59_356 VDD VSS sg13g2_fill_2
Xfanout177 _10095_/A0 _10162_/A1 VDD VSS sg13g2_buf_1
Xfanout188 _10127_/A0 fanout191/X VDD VSS sg13g2_buf_1
XFILLER_86_164 VDD VSS sg13g2_decap_4
XFILLER_47_35 VDD VSS sg13g2_decap_8
XFILLER_170_14 VDD VSS sg13g2_decap_8
Xfanout199 _10159_/A1 _10092_/A0 VDD VSS sg13g2_buf_1
X_07989_ _07989_/Y _10172_/C _10177_/A _13283_/A VDD VSS sg13g2_nand3_1
X_09728_ _14319_/D _10125_/A0 _14319_/Q _09738_/S VDD VSS sg13g2_mux2_1
XFILLER_74_359 VDD VSS sg13g2_fill_2
XFILLER_27_231 VDD VSS sg13g2_decap_8
XFILLER_16_938 VDD VSS sg13g2_decap_8
X_14242__1937 _14242_/RESET_B VDD VSS sg13g2_tiehi
X_09659_ _14252_/D _09923_/A1 _14252_/Q _09667_/S VDD VSS sg13g2_mux2_1
X_14388__1791 _14388_/RESET_B VDD VSS sg13g2_tiehi
XFILLER_43_746 VDD VSS sg13g2_decap_8
XFILLER_15_448 VDD VSS sg13g2_decap_8
XFILLER_76_1159 VDD VSS sg13g2_decap_8
XFILLER_163_1118 VDD VSS sg13g2_fill_1
X_12670_ _12670_/X _13842_/Q _13874_/Q _13906_/Q _13938_/Q _12727_/S0 _12727_/S1 VDD
+ VSS sg13g2_mux4_1
XFILLER_42_267 VDD VSS sg13g2_decap_8
X_11621_ _11621_/X _14694_/Q _14726_/Q _13766_/Q _13798_/Q _11741_/A _11760_/C VDD
+ VSS sg13g2_mux4_1
XFILLER_168_420 VDD VSS sg13g2_decap_8
XFILLER_169_954 VDD VSS sg13g2_fill_2
X_14340_ _14340_/Q _14672_/CLK _14340_/D _14340_/RESET_B VDD VSS sg13g2_dfrbpq_1
X_11552_ _11552_/Y _11649_/S0 _13892_/Q VDD VSS sg13g2_nand2b_1
XFILLER_11_665 VDD VSS sg13g2_decap_8
XFILLER_128_317 VDD VSS sg13g2_decap_8
XFILLER_156_626 VDD VSS sg13g2_decap_8
X_14008__2171 _14008_/RESET_B VDD VSS sg13g2_tiehi
Xwire523 wire523/X wire523/A VDD VSS sg13g2_buf_4
XFILLER_168_497 VDD VSS sg13g2_decap_8
X_10503_ _10507_/D _14854_/Q _14853_/Q VDD VSS sg13g2_and2_1
X_14271_ _14271_/Q clkload14/A _14271_/D _14271_/RESET_B VDD VSS sg13g2_dfrbpq_1
X_11483_ _11485_/A _11483_/A _13686_/Q VDD VSS sg13g2_xnor2_1
XFILLER_52_1181 VDD VSS sg13g2_decap_8
XFILLER_10_175 VDD VSS sg13g2_decap_8
XFILLER_155_147 VDD VSS sg13g2_decap_4
XFILLER_7_658 VDD VSS sg13g2_decap_8
XFILLER_52_1192 VDD VSS sg13g2_fill_2
XFILLER_109_553 VDD VSS sg13g2_decap_8
XFILLER_171_607 VDD VSS sg13g2_decap_8
X_13222_ _13222_/Y _13253_/B2 _13217_/X _13221_/Y VDD VSS sg13g2_a21oi_1
X_10434_ _10443_/D _14834_/Q _14833_/Q _10434_/C VDD VSS sg13g2_and3_1
XFILLER_13_1176 VDD VSS sg13g2_decap_8
XFILLER_152_810 VDD VSS sg13g2_decap_8
XFILLER_164_670 VDD VSS sg13g2_fill_2
XFILLER_6_168 VDD VSS sg13g2_decap_8
XFILLER_87_1266 VDD VSS sg13g2_decap_8
XFILLER_48_1217 VDD VSS sg13g2_decap_8
XFILLER_100_1168 VDD VSS sg13g2_decap_4
X_13153_ _13153_/Y _13150_/Y _13151_/Y _13152_/Y VDD VSS sg13g2_a21oi_1
X_10365_ _14813_/D _10365_/A _10365_/B _10392_/B VDD VSS sg13g2_and3_1
XFILLER_48_1228 VDD VSS sg13g2_fill_1
XFILLER_174_1225 VDD VSS sg13g2_decap_4
XFILLER_128_93 VDD VSS sg13g2_decap_8
XFILLER_83_1119 VDD VSS sg13g2_fill_2
XFILLER_152_876 VDD VSS sg13g2_decap_8
XFILLER_139_1378 VDD VSS sg13g2_fill_2
X_13730__2449 _13730_/RESET_B VDD VSS sg13g2_tiehi
X_12104_ _12104_/Y _12252_/S0 _14484_/Q VDD VSS sg13g2_nand2b_1
X_13084_ _13085_/C _14848_/Q _13150_/B VDD VSS sg13g2_nand2_1
X_14490__1689 _14490_/RESET_B VDD VSS sg13g2_tiehi
XFILLER_3_875 VDD VSS sg13g2_decap_8
XFILLER_111_206 VDD VSS sg13g2_decap_8
X_10296_ _10297_/C _14788_/Q _14789_/Q _14791_/Q _14792_/Q VDD VSS sg13g2_nand4_1
XFILLER_97_429 VDD VSS sg13g2_decap_8
XFILLER_111_217 VDD VSS sg13g2_fill_2
XFILLER_78_621 VDD VSS sg13g2_decap_8
X_12035_ _12036_/A _14258_/Q _14290_/Q _14322_/Q _14354_/Q _12235_/A _12236_/C VDD
+ VSS sg13g2_mux4_1
XFILLER_2_385 VDD VSS sg13g2_decap_8
XFILLER_120_762 VDD VSS sg13g2_fill_1
XFILLER_120_773 VDD VSS sg13g2_fill_1
XFILLER_93_613 VDD VSS sg13g2_decap_8
XFILLER_92_101 VDD VSS sg13g2_fill_1
XFILLER_19_7 VDD VSS sg13g2_decap_8
XFILLER_19_721 VDD VSS sg13g2_decap_8
XFILLER_168_1007 VDD VSS sg13g2_decap_8
X_14110__2069 _14110_/RESET_B VDD VSS sg13g2_tiehi
XFILLER_4_1344 VDD VSS sg13g2_decap_8
XFILLER_150_1291 VDD VSS sg13g2_fill_2
X_13986_ _13986_/Q _14722_/CLK _13986_/D _13986_/RESET_B VDD VSS sg13g2_dfrbpq_1
XFILLER_18_231 VDD VSS sg13g2_decap_8
XFILLER_81_819 VDD VSS sg13g2_decap_8
X_12937_ _12937_/Y _12937_/A _12936_/Y VDD VSS sg13g2_nor2b_1
XFILLER_73_370 VDD VSS sg13g2_decap_8
XFILLER_20_1169 VDD VSS sg13g2_decap_8
XFILLER_19_798 VDD VSS sg13g2_decap_8
XFILLER_33_212 VDD VSS sg13g2_decap_8
XFILLER_160_91 VDD VSS sg13g2_decap_8
X_14218__1961 _14218_/RESET_B VDD VSS sg13g2_tiehi
XFILLER_146_1316 VDD VSS sg13g2_decap_4
XFILLER_61_532 VDD VSS sg13g2_fill_1
X_12868_ _12868_/Y input30/X _12841_/B _12803_/X input7/X _12866_/X VDD VSS sg13g2_a221oi_1
XFILLER_33_267 VDD VSS sg13g2_decap_8
X_14607_ _14607_/Q _14607_/CLK _14607_/D _14607_/RESET_B VDD VSS sg13g2_dfrbpq_1
XFILLER_159_420 VDD VSS sg13g2_decap_8
X_11819_ _11819_/Y _11821_/S0 _14508_/Q _11894_/B VDD VSS sg13g2_a21oi_1
X_12799_ _12799_/X _13601_/A _12844_/C VDD VSS sg13g2_and2_1
XFILLER_18_1043 VDD VSS sg13g2_decap_8
X_14538_ _14538_/Q _14730_/CLK _14538_/D _14538_/RESET_B VDD VSS sg13g2_dfrbpq_1
XFILLER_144_1084 VDD VSS sg13g2_fill_2
X_14469_ _14469_/Q clkload7/A _14469_/D _14469_/RESET_B VDD VSS sg13g2_dfrbpq_1
XFILLER_70_1281 VDD VSS sg13g2_decap_4
XFILLER_31_1232 VDD VSS sg13g2_decap_8
XFILLER_105_1079 VDD VSS sg13g2_decap_8
XFILLER_146_158 VDD VSS sg13g2_decap_8
XFILLER_162_618 VDD VSS sg13g2_fill_1
XFILLER_127_394 VDD VSS sg13g2_fill_1
XFILLER_103_707 VDD VSS sg13g2_decap_8
XFILLER_45_0 VDD VSS sg13g2_decap_8
XFILLER_170_684 VDD VSS sg13g2_decap_8
X_14320__1859 _14320_/RESET_B VDD VSS sg13g2_tiehi
X_08961_ _09641_/D _10776_/C _10793_/B _11183_/B1 VDD VSS sg13g2_o21ai_1
X_13706__2473 _13706_/RESET_B VDD VSS sg13g2_tiehi
XFILLER_9_1211 VDD VSS sg13g2_decap_8
XFILLER_97_930 VDD VSS sg13g2_fill_1
XFILLER_64_1041 VDD VSS sg13g2_decap_8
XFILLER_142_397 VDD VSS sg13g2_decap_8
X_07912_ _07912_/Y _07911_/A _07912_/B VDD VSS sg13g2_nand2b_1
XFILLER_155_1180 VDD VSS sg13g2_decap_8
X_08892_ _13706_/D _16868_/A _08891_/X _08892_/S VDD VSS sg13g2_mux2_1
XFILLER_64_1074 VDD VSS sg13g2_decap_8
XFILLER_69_665 VDD VSS sg13g2_fill_1
XFILLER_69_676 VDD VSS sg13g2_decap_8
XFILLER_68_142 VDD VSS sg13g2_decap_8
XFILLER_9_1288 VDD VSS sg13g2_decap_8
XFILLER_68_153 VDD VSS sg13g2_fill_1
X_07843_ _08678_/B _15017_/Q _07972_/B VDD VSS sg13g2_or2_1
XFILLER_96_484 VDD VSS sg13g2_decap_4
XFILLER_68_186 VDD VSS sg13g2_decap_4
XFILLER_83_134 VDD VSS sg13g2_decap_8
XFILLER_56_348 VDD VSS sg13g2_decap_4
X_07774_ _08315_/B _07775_/A _08306_/B VDD VSS sg13g2_xnor2_1
XFILLER_42_1383 VDD VSS sg13g2_fill_1
X_09513_ _14112_/D _10043_/A0 _14112_/Q _09535_/S VDD VSS sg13g2_mux2_1
XFILLER_17_49 VDD VSS sg13g2_decap_8
XFILLER_140_28 VDD VSS sg13g2_decap_8
XFILLER_65_882 VDD VSS sg13g2_decap_8
XFILLER_92_690 VDD VSS sg13g2_decap_8
XFILLER_64_392 VDD VSS sg13g2_decap_8
X_09444_ _14045_/D _09609_/A0 _14045_/Q _09467_/S VDD VSS sg13g2_mux2_1
XFILLER_24_245 VDD VSS sg13g2_decap_8
XFILLER_169_217 VDD VSS sg13g2_decap_8
XFILLER_25_779 VDD VSS sg13g2_fill_1
XFILLER_52_576 VDD VSS sg13g2_decap_8
XFILLER_80_896 VDD VSS sg13g2_decap_8
XFILLER_75_1170 VDD VSS sg13g2_fill_1
X_09375_ _09375_/Y _10004_/B _10004_/C _09441_/D VDD VSS sg13g2_nand3_1
XFILLER_166_902 VDD VSS sg13g2_fill_2
XFILLER_71_1034 VDD VSS sg13g2_decap_8
X_08326_ _08335_/B _08414_/B _08541_/A _07796_/B _08674_/A2 _08325_/Y VDD VSS sg13g2_a221oi_1
XFILLER_21_952 VDD VSS sg13g2_decap_8
XFILLER_138_615 VDD VSS sg13g2_fill_2
XFILLER_20_462 VDD VSS sg13g2_decap_8
XFILLER_165_434 VDD VSS sg13g2_decap_8
X_08257_ _08257_/Y _08045_/Y _08241_/A _08027_/Y VDD VSS sg13g2_a21oi_1
XFILLER_123_7 VDD VSS sg13g2_decap_8
XFILLER_123_1179 VDD VSS sg13g2_decap_8
XFILLER_153_607 VDD VSS sg13g2_fill_1
XFILLER_125_309 VDD VSS sg13g2_decap_8
XFILLER_10_1316 VDD VSS sg13g2_decap_8
X_08188_ _08188_/Y _08188_/A _08188_/B _08188_/C VDD VSS sg13g2_nor3_1
XFILLER_134_810 VDD VSS sg13g2_fill_2
XFILLER_165_14 VDD VSS sg13g2_decap_8
XFILLER_118_372 VDD VSS sg13g2_decap_8
XFILLER_3_105 VDD VSS sg13g2_decap_8
XFILLER_133_320 VDD VSS sg13g2_decap_4
XFILLER_145_180 VDD VSS sg13g2_fill_1
XFILLER_134_854 VDD VSS sg13g2_fill_1
XFILLER_161_640 VDD VSS sg13g2_fill_2
XFILLER_133_342 VDD VSS sg13g2_decap_4
XFILLER_134_876 VDD VSS sg13g2_fill_2
X_10150_ _14727_/D _14727_/Q _10150_/A1 _10168_/S VDD VSS sg13g2_mux2_1
XFILLER_106_589 VDD VSS sg13g2_decap_8
XFILLER_160_161 VDD VSS sg13g2_decap_8
XFILLER_161_684 VDD VSS sg13g2_fill_1
X_10081_ _14661_/D _10148_/A1 _14661_/Q _10093_/S VDD VSS sg13g2_mux2_1
XFILLER_0_856 VDD VSS sg13g2_decap_8
XFILLER_102_740 VDD VSS sg13g2_decap_8
XFILLER_47_1283 VDD VSS sg13g2_decap_8
XFILLER_134_1297 VDD VSS sg13g2_fill_2
XFILLER_169_1305 VDD VSS sg13g2_decap_8
XFILLER_87_495 VDD VSS sg13g2_decap_8
XFILLER_169_1316 VDD VSS sg13g2_fill_2
X_13840_ _13840_/Q clkload8/A _13840_/D _13840_/RESET_B VDD VSS sg13g2_dfrbpq_1
X_14475__1704 _14475_/RESET_B VDD VSS sg13g2_tiehi
XFILLER_114_84 VDD VSS sg13g2_fill_2
XFILLER_169_1338 VDD VSS sg13g2_decap_8
XFILLER_74_145 VDD VSS sg13g2_decap_8
XFILLER_28_562 VDD VSS sg13g2_decap_8
X_13771_ _13771_/Q clkload1/A _13771_/D _13771_/RESET_B VDD VSS sg13g2_dfrbpq_1
X_10983_ _10984_/A _10983_/A1 _10982_/X _11109_/B VDD VSS sg13g2_o21ai_1
XFILLER_167_1040 VDD VSS sg13g2_fill_1
XFILLER_16_735 VDD VSS sg13g2_decap_8
X_12722_ _15015_/D _12722_/A _12722_/B VDD VSS sg13g2_nor2_1
XFILLER_15_245 VDD VSS sg13g2_decap_8
XFILLER_71_874 VDD VSS sg13g2_fill_2
XFILLER_43_565 VDD VSS sg13g2_fill_1
XFILLER_128_1046 VDD VSS sg13g2_decap_4
XFILLER_31_716 VDD VSS sg13g2_fill_1
XFILLER_90_21 VDD VSS sg13g2_decap_8
XFILLER_19_1330 VDD VSS sg13g2_decap_8
X_12653_ _12666_/A _12653_/A1 _07737_/B _07956_/A VDD VSS sg13g2_a21oi_1
XFILLER_93_1270 VDD VSS sg13g2_decap_8
XFILLER_70_373 VDD VSS sg13g2_decap_8
XFILLER_54_1221 VDD VSS sg13g2_decap_8
XFILLER_130_94 VDD VSS sg13g2_fill_1
XFILLER_93_1281 VDD VSS sg13g2_fill_2
XFILLER_43_598 VDD VSS sg13g2_fill_2
XFILLER_169_773 VDD VSS sg13g2_decap_8
X_11604_ _11604_/Y _11993_/S0 _14630_/Q VDD VSS sg13g2_nand2b_1
XFILLER_12_952 VDD VSS sg13g2_decap_8
XFILLER_141_1224 VDD VSS sg13g2_fill_2
X_12584_ _12597_/A _12709_/A1 _12737_/A2 _15006_/Q VDD VSS sg13g2_a21oi_1
XFILLER_54_1276 VDD VSS sg13g2_fill_1
XFILLER_50_1118 VDD VSS sg13g2_fill_2
XFILLER_128_114 VDD VSS sg13g2_decap_8
XFILLER_156_423 VDD VSS sg13g2_decap_8
XFILLER_11_462 VDD VSS sg13g2_decap_8
X_14323_ _14323_/Q _14660_/CLK _14323_/D _14323_/RESET_B VDD VSS sg13g2_dfrbpq_1
Xwire320 wire320/X wire320/A VDD VSS sg13g2_buf_2
XFILLER_54_1298 VDD VSS sg13g2_fill_1
XFILLER_23_70 VDD VSS sg13g2_decap_8
XFILLER_141_1257 VDD VSS sg13g2_fill_1
XFILLER_168_294 VDD VSS sg13g2_decap_8
Xwire331 wire331/X wire331/A VDD VSS sg13g2_buf_2
X_11535_ _11535_/Y _11535_/A _11549_/B VDD VSS sg13g2_nand2_1
XFILLER_8_945 VDD VSS sg13g2_decap_8
XFILLER_139_70 VDD VSS sg13g2_fill_2
XFILLER_128_169 VDD VSS sg13g2_decap_8
XFILLER_7_455 VDD VSS sg13g2_decap_8
XFILLER_144_629 VDD VSS sg13g2_decap_8
X_14254_ _14254_/Q clkload37/A _14254_/D _14254_/RESET_B VDD VSS sg13g2_dfrbpq_1
XFILLER_171_404 VDD VSS sg13g2_decap_8
X_11466_ _11466_/X _14113_/Q _14145_/Q _14177_/Q _14209_/Q _12282_/S0 _11493_/S1 VDD
+ VSS sg13g2_mux4_1
XFILLER_104_1090 VDD VSS sg13g2_decap_4
XFILLER_99_52 VDD VSS sg13g2_decap_8
XFILLER_137_692 VDD VSS sg13g2_decap_8
X_13205_ _13205_/X input22/X _13205_/A2 _13205_/B1 VDD VSS sg13g2_a21o_1
X_13963__2216 _13963_/RESET_B VDD VSS sg13g2_tiehi
X_10417_ _14828_/D _14828_/Q _10415_/A _10416_/Y VDD VSS sg13g2_a21oi_1
X_14185_ _14185_/Q _14649_/CLK _14185_/D _14185_/RESET_B VDD VSS sg13g2_dfrbpq_1
X_11397_ _11397_/Y _11418_/A _14559_/Q VDD VSS sg13g2_nand2b_1
XFILLER_48_1025 VDD VSS sg13g2_decap_8
XFILLER_125_876 VDD VSS sg13g2_decap_8
X_15204__2972 _15204_/RESET_B VDD VSS sg13g2_tiehi
XFILLER_87_1085 VDD VSS sg13g2_decap_8
XFILLER_174_1044 VDD VSS sg13g2_fill_1
XFILLER_152_673 VDD VSS sg13g2_decap_8
X_13136_ _13136_/X input17/X _13205_/A2 _13205_/B1 VDD VSS sg13g2_a21o_1
XFILLER_97_204 VDD VSS sg13g2_decap_8
X_10348_ _10350_/A _14809_/Q _10352_/C VDD VSS sg13g2_or2_1
XFILLER_174_1055 VDD VSS sg13g2_decap_8
XFILLER_152_695 VDD VSS sg13g2_decap_8
XFILLER_3_672 VDD VSS sg13g2_decap_8
XFILLER_140_846 VDD VSS sg13g2_decap_8
XFILLER_26_1301 VDD VSS sg13g2_decap_8
XFILLER_155_91 VDD VSS sg13g2_decap_8
XFILLER_79_952 VDD VSS sg13g2_fill_1
X_13067_ _13067_/Y _13066_/Y _13160_/B _13067_/C VDD VSS sg13g2_nand3b_1
X_10279_ _14787_/D _10661_/A _10279_/B _10311_/A VDD VSS sg13g2_nor3_1
XFILLER_97_259 VDD VSS sg13g2_decap_4
XFILLER_2_182 VDD VSS sg13g2_decap_8
XFILLER_174_1099 VDD VSS sg13g2_decap_4
XFILLER_65_1383 VDD VSS sg13g2_fill_1
XFILLER_152_1342 VDD VSS sg13g2_decap_8
XFILLER_94_911 VDD VSS sg13g2_decap_4
XFILLER_61_1236 VDD VSS sg13g2_decap_8
X_12018_ _12019_/B _12018_/A _12018_/B _12018_/C VDD VSS sg13g2_nand3_1
XFILLER_38_304 VDD VSS sg13g2_decap_8
XFILLER_26_1378 VDD VSS sg13g2_decap_4
XFILLER_94_977 VDD VSS sg13g2_fill_2
XFILLER_65_134 VDD VSS sg13g2_fill_1
XFILLER_54_808 VDD VSS sg13g2_decap_8
XFILLER_4_1141 VDD VSS sg13g2_decap_8
XFILLER_94_988 VDD VSS sg13g2_decap_8
XFILLER_93_487 VDD VSS sg13g2_decap_8
XFILLER_47_871 VDD VSS sg13g2_decap_8
X_13969_ _13969_/Q _14737_/CLK _13969_/D _13969_/RESET_B VDD VSS sg13g2_dfrbpq_1
XFILLER_34_510 VDD VSS sg13g2_decap_8
XFILLER_0_63 VDD VSS sg13g2_decap_8
XFILLER_34_521 VDD VSS sg13g2_fill_1
XFILLER_19_595 VDD VSS sg13g2_decap_8
XFILLER_0_1038 VDD VSS sg13g2_decap_8
XFILLER_98_1192 VDD VSS sg13g2_decap_8
XFILLER_80_159 VDD VSS sg13g2_decap_8
XFILLER_55_1007 VDD VSS sg13g2_decap_4
XFILLER_59_1187 VDD VSS sg13g2_decap_8
XFILLER_59_1198 VDD VSS sg13g2_fill_2
XFILLER_55_1029 VDD VSS sg13g2_decap_8
XFILLER_146_1157 VDD VSS sg13g2_fill_2
XFILLER_22_738 VDD VSS sg13g2_decap_8
XFILLER_148_902 VDD VSS sg13g2_decap_4
X_09160_ _13785_/D _13785_/Q _09338_/A0 _09160_/S VDD VSS sg13g2_mux2_1
X_15191__2781 _15191_/RESET_B VDD VSS sg13g2_tiehi
XFILLER_72_1354 VDD VSS sg13g2_decap_4
XFILLER_147_401 VDD VSS sg13g2_fill_1
XFILLER_148_924 VDD VSS sg13g2_decap_4
XFILLER_33_1316 VDD VSS sg13g2_decap_8
XFILLER_21_259 VDD VSS sg13g2_decap_8
XFILLER_148_935 VDD VSS sg13g2_decap_8
X_08111_ _08112_/A _08246_/A1 _08087_/X _08098_/Y _08104_/Y _08093_/Y VDD VSS sg13g2_a221oi_1
XFILLER_159_294 VDD VSS sg13g2_decap_8
X_09091_ _09091_/Y _09090_/A _09086_/Y _09090_/Y VDD VSS sg13g2_o21ai_1
X_08042_ _08042_/X _08487_/A3 _08493_/B2 _08470_/B _08510_/A1 _08083_/S0 _08669_/B1
+ VDD VSS sg13g2_mux4_1
XFILLER_31_1040 VDD VSS sg13g2_decap_8
XFILLER_162_404 VDD VSS sg13g2_decap_8
XFILLER_135_629 VDD VSS sg13g2_decap_8
XFILLER_122_1190 VDD VSS sg13g2_decap_8
X_14553__1626 _14553_/RESET_B VDD VSS sg13g2_tiehi
XFILLER_143_640 VDD VSS sg13g2_decap_8
X_13939__2240 _13939_/RESET_B VDD VSS sg13g2_tiehi
XFILLER_115_342 VDD VSS sg13g2_decap_8
X_14699__1480 _14699_/RESET_B VDD VSS sg13g2_tiehi
XFILLER_115_353 VDD VSS sg13g2_fill_2
XFILLER_116_876 VDD VSS sg13g2_decap_8
XFILLER_1_609 VDD VSS sg13g2_decap_8
XFILLER_118_1215 VDD VSS sg13g2_decap_8
XFILLER_66_1147 VDD VSS sg13g2_decap_8
XFILLER_171_982 VDD VSS sg13g2_fill_2
XFILLER_135_28 VDD VSS sg13g2_decap_8
XFILLER_143_684 VDD VSS sg13g2_fill_2
X_09993_ _14576_/D _10092_/A0 _14576_/Q _10003_/S VDD VSS sg13g2_mux2_1
XFILLER_88_215 VDD VSS sg13g2_decap_8
XFILLER_0_119 VDD VSS sg13g2_decap_8
XFILLER_157_1286 VDD VSS sg13g2_decap_8
Xhold3025 hold3025/X input32/X VDD VSS sg13g2_dlygate4sd3_1
XFILLER_89_749 VDD VSS sg13g2_decap_8
Xhold3036 input8/A mem_axi_rdata[13] VDD VSS sg13g2_dlygate4sd3_1
XFILLER_103_548 VDD VSS sg13g2_decap_8
Xhold3047 input30/A mem_axi_rdata[4] VDD VSS sg13g2_dlygate4sd3_1
X_08944_ _08944_/Y _08942_/Y _08943_/Y _08940_/S VDD VSS sg13g2_a21oi_1
Xhold3058 input31/A mem_axi_rdata[5] VDD VSS sg13g2_dlygate4sd3_1
Xhold3069 _15193_/D _08721_/X VDD VSS sg13g2_dlygate4sd3_1
XFILLER_130_378 VDD VSS sg13g2_decap_4
X_08875_ _08875_/X _08874_/X _11591_/A _08940_/S VDD VSS sg13g2_mux2_1
XFILLER_9_1085 VDD VSS sg13g2_decap_8
XFILLER_111_581 VDD VSS sg13g2_fill_2
XFILLER_29_326 VDD VSS sg13g2_decap_8
X_07826_ _07826_/X _15005_/Q _07826_/B VDD VSS sg13g2_and2_1
XFILLER_57_668 VDD VSS sg13g2_decap_8
XFILLER_151_49 VDD VSS sg13g2_decap_8
XFILLER_77_1210 VDD VSS sg13g2_decap_8
X_07757_ _07757_/Y _07751_/Y _13304_/B _13305_/B VDD VSS sg13g2_a21oi_1
XFILLER_65_690 VDD VSS sg13g2_decap_4
XFILLER_44_14 VDD VSS sg13g2_decap_8
XFILLER_37_392 VDD VSS sg13g2_decap_8
XFILLER_38_1205 VDD VSS sg13g2_decap_8
XFILLER_53_863 VDD VSS sg13g2_decap_8
XFILLER_25_554 VDD VSS sg13g2_fill_2
X_07688_ _07696_/A _07697_/A _12997_/B VDD VSS sg13g2_nand2_1
XFILLER_164_1235 VDD VSS sg13g2_fill_1
XFILLER_80_660 VDD VSS sg13g2_decap_8
XFILLER_77_1287 VDD VSS sg13g2_decap_8
XFILLER_52_362 VDD VSS sg13g2_decap_8
X_09427_ _14029_/D _09625_/A0 _14029_/Q _09431_/S VDD VSS sg13g2_mux2_1
XFILLER_13_749 VDD VSS sg13g2_decap_8
XFILLER_164_1268 VDD VSS sg13g2_decap_8
XFILLER_100_42 VDD VSS sg13g2_decap_8
XFILLER_12_259 VDD VSS sg13g2_decap_8
X_09358_ _13962_/D _09622_/A0 _13962_/Q _09368_/S VDD VSS sg13g2_mux2_1
X_14753__2963 _14753_/RESET_B VDD VSS sg13g2_tiehi
XFILLER_100_86 VDD VSS sg13g2_decap_8
XFILLER_166_743 VDD VSS sg13g2_fill_2
X_08309_ _08312_/B _13529_/A _08122_/Y _08308_/X VDD VSS sg13g2_a21oi_1
XFILLER_60_35 VDD VSS sg13g2_decap_8
XFILLER_165_231 VDD VSS sg13g2_decap_8
X_09289_ _13897_/D _13897_/Q _09621_/A0 _09301_/S VDD VSS sg13g2_mux2_1
XFILLER_166_765 VDD VSS sg13g2_fill_2
XFILLER_14_1260 VDD VSS sg13g2_decap_8
X_11320_ _11320_/X _14237_/Q _14269_/Q _14301_/Q _14333_/Q _11320_/S0 _11328_/S1 VDD
+ VSS sg13g2_mux4_1
XFILLER_166_798 VDD VSS sg13g2_decap_4
X_14192__1987 _14192_/RESET_B VDD VSS sg13g2_tiehi
XFILLER_10_1113 VDD VSS sg13g2_decap_8
XFILLER_101_1252 VDD VSS sg13g2_fill_2
XFILLER_158_1039 VDD VSS sg13g2_decap_4
X_11251_ _11251_/Y _12303_/S _14556_/Q VDD VSS sg13g2_nand2b_1
XFILLER_5_959 VDD VSS sg13g2_decap_8
XFILLER_49_1323 VDD VSS sg13g2_fill_2
XFILLER_118_191 VDD VSS sg13g2_decap_8
XFILLER_134_640 VDD VSS sg13g2_decap_4
XFILLER_107_865 VDD VSS sg13g2_fill_2
XFILLER_88_1383 VDD VSS sg13g2_fill_1
XFILLER_109_84 VDD VSS sg13g2_decap_4
X_14529__1650 _14529_/RESET_B VDD VSS sg13g2_tiehi
XFILLER_4_469 VDD VSS sg13g2_decap_8
X_10202_ _14758_/D _15182_/D _14758_/Q _13346_/A VDD VSS sg13g2_mux2_1
XFILLER_136_1315 VDD VSS sg13g2_decap_4
X_11182_ _11182_/Y _11181_/X _11151_/A _11179_/X _11177_/X _13412_/C VDD VSS sg13g2_a221oi_1
XFILLER_79_226 VDD VSS sg13g2_decap_8
XFILLER_122_846 VDD VSS sg13g2_decap_4
XFILLER_136_1337 VDD VSS sg13g2_decap_8
XFILLER_122_857 VDD VSS sg13g2_decap_8
X_10133_ _14711_/D _10166_/A1 _14711_/Q wire421/X VDD VSS sg13g2_mux2_1
XFILLER_95_708 VDD VSS sg13g2_fill_2
X_14941_ _14941_/Q clkload43/A _14941_/D _14941_/RESET_B VDD VSS sg13g2_dfrbpq_1
X_10064_ _14645_/D _10097_/A0 _14645_/Q _10064_/S VDD VSS sg13g2_mux2_1
XFILLER_0_686 VDD VSS sg13g2_decap_4
XFILLER_87_281 VDD VSS sg13g2_decap_8
XFILLER_134_1094 VDD VSS sg13g2_decap_8
XFILLER_169_1113 VDD VSS sg13g2_decap_8
X_14872_ _14872_/Q _14874_/CLK _14872_/D _14872_/RESET_B VDD VSS sg13g2_dfrbpq_1
XFILLER_75_454 VDD VSS sg13g2_fill_2
XFILLER_76_988 VDD VSS sg13g2_decap_8
XFILLER_63_605 VDD VSS sg13g2_decap_8
XFILLER_47_167 VDD VSS sg13g2_decap_8
X_13823_ _13823_/Q clkload12/A _13823_/D _13823_/RESET_B VDD VSS sg13g2_dfrbpq_1
XFILLER_21_1253 VDD VSS sg13g2_decap_8
XFILLER_18_70 VDD VSS sg13g2_decap_8
XFILLER_63_649 VDD VSS sg13g2_decap_8
XFILLER_169_1179 VDD VSS sg13g2_decap_8
XFILLER_16_532 VDD VSS sg13g2_decap_8
XFILLER_1_1358 VDD VSS sg13g2_decap_8
X_13754_ _13754_/Q _14516_/CLK _13754_/D _13754_/RESET_B VDD VSS sg13g2_dfrbpq_1
X_10966_ _10966_/Y _11015_/A _11015_/C _11027_/B1 VDD VSS sg13g2_a21oi_1
XFILLER_43_340 VDD VSS sg13g2_decap_8
X_12705_ _12705_/X _12703_/X _12702_/X _12697_/X _12696_/X _12705_/S0 _12789_/S1 VDD
+ VSS sg13g2_mux4_1
X_14631__1548 _14631_/RESET_B VDD VSS sg13g2_tiehi
X_13685_ _13685_/Q clkload55/A _13685_/D _13685_/RESET_B VDD VSS sg13g2_dfrbpq_1
X_10897_ _10936_/A _10897_/A _10897_/B _10923_/A _10897_/D VDD VSS sg13g2_nor4_1
X_12636_ _12636_/X _12634_/X _12635_/X _12720_/S VDD VSS sg13g2_mux2_1
XFILLER_157_710 VDD VSS sg13g2_fill_2
XFILLER_34_91 VDD VSS sg13g2_decap_8
XFILLER_169_581 VDD VSS sg13g2_decap_8
XFILLER_86_7 VDD VSS sg13g2_decap_4
XFILLER_141_1021 VDD VSS sg13g2_decap_4
XFILLER_156_220 VDD VSS sg13g2_fill_2
XFILLER_157_754 VDD VSS sg13g2_fill_1
XFILLER_15_1057 VDD VSS sg13g2_decap_8
X_12567_ _12567_/X _12566_/X _12565_/X _12567_/S VDD VSS sg13g2_mux2_1
XFILLER_8_742 VDD VSS sg13g2_decap_8
XFILLER_89_1114 VDD VSS sg13g2_decap_8
XFILLER_145_916 VDD VSS sg13g2_fill_1
XFILLER_106_1196 VDD VSS sg13g2_decap_8
X_14306_ _14306_/Q clkload25/A _14306_/D _14306_/RESET_B VDD VSS sg13g2_dfrbpq_1
XFILLER_117_629 VDD VSS sg13g2_decap_4
XFILLER_141_1087 VDD VSS sg13g2_decap_8
X_11518_ _11518_/Y _11559_/C _11516_/Y _12292_/A VDD VSS sg13g2_a21oi_1
XFILLER_7_252 VDD VSS sg13g2_decap_8
X_12498_ _12499_/B _13683_/Q _12721_/A2 _12497_/X _12721_/B2 _12624_/C1 VDD VSS sg13g2_a221oi_1
XFILLER_89_1158 VDD VSS sg13g2_decap_4
XFILLER_144_448 VDD VSS sg13g2_decap_4
X_14237_ _14237_/Q clkload47/A _14237_/D _14237_/RESET_B VDD VSS sg13g2_dfrbpq_1
X_11449_ _11449_/X _11441_/X _11440_/X _11435_/X _11434_/X _12214_/B _11446_/A VDD
+ VSS sg13g2_mux4_1
XFILLER_140_610 VDD VSS sg13g2_fill_2
X_14168_ _14168_/Q _14632_/CLK _14168_/D _14168_/RESET_B VDD VSS sg13g2_dfrbpq_1
XFILLER_171_289 VDD VSS sg13g2_decap_8
XFILLER_124_172 VDD VSS sg13g2_decap_8
X_13119_ _13132_/A _13170_/A _13120_/A VDD VSS sg13g2_nor2_1
XFILLER_112_345 VDD VSS sg13g2_fill_2
XFILLER_140_665 VDD VSS sg13g2_fill_1
X_14099_ _14099_/Q clkload22/A _14099_/D _14099_/RESET_B VDD VSS sg13g2_dfrbpq_1
XFILLER_39_613 VDD VSS sg13g2_fill_1
XFILLER_100_529 VDD VSS sg13g2_fill_2
XFILLER_112_389 VDD VSS sg13g2_fill_2
XFILLER_140_698 VDD VSS sg13g2_fill_2
XFILLER_6_1225 VDD VSS sg13g2_decap_8
XFILLER_152_1161 VDD VSS sg13g2_decap_8
XFILLER_78_270 VDD VSS sg13g2_decap_8
XFILLER_26_1175 VDD VSS sg13g2_decap_8
Xfanout1270 _12091_/C _12319_/B1 VDD VSS sg13g2_buf_1
Xfanout1281 _12073_/S1 _12187_/C VDD VSS sg13g2_buf_1
X_08660_ _08661_/D _08678_/A _08674_/A2 _08341_/Y _08544_/B _08654_/Y VDD VSS sg13g2_a221oi_1
Xfanout1292 _12212_/S1 _12215_/S1 VDD VSS sg13g2_buf_1
XFILLER_67_999 VDD VSS sg13g2_decap_4
XFILLER_113_1189 VDD VSS sg13g2_decap_8
XFILLER_93_262 VDD VSS sg13g2_decap_8
XFILLER_38_178 VDD VSS sg13g2_decap_4
X_08591_ _08591_/X _08620_/A2 _08620_/A3 _08598_/A3 _08591_/A3 _08635_/S0 _08635_/S1
+ VDD VSS sg13g2_mux4_1
XFILLER_81_424 VDD VSS sg13g2_decap_8
XFILLER_19_392 VDD VSS sg13g2_decap_8
X_14846__2852 _14846_/RESET_B VDD VSS sg13g2_tiehi
XFILLER_62_671 VDD VSS sg13g2_decap_8
XFILLER_50_844 VDD VSS sg13g2_fill_2
XFILLER_14_28 VDD VSS sg13g2_decap_8
X_14607__1572 _14607_/RESET_B VDD VSS sg13g2_tiehi
XFILLER_22_546 VDD VSS sg13g2_fill_2
XFILLER_167_518 VDD VSS sg13g2_decap_8
X_09212_ _13823_/D _09910_/A1 _13823_/Q _09230_/S VDD VSS sg13g2_mux2_1
XFILLER_72_1151 VDD VSS sg13g2_decap_8
XFILLER_148_743 VDD VSS sg13g2_fill_2
X_09143_ _09143_/Y _10781_/B _09141_/A _09157_/D _09157_/C VDD VSS sg13g2_a22oi_1
XFILLER_148_754 VDD VSS sg13g2_decap_4
XFILLER_136_905 VDD VSS sg13g2_fill_1
X_14879__2786 _14879_/RESET_B VDD VSS sg13g2_tiehi
XFILLER_163_702 VDD VSS sg13g2_fill_1
XFILLER_147_264 VDD VSS sg13g2_decap_8
X_09074_ _09074_/Y _13088_/A _09103_/C _09111_/A1 VDD VSS sg13g2_o21ai_1
XFILLER_120_1149 VDD VSS sg13g2_decap_8
XFILLER_159_1326 VDD VSS sg13g2_decap_4
XFILLER_30_49 VDD VSS sg13g2_decap_8
XFILLER_163_757 VDD VSS sg13g2_decap_8
X_08025_ _08032_/C _08103_/A _08103_/B _08025_/C VDD VSS sg13g2_nor3_1
XFILLER_162_245 VDD VSS sg13g2_decap_8
XFILLER_151_919 VDD VSS sg13g2_decap_4
XFILLER_146_49 VDD VSS sg13g2_decap_8
XFILLER_104_813 VDD VSS sg13g2_fill_2
XFILLER_162_278 VDD VSS sg13g2_decap_8
XFILLER_1_406 VDD VSS sg13g2_decap_8
XFILLER_157_1061 VDD VSS sg13g2_decap_8
XFILLER_39_14 VDD VSS sg13g2_decap_8
XFILLER_77_708 VDD VSS sg13g2_decap_4
X_09976_ _14559_/D _10109_/A0 _14559_/Q _09994_/S VDD VSS sg13g2_mux2_1
XFILLER_130_153 VDD VSS sg13g2_decap_8
XFILLER_76_207 VDD VSS sg13g2_decap_8
XFILLER_131_1201 VDD VSS sg13g2_decap_8
XFILLER_170_1250 VDD VSS sg13g2_decap_8
X_08927_ _08927_/X _15045_/Q _14949_/Q _10767_/A VDD VSS sg13g2_mux2_1
XFILLER_130_186 VDD VSS sg13g2_decap_4
X_08858_ _13697_/D _16859_/A _08857_/X _08892_/S VDD VSS sg13g2_mux2_1
XFILLER_58_977 VDD VSS sg13g2_decap_8
XFILLER_18_819 VDD VSS sg13g2_decap_8
XFILLER_85_785 VDD VSS sg13g2_decap_8
XFILLER_131_1289 VDD VSS sg13g2_decap_8
X_07809_ _08553_/A _15012_/Q _08541_/B VDD VSS sg13g2_xor2_1
XFILLER_55_35 VDD VSS sg13g2_decap_8
XFILLER_45_638 VDD VSS sg13g2_fill_2
XFILLER_17_329 VDD VSS sg13g2_decap_8
X_08789_ _13681_/D _08728_/Y _08788_/Y _08787_/Y VDD VSS sg13g2_a21oi_1
XFILLER_166_1319 VDD VSS sg13g2_fill_2
XFILLER_73_969 VDD VSS sg13g2_decap_4
XFILLER_26_841 VDD VSS sg13g2_decap_8
X_10820_ _10821_/C _10803_/Y _10805_/Y _10804_/Y VDD VSS sg13g2_o21ai_1
XFILLER_55_79 VDD VSS sg13g2_decap_8
XFILLER_72_479 VDD VSS sg13g2_fill_2
X_15203__2971 _15203_/RESET_B VDD VSS sg13g2_tiehi
XFILLER_26_885 VDD VSS sg13g2_decap_8
XFILLER_111_52 VDD VSS sg13g2_decap_8
XFILLER_164_1043 VDD VSS sg13g2_decap_8
X_10751_ _14915_/D _09204_/C _11078_/B _10750_/Y VDD VSS sg13g2_o21ai_1
XFILLER_77_1095 VDD VSS sg13g2_decap_8
XFILLER_40_310 VDD VSS sg13g2_fill_2
XFILLER_129_1174 VDD VSS sg13g2_fill_1
XFILLER_13_546 VDD VSS sg13g2_decap_8
XFILLER_111_96 VDD VSS sg13g2_decap_8
XFILLER_158_518 VDD VSS sg13g2_decap_8
X_13470_ _15109_/D _15109_/Q _13470_/A2 _13469_/X VDD VSS sg13g2_a21o_1
XFILLER_164_1098 VDD VSS sg13g2_decap_8
X_10682_ _14897_/D _07705_/B _10818_/B _10681_/Y VDD VSS sg13g2_o21ai_1
XFILLER_41_888 VDD VSS sg13g2_decap_8
XFILLER_40_365 VDD VSS sg13g2_fill_1
XFILLER_9_539 VDD VSS sg13g2_decap_8
XFILLER_16_1344 VDD VSS sg13g2_decap_8
X_12421_ _12421_/X _14240_/Q _14272_/Q _14304_/Q _14336_/Q _12452_/S0 _12452_/S1 VDD
+ VSS sg13g2_mux4_1
XFILLER_71_89 VDD VSS sg13g2_decap_8
XFILLER_138_264 VDD VSS sg13g2_fill_2
X_15140_ _15140_/Q clkload59/A _15140_/D _15140_/RESET_B VDD VSS sg13g2_dfrbpq_1
X_12352_ _12352_/X _14235_/Q _14267_/Q _14299_/Q _14331_/Q _12352_/S0 _12352_/S1 VDD
+ VSS sg13g2_mux4_1
XFILLER_166_595 VDD VSS sg13g2_decap_8
XFILLER_112_0 VDD VSS sg13g2_decap_8
XFILLER_154_757 VDD VSS sg13g2_fill_1
X_11303_ _11303_/Y _11310_/A1 _14589_/Q _11366_/C VDD VSS sg13g2_a21oi_1
X_15071_ _15071_/Q clkload65/A _15071_/D _15071_/RESET_B VDD VSS sg13g2_dfrbpq_1
XFILLER_142_919 VDD VSS sg13g2_decap_4
X_12283_ _12283_/X _13849_/Q _13881_/Q _13913_/Q _13945_/Q _12288_/S0 _12288_/S1 VDD
+ VSS sg13g2_mux4_1
XFILLER_5_756 VDD VSS sg13g2_decap_8
XFILLER_84_1011 VDD VSS sg13g2_decap_4
XFILLER_153_278 VDD VSS sg13g2_decap_8
X_14022_ _14022_/Q clkload2/A _14022_/D _14022_/RESET_B VDD VSS sg13g2_dfrbpq_1
XFILLER_88_1191 VDD VSS sg13g2_decap_8
X_14045__2134 _14045_/RESET_B VDD VSS sg13g2_tiehi
X_11234_ wire523/A _11232_/Y _11233_/Y _15217_/Q VDD VSS sg13g2_a21oi_1
XFILLER_84_1033 VDD VSS sg13g2_decap_8
XFILLER_4_266 VDD VSS sg13g2_decap_8
XFILLER_49_1153 VDD VSS sg13g2_decap_8
XFILLER_122_632 VDD VSS sg13g2_decap_8
XFILLER_136_1145 VDD VSS sg13g2_fill_2
X_11165_ _11165_/X _11191_/A _11181_/B VDD VSS sg13g2_or2_1
XFILLER_96_31 VDD VSS sg13g2_fill_1
XFILLER_49_911 VDD VSS sg13g2_decap_8
XFILLER_1_973 VDD VSS sg13g2_decap_8
X_10116_ _14694_/D _10149_/A1 _14694_/Q _10127_/S VDD VSS sg13g2_mux2_1
XFILLER_171_1069 VDD VSS sg13g2_decap_8
X_11096_ _11096_/Y _11097_/A _11097_/C _11115_/A VDD VSS sg13g2_o21ai_1
XFILLER_0_483 VDD VSS sg13g2_decap_8
XFILLER_76_730 VDD VSS sg13g2_fill_1
X_14924_ _14924_/Q clkload53/A _14924_/D _14924_/RESET_B VDD VSS sg13g2_dfrbpq_1
X_10047_ _14628_/D _10047_/A0 _14628_/Q _10060_/S VDD VSS sg13g2_mux2_1
XFILLER_49_966 VDD VSS sg13g2_decap_4
XFILLER_64_914 VDD VSS sg13g2_decap_8
XFILLER_29_91 VDD VSS sg13g2_decap_8
XFILLER_152_70 VDD VSS sg13g2_decap_8
XFILLER_49_999 VDD VSS sg13g2_fill_1
XFILLER_48_476 VDD VSS sg13g2_decap_8
XFILLER_110_1329 VDD VSS sg13g2_decap_8
X_14855_ _14855_/Q _14874_/CLK _14855_/D _14855_/RESET_B VDD VSS sg13g2_dfrbpq_1
XFILLER_21_1050 VDD VSS sg13g2_decap_8
X_13806_ _13806_/Q clkload39/A _13806_/D _13806_/RESET_B VDD VSS sg13g2_dfrbpq_1
XFILLER_1_1155 VDD VSS sg13g2_decap_8
X_14786_ _14786_/Q _14890_/CLK _14786_/D _14786_/RESET_B VDD VSS sg13g2_dfrbpq_1
X_11998_ _11998_/X _11994_/X _11995_/X _11993_/X _11992_/X _11743_/C _11999_/S1 VDD
+ VSS sg13g2_mux4_1
XFILLER_91_799 VDD VSS sg13g2_decap_4
XFILLER_17_896 VDD VSS sg13g2_decap_8
X_13737_ _13737_/Q clkload20/A _13737_/D _13737_/RESET_B VDD VSS sg13g2_dfrbpq_1
XFILLER_56_1135 VDD VSS sg13g2_decap_8
X_10949_ _10949_/Y _10893_/X _11005_/A _11007_/B VDD VSS sg13g2_o21ai_1
XFILLER_43_181 VDD VSS sg13g2_decap_8
XFILLER_32_844 VDD VSS sg13g2_decap_8
XFILLER_143_1127 VDD VSS sg13g2_decap_8
XFILLER_149_529 VDD VSS sg13g2_decap_8
X_13668_ _13668_/Q clkload64/A _13668_/D _13668_/RESET_B VDD VSS sg13g2_dfrbpq_1
X_12619_ _12619_/X _13838_/Q _13870_/Q _13902_/Q _13934_/Q _12703_/S0 _12703_/S1 VDD
+ VSS sg13g2_mux4_1
X_14255__1924 _14255_/RESET_B VDD VSS sg13g2_tiehi
X_13599_ _13599_/Y _13600_/A _13508_/C hold3168/X VDD VSS sg13g2_a21oi_1
XFILLER_129_264 VDD VSS sg13g2_decap_8
XFILLER_144_245 VDD VSS sg13g2_decap_8
XFILLER_172_554 VDD VSS sg13g2_fill_2
XFILLER_144_267 VDD VSS sg13g2_decap_8
XFILLER_6_84 VDD VSS sg13g2_decap_8
XFILLER_172_587 VDD VSS sg13g2_decap_4
XFILLER_67_1253 VDD VSS sg13g2_fill_1
XFILLER_119_1343 VDD VSS sg13g2_fill_1
XFILLER_98_332 VDD VSS sg13g2_decap_8
XFILLER_113_643 VDD VSS sg13g2_decap_8
XFILLER_154_1234 VDD VSS sg13g2_decap_8
Xfanout507 _13543_/B _13524_/A1 VDD VSS sg13g2_buf_1
X_09830_ _14418_/D _10061_/A0 _14418_/Q _09831_/S VDD VSS sg13g2_mux2_1
XFILLER_8_1309 VDD VSS sg13g2_decap_8
XFILLER_113_654 VDD VSS sg13g2_fill_1
XFILLER_154_1245 VDD VSS sg13g2_fill_1
Xfanout518 _12777_/A2 _12358_/Y VDD VSS sg13g2_buf_1
XFILLER_141_974 VDD VSS sg13g2_decap_8
Xfanout529 _09907_/A1 _10105_/A VDD VSS sg13g2_buf_1
XFILLER_28_1259 VDD VSS sg13g2_decap_8
XFILLER_119_1376 VDD VSS sg13g2_decap_4
XFILLER_112_153 VDD VSS sg13g2_fill_2
XFILLER_98_376 VDD VSS sg13g2_decap_8
XFILLER_98_387 VDD VSS sg13g2_fill_2
XFILLER_101_838 VDD VSS sg13g2_decap_8
X_09761_ _14351_/D _14351_/Q _10125_/A0 _09768_/S VDD VSS sg13g2_mux2_1
XFILLER_6_1022 VDD VSS sg13g2_decap_8
XFILLER_67_730 VDD VSS sg13g2_fill_1
X_08712_ _13661_/D _15188_/D _14760_/Q _13652_/S VDD VSS sg13g2_mux2_1
X_09692_ _14284_/D _09923_/A1 _14284_/Q _09700_/S VDD VSS sg13g2_mux2_1
X_13743__2436 _13743_/RESET_B VDD VSS sg13g2_tiehi
XFILLER_66_262 VDD VSS sg13g2_decap_8
X_08643_ _08646_/B _08643_/A _08646_/A _08643_/C _08643_/D VDD VSS sg13g2_nand4_1
XFILLER_6_1099 VDD VSS sg13g2_decap_8
XFILLER_54_413 VDD VSS sg13g2_decap_4
X_13889__2290 _13889_/RESET_B VDD VSS sg13g2_tiehi
XFILLER_66_295 VDD VSS sg13g2_decap_8
XFILLER_54_435 VDD VSS sg13g2_decap_8
XFILLER_26_126 VDD VSS sg13g2_decap_8
X_08574_ _08575_/B _08574_/A _08574_/B _08574_/C _08574_/D VDD VSS sg13g2_nand4_1
XFILLER_78_1371 VDD VSS sg13g2_decap_8
XFILLER_70_928 VDD VSS sg13g2_decap_8
XFILLER_82_799 VDD VSS sg13g2_decap_8
XFILLER_25_49 VDD VSS sg13g2_decap_8
XFILLER_39_1344 VDD VSS sg13g2_decap_8
XFILLER_126_1314 VDD VSS sg13g2_decap_8
XFILLER_50_630 VDD VSS sg13g2_fill_1
XFILLER_165_1374 VDD VSS sg13g2_decap_4
XFILLER_62_490 VDD VSS sg13g2_fill_1
XFILLER_168_838 VDD VSS sg13g2_decap_8
X_14123__2056 _14123_/RESET_B VDD VSS sg13g2_tiehi
XFILLER_50_652 VDD VSS sg13g2_decap_4
XFILLER_22_343 VDD VSS sg13g2_decap_8
XFILLER_167_315 VDD VSS sg13g2_decap_8
XFILLER_126_1358 VDD VSS sg13g2_decap_8
XFILLER_136_713 VDD VSS sg13g2_fill_1
X_09126_ _09126_/Y _09117_/A _10767_/B _09125_/X VDD VSS sg13g2_o21ai_1
XFILLER_159_1101 VDD VSS sg13g2_fill_1
XFILLER_135_223 VDD VSS sg13g2_decap_4
XFILLER_163_532 VDD VSS sg13g2_decap_8
XFILLER_68_1017 VDD VSS sg13g2_fill_2
XFILLER_136_768 VDD VSS sg13g2_decap_8
X_09057_ _09057_/X _09057_/A _09057_/B _09089_/C VDD VSS sg13g2_or3_1
XFILLER_117_960 VDD VSS sg13g2_decap_8
XFILLER_159_1167 VDD VSS sg13g2_decap_8
X_13991__2188 _13991_/RESET_B VDD VSS sg13g2_tiehi
XFILLER_11_1274 VDD VSS sg13g2_decap_8
X_08008_ _08008_/Y _08340_/A _08008_/B VDD VSS sg13g2_nor2_1
XFILLER_1_203 VDD VSS sg13g2_decap_8
XFILLER_173_14 VDD VSS sg13g2_decap_8
XFILLER_172_1301 VDD VSS sg13g2_decap_8
XFILLER_116_481 VDD VSS sg13g2_fill_2
XFILLER_104_632 VDD VSS sg13g2_fill_1
XFILLER_132_974 VDD VSS sg13g2_fill_1
XFILLER_172_1356 VDD VSS sg13g2_decap_8
X_13676__2520 _13676_/RESET_B VDD VSS sg13g2_tiehi
X_09959_ _14543_/D _14543_/Q _09959_/A1 _09970_/S VDD VSS sg13g2_mux2_1
XFILLER_89_398 VDD VSS sg13g2_fill_1
X_12970_ _12970_/Y _12969_/Y _07683_/A _12966_/Y VDD VSS sg13g2_a21oi_1
XFILLER_92_508 VDD VSS sg13g2_fill_2
XFILLER_92_519 VDD VSS sg13g2_decap_8
XFILLER_66_67 VDD VSS sg13g2_fill_2
XFILLER_18_616 VDD VSS sg13g2_decap_8
XFILLER_131_1064 VDD VSS sg13g2_decap_8
X_11921_ _11921_/X _14703_/Q _14735_/Q _13775_/Q _13807_/Q _11925_/S0 _11925_/S1 VDD
+ VSS sg13g2_mux4_1
XFILLER_58_796 VDD VSS sg13g2_decap_8
X_14333__1846 _14333_/RESET_B VDD VSS sg13g2_tiehi
XFILLER_17_126 VDD VSS sg13g2_decap_8
XFILLER_131_1097 VDD VSS sg13g2_decap_4
X_13719__2460 _13719_/RESET_B VDD VSS sg13g2_tiehi
XFILLER_166_1116 VDD VSS sg13g2_decap_4
X_14640_ _14640_/Q _14672_/CLK _14640_/D _14640_/RESET_B VDD VSS sg13g2_dfrbpq_1
XFILLER_73_766 VDD VSS sg13g2_decap_8
X_11852_ _11852_/X _13965_/Q _13997_/Q _14029_/Q _14061_/Q _11852_/S0 _11852_/S1 VDD
+ VSS sg13g2_mux4_1
XFILLER_26_660 VDD VSS sg13g2_decap_8
XFILLER_122_95 VDD VSS sg13g2_decap_4
X_10803_ _10803_/Y _10675_/A _08971_/X _10802_/Y VDD VSS sg13g2_o21ai_1
XFILLER_14_833 VDD VSS sg13g2_decap_8
X_14571_ _14571_/Q clkload0/A _14571_/D _14571_/RESET_B VDD VSS sg13g2_dfrbpq_1
X_11783_ _11783_/X _14571_/Q _14603_/Q _14635_/Q _14667_/Q _11996_/S0 _11996_/S1 VDD
+ VSS sg13g2_mux4_1
X_15193__2773 _15193_/RESET_B VDD VSS sg13g2_tiehi
XFILLER_92_1346 VDD VSS sg13g2_fill_1
XFILLER_13_343 VDD VSS sg13g2_decap_8
X_13522_ _13522_/Y _13522_/A1 _13533_/B _14998_/Q _13546_/B2 VDD VSS sg13g2_a22oi_1
X_10734_ _14911_/D _10734_/A VDD VSS sg13g2_inv_1
XFILLER_158_326 VDD VSS sg13g2_decap_8
XFILLER_9_336 VDD VSS sg13g2_decap_8
XFILLER_16_1141 VDD VSS sg13g2_decap_8
X_13453_ _13454_/D _15186_/Q _15187_/Q _15188_/Q _15171_/Q VDD VSS sg13g2_nor4_1
X_10665_ _10667_/B _14893_/Q _10661_/C hold3169/X VDD VSS sg13g2_a21oi_1
XFILLER_107_1291 VDD VSS sg13g2_decap_4
X_12404_ _12404_/X _14111_/Q _14143_/Q _14175_/Q _14207_/Q _12606_/S0 _12606_/S1 VDD
+ VSS sg13g2_mux4_1
XFILLER_139_584 VDD VSS sg13g2_decap_8
XFILLER_173_329 VDD VSS sg13g2_decap_8
X_13384_ _13384_/Y _08723_/A _13307_/B _15081_/Q VDD VSS sg13g2_o21ai_1
X_10596_ _10599_/B _14875_/Q _10607_/C _14876_/Q VDD VSS sg13g2_a21oi_1
XFILLER_166_392 VDD VSS sg13g2_decap_8
XFILLER_127_757 VDD VSS sg13g2_fill_2
X_15123_ _15123_/Q clkload66/A _15123_/D _15123_/RESET_B VDD VSS sg13g2_dfrbpq_1
X_12335_ _12335_/Y _12315_/Y _12317_/X _12335_/B1 VDD VSS sg13g2_o21ai_1
XFILLER_86_1117 VDD VSS sg13g2_decap_8
XFILLER_31_70 VDD VSS sg13g2_decap_8
XFILLER_5_553 VDD VSS sg13g2_decap_8
XFILLER_114_407 VDD VSS sg13g2_decap_8
XFILLER_147_70 VDD VSS sg13g2_decap_4
X_13821__2358 _13821_/RESET_B VDD VSS sg13g2_tiehi
X_14581__1598 _14581_/RESET_B VDD VSS sg13g2_tiehi
X_15054_ _15054_/Q clkload69/A _15054_/D _15054_/RESET_B VDD VSS sg13g2_dfrbpq_1
XFILLER_173_1109 VDD VSS sg13g2_fill_2
X_12266_ _12266_/Y _12264_/Y _12265_/Y _12223_/A VDD VSS sg13g2_a21oi_1
XFILLER_141_226 VDD VSS sg13g2_decap_4
XFILLER_49_7 VDD VSS sg13g2_decap_8
X_14005_ _14005_/Q _14677_/CLK _14005_/D _14005_/RESET_B VDD VSS sg13g2_dfrbpq_1
X_11217_ _11217_/X _14555_/Q _14587_/Q _11217_/S VDD VSS sg13g2_mux2_1
XFILLER_96_803 VDD VSS sg13g2_decap_8
XFILLER_150_760 VDD VSS sg13g2_decap_8
Xoutput70 mem_axi_arvalid wire504/X VDD VSS sg13g2_buf_1
X_12197_ _12197_/Y _12197_/A _12197_/B _12198_/B _12198_/D VDD VSS sg13g2_nor4_1
XFILLER_110_602 VDD VSS sg13g2_decap_8
Xoutput81 mem_axi_awaddr[20] _16873_/X VDD VSS sg13g2_buf_1
Xoutput92 mem_axi_awaddr[30] _16883_/X VDD VSS sg13g2_buf_1
XFILLER_1_770 VDD VSS sg13g2_decap_8
X_11148_ _11150_/A _11125_/A _11147_/Y _11173_/B _11128_/A VDD VSS sg13g2_a22oi_1
XFILLER_95_324 VDD VSS sg13g2_decap_8
XFILLER_0_280 VDD VSS sg13g2_decap_8
XFILLER_163_91 VDD VSS sg13g2_decap_8
XFILLER_27_1292 VDD VSS sg13g2_decap_8
XFILLER_110_679 VDD VSS sg13g2_decap_4
X_11079_ _11079_/Y _11097_/A _11097_/C VDD VSS sg13g2_xnor2_1
XFILLER_3_1239 VDD VSS sg13g2_decap_8
XFILLER_37_936 VDD VSS sg13g2_decap_8
XFILLER_23_1167 VDD VSS sg13g2_decap_8
XFILLER_110_1126 VDD VSS sg13g2_fill_2
X_14907_ _14907_/Q clkload52/A _14907_/D _14907_/RESET_B VDD VSS sg13g2_dfrbpq_1
XFILLER_64_733 VDD VSS sg13g2_decap_8
XFILLER_48_284 VDD VSS sg13g2_decap_8
XFILLER_91_541 VDD VSS sg13g2_decap_8
X_14309__1870 _14309_/RESET_B VDD VSS sg13g2_tiehi
XFILLER_24_608 VDD VSS sg13g2_fill_2
X_14838_ _14838_/Q clkload50/A _14838_/D _14838_/RESET_B VDD VSS sg13g2_dfrbpq_1
X_14769_ _14769_/Q _14867_/CLK _14769_/D _14769_/RESET_B VDD VSS sg13g2_dfrbpq_1
XFILLER_17_693 VDD VSS sg13g2_decap_8
XFILLER_32_630 VDD VSS sg13g2_decap_8
XFILLER_108_1011 VDD VSS sg13g2_fill_2
XFILLER_147_1060 VDD VSS sg13g2_decap_8
XFILLER_32_641 VDD VSS sg13g2_fill_1
XFILLER_32_652 VDD VSS sg13g2_decap_8
X_08290_ _08290_/X _08286_/Y _08289_/Y _08290_/S VDD VSS sg13g2_mux2_1
XFILLER_20_847 VDD VSS sg13g2_decap_8
XFILLER_31_184 VDD VSS sg13g2_fill_1
XFILLER_108_1099 VDD VSS sg13g2_fill_1
XFILLER_158_860 VDD VSS sg13g2_decap_8
XFILLER_118_702 VDD VSS sg13g2_fill_2
XFILLER_121_1211 VDD VSS sg13g2_decap_8
XFILLER_160_1260 VDD VSS sg13g2_decap_8
XFILLER_118_713 VDD VSS sg13g2_decap_4
XFILLER_75_0 VDD VSS sg13g2_decap_8
XFILLER_164_329 VDD VSS sg13g2_decap_8
XFILLER_157_370 VDD VSS sg13g2_fill_2
XFILLER_30_1149 VDD VSS sg13g2_decap_8
XFILLER_69_1337 VDD VSS sg13g2_fill_1
XFILLER_121_1288 VDD VSS sg13g2_decap_4
XFILLER_173_874 VDD VSS sg13g2_decap_4
XFILLER_133_716 VDD VSS sg13g2_decap_4
XFILLER_145_587 VDD VSS sg13g2_decap_8
X_14411__1768 _14411_/RESET_B VDD VSS sg13g2_tiehi
Xclkbuf_leaf_114_clk_i _14310_/CLK clkbuf_5_6__f_clk_i/X VDD VSS sg13g2_buf_8
XFILLER_132_237 VDD VSS sg13g2_fill_2
XFILLER_28_1001 VDD VSS sg13g2_decap_8
X_15202__2970 _15202_/RESET_B VDD VSS sg13g2_tiehi
XFILLER_87_803 VDD VSS sg13g2_fill_2
XFILLER_114_974 VDD VSS sg13g2_fill_2
Xfanout304 _10954_/C _10965_/A VDD VSS sg13g2_buf_1
XFILLER_98_140 VDD VSS sg13g2_decap_8
XFILLER_8_1106 VDD VSS sg13g2_decap_8
XFILLER_154_1042 VDD VSS sg13g2_fill_2
Xfanout315 _09961_/S _09970_/S VDD VSS sg13g2_buf_1
XFILLER_87_814 VDD VSS sg13g2_decap_4
XFILLER_101_602 VDD VSS sg13g2_decap_4
Xfanout326 _09862_/S _09863_/S VDD VSS sg13g2_buf_1
XFILLER_113_473 VDD VSS sg13g2_fill_1
XFILLER_114_996 VDD VSS sg13g2_decap_8
XFILLER_115_1015 VDD VSS sg13g2_decap_8
XFILLER_141_782 VDD VSS sg13g2_decap_8
Xfanout337 _09730_/S _09737_/S VDD VSS sg13g2_buf_1
X_09813_ _14401_/D _09912_/A1 _14401_/Q _09837_/S VDD VSS sg13g2_mux2_1
XFILLER_141_793 VDD VSS sg13g2_fill_2
XFILLER_154_1075 VDD VSS sg13g2_decap_8
Xfanout348 _09632_/S _09638_/S VDD VSS sg13g2_buf_1
XFILLER_143_28 VDD VSS sg13g2_decap_8
XFILLER_86_324 VDD VSS sg13g2_decap_8
XFILLER_101_646 VDD VSS sg13g2_decap_4
Xfanout359 _09330_/S _09325_/S VDD VSS sg13g2_buf_1
XFILLER_100_134 VDD VSS sg13g2_decap_8
XFILLER_115_1059 VDD VSS sg13g2_fill_1
X_13976__2203 _13976_/RESET_B VDD VSS sg13g2_tiehi
X_09744_ _14334_/D _14334_/Q _09909_/A1 _09766_/S VDD VSS sg13g2_mux2_1
XFILLER_74_519 VDD VSS sg13g2_fill_1
XFILLER_39_262 VDD VSS sg13g2_decap_8
X_09675_ _14267_/D _09774_/A0 _14267_/Q _09700_/S VDD VSS sg13g2_mux2_1
XFILLER_41_1278 VDD VSS sg13g2_fill_1
XFILLER_27_435 VDD VSS sg13g2_decap_8
XFILLER_76_1308 VDD VSS sg13g2_fill_1
X_08626_ _08633_/B _08688_/C _08616_/Y _08625_/Y VDD VSS sg13g2_a21oi_1
XFILLER_55_777 VDD VSS sg13g2_decap_8
XFILLER_54_265 VDD VSS sg13g2_decap_8
XFILLER_42_405 VDD VSS sg13g2_fill_1
XFILLER_54_276 VDD VSS sg13g2_decap_8
XFILLER_42_427 VDD VSS sg13g2_decap_8
XFILLER_74_1010 VDD VSS sg13g2_decap_8
X_08557_ _08557_/Y _08625_/A _08237_/Y _08397_/Y VDD VSS sg13g2_o21ai_1
XFILLER_153_7 VDD VSS sg13g2_decap_8
XFILLER_168_602 VDD VSS sg13g2_decap_8
XFILLER_52_14 VDD VSS sg13g2_decap_8
XFILLER_39_1185 VDD VSS sg13g2_fill_1
XFILLER_22_140 VDD VSS sg13g2_decap_8
XFILLER_167_112 VDD VSS sg13g2_decap_8
XFILLER_168_14 VDD VSS sg13g2_decap_8
X_08488_ _08488_/Y _08511_/S _08488_/B VDD VSS sg13g2_nand2_1
XFILLER_23_685 VDD VSS sg13g2_fill_1
XFILLER_126_1166 VDD VSS sg13g2_decap_8
XFILLER_11_847 VDD VSS sg13g2_decap_8
XFILLER_52_1341 VDD VSS sg13g2_decap_8
XFILLER_10_357 VDD VSS sg13g2_decap_8
XFILLER_52_1374 VDD VSS sg13g2_decap_8
XFILLER_167_189 VDD VSS sg13g2_decap_8
X_10450_ _14839_/D _10633_/A _10450_/B _10450_/C VDD VSS sg13g2_nor3_1
XFILLER_13_1358 VDD VSS sg13g2_decap_8
XFILLER_148_392 VDD VSS sg13g2_fill_2
XFILLER_100_1317 VDD VSS sg13g2_decap_8
X_09109_ _09109_/Y _10760_/A _09150_/B _09111_/A1 VDD VSS sg13g2_o21ai_1
XFILLER_164_863 VDD VSS sg13g2_decap_8
X_10381_ _10381_/Y _14818_/Q _10379_/A _10630_/C VDD VSS sg13g2_o21ai_1
XFILLER_108_278 VDD VSS sg13g2_decap_8
X_12120_ _12120_/Y _12115_/X _12332_/B1 _12334_/C VDD VSS sg13g2_a21oi_1
XFILLER_11_1071 VDD VSS sg13g2_decap_8
XFILLER_123_237 VDD VSS sg13g2_decap_8
X_12051_ _12051_/Y _12123_/A1 _12050_/Y _12082_/B VDD VSS sg13g2_o21ai_1
XFILLER_2_567 VDD VSS sg13g2_decap_8
XFILLER_105_985 VDD VSS sg13g2_fill_2
XFILLER_133_1104 VDD VSS sg13g2_decap_8
X_11002_ _11022_/A _11042_/D _15117_/Q VDD VSS sg13g2_nand2_1
XFILLER_81_1036 VDD VSS sg13g2_decap_8
XFILLER_78_836 VDD VSS sg13g2_decap_8
XFILLER_120_933 VDD VSS sg13g2_decap_8
XFILLER_133_1115 VDD VSS sg13g2_fill_2
XFILLER_77_324 VDD VSS sg13g2_decap_8
Xfanout860 fanout860/X fanout864/X VDD VSS sg13g2_buf_1
Xfanout871 _12352_/S0 _12618_/S0 VDD VSS sg13g2_buf_1
X_14566__1613 _14566_/RESET_B VDD VSS sg13g2_tiehi
Xfanout882 _12727_/S0 _12731_/S0 VDD VSS sg13g2_buf_1
XFILLER_19_903 VDD VSS sg13g2_decap_8
Xfanout893 _12437_/S0 fanout894/X VDD VSS sg13g2_buf_1
XFILLER_133_61 VDD VSS sg13g2_fill_1
XFILLER_58_571 VDD VSS sg13g2_decap_8
XFILLER_18_413 VDD VSS sg13g2_decap_8
X_12953_ _12953_/Y _12951_/Y _12952_/Y _12933_/Y VDD VSS sg13g2_o21ai_1
XFILLER_93_21 VDD VSS sg13g2_decap_8
Xclkbuf_leaf_93_clk_i clkload45/A clkbuf_leaf_97_clk_i/A VDD VSS sg13g2_buf_8
X_11904_ _11904_/X _14913_/Q _11904_/A2 _11903_/Y VDD VSS sg13g2_a21o_1
XFILLER_45_254 VDD VSS sg13g2_fill_2
X_12884_ _12884_/Y _12900_/B input17/X _12884_/C VDD VSS sg13g2_nand3_1
XFILLER_73_574 VDD VSS sg13g2_decap_8
XFILLER_33_405 VDD VSS sg13g2_decap_8
X_14623_ _14623_/Q _14733_/CLK _14623_/D _14623_/RESET_B VDD VSS sg13g2_dfrbpq_1
XFILLER_60_213 VDD VSS sg13g2_decap_8
XFILLER_27_991 VDD VSS sg13g2_decap_8
X_11835_ _11835_/Y _11833_/Y _11834_/Y _11236_/C VDD VSS sg13g2_a21oi_1
XFILLER_57_1230 VDD VSS sg13g2_decap_8
XFILLER_26_70 VDD VSS sg13g2_decap_8
XFILLER_14_630 VDD VSS sg13g2_decap_8
X_14554_ _14554_/Q _14682_/CLK _14554_/D _14554_/RESET_B VDD VSS sg13g2_dfrbpq_1
XFILLER_18_1225 VDD VSS sg13g2_decap_8
XFILLER_109_1353 VDD VSS sg13g2_fill_2
XFILLER_13_140 VDD VSS sg13g2_decap_8
X_11766_ _11766_/Y _11765_/Y _11755_/Y _11747_/Y _11737_/Y _12001_/A VDD VSS sg13g2_a221oi_1
XFILLER_158_112 VDD VSS sg13g2_decap_8
XFILLER_41_460 VDD VSS sg13g2_fill_2
XFILLER_144_1255 VDD VSS sg13g2_decap_4
XFILLER_53_1138 VDD VSS sg13g2_fill_1
XFILLER_159_657 VDD VSS sg13g2_decap_4
X_13505_ _15130_/D _15130_/Q _13655_/S _13504_/Y VDD VSS sg13g2_a21o_1
XFILLER_92_1198 VDD VSS sg13g2_decap_8
XFILLER_41_482 VDD VSS sg13g2_fill_1
XFILLER_159_668 VDD VSS sg13g2_fill_2
X_10717_ _10965_/A _14938_/Q _10725_/A _10716_/Y VDD VSS sg13g2_a21oi_1
X_14485_ _14485_/Q clkload18/A _14485_/D _14485_/RESET_B VDD VSS sg13g2_dfrbpq_1
XFILLER_9_133 VDD VSS sg13g2_decap_8
XFILLER_174_605 VDD VSS sg13g2_decap_8
XFILLER_105_1239 VDD VSS sg13g2_decap_8
X_11697_ _11698_/A _11694_/Y _11696_/Y _11747_/A VDD VSS sg13g2_a21oi_1
XFILLER_158_189 VDD VSS sg13g2_fill_2
X_13436_ _15100_/D _15100_/Q _13353_/Y _13435_/Y VDD VSS sg13g2_a21o_1
X_10648_ _10653_/C _14884_/Q _14883_/Q _14880_/Q _14879_/Q VDD VSS sg13g2_and4_1
XFILLER_173_126 VDD VSS sg13g2_decap_8
XFILLER_155_863 VDD VSS sg13g2_fill_2
XFILLER_158_91 VDD VSS sg13g2_decap_8
Xclkbuf_leaf_31_clk_i _14505_/CLK clkbuf_leaf_36_clk_i/A VDD VSS sg13g2_buf_8
XFILLER_6_840 VDD VSS sg13g2_decap_8
X_13367_ _13367_/Y _13429_/A _13438_/D VDD VSS sg13g2_nand2_1
XFILLER_127_565 VDD VSS sg13g2_decap_4
X_10579_ _10580_/A _14871_/Q _10579_/B _10579_/C _10583_/D VDD VSS sg13g2_and4_1
XFILLER_154_362 VDD VSS sg13g2_decap_8
XFILLER_155_885 VDD VSS sg13g2_decap_8
X_15106_ _15106_/Q clkload63/A _15106_/D _15106_/RESET_B VDD VSS sg13g2_dfrbpq_1
XFILLER_5_350 VDD VSS sg13g2_decap_8
X_12318_ _12318_/Y _12321_/A1 _14394_/Q VDD VSS sg13g2_nand2b_1
XFILLER_154_395 VDD VSS sg13g2_decap_8
X_13298_ _13298_/X _13506_/A _13298_/B VDD VSS sg13g2_and2_1
XFILLER_29_1310 VDD VSS sg13g2_decap_8
XFILLER_170_866 VDD VSS sg13g2_decap_8
X_15037_ _15037_/Q clkload50/A _15037_/D _15037_/RESET_B VDD VSS sg13g2_dfrbpq_1
X_12249_ _12249_/Y _12250_/A1 _14488_/Q VDD VSS sg13g2_nand2b_1
XFILLER_111_911 VDD VSS sg13g2_decap_8
XFILLER_155_1362 VDD VSS sg13g2_fill_2
XFILLER_174_90 VDD VSS sg13g2_decap_8
Xclkbuf_leaf_46_clk_i _15015_/CLK clkbuf_leaf_47_clk_i/A VDD VSS sg13g2_buf_8
XFILLER_69_847 VDD VSS sg13g2_fill_1
XFILLER_25_1218 VDD VSS sg13g2_decap_8
XFILLER_69_858 VDD VSS sg13g2_fill_1
XFILLER_3_63 VDD VSS sg13g2_decap_8
XFILLER_96_666 VDD VSS sg13g2_decap_8
X_07790_ _08412_/A _07790_/A _15003_/Q VDD VSS sg13g2_nand2_1
XFILLER_7_1183 VDD VSS sg13g2_decap_8
XFILLER_37_722 VDD VSS sg13g2_decap_8
XFILLER_3_1036 VDD VSS sg13g2_decap_8
XFILLER_36_232 VDD VSS sg13g2_fill_1
XFILLER_25_906 VDD VSS sg13g2_decap_8
X_09460_ _14061_/D _09625_/A0 _14061_/Q _09464_/S VDD VSS sg13g2_mux2_1
XFILLER_37_799 VDD VSS sg13g2_decap_8
XFILLER_18_980 VDD VSS sg13g2_decap_8
X_08411_ _08411_/Y _08411_/A _08414_/C _08411_/C VDD VSS sg13g2_nor3_1
XFILLER_64_596 VDD VSS sg13g2_decap_8
XFILLER_52_736 VDD VSS sg13g2_decap_4
XFILLER_145_1008 VDD VSS sg13g2_fill_2
X_09391_ _13994_/D _09622_/A0 _13994_/Q _09401_/S VDD VSS sg13g2_mux2_1
XFILLER_17_490 VDD VSS sg13g2_decap_8
XFILLER_51_246 VDD VSS sg13g2_decap_8
X_08342_ _08346_/A _11661_/A _15002_/Q _08674_/B1 VDD VSS sg13g2_o21ai_1
XFILLER_75_1374 VDD VSS sg13g2_fill_2
XFILLER_162_1344 VDD VSS sg13g2_decap_8
XFILLER_71_1238 VDD VSS sg13g2_decap_8
XFILLER_36_1358 VDD VSS sg13g2_decap_8
XFILLER_32_471 VDD VSS sg13g2_decap_8
X_08273_ _08273_/Y _08603_/B VDD VSS sg13g2_inv_1
X_14911__2722 _14911_/RESET_B VDD VSS sg13g2_tiehi
XFILLER_20_644 VDD VSS sg13g2_decap_8
XFILLER_165_616 VDD VSS sg13g2_fill_1
XFILLER_22_28 VDD VSS sg13g2_decap_8
X_13693__2486 _13693_/RESET_B VDD VSS sg13g2_tiehi
XFILLER_165_649 VDD VSS sg13g2_decap_8
XFILLER_138_28 VDD VSS sg13g2_decap_8
XFILLER_164_126 VDD VSS sg13g2_decap_8
XFILLER_146_841 VDD VSS sg13g2_decap_8
XFILLER_69_1112 VDD VSS sg13g2_decap_4
X_14644__1535 _14644_/RESET_B VDD VSS sg13g2_tiehi
XFILLER_121_1085 VDD VSS sg13g2_decap_8
X_14944__2656 _14944_/RESET_B VDD VSS sg13g2_tiehi
XFILLER_133_557 VDD VSS sg13g2_decap_8
XFILLER_69_1189 VDD VSS sg13g2_decap_8
XFILLER_160_365 VDD VSS sg13g2_decap_8
XFILLER_102_911 VDD VSS sg13g2_decap_8
XFILLER_154_49 VDD VSS sg13g2_decap_8
XFILLER_114_782 VDD VSS sg13g2_decap_4
XFILLER_99_493 VDD VSS sg13g2_decap_4
XFILLER_59_324 VDD VSS sg13g2_decap_8
Xfanout145 _10169_/A1 _09166_/Y VDD VSS sg13g2_buf_1
Xfanout156 _09902_/A0 _09152_/Y VDD VSS sg13g2_buf_1
Xfanout167 _10031_/A0 _10097_/A0 VDD VSS sg13g2_buf_1
XFILLER_47_14 VDD VSS sg13g2_decap_8
XFILLER_86_143 VDD VSS sg13g2_decap_8
Xfanout178 _09666_/A0 fanout182/X VDD VSS sg13g2_buf_1
X_15012__2575 _15012_/RESET_B VDD VSS sg13g2_tiehi
Xfanout189 _09928_/A1 fanout191/X VDD VSS sg13g2_buf_1
X_07988_ _07988_/Y _13312_/A _11243_/C _13320_/C _07988_/D VDD VSS sg13g2_nor4_1
XFILLER_28_722 VDD VSS sg13g2_fill_2
X_09727_ _14318_/D _09760_/A1 _14318_/Q _09733_/S VDD VSS sg13g2_mux2_1
XFILLER_27_210 VDD VSS sg13g2_decap_8
XFILLER_132_1181 VDD VSS sg13g2_fill_2
XFILLER_28_766 VDD VSS sg13g2_decap_4
XFILLER_16_917 VDD VSS sg13g2_decap_8
X_09658_ _14251_/D _09889_/A0 _14251_/Q _09664_/S VDD VSS sg13g2_mux2_1
XFILLER_83_872 VDD VSS sg13g2_fill_2
X_15122__2715 _15122_/RESET_B VDD VSS sg13g2_tiehi
XFILLER_167_1244 VDD VSS sg13g2_fill_1
XFILLER_43_725 VDD VSS sg13g2_decap_8
XFILLER_128_1206 VDD VSS sg13g2_decap_8
XFILLER_15_427 VDD VSS sg13g2_decap_8
X_08609_ _08643_/A _07857_/X _08608_/B _07858_/X VDD VSS sg13g2_a21o_1
XFILLER_63_35 VDD VSS sg13g2_decap_8
X_09589_ _14186_/D _14186_/Q _09622_/A0 _09599_/S VDD VSS sg13g2_mux2_1
XFILLER_70_544 VDD VSS sg13g2_fill_1
XFILLER_128_1239 VDD VSS sg13g2_fill_2
XFILLER_63_57 VDD VSS sg13g2_fill_1
X_11620_ _11620_/Y _11616_/Y _11617_/Y _11619_/Y _11618_/Y _11763_/B VDD VSS sg13g2_a221oi_1
X_11551_ _11551_/Y _11649_/S0 _13860_/Q _12138_/S1 VDD VSS sg13g2_a21oi_1
XFILLER_11_644 VDD VSS sg13g2_decap_8
XFILLER_168_476 VDD VSS sg13g2_decap_8
Xwire513 wire513/X wire513/A VDD VSS sg13g2_buf_2
X_10502_ _10505_/C _10502_/A _10502_/B _10502_/C VDD VSS sg13g2_nor3_1
XFILLER_10_154 VDD VSS sg13g2_decap_8
X_14270_ _14270_/Q _14686_/CLK _14270_/D _14270_/RESET_B VDD VSS sg13g2_dfrbpq_1
XFILLER_52_1160 VDD VSS sg13g2_decap_4
XFILLER_155_126 VDD VSS sg13g2_decap_8
X_14283__1896 _14283_/RESET_B VDD VSS sg13g2_tiehi
X_11482_ _11777_/A _11483_/A _13686_/Q VDD VSS sg13g2_nor2_1
XFILLER_7_637 VDD VSS sg13g2_decap_8
XFILLER_109_532 VDD VSS sg13g2_decap_8
X_13221_ _13221_/Y _13218_/Y _13219_/Y _13220_/Y VDD VSS sg13g2_a21oi_1
XFILLER_104_1272 VDD VSS sg13g2_decap_8
XFILLER_137_863 VDD VSS sg13g2_fill_1
XFILLER_13_1155 VDD VSS sg13g2_decap_8
X_10433_ _10435_/B _14833_/Q _10434_/C _14834_/Q VDD VSS sg13g2_a21oi_1
XFILLER_6_147 VDD VSS sg13g2_decap_8
XFILLER_136_362 VDD VSS sg13g2_fill_2
X_13152_ _13152_/Y _14789_/Q _13152_/A2 _13208_/B1 VDD VSS sg13g2_o21ai_1
X_10364_ _10365_/B _14812_/Q _14813_/Q _10364_/C VDD VSS sg13g2_nand3_1
XFILLER_88_21 VDD VSS sg13g2_decap_8
XFILLER_88_32 VDD VSS sg13g2_fill_1
X_12103_ _12103_/Y _12252_/S0 _14420_/Q _12312_/B1 VDD VSS sg13g2_a21oi_1
XFILLER_3_854 VDD VSS sg13g2_decap_8
XFILLER_5_0 VDD VSS sg13g2_decap_8
XFILLER_174_1248 VDD VSS sg13g2_fill_1
X_13083_ _13085_/B _14816_/Q _13068_/B _13162_/B1 _14880_/Q VDD VSS sg13g2_a22oi_1
X_10295_ _14792_/D _10295_/A _10295_/B _10295_/C VDD VSS sg13g2_and3_1
XFILLER_88_87 VDD VSS sg13g2_fill_2
XFILLER_2_364 VDD VSS sg13g2_decap_8
X_12034_ _12034_/Y _12030_/Y _12031_/Y _12033_/Y _12032_/Y _12239_/B VDD VSS sg13g2_a221oi_1
XFILLER_78_644 VDD VSS sg13g2_decap_8
XFILLER_120_741 VDD VSS sg13g2_decap_8
XFILLER_144_82 VDD VSS sg13g2_fill_1
XFILLER_19_700 VDD VSS sg13g2_decap_8
Xfanout690 _11975_/A _12335_/B1 VDD VSS sg13g2_buf_1
XFILLER_4_1323 VDD VSS sg13g2_decap_8
XFILLER_18_210 VDD VSS sg13g2_decap_8
X_13985_ _13985_/Q _14649_/CLK _13985_/D _13985_/RESET_B VDD VSS sg13g2_dfrbpq_1
XFILLER_93_658 VDD VSS sg13g2_decap_8
XFILLER_98_1341 VDD VSS sg13g2_decap_8
XFILLER_24_1295 VDD VSS sg13g2_decap_8
X_12936_ _12936_/Y _13601_/B _12936_/B VDD VSS sg13g2_nand2b_1
XFILLER_46_563 VDD VSS sg13g2_fill_2
XFILLER_20_1148 VDD VSS sg13g2_decap_8
XFILLER_19_777 VDD VSS sg13g2_decap_8
XFILLER_94_1216 VDD VSS sg13g2_decap_8
XFILLER_92_179 VDD VSS sg13g2_decap_8
XFILLER_37_91 VDD VSS sg13g2_decap_8
XFILLER_111_1287 VDD VSS sg13g2_decap_8
XFILLER_160_70 VDD VSS sg13g2_decap_8
XFILLER_94_1227 VDD VSS sg13g2_fill_1
XFILLER_61_511 VDD VSS sg13g2_decap_8
XFILLER_18_287 VDD VSS sg13g2_decap_8
XFILLER_59_1369 VDD VSS sg13g2_decap_8
X_12867_ _12867_/Y _12900_/B input16/X _12867_/C VDD VSS sg13g2_nand3_1
X_14722__1457 _14722_/RESET_B VDD VSS sg13g2_tiehi
XFILLER_61_544 VDD VSS sg13g2_decap_8
XFILLER_33_235 VDD VSS sg13g2_fill_1
XFILLER_33_246 VDD VSS sg13g2_decap_8
X_14606_ _14606_/Q clkload39/A _14606_/D _14606_/RESET_B VDD VSS sg13g2_dfrbpq_1
X_11818_ _11818_/Y _11821_/S0 _14476_/Q VDD VSS sg13g2_nand2b_1
XFILLER_61_588 VDD VSS sg13g2_decap_4
XFILLER_18_1022 VDD VSS sg13g2_decap_8
X_12798_ _12798_/Y _13602_/A _12801_/B _13567_/A2 VDD VSS sg13g2_o21ai_1
XFILLER_57_1082 VDD VSS sg13g2_decap_8
XFILLER_15_994 VDD VSS sg13g2_decap_8
XFILLER_144_1052 VDD VSS sg13g2_decap_8
X_14537_ _14537_/Q clkload20/A _14537_/D _14537_/RESET_B VDD VSS sg13g2_dfrbpq_1
X_11749_ _11749_/Y _11749_/A1 _14410_/Q _11897_/C VDD VSS sg13g2_a21oi_1
XFILLER_31_1211 VDD VSS sg13g2_decap_8
XFILLER_18_1099 VDD VSS sg13g2_decap_8
X_14468_ _14468_/Q _14672_/CLK _14468_/D _14468_/RESET_B VDD VSS sg13g2_dfrbpq_1
XFILLER_146_137 VDD VSS sg13g2_decap_4
XFILLER_122_1361 VDD VSS sg13g2_decap_8
X_13419_ _13419_/Y _08723_/A _13493_/A2 _15094_/Q VDD VSS sg13g2_o21ai_1
XFILLER_174_468 VDD VSS sg13g2_decap_8
XFILLER_174_479 VDD VSS sg13g2_decap_8
XFILLER_143_800 VDD VSS sg13g2_fill_1
X_14399_ _14399_/Q clkload14/A _14399_/D _14399_/RESET_B VDD VSS sg13g2_dfrbpq_1
XFILLER_115_513 VDD VSS sg13g2_decap_8
XFILLER_31_1288 VDD VSS sg13g2_decap_8
XFILLER_154_192 VDD VSS sg13g2_decap_8
X_08960_ _09441_/C _09204_/C _09204_/D VDD VSS sg13g2_nor2_1
XFILLER_88_419 VDD VSS sg13g2_fill_1
XFILLER_69_611 VDD VSS sg13g2_fill_1
X_07911_ _07911_/Y _07911_/A _07912_/B VDD VSS sg13g2_nor2b_1
XFILLER_38_0 VDD VSS sg13g2_decap_8
XFILLER_151_1001 VDD VSS sg13g2_decap_8
XFILLER_97_942 VDD VSS sg13g2_decap_4
XFILLER_25_1004 VDD VSS sg13g2_fill_2
X_08891_ _08891_/X _08890_/X _11726_/A _08891_/S VDD VSS sg13g2_mux2_1
XFILLER_69_644 VDD VSS sg13g2_decap_4
XFILLER_29_1184 VDD VSS sg13g2_decap_8
XFILLER_9_1267 VDD VSS sg13g2_decap_8
XFILLER_116_1165 VDD VSS sg13g2_decap_8
X_07842_ _08678_/A _08654_/A _07841_/Y VDD VSS sg13g2_nor2b_1
XFILLER_99_1105 VDD VSS sg13g2_decap_8
XFILLER_29_519 VDD VSS sg13g2_decap_8
XFILLER_112_1029 VDD VSS sg13g2_decap_8
XFILLER_83_113 VDD VSS sg13g2_decap_8
XFILLER_42_1362 VDD VSS sg13g2_decap_8
X_14058__2121 _14058_/RESET_B VDD VSS sg13g2_tiehi
X_07773_ _07773_/Y _08306_/B _07775_/A VDD VSS sg13g2_nor2b_1
XFILLER_84_669 VDD VSS sg13g2_decap_8
XFILLER_17_28 VDD VSS sg13g2_decap_8
X_09512_ _14111_/D _09611_/A0 _14111_/Q _09530_/S VDD VSS sg13g2_mux2_1
XFILLER_37_552 VDD VSS sg13g2_decap_8
XFILLER_64_371 VDD VSS sg13g2_decap_8
XFILLER_37_596 VDD VSS sg13g2_decap_8
X_15195__2765 _15195_/RESET_B VDD VSS sg13g2_tiehi
X_09443_ _14044_/D _09608_/A0 _14044_/Q _09467_/S VDD VSS sg13g2_mux2_1
XFILLER_24_224 VDD VSS sg13g2_decap_8
X_09374_ _13978_/D _09970_/A1 _13978_/Q _09374_/S VDD VSS sg13g2_mux2_1
XFILLER_75_1182 VDD VSS sg13g2_decap_8
XFILLER_21_931 VDD VSS sg13g2_decap_8
X_08325_ _08325_/Y _08414_/A _08654_/B VDD VSS sg13g2_nor2_1
XFILLER_33_49 VDD VSS sg13g2_decap_8
X_14806__2907 _14806_/RESET_B VDD VSS sg13g2_tiehi
XFILLER_166_914 VDD VSS sg13g2_decap_4
XFILLER_127_1294 VDD VSS sg13g2_decap_8
XFILLER_149_49 VDD VSS sg13g2_decap_8
XFILLER_36_1177 VDD VSS sg13g2_decap_8
XFILLER_20_441 VDD VSS sg13g2_decap_8
XFILLER_165_413 VDD VSS sg13g2_decap_8
XFILLER_36_1199 VDD VSS sg13g2_decap_8
XFILLER_166_958 VDD VSS sg13g2_decap_8
X_08256_ _08256_/Y _08256_/A _08329_/B VDD VSS sg13g2_nand2_1
XFILLER_123_1158 VDD VSS sg13g2_decap_8
XFILLER_153_619 VDD VSS sg13g2_decap_8
X_15151__2655 _15151_/RESET_B VDD VSS sg13g2_tiehi
X_08187_ _15223_/D _08187_/A _08187_/B _08187_/C VDD VSS sg13g2_nand3_1
XFILLER_116_7 VDD VSS sg13g2_decap_8
X_14160__2019 _14160_/RESET_B VDD VSS sg13g2_tiehi
XFILLER_174_991 VDD VSS sg13g2_fill_1
XFILLER_146_693 VDD VSS sg13g2_decap_8
XFILLER_152_129 VDD VSS sg13g2_decap_8
XFILLER_160_140 VDD VSS sg13g2_decap_8
XFILLER_161_663 VDD VSS sg13g2_fill_1
XFILLER_79_408 VDD VSS sg13g2_fill_1
XFILLER_79_419 VDD VSS sg13g2_decap_8
XFILLER_134_899 VDD VSS sg13g2_decap_8
X_14268__1911 _14268_/RESET_B VDD VSS sg13g2_tiehi
XFILLER_0_835 VDD VSS sg13g2_decap_8
XFILLER_133_398 VDD VSS sg13g2_decap_8
XFILLER_58_35 VDD VSS sg13g2_decap_8
X_10080_ _14660_/D _10080_/A0 _14660_/Q _10098_/S VDD VSS sg13g2_mux2_1
XFILLER_82_1153 VDD VSS sg13g2_decap_8
XFILLER_43_1104 VDD VSS sg13g2_decap_8
XFILLER_99_290 VDD VSS sg13g2_decap_8
XFILLER_88_953 VDD VSS sg13g2_decap_8
XFILLER_173_1281 VDD VSS sg13g2_decap_8
XFILLER_43_1137 VDD VSS sg13g2_decap_8
XFILLER_87_474 VDD VSS sg13g2_decap_8
XFILLER_43_1159 VDD VSS sg13g2_decap_8
XFILLER_48_839 VDD VSS sg13g2_fill_1
XFILLER_59_187 VDD VSS sg13g2_decap_8
XFILLER_47_327 VDD VSS sg13g2_fill_2
XFILLER_114_52 VDD VSS sg13g2_decap_8
XFILLER_130_1129 VDD VSS sg13g2_decap_4
XFILLER_74_113 VDD VSS sg13g2_fill_1
XFILLER_59_198 VDD VSS sg13g2_fill_1
XFILLER_28_541 VDD VSS sg13g2_decap_8
X_13770_ _13770_/Q _14730_/CLK _13770_/D _13770_/RESET_B VDD VSS sg13g2_dfrbpq_1
XFILLER_16_714 VDD VSS sg13g2_decap_8
X_10982_ _10982_/X _10995_/A _11042_/A VDD VSS sg13g2_xor2_1
XFILLER_90_628 VDD VSS sg13g2_decap_8
XFILLER_55_360 VDD VSS sg13g2_decap_8
X_12721_ _12722_/B _13667_/Q _12721_/A2 _12720_/X _12721_/B2 _12763_/C1 VDD VSS sg13g2_a221oi_1
XFILLER_15_224 VDD VSS sg13g2_decap_8
XFILLER_55_393 VDD VSS sg13g2_decap_8
XFILLER_70_330 VDD VSS sg13g2_decap_8
XFILLER_82_190 VDD VSS sg13g2_decap_8
XFILLER_70_341 VDD VSS sg13g2_fill_2
X_12652_ _15010_/D _12652_/A _12652_/B VDD VSS sg13g2_nor2_1
XFILLER_43_577 VDD VSS sg13g2_decap_8
XFILLER_12_931 VDD VSS sg13g2_decap_8
XFILLER_142_0 VDD VSS sg13g2_decap_8
XFILLER_169_752 VDD VSS sg13g2_decap_8
X_14370__1809 _14370_/RESET_B VDD VSS sg13g2_tiehi
X_11603_ _11603_/Y _11993_/S0 _14598_/Q _11996_/S1 VDD VSS sg13g2_a21oi_1
X_13756__2423 _13756_/RESET_B VDD VSS sg13g2_tiehi
XFILLER_54_1255 VDD VSS sg13g2_decap_8
X_12583_ _15005_/D _12583_/A _12583_/B VDD VSS sg13g2_nor2_1
XFILLER_11_441 VDD VSS sg13g2_decap_8
XFILLER_106_1356 VDD VSS sg13g2_decap_4
XFILLER_15_1239 VDD VSS sg13g2_decap_8
XFILLER_168_273 VDD VSS sg13g2_decap_8
X_14322_ _14322_/Q _14632_/CLK _14322_/D _14322_/RESET_B VDD VSS sg13g2_dfrbpq_1
XFILLER_90_99 VDD VSS sg13g2_decap_8
XFILLER_8_924 VDD VSS sg13g2_decap_8
X_11534_ _11535_/A _13956_/Q _13988_/Q _14020_/Q _14052_/Q _11649_/S0 _11651_/S1 VDD
+ VSS sg13g2_mux4_1
XFILLER_7_434 VDD VSS sg13g2_decap_8
XFILLER_144_608 VDD VSS sg13g2_decap_8
X_14253_ _14253_/Q clkload4/A _14253_/D _14253_/RESET_B VDD VSS sg13g2_dfrbpq_1
X_11465_ _11465_/Y _11463_/Y _11465_/B VDD VSS sg13g2_nand2b_1
XFILLER_125_822 VDD VSS sg13g2_fill_1
X_13204_ _13204_/Y _13224_/A _13204_/B VDD VSS sg13g2_xnor2_1
Xwire398 wire398/X wire398/A VDD VSS sg13g2_buf_4
X_10416_ _10416_/Y _14828_/Q _10415_/A _10423_/C VDD VSS sg13g2_o21ai_1
X_14136__2043 _14136_/RESET_B VDD VSS sg13g2_tiehi
X_14184_ _14184_/Q _14310_/CLK _14184_/D _14184_/RESET_B VDD VSS sg13g2_dfrbpq_1
XFILLER_164_490 VDD VSS sg13g2_decap_8
X_11396_ _11396_/Y _11392_/Y _11393_/X _11395_/Y VDD VSS sg13g2_o21ai_1
XFILLER_152_652 VDD VSS sg13g2_fill_2
XFILLER_174_1023 VDD VSS sg13g2_fill_1
X_13135_ _13135_/Y _13170_/B _13131_/Y _13134_/Y VDD VSS sg13g2_a21oi_1
X_10347_ _14808_/D _10352_/C _10599_/A _10347_/C VDD VSS sg13g2_nor3_1
XFILLER_3_651 VDD VSS sg13g2_decap_8
XFILLER_48_1059 VDD VSS sg13g2_fill_1
XFILLER_151_162 VDD VSS sg13g2_fill_2
XFILLER_124_387 VDD VSS sg13g2_decap_8
XFILLER_155_70 VDD VSS sg13g2_decap_8
XFILLER_2_161 VDD VSS sg13g2_decap_8
X_13066_ _13066_/Y _13066_/A _13172_/A _13066_/C VDD VSS sg13g2_nor3_1
X_14748__1430 _14748_/RESET_B VDD VSS sg13g2_tiehi
XFILLER_31_7 VDD VSS sg13g2_decap_8
X_10278_ _10311_/A _14784_/Q _14785_/Q _10278_/C _10305_/B VDD VSS sg13g2_and4_1
XFILLER_79_964 VDD VSS sg13g2_decap_4
X_12017_ _12018_/B _12017_/A _13938_/Q VDD VSS sg13g2_nand2_1
XFILLER_26_1357 VDD VSS sg13g2_decap_8
XFILLER_78_474 VDD VSS sg13g2_decap_8
XFILLER_113_1327 VDD VSS sg13g2_fill_1
XFILLER_78_485 VDD VSS sg13g2_fill_2
XFILLER_113_1338 VDD VSS sg13g2_decap_8
XFILLER_4_1120 VDD VSS sg13g2_decap_8
XFILLER_93_444 VDD VSS sg13g2_fill_1
XFILLER_38_349 VDD VSS sg13g2_fill_1
XFILLER_65_146 VDD VSS sg13g2_decap_4
XFILLER_47_850 VDD VSS sg13g2_decap_8
XFILLER_24_1092 VDD VSS sg13g2_decap_8
XFILLER_171_91 VDD VSS sg13g2_decap_8
XFILLER_0_42 VDD VSS sg13g2_decap_8
XFILLER_98_1160 VDD VSS sg13g2_decap_4
XFILLER_80_105 VDD VSS sg13g2_decap_4
XFILLER_19_574 VDD VSS sg13g2_decap_8
XFILLER_0_1017 VDD VSS sg13g2_decap_8
XFILLER_111_1062 VDD VSS sg13g2_fill_1
X_13968_ _13968_/Q clkload7/A _13968_/D _13968_/RESET_B VDD VSS sg13g2_dfrbpq_1
XFILLER_94_1002 VDD VSS sg13g2_fill_2
XFILLER_4_1197 VDD VSS sg13g2_decap_8
X_12919_ _12919_/Y _12916_/Y _12917_/Y _12918_/Y VDD VSS sg13g2_a21oi_1
XFILLER_146_1114 VDD VSS sg13g2_fill_2
X_13899_ _13899_/Q clkload2/A _13899_/D _13899_/RESET_B VDD VSS sg13g2_dfrbpq_1
XFILLER_59_1166 VDD VSS sg13g2_decap_8
XFILLER_62_886 VDD VSS sg13g2_fill_2
XFILLER_61_363 VDD VSS sg13g2_decap_4
XFILLER_15_791 VDD VSS sg13g2_decap_8
XFILLER_72_1333 VDD VSS sg13g2_decap_8
XFILLER_21_238 VDD VSS sg13g2_decap_8
X_14346__1833 _14346_/RESET_B VDD VSS sg13g2_tiehi
XFILLER_72_1366 VDD VSS sg13g2_decap_8
XFILLER_159_273 VDD VSS sg13g2_decap_8
X_08110_ _08112_/B _08452_/A _08138_/B _08110_/C _08110_/D VDD VSS sg13g2_nand4_1
XFILLER_9_84 VDD VSS sg13g2_decap_8
X_09090_ _09090_/Y _09090_/A _09090_/B _09090_/C VDD VSS sg13g2_nand3_1
XFILLER_148_969 VDD VSS sg13g2_decap_8
XFILLER_30_794 VDD VSS sg13g2_fill_2
XFILLER_119_148 VDD VSS sg13g2_fill_1
XFILLER_135_608 VDD VSS sg13g2_decap_8
X_08041_ _15218_/D _08003_/Y _08040_/Y _08002_/Y VDD VSS sg13g2_a21oi_1
XFILLER_116_811 VDD VSS sg13g2_fill_1
XFILLER_115_321 VDD VSS sg13g2_decap_8
XFILLER_66_1126 VDD VSS sg13g2_decap_8
XFILLER_157_1243 VDD VSS sg13g2_fill_1
XFILLER_131_814 VDD VSS sg13g2_decap_8
XFILLER_157_1265 VDD VSS sg13g2_fill_2
X_09992_ _14575_/D _10091_/A0 _14575_/Q _09994_/S VDD VSS sg13g2_mux2_1
XFILLER_89_728 VDD VSS sg13g2_decap_8
XFILLER_103_516 VDD VSS sg13g2_decap_8
XFILLER_115_376 VDD VSS sg13g2_decap_8
XFILLER_131_825 VDD VSS sg13g2_fill_2
XFILLER_131_836 VDD VSS sg13g2_fill_1
Xhold3026 input5/A mem_axi_rdata[10] VDD VSS sg13g2_dlygate4sd3_1
Xhold3037 hold3037/X input8/X VDD VSS sg13g2_dlygate4sd3_1
X_08943_ _08943_/Y _08943_/A _14954_/Q VDD VSS sg13g2_nand2_1
Xhold3048 hold3048/X input30/X VDD VSS sg13g2_dlygate4sd3_1
Xhold3059 hold3059/X input31/X VDD VSS sg13g2_dlygate4sd3_1
XFILLER_130_357 VDD VSS sg13g2_decap_8
XFILLER_97_750 VDD VSS sg13g2_fill_1
XFILLER_69_452 VDD VSS sg13g2_decap_4
XFILLER_9_1064 VDD VSS sg13g2_decap_8
X_08874_ _08874_/X _15032_/Q _10788_/S _08873_/Y VDD VSS sg13g2_a21o_1
XFILLER_29_305 VDD VSS sg13g2_decap_8
X_13834__2345 _13834_/RESET_B VDD VSS sg13g2_tiehi
X_15059__2497 _15059_/RESET_B VDD VSS sg13g2_tiehi
X_07825_ _08436_/B _15005_/Q _07946_/B VDD VSS sg13g2_or2_1
XFILLER_28_49 VDD VSS sg13g2_decap_8
XFILLER_151_28 VDD VSS sg13g2_decap_8
X_14594__1585 _14594_/RESET_B VDD VSS sg13g2_tiehi
XFILLER_85_978 VDD VSS sg13g2_decap_8
XFILLER_77_1200 VDD VSS sg13g2_fill_2
XFILLER_56_168 VDD VSS sg13g2_decap_8
X_07756_ _13305_/B _13499_/C _13300_/A VDD VSS sg13g2_nor2b_1
XFILLER_38_883 VDD VSS sg13g2_decap_8
XFILLER_37_371 VDD VSS sg13g2_decap_8
XFILLER_25_511 VDD VSS sg13g2_decap_4
XFILLER_168_1372 VDD VSS sg13g2_decap_8
X_07687_ _07697_/A _07687_/A _07687_/B _07687_/C VDD VSS sg13g2_or3_1
XFILLER_64_190 VDD VSS sg13g2_decap_8
XFILLER_77_1266 VDD VSS sg13g2_fill_1
X_09426_ _14028_/D _09624_/A0 _14028_/Q _09434_/S VDD VSS sg13g2_mux2_1
XFILLER_38_1239 VDD VSS sg13g2_decap_8
XFILLER_13_728 VDD VSS sg13g2_decap_8
XFILLER_164_1247 VDD VSS sg13g2_decap_8
XFILLER_40_525 VDD VSS sg13g2_decap_8
XFILLER_100_21 VDD VSS sg13g2_decap_8
XFILLER_40_536 VDD VSS sg13g2_fill_1
XFILLER_12_238 VDD VSS sg13g2_decap_8
X_09357_ _13961_/D _09953_/A1 _13961_/Q _09373_/S VDD VSS sg13g2_mux2_1
XFILLER_40_558 VDD VSS sg13g2_fill_1
Xclkbuf_5_3__f_clk_i clkbuf_leaf_4_clk_i/A clkbuf_4_1_0_clk_i/X VDD VSS sg13g2_buf_16
XFILLER_166_722 VDD VSS sg13g2_decap_8
XFILLER_60_14 VDD VSS sg13g2_decap_8
X_08308_ _08308_/X _08131_/Y _08363_/S0 _08027_/Y VDD VSS sg13g2_a21o_1
XFILLER_165_210 VDD VSS sg13g2_decap_8
XFILLER_166_733 VDD VSS sg13g2_fill_2
X_09288_ _13896_/D _13896_/Q _09919_/A1 _09297_/S VDD VSS sg13g2_mux2_1
XFILLER_138_446 VDD VSS sg13g2_decap_8
X_08239_ _08239_/Y _08265_/B _08692_/A _08318_/A _08522_/C _08238_/Y VDD VSS sg13g2_a221oi_1
XFILLER_107_811 VDD VSS sg13g2_fill_1
XFILLER_165_287 VDD VSS sg13g2_decap_8
XFILLER_5_938 VDD VSS sg13g2_decap_8
XFILLER_158_1018 VDD VSS sg13g2_decap_8
XFILLER_118_170 VDD VSS sg13g2_decap_8
X_11250_ _14957_/D _11248_/Y _11237_/Y _11249_/Y VDD VSS sg13g2_a21oi_1
XFILLER_88_1351 VDD VSS sg13g2_decap_4
XFILLER_107_844 VDD VSS sg13g2_decap_8
XFILLER_4_448 VDD VSS sg13g2_decap_8
XFILLER_10_1169 VDD VSS sg13g2_decap_8
X_10201_ _15182_/D hold3037/X _10201_/A1 _13477_/S VDD VSS sg13g2_mux2_1
XFILLER_101_1297 VDD VSS sg13g2_decap_8
XFILLER_106_354 VDD VSS sg13g2_fill_2
XFILLER_122_814 VDD VSS sg13g2_decap_8
X_11181_ _11181_/X _11181_/A _11181_/B VDD VSS sg13g2_xor2_1
XFILLER_107_899 VDD VSS sg13g2_decap_8
XFILLER_122_825 VDD VSS sg13g2_fill_2
XFILLER_49_1379 VDD VSS sg13g2_fill_1
XFILLER_161_493 VDD VSS sg13g2_decap_8
X_10132_ _14710_/D _10165_/A1 _14710_/Q _10134_/S VDD VSS sg13g2_mux2_1
XFILLER_47_1081 VDD VSS sg13g2_decap_8
XFILLER_0_665 VDD VSS sg13g2_decap_8
XFILLER_125_62 VDD VSS sg13g2_decap_4
X_14940_ _14940_/Q clkload53/A _14940_/D _14940_/RESET_B VDD VSS sg13g2_dfrbpq_1
X_10063_ _14644_/D _10096_/A0 _14644_/Q _10063_/S VDD VSS sg13g2_mux2_1
XFILLER_87_260 VDD VSS sg13g2_decap_8
XFILLER_130_880 VDD VSS sg13g2_decap_8
XFILLER_134_1062 VDD VSS sg13g2_fill_1
XFILLER_85_33 VDD VSS sg13g2_fill_1
XFILLER_48_625 VDD VSS sg13g2_decap_8
X_14424__1755 _14424_/RESET_B VDD VSS sg13g2_tiehi
X_14871_ _14871_/Q _14874_/CLK _14871_/D _14871_/RESET_B VDD VSS sg13g2_dfrbpq_1
XFILLER_60_1270 VDD VSS sg13g2_decap_8
XFILLER_47_146 VDD VSS sg13g2_decap_8
XFILLER_21_1232 VDD VSS sg13g2_decap_8
X_13822_ _13822_/Q _14686_/CLK _13822_/D _13822_/RESET_B VDD VSS sg13g2_dfrbpq_1
XFILLER_62_105 VDD VSS sg13g2_decap_8
XFILLER_16_511 VDD VSS sg13g2_decap_8
XFILLER_75_499 VDD VSS sg13g2_decap_8
XFILLER_56_680 VDD VSS sg13g2_decap_4
XFILLER_1_1337 VDD VSS sg13g2_decap_8
X_13753_ _13753_/Q clkload21/A _13753_/D _13753_/RESET_B VDD VSS sg13g2_dfrbpq_1
XFILLER_62_138 VDD VSS sg13g2_decap_8
X_10965_ _11042_/A _10965_/A _10965_/B _10965_/C VDD VSS sg13g2_nor3_1
XFILLER_56_1306 VDD VSS sg13g2_fill_2
XFILLER_141_94 VDD VSS sg13g2_decap_8
X_12704_ _12704_/X _12700_/X _12701_/X _12699_/X _12698_/X _12705_/S0 _12789_/S1 VDD
+ VSS sg13g2_mux4_1
XFILLER_31_503 VDD VSS sg13g2_fill_1
XFILLER_16_588 VDD VSS sg13g2_decap_8
X_13684_ _13684_/Q clkload56/A _13684_/D _13684_/RESET_B VDD VSS sg13g2_dfrbpq_1
X_10896_ _10896_/Y _10948_/A _10893_/X _10895_/Y VDD VSS sg13g2_a21oi_1
XFILLER_70_182 VDD VSS sg13g2_decap_8
X_12635_ _12635_/X _12633_/X _12632_/X _12629_/X _12628_/X _12663_/S1 _12678_/S VDD
+ VSS sg13g2_mux4_1
XFILLER_34_70 VDD VSS sg13g2_decap_8
XFILLER_169_560 VDD VSS sg13g2_decap_8
XFILLER_129_402 VDD VSS sg13g2_fill_1
XFILLER_31_569 VDD VSS sg13g2_fill_1
XFILLER_19_1183 VDD VSS sg13g2_decap_8
XFILLER_129_424 VDD VSS sg13g2_fill_2
XFILLER_8_721 VDD VSS sg13g2_decap_8
XFILLER_141_1033 VDD VSS sg13g2_fill_1
XFILLER_15_1036 VDD VSS sg13g2_decap_8
X_12566_ _12566_/X _12562_/X _12561_/X _12558_/X _12557_/X _12608_/S1 _12539_/S VDD
+ VSS sg13g2_mux4_1
XFILLER_106_1164 VDD VSS sg13g2_fill_1
XFILLER_79_7 VDD VSS sg13g2_decap_8
XFILLER_7_231 VDD VSS sg13g2_decap_8
X_14305_ _14305_/Q clkload31/A _14305_/D _14305_/RESET_B VDD VSS sg13g2_dfrbpq_1
X_11517_ _11517_/X _11507_/X _11508_/X _11511_/X _11512_/X _12290_/S0 _12293_/A1 VDD
+ VSS sg13g2_mux4_1
XFILLER_129_479 VDD VSS sg13g2_decap_8
XFILLER_102_1039 VDD VSS sg13g2_decap_4
XFILLER_116_107 VDD VSS sg13g2_decap_8
XFILLER_145_939 VDD VSS sg13g2_decap_8
X_12497_ _12497_/X _12495_/X _12496_/X _12664_/S VDD VSS sg13g2_mux2_1
XFILLER_32_1372 VDD VSS sg13g2_decap_4
XFILLER_116_118 VDD VSS sg13g2_fill_1
XFILLER_144_427 VDD VSS sg13g2_decap_8
XFILLER_8_798 VDD VSS sg13g2_decap_8
XFILLER_144_438 VDD VSS sg13g2_fill_2
X_13912__2267 _13912_/RESET_B VDD VSS sg13g2_tiehi
X_14236_ _14236_/Q clkload44/A _14236_/D _14236_/RESET_B VDD VSS sg13g2_dfrbpq_1
XFILLER_171_224 VDD VSS sg13g2_decap_4
X_11448_ _11448_/X _11448_/A _12291_/A _11448_/C VDD VSS sg13g2_and3_1
XFILLER_153_972 VDD VSS sg13g2_decap_8
XFILLER_166_91 VDD VSS sg13g2_decap_8
XFILLER_171_268 VDD VSS sg13g2_decap_8
XFILLER_153_983 VDD VSS sg13g2_fill_1
X_14167_ _14167_/Q clkload30/A _14167_/D _14167_/RESET_B VDD VSS sg13g2_dfrbpq_1
XFILLER_98_503 VDD VSS sg13g2_decap_8
XFILLER_124_151 VDD VSS sg13g2_decap_4
X_11379_ _11379_/Y _11231_/S _11378_/X _11236_/C VDD VSS sg13g2_a21oi_1
XFILLER_98_525 VDD VSS sg13g2_decap_8
X_13118_ _13170_/A _14914_/Q _13673_/Q VDD VSS sg13g2_xnor2_1
X_14098_ _14098_/Q _14706_/CLK _14098_/D _14098_/RESET_B VDD VSS sg13g2_dfrbpq_1
XFILLER_98_558 VDD VSS sg13g2_fill_2
XFILLER_86_709 VDD VSS sg13g2_decap_8
XFILLER_6_1204 VDD VSS sg13g2_decap_8
XFILLER_65_1181 VDD VSS sg13g2_decap_8
XFILLER_61_1012 VDD VSS sg13g2_decap_8
X_13049_ _13049_/X _15062_/Q _15061_/Q VDD VSS sg13g2_or2_1
XFILLER_61_1023 VDD VSS sg13g2_fill_1
XFILLER_79_783 VDD VSS sg13g2_fill_1
XFILLER_26_1154 VDD VSS sg13g2_decap_8
XFILLER_113_1124 VDD VSS sg13g2_decap_4
Xfanout1260 _12236_/C _11762_/S1 VDD VSS sg13g2_buf_1
XFILLER_38_113 VDD VSS sg13g2_fill_2
Xfanout1271 _12312_/B1 _12319_/B1 VDD VSS sg13g2_buf_1
XFILLER_22_1018 VDD VSS sg13g2_decap_4
Xfanout1282 _12187_/C fanout1291/X VDD VSS sg13g2_buf_1
XFILLER_113_1157 VDD VSS sg13g2_decap_8
XFILLER_93_230 VDD VSS sg13g2_fill_1
Xfanout1293 _12215_/S1 _13658_/Q VDD VSS sg13g2_buf_1
XFILLER_93_241 VDD VSS sg13g2_decap_8
XFILLER_96_1119 VDD VSS sg13g2_decap_8
X_08590_ _08590_/Y _08625_/A _08590_/B VDD VSS sg13g2_nor2_1
XFILLER_19_371 VDD VSS sg13g2_decap_8
XFILLER_53_138 VDD VSS sg13g2_fill_1
X_14579__1600 _14579_/RESET_B VDD VSS sg13g2_tiehi
XFILLER_22_525 VDD VSS sg13g2_decap_8
X_09211_ _13822_/D _10141_/A1 _13822_/Q _09233_/S VDD VSS sg13g2_mux2_1
XFILLER_61_182 VDD VSS sg13g2_decap_8
XFILLER_34_396 VDD VSS sg13g2_fill_1
XFILLER_61_193 VDD VSS sg13g2_fill_1
XFILLER_37_1283 VDD VSS sg13g2_fill_1
X_09142_ _09157_/D _13245_/A _14921_/Q _14920_/Q VDD VSS sg13g2_and3_1
XFILLER_33_1125 VDD VSS sg13g2_decap_8
XFILLER_124_1275 VDD VSS sg13g2_decap_8
XFILLER_136_917 VDD VSS sg13g2_decap_8
XFILLER_120_1128 VDD VSS sg13g2_decap_8
XFILLER_148_788 VDD VSS sg13g2_decap_8
X_09073_ _10735_/B _09072_/B _15039_/Q _09072_/Y VDD VSS sg13g2_o21ai_1
XFILLER_136_939 VDD VSS sg13g2_fill_2
XFILLER_129_980 VDD VSS sg13g2_fill_1
XFILLER_30_28 VDD VSS sg13g2_decap_8
XFILLER_135_427 VDD VSS sg13g2_fill_2
XFILLER_162_224 VDD VSS sg13g2_decap_8
X_08024_ _08025_/C _07903_/B _08063_/B _11335_/A _11384_/A _07900_/B _07884_/A VDD
+ VSS sg13g2_mux4_1
XFILLER_146_28 VDD VSS sg13g2_decap_8
X_14502__1677 _14502_/RESET_B VDD VSS sg13g2_tiehi
XFILLER_116_652 VDD VSS sg13g2_decap_8
XFILLER_131_600 VDD VSS sg13g2_decap_8
XFILLER_89_525 VDD VSS sg13g2_fill_1
XFILLER_118_1035 VDD VSS sg13g2_fill_1
X_09975_ _14558_/D _10074_/A0 _14558_/Q _09997_/S VDD VSS sg13g2_mux2_1
XFILLER_89_569 VDD VSS sg13g2_decap_8
XFILLER_58_901 VDD VSS sg13g2_fill_2
X_08926_ _13714_/D _16876_/A _08925_/X _08932_/S VDD VSS sg13g2_mux2_1
XFILLER_44_1243 VDD VSS sg13g2_fill_1
XFILLER_112_880 VDD VSS sg13g2_fill_1
XFILLER_162_49 VDD VSS sg13g2_decap_8
XFILLER_135_1382 VDD VSS sg13g2_fill_2
XFILLER_69_271 VDD VSS sg13g2_decap_8
XFILLER_69_282 VDD VSS sg13g2_fill_1
X_08857_ _08857_/X _08856_/X _07888_/B _08860_/S VDD VSS sg13g2_mux2_1
XFILLER_44_1287 VDD VSS sg13g2_fill_1
XFILLER_29_135 VDD VSS sg13g2_fill_1
XFILLER_131_1246 VDD VSS sg13g2_decap_4
XFILLER_85_764 VDD VSS sg13g2_fill_2
XFILLER_55_14 VDD VSS sg13g2_decap_8
X_15065__2881 _15065_/RESET_B VDD VSS sg13g2_tiehi
X_07808_ _07808_/Y _15012_/Q _08541_/B VDD VSS sg13g2_nor2_1
XFILLER_17_308 VDD VSS sg13g2_decap_8
XFILLER_79_1339 VDD VSS sg13g2_decap_4
X_08788_ _08788_/Y _13345_/B _14757_/Q _10199_/A1 _07719_/X VDD VSS sg13g2_a22oi_1
XFILLER_73_948 VDD VSS sg13g2_decap_8
XFILLER_84_285 VDD VSS sg13g2_decap_8
XFILLER_72_425 VDD VSS sg13g2_decap_8
XFILLER_38_680 VDD VSS sg13g2_decap_8
X_07739_ _15209_/D _13284_/B _07738_/Y _07714_/Y VDD VSS sg13g2_o21ai_1
X_10750_ _10750_/Y _14915_/Q _11048_/B VDD VSS sg13g2_nand2_1
XFILLER_164_1033 VDD VSS sg13g2_fill_1
XFILLER_52_160 VDD VSS sg13g2_decap_8
XFILLER_0_1381 VDD VSS sg13g2_fill_2
XFILLER_13_525 VDD VSS sg13g2_decap_8
XFILLER_80_480 VDD VSS sg13g2_fill_1
XFILLER_53_694 VDD VSS sg13g2_decap_8
XFILLER_52_171 VDD VSS sg13g2_fill_1
XFILLER_38_1047 VDD VSS sg13g2_decap_8
XFILLER_41_845 VDD VSS sg13g2_decap_8
X_09409_ _14011_/D _09574_/A1 _14011_/Q _09434_/S VDD VSS sg13g2_mux2_1
XFILLER_164_1077 VDD VSS sg13g2_decap_8
XFILLER_55_1350 VDD VSS sg13g2_fill_1
X_10681_ _10681_/Y _10681_/A _10862_/B VDD VSS sg13g2_nand2_1
XFILLER_90_1241 VDD VSS sg13g2_decap_4
XFILLER_40_344 VDD VSS sg13g2_decap_8
XFILLER_139_711 VDD VSS sg13g2_fill_1
XFILLER_9_518 VDD VSS sg13g2_decap_8
XFILLER_55_1361 VDD VSS sg13g2_decap_8
XFILLER_16_1323 VDD VSS sg13g2_decap_8
X_12420_ _12420_/X _14368_/Q _14400_/Q _14464_/Q _14496_/Q _12452_/S0 _12452_/S1 VDD
+ VSS sg13g2_mux4_1
XFILLER_90_1263 VDD VSS sg13g2_decap_8
XFILLER_103_1304 VDD VSS sg13g2_decap_4
XFILLER_139_744 VDD VSS sg13g2_decap_4
XFILLER_139_755 VDD VSS sg13g2_decap_8
XFILLER_103_1315 VDD VSS sg13g2_fill_1
X_12351_ _12351_/X _14363_/Q _14395_/Q _14459_/Q _14491_/Q _12352_/S0 _12352_/S1 VDD
+ VSS sg13g2_mux4_1
XFILLER_154_714 VDD VSS sg13g2_decap_8
XFILLER_166_574 VDD VSS sg13g2_decap_8
X_11302_ _11302_/Y _11310_/A1 _14557_/Q VDD VSS sg13g2_nand2b_1
X_15070_ _15070_/Q _15183_/CLK _15070_/D _15070_/RESET_B VDD VSS sg13g2_dfrbpq_1
XFILLER_5_735 VDD VSS sg13g2_decap_8
X_12282_ _12282_/X _13753_/Q _14105_/Q _14457_/Q _14553_/Q _12282_/S0 _12282_/S1 VDD
+ VSS sg13g2_mux4_1
XFILLER_107_641 VDD VSS sg13g2_decap_4
XFILLER_153_257 VDD VSS sg13g2_decap_8
XFILLER_105_0 VDD VSS sg13g2_decap_8
XFILLER_141_408 VDD VSS sg13g2_fill_2
X_14021_ _14021_/Q clkload5/A _14021_/D _14021_/RESET_B VDD VSS sg13g2_dfrbpq_1
XFILLER_4_245 VDD VSS sg13g2_decap_8
XFILLER_106_140 VDD VSS sg13g2_fill_1
XFILLER_135_972 VDD VSS sg13g2_decap_8
X_11233_ _11233_/Y _15117_/Q _15118_/Q _14760_/Q VDD VSS sg13g2_nor3_1
XFILLER_136_1102 VDD VSS sg13g2_decap_4
XFILLER_134_493 VDD VSS sg13g2_decap_8
X_11164_ _11181_/B _11164_/A _11164_/B _11164_/C _11190_/C VDD VSS sg13g2_nor4_1
XFILLER_96_21 VDD VSS sg13g2_fill_2
XFILLER_68_709 VDD VSS sg13g2_decap_8
XFILLER_49_1198 VDD VSS sg13g2_decap_8
XFILLER_1_952 VDD VSS sg13g2_decap_8
X_10115_ _14693_/D _10148_/A1 _14693_/Q _10127_/S VDD VSS sg13g2_mux2_1
XFILLER_95_517 VDD VSS sg13g2_fill_2
XFILLER_136_1179 VDD VSS sg13g2_decap_8
XFILLER_0_462 VDD VSS sg13g2_decap_8
X_14657__1522 _14657_/RESET_B VDD VSS sg13g2_tiehi
X_11095_ _11095_/Y _11095_/A _11095_/B VDD VSS sg13g2_nor2_1
XFILLER_62_1354 VDD VSS sg13g2_fill_2
XFILLER_49_945 VDD VSS sg13g2_decap_8
X_14923_ _14923_/Q clkload54/A _14923_/D _14923_/RESET_B VDD VSS sg13g2_dfrbpq_1
X_10046_ _14627_/D _10079_/A0 _14627_/Q _10064_/S VDD VSS sg13g2_mux2_1
XFILLER_48_433 VDD VSS sg13g2_decap_4
XFILLER_29_70 VDD VSS sg13g2_decap_8
XFILLER_48_455 VDD VSS sg13g2_decap_8
XFILLER_23_1349 VDD VSS sg13g2_decap_8
XFILLER_91_701 VDD VSS sg13g2_decap_8
X_14086__2093 _14086_/RESET_B VDD VSS sg13g2_tiehi
X_14854_ _14854_/Q _14854_/CLK _14854_/D _14854_/RESET_B VDD VSS sg13g2_dfrbpq_1
XFILLER_63_414 VDD VSS sg13g2_fill_2
X_14801__2912 _14801_/RESET_B VDD VSS sg13g2_tiehi
X_15197__2757 _15197_/RESET_B VDD VSS sg13g2_tiehi
XFILLER_5_1281 VDD VSS sg13g2_decap_8
XFILLER_29_691 VDD VSS sg13g2_decap_4
XFILLER_1_1134 VDD VSS sg13g2_decap_8
X_13805_ _13805_/Q clkload10/A _13805_/D _13805_/RESET_B VDD VSS sg13g2_dfrbpq_1
X_14785_ _14785_/Q _14894_/CLK _14785_/D _14785_/RESET_B VDD VSS sg13g2_dfrbpq_1
X_11997_ _11997_/X _13745_/Q _14097_/Q _14449_/Q _14545_/Q _11997_/S0 _11997_/S1 VDD
+ VSS sg13g2_mux4_1
XFILLER_17_875 VDD VSS sg13g2_decap_8
X_13736_ _13736_/Q _14512_/CLK _13736_/D _13736_/RESET_B VDD VSS sg13g2_dfrbpq_1
X_10948_ _11005_/A _10948_/A _10948_/B _10948_/C _10948_/D VDD VSS sg13g2_or4_1
XFILLER_32_823 VDD VSS sg13g2_decap_8
XFILLER_16_385 VDD VSS sg13g2_decap_8
X_15025__2562 _15025_/RESET_B VDD VSS sg13g2_tiehi
XFILLER_44_694 VDD VSS sg13g2_decap_8
XFILLER_43_160 VDD VSS sg13g2_decap_8
X_13667_ _13667_/Q clkload64/A _13667_/D _13667_/RESET_B VDD VSS sg13g2_dfrbpq_1
X_10879_ _10879_/Y _14754_/Q _10897_/A VDD VSS sg13g2_nand2b_1
XFILLER_31_377 VDD VSS sg13g2_decap_4
X_12618_ _12618_/X _13742_/Q _14094_/Q _14446_/Q _14542_/Q _12618_/S0 _12618_/S1 VDD
+ VSS sg13g2_mux4_1
X_13598_ _15164_/D _13597_/Y _13508_/C _13595_/Y VDD VSS sg13g2_a21oi_1
XFILLER_129_243 VDD VSS sg13g2_decap_8
X_12549_ _12549_/X _14121_/Q _14153_/Q _14185_/Q _14217_/Q _12767_/S0 _12767_/S1 VDD
+ VSS sg13g2_mux4_1
XFILLER_117_427 VDD VSS sg13g2_decap_4
XFILLER_144_224 VDD VSS sg13g2_decap_8
XFILLER_8_595 VDD VSS sg13g2_decap_8
XFILLER_172_533 VDD VSS sg13g2_decap_4
XANTENNA_1 _16884_/A VDD VSS sg13g2_antennanp
X_14849__2846 _14849_/RESET_B VDD VSS sg13g2_tiehi
XFILLER_6_63 VDD VSS sg13g2_decap_8
XFILLER_172_566 VDD VSS sg13g2_decap_8
XFILLER_160_728 VDD VSS sg13g2_decap_8
X_14219_ _14219_/Q clkload1/A _14219_/D _14219_/RESET_B VDD VSS sg13g2_dfrbpq_1
XFILLER_67_1232 VDD VSS sg13g2_decap_8
X_15199_ _15199_/Q clkload64/A _15199_/D _15199_/RESET_B VDD VSS sg13g2_dfrbpq_1
XFILLER_113_622 VDD VSS sg13g2_decap_8
XFILLER_112_110 VDD VSS sg13g2_fill_1
X_14296__1883 _14296_/RESET_B VDD VSS sg13g2_tiehi
Xfanout508 _13524_/A1 _13508_/X VDD VSS sg13g2_buf_1
XFILLER_28_1238 VDD VSS sg13g2_decap_8
XFILLER_112_132 VDD VSS sg13g2_decap_8
Xfanout519 _12292_/A _11236_/C VDD VSS sg13g2_buf_1
XFILLER_113_677 VDD VSS sg13g2_decap_8
XFILLER_113_688 VDD VSS sg13g2_fill_2
X_09760_ _14350_/D _14350_/Q _09760_/A1 _09766_/S VDD VSS sg13g2_mux2_1
XFILLER_140_474 VDD VSS sg13g2_decap_8
XFILLER_154_1279 VDD VSS sg13g2_fill_2
XFILLER_6_1001 VDD VSS sg13g2_decap_8
XFILLER_98_399 VDD VSS sg13g2_decap_8
XFILLER_112_187 VDD VSS sg13g2_decap_8
XFILLER_20_0 VDD VSS sg13g2_decap_8
X_08711_ _15188_/D hold3090/X _15188_/Q _10203_/S VDD VSS sg13g2_mux2_1
X_09691_ _14283_/D _09889_/A0 _14283_/Q _09697_/S VDD VSS sg13g2_mux2_1
Xfanout1090 _08653_/B _12229_/A VDD VSS sg13g2_buf_1
XFILLER_82_701 VDD VSS sg13g2_fill_1
XFILLER_6_1078 VDD VSS sg13g2_decap_8
X_08642_ _08642_/Y _08573_/A _08575_/Y _08641_/Y VDD VSS sg13g2_o21ai_1
XFILLER_55_926 VDD VSS sg13g2_decap_8
XFILLER_26_105 VDD VSS sg13g2_decap_8
XFILLER_81_200 VDD VSS sg13g2_decap_8
XFILLER_82_756 VDD VSS sg13g2_decap_8
X_08573_ _08573_/Y _08573_/A VDD VSS sg13g2_inv_1
XFILLER_82_767 VDD VSS sg13g2_fill_2
XFILLER_78_1350 VDD VSS sg13g2_fill_2
XFILLER_82_778 VDD VSS sg13g2_fill_1
XFILLER_54_469 VDD VSS sg13g2_decap_8
XFILLER_25_28 VDD VSS sg13g2_decap_8
XFILLER_63_981 VDD VSS sg13g2_decap_8
XFILLER_126_1304 VDD VSS sg13g2_fill_2
XFILLER_22_322 VDD VSS sg13g2_decap_8
XFILLER_168_817 VDD VSS sg13g2_decap_8
XFILLER_161_1217 VDD VSS sg13g2_decap_8
Xclkbuf_5_21__f_clk_i clkbuf_leaf_92_clk_i/A clkbuf_4_10_0_clk_i/X VDD VSS sg13g2_buf_16
XFILLER_161_1239 VDD VSS sg13g2_fill_1
X_13784__2395 _13784_/RESET_B VDD VSS sg13g2_tiehi
XFILLER_50_697 VDD VSS sg13g2_decap_8
XFILLER_10_539 VDD VSS sg13g2_decap_8
XFILLER_124_1050 VDD VSS sg13g2_decap_8
XFILLER_22_399 VDD VSS sg13g2_decap_8
XFILLER_124_1061 VDD VSS sg13g2_fill_2
X_09125_ _09125_/X _09137_/A _09125_/B _09157_/C VDD VSS sg13g2_or3_1
XFILLER_41_49 VDD VSS sg13g2_decap_8
XFILLER_109_928 VDD VSS sg13g2_decap_8
X_14735__1444 _14735_/RESET_B VDD VSS sg13g2_tiehi
XFILLER_163_511 VDD VSS sg13g2_decap_8
XFILLER_157_49 VDD VSS sg13g2_decap_8
X_09056_ _09089_/C _14909_/Q _14908_/Q _09056_/C VDD VSS sg13g2_and3_1
XFILLER_159_1146 VDD VSS sg13g2_decap_8
XFILLER_11_1253 VDD VSS sg13g2_decap_8
XFILLER_159_1157 VDD VSS sg13g2_fill_2
X_08007_ _08008_/B _08005_/X _08146_/A _08014_/B VDD VSS sg13g2_mux2_1
XFILLER_85_1321 VDD VSS sg13g2_fill_1
XFILLER_123_419 VDD VSS sg13g2_fill_2
XFILLER_163_588 VDD VSS sg13g2_decap_8
XFILLER_116_460 VDD VSS sg13g2_decap_8
XFILLER_151_739 VDD VSS sg13g2_fill_1
XFILLER_163_599 VDD VSS sg13g2_fill_1
XFILLER_85_1343 VDD VSS sg13g2_fill_2
XFILLER_9_7 VDD VSS sg13g2_decap_8
XFILLER_46_1305 VDD VSS sg13g2_decap_4
XFILLER_2_749 VDD VSS sg13g2_decap_8
XFILLER_150_249 VDD VSS sg13g2_fill_2
XFILLER_143_290 VDD VSS sg13g2_fill_1
XFILLER_89_355 VDD VSS sg13g2_decap_8
XFILLER_1_259 VDD VSS sg13g2_decap_8
XFILLER_104_677 VDD VSS sg13g2_fill_1
XFILLER_131_452 VDD VSS sg13g2_fill_1
XFILLER_133_1308 VDD VSS sg13g2_fill_1
XFILLER_106_42 VDD VSS sg13g2_decap_8
XFILLER_49_219 VDD VSS sg13g2_decap_4
XFILLER_172_1379 VDD VSS sg13g2_fill_1
XFILLER_104_699 VDD VSS sg13g2_decap_8
X_09958_ _14542_/D _14542_/Q _10090_/A0 _09968_/S VDD VSS sg13g2_mux2_1
XFILLER_103_198 VDD VSS sg13g2_decap_8
X_08909_ _08909_/Y _11865_/A _08931_/S _08908_/Y VDD VSS sg13g2_a21oi_1
XFILLER_66_35 VDD VSS sg13g2_decap_8
XFILLER_66_46 VDD VSS sg13g2_decap_8
XFILLER_46_904 VDD VSS sg13g2_fill_1
XFILLER_131_1043 VDD VSS sg13g2_fill_2
X_09889_ _14475_/D _09889_/A0 _14475_/Q _09895_/S VDD VSS sg13g2_mux2_1
XFILLER_85_550 VDD VSS sg13g2_fill_2
XFILLER_58_775 VDD VSS sg13g2_decap_8
XFILLER_100_883 VDD VSS sg13g2_decap_4
X_11920_ _11920_/X _13839_/Q _13871_/Q _13903_/Q _13935_/Q _11925_/S0 _11925_/S1 VDD
+ VSS sg13g2_mux4_1
XFILLER_17_105 VDD VSS sg13g2_decap_8
X_11851_ _11851_/X _14125_/Q _14157_/Q _14189_/Q _14221_/Q _11852_/S0 _11851_/S1 VDD
+ VSS sg13g2_mux4_1
XFILLER_122_74 VDD VSS sg13g2_decap_8
XFILLER_14_812 VDD VSS sg13g2_decap_8
X_10802_ _10802_/Y _10802_/A _12346_/A VDD VSS sg13g2_nor2b_1
X_14570_ _14570_/Q _14730_/CLK _14570_/D _14570_/RESET_B VDD VSS sg13g2_dfrbpq_1
XFILLER_32_119 VDD VSS sg13g2_decap_8
X_11782_ _11782_/X _13835_/Q _13867_/Q _13899_/Q _13931_/Q _11993_/S0 _11995_/S1 VDD
+ VSS sg13g2_mux4_1
XFILLER_72_288 VDD VSS sg13g2_decap_8
XFILLER_60_439 VDD VSS sg13g2_decap_4
XFILLER_13_322 VDD VSS sg13g2_decap_8
XFILLER_25_182 VDD VSS sg13g2_decap_8
X_13521_ _13521_/X _13521_/A _13533_/B VDD VSS sg13g2_and2_1
X_10733_ _10734_/A _14911_/Q _11048_/B _11183_/B1 _11042_/D VDD VSS sg13g2_a22oi_1
XFILLER_158_305 VDD VSS sg13g2_decap_8
XFILLER_14_889 VDD VSS sg13g2_decap_8
XFILLER_9_315 VDD VSS sg13g2_decap_8
XFILLER_16_1120 VDD VSS sg13g2_decap_8
X_13452_ _13454_/C _15184_/Q _15185_/Q VDD VSS sg13g2_nor2_1
X_10664_ _14893_/D _10664_/A _10667_/A _10664_/C VDD VSS sg13g2_nor3_1
XFILLER_13_399 VDD VSS sg13g2_decap_8
XFILLER_55_1191 VDD VSS sg13g2_decap_8
X_12403_ _12403_/Y _12765_/A1 _12542_/A2 _08659_/A VDD VSS sg13g2_a21oi_1
XFILLER_173_308 VDD VSS sg13g2_decap_8
XFILLER_103_1123 VDD VSS sg13g2_decap_8
XFILLER_139_563 VDD VSS sg13g2_decap_8
X_13383_ _15080_/D _13378_/C _13455_/A _13380_/Y VDD VSS sg13g2_o21ai_1
XFILLER_103_1134 VDD VSS sg13g2_fill_2
XFILLER_127_725 VDD VSS sg13g2_fill_1
XFILLER_166_371 VDD VSS sg13g2_decap_8
X_10595_ _14875_/D _10595_/A _10599_/A _10595_/C VDD VSS sg13g2_nor3_1
XFILLER_16_1197 VDD VSS sg13g2_decap_8
XFILLER_154_533 VDD VSS sg13g2_decap_8
X_15122_ _15122_/Q clkload63/A _15122_/D _15122_/RESET_B VDD VSS sg13g2_dfrbpq_1
X_12334_ _12334_/Y _12332_/Y _12334_/B _12334_/C VDD VSS sg13g2_nand3b_1
XFILLER_51_1099 VDD VSS sg13g2_decap_4
XFILLER_154_544 VDD VSS sg13g2_fill_2
XFILLER_5_532 VDD VSS sg13g2_decap_8
XFILLER_115_909 VDD VSS sg13g2_decap_8
XFILLER_142_706 VDD VSS sg13g2_decap_8
XFILLER_108_972 VDD VSS sg13g2_fill_1
XFILLER_154_577 VDD VSS sg13g2_decap_8
X_15053_ _15053_/Q _15214_/CLK _15053_/D _15053_/RESET_B VDD VSS sg13g2_dfrbpq_1
XFILLER_99_108 VDD VSS sg13g2_fill_1
XFILLER_108_983 VDD VSS sg13g2_decap_8
XFILLER_141_205 VDD VSS sg13g2_decap_8
X_12265_ _12265_/Y _12260_/X _12174_/A _12265_/B1 VDD VSS sg13g2_a21oi_1
XFILLER_99_119 VDD VSS sg13g2_decap_8
XFILLER_147_93 VDD VSS sg13g2_decap_8
XFILLER_135_780 VDD VSS sg13g2_decap_4
X_14004_ _14004_/Q _14516_/CLK _14004_/D _14004_/RESET_B VDD VSS sg13g2_dfrbpq_1
X_11216_ _11224_/B _11216_/A _11216_/B VDD VSS sg13g2_nor2_1
X_12196_ _14984_/D _12156_/Y _12195_/Y _12150_/Y VDD VSS sg13g2_a21oi_1
Xoutput60 mem_axi_araddr[30] _16883_/A VDD VSS sg13g2_buf_1
Xoutput71 mem_axi_awaddr[10] _16863_/X VDD VSS sg13g2_buf_1
XFILLER_122_463 VDD VSS sg13g2_decap_8
Xoutput82 mem_axi_awaddr[21] _16874_/X VDD VSS sg13g2_buf_1
Xoutput93 mem_axi_awaddr[31] _16884_/X VDD VSS sg13g2_buf_1
X_11147_ _11147_/Y _11147_/A _11163_/A VDD VSS sg13g2_nand2_1
XFILLER_68_528 VDD VSS sg13g2_decap_4
XFILLER_163_70 VDD VSS sg13g2_decap_8
X_14173__2006 _14173_/RESET_B VDD VSS sg13g2_tiehi
XFILLER_49_731 VDD VSS sg13g2_decap_8
XFILLER_27_1271 VDD VSS sg13g2_decap_8
X_11078_ _11138_/B _11078_/A _11078_/B _11097_/A _11078_/D VDD VSS sg13g2_nor4_1
XFILLER_7_1365 VDD VSS sg13g2_decap_8
XFILLER_37_915 VDD VSS sg13g2_decap_8
XFILLER_23_1146 VDD VSS sg13g2_decap_8
XFILLER_3_1218 VDD VSS sg13g2_decap_8
X_14906_ _14906_/Q clkload57/A _14906_/D _14906_/RESET_B VDD VSS sg13g2_dfrbpq_1
X_10029_ _14611_/D _10095_/A0 _14611_/Q _10032_/S VDD VSS sg13g2_mux2_1
XFILLER_64_712 VDD VSS sg13g2_decap_8
XFILLER_48_263 VDD VSS sg13g2_decap_8
XFILLER_76_583 VDD VSS sg13g2_decap_8
XFILLER_149_1304 VDD VSS sg13g2_fill_2
X_14837_ _14837_/Q _15064_/CLK _14837_/D _14837_/RESET_B VDD VSS sg13g2_dfrbpq_1
XFILLER_17_672 VDD VSS sg13g2_decap_8
XFILLER_23_119 VDD VSS sg13g2_decap_8
X_14768_ _14768_/Q _14867_/CLK _14768_/D _14768_/RESET_B VDD VSS sg13g2_dfrbpq_1
XFILLER_16_182 VDD VSS sg13g2_decap_8
X_13719_ _16881_/A clkload54/A _13719_/D _13719_/RESET_B VDD VSS sg13g2_dfrbpq_1
X_14699_ _14699_/Q clkload0/A _14699_/D _14699_/RESET_B VDD VSS sg13g2_dfrbpq_1
XFILLER_108_1056 VDD VSS sg13g2_decap_8
XFILLER_108_1067 VDD VSS sg13g2_fill_2
XFILLER_34_1220 VDD VSS sg13g2_fill_1
XFILLER_20_826 VDD VSS sg13g2_decap_8
XFILLER_149_349 VDD VSS sg13g2_decap_8
X_14204__1975 _14204_/RESET_B VDD VSS sg13g2_tiehi
X_14980__2607 _14980_/RESET_B VDD VSS sg13g2_tiehi
XFILLER_34_1253 VDD VSS sg13g2_decap_8
XFILLER_31_196 VDD VSS sg13g2_decap_4
XFILLER_164_308 VDD VSS sg13g2_decap_8
XFILLER_121_1223 VDD VSS sg13g2_decap_8
XFILLER_160_1272 VDD VSS sg13g2_decap_8
XFILLER_145_511 VDD VSS sg13g2_fill_1
XFILLER_9_882 VDD VSS sg13g2_decap_8
XFILLER_30_1128 VDD VSS sg13g2_decap_8
XFILLER_117_224 VDD VSS sg13g2_decap_8
XFILLER_69_1316 VDD VSS sg13g2_decap_8
XFILLER_68_0 VDD VSS sg13g2_decap_8
XFILLER_8_392 VDD VSS sg13g2_decap_8
XFILLER_145_566 VDD VSS sg13g2_decap_8
X_13769__2410 _13769_/RESET_B VDD VSS sg13g2_tiehi
XFILLER_114_953 VDD VSS sg13g2_decap_8
XFILLER_154_1021 VDD VSS sg13g2_decap_8
Xfanout305 _10160_/S _10156_/S VDD VSS sg13g2_buf_1
XFILLER_99_664 VDD VSS sg13g2_decap_8
Xfanout316 _09968_/S _09970_/S VDD VSS sg13g2_buf_1
XFILLER_113_463 VDD VSS sg13g2_decap_4
XFILLER_87_826 VDD VSS sg13g2_fill_1
X_15168__2499 _15168_/RESET_B VDD VSS sg13g2_tiehi
Xfanout327 _09863_/S wire331/A VDD VSS sg13g2_buf_1
X_09812_ _14400_/D _09911_/A1 _14400_/Q _09837_/S VDD VSS sg13g2_mux2_1
Xfanout338 _09738_/S _09737_/S VDD VSS sg13g2_buf_1
Xfanout349 _09638_/S wire352/X VDD VSS sg13g2_buf_1
XFILLER_98_196 VDD VSS sg13g2_decap_8
XFILLER_154_1098 VDD VSS sg13g2_fill_1
X_14149__2030 _14149_/RESET_B VDD VSS sg13g2_tiehi
X_09743_ _14333_/D _14333_/Q _09908_/A1 _09766_/S VDD VSS sg13g2_mux2_1
XFILLER_45_1382 VDD VSS sg13g2_fill_2
XFILLER_80_1284 VDD VSS sg13g2_decap_8
XFILLER_27_403 VDD VSS sg13g2_fill_2
X_09674_ _09702_/S _10137_/C _09740_/B VDD VSS sg13g2_or2_1
XFILLER_39_285 VDD VSS sg13g2_decap_8
XFILLER_94_391 VDD VSS sg13g2_decap_8
XFILLER_55_745 VDD VSS sg13g2_decap_4
X_08625_ _08625_/Y _08625_/A _08625_/B VDD VSS sg13g2_nor2_1
XFILLER_36_49 VDD VSS sg13g2_decap_8
XFILLER_54_244 VDD VSS sg13g2_decap_8
XFILLER_15_609 VDD VSS sg13g2_decap_8
XFILLER_70_704 VDD VSS sg13g2_fill_2
XFILLER_43_929 VDD VSS sg13g2_decap_8
XFILLER_14_119 VDD VSS sg13g2_decap_8
X_08556_ _15241_/D _08555_/Y _08553_/Y _08545_/X VDD VSS sg13g2_o21ai_1
X_13679__2514 _13679_/RESET_B VDD VSS sg13g2_tiehi
X_13871__2308 _13871_/RESET_B VDD VSS sg13g2_tiehi
XFILLER_161_1014 VDD VSS sg13g2_fill_1
X_08487_ _08488_/B _08510_/A1 _08470_/B _07949_/C _08487_/A3 _08635_/S0 _08635_/S1
+ VDD VSS sg13g2_mux4_1
XFILLER_146_7 VDD VSS sg13g2_decap_8
XFILLER_126_1145 VDD VSS sg13g2_decap_8
XFILLER_39_1197 VDD VSS sg13g2_decap_8
XFILLER_11_826 VDD VSS sg13g2_decap_8
XFILLER_161_1069 VDD VSS sg13g2_fill_1
XFILLER_10_336 VDD VSS sg13g2_decap_8
XFILLER_22_196 VDD VSS sg13g2_decap_8
XFILLER_167_168 VDD VSS sg13g2_decap_8
XFILLER_7_819 VDD VSS sg13g2_decap_8
XFILLER_109_714 VDD VSS sg13g2_fill_1
XFILLER_13_1337 VDD VSS sg13g2_decap_8
XFILLER_148_371 VDD VSS sg13g2_decap_8
XFILLER_149_894 VDD VSS sg13g2_fill_1
XFILLER_6_329 VDD VSS sg13g2_decap_8
X_09108_ _10757_/B _09140_/S _15044_/Q _09107_/Y VDD VSS sg13g2_o21ai_1
X_10380_ _10380_/X _14815_/Q _14816_/Q _14817_/Q _14818_/Q VDD VSS sg13g2_and4_1
XFILLER_108_257 VDD VSS sg13g2_decap_8
XFILLER_11_1050 VDD VSS sg13g2_decap_8
XFILLER_136_588 VDD VSS sg13g2_fill_2
XFILLER_164_897 VDD VSS sg13g2_decap_4
X_09039_ _09039_/Y _15231_/Q _09100_/B VDD VSS sg13g2_nand2b_1
XFILLER_123_205 VDD VSS sg13g2_decap_4
XFILLER_124_739 VDD VSS sg13g2_decap_8
XFILLER_123_216 VDD VSS sg13g2_decap_8
XFILLER_163_385 VDD VSS sg13g2_decap_8
X_14359__1820 _14359_/RESET_B VDD VSS sg13g2_tiehi
X_15178__2855 _15178_/RESET_B VDD VSS sg13g2_tiehi
X_12050_ _12050_/Y _10760_/A _11792_/B _12046_/Y _12049_/Y VDD VSS sg13g2_a22oi_1
XFILLER_116_290 VDD VSS sg13g2_decap_8
XFILLER_2_546 VDD VSS sg13g2_decap_8
XFILLER_172_1110 VDD VSS sg13g2_fill_2
XFILLER_105_964 VDD VSS sg13g2_decap_8
XFILLER_151_569 VDD VSS sg13g2_fill_1
XFILLER_46_1124 VDD VSS sg13g2_decap_8
XFILLER_46_1135 VDD VSS sg13g2_fill_2
X_11001_ _11001_/Y _11001_/A _11021_/B VDD VSS sg13g2_nand2_1
X_14989__2598 _14989_/RESET_B VDD VSS sg13g2_tiehi
XFILLER_117_96 VDD VSS sg13g2_decap_8
XFILLER_77_314 VDD VSS sg13g2_decap_4
XFILLER_132_794 VDD VSS sg13g2_fill_2
XFILLER_104_496 VDD VSS sg13g2_decap_8
Xfanout850 _12601_/S0 _12660_/S0 VDD VSS sg13g2_buf_1
Xfanout861 _12674_/S0 _12759_/S0 VDD VSS sg13g2_buf_1
XFILLER_77_89 VDD VSS sg13g2_decap_8
X_14833__2878 _14833_/RESET_B VDD VSS sg13g2_tiehi
Xfanout872 _12618_/S0 fanout897/X VDD VSS sg13g2_buf_1
Xfanout883 _12757_/S0 _12731_/S0 VDD VSS sg13g2_buf_1
XFILLER_58_550 VDD VSS sg13g2_decap_8
Xfanout894 fanout894/X _12745_/S0 VDD VSS sg13g2_buf_1
XFILLER_86_881 VDD VSS sg13g2_decap_8
X_12952_ _12952_/Y input21/X _12795_/Y _12937_/Y VDD VSS sg13g2_o21ai_1
XFILLER_19_959 VDD VSS sg13g2_decap_8
XFILLER_73_542 VDD VSS sg13g2_fill_2
XFILLER_46_756 VDD VSS sg13g2_decap_4
XFILLER_172_0 VDD VSS sg13g2_decap_8
X_11903_ _11903_/Y _11902_/Y _11892_/Y _11884_/Y _11876_/Y _11236_/C VDD VSS sg13g2_a221oi_1
XFILLER_18_469 VDD VSS sg13g2_decap_8
X_12883_ _12883_/X _12883_/A _12884_/C _12899_/C input25/X VDD VSS sg13g2_and4_1
X_14622_ _14622_/Q clkload36/A _14622_/D _14622_/RESET_B VDD VSS sg13g2_dfrbpq_1
X_11834_ _11834_/Y _11829_/X _11224_/A _12118_/C VDD VSS sg13g2_a21oi_1
XFILLER_2_1295 VDD VSS sg13g2_decap_8
XFILLER_96_1291 VDD VSS sg13g2_decap_8
XFILLER_159_603 VDD VSS sg13g2_decap_8
X_14461__1718 _14461_/RESET_B VDD VSS sg13g2_tiehi
XFILLER_18_1204 VDD VSS sg13g2_decap_8
XFILLER_109_1332 VDD VSS sg13g2_decap_8
XFILLER_144_1212 VDD VSS sg13g2_decap_8
X_13847__2332 _13847_/RESET_B VDD VSS sg13g2_tiehi
XFILLER_57_1264 VDD VSS sg13g2_decap_4
X_14553_ _14553_/Q clkload21/A _14553_/D _14553_/RESET_B VDD VSS sg13g2_dfrbpq_1
X_11765_ _11765_/Y _11975_/A _11765_/B VDD VSS sg13g2_nor2_1
XFILLER_144_1234 VDD VSS sg13g2_decap_8
XFILLER_92_1177 VDD VSS sg13g2_decap_8
XFILLER_53_1128 VDD VSS sg13g2_fill_2
XFILLER_14_686 VDD VSS sg13g2_decap_8
X_13504_ _13504_/Y _13504_/A _15174_/D VDD VSS sg13g2_nor2b_1
X_10716_ _10716_/Y _10725_/A _10716_/B VDD VSS sg13g2_nor2_1
XFILLER_9_112 VDD VSS sg13g2_decap_8
X_14484_ _14484_/Q clkload15/A _14484_/D _14484_/RESET_B VDD VSS sg13g2_dfrbpq_1
X_11696_ _11696_/Y _11696_/A _12036_/B VDD VSS sg13g2_nand2_1
XFILLER_13_196 VDD VSS sg13g2_decap_8
XFILLER_158_168 VDD VSS sg13g2_decap_8
XFILLER_42_70 VDD VSS sg13g2_decap_8
X_13435_ _13435_/Y _13435_/A _13435_/B _13444_/C VDD VSS sg13g2_nor3_1
X_10647_ _10653_/B _10647_/A _14870_/Q _10647_/C _15250_/Q VDD VSS sg13g2_and4_1
XFILLER_173_105 VDD VSS sg13g2_decap_8
XFILLER_139_371 VDD VSS sg13g2_decap_4
XFILLER_9_189 VDD VSS sg13g2_decap_8
XFILLER_158_70 VDD VSS sg13g2_decap_8
XFILLER_155_842 VDD VSS sg13g2_decap_8
X_13366_ _13366_/Y _13427_/A _13427_/B _15075_/Q VDD VSS sg13g2_nand3_1
XFILLER_61_7 VDD VSS sg13g2_decap_8
XFILLER_154_341 VDD VSS sg13g2_decap_8
X_10578_ _10580_/C _10591_/C _10583_/D _14871_/Q VDD VSS sg13g2_a21oi_1
X_15105_ _15105_/Q clkload63/A _15105_/D _15105_/RESET_B VDD VSS sg13g2_dfrbpq_1
X_12317_ _12317_/X _12317_/A _12317_/B VDD VSS sg13g2_and2_1
X_13297_ _13297_/X _13297_/A0 wire649/X _13300_/C VDD VSS sg13g2_mux2_1
XFILLER_6_896 VDD VSS sg13g2_decap_8
XFILLER_170_845 VDD VSS sg13g2_fill_2
X_15036_ _15036_/Q clkload58/A _15036_/D _15036_/RESET_B VDD VSS sg13g2_dfrbpq_1
X_12248_ _12248_/Y _12252_/S0 _14424_/Q _12312_/B1 VDD VSS sg13g2_a21oi_1
XFILLER_64_1213 VDD VSS sg13g2_fill_1
XFILLER_96_612 VDD VSS sg13g2_decap_4
XFILLER_64_1246 VDD VSS sg13g2_decap_8
XFILLER_29_1366 VDD VSS sg13g2_decap_8
XFILLER_151_1205 VDD VSS sg13g2_fill_2
X_12179_ _12179_/Y _12175_/Y _12176_/Y _12178_/Y _12177_/Y _12216_/S VDD VSS sg13g2_a221oi_1
XFILLER_3_42 VDD VSS sg13g2_decap_8
XFILLER_95_111 VDD VSS sg13g2_decap_8
XFILLER_151_1238 VDD VSS sg13g2_decap_4
XFILLER_116_1369 VDD VSS sg13g2_fill_2
X_15067__2873 _15067_/RESET_B VDD VSS sg13g2_tiehi
XFILLER_96_678 VDD VSS sg13g2_decap_8
XFILLER_7_1162 VDD VSS sg13g2_decap_8
XFILLER_37_701 VDD VSS sg13g2_decap_8
XFILLER_3_1015 VDD VSS sg13g2_decap_8
XFILLER_49_594 VDD VSS sg13g2_fill_2
XFILLER_64_553 VDD VSS sg13g2_fill_1
X_08410_ _08410_/X _08410_/A _08410_/B _08410_/C _08410_/D VDD VSS sg13g2_and4_1
X_09390_ _13993_/D _09953_/A1 _13993_/Q _09406_/S VDD VSS sg13g2_mux2_1
XFILLER_91_383 VDD VSS sg13g2_fill_2
XFILLER_24_439 VDD VSS sg13g2_decap_8
X_08341_ _08341_/Y _08560_/A _08339_/Y _08340_/Y VDD VSS sg13g2_o21ai_1
XFILLER_162_1323 VDD VSS sg13g2_decap_8
X_14437__1742 _14437_/RESET_B VDD VSS sg13g2_tiehi
XFILLER_36_1337 VDD VSS sg13g2_decap_8
XFILLER_32_450 VDD VSS sg13g2_decap_8
X_08272_ _08603_/B _08270_/B _08082_/X _08688_/B VDD VSS sg13g2_o21ai_1
XFILLER_20_623 VDD VSS sg13g2_decap_8
XFILLER_165_606 VDD VSS sg13g2_fill_2
XFILLER_32_494 VDD VSS sg13g2_fill_1
XFILLER_164_105 VDD VSS sg13g2_decap_8
XFILLER_121_1042 VDD VSS sg13g2_decap_8
XFILLER_118_544 VDD VSS sg13g2_decap_8
XFILLER_145_330 VDD VSS sg13g2_fill_2
XFILLER_106_739 VDD VSS sg13g2_decap_8
XFILLER_161_845 VDD VSS sg13g2_decap_4
XFILLER_172_182 VDD VSS sg13g2_decap_8
XFILLER_160_344 VDD VSS sg13g2_decap_8
XFILLER_161_867 VDD VSS sg13g2_decap_8
XFILLER_154_28 VDD VSS sg13g2_decap_8
XFILLER_102_901 VDD VSS sg13g2_decap_4
XFILLER_114_761 VDD VSS sg13g2_fill_2
XFILLER_82_1335 VDD VSS sg13g2_decap_4
Xfanout146 _09937_/A1 _09166_/Y VDD VSS sg13g2_buf_1
XFILLER_102_967 VDD VSS sg13g2_fill_2
X_13925__2254 _13925_/RESET_B VDD VSS sg13g2_tiehi
Xfanout157 _09934_/A1 fanout162/X VDD VSS sg13g2_buf_1
X_14685__1494 _14685_/RESET_B VDD VSS sg13g2_tiehi
Xfanout168 _10097_/A0 _10131_/A0 VDD VSS sg13g2_buf_1
Xfanout179 _10162_/A1 fanout182/X VDD VSS sg13g2_buf_1
X_07987_ _07987_/Y _13290_/B _13300_/A _13499_/C _13290_/A VDD VSS sg13g2_nand4_1
XFILLER_59_369 VDD VSS sg13g2_decap_8
XFILLER_68_881 VDD VSS sg13g2_decap_8
X_09726_ _14317_/D _09924_/A1 _14317_/Q _09730_/S VDD VSS sg13g2_mux2_1
XFILLER_86_199 VDD VSS sg13g2_decap_8
XFILLER_28_734 VDD VSS sg13g2_fill_1
XFILLER_170_49 VDD VSS sg13g2_decap_8
XFILLER_167_1223 VDD VSS sg13g2_decap_8
X_09657_ _14250_/D _09921_/A1 _14250_/Q _09667_/S VDD VSS sg13g2_mux2_1
XFILLER_43_704 VDD VSS sg13g2_decap_8
XFILLER_41_1098 VDD VSS sg13g2_decap_4
XFILLER_15_406 VDD VSS sg13g2_decap_8
XFILLER_63_14 VDD VSS sg13g2_decap_8
X_08608_ _08608_/Y _08608_/A _08608_/B _08641_/C VDD VSS sg13g2_nor3_1
XFILLER_103_87 VDD VSS sg13g2_decap_8
X_09588_ _14185_/D _14185_/Q _09621_/A0 _09604_/S VDD VSS sg13g2_mux2_1
XFILLER_163_1109 VDD VSS sg13g2_decap_8
XFILLER_82_394 VDD VSS sg13g2_decap_8
XFILLER_169_912 VDD VSS sg13g2_decap_8
X_08539_ _08539_/Y _08378_/Y _08621_/A _08539_/B1 VDD VSS sg13g2_a21oi_1
XFILLER_70_578 VDD VSS sg13g2_decap_8
XFILLER_169_956 VDD VSS sg13g2_fill_1
XFILLER_11_623 VDD VSS sg13g2_decap_8
X_11550_ _11550_/Y _11649_/S0 _13828_/Q VDD VSS sg13g2_nand2b_1
XFILLER_23_483 VDD VSS sg13g2_decap_8
XFILLER_168_455 VDD VSS sg13g2_decap_8
XFILLER_10_133 VDD VSS sg13g2_decap_8
X_10501_ _10502_/C _14852_/Q _10513_/D _14850_/Q _14849_/Q VDD VSS sg13g2_nand4_1
XFILLER_155_105 VDD VSS sg13g2_decap_8
XFILLER_7_616 VDD VSS sg13g2_decap_8
XFILLER_109_500 VDD VSS sg13g2_decap_4
Xwire525 wire525/X wire525/A VDD VSS sg13g2_buf_2
X_11481_ _14963_/D _11461_/A _11501_/A2 _11480_/Y VDD VSS sg13g2_a21o_1
XFILLER_17_1281 VDD VSS sg13g2_decap_8
XFILLER_109_511 VDD VSS sg13g2_fill_1
XFILLER_137_820 VDD VSS sg13g2_decap_4
XFILLER_13_1134 VDD VSS sg13g2_decap_8
X_13220_ _13220_/Y _14794_/Q _13236_/A2 _13236_/B1 VDD VSS sg13g2_o21ai_1
XFILLER_6_126 VDD VSS sg13g2_decap_8
X_10432_ _14833_/D _14833_/Q _10434_/C _10431_/Y VDD VSS sg13g2_a21oi_1
XFILLER_100_1137 VDD VSS sg13g2_fill_1
XFILLER_12_84 VDD VSS sg13g2_decap_8
XFILLER_137_897 VDD VSS sg13g2_decap_8
XFILLER_164_672 VDD VSS sg13g2_fill_1
XFILLER_170_119 VDD VSS sg13g2_decap_8
X_13151_ _13151_/Y _14821_/Q _13068_/B _13162_/B1 _14885_/Q _13082_/B VDD VSS sg13g2_a221oi_1
XFILLER_87_1246 VDD VSS sg13g2_decap_8
XFILLER_136_374 VDD VSS sg13g2_decap_4
X_10363_ _10365_/A _14812_/Q _10359_/Y _14813_/Q VDD VSS sg13g2_a21o_1
XFILLER_139_1336 VDD VSS sg13g2_decap_4
XFILLER_3_833 VDD VSS sg13g2_decap_8
XFILLER_128_84 VDD VSS sg13g2_decap_4
XFILLER_163_182 VDD VSS sg13g2_decap_8
X_12102_ _12102_/Y _12252_/S0 _14388_/Q VDD VSS sg13g2_nand2b_1
XFILLER_88_44 VDD VSS sg13g2_fill_2
X_13082_ _13085_/A _14784_/Q _13082_/B VDD VSS sg13g2_nand2_1
X_10294_ _10295_/B _14791_/Q _14792_/Q _10294_/C VDD VSS sg13g2_nand3_1
XFILLER_2_343 VDD VSS sg13g2_decap_8
X_12033_ _12033_/Y _12235_/A _14514_/Q _12023_/B VDD VSS sg13g2_a21oi_1
XFILLER_137_1082 VDD VSS sg13g2_decap_8
XFILLER_104_282 VDD VSS sg13g2_decap_8
X_14515__1664 _14515_/RESET_B VDD VSS sg13g2_tiehi
XFILLER_77_155 VDD VSS sg13g2_fill_2
XFILLER_4_1302 VDD VSS sg13g2_decap_8
Xfanout680 _11340_/A1 _07683_/X VDD VSS sg13g2_buf_1
XFILLER_78_689 VDD VSS sg13g2_decap_8
XFILLER_65_306 VDD VSS sg13g2_decap_8
XFILLER_63_1290 VDD VSS sg13g2_decap_8
XFILLER_120_786 VDD VSS sg13g2_fill_2
Xfanout691 _12293_/A1 _12192_/A VDD VSS sg13g2_buf_1
XFILLER_93_637 VDD VSS sg13g2_decap_8
XFILLER_65_328 VDD VSS sg13g2_decap_8
X_13984_ _13984_/Q clkload29/A _13984_/D _13984_/RESET_B VDD VSS sg13g2_dfrbpq_1
XFILLER_58_380 VDD VSS sg13g2_decap_4
XFILLER_24_1274 VDD VSS sg13g2_decap_8
XFILLER_150_1282 VDD VSS sg13g2_fill_1
XFILLER_92_136 VDD VSS sg13g2_decap_8
XFILLER_20_1127 VDD VSS sg13g2_decap_8
XFILLER_19_756 VDD VSS sg13g2_decap_8
XFILLER_111_1255 VDD VSS sg13g2_fill_1
X_14769__2944 _14769_/RESET_B VDD VSS sg13g2_tiehi
X_12935_ _12937_/A _15061_/Q _15062_/Q VDD VSS sg13g2_nor2b_1
XFILLER_4_1379 VDD VSS sg13g2_fill_1
XFILLER_37_70 VDD VSS sg13g2_decap_8
XFILLER_34_704 VDD VSS sg13g2_fill_2
XFILLER_59_1337 VDD VSS sg13g2_fill_2
XFILLER_46_575 VDD VSS sg13g2_decap_8
XFILLER_18_266 VDD VSS sg13g2_decap_8
XFILLER_94_1239 VDD VSS sg13g2_decap_8
X_12866_ _12866_/X _12883_/A _12884_/C _12899_/C input24/X VDD VSS sg13g2_and4_1
XFILLER_2_1092 VDD VSS sg13g2_decap_8
Xclkbuf_leaf_113_clk_i _14728_/CLK clkbuf_5_6__f_clk_i/X VDD VSS sg13g2_buf_8
X_14605_ _14605_/Q clkload3/A _14605_/D _14605_/RESET_B VDD VSS sg13g2_dfrbpq_1
XFILLER_18_1001 VDD VSS sg13g2_decap_8
X_11817_ _11817_/Y _11821_/S0 _14412_/Q _11374_/C VDD VSS sg13g2_a21oi_1
XFILLER_15_973 VDD VSS sg13g2_decap_8
XFILLER_144_1020 VDD VSS sg13g2_fill_1
X_12797_ _12900_/B _12997_/B _12883_/A VDD VSS sg13g2_nand2b_1
XFILLER_30_910 VDD VSS sg13g2_decap_8
XFILLER_109_1151 VDD VSS sg13g2_fill_1
XFILLER_144_1031 VDD VSS sg13g2_decap_8
XFILLER_109_1162 VDD VSS sg13g2_decap_8
XFILLER_14_483 VDD VSS sg13g2_decap_8
X_14536_ _14536_/Q _14728_/CLK _14536_/D _14536_/RESET_B VDD VSS sg13g2_dfrbpq_1
X_11748_ _11748_/Y _11749_/A1 _14378_/Q VDD VSS sg13g2_nand2b_1
XFILLER_105_1015 VDD VSS sg13g2_decap_8
XFILLER_30_954 VDD VSS sg13g2_fill_1
XFILLER_105_1026 VDD VSS sg13g2_fill_1
XFILLER_30_965 VDD VSS sg13g2_fill_2
XFILLER_18_1078 VDD VSS sg13g2_decap_8
XFILLER_144_1086 VDD VSS sg13g2_fill_1
XFILLER_159_488 VDD VSS sg13g2_decap_4
XFILLER_169_91 VDD VSS sg13g2_decap_8
XFILLER_174_414 VDD VSS sg13g2_decap_8
XFILLER_105_1059 VDD VSS sg13g2_fill_2
XFILLER_147_639 VDD VSS sg13g2_fill_2
X_14467_ _14467_/Q clkload22/A _14467_/D _14467_/RESET_B VDD VSS sg13g2_dfrbpq_1
XFILLER_174_425 VDD VSS sg13g2_decap_8
XFILLER_128_831 VDD VSS sg13g2_decap_8
X_11679_ _11679_/X _12036_/B _11678_/X _11677_/Y VDD VSS sg13g2_a21o_1
XFILLER_139_190 VDD VSS sg13g2_fill_1
X_13418_ _15093_/D _13435_/B _13490_/D _13416_/Y VDD VSS sg13g2_o21ai_1
X_13663__2546 _13663_/RESET_B VDD VSS sg13g2_tiehi
X_14398_ _14398_/Q _14686_/CLK _14398_/D _14398_/RESET_B VDD VSS sg13g2_dfrbpq_1
XFILLER_31_1267 VDD VSS sg13g2_decap_8
XFILLER_142_300 VDD VSS sg13g2_decap_8
XFILLER_161_119 VDD VSS sg13g2_decap_8
X_13349_ _15070_/D _13351_/C _13348_/Y _13345_/Y VDD VSS sg13g2_o21ai_1
XFILLER_6_693 VDD VSS sg13g2_decap_8
XFILLER_143_878 VDD VSS sg13g2_decap_4
XFILLER_170_664 VDD VSS sg13g2_decap_8
XFILLER_130_517 VDD VSS sg13g2_fill_2
X_14914__2716 _14914_/RESET_B VDD VSS sg13g2_tiehi
XFILLER_97_921 VDD VSS sg13g2_decap_8
XFILLER_64_1032 VDD VSS sg13g2_fill_1
XFILLER_116_1100 VDD VSS sg13g2_decap_8
X_15019_ _15019_/Q clkload33/A _15019_/D _15019_/RESET_B VDD VSS sg13g2_dfrbpq_1
X_07910_ _07910_/Y _07910_/A _07910_/B VDD VSS sg13g2_nand2_1
X_08890_ _08890_/X _15036_/Q _14940_/Q _10725_/A VDD VSS sg13g2_mux2_1
XFILLER_69_623 VDD VSS sg13g2_decap_8
XFILLER_29_1163 VDD VSS sg13g2_decap_8
XFILLER_123_580 VDD VSS sg13g2_decap_8
XFILLER_9_1246 VDD VSS sg13g2_decap_8
XFILLER_111_731 VDD VSS sg13g2_fill_2
X_07841_ _07841_/Y _15018_/Q _08010_/B VDD VSS sg13g2_nand2_1
XFILLER_57_818 VDD VSS sg13g2_fill_2
XFILLER_84_615 VDD VSS sg13g2_decap_8
XFILLER_151_1068 VDD VSS sg13g2_decap_8
XFILLER_84_626 VDD VSS sg13g2_fill_1
XFILLER_42_1341 VDD VSS sg13g2_decap_8
X_07772_ _07797_/A _08318_/A _08318_/B VDD VSS sg13g2_or2_1
XFILLER_99_1139 VDD VSS sg13g2_fill_2
XFILLER_110_285 VDD VSS sg13g2_decap_8
XFILLER_84_648 VDD VSS sg13g2_decap_8
XFILLER_37_531 VDD VSS sg13g2_decap_8
X_09511_ _14110_/D _09610_/A0 _14110_/Q _09533_/S VDD VSS sg13g2_mux2_1
XFILLER_71_309 VDD VSS sg13g2_decap_8
X_09442_ _14043_/D _09574_/A1 _14043_/Q _09467_/S VDD VSS sg13g2_mux2_1
XFILLER_92_681 VDD VSS sg13g2_fill_1
XFILLER_24_203 VDD VSS sg13g2_decap_8
XFILLER_80_832 VDD VSS sg13g2_decap_8
X_09373_ _13977_/D _10101_/A0 _13977_/Q _09373_/S VDD VSS sg13g2_mux2_1
XFILLER_52_589 VDD VSS sg13g2_decap_4
XFILLER_33_28 VDD VSS sg13g2_decap_8
XFILLER_21_910 VDD VSS sg13g2_decap_8
X_08324_ _08335_/A _07796_/B _08322_/Y _08323_/Y VDD VSS sg13g2_a21o_1
X_14099__2080 _14099_/RESET_B VDD VSS sg13g2_tiehi
XFILLER_127_1273 VDD VSS sg13g2_fill_2
XFILLER_166_904 VDD VSS sg13g2_fill_1
XFILLER_149_28 VDD VSS sg13g2_decap_8
XFILLER_20_420 VDD VSS sg13g2_decap_8
XFILLER_138_617 VDD VSS sg13g2_fill_1
XFILLER_123_1126 VDD VSS sg13g2_fill_1
XFILLER_162_1186 VDD VSS sg13g2_decap_8
X_08255_ _08590_/B _08431_/A _08234_/Y _08426_/A _08426_/B VDD VSS sg13g2_a22oi_1
XFILLER_71_1069 VDD VSS sg13g2_fill_2
XFILLER_21_987 VDD VSS sg13g2_decap_8
X_15125__2709 _15125_/RESET_B VDD VSS sg13g2_tiehi
XFILLER_119_853 VDD VSS sg13g2_decap_8
XFILLER_20_497 VDD VSS sg13g2_decap_8
XFILLER_165_469 VDD VSS sg13g2_decap_8
X_08186_ _08187_/A _07876_/Y _08184_/Y _08185_/Y VDD VSS sg13g2_o21ai_1
XFILLER_119_886 VDD VSS sg13g2_decap_8
XFILLER_146_672 VDD VSS sg13g2_decap_8
Xclkbuf_leaf_92_clk_i _14886_/CLK clkbuf_leaf_92_clk_i/A VDD VSS sg13g2_buf_8
XFILLER_109_7 VDD VSS sg13g2_decap_8
XFILLER_134_845 VDD VSS sg13g2_decap_8
XFILLER_165_49 VDD VSS sg13g2_decap_8
XFILLER_121_506 VDD VSS sg13g2_fill_2
XFILLER_161_675 VDD VSS sg13g2_decap_4
XFILLER_0_814 VDD VSS sg13g2_decap_8
XFILLER_58_14 VDD VSS sg13g2_decap_8
XFILLER_160_196 VDD VSS sg13g2_decap_8
XFILLER_59_133 VDD VSS sg13g2_decap_8
XFILLER_47_1296 VDD VSS sg13g2_fill_1
XFILLER_87_453 VDD VSS sg13g2_decap_8
XFILLER_59_144 VDD VSS sg13g2_fill_2
XFILLER_48_818 VDD VSS sg13g2_decap_8
XFILLER_102_786 VDD VSS sg13g2_decap_8
XFILLER_130_1108 VDD VSS sg13g2_decap_8
XFILLER_74_103 VDD VSS sg13g2_decap_4
XFILLER_47_339 VDD VSS sg13g2_decap_8
XFILLER_28_520 VDD VSS sg13g2_decap_8
X_09709_ _14300_/D _10139_/A1 _14300_/Q _09733_/S VDD VSS sg13g2_mux2_1
XFILLER_74_35 VDD VSS sg13g2_fill_2
X_10981_ _10981_/Y _11009_/D _10978_/Y _10980_/Y VDD VSS sg13g2_o21ai_1
Xclkbuf_leaf_30_clk_i clkload19/A clkbuf_leaf_35_clk_i/A VDD VSS sg13g2_buf_8
XFILLER_83_670 VDD VSS sg13g2_decap_4
XFILLER_15_203 VDD VSS sg13g2_decap_8
XFILLER_167_1031 VDD VSS sg13g2_decap_8
X_12720_ _12720_/X _12718_/X _12719_/X _12720_/S VDD VSS sg13g2_mux2_1
X_14757__2959 _14757_/RESET_B VDD VSS sg13g2_tiehi
XFILLER_31_707 VDD VSS sg13g2_decap_8
X_12651_ _12652_/B _13129_/B _12707_/A2 _12650_/X _12679_/B2 _12707_/C1 VDD VSS sg13g2_a221oi_1
XFILLER_12_910 VDD VSS sg13g2_decap_8
XFILLER_169_731 VDD VSS sg13g2_decap_8
X_11602_ _11602_/Y _11993_/S0 _14566_/Q VDD VSS sg13g2_nand2b_1
X_12582_ _12583_/B _13064_/B _12707_/A2 _12581_/X _12679_/B2 _12707_/C1 VDD VSS sg13g2_a221oi_1
XFILLER_30_239 VDD VSS sg13g2_decap_8
XFILLER_19_1365 VDD VSS sg13g2_decap_8
XFILLER_106_1324 VDD VSS sg13g2_decap_4
XFILLER_11_420 VDD VSS sg13g2_decap_8
Xclkbuf_leaf_45_clk_i clkload27/A clkbuf_leaf_47_clk_i/A VDD VSS sg13g2_buf_8
XFILLER_23_280 VDD VSS sg13g2_decap_8
XFILLER_157_915 VDD VSS sg13g2_decap_8
XFILLER_15_1218 VDD VSS sg13g2_decap_8
XFILLER_168_252 VDD VSS sg13g2_decap_8
XFILLER_8_903 VDD VSS sg13g2_decap_8
XFILLER_129_617 VDD VSS sg13g2_decap_8
XFILLER_141_1226 VDD VSS sg13g2_fill_1
XFILLER_135_0 VDD VSS sg13g2_decap_8
X_14321_ _14321_/Q _14667_/CLK _14321_/D _14321_/RESET_B VDD VSS sg13g2_dfrbpq_1
XFILLER_12_987 VDD VSS sg13g2_decap_8
XFILLER_141_1237 VDD VSS sg13g2_decap_8
X_11533_ _11533_/Y _11533_/A _11533_/B _12188_/C VDD VSS sg13g2_nand3_1
XFILLER_54_1289 VDD VSS sg13g2_decap_8
XFILLER_157_959 VDD VSS sg13g2_decap_8
XFILLER_7_413 VDD VSS sg13g2_decap_8
XFILLER_11_497 VDD VSS sg13g2_decap_8
XFILLER_128_149 VDD VSS sg13g2_fill_2
X_14252_ _14252_/Q clkload35/A _14252_/D _14252_/RESET_B VDD VSS sg13g2_dfrbpq_1
X_11464_ _11465_/B _11463_/A _11463_/C _11463_/B VDD VSS sg13g2_o21ai_1
XFILLER_109_341 VDD VSS sg13g2_decap_4
XFILLER_99_21 VDD VSS sg13g2_decap_8
XFILLER_139_83 VDD VSS sg13g2_decap_8
XFILLER_99_32 VDD VSS sg13g2_fill_2
X_13203_ _13203_/Y _13202_/A _13202_/B _13224_/A VDD VSS sg13g2_a21oi_1
X_10415_ _14827_/D _10415_/A _10661_/A _10415_/C VDD VSS sg13g2_nor3_1
XFILLER_171_439 VDD VSS sg13g2_decap_8
XFILLER_125_834 VDD VSS sg13g2_decap_4
X_14183_ _14183_/Q _14735_/CLK _14183_/D _14183_/RESET_B VDD VSS sg13g2_dfrbpq_1
X_11395_ _11395_/Y _11395_/A _11745_/B VDD VSS sg13g2_nand2_1
XFILLER_152_631 VDD VSS sg13g2_decap_8
XFILLER_99_76 VDD VSS sg13g2_decap_8
XFILLER_152_642 VDD VSS sg13g2_fill_1
XFILLER_174_1013 VDD VSS sg13g2_fill_2
XFILLER_3_630 VDD VSS sg13g2_decap_8
X_13134_ _13134_/Y _13146_/B _13146_/C _13160_/B VDD VSS sg13g2_nand3_1
X_13797__2382 _13797_/RESET_B VDD VSS sg13g2_tiehi
X_10346_ _10352_/C _10400_/A _10397_/B VDD VSS sg13g2_nor2_1
XFILLER_98_718 VDD VSS sg13g2_decap_8
XFILLER_124_366 VDD VSS sg13g2_decap_8
XFILLER_140_815 VDD VSS sg13g2_decap_8
XFILLER_2_140 VDD VSS sg13g2_decap_8
X_13065_ _13067_/C _13066_/A _13066_/C _13172_/A VDD VSS sg13g2_o21ai_1
XFILLER_79_932 VDD VSS sg13g2_decap_4
XFILLER_174_1079 VDD VSS sg13g2_decap_4
XFILLER_151_185 VDD VSS sg13g2_decap_8
X_10277_ _10305_/B _14786_/Q _14787_/Q VDD VSS sg13g2_and2_1
XFILLER_79_943 VDD VSS sg13g2_decap_8
XFILLER_78_431 VDD VSS sg13g2_decap_8
X_12016_ _12018_/A _12017_/A _13906_/Q VDD VSS sg13g2_nand2b_1
XFILLER_26_1336 VDD VSS sg13g2_decap_8
XFILLER_24_7 VDD VSS sg13g2_decap_8
X_14031__2148 _14031_/RESET_B VDD VSS sg13g2_tiehi
XFILLER_94_946 VDD VSS sg13g2_decap_8
XFILLER_93_423 VDD VSS sg13g2_decap_8
XFILLER_78_497 VDD VSS sg13g2_decap_8
XFILLER_120_594 VDD VSS sg13g2_decap_8
XFILLER_94_957 VDD VSS sg13g2_fill_2
XFILLER_24_1071 VDD VSS sg13g2_decap_8
XFILLER_171_70 VDD VSS sg13g2_decap_8
XFILLER_0_21 VDD VSS sg13g2_decap_8
XFILLER_93_467 VDD VSS sg13g2_fill_1
XFILLER_19_553 VDD VSS sg13g2_decap_8
X_13967_ _13967_/Q clkload6/A _13967_/D _13967_/RESET_B VDD VSS sg13g2_dfrbpq_1
XFILLER_65_169 VDD VSS sg13g2_fill_1
XFILLER_4_1176 VDD VSS sg13g2_decap_8
XFILLER_59_1123 VDD VSS sg13g2_decap_8
XFILLER_47_895 VDD VSS sg13g2_decap_8
X_12918_ _12918_/Y _14774_/Q _12918_/A2 _13275_/B1 VDD VSS sg13g2_o21ai_1
XFILLER_146_1104 VDD VSS sg13g2_fill_2
XFILLER_62_843 VDD VSS sg13g2_decap_8
XFILLER_0_98 VDD VSS sg13g2_decap_8
X_13898_ _13898_/Q clkload12/A _13898_/D _13898_/RESET_B VDD VSS sg13g2_dfrbpq_1
XFILLER_146_1137 VDD VSS sg13g2_decap_8
X_12849_ _12849_/Y _12848_/X _12846_/Y _12878_/D VDD VSS sg13g2_o21ai_1
XFILLER_15_770 VDD VSS sg13g2_decap_8
XFILLER_21_217 VDD VSS sg13g2_decap_8
XFILLER_14_280 VDD VSS sg13g2_decap_8
XFILLER_159_252 VDD VSS sg13g2_decap_8
XFILLER_9_63 VDD VSS sg13g2_decap_8
X_14519_ _14519_/Q clkload28/A _14519_/D _14519_/RESET_B VDD VSS sg13g2_dfrbpq_1
XFILLER_30_762 VDD VSS sg13g2_decap_8
XFILLER_119_116 VDD VSS sg13g2_fill_2
XFILLER_163_907 VDD VSS sg13g2_decap_8
X_08040_ _08040_/Y _08246_/A1 _08016_/Y _08021_/Y _08032_/Y _08039_/Y VDD VSS sg13g2_a221oi_1
XFILLER_134_119 VDD VSS sg13g2_decap_8
XFILLER_7_980 VDD VSS sg13g2_decap_8
XFILLER_174_288 VDD VSS sg13g2_decap_8
XFILLER_128_694 VDD VSS sg13g2_fill_2
XFILLER_162_439 VDD VSS sg13g2_decap_8
XFILLER_174_299 VDD VSS sg13g2_decap_8
XFILLER_66_1105 VDD VSS sg13g2_decap_8
XFILLER_50_0 VDD VSS sg13g2_decap_8
XFILLER_171_940 VDD VSS sg13g2_decap_4
XFILLER_127_193 VDD VSS sg13g2_fill_1
XFILLER_6_490 VDD VSS sg13g2_decap_8
XFILLER_142_130 VDD VSS sg13g2_decap_8
X_14241__1938 _14241_/RESET_B VDD VSS sg13g2_tiehi
XFILLER_89_707 VDD VSS sg13g2_decap_8
X_14387__1792 _14387_/RESET_B VDD VSS sg13g2_tiehi
X_09991_ _14574_/D _10090_/A0 _14574_/Q _09997_/S VDD VSS sg13g2_mux2_1
XFILLER_171_984 VDD VSS sg13g2_fill_1
XFILLER_143_697 VDD VSS sg13g2_decap_8
XFILLER_170_483 VDD VSS sg13g2_decap_8
Xhold3027 hold3027/X input5/X VDD VSS sg13g2_dlygate4sd3_1
XFILLER_142_185 VDD VSS sg13g2_decap_8
Xhold3038 input34/A mem_axi_rdata[8] VDD VSS sg13g2_dlygate4sd3_1
X_08942_ _08942_/Y _10781_/C _10781_/B _15050_/Q VDD VSS sg13g2_nand3_1
XFILLER_69_420 VDD VSS sg13g2_fill_1
Xhold3049 input35/A hold3093/X VDD VSS sg13g2_dlygate4sd3_1
XFILLER_9_1043 VDD VSS sg13g2_decap_8
XFILLER_97_762 VDD VSS sg13g2_decap_8
X_08873_ _08873_/Y _10788_/S _14936_/Q VDD VSS sg13g2_nor2b_1
XFILLER_96_250 VDD VSS sg13g2_decap_4
XFILLER_111_561 VDD VSS sg13g2_fill_2
X_15154__2649 _15154_/RESET_B VDD VSS sg13g2_tiehi
XFILLER_28_28 VDD VSS sg13g2_decap_8
XFILLER_111_583 VDD VSS sg13g2_fill_1
X_07824_ _07829_/A _08553_/A _07954_/B _08527_/A _08527_/B VDD VSS sg13g2_nor4_1
XFILLER_111_594 VDD VSS sg13g2_decap_8
X_14007__2172 _14007_/RESET_B VDD VSS sg13g2_tiehi
XFILLER_85_957 VDD VSS sg13g2_decap_8
X_07755_ _07755_/Y _08831_/B _11458_/A _13320_/C VDD VSS sg13g2_o21ai_1
XFILLER_72_629 VDD VSS sg13g2_decap_4
XFILLER_168_1351 VDD VSS sg13g2_decap_8
XFILLER_53_832 VDD VSS sg13g2_decap_8
X_07686_ _07687_/C _13304_/B _07684_/B _07684_/Y VDD VSS sg13g2_o21ai_1
XFILLER_77_1245 VDD VSS sg13g2_decap_8
XFILLER_44_49 VDD VSS sg13g2_decap_8
XFILLER_25_556 VDD VSS sg13g2_fill_1
XFILLER_13_707 VDD VSS sg13g2_decap_8
X_09425_ _14027_/D _09623_/A0 _14027_/Q _09431_/S VDD VSS sg13g2_mux2_1
XFILLER_53_898 VDD VSS sg13g2_decap_8
XFILLER_25_589 VDD VSS sg13g2_decap_8
XFILLER_12_217 VDD VSS sg13g2_decap_8
XFILLER_80_695 VDD VSS sg13g2_decap_4
X_09356_ _13960_/D _09853_/A1 _13960_/Q _09365_/S VDD VSS sg13g2_mux2_1
XFILLER_166_701 VDD VSS sg13g2_decap_4
XFILLER_127_1081 VDD VSS sg13g2_decap_8
XFILLER_138_403 VDD VSS sg13g2_decap_8
X_08307_ _08312_/A _08303_/Y _08305_/Y _08306_/Y VDD VSS sg13g2_o21ai_1
XFILLER_138_425 VDD VSS sg13g2_decap_8
X_09287_ _13895_/D _13895_/Q _09720_/A0 _09301_/S VDD VSS sg13g2_mux2_1
XFILLER_166_745 VDD VSS sg13g2_fill_1
XFILLER_21_784 VDD VSS sg13g2_decap_8
XFILLER_154_907 VDD VSS sg13g2_decap_8
X_08238_ _08238_/Y _08265_/A _08238_/B VDD VSS sg13g2_nor2_1
XFILLER_154_918 VDD VSS sg13g2_fill_2
XFILLER_153_406 VDD VSS sg13g2_fill_2
XFILLER_5_917 VDD VSS sg13g2_decap_8
XFILLER_20_294 VDD VSS sg13g2_decap_8
XFILLER_119_661 VDD VSS sg13g2_fill_2
XFILLER_165_266 VDD VSS sg13g2_decap_8
XFILLER_88_1330 VDD VSS sg13g2_decap_8
XFILLER_107_823 VDD VSS sg13g2_decap_8
XFILLER_14_1295 VDD VSS sg13g2_decap_8
X_08169_ _08169_/Y _08014_/B _08052_/Y _08688_/A VDD VSS sg13g2_o21ai_1
XFILLER_4_427 VDD VSS sg13g2_decap_8
XFILLER_10_1148 VDD VSS sg13g2_decap_8
XFILLER_106_333 VDD VSS sg13g2_decap_8
X_10200_ _14757_/D _15181_/D _14757_/Q _13346_/A VDD VSS sg13g2_mux2_1
XFILLER_107_867 VDD VSS sg13g2_fill_1
XFILLER_49_1336 VDD VSS sg13g2_decap_8
X_11180_ _11190_/A _11180_/A _11181_/A _11180_/C VDD VSS sg13g2_nand3_1
XFILLER_161_450 VDD VSS sg13g2_decap_4
XFILLER_134_675 VDD VSS sg13g2_decap_8
XFILLER_162_984 VDD VSS sg13g2_decap_8
X_14217__1962 _14217_/RESET_B VDD VSS sg13g2_tiehi
XFILLER_161_472 VDD VSS sg13g2_decap_8
X_10131_ _14709_/D _10131_/A0 _14709_/Q _10135_/S VDD VSS sg13g2_mux2_1
XFILLER_0_644 VDD VSS sg13g2_decap_8
XFILLER_88_740 VDD VSS sg13g2_decap_4
XFILLER_121_358 VDD VSS sg13g2_decap_4
X_10062_ _14643_/D _10095_/A0 _14643_/Q _10064_/S VDD VSS sg13g2_mux2_1
XFILLER_48_604 VDD VSS sg13g2_decap_8
XFILLER_88_784 VDD VSS sg13g2_fill_2
X_14870_ _14870_/Q _14874_/CLK _14870_/D _14870_/RESET_B VDD VSS sg13g2_dfrbpq_1
XFILLER_47_125 VDD VSS sg13g2_decap_8
XFILLER_48_659 VDD VSS sg13g2_decap_8
XFILLER_21_1211 VDD VSS sg13g2_decap_8
XFILLER_91_905 VDD VSS sg13g2_decap_8
XFILLER_75_456 VDD VSS sg13g2_fill_1
X_13821_ _13821_/Q clkload45/A _13821_/D _13821_/RESET_B VDD VSS sg13g2_dfrbpq_1
XFILLER_169_1148 VDD VSS sg13g2_decap_8
XFILLER_1_1316 VDD VSS sg13g2_decap_8
XFILLER_62_117 VDD VSS sg13g2_decap_8
XFILLER_95_1334 VDD VSS sg13g2_decap_8
X_13752_ _13752_/Q clkload23/A _13752_/D _13752_/RESET_B VDD VSS sg13g2_dfrbpq_1
XFILLER_90_448 VDD VSS sg13g2_fill_1
XFILLER_21_1288 VDD VSS sg13g2_decap_8
X_10964_ _10964_/Y _11004_/B _10964_/B VDD VSS sg13g2_xnor2_1
XFILLER_95_1345 VDD VSS sg13g2_fill_1
XFILLER_55_191 VDD VSS sg13g2_decap_8
XFILLER_56_1318 VDD VSS sg13g2_fill_1
XFILLER_44_865 VDD VSS sg13g2_decap_8
XFILLER_16_567 VDD VSS sg13g2_decap_8
X_12703_ _12703_/X _13748_/Q _14100_/Q _14452_/Q _14548_/Q _12703_/S0 _12703_/S1 VDD
+ VSS sg13g2_mux4_1
X_13683_ _13683_/Q clkload56/A _13683_/D _13683_/RESET_B VDD VSS sg13g2_dfrbpq_1
X_10895_ _10895_/Y _10948_/A _10893_/X _11027_/B1 VDD VSS sg13g2_o21ai_1
XFILLER_70_161 VDD VSS sg13g2_decap_8
XFILLER_43_386 VDD VSS sg13g2_decap_8
XFILLER_31_537 VDD VSS sg13g2_decap_8
X_12634_ _12634_/X _12631_/X _12630_/X _12627_/X _12626_/X _12663_/S1 _12678_/S VDD
+ VSS sg13g2_mux4_1
X_13705__2474 _13705_/RESET_B VDD VSS sg13g2_tiehi
XFILLER_19_1162 VDD VSS sg13g2_decap_8
XFILLER_8_700 VDD VSS sg13g2_decap_8
XFILLER_15_1015 VDD VSS sg13g2_decap_8
X_12565_ _12565_/X _12564_/X _12563_/X _12560_/X _12559_/X _12705_/S0 _12706_/S VDD
+ VSS sg13g2_mux4_1
XFILLER_12_784 VDD VSS sg13g2_decap_8
XFILLER_7_210 VDD VSS sg13g2_decap_8
XFILLER_129_458 VDD VSS sg13g2_decap_8
XFILLER_145_907 VDD VSS sg13g2_decap_8
X_14304_ _14304_/Q clkload31/A _14304_/D _14304_/RESET_B VDD VSS sg13g2_dfrbpq_1
X_11516_ _11516_/Y _11516_/A VDD VSS sg13g2_inv_1
XFILLER_11_294 VDD VSS sg13g2_decap_8
XFILLER_32_1351 VDD VSS sg13g2_decap_8
XFILLER_172_704 VDD VSS sg13g2_fill_2
XFILLER_138_970 VDD VSS sg13g2_fill_2
XFILLER_144_406 VDD VSS sg13g2_decap_8
XFILLER_157_789 VDD VSS sg13g2_decap_8
X_12496_ _12496_/X _12494_/X _12493_/X _12490_/X _12489_/X _12663_/S1 _12663_/S0 VDD
+ VSS sg13g2_mux4_1
XFILLER_8_777 VDD VSS sg13g2_decap_8
XFILLER_171_203 VDD VSS sg13g2_decap_8
XFILLER_109_160 VDD VSS sg13g2_decap_8
X_14235_ _14235_/Q _14653_/CLK _14235_/D _14235_/RESET_B VDD VSS sg13g2_dfrbpq_1
X_11447_ _11448_/A _12214_/B _11444_/X _11446_/Y VDD VSS sg13g2_o21ai_1
XFILLER_7_287 VDD VSS sg13g2_decap_8
XFILLER_125_642 VDD VSS sg13g2_decap_8
XFILLER_166_70 VDD VSS sg13g2_decap_8
XFILLER_171_247 VDD VSS sg13g2_decap_8
XFILLER_113_804 VDD VSS sg13g2_decap_8
X_14166_ _14166_/Q _14984_/CLK _14166_/D _14166_/RESET_B VDD VSS sg13g2_dfrbpq_1
X_11378_ _11378_/X _11369_/Y _11377_/Y _11378_/S VDD VSS sg13g2_mux2_1
XFILLER_153_995 VDD VSS sg13g2_decap_8
XFILLER_152_472 VDD VSS sg13g2_fill_1
X_13117_ _13120_/A _13078_/A _13113_/X _13171_/A VDD VSS sg13g2_a21oi_1
X_10329_ _10331_/A _10414_/B _10345_/C _14803_/Q VDD VSS sg13g2_a21o_1
XFILLER_4_994 VDD VSS sg13g2_decap_8
XFILLER_140_634 VDD VSS sg13g2_decap_8
X_14097_ _14097_/Q clkload5/A _14097_/D _14097_/RESET_B VDD VSS sg13g2_dfrbpq_1
XFILLER_112_347 VDD VSS sg13g2_fill_1
XFILLER_79_740 VDD VSS sg13g2_decap_4
XFILLER_65_1160 VDD VSS sg13g2_decap_8
XFILLER_26_1133 VDD VSS sg13g2_decap_8
X_13048_ _13048_/X _13048_/A _13048_/B VDD VSS sg13g2_and2_1
XFILLER_94_710 VDD VSS sg13g2_decap_8
Xfanout1250 _11852_/S1 _11762_/S1 VDD VSS sg13g2_buf_1
XFILLER_94_721 VDD VSS sg13g2_fill_1
Xfanout1261 _11762_/S1 _12215_/S1 VDD VSS sg13g2_buf_1
Xfanout1272 _12307_/C _12319_/B1 VDD VSS sg13g2_buf_1
Xfanout1283 _11715_/S1 _12288_/S1 VDD VSS sg13g2_buf_1
Xfanout1294 _11848_/S0 _11852_/S0 VDD VSS sg13g2_buf_1
XFILLER_38_147 VDD VSS sg13g2_decap_8
XFILLER_19_350 VDD VSS sg13g2_decap_8
X_14999_ _14999_/Q clkload32/A _14999_/D _14999_/RESET_B VDD VSS sg13g2_dfrbpq_1
XFILLER_53_106 VDD VSS sg13g2_fill_1
XFILLER_53_117 VDD VSS sg13g2_decap_8
XFILLER_93_297 VDD VSS sg13g2_decap_8
XFILLER_34_331 VDD VSS sg13g2_decap_4
XFILLER_90_971 VDD VSS sg13g2_decap_8
XFILLER_22_504 VDD VSS sg13g2_decap_8
XFILLER_35_898 VDD VSS sg13g2_fill_2
XFILLER_61_161 VDD VSS sg13g2_decap_8
X_09210_ _13821_/D _09310_/A0 _13821_/Q _09233_/S VDD VSS sg13g2_mux2_1
XFILLER_50_846 VDD VSS sg13g2_fill_1
XFILLER_98_0 VDD VSS sg13g2_decap_8
XFILLER_22_548 VDD VSS sg13g2_fill_1
XFILLER_22_559 VDD VSS sg13g2_decap_8
XFILLER_148_712 VDD VSS sg13g2_decap_8
XFILLER_33_1104 VDD VSS sg13g2_decap_8
X_09141_ _09145_/A _09141_/A _10781_/A _10781_/B VDD VSS sg13g2_nand3_1
XFILLER_148_723 VDD VSS sg13g2_fill_1
XFILLER_148_745 VDD VSS sg13g2_fill_1
XFILLER_72_1186 VDD VSS sg13g2_decap_8
XFILLER_147_244 VDD VSS sg13g2_decap_4
X_09072_ _09072_/Y _15236_/Q _09072_/B VDD VSS sg13g2_nand2b_1
XFILLER_163_726 VDD VSS sg13g2_fill_1
XFILLER_162_203 VDD VSS sg13g2_decap_8
X_08023_ _08023_/Y _13517_/A _08063_/B VDD VSS sg13g2_nand2_1
X_14474__1705 _14474_/RESET_B VDD VSS sg13g2_tiehi
XFILLER_116_620 VDD VSS sg13g2_fill_1
XFILLER_128_480 VDD VSS sg13g2_decap_8
XFILLER_144_962 VDD VSS sg13g2_fill_1
XFILLER_157_1030 VDD VSS sg13g2_decap_4
XFILLER_116_675 VDD VSS sg13g2_decap_8
XFILLER_115_152 VDD VSS sg13g2_decap_8
XFILLER_118_1014 VDD VSS sg13g2_decap_8
XFILLER_143_472 VDD VSS sg13g2_decap_8
XFILLER_170_280 VDD VSS sg13g2_decap_8
X_09974_ _14557_/D _10107_/A0 _14557_/Q _09997_/S VDD VSS sg13g2_mux2_1
XFILLER_83_1260 VDD VSS sg13g2_decap_8
XFILLER_44_1222 VDD VSS sg13g2_fill_1
XFILLER_131_678 VDD VSS sg13g2_decap_8
XFILLER_170_1230 VDD VSS sg13g2_decap_8
X_08925_ _08925_/X _08924_/X _12009_/A _08931_/S VDD VSS sg13g2_mux2_1
XFILLER_83_1282 VDD VSS sg13g2_decap_8
XFILLER_39_49 VDD VSS sg13g2_decap_8
XFILLER_131_689 VDD VSS sg13g2_decap_8
XFILLER_162_28 VDD VSS sg13g2_decap_8
XFILLER_69_250 VDD VSS sg13g2_decap_8
X_08856_ _08856_/X _15027_/Q _14931_/Q _10725_/A VDD VSS sg13g2_mux2_1
XFILLER_85_743 VDD VSS sg13g2_decap_8
XFILLER_170_1296 VDD VSS sg13g2_decap_8
X_07807_ _07828_/C _07950_/A _07949_/B _07807_/C _08476_/A VDD VSS sg13g2_nand4_1
XFILLER_57_478 VDD VSS sg13g2_decap_8
X_08787_ _08787_/Y _13681_/Q _08818_/B VDD VSS sg13g2_nor2_1
XFILLER_73_938 VDD VSS sg13g2_decap_4
XFILLER_26_810 VDD VSS sg13g2_fill_1
X_07738_ _07738_/Y _13302_/C _13300_/C _07754_/B VDD VSS sg13g2_nand3_1
X_13962__2217 _13962_/RESET_B VDD VSS sg13g2_tiehi
XFILLER_111_21 VDD VSS sg13g2_decap_8
XFILLER_53_651 VDD VSS sg13g2_decap_8
XFILLER_53_662 VDD VSS sg13g2_fill_1
XFILLER_26_876 VDD VSS sg13g2_decap_4
XFILLER_0_1360 VDD VSS sg13g2_decap_8
XFILLER_13_504 VDD VSS sg13g2_decap_8
XFILLER_53_673 VDD VSS sg13g2_decap_8
XFILLER_38_1026 VDD VSS sg13g2_decap_8
X_07669_ _10172_/C _13508_/B _08721_/S _10171_/D VDD VSS sg13g2_o21ai_1
XFILLER_71_14 VDD VSS sg13g2_decap_8
XFILLER_40_312 VDD VSS sg13g2_fill_1
XFILLER_111_76 VDD VSS sg13g2_decap_8
X_09408_ _09408_/Y _10037_/B _09441_/D VDD VSS sg13g2_nand2_1
X_10680_ _10844_/B _08980_/X _10669_/S _08844_/Y VDD VSS sg13g2_a21o_1
XFILLER_16_1302 VDD VSS sg13g2_decap_8
XFILLER_90_1253 VDD VSS sg13g2_fill_2
XFILLER_138_200 VDD VSS sg13g2_decap_8
XFILLER_139_723 VDD VSS sg13g2_decap_8
X_09339_ _13946_/D _10169_/A1 _13946_/Q _09339_/S VDD VSS sg13g2_mux2_1
XFILLER_142_1365 VDD VSS sg13g2_fill_2
XFILLER_21_581 VDD VSS sg13g2_decap_8
XFILLER_166_553 VDD VSS sg13g2_decap_8
XFILLER_16_1379 VDD VSS sg13g2_decap_4
XFILLER_127_918 VDD VSS sg13g2_decap_8
X_12350_ _12350_/X _14683_/Q _14715_/Q _13755_/Q _13787_/Q _12352_/S0 _12352_/S1 VDD
+ VSS sg13g2_mux4_1
XFILLER_127_929 VDD VSS sg13g2_fill_1
XFILLER_5_714 VDD VSS sg13g2_decap_8
X_11301_ _11301_/Y _11300_/X _11329_/B1 _11299_/Y VDD VSS sg13g2_a21oi_1
X_12281_ _12281_/X _14585_/Q _14617_/Q _14649_/Q _14681_/Q _12286_/S0 _12286_/S1 VDD
+ VSS sg13g2_mux4_1
XFILLER_107_620 VDD VSS sg13g2_decap_8
XFILLER_14_1092 VDD VSS sg13g2_decap_8
XFILLER_153_236 VDD VSS sg13g2_decap_8
XFILLER_4_224 VDD VSS sg13g2_decap_8
X_14020_ _14020_/Q clkload17/A _14020_/D _14020_/RESET_B VDD VSS sg13g2_dfrbpq_1
X_11232_ _11232_/Y _15115_/Q _15116_/Q VDD VSS sg13g2_nor2_1
XFILLER_101_1084 VDD VSS sg13g2_decap_8
XFILLER_162_770 VDD VSS sg13g2_decap_8
XFILLER_101_1095 VDD VSS sg13g2_fill_2
XFILLER_107_686 VDD VSS sg13g2_decap_8
XFILLER_135_995 VDD VSS sg13g2_decap_8
XFILLER_20_84 VDD VSS sg13g2_decap_8
XFILLER_136_1125 VDD VSS sg13g2_decap_8
X_11163_ _11180_/A _11163_/A _11164_/C VDD VSS sg13g2_nor2_1
XFILLER_1_931 VDD VSS sg13g2_decap_8
XFILLER_62_1300 VDD VSS sg13g2_fill_1
XFILLER_136_84 VDD VSS sg13g2_decap_4
XFILLER_84_1079 VDD VSS sg13g2_decap_8
XFILLER_136_1158 VDD VSS sg13g2_decap_8
X_10114_ _14692_/D _10147_/A1 _14692_/Q _10135_/S VDD VSS sg13g2_mux2_1
XFILLER_0_441 VDD VSS sg13g2_decap_8
X_11094_ _11095_/B _11118_/C _11094_/B VDD VSS sg13g2_nor2_1
XFILLER_62_1333 VDD VSS sg13g2_decap_8
XFILLER_96_66 VDD VSS sg13g2_fill_1
XFILLER_103_881 VDD VSS sg13g2_fill_1
XFILLER_96_88 VDD VSS sg13g2_decap_8
XFILLER_88_581 VDD VSS sg13g2_fill_2
XFILLER_48_412 VDD VSS sg13g2_decap_8
X_14922_ _14922_/Q clkload52/A _14922_/D _14922_/RESET_B VDD VSS sg13g2_dfrbpq_1
X_10045_ _14626_/D _10045_/A0 _14626_/Q _10064_/S VDD VSS sg13g2_mux2_1
XFILLER_102_380 VDD VSS sg13g2_decap_8
XFILLER_23_1328 VDD VSS sg13g2_decap_8
X_14853_ _14853_/Q _14854_/CLK _14853_/D _14853_/RESET_B VDD VSS sg13g2_dfrbpq_1
XFILLER_5_1260 VDD VSS sg13g2_decap_8
XFILLER_1_1113 VDD VSS sg13g2_decap_8
X_13804_ _13804_/Q clkload35/A _13804_/D _13804_/RESET_B VDD VSS sg13g2_dfrbpq_1
X_14784_ _14784_/Q _14894_/CLK _14784_/D _14784_/RESET_B VDD VSS sg13g2_dfrbpq_1
X_11996_ _11996_/X _14577_/Q _14609_/Q _14641_/Q _14673_/Q _11996_/S0 _11996_/S1 VDD
+ VSS sg13g2_mux4_1
XFILLER_21_1085 VDD VSS sg13g2_decap_8
XFILLER_17_854 VDD VSS sg13g2_decap_8
X_14552__1627 _14552_/RESET_B VDD VSS sg13g2_tiehi
X_13735_ _13735_/Q _14607_/CLK _13735_/D _13735_/RESET_B VDD VSS sg13g2_dfrbpq_1
X_13938__2241 _13938_/RESET_B VDD VSS sg13g2_tiehi
XFILLER_45_70 VDD VSS sg13g2_decap_8
XFILLER_16_364 VDD VSS sg13g2_decap_8
X_14698__1481 _14698_/RESET_B VDD VSS sg13g2_tiehi
X_10947_ _11007_/B _10932_/B _10946_/Y _10945_/Y _10944_/Y VDD VSS sg13g2_a22oi_1
XFILLER_44_673 VDD VSS sg13g2_decap_8
XFILLER_91_1039 VDD VSS sg13g2_decap_8
X_13666_ _13666_/Q clkload64/A _13666_/D _13666_/RESET_B VDD VSS sg13g2_dfrbpq_1
XFILLER_91_7 VDD VSS sg13g2_decap_8
XFILLER_147_1298 VDD VSS sg13g2_decap_8
X_10878_ _10878_/Y _10923_/D _10878_/B VDD VSS sg13g2_nand2_1
XFILLER_32_879 VDD VSS sg13g2_decap_8
XFILLER_31_356 VDD VSS sg13g2_decap_8
XFILLER_129_200 VDD VSS sg13g2_decap_4
X_12617_ _12617_/X _14574_/Q _14606_/Q _14638_/Q _14670_/Q _12617_/S0 _12617_/S1 VDD
+ VSS sg13g2_mux4_1
X_14842__2860 _14842_/RESET_B VDD VSS sg13g2_tiehi
XFILLER_157_531 VDD VSS sg13g2_decap_8
X_13597_ _13597_/Y _12798_/Y _13596_/Y _08830_/X VDD VSS sg13g2_o21ai_1
XFILLER_12_581 VDD VSS sg13g2_decap_8
X_12548_ _12548_/X _13737_/Q _14089_/Q _14441_/Q _14537_/Q _12767_/S0 _12767_/S1 VDD
+ VSS sg13g2_mux4_1
XFILLER_61_91 VDD VSS sg13g2_decap_8
XFILLER_157_586 VDD VSS sg13g2_fill_1
XFILLER_8_574 VDD VSS sg13g2_decap_8
XFILLER_172_512 VDD VSS sg13g2_decap_8
XFILLER_145_748 VDD VSS sg13g2_decap_8
XANTENNA_2 _16872_/A VDD VSS sg13g2_antennanp
X_12479_ _12479_/X _13828_/Q _13860_/Q _13892_/Q _13924_/Q _12716_/S0 _12716_/S1 VDD
+ VSS sg13g2_mux4_1
XFILLER_6_42 VDD VSS sg13g2_decap_8
XFILLER_160_707 VDD VSS sg13g2_decap_8
X_14218_ _14218_/Q _14666_/CLK _14218_/D _14218_/RESET_B VDD VSS sg13g2_dfrbpq_1
X_14875__2794 _14875_/RESET_B VDD VSS sg13g2_tiehi
XFILLER_158_1350 VDD VSS sg13g2_decap_8
XFILLER_113_601 VDD VSS sg13g2_decap_8
XFILLER_126_984 VDD VSS sg13g2_decap_8
X_15198_ _15198_/Q clkload64/A _15198_/D _15198_/RESET_B VDD VSS sg13g2_dfrbpq_1
XFILLER_99_835 VDD VSS sg13g2_decap_8
XFILLER_28_1217 VDD VSS sg13g2_decap_8
XFILLER_141_943 VDD VSS sg13g2_decap_8
XFILLER_152_280 VDD VSS sg13g2_decap_8
X_14149_ _14149_/Q _14725_/CLK _14149_/D _14149_/RESET_B VDD VSS sg13g2_dfrbpq_1
XFILLER_4_791 VDD VSS sg13g2_decap_8
Xfanout509 _13565_/S _13570_/S VDD VSS sg13g2_buf_1
XFILLER_63_1119 VDD VSS sg13g2_fill_2
XFILLER_99_879 VDD VSS sg13g2_decap_8
XFILLER_67_1299 VDD VSS sg13g2_fill_2
XFILLER_112_155 VDD VSS sg13g2_fill_1
XFILLER_86_529 VDD VSS sg13g2_decap_8
XFILLER_67_710 VDD VSS sg13g2_fill_1
XFILLER_100_328 VDD VSS sg13g2_decap_4
X_08710_ _13660_/D _15187_/D _15118_/Q _13652_/S VDD VSS sg13g2_mux2_1
X_14752__2964 _14752_/RESET_B VDD VSS sg13g2_tiehi
X_09690_ _14282_/D _09921_/A1 _14282_/Q _09700_/S VDD VSS sg13g2_mux2_1
XFILLER_6_1057 VDD VSS sg13g2_decap_8
XFILLER_13_0 VDD VSS sg13g2_decap_8
Xfanout1080 _07900_/B _08253_/S0 VDD VSS sg13g2_buf_1
Xfanout1091 _12229_/A _14986_/Q VDD VSS sg13g2_buf_1
X_08641_ _08641_/Y _08641_/A _08641_/B _08641_/C _08641_/D VDD VSS sg13g2_nor4_1
XFILLER_67_787 VDD VSS sg13g2_decap_8
XFILLER_27_618 VDD VSS sg13g2_decap_4
XFILLER_82_724 VDD VSS sg13g2_fill_1
XFILLER_94_595 VDD VSS sg13g2_decap_8
XFILLER_82_735 VDD VSS sg13g2_decap_8
XFILLER_48_990 VDD VSS sg13g2_decap_4
X_14191__1988 _14191_/RESET_B VDD VSS sg13g2_tiehi
X_08572_ _08573_/A _08445_/Y _08571_/Y _08570_/Y VDD VSS sg13g2_o21ai_1
XFILLER_130_1291 VDD VSS sg13g2_decap_4
XFILLER_81_245 VDD VSS sg13g2_decap_8
XFILLER_74_1204 VDD VSS sg13g2_decap_8
X_14528__1651 _14528_/RESET_B VDD VSS sg13g2_tiehi
XFILLER_22_301 VDD VSS sg13g2_decap_8
XFILLER_62_481 VDD VSS sg13g2_decap_8
XFILLER_50_621 VDD VSS sg13g2_decap_8
XFILLER_39_1379 VDD VSS sg13g2_fill_1
XFILLER_10_518 VDD VSS sg13g2_decap_8
XFILLER_22_378 VDD VSS sg13g2_decap_8
XFILLER_41_28 VDD VSS sg13g2_decap_8
X_09124_ _09157_/C _14919_/Q _13189_/A _10760_/A _09150_/B VDD VSS sg13g2_and4_1
XFILLER_157_28 VDD VSS sg13g2_decap_8
XFILLER_148_597 VDD VSS sg13g2_decap_8
X_09055_ _09057_/B _14908_/Q _09056_/C _14909_/Q VDD VSS sg13g2_a21oi_1
XFILLER_159_1125 VDD VSS sg13g2_decap_8
XFILLER_11_1232 VDD VSS sg13g2_decap_8
XFILLER_68_1019 VDD VSS sg13g2_fill_1
XFILLER_163_567 VDD VSS sg13g2_decap_8
X_08006_ _08146_/A _08519_/A2 _07818_/B _08591_/A3 _08598_/A3 _08046_/B _08669_/B1
+ VDD VSS sg13g2_mux4_1
XFILLER_2_728 VDD VSS sg13g2_decap_8
XFILLER_116_483 VDD VSS sg13g2_fill_1
XFILLER_85_1355 VDD VSS sg13g2_fill_1
XFILLER_132_943 VDD VSS sg13g2_fill_2
XFILLER_104_645 VDD VSS sg13g2_fill_2
XFILLER_89_334 VDD VSS sg13g2_decap_8
XFILLER_46_1339 VDD VSS sg13g2_fill_1
XFILLER_1_238 VDD VSS sg13g2_decap_8
XFILLER_173_49 VDD VSS sg13g2_decap_8
XFILLER_172_1336 VDD VSS sg13g2_decap_8
XFILLER_104_656 VDD VSS sg13g2_decap_8
XFILLER_106_21 VDD VSS sg13g2_decap_8
X_14630__1549 _14630_/RESET_B VDD VSS sg13g2_tiehi
XFILLER_77_518 VDD VSS sg13g2_fill_2
X_09957_ _14541_/D _14541_/Q _10056_/A0 _09961_/S VDD VSS sg13g2_mux2_1
XFILLER_89_389 VDD VSS sg13g2_decap_8
XFILLER_58_710 VDD VSS sg13g2_fill_2
XFILLER_131_1000 VDD VSS sg13g2_fill_2
XFILLER_66_14 VDD VSS sg13g2_decap_8
X_08908_ _08908_/Y _08906_/Y _08907_/Y _08931_/S VDD VSS sg13g2_a21oi_1
XFILLER_106_87 VDD VSS sg13g2_decap_4
XFILLER_131_1022 VDD VSS sg13g2_fill_1
X_09888_ _14474_/D _09921_/A1 _14474_/Q _09898_/S VDD VSS sg13g2_mux2_1
XFILLER_66_69 VDD VSS sg13g2_fill_1
X_08839_ _10805_/B _10669_/S _14927_/Q VDD VSS sg13g2_nor2b_1
XFILLER_85_573 VDD VSS sg13g2_decap_8
XFILLER_73_724 VDD VSS sg13g2_decap_4
XFILLER_131_1088 VDD VSS sg13g2_fill_1
XFILLER_79_1159 VDD VSS sg13g2_fill_2
XFILLER_45_437 VDD VSS sg13g2_fill_2
XFILLER_122_53 VDD VSS sg13g2_decap_8
X_11850_ _11850_/X _14701_/Q _14733_/Q _13773_/Q _13805_/Q _11854_/S0 _07654_/A VDD
+ VSS sg13g2_mux4_1
XFILLER_26_640 VDD VSS sg13g2_decap_8
X_10801_ _10801_/Y _10797_/A _10844_/A _10873_/A1 VDD VSS sg13g2_o21ai_1
XFILLER_92_1304 VDD VSS sg13g2_decap_8
XFILLER_72_267 VDD VSS sg13g2_decap_8
XFILLER_60_418 VDD VSS sg13g2_decap_8
X_11781_ _11781_/X _14699_/Q _14731_/Q _13771_/Q _13803_/Q _11848_/S0 _11851_/S1 VDD
+ VSS sg13g2_mux4_1
XFILLER_13_301 VDD VSS sg13g2_decap_8
XFILLER_25_161 VDD VSS sg13g2_decap_8
XFILLER_159_807 VDD VSS sg13g2_fill_2
XFILLER_26_695 VDD VSS sg13g2_decap_8
X_13520_ _15140_/D _13524_/A1 _13518_/Y _13519_/Y VDD VSS sg13g2_a21oi_1
X_10732_ _11042_/D _10735_/A _09066_/Y _08898_/Y VDD VSS sg13g2_o21ai_1
XFILLER_14_868 VDD VSS sg13g2_decap_8
XFILLER_159_829 VDD VSS sg13g2_fill_2
XFILLER_15_84 VDD VSS sg13g2_decap_8
XFILLER_13_378 VDD VSS sg13g2_decap_8
X_13451_ _13455_/C _15174_/Q _15175_/Q VDD VSS sg13g2_nand2_1
XFILLER_55_1170 VDD VSS sg13g2_decap_8
X_10663_ _10664_/A _14893_/Q _14892_/Q _14891_/Q _10663_/D VDD VSS sg13g2_and4_1
XFILLER_139_542 VDD VSS sg13g2_decap_8
X_12402_ _14992_/D _08426_/A _12443_/A2 _12401_/Y _12400_/Y VDD VSS sg13g2_a22oi_1
XFILLER_166_350 VDD VSS sg13g2_decap_8
XFILLER_16_1176 VDD VSS sg13g2_decap_8
X_13382_ _13455_/A _13389_/B _13382_/B VDD VSS sg13g2_nand2_1
X_10594_ _10595_/A _14875_/Q _14874_/Q _10649_/B _10594_/D VDD VSS sg13g2_and4_1
XFILLER_12_1029 VDD VSS sg13g2_decap_8
XFILLER_167_895 VDD VSS sg13g2_decap_8
X_15121_ _15121_/Q _15214_/CLK _15121_/D _15121_/RESET_B VDD VSS sg13g2_dfrbpq_1
X_12333_ _12334_/B _12322_/Y _12324_/X _11957_/A VDD VSS sg13g2_o21ai_1
XFILLER_5_511 VDD VSS sg13g2_decap_8
XFILLER_103_1179 VDD VSS sg13g2_decap_8
XFILLER_138_1209 VDD VSS sg13g2_fill_2
X_15052_ _15052_/Q clkload53/A _15052_/D _15052_/RESET_B VDD VSS sg13g2_dfrbpq_1
XFILLER_142_729 VDD VSS sg13g2_fill_2
X_12264_ _12264_/Y _12244_/Y _12246_/X _12192_/A VDD VSS sg13g2_o21ai_1
XFILLER_5_588 VDD VSS sg13g2_decap_8
X_14003_ _14003_/Q clkload16/A _14003_/D _14003_/RESET_B VDD VSS sg13g2_dfrbpq_1
X_11215_ _11216_/B _12092_/C _11210_/X _11231_/S VDD VSS sg13g2_o21ai_1
X_12195_ _12195_/Y _12194_/X _12296_/A1 _12126_/A VDD VSS sg13g2_a21oi_1
XFILLER_123_954 VDD VSS sg13g2_decap_4
Xoutput50 mem_axi_araddr[21] _16874_/A VDD VSS sg13g2_buf_1
XFILLER_122_442 VDD VSS sg13g2_decap_8
Xoutput61 mem_axi_araddr[31] _16884_/A VDD VSS sg13g2_buf_1
XFILLER_123_976 VDD VSS sg13g2_decap_4
Xoutput72 mem_axi_awaddr[11] _16864_/X VDD VSS sg13g2_buf_1
Xoutput83 mem_axi_awaddr[22] _16875_/X VDD VSS sg13g2_buf_1
X_11146_ _11173_/B _11146_/A _11146_/B VDD VSS sg13g2_nor2_1
X_14606__1573 _14606_/RESET_B VDD VSS sg13g2_tiehi
Xoutput94 mem_axi_awaddr[3] _16856_/X VDD VSS sg13g2_buf_1
XFILLER_150_795 VDD VSS sg13g2_decap_8
XFILLER_96_849 VDD VSS sg13g2_decap_8
XFILLER_27_1250 VDD VSS sg13g2_decap_8
XFILLER_153_1280 VDD VSS sg13g2_fill_2
X_11077_ _11077_/Y _11118_/B _11077_/B VDD VSS sg13g2_xnor2_1
XFILLER_7_1344 VDD VSS sg13g2_decap_8
XFILLER_62_1174 VDD VSS sg13g2_decap_8
XFILLER_23_1125 VDD VSS sg13g2_decap_8
XFILLER_62_1185 VDD VSS sg13g2_fill_1
XFILLER_48_242 VDD VSS sg13g2_decap_8
X_14905_ _14905_/Q _15213_/CLK _14905_/D _14905_/RESET_B VDD VSS sg13g2_dfrbpq_1
X_10028_ _14610_/D _10161_/A1 _14610_/Q _10036_/S VDD VSS sg13g2_mux2_1
XFILLER_110_1128 VDD VSS sg13g2_fill_1
X_14836_ _14836_/Q _15064_/CLK _14836_/D _14836_/RESET_B VDD VSS sg13g2_dfrbpq_1
XFILLER_17_651 VDD VSS sg13g2_decap_8
XFILLER_45_971 VDD VSS sg13g2_fill_1
XFILLER_63_278 VDD VSS sg13g2_decap_8
X_14767_ _14767_/Q _15113_/CLK _14767_/D _14767_/RESET_B VDD VSS sg13g2_dfrbpq_1
XFILLER_16_161 VDD VSS sg13g2_decap_8
X_11979_ _14978_/D _11939_/Y _11978_/Y _11934_/Y VDD VSS sg13g2_a21oi_1
X_13718_ _16880_/A clkload52/A _13718_/D _13718_/RESET_B VDD VSS sg13g2_dfrbpq_1
X_14698_ _14698_/Q _14730_/CLK _14698_/D _14698_/RESET_B VDD VSS sg13g2_dfrbpq_1
XFILLER_20_805 VDD VSS sg13g2_decap_8
XFILLER_149_328 VDD VSS sg13g2_decap_8
XFILLER_32_687 VDD VSS sg13g2_decap_8
X_13649_ _15115_/D _15184_/D _15115_/Q _13656_/S VDD VSS sg13g2_mux2_1
XFILLER_73_1270 VDD VSS sg13g2_fill_1
XFILLER_108_1079 VDD VSS sg13g2_fill_2
XFILLER_31_175 VDD VSS sg13g2_decap_8
XFILLER_118_704 VDD VSS sg13g2_fill_1
XFILLER_9_861 VDD VSS sg13g2_decap_8
XFILLER_30_1107 VDD VSS sg13g2_decap_8
XFILLER_117_203 VDD VSS sg13g2_decap_8
XFILLER_145_523 VDD VSS sg13g2_decap_8
XFILLER_34_1298 VDD VSS sg13g2_fill_2
XFILLER_8_371 VDD VSS sg13g2_decap_8
XFILLER_145_534 VDD VSS sg13g2_fill_1
XFILLER_145_545 VDD VSS sg13g2_decap_8
XFILLER_172_386 VDD VSS sg13g2_decap_8
XFILLER_160_537 VDD VSS sg13g2_decap_4
XFILLER_154_1000 VDD VSS sg13g2_decap_8
XFILLER_132_239 VDD VSS sg13g2_fill_1
XFILLER_119_1142 VDD VSS sg13g2_decap_8
Xfanout306 _10168_/S _10156_/S VDD VSS sg13g2_buf_1
XFILLER_87_805 VDD VSS sg13g2_fill_1
XFILLER_119_1164 VDD VSS sg13g2_decap_8
Xfanout317 _09970_/S wire320/A VDD VSS sg13g2_buf_1
X_09811_ _14399_/D _09877_/A0 _14399_/Q _09829_/S VDD VSS sg13g2_mux2_1
Xfanout328 _09871_/S wire331/X VDD VSS sg13g2_buf_1
Xfanout339 _09736_/S _09737_/S VDD VSS sg13g2_buf_1
XFILLER_99_698 VDD VSS sg13g2_fill_2
XFILLER_98_175 VDD VSS sg13g2_decap_8
XFILLER_119_1197 VDD VSS sg13g2_fill_1
XFILLER_45_1350 VDD VSS sg13g2_fill_1
X_09742_ _14332_/D _14332_/Q _10139_/A1 _09766_/S VDD VSS sg13g2_mux2_1
XFILLER_132_1342 VDD VSS sg13g2_fill_1
XFILLER_67_551 VDD VSS sg13g2_decap_8
XFILLER_41_1247 VDD VSS sg13g2_decap_8
X_09673_ _14266_/D _09772_/A1 _14266_/Q _09673_/S VDD VSS sg13g2_mux2_1
XFILLER_67_584 VDD VSS sg13g2_decap_8
XFILLER_55_724 VDD VSS sg13g2_decap_8
XFILLER_67_595 VDD VSS sg13g2_fill_2
XFILLER_36_28 VDD VSS sg13g2_decap_8
X_08624_ _08633_/C _07849_/X _08672_/A _08623_/Y _08643_/C _08622_/Y VDD VSS sg13g2_a221oi_1
XFILLER_82_532 VDD VSS sg13g2_fill_2
XFILLER_54_223 VDD VSS sg13g2_decap_8
XFILLER_82_565 VDD VSS sg13g2_fill_1
XFILLER_36_971 VDD VSS sg13g2_decap_4
X_08555_ _08555_/Y _08554_/Y _08549_/Y _08588_/B VDD VSS sg13g2_o21ai_1
XFILLER_82_587 VDD VSS sg13g2_fill_2
XFILLER_36_993 VDD VSS sg13g2_decap_4
XFILLER_35_470 VDD VSS sg13g2_fill_2
XFILLER_165_1140 VDD VSS sg13g2_fill_2
X_14044__2135 _14044_/RESET_B VDD VSS sg13g2_tiehi
XFILLER_126_1124 VDD VSS sg13g2_decap_8
XFILLER_165_1173 VDD VSS sg13g2_decap_8
X_08486_ _08501_/C _07822_/B _08672_/A _08485_/Y _07820_/X _08484_/Y VDD VSS sg13g2_a221oi_1
XFILLER_50_440 VDD VSS sg13g2_decap_8
XFILLER_11_805 VDD VSS sg13g2_decap_8
XFILLER_168_648 VDD VSS sg13g2_decap_8
XFILLER_52_49 VDD VSS sg13g2_fill_1
XFILLER_51_985 VDD VSS sg13g2_decap_8
XFILLER_10_315 VDD VSS sg13g2_decap_8
XFILLER_168_659 VDD VSS sg13g2_fill_1
XFILLER_50_484 VDD VSS sg13g2_decap_8
XFILLER_22_175 VDD VSS sg13g2_decap_8
XFILLER_139_7 VDD VSS sg13g2_decap_8
XFILLER_167_147 VDD VSS sg13g2_decap_8
XFILLER_168_49 VDD VSS sg13g2_decap_8
XFILLER_13_1316 VDD VSS sg13g2_decap_8
XFILLER_148_350 VDD VSS sg13g2_decap_8
XFILLER_6_308 VDD VSS sg13g2_decap_8
X_14956__2632 _14956_/RESET_B VDD VSS sg13g2_tiehi
XFILLER_164_821 VDD VSS sg13g2_decap_8
XFILLER_164_832 VDD VSS sg13g2_fill_1
X_09107_ _09107_/Y _15241_/Q _09107_/B VDD VSS sg13g2_nand2b_1
XFILLER_164_843 VDD VSS sg13g2_decap_8
XFILLER_108_236 VDD VSS sg13g2_decap_4
XFILLER_124_718 VDD VSS sg13g2_decap_8
XFILLER_163_364 VDD VSS sg13g2_decap_8
X_09038_ _13767_/D _13767_/Q _10083_/A0 _09160_/S VDD VSS sg13g2_mux2_1
XFILLER_105_921 VDD VSS sg13g2_decap_8
XFILLER_85_1130 VDD VSS sg13g2_decap_8
XFILLER_2_525 VDD VSS sg13g2_decap_8
XFILLER_117_42 VDD VSS sg13g2_fill_2
XFILLER_46_1103 VDD VSS sg13g2_decap_8
XFILLER_85_1174 VDD VSS sg13g2_decap_8
XFILLER_132_751 VDD VSS sg13g2_decap_4
XFILLER_117_75 VDD VSS sg13g2_decap_8
X_11000_ _14941_/D _10999_/X _10998_/Y _10987_/Y VDD VSS sg13g2_o21ai_1
XFILLER_78_816 VDD VSS sg13g2_fill_2
XFILLER_77_35 VDD VSS sg13g2_decap_8
X_14997__2590 _14997_/RESET_B VDD VSS sg13g2_tiehi
XFILLER_46_1169 VDD VSS sg13g2_fill_2
XFILLER_120_946 VDD VSS sg13g2_fill_2
XFILLER_137_1297 VDD VSS sg13g2_fill_2
Xfanout840 _12771_/S1 _12773_/S1 VDD VSS sg13g2_buf_1
XFILLER_77_68 VDD VSS sg13g2_decap_8
Xfanout851 _12661_/S0 _12660_/S0 VDD VSS sg13g2_buf_1
Xfanout862 _12758_/S0 _12759_/S0 VDD VSS sg13g2_buf_1
Xfanout873 _12703_/S0 _12785_/S0 VDD VSS sg13g2_buf_1
XFILLER_77_359 VDD VSS sg13g2_fill_1
Xfanout884 _12689_/S0 _12731_/S0 VDD VSS sg13g2_buf_1
XFILLER_86_860 VDD VSS sg13g2_decap_8
X_14254__1925 _14254_/RESET_B VDD VSS sg13g2_tiehi
Xfanout895 _12752_/S0 _12745_/S0 VDD VSS sg13g2_buf_1
X_12951_ _12951_/Y _12900_/A _12884_/C input35/X VDD VSS sg13g2_a21oi_1
XFILLER_45_201 VDD VSS sg13g2_decap_8
XFILLER_20_1309 VDD VSS sg13g2_decap_8
XFILLER_19_938 VDD VSS sg13g2_decap_8
XFILLER_85_381 VDD VSS sg13g2_decap_4
X_11902_ _11902_/Y _11902_/A _12118_/C VDD VSS sg13g2_nor2b_1
XFILLER_18_448 VDD VSS sg13g2_decap_8
X_12882_ _12882_/Y _12879_/Y _12880_/Y _12881_/Y VDD VSS sg13g2_a21oi_1
XFILLER_45_256 VDD VSS sg13g2_fill_1
XFILLER_34_919 VDD VSS sg13g2_fill_1
XFILLER_22_1191 VDD VSS sg13g2_decap_8
XFILLER_165_0 VDD VSS sg13g2_decap_8
X_14621_ _14621_/Q _14653_/CLK _14621_/D _14621_/RESET_B VDD VSS sg13g2_dfrbpq_1
X_11833_ _11833_/Y _11813_/Y _11815_/X _11378_/S VDD VSS sg13g2_o21ai_1
XFILLER_2_1274 VDD VSS sg13g2_decap_8
XFILLER_27_982 VDD VSS sg13g2_decap_4
XFILLER_96_1270 VDD VSS sg13g2_fill_1
X_14552_ _14552_/Q _14744_/CLK _14552_/D _14552_/RESET_B VDD VSS sg13g2_dfrbpq_1
X_11764_ _11765_/B _11761_/Y _11763_/Y _11625_/C VDD VSS sg13g2_a21oi_1
XFILLER_92_1156 VDD VSS sg13g2_decap_8
XFILLER_57_1276 VDD VSS sg13g2_decap_8
XFILLER_14_665 VDD VSS sg13g2_decap_8
XFILLER_159_637 VDD VSS sg13g2_fill_2
X_13503_ _15129_/D _15174_/D _13504_/A _13501_/Y VDD VSS sg13g2_o21ai_1
XFILLER_42_985 VDD VSS sg13g2_decap_8
X_10715_ _14906_/D _11193_/B1 _10954_/B _10714_/Y VDD VSS sg13g2_o21ai_1
X_14483_ _14483_/Q _14660_/CLK _14483_/D _14483_/RESET_B VDD VSS sg13g2_dfrbpq_1
XFILLER_13_175 VDD VSS sg13g2_decap_8
X_11695_ _11696_/A _13960_/Q _13992_/Q _14024_/Q _14056_/Q _11692_/A _12026_/C VDD
+ VSS sg13g2_mux4_1
XFILLER_158_147 VDD VSS sg13g2_decap_8
X_13434_ _15099_/D _15099_/Q _13470_/A2 _13433_/Y VDD VSS sg13g2_a21o_1
XFILLER_139_350 VDD VSS sg13g2_decap_8
X_10646_ _10655_/C _14889_/Q _10643_/C hold3137/X VDD VSS sg13g2_a21oi_1
XFILLER_9_168 VDD VSS sg13g2_decap_8
XFILLER_127_512 VDD VSS sg13g2_fill_2
XFILLER_10_882 VDD VSS sg13g2_decap_8
X_13365_ _15074_/D _13361_/C _13435_/A _13363_/Y VDD VSS sg13g2_o21ai_1
X_10577_ _14870_/D _10586_/D _10599_/A _10577_/C VDD VSS sg13g2_nor3_1
XFILLER_155_865 VDD VSS sg13g2_fill_1
X_13742__2437 _13742_/RESET_B VDD VSS sg13g2_tiehi
X_15104_ _15104_/Q clkload67/A _15104_/D _15104_/RESET_B VDD VSS sg13g2_dfrbpq_1
X_13888__2291 _13888_/RESET_B VDD VSS sg13g2_tiehi
X_12316_ _12317_/A _13754_/Q _14106_/Q _14458_/Q _14554_/Q _12316_/S0 _12091_/C VDD
+ VSS sg13g2_mux4_1
XFILLER_115_729 VDD VSS sg13g2_decap_8
XFILLER_142_515 VDD VSS sg13g2_fill_1
XFILLER_6_875 VDD VSS sg13g2_decap_8
XFILLER_170_824 VDD VSS sg13g2_decap_8
X_13296_ _15056_/D _13293_/A _07710_/Y _13295_/Y VDD VSS sg13g2_a21o_1
XFILLER_54_7 VDD VSS sg13g2_decap_8
XFILLER_68_1350 VDD VSS sg13g2_decap_8
X_15035_ _15035_/Q clkload57/A _15035_/D _15035_/RESET_B VDD VSS sg13g2_dfrbpq_1
XFILLER_5_385 VDD VSS sg13g2_decap_8
X_12247_ _12247_/Y _12252_/S0 _14392_/Q VDD VSS sg13g2_nand2b_1
XFILLER_68_1372 VDD VSS sg13g2_decap_4
XFILLER_123_740 VDD VSS sg13g2_decap_8
XFILLER_29_1345 VDD VSS sg13g2_decap_8
XFILLER_3_21 VDD VSS sg13g2_decap_8
XFILLER_123_773 VDD VSS sg13g2_decap_8
XFILLER_122_261 VDD VSS sg13g2_decap_4
X_12178_ _12178_/Y _12257_/A1 _14518_/Q _12233_/B VDD VSS sg13g2_a21oi_1
XFILLER_68_326 VDD VSS sg13g2_decap_8
X_14122__2057 _14122_/RESET_B VDD VSS sg13g2_tiehi
XFILLER_116_1348 VDD VSS sg13g2_fill_1
XFILLER_122_283 VDD VSS sg13g2_decap_8
XFILLER_68_337 VDD VSS sg13g2_fill_1
XFILLER_116_1359 VDD VSS sg13g2_fill_2
X_11129_ _11129_/Y _11128_/A _11128_/B _11151_/A VDD VSS sg13g2_a21oi_1
XFILLER_68_348 VDD VSS sg13g2_decap_8
XFILLER_7_1141 VDD VSS sg13g2_decap_8
XFILLER_3_98 VDD VSS sg13g2_decap_8
XFILLER_114_1050 VDD VSS sg13g2_fill_2
XFILLER_77_871 VDD VSS sg13g2_decap_4
XFILLER_49_562 VDD VSS sg13g2_fill_1
XFILLER_110_489 VDD VSS sg13g2_decap_8
XFILLER_114_1061 VDD VSS sg13g2_fill_1
XFILLER_114_1072 VDD VSS sg13g2_decap_8
XFILLER_92_830 VDD VSS sg13g2_decap_8
XFILLER_37_757 VDD VSS sg13g2_decap_8
XFILLER_97_1045 VDD VSS sg13g2_decap_8
XFILLER_37_768 VDD VSS sg13g2_fill_2
XFILLER_92_863 VDD VSS sg13g2_decap_4
XFILLER_149_1135 VDD VSS sg13g2_fill_2
XFILLER_40_1291 VDD VSS sg13g2_decap_8
XFILLER_36_267 VDD VSS sg13g2_fill_1
X_14819_ _14819_/Q _14886_/CLK _14819_/D _14819_/RESET_B VDD VSS sg13g2_dfrbpq_1
XFILLER_24_418 VDD VSS sg13g2_decap_8
X_13990__2189 _13990_/RESET_B VDD VSS sg13g2_tiehi
XFILLER_162_1302 VDD VSS sg13g2_decap_8
X_08340_ _08340_/Y _08340_/A _08340_/B VDD VSS sg13g2_nand2_1
XFILLER_36_1316 VDD VSS sg13g2_decap_8
XFILLER_75_1376 VDD VSS sg13g2_fill_1
XFILLER_20_602 VDD VSS sg13g2_decap_8
X_08271_ _08271_/Y _08098_/B _08363_/S0 _08027_/Y VDD VSS sg13g2_a21oi_1
XFILLER_149_136 VDD VSS sg13g2_decap_8
XFILLER_80_0 VDD VSS sg13g2_decap_8
XFILLER_149_158 VDD VSS sg13g2_decap_8
XFILLER_20_679 VDD VSS sg13g2_decap_8
XFILLER_160_1092 VDD VSS sg13g2_decap_4
XFILLER_173_640 VDD VSS sg13g2_decap_8
XFILLER_146_887 VDD VSS sg13g2_decap_8
X_14332__1847 _14332_/RESET_B VDD VSS sg13g2_tiehi
XFILLER_161_813 VDD VSS sg13g2_decap_4
X_13718__2461 _13718_/RESET_B VDD VSS sg13g2_tiehi
XFILLER_156_1106 VDD VSS sg13g2_fill_2
XFILLER_172_161 VDD VSS sg13g2_decap_8
XFILLER_133_537 VDD VSS sg13g2_fill_2
XFILLER_160_323 VDD VSS sg13g2_decap_8
XFILLER_82_1314 VDD VSS sg13g2_decap_8
XFILLER_99_462 VDD VSS sg13g2_decap_8
XFILLER_102_946 VDD VSS sg13g2_decap_8
XFILLER_141_581 VDD VSS sg13g2_fill_1
Xfanout147 _09936_/A1 _10168_/A1 VDD VSS sg13g2_buf_1
XFILLER_101_434 VDD VSS sg13g2_decap_8
Xfanout158 _09703_/A0 fanout162/X VDD VSS sg13g2_buf_1
XFILLER_87_668 VDD VSS sg13g2_fill_2
Xfanout169 _10164_/A1 _10131_/A0 VDD VSS sg13g2_buf_1
X_07986_ _07988_/D _13290_/A _13290_/B VDD VSS sg13g2_nand2_1
XFILLER_80_1071 VDD VSS sg13g2_decap_8
XFILLER_45_1191 VDD VSS sg13g2_decap_8
X_09725_ _14316_/D _09923_/A1 _14316_/Q _09733_/S VDD VSS sg13g2_mux2_1
XFILLER_86_178 VDD VSS sg13g2_decap_8
XFILLER_80_1082 VDD VSS sg13g2_fill_1
XFILLER_47_49 VDD VSS sg13g2_decap_8
XFILLER_170_28 VDD VSS sg13g2_decap_8
XFILLER_41_1055 VDD VSS sg13g2_decap_8
XFILLER_83_830 VDD VSS sg13g2_decap_4
XFILLER_132_1183 VDD VSS sg13g2_fill_1
XFILLER_55_532 VDD VSS sg13g2_decap_8
X_09656_ _14249_/D _10152_/A1 _14249_/Q _09672_/S VDD VSS sg13g2_mux2_1
XFILLER_27_245 VDD VSS sg13g2_decap_8
XFILLER_82_351 VDD VSS sg13g2_decap_8
X_08607_ _08615_/C _08688_/C _08603_/Y _08606_/Y VDD VSS sg13g2_a21oi_1
XFILLER_70_513 VDD VSS sg13g2_decap_8
X_09587_ _14184_/D _14184_/Q _09853_/A1 _09596_/S VDD VSS sg13g2_mux2_1
X_13820__2359 _13820_/RESET_B VDD VSS sg13g2_tiehi
X_14580__1599 _14580_/RESET_B VDD VSS sg13g2_tiehi
X_08538_ _08538_/X _08465_/X _08537_/X _08597_/B VDD VSS sg13g2_mux2_1
XFILLER_11_602 VDD VSS sg13g2_decap_8
XFILLER_23_462 VDD VSS sg13g2_decap_8
XFILLER_168_434 VDD VSS sg13g2_decap_8
X_08469_ _08475_/C _08469_/A _08469_/B VDD VSS sg13g2_nor2_1
XFILLER_10_112 VDD VSS sg13g2_decap_8
X_15163__2631 _15163_/RESET_B VDD VSS sg13g2_tiehi
Xwire504 wire504/X wire504/A VDD VSS sg13g2_buf_4
X_10500_ _10502_/B _10500_/A _14840_/Q _14839_/Q VDD VSS sg13g2_nand3_1
XFILLER_17_1260 VDD VSS sg13g2_decap_8
X_11480_ _11480_/Y _11479_/Y _11478_/Y _11465_/Y _11500_/B2 _11501_/A2 VDD VSS sg13g2_a221oi_1
XFILLER_11_679 VDD VSS sg13g2_decap_8
XFILLER_13_1113 VDD VSS sg13g2_decap_8
XFILLER_6_105 VDD VSS sg13g2_decap_8
X_10431_ _10431_/Y _14833_/Q _10434_/C _10557_/C VDD VSS sg13g2_o21ai_1
XFILLER_10_189 VDD VSS sg13g2_decap_8
XFILLER_137_854 VDD VSS sg13g2_decap_8
XFILLER_100_1116 VDD VSS sg13g2_decap_8
XFILLER_12_63 VDD VSS sg13g2_decap_8
XFILLER_139_1304 VDD VSS sg13g2_decap_4
X_13150_ _13150_/Y _14853_/Q _13150_/B VDD VSS sg13g2_nand2_1
XFILLER_124_515 VDD VSS sg13g2_decap_4
XFILLER_152_824 VDD VSS sg13g2_decap_8
XFILLER_164_684 VDD VSS sg13g2_decap_4
X_10362_ _14812_/D _14812_/Q _10359_/Y _10361_/Y VDD VSS sg13g2_a21oi_1
XFILLER_128_63 VDD VSS sg13g2_decap_8
XFILLER_163_161 VDD VSS sg13g2_decap_8
XFILLER_3_812 VDD VSS sg13g2_decap_8
X_14308__1871 _14308_/RESET_B VDD VSS sg13g2_tiehi
X_12101_ _12101_/X _12101_/A _12253_/B VDD VSS sg13g2_and2_1
X_13081_ _13081_/X input12/X _13205_/A2 _13205_/B1 VDD VSS sg13g2_a21o_1
X_10293_ _10295_/A _14791_/Q _10294_/C _14792_/Q VDD VSS sg13g2_a21o_1
XFILLER_2_322 VDD VSS sg13g2_decap_8
XFILLER_174_1239 VDD VSS sg13g2_decap_8
XFILLER_105_751 VDD VSS sg13g2_fill_1
XFILLER_105_762 VDD VSS sg13g2_fill_2
X_12032_ _12032_/Y _12235_/A _14482_/Q VDD VSS sg13g2_nand2b_1
XFILLER_3_889 VDD VSS sg13g2_decap_8
XFILLER_104_250 VDD VSS sg13g2_fill_2
XFILLER_137_1061 VDD VSS sg13g2_decap_8
XFILLER_78_635 VDD VSS sg13g2_decap_4
XFILLER_2_399 VDD VSS sg13g2_decap_8
Xfanout670 _07753_/B _11056_/B1 VDD VSS sg13g2_buf_1
Xfanout681 _12296_/A1 _11664_/A VDD VSS sg13g2_buf_1
Xfanout692 _12192_/A _12217_/A VDD VSS sg13g2_buf_1
XFILLER_93_627 VDD VSS sg13g2_fill_2
XFILLER_59_882 VDD VSS sg13g2_decap_8
XFILLER_24_1253 VDD VSS sg13g2_decap_8
XFILLER_111_1212 VDD VSS sg13g2_decap_8
X_13983_ _13983_/Q clkload10/A _13983_/D _13983_/RESET_B VDD VSS sg13g2_dfrbpq_1
XFILLER_77_189 VDD VSS sg13g2_fill_2
XFILLER_20_1106 VDD VSS sg13g2_decap_8
XFILLER_19_735 VDD VSS sg13g2_decap_8
XFILLER_111_1234 VDD VSS sg13g2_decap_8
XFILLER_4_1358 VDD VSS sg13g2_decap_8
XFILLER_46_532 VDD VSS sg13g2_decap_8
X_12934_ _12934_/Y _12900_/A _12997_/A input34/X VDD VSS sg13g2_a21oi_1
XFILLER_59_1316 VDD VSS sg13g2_decap_8
XFILLER_18_245 VDD VSS sg13g2_decap_8
XFILLER_59_1349 VDD VSS sg13g2_fill_1
XFILLER_34_727 VDD VSS sg13g2_fill_2
X_12865_ _12865_/Y _12862_/Y _12863_/Y _12864_/Y VDD VSS sg13g2_a21oi_1
XFILLER_73_384 VDD VSS sg13g2_fill_2
XFILLER_2_1071 VDD VSS sg13g2_decap_8
XFILLER_33_226 VDD VSS sg13g2_decap_8
X_14604_ _14604_/Q clkload13/A _14604_/D _14604_/RESET_B VDD VSS sg13g2_dfrbpq_1
XFILLER_15_952 VDD VSS sg13g2_decap_8
X_14410__1769 _14410_/RESET_B VDD VSS sg13g2_tiehi
X_11816_ _11816_/Y _11821_/S0 _14380_/Q VDD VSS sg13g2_nand2b_1
X_12796_ _12801_/B _13601_/B _13601_/A VDD VSS sg13g2_nor2b_1
XFILLER_14_462 VDD VSS sg13g2_decap_8
XFILLER_42_771 VDD VSS sg13g2_decap_8
XFILLER_159_434 VDD VSS sg13g2_decap_8
X_14535_ _14535_/Q _14607_/CLK _14535_/D _14535_/RESET_B VDD VSS sg13g2_dfrbpq_1
X_11747_ _11747_/Y _11747_/A _11747_/B VDD VSS sg13g2_nor2_1
XFILLER_18_1057 VDD VSS sg13g2_decap_8
XFILLER_169_70 VDD VSS sg13g2_decap_8
X_14466_ _14466_/Q clkload25/A _14466_/D _14466_/RESET_B VDD VSS sg13g2_dfrbpq_1
XFILLER_128_810 VDD VSS sg13g2_fill_2
X_11678_ _11678_/X _13736_/Q _14088_/Q _14440_/Q _14536_/Q _11969_/A _12038_/B1 VDD
+ VSS sg13g2_mux4_1
XFILLER_35_1371 VDD VSS sg13g2_decap_8
X_13975__2204 _13975_/RESET_B VDD VSS sg13g2_tiehi
XFILLER_70_1262 VDD VSS sg13g2_fill_2
XFILLER_35_1382 VDD VSS sg13g2_fill_2
X_13417_ _13490_/D _15129_/Q _13438_/B _13438_/D VDD VSS sg13g2_nand3_1
XFILLER_128_854 VDD VSS sg13g2_decap_4
X_10629_ _10630_/B _14880_/Q _14879_/Q _10629_/C _10629_/D VDD VSS sg13g2_nand4_1
XFILLER_31_1246 VDD VSS sg13g2_decap_8
X_14397_ _14397_/Q clkload45/A _14397_/D _14397_/RESET_B VDD VSS sg13g2_dfrbpq_1
XFILLER_143_813 VDD VSS sg13g2_decap_8
XFILLER_155_673 VDD VSS sg13g2_decap_8
X_13348_ _13348_/Y _15171_/D _15169_/D _15170_/D _15172_/D VDD VSS sg13g2_nand4_1
XFILLER_154_161 VDD VSS sg13g2_fill_2
XFILLER_6_672 VDD VSS sg13g2_decap_8
XFILLER_115_537 VDD VSS sg13g2_decap_8
XFILLER_5_182 VDD VSS sg13g2_decap_8
X_13279_ _13279_/Y _15071_/Q _13279_/B _13307_/B _13279_/D VDD VSS sg13g2_nor4_1
X_15018_ _15018_/Q clkload33/A _15018_/D _15018_/RESET_B VDD VSS sg13g2_dfrbpq_1
XFILLER_29_1142 VDD VSS sg13g2_decap_8
XFILLER_170_698 VDD VSS sg13g2_decap_8
XFILLER_9_1225 VDD VSS sg13g2_decap_8
XFILLER_64_1055 VDD VSS sg13g2_decap_8
XFILLER_25_1006 VDD VSS sg13g2_fill_1
X_14940__2664 _14940_/RESET_B VDD VSS sg13g2_tiehi
XFILLER_155_1194 VDD VSS sg13g2_decap_8
X_07840_ _08654_/A _15018_/Q _08010_/B VDD VSS sg13g2_nor2_1
XFILLER_64_1088 VDD VSS sg13g2_decap_8
XFILLER_42_1320 VDD VSS sg13g2_decap_8
XFILLER_110_253 VDD VSS sg13g2_decap_4
X_07771_ _08318_/B _08258_/C _14998_/Q VDD VSS sg13g2_xor2_1
X_09510_ _14109_/D _09609_/A0 _14109_/Q _09533_/S VDD VSS sg13g2_mux2_1
XFILLER_83_148 VDD VSS sg13g2_decap_4
XFILLER_25_705 VDD VSS sg13g2_decap_4
XFILLER_64_362 VDD VSS sg13g2_decap_4
X_09441_ wire462/A _09441_/A _09806_/B _09441_/C _09441_/D VDD VSS sg13g2_nand4_1
XFILLER_65_896 VDD VSS sg13g2_decap_4
XFILLER_91_170 VDD VSS sg13g2_decap_4
XFILLER_25_749 VDD VSS sg13g2_decap_8
XFILLER_91_192 VDD VSS sg13g2_fill_1
X_09372_ _13976_/D _09636_/A0 _13976_/Q _09374_/S VDD VSS sg13g2_mux2_1
XFILLER_40_708 VDD VSS sg13g2_decap_4
XFILLER_24_259 VDD VSS sg13g2_decap_8
XFILLER_36_1124 VDD VSS sg13g2_decap_8
X_08323_ _08323_/Y _07796_/B _08322_/Y _08588_/B VDD VSS sg13g2_o21ai_1
XFILLER_71_1015 VDD VSS sg13g2_fill_1
X_15090__2805 _15090_/RESET_B VDD VSS sg13g2_tiehi
XFILLER_71_1048 VDD VSS sg13g2_decap_8
XFILLER_21_966 VDD VSS sg13g2_decap_8
X_08254_ _08426_/B _08171_/X _08253_/X _08254_/S VDD VSS sg13g2_mux2_1
XFILLER_119_832 VDD VSS sg13g2_decap_8
XFILLER_20_476 VDD VSS sg13g2_decap_8
XFILLER_165_448 VDD VSS sg13g2_decap_8
X_14565__1614 _14565_/RESET_B VDD VSS sg13g2_tiehi
X_08185_ _08185_/Y _08184_/Y _07876_/Y _08424_/A1 VDD VSS sg13g2_a21oi_1
XFILLER_119_865 VDD VSS sg13g2_fill_2
XFILLER_4_609 VDD VSS sg13g2_decap_8
XFILLER_165_28 VDD VSS sg13g2_decap_8
XFILLER_118_386 VDD VSS sg13g2_fill_1
XFILLER_3_119 VDD VSS sg13g2_decap_8
XFILLER_12_1190 VDD VSS sg13g2_decap_8
XFILLER_133_367 VDD VSS sg13g2_decap_8
XFILLER_82_1111 VDD VSS sg13g2_decap_8
XFILLER_47_1242 VDD VSS sg13g2_decap_8
XFILLER_134_1201 VDD VSS sg13g2_fill_1
XFILLER_160_175 VDD VSS sg13g2_decap_8
XFILLER_138_1381 VDD VSS sg13g2_fill_2
XFILLER_82_1144 VDD VSS sg13g2_fill_1
XFILLER_59_101 VDD VSS sg13g2_decap_4
XFILLER_87_432 VDD VSS sg13g2_decap_8
XFILLER_82_1166 VDD VSS sg13g2_decap_8
XFILLER_102_754 VDD VSS sg13g2_decap_4
XFILLER_43_1128 VDD VSS sg13g2_decap_4
XFILLER_75_605 VDD VSS sg13g2_fill_2
XFILLER_114_21 VDD VSS sg13g2_decap_8
X_07969_ _07976_/C _07969_/A _08678_/A _08650_/A _07969_/D VDD VSS sg13g2_nor4_1
XFILLER_74_14 VDD VSS sg13g2_decap_8
X_09708_ _14299_/D _09774_/A0 _14299_/Q _09733_/S VDD VSS sg13g2_mux2_1
X_10980_ _10980_/Y _10978_/Y _11009_/D _11188_/C1 VDD VSS sg13g2_a21oi_1
XFILLER_74_159 VDD VSS sg13g2_decap_4
XFILLER_167_1010 VDD VSS sg13g2_fill_2
XFILLER_28_576 VDD VSS sg13g2_fill_2
X_09639_ _09806_/D _09938_/A _10105_/C VDD VSS sg13g2_and2_1
XFILLER_16_749 VDD VSS sg13g2_decap_8
XFILLER_43_546 VDD VSS sg13g2_decap_8
X_12650_ _12650_/X _12648_/X _12649_/X _12678_/S VDD VSS sg13g2_mux2_1
XFILLER_15_259 VDD VSS sg13g2_decap_8
XFILLER_70_354 VDD VSS sg13g2_decap_8
XFILLER_71_888 VDD VSS sg13g2_fill_2
X_11601_ _11601_/Y _11601_/A _11973_/B VDD VSS sg13g2_nand2_1
XFILLER_90_35 VDD VSS sg13g2_decap_8
XFILLER_19_1344 VDD VSS sg13g2_decap_8
XFILLER_106_1303 VDD VSS sg13g2_decap_8
XFILLER_70_387 VDD VSS sg13g2_decap_8
XFILLER_54_1235 VDD VSS sg13g2_fill_2
XFILLER_168_231 VDD VSS sg13g2_decap_8
X_12581_ _12581_/X _12580_/X _12579_/X _12664_/S VDD VSS sg13g2_mux2_1
XFILLER_145_1374 VDD VSS sg13g2_fill_1
XFILLER_90_68 VDD VSS sg13g2_fill_2
X_14320_ _14320_/Q _14662_/CLK _14320_/D _14320_/RESET_B VDD VSS sg13g2_dfrbpq_1
XFILLER_12_966 VDD VSS sg13g2_decap_8
X_11532_ _11533_/B _11532_/A _11532_/B _12018_/C VDD VSS sg13g2_nand3_1
XFILLER_128_128 VDD VSS sg13g2_decap_8
XFILLER_11_476 VDD VSS sg13g2_decap_8
XFILLER_23_84 VDD VSS sg13g2_decap_8
XFILLER_128_0 VDD VSS sg13g2_decap_8
X_14251_ _14251_/Q clkload4/A _14251_/D _14251_/RESET_B VDD VSS sg13g2_dfrbpq_1
XFILLER_8_959 VDD VSS sg13g2_decap_8
X_11463_ _11463_/Y _11463_/A _11463_/B _11463_/C VDD VSS sg13g2_nor3_1
X_13202_ _13204_/B _13202_/A _13202_/B VDD VSS sg13g2_nand2_1
Xwire378 wire378/X wire378/A VDD VSS sg13g2_buf_4
XFILLER_7_469 VDD VSS sg13g2_decap_8
XFILLER_125_813 VDD VSS sg13g2_decap_8
XFILLER_137_673 VDD VSS sg13g2_decap_8
X_10414_ _10415_/A _14827_/Q _10414_/B _10414_/C _10414_/D VDD VSS sg13g2_and4_1
XFILLER_87_1022 VDD VSS sg13g2_decap_8
XFILLER_171_418 VDD VSS sg13g2_decap_8
XFILLER_109_375 VDD VSS sg13g2_decap_8
X_14182_ _14182_/Q clkload11/A _14182_/D _14182_/RESET_B VDD VSS sg13g2_dfrbpq_1
X_11394_ _11395_/A _14687_/Q _14719_/Q _13759_/Q _13791_/Q _11418_/A _11419_/C VDD
+ VSS sg13g2_mux4_1
XFILLER_99_66 VDD VSS sg13g2_decap_4
XFILLER_136_172 VDD VSS sg13g2_fill_2
XFILLER_87_1055 VDD VSS sg13g2_fill_1
XFILLER_124_323 VDD VSS sg13g2_decap_8
XFILLER_139_1123 VDD VSS sg13g2_decap_4
XFILLER_139_1134 VDD VSS sg13g2_decap_8
X_13133_ _13146_/C _14914_/Q _13673_/Q _13133_/C VDD VSS sg13g2_nand3_1
XFILLER_124_345 VDD VSS sg13g2_fill_2
XFILLER_139_1145 VDD VSS sg13g2_fill_2
X_10345_ _10397_/B _14807_/Q _14808_/Q _10345_/C _10345_/D VDD VSS sg13g2_nand4_1
XFILLER_48_1039 VDD VSS sg13g2_decap_4
XFILLER_79_900 VDD VSS sg13g2_decap_8
XFILLER_112_507 VDD VSS sg13g2_fill_2
XFILLER_97_218 VDD VSS sg13g2_fill_2
X_13064_ _13172_/A _13064_/A _13064_/B VDD VSS sg13g2_xor2_1
X_10276_ _10279_/B _14786_/Q _10305_/A _14787_/Q VDD VSS sg13g2_a21oi_1
XFILLER_3_686 VDD VSS sg13g2_decap_8
XFILLER_26_1315 VDD VSS sg13g2_decap_8
Xfanout1410 _10177_/A fanout1413/X VDD VSS sg13g2_buf_1
X_12015_ _12019_/A _12014_/X _12015_/B VDD VSS sg13g2_nand2b_1
XFILLER_61_1217 VDD VSS sg13g2_fill_1
XFILLER_2_196 VDD VSS sg13g2_decap_8
XFILLER_94_936 VDD VSS sg13g2_fill_1
XFILLER_93_402 VDD VSS sg13g2_decap_8
XFILLER_17_7 VDD VSS sg13g2_decap_8
XFILLER_24_1050 VDD VSS sg13g2_decap_8
XFILLER_19_532 VDD VSS sg13g2_decap_8
XFILLER_111_1031 VDD VSS sg13g2_decap_8
X_13966_ _13966_/Q clkload37/A _13966_/D _13966_/RESET_B VDD VSS sg13g2_dfrbpq_1
XFILLER_4_1155 VDD VSS sg13g2_decap_8
XFILLER_74_660 VDD VSS sg13g2_fill_2
X_14643__1536 _14643_/RESET_B VDD VSS sg13g2_tiehi
XFILLER_94_1004 VDD VSS sg13g2_fill_1
X_12917_ _12917_/Y _14806_/Q _12851_/B _12917_/B1 VDD VSS sg13g2_a21oi_1
XFILLER_62_822 VDD VSS sg13g2_decap_8
XFILLER_0_77 VDD VSS sg13g2_decap_8
X_13897_ _13897_/Q _14649_/CLK _13897_/D _13897_/RESET_B VDD VSS sg13g2_dfrbpq_1
XFILLER_94_1059 VDD VSS sg13g2_decap_4
X_12848_ _12848_/X _14897_/Q _13690_/Q VDD VSS sg13g2_xor2_1
XFILLER_62_888 VDD VSS sg13g2_fill_1
XFILLER_159_231 VDD VSS sg13g2_decap_8
X_12779_ _12792_/A _12956_/B _13293_/C _08692_/C VDD VSS sg13g2_a21oi_1
XFILLER_9_42 VDD VSS sg13g2_decap_8
X_14518_ _14518_/Q _14984_/CLK _14518_/D _14518_/RESET_B VDD VSS sg13g2_dfrbpq_1
XFILLER_174_234 VDD VSS sg13g2_decap_8
X_14449_ _14449_/Q _14737_/CLK _14449_/D _14449_/RESET_B VDD VSS sg13g2_dfrbpq_1
X_15011__2576 _15011_/RESET_B VDD VSS sg13g2_tiehi
XFILLER_174_245 VDD VSS sg13g2_decap_8
XFILLER_128_673 VDD VSS sg13g2_decap_8
XFILLER_162_418 VDD VSS sg13g2_decap_8
XFILLER_155_492 VDD VSS sg13g2_decap_8
XFILLER_157_1223 VDD VSS sg13g2_decap_8
XFILLER_143_654 VDD VSS sg13g2_decap_8
X_09990_ _14573_/D _10056_/A0 _14573_/Q _09994_/S VDD VSS sg13g2_mux2_1
XFILLER_157_1256 VDD VSS sg13g2_fill_2
XFILLER_157_1267 VDD VSS sg13g2_fill_1
XFILLER_170_462 VDD VSS sg13g2_decap_8
XFILLER_43_0 VDD VSS sg13g2_decap_8
XFILLER_118_1229 VDD VSS sg13g2_decap_8
Xhold3017 input37/A mem_axi_wready VDD VSS sg13g2_dlygate4sd3_1
X_08941_ _13719_/D _16881_/A _08940_/X _08941_/S VDD VSS sg13g2_mux2_1
Xhold3028 input29/A mem_axi_rdata[3] VDD VSS sg13g2_dlygate4sd3_1
XFILLER_88_229 VDD VSS sg13g2_decap_8
Xhold3039 hold3039/X input34/X VDD VSS sg13g2_dlygate4sd3_1
XFILLER_9_1022 VDD VSS sg13g2_decap_8
X_08872_ _13701_/D _16863_/A _08871_/X _08941_/S VDD VSS sg13g2_mux2_1
XFILLER_85_903 VDD VSS sg13g2_decap_8
X_07823_ _07823_/Y _07822_/A _07822_/B _07818_/Y VDD VSS sg13g2_o21ai_1
Xclkbuf_5_15__f_clk_i clkbuf_leaf_43_clk_i/A clkbuf_4_7_0_clk_i/X VDD VSS sg13g2_buf_16
XFILLER_9_1099 VDD VSS sg13g2_decap_8
XFILLER_42_1161 VDD VSS sg13g2_decap_8
X_14282__1897 _14282_/RESET_B VDD VSS sg13g2_tiehi
XFILLER_42_1172 VDD VSS sg13g2_fill_1
XFILLER_38_852 VDD VSS sg13g2_decap_4
X_07754_ _07754_/Y _10172_/A _07754_/B VDD VSS sg13g2_nor2_1
XFILLER_42_1183 VDD VSS sg13g2_fill_1
X_15248__3016 _15248_/RESET_B VDD VSS sg13g2_tiehi
XFILLER_93_980 VDD VSS sg13g2_fill_2
XFILLER_65_671 VDD VSS sg13g2_fill_1
XFILLER_77_1224 VDD VSS sg13g2_decap_8
X_07685_ _07687_/B _15055_/Q _13293_/D _10172_/A VDD VSS sg13g2_a21o_1
X_14619__1560 _14619_/RESET_B VDD VSS sg13g2_tiehi
XFILLER_129_1325 VDD VSS sg13g2_decap_8
XFILLER_44_28 VDD VSS sg13g2_decap_8
XFILLER_164_1216 VDD VSS sg13g2_decap_4
X_09424_ _14026_/D _09622_/A0 _14026_/Q _09434_/S VDD VSS sg13g2_mux2_1
XFILLER_38_1219 VDD VSS sg13g2_decap_4
XFILLER_53_877 VDD VSS sg13g2_decap_8
XFILLER_80_674 VDD VSS sg13g2_decap_8
XFILLER_52_376 VDD VSS sg13g2_decap_8
X_09355_ _13959_/D _09984_/A0 _13959_/Q _09370_/S VDD VSS sg13g2_mux2_1
XFILLER_127_1071 VDD VSS sg13g2_fill_2
XFILLER_100_56 VDD VSS sg13g2_decap_8
X_08306_ _08306_/Y _08541_/A _08306_/B _08306_/C VDD VSS sg13g2_nand3_1
XFILLER_139_949 VDD VSS sg13g2_fill_1
X_09286_ _13894_/D _13894_/Q _10082_/A0 _09297_/S VDD VSS sg13g2_mux2_1
XFILLER_21_763 VDD VSS sg13g2_decap_8
X_08237_ _08237_/Y _08036_/A _08234_/Y _08431_/C _08236_/X VDD VSS sg13g2_a22oi_1
XFILLER_20_273 VDD VSS sg13g2_decap_8
XFILLER_119_640 VDD VSS sg13g2_decap_4
XFILLER_121_7 VDD VSS sg13g2_decap_8
XFILLER_165_245 VDD VSS sg13g2_decap_8
XFILLER_101_1200 VDD VSS sg13g2_fill_1
XFILLER_119_651 VDD VSS sg13g2_fill_1
XFILLER_88_1320 VDD VSS sg13g2_decap_4
XFILLER_14_1274 VDD VSS sg13g2_decap_8
XFILLER_4_406 VDD VSS sg13g2_decap_8
XFILLER_10_1127 VDD VSS sg13g2_decap_8
X_08168_ _08168_/Y _08014_/B _08044_/X _08167_/X VDD VSS sg13g2_o21ai_1
XFILLER_84_1206 VDD VSS sg13g2_decap_8
XFILLER_69_14 VDD VSS sg13g2_decap_8
XFILLER_133_131 VDD VSS sg13g2_decap_8
XFILLER_162_963 VDD VSS sg13g2_decap_8
X_08099_ _08200_/C _08219_/A _08258_/C _07888_/B _07929_/B _08402_/A _08063_/A VDD
+ VSS sg13g2_mux4_1
X_14721__1458 _14721_/RESET_B VDD VSS sg13g2_tiehi
X_10130_ _14708_/D _10163_/A1 _14708_/Q _10136_/S VDD VSS sg13g2_mux2_1
XFILLER_121_326 VDD VSS sg13g2_fill_1
Xclkbuf_leaf_112_clk_i _14644_/CLK clkbuf_5_7__f_clk_i/X VDD VSS sg13g2_buf_8
XFILLER_0_623 VDD VSS sg13g2_decap_8
XFILLER_125_42 VDD VSS sg13g2_fill_2
X_10061_ _14642_/D _10061_/A0 _14642_/Q _10069_/S VDD VSS sg13g2_mux2_1
XFILLER_76_903 VDD VSS sg13g2_decap_8
X_15095__2791 _15095_/RESET_B VDD VSS sg13g2_tiehi
XFILLER_88_763 VDD VSS sg13g2_decap_8
XFILLER_130_860 VDD VSS sg13g2_fill_2
XFILLER_87_251 VDD VSS sg13g2_fill_1
XFILLER_102_562 VDD VSS sg13g2_fill_1
XFILLER_85_24 VDD VSS sg13g2_decap_8
XFILLER_47_104 VDD VSS sg13g2_decap_4
XFILLER_87_295 VDD VSS sg13g2_decap_8
X_13820_ _13820_/Q _14746_/CLK _13820_/D _13820_/RESET_B VDD VSS sg13g2_dfrbpq_1
XFILLER_169_1127 VDD VSS sg13g2_decap_8
Xclkbuf_leaf_127_clk_i clkload1/A clkbuf_leaf_2_clk_i/A VDD VSS sg13g2_buf_8
XFILLER_63_619 VDD VSS sg13g2_decap_8
XFILLER_21_1267 VDD VSS sg13g2_decap_8
X_13751_ _13751_/Q clkload32/A _13751_/D _13751_/RESET_B VDD VSS sg13g2_dfrbpq_1
XFILLER_18_84 VDD VSS sg13g2_decap_8
X_10963_ _10964_/B _10949_/Y _11004_/A _10942_/Y VDD VSS sg13g2_a21oi_1
XFILLER_55_170 VDD VSS sg13g2_decap_8
XFILLER_16_546 VDD VSS sg13g2_decap_8
X_12702_ _12702_/X _14580_/Q _14612_/Q _14644_/Q _14676_/Q _12703_/S0 _12703_/S1 VDD
+ VSS sg13g2_mux4_1
X_13682_ _13682_/Q clkload66/A _13682_/D _13682_/RESET_B VDD VSS sg13g2_dfrbpq_1
XFILLER_70_140 VDD VSS sg13g2_decap_8
XFILLER_43_354 VDD VSS sg13g2_decap_4
X_10894_ _10904_/B _10893_/A _10893_/B _10948_/A VDD VSS sg13g2_a21o_1
XFILLER_44_899 VDD VSS sg13g2_fill_2
X_12633_ _12633_/X _14703_/Q _14735_/Q _13775_/Q _13807_/Q _12633_/S0 _12633_/S1 VDD
+ VSS sg13g2_mux4_1
XFILLER_19_1141 VDD VSS sg13g2_decap_8
XFILLER_106_1111 VDD VSS sg13g2_decap_4
XFILLER_54_1065 VDD VSS sg13g2_decap_8
XFILLER_12_763 VDD VSS sg13g2_decap_8
XFILLER_157_724 VDD VSS sg13g2_fill_2
X_12564_ _12564_/X _13962_/Q _13994_/Q _14026_/Q _14058_/Q _12614_/S0 _12614_/S1 VDD
+ VSS sg13g2_mux4_1
XFILLER_169_595 VDD VSS sg13g2_decap_8
XFILLER_129_437 VDD VSS sg13g2_decap_8
X_14303_ _14303_/Q clkload14/A _14303_/D _14303_/RESET_B VDD VSS sg13g2_dfrbpq_1
XFILLER_11_273 VDD VSS sg13g2_decap_8
X_11515_ _11516_/A _11509_/X _11510_/X _11513_/X _11514_/X _12290_/S0 _12293_/A1 VDD
+ VSS sg13g2_mux4_1
XFILLER_32_1330 VDD VSS sg13g2_decap_8
XFILLER_8_756 VDD VSS sg13g2_decap_8
X_12495_ _12495_/X _12492_/X _12491_/X _12488_/X _12487_/X _12663_/S1 _12663_/S0 VDD
+ VSS sg13g2_mux4_1
XFILLER_89_1128 VDD VSS sg13g2_decap_8
X_14057__2122 _14057_/RESET_B VDD VSS sg13g2_tiehi
X_14234_ _14234_/Q _14682_/CLK _14234_/D _14234_/RESET_B VDD VSS sg13g2_dfrbpq_1
XFILLER_7_266 VDD VSS sg13g2_decap_8
XFILLER_138_993 VDD VSS sg13g2_decap_8
X_11446_ _11446_/Y _11446_/A _11446_/B VDD VSS sg13g2_nor2_1
XFILLER_125_621 VDD VSS sg13g2_decap_8
XFILLER_153_930 VDD VSS sg13g2_decap_8
XFILLER_50_93 VDD VSS sg13g2_decap_4
X_14165_ _14165_/Q _14677_/CLK _14165_/D _14165_/RESET_B VDD VSS sg13g2_dfrbpq_1
X_11377_ _11377_/Y _11375_/Y _11374_/Y _11881_/C1 _11376_/X VDD VSS sg13g2_a22oi_1
XFILLER_4_973 VDD VSS sg13g2_decap_8
X_13116_ _13171_/A _13116_/A _13116_/B _13116_/C VDD VSS sg13g2_nand3_1
X_10328_ _14802_/D _10414_/B _10345_/C _10325_/B _07646_/Y _10572_/B VDD VSS sg13g2_a221oi_1
X_14096_ _14096_/Q clkload8/A _14096_/D _14096_/RESET_B VDD VSS sg13g2_dfrbpq_1
XFILLER_124_186 VDD VSS sg13g2_decap_8
XFILLER_3_483 VDD VSS sg13g2_decap_8
XFILLER_26_1112 VDD VSS sg13g2_decap_8
XFILLER_152_1120 VDD VSS sg13g2_decap_8
X_13047_ _13048_/A _12937_/A _13046_/Y _12933_/Y VDD VSS sg13g2_o21ai_1
XFILLER_152_1131 VDD VSS sg13g2_fill_2
X_10259_ _10259_/Y _10265_/A _10265_/D _10295_/C VDD VSS sg13g2_o21ai_1
XFILLER_113_1104 VDD VSS sg13g2_fill_1
X_14805__2908 _14805_/RESET_B VDD VSS sg13g2_tiehi
XFILLER_61_1036 VDD VSS sg13g2_fill_1
Xfanout1240 _11743_/C _12237_/C VDD VSS sg13g2_buf_1
Xfanout1251 _11419_/C _07654_/A VDD VSS sg13g2_buf_1
XFILLER_6_1239 VDD VSS sg13g2_decap_8
XFILLER_117_1295 VDD VSS sg13g2_decap_8
Xfanout1262 _11374_/C _11805_/C VDD VSS sg13g2_buf_1
XFILLER_67_947 VDD VSS sg13g2_fill_1
XFILLER_38_115 VDD VSS sg13g2_fill_1
Xfanout1273 _11262_/B _12319_/B1 VDD VSS sg13g2_buf_1
XFILLER_94_744 VDD VSS sg13g2_decap_8
XFILLER_38_126 VDD VSS sg13g2_decap_8
XFILLER_26_1189 VDD VSS sg13g2_decap_8
XFILLER_67_969 VDD VSS sg13g2_decap_8
XFILLER_66_446 VDD VSS sg13g2_decap_8
Xfanout1284 _12282_/S1 _12288_/S1 VDD VSS sg13g2_buf_1
Xfanout1295 _11993_/S0 _11996_/S0 VDD VSS sg13g2_buf_1
XFILLER_66_457 VDD VSS sg13g2_fill_1
XFILLER_82_928 VDD VSS sg13g2_decap_4
X_14998_ _14998_/Q clkload32/A _14998_/D _14998_/RESET_B VDD VSS sg13g2_dfrbpq_1
X_15029__2558 _15029_/RESET_B VDD VSS sg13g2_tiehi
XFILLER_93_276 VDD VSS sg13g2_decap_8
X_13949_ _13949_/Q clkload38/A _13949_/D _13949_/RESET_B VDD VSS sg13g2_dfrbpq_1
XFILLER_46_170 VDD VSS sg13g2_decap_8
XFILLER_90_950 VDD VSS sg13g2_decap_8
Xclkbuf_leaf_91_clk_i _14890_/CLK clkbuf_leaf_92_clk_i/A VDD VSS sg13g2_buf_8
XFILLER_90_983 VDD VSS sg13g2_decap_8
XFILLER_72_1110 VDD VSS sg13g2_decap_8
X_14267__1912 _14267_/RESET_B VDD VSS sg13g2_tiehi
X_09140_ _10781_/A _15049_/Q _15246_/Q _09140_/S VDD VSS sg13g2_mux2_1
XFILLER_72_1165 VDD VSS sg13g2_decap_8
XFILLER_124_1244 VDD VSS sg13g2_decap_8
XFILLER_124_1266 VDD VSS sg13g2_decap_4
X_09071_ _13772_/D _13772_/Q _10088_/A0 _09167_/S VDD VSS sg13g2_mux2_1
XFILLER_129_971 VDD VSS sg13g2_decap_8
XFILLER_147_278 VDD VSS sg13g2_decap_8
X_08022_ _08402_/C _08426_/A _08254_/S VDD VSS sg13g2_nand2_1
XFILLER_135_429 VDD VSS sg13g2_fill_1
XFILLER_162_259 VDD VSS sg13g2_decap_8
XFILLER_104_838 VDD VSS sg13g2_decap_8
XFILLER_115_175 VDD VSS sg13g2_decap_8
XFILLER_157_1075 VDD VSS sg13g2_decap_8
X_09973_ _14556_/D _10072_/A0 _14556_/Q _09997_/S VDD VSS sg13g2_mux2_1
X_14764__2950 _14764_/RESET_B VDD VSS sg13g2_tiehi
XFILLER_44_1201 VDD VSS sg13g2_decap_8
XFILLER_131_657 VDD VSS sg13g2_decap_8
XFILLER_39_28 VDD VSS sg13g2_decap_8
XFILLER_103_359 VDD VSS sg13g2_decap_8
X_08924_ _08924_/X _15044_/Q _14948_/Q _10757_/A VDD VSS sg13g2_mux2_1
XFILLER_44_1234 VDD VSS sg13g2_decap_4
XFILLER_130_167 VDD VSS sg13g2_decap_8
XFILLER_97_560 VDD VSS sg13g2_decap_8
X_13755__2424 _13755_/RESET_B VDD VSS sg13g2_tiehi
Xclkbuf_leaf_44_clk_i clkload31/A clkbuf_leaf_44_clk_i/A VDD VSS sg13g2_buf_8
XFILLER_131_1215 VDD VSS sg13g2_fill_2
XFILLER_170_1264 VDD VSS sg13g2_decap_8
XFILLER_85_722 VDD VSS sg13g2_decap_8
X_08855_ _13696_/D _16858_/A _08854_/X _08855_/S VDD VSS sg13g2_mux2_1
XFILLER_170_1275 VDD VSS sg13g2_fill_2
XFILLER_97_593 VDD VSS sg13g2_decap_8
X_07806_ _07948_/A _07807_/C _08476_/A VDD VSS sg13g2_and2_1
X_08786_ _13680_/D _08728_/Y _08785_/Y _08784_/Y VDD VSS sg13g2_a21oi_1
XFILLER_55_49 VDD VSS sg13g2_decap_4
X_07737_ _07737_/Y _10213_/A _07737_/B VDD VSS sg13g2_nand2_1
Xclkbuf_leaf_59_clk_i clkload71/A clkbuf_leaf_61_clk_i/A VDD VSS sg13g2_buf_8
XFILLER_65_490 VDD VSS sg13g2_decap_8
XFILLER_53_630 VDD VSS sg13g2_decap_8
XFILLER_169_7 VDD VSS sg13g2_decap_8
XFILLER_37_192 VDD VSS sg13g2_decap_8
XFILLER_26_855 VDD VSS sg13g2_decap_8
XFILLER_25_332 VDD VSS sg13g2_decap_8
X_14135__2044 _14135_/RESET_B VDD VSS sg13g2_tiehi
XFILLER_38_1005 VDD VSS sg13g2_decap_8
X_07668_ _10171_/D _13613_/B _13613_/C VDD VSS sg13g2_nand2_1
XFILLER_164_1024 VDD VSS sg13g2_fill_2
XFILLER_81_983 VDD VSS sg13g2_decap_8
XFILLER_26_899 VDD VSS sg13g2_fill_2
XFILLER_0_1383 VDD VSS sg13g2_fill_1
X_09407_ _14010_/D _09970_/A1 _14010_/Q _09407_/S VDD VSS sg13g2_mux2_1
XFILLER_125_1008 VDD VSS sg13g2_decap_8
XFILLER_125_1019 VDD VSS sg13g2_fill_1
XFILLER_142_1322 VDD VSS sg13g2_decap_8
X_09338_ _13945_/D _09338_/A0 _13945_/Q _09338_/S VDD VSS sg13g2_mux2_1
XFILLER_21_560 VDD VSS sg13g2_decap_8
XFILLER_166_532 VDD VSS sg13g2_decap_8
XFILLER_16_1358 VDD VSS sg13g2_decap_8
XFILLER_138_234 VDD VSS sg13g2_decap_8
X_09269_ _13878_/D _13878_/Q _10165_/A1 _09271_/S VDD VSS sg13g2_mux2_1
XFILLER_103_1339 VDD VSS sg13g2_decap_4
XFILLER_139_779 VDD VSS sg13g2_decap_8
X_11300_ _11300_/X _14685_/Q _14717_/Q _13757_/Q _13789_/Q _11300_/S0 _11366_/C VDD
+ VSS sg13g2_mux4_1
XFILLER_14_1071 VDD VSS sg13g2_decap_8
XFILLER_153_215 VDD VSS sg13g2_decap_8
X_12280_ _12280_/Y _12280_/A _12280_/B VDD VSS sg13g2_xnor2_1
XFILLER_4_203 VDD VSS sg13g2_decap_8
XFILLER_147_790 VDD VSS sg13g2_decap_8
XFILLER_101_1052 VDD VSS sg13g2_decap_8
XFILLER_101_1063 VDD VSS sg13g2_decap_4
X_11231_ _11231_/X _11230_/X _11227_/X _11231_/S VDD VSS sg13g2_mux2_1
XFILLER_134_440 VDD VSS sg13g2_decap_8
XFILLER_150_900 VDD VSS sg13g2_decap_8
XFILLER_20_63 VDD VSS sg13g2_decap_8
XFILLER_84_1047 VDD VSS sg13g2_fill_2
XFILLER_1_910 VDD VSS sg13g2_decap_8
XFILLER_106_175 VDD VSS sg13g2_decap_8
XFILLER_150_933 VDD VSS sg13g2_decap_8
X_11162_ _11162_/Y _14953_/Q _10720_/A _11152_/B _11180_/C _10781_/X VDD VSS sg13g2_a221oi_1
XFILLER_136_63 VDD VSS sg13g2_decap_8
XFILLER_150_944 VDD VSS sg13g2_decap_8
XFILLER_84_1058 VDD VSS sg13g2_decap_8
XFILLER_122_646 VDD VSS sg13g2_decap_8
XFILLER_150_955 VDD VSS sg13g2_fill_1
XFILLER_0_420 VDD VSS sg13g2_decap_8
X_10113_ _14691_/D _10146_/A1 _14691_/Q _10135_/S VDD VSS sg13g2_mux2_1
XFILLER_62_1312 VDD VSS sg13g2_decap_8
XFILLER_122_668 VDD VSS sg13g2_decap_8
XFILLER_110_819 VDD VSS sg13g2_decap_8
X_11093_ _11093_/Y _11094_/B _11118_/C VDD VSS sg13g2_nand2_1
XFILLER_1_987 VDD VSS sg13g2_decap_8
XFILLER_62_1356 VDD VSS sg13g2_fill_1
XFILLER_23_1307 VDD VSS sg13g2_decap_8
X_14345__1834 _14345_/RESET_B VDD VSS sg13g2_tiehi
X_14921_ _14921_/Q clkload54/A _14921_/D _14921_/RESET_B VDD VSS sg13g2_dfrbpq_1
X_10044_ _14625_/D _10077_/A0 _14625_/Q _10064_/S VDD VSS sg13g2_mux2_1
XFILLER_62_1367 VDD VSS sg13g2_decap_8
XFILLER_0_497 VDD VSS sg13g2_decap_8
XFILLER_75_221 VDD VSS sg13g2_decap_8
XFILLER_62_1378 VDD VSS sg13g2_fill_2
X_14852_ _14852_/Q _14854_/CLK _14852_/D _14852_/RESET_B VDD VSS sg13g2_dfrbpq_1
XFILLER_64_928 VDD VSS sg13g2_decap_8
XFILLER_152_84 VDD VSS sg13g2_decap_8
XFILLER_63_405 VDD VSS sg13g2_fill_1
XFILLER_76_799 VDD VSS sg13g2_decap_8
XFILLER_63_416 VDD VSS sg13g2_fill_1
X_13803_ _13803_/Q clkload1/A _13803_/D _13803_/RESET_B VDD VSS sg13g2_dfrbpq_1
X_14783_ _14783_/Q _14894_/CLK _14783_/D _14783_/RESET_B VDD VSS sg13g2_dfrbpq_1
XFILLER_28_170 VDD VSS sg13g2_decap_8
XFILLER_21_1064 VDD VSS sg13g2_decap_8
XFILLER_17_833 VDD VSS sg13g2_decap_8
X_11995_ _11995_/X _13841_/Q _13873_/Q _13905_/Q _13937_/Q _11996_/S0 _11995_/S1 VDD
+ VSS sg13g2_mux4_1
XFILLER_91_769 VDD VSS sg13g2_decap_8
XFILLER_16_343 VDD VSS sg13g2_decap_8
X_13734_ _13734_/Q _14662_/CLK _13734_/D _13734_/RESET_B VDD VSS sg13g2_dfrbpq_1
XFILLER_95_1154 VDD VSS sg13g2_fill_2
XFILLER_44_652 VDD VSS sg13g2_decap_8
XFILLER_1_1169 VDD VSS sg13g2_decap_8
X_10946_ _10946_/Y _10946_/A _10946_/B VDD VSS sg13g2_nand2_1
XFILLER_56_1127 VDD VSS sg13g2_fill_2
XFILLER_31_302 VDD VSS sg13g2_decap_8
XFILLER_108_1217 VDD VSS sg13g2_fill_2
XFILLER_71_482 VDD VSS sg13g2_decap_8
XFILLER_56_1149 VDD VSS sg13g2_decap_8
XFILLER_31_313 VDD VSS sg13g2_fill_2
X_13665_ _13665_/Q clkload63/A _13665_/D _13665_/RESET_B VDD VSS sg13g2_dfrbpq_1
XFILLER_108_1239 VDD VSS sg13g2_decap_8
X_10877_ _10878_/B _10897_/D _10897_/B _10897_/A VDD VSS sg13g2_o21ai_1
XFILLER_43_195 VDD VSS sg13g2_fill_2
XFILLER_32_858 VDD VSS sg13g2_decap_8
X_12616_ _12616_/X _14254_/Q _14286_/Q _14318_/Q _14350_/Q _12618_/S0 _12618_/S1 VDD
+ VSS sg13g2_mux4_1
X_13596_ _13596_/Y _13600_/A _13600_/C VDD VSS sg13g2_nand2_1
XFILLER_84_7 VDD VSS sg13g2_decap_8
XFILLER_12_560 VDD VSS sg13g2_decap_8
XFILLER_169_392 VDD VSS sg13g2_decap_8
XFILLER_61_70 VDD VSS sg13g2_decap_8
X_12547_ _12547_/X _14569_/Q _14601_/Q _14633_/Q _14665_/Q _12767_/S0 _12767_/S1 VDD
+ VSS sg13g2_mux4_1
XFILLER_145_705 VDD VSS sg13g2_decap_8
XFILLER_8_553 VDD VSS sg13g2_decap_8
X_13833__2346 _13833_/RESET_B VDD VSS sg13g2_tiehi
XFILLER_129_278 VDD VSS sg13g2_decap_4
X_14593__1586 _14593_/RESET_B VDD VSS sg13g2_tiehi
XFILLER_6_21 VDD VSS sg13g2_decap_8
X_12478_ _12478_/X _13732_/Q _14084_/Q _14436_/Q _14532_/Q _12727_/S0 _12727_/S1 VDD
+ VSS sg13g2_mux4_1
XANTENNA_3 _09019_/Y VDD VSS sg13g2_antennanp
XFILLER_126_952 VDD VSS sg13g2_decap_8
X_14217_ _14217_/Q _14649_/CLK _14217_/D _14217_/RESET_B VDD VSS sg13g2_dfrbpq_1
X_15247__3015 _15247_/RESET_B VDD VSS sg13g2_tiehi
XFILLER_126_963 VDD VSS sg13g2_decap_8
X_11429_ _11430_/B _11385_/B _11385_/A _11383_/Y VDD VSS sg13g2_o21ai_1
X_15197_ _15197_/Q clkload55/A _15197_/D _15197_/RESET_B VDD VSS sg13g2_dfrbpq_1
XFILLER_99_803 VDD VSS sg13g2_decap_8
XFILLER_6_98 VDD VSS sg13g2_decap_8
XFILLER_119_1324 VDD VSS sg13g2_decap_8
XFILLER_141_922 VDD VSS sg13g2_decap_8
X_14148_ _14148_/Q _14660_/CLK _14148_/D _14148_/RESET_B VDD VSS sg13g2_dfrbpq_1
XFILLER_4_770 VDD VSS sg13g2_decap_8
XFILLER_112_101 VDD VSS sg13g2_decap_8
XFILLER_98_346 VDD VSS sg13g2_decap_8
XFILLER_3_280 VDD VSS sg13g2_decap_8
XFILLER_141_988 VDD VSS sg13g2_decap_4
X_14079_ _14079_/Q _14733_/CLK _14079_/D _14079_/RESET_B VDD VSS sg13g2_dfrbpq_1
XFILLER_100_307 VDD VSS sg13g2_decap_8
XFILLER_6_1036 VDD VSS sg13g2_decap_8
Xfanout1070 _08207_/S1 _13521_/A VDD VSS sg13g2_buf_1
Xfanout1081 _08253_/S0 _08137_/S0 VDD VSS sg13g2_buf_1
X_08640_ _08640_/X _08640_/A _08640_/B _08640_/C _08640_/D VDD VSS sg13g2_and4_1
Xfanout1092 _07972_/B _12203_/A VDD VSS sg13g2_buf_1
XFILLER_148_1008 VDD VSS sg13g2_decap_8
X_08571_ _08571_/Y _08574_/C _08574_/D VDD VSS sg13g2_nand2_1
XFILLER_81_224 VDD VSS sg13g2_decap_8
XFILLER_54_449 VDD VSS sg13g2_decap_8
XFILLER_165_1322 VDD VSS sg13g2_fill_2
XFILLER_35_674 VDD VSS sg13g2_fill_1
XFILLER_62_471 VDD VSS sg13g2_fill_1
XFILLER_39_1358 VDD VSS sg13g2_decap_8
XFILLER_34_173 VDD VSS sg13g2_fill_1
XFILLER_74_1249 VDD VSS sg13g2_fill_1
XFILLER_126_1328 VDD VSS sg13g2_decap_8
XFILLER_22_357 VDD VSS sg13g2_decap_8
XFILLER_167_329 VDD VSS sg13g2_decap_8
XFILLER_148_510 VDD VSS sg13g2_decap_8
XFILLER_31_880 VDD VSS sg13g2_decap_8
X_09123_ _09150_/C _14919_/Q _13189_/A _10760_/A VDD VSS sg13g2_and3_1
XFILLER_124_1063 VDD VSS sg13g2_fill_1
XFILLER_148_565 VDD VSS sg13g2_fill_2
XFILLER_108_407 VDD VSS sg13g2_decap_4
XFILLER_124_1085 VDD VSS sg13g2_decap_8
XFILLER_124_1096 VDD VSS sg13g2_fill_1
XFILLER_135_204 VDD VSS sg13g2_decap_8
XFILLER_11_1211 VDD VSS sg13g2_decap_8
X_14423__1756 _14423_/RESET_B VDD VSS sg13g2_tiehi
X_09054_ _10725_/B _09100_/B _15036_/Q _09053_/Y VDD VSS sg13g2_o21ai_1
X_13809__2370 _13809_/RESET_B VDD VSS sg13g2_tiehi
XFILLER_50_1271 VDD VSS sg13g2_decap_8
XFILLER_163_546 VDD VSS sg13g2_decap_8
X_08005_ _08005_/X _07826_/B _07945_/B _08493_/B2 _08471_/B _08009_/S _08235_/S0 VDD
+ VSS sg13g2_mux4_1
XFILLER_151_708 VDD VSS sg13g2_decap_8
XFILLER_117_974 VDD VSS sg13g2_decap_4
XFILLER_132_900 VDD VSS sg13g2_decap_4
XFILLER_2_707 VDD VSS sg13g2_decap_8
XFILLER_11_1288 VDD VSS sg13g2_decap_8
XFILLER_1_217 VDD VSS sg13g2_decap_8
XFILLER_173_28 VDD VSS sg13g2_decap_8
XFILLER_172_1315 VDD VSS sg13g2_decap_8
XFILLER_116_495 VDD VSS sg13g2_decap_8
Xclkbuf_5_30__f_clk_i clkbuf_leaf_62_clk_i/A clkbuf_4_15_0_clk_i/X VDD VSS sg13g2_buf_16
XFILLER_81_1209 VDD VSS sg13g2_decap_8
X_09956_ _14540_/D _14540_/Q _10088_/A0 _09968_/S VDD VSS sg13g2_mux2_1
X_08907_ _08907_/Y _10747_/A _14944_/Q VDD VSS sg13g2_nand2_1
X_09887_ _14473_/D _09920_/A1 _14473_/Q _09899_/S VDD VSS sg13g2_mux2_1
XFILLER_57_232 VDD VSS sg13g2_fill_2
XFILLER_85_552 VDD VSS sg13g2_fill_1
XFILLER_100_863 VDD VSS sg13g2_fill_1
X_08838_ _08838_/Y _10793_/A _10697_/B VDD VSS sg13g2_nand2_1
XFILLER_85_563 VDD VSS sg13g2_decap_4
XFILLER_79_1105 VDD VSS sg13g2_decap_8
XFILLER_122_21 VDD VSS sg13g2_decap_8
XFILLER_131_1078 VDD VSS sg13g2_decap_4
X_08769_ _08769_/Y _13675_/Q _08775_/B VDD VSS sg13g2_nor2_1
XFILLER_72_224 VDD VSS sg13g2_decap_8
XFILLER_22_1373 VDD VSS sg13g2_decap_8
XFILLER_38_490 VDD VSS sg13g2_decap_8
X_13911__2268 _13911_/RESET_B VDD VSS sg13g2_tiehi
XFILLER_82_14 VDD VSS sg13g2_decap_8
X_10800_ _10800_/Y _10800_/A _10837_/B VDD VSS sg13g2_nand2_1
X_11780_ _11780_/Y _11910_/A _11912_/A VDD VSS sg13g2_xnor2_1
XFILLER_25_140 VDD VSS sg13g2_decap_8
XFILLER_26_674 VDD VSS sg13g2_decap_8
XFILLER_81_780 VDD VSS sg13g2_fill_1
XFILLER_14_847 VDD VSS sg13g2_decap_8
X_10731_ _14910_/D _10999_/B1 _10995_/B _10730_/Y VDD VSS sg13g2_o21ai_1
XFILLER_81_791 VDD VSS sg13g2_decap_4
XFILLER_15_63 VDD VSS sg13g2_decap_8
XFILLER_13_357 VDD VSS sg13g2_decap_8
X_15175__2875 _15175_/RESET_B VDD VSS sg13g2_tiehi
X_13450_ _13455_/B _15172_/Q _15173_/Q VDD VSS sg13g2_nand2b_1
X_10662_ _10664_/C _14892_/Q _10666_/D _14893_/Q VDD VSS sg13g2_a21oi_1
XFILLER_90_1051 VDD VSS sg13g2_decap_8
XFILLER_139_521 VDD VSS sg13g2_decap_8
X_12401_ _12401_/Y _15122_/Q _12348_/A _12777_/A2 _13690_/Q _13282_/A1 VDD VSS sg13g2_a221oi_1
XFILLER_107_1272 VDD VSS sg13g2_fill_1
XFILLER_16_1155 VDD VSS sg13g2_decap_8
X_13381_ _13382_/B _13389_/A _13396_/C VDD VSS sg13g2_nor2_1
XFILLER_12_1008 VDD VSS sg13g2_decap_8
X_10593_ _10595_/C _14874_/Q _10597_/D _14875_/Q VDD VSS sg13g2_a21oi_1
XFILLER_142_1185 VDD VSS sg13g2_decap_8
XFILLER_154_513 VDD VSS sg13g2_fill_2
X_15120_ _15120_/Q clkload72/A _15120_/D _15120_/RESET_B VDD VSS sg13g2_dfrbpq_1
XFILLER_103_1147 VDD VSS sg13g2_decap_8
X_12332_ _12332_/Y _12308_/Y _12310_/Y _12332_/B1 VDD VSS sg13g2_a21oi_1
XFILLER_139_598 VDD VSS sg13g2_fill_2
XFILLER_103_1169 VDD VSS sg13g2_fill_2
XFILLER_110_0 VDD VSS sg13g2_decap_8
X_15051_ _15051_/Q _15213_/CLK _15051_/D _15051_/RESET_B VDD VSS sg13g2_dfrbpq_1
XFILLER_31_84 VDD VSS sg13g2_decap_8
XFILLER_108_963 VDD VSS sg13g2_decap_8
X_12263_ _12263_/Y _12261_/Y _12263_/B _12334_/C VDD VSS sg13g2_nand3b_1
XFILLER_5_567 VDD VSS sg13g2_decap_8
XFILLER_107_462 VDD VSS sg13g2_fill_2
X_14002_ _14002_/Q _14632_/CLK _14002_/D _14002_/RESET_B VDD VSS sg13g2_dfrbpq_1
X_11214_ _11216_/A _11325_/B1 _11211_/X _11213_/X VDD VSS sg13g2_a21oi_1
X_12194_ _12194_/X _14921_/Q _11655_/B _12193_/Y VDD VSS sg13g2_a21o_1
XFILLER_134_281 VDD VSS sg13g2_decap_8
X_14845__2854 _14845_/RESET_B VDD VSS sg13g2_tiehi
Xoutput40 mem_axi_araddr[11] _16864_/A VDD VSS sg13g2_buf_1
Xoutput51 mem_axi_araddr[22] _16875_/A VDD VSS sg13g2_buf_1
Xoutput62 mem_axi_araddr[3] _16856_/A VDD VSS sg13g2_buf_1
X_14578__1601 _14578_/RESET_B VDD VSS sg13g2_tiehi
Xoutput73 mem_axi_awaddr[12] _16865_/X VDD VSS sg13g2_buf_1
X_11145_ _11150_/B _11145_/A _11164_/B VDD VSS sg13g2_xnor2_1
XFILLER_150_774 VDD VSS sg13g2_decap_8
Xoutput84 mem_axi_awaddr[23] _16876_/X VDD VSS sg13g2_buf_1
XFILLER_68_519 VDD VSS sg13g2_decap_4
XFILLER_62_1120 VDD VSS sg13g2_decap_8
Xoutput95 mem_axi_awaddr[4] _16857_/X VDD VSS sg13g2_buf_1
XFILLER_89_880 VDD VSS sg13g2_decap_8
XFILLER_7_1323 VDD VSS sg13g2_decap_8
XFILLER_1_784 VDD VSS sg13g2_decap_8
XFILLER_95_338 VDD VSS sg13g2_decap_8
XFILLER_153_1270 VDD VSS sg13g2_fill_2
X_11076_ _11077_/B _11088_/A _11118_/A _11058_/Y VDD VSS sg13g2_a21oi_1
XFILLER_62_1153 VDD VSS sg13g2_decap_8
XFILLER_23_1104 VDD VSS sg13g2_decap_8
XFILLER_0_294 VDD VSS sg13g2_decap_8
XFILLER_49_766 VDD VSS sg13g2_decap_8
X_14904_ _14904_/Q clkload56/A _14904_/D _14904_/RESET_B VDD VSS sg13g2_dfrbpq_1
X_10027_ _14609_/D _10127_/A0 _14609_/Q _10027_/S VDD VSS sg13g2_mux2_1
X_14878__2788 _14878_/RESET_B VDD VSS sg13g2_tiehi
XFILLER_64_747 VDD VSS sg13g2_decap_8
XFILLER_149_1317 VDD VSS sg13g2_decap_8
X_14835_ _14835_/Q _15064_/CLK _14835_/D _14835_/RESET_B VDD VSS sg13g2_dfrbpq_1
XFILLER_97_1249 VDD VSS sg13g2_decap_8
XFILLER_149_1328 VDD VSS sg13g2_fill_1
XFILLER_17_630 VDD VSS sg13g2_decap_8
XFILLER_91_555 VDD VSS sg13g2_decap_4
XFILLER_63_246 VDD VSS sg13g2_decap_8
X_14501__1678 _14501_/RESET_B VDD VSS sg13g2_tiehi
XFILLER_16_140 VDD VSS sg13g2_decap_8
X_14766_ _14766_/Q _15214_/CLK _14766_/D _14766_/RESET_B VDD VSS sg13g2_dfrbpq_1
X_11978_ _11978_/Y _11977_/X _12296_/A1 _11980_/A VDD VSS sg13g2_a21oi_1
X_13717_ _16879_/A clkload52/A _13717_/D _13717_/RESET_B VDD VSS sg13g2_dfrbpq_1
X_10929_ _10929_/Y _10929_/A _11170_/B VDD VSS sg13g2_nand2_1
XFILLER_44_493 VDD VSS sg13g2_decap_8
X_14697_ _14697_/Q clkload19/A _14697_/D _14697_/RESET_B VDD VSS sg13g2_dfrbpq_1
XFILLER_147_1074 VDD VSS sg13g2_fill_1
XFILLER_31_132 VDD VSS sg13g2_decap_8
XFILLER_32_666 VDD VSS sg13g2_decap_8
X_13648_ _14760_/D _15188_/D _14760_/Q _13652_/S VDD VSS sg13g2_mux2_1
XFILLER_72_91 VDD VSS sg13g2_decap_8
XFILLER_9_840 VDD VSS sg13g2_decap_8
XFILLER_73_1293 VDD VSS sg13g2_decap_8
XFILLER_125_1372 VDD VSS sg13g2_fill_2
XFILLER_158_874 VDD VSS sg13g2_decap_8
X_13579_ _15158_/D _13584_/B _13577_/Y _13578_/Y VDD VSS sg13g2_a21oi_1
XFILLER_158_885 VDD VSS sg13g2_fill_2
XFILLER_34_1277 VDD VSS sg13g2_decap_8
XFILLER_145_502 VDD VSS sg13g2_decap_8
XFILLER_8_350 VDD VSS sg13g2_decap_8
XFILLER_173_822 VDD VSS sg13g2_fill_2
XFILLER_118_738 VDD VSS sg13g2_decap_8
XFILLER_121_1247 VDD VSS sg13g2_fill_2
XFILLER_173_833 VDD VSS sg13g2_fill_1
XFILLER_118_749 VDD VSS sg13g2_fill_2
XFILLER_172_332 VDD VSS sg13g2_decap_8
XFILLER_172_343 VDD VSS sg13g2_decap_8
XFILLER_117_259 VDD VSS sg13g2_decap_8
X_15249_ _15249_/Q clkload58/A _15249_/D _15249_/RESET_B VDD VSS sg13g2_dfrbpq_1
XFILLER_119_1110 VDD VSS sg13g2_decap_4
XFILLER_67_1042 VDD VSS sg13g2_fill_2
XFILLER_113_410 VDD VSS sg13g2_decap_8
XFILLER_119_1121 VDD VSS sg13g2_decap_8
XFILLER_158_1181 VDD VSS sg13g2_decap_8
XFILLER_28_1015 VDD VSS sg13g2_decap_8
XFILLER_141_741 VDD VSS sg13g2_decap_8
XFILLER_67_1075 VDD VSS sg13g2_fill_2
X_15097__2783 _15097_/RESET_B VDD VSS sg13g2_tiehi
Xfanout307 _10167_/S _10156_/S VDD VSS sg13g2_buf_1
X_09810_ _14398_/D _09909_/A1 _14398_/Q _09832_/S VDD VSS sg13g2_mux2_1
Xfanout318 _09966_/S _09969_/S VDD VSS sg13g2_buf_1
XFILLER_98_154 VDD VSS sg13g2_decap_8
XFILLER_141_774 VDD VSS sg13g2_decap_4
Xfanout329 _09867_/S _09870_/S VDD VSS sg13g2_buf_1
XFILLER_87_839 VDD VSS sg13g2_decap_8
XFILLER_115_1029 VDD VSS sg13g2_decap_8
X_09741_ _14331_/D _14331_/Q _09774_/A0 _09766_/S VDD VSS sg13g2_mux2_1
XFILLER_154_1089 VDD VSS sg13g2_decap_8
XFILLER_86_338 VDD VSS sg13g2_decap_8
XFILLER_100_148 VDD VSS sg13g2_decap_4
XFILLER_41_1226 VDD VSS sg13g2_decap_8
X_09672_ _14265_/D _09936_/A1 _14265_/Q _09672_/S VDD VSS sg13g2_mux2_1
XFILLER_67_563 VDD VSS sg13g2_decap_4
XFILLER_95_883 VDD VSS sg13g2_decap_8
XFILLER_54_202 VDD VSS sg13g2_decap_8
X_08623_ _08623_/Y _07849_/X _08623_/A2 _08654_/B VDD VSS sg13g2_o21ai_1
XFILLER_55_758 VDD VSS sg13g2_decap_4
XFILLER_27_449 VDD VSS sg13g2_fill_2
X_08554_ _08554_/Y _08548_/A _08550_/Y _08553_/A VDD VSS sg13g2_o21ai_1
XFILLER_78_1160 VDD VSS sg13g2_decap_8
XFILLER_39_1111 VDD VSS sg13g2_decap_8
XFILLER_78_1171 VDD VSS sg13g2_fill_1
XFILLER_63_780 VDD VSS sg13g2_decap_8
XFILLER_165_1152 VDD VSS sg13g2_decap_8
XFILLER_74_1035 VDD VSS sg13g2_decap_8
X_08485_ _08485_/Y _07822_/B _08623_/A2 _08654_/B VDD VSS sg13g2_o21ai_1
XFILLER_161_1005 VDD VSS sg13g2_fill_2
XFILLER_52_28 VDD VSS sg13g2_decap_8
XFILLER_161_1027 VDD VSS sg13g2_fill_2
XFILLER_161_1038 VDD VSS sg13g2_decap_8
XFILLER_167_126 VDD VSS sg13g2_decap_8
XFILLER_168_28 VDD VSS sg13g2_decap_8
XFILLER_91_1360 VDD VSS sg13g2_fill_1
XFILLER_22_154 VDD VSS sg13g2_decap_8
XFILLER_149_830 VDD VSS sg13g2_decap_8
XFILLER_149_841 VDD VSS sg13g2_fill_1
X_14656__1523 _14656_/RESET_B VDD VSS sg13g2_tiehi
XFILLER_109_727 VDD VSS sg13g2_decap_8
X_09106_ _13777_/D _13777_/Q _10160_/A1 _09106_/S VDD VSS sg13g2_mux2_1
XFILLER_108_226 VDD VSS sg13g2_decap_4
XFILLER_163_343 VDD VSS sg13g2_decap_8
X_14085__2094 _14085_/RESET_B VDD VSS sg13g2_tiehi
XFILLER_164_877 VDD VSS sg13g2_fill_2
X_14800__2913 _14800_/RESET_B VDD VSS sg13g2_tiehi
X_09037_ _09037_/X _09057_/A _09034_/X _09036_/Y VDD VSS sg13g2_a21o_1
XFILLER_117_760 VDD VSS sg13g2_decap_4
XFILLER_117_771 VDD VSS sg13g2_decap_8
XFILLER_2_504 VDD VSS sg13g2_decap_8
XFILLER_117_21 VDD VSS sg13g2_decap_8
XFILLER_11_1085 VDD VSS sg13g2_decap_8
XFILLER_85_1142 VDD VSS sg13g2_decap_8
XFILLER_137_1210 VDD VSS sg13g2_fill_1
XFILLER_85_1153 VDD VSS sg13g2_decap_8
XFILLER_104_432 VDD VSS sg13g2_fill_1
XFILLER_77_14 VDD VSS sg13g2_decap_8
X_15024__2563 _15024_/RESET_B VDD VSS sg13g2_tiehi
XFILLER_132_796 VDD VSS sg13g2_fill_1
Xfanout830 _12522_/S1 _12717_/S1 VDD VSS sg13g2_buf_1
Xfanout841 _12773_/S1 fanout846/X VDD VSS sg13g2_buf_1
Xfanout852 _12660_/S0 fanout864/X VDD VSS sg13g2_buf_1
XFILLER_77_338 VDD VSS sg13g2_decap_8
X_09939_ _14523_/D _14523_/Q _10104_/A0 _09968_/S VDD VSS sg13g2_mux2_1
Xfanout863 _12759_/S0 fanout864/X VDD VSS sg13g2_buf_1
Xfanout874 _12785_/S0 _12782_/S0 VDD VSS sg13g2_buf_1
Xfanout885 _12731_/S0 fanout894/X VDD VSS sg13g2_buf_1
XFILLER_133_42 VDD VSS sg13g2_decap_4
X_12950_ _12950_/Y _12947_/Y _12948_/Y _12949_/Y VDD VSS sg13g2_a21oi_1
Xfanout896 _12745_/S0 fanout897/X VDD VSS sg13g2_buf_1
XFILLER_19_917 VDD VSS sg13g2_decap_8
XFILLER_100_660 VDD VSS sg13g2_fill_1
XFILLER_86_894 VDD VSS sg13g2_fill_2
XFILLER_58_585 VDD VSS sg13g2_decap_8
X_11901_ _11902_/A _11898_/Y _11900_/Y _11224_/A VDD VSS sg13g2_a21oi_1
XFILLER_18_427 VDD VSS sg13g2_decap_8
XFILLER_100_693 VDD VSS sg13g2_decap_4
X_12881_ _12881_/Y _14772_/Q _12918_/A2 _13140_/B2 VDD VSS sg13g2_o21ai_1
XFILLER_73_544 VDD VSS sg13g2_fill_1
XFILLER_22_1170 VDD VSS sg13g2_decap_8
XFILLER_27_950 VDD VSS sg13g2_decap_8
XFILLER_61_706 VDD VSS sg13g2_decap_8
XFILLER_2_1253 VDD VSS sg13g2_decap_8
X_14620_ _14620_/Q _14682_/CLK _14620_/D _14620_/RESET_B VDD VSS sg13g2_dfrbpq_1
X_11832_ _11832_/Y _11830_/Y _11832_/B _12118_/C VDD VSS sg13g2_nand3b_1
X_15246__3014 _15246_/RESET_B VDD VSS sg13g2_tiehi
XFILLER_33_419 VDD VSS sg13g2_decap_8
XFILLER_73_588 VDD VSS sg13g2_decap_4
XFILLER_92_1113 VDD VSS sg13g2_decap_4
XFILLER_60_227 VDD VSS sg13g2_decap_8
XFILLER_109_1312 VDD VSS sg13g2_decap_8
X_14551_ _14551_/Q clkload32/A _14551_/D _14551_/RESET_B VDD VSS sg13g2_dfrbpq_1
XFILLER_57_1244 VDD VSS sg13g2_fill_1
XFILLER_26_84 VDD VSS sg13g2_decap_8
XFILLER_148_1372 VDD VSS sg13g2_decap_8
XFILLER_158_0 VDD VSS sg13g2_decap_8
X_11763_ _11763_/Y _11763_/A _11763_/B VDD VSS sg13g2_nand2_1
XFILLER_42_942 VDD VSS sg13g2_fill_2
XFILLER_14_644 VDD VSS sg13g2_decap_8
XFILLER_144_1225 VDD VSS sg13g2_decap_4
XFILLER_42_964 VDD VSS sg13g2_decap_8
XFILLER_41_441 VDD VSS sg13g2_fill_1
X_13502_ _13504_/A _13502_/A _13502_/B _15175_/D _13502_/D VDD VSS sg13g2_or4_1
X_14295__1884 _14295_/RESET_B VDD VSS sg13g2_tiehi
X_10714_ _10714_/Y _14906_/Q _10941_/B VDD VSS sg13g2_nand2_1
XFILLER_18_1239 VDD VSS sg13g2_decap_8
XFILLER_13_154 VDD VSS sg13g2_decap_8
X_14482_ _14482_/Q _14632_/CLK _14482_/D _14482_/RESET_B VDD VSS sg13g2_dfrbpq_1
XFILLER_105_1209 VDD VSS sg13g2_fill_2
XFILLER_158_126 VDD VSS sg13g2_decap_8
X_11694_ _11694_/Y _11694_/A _11694_/B _11743_/C VDD VSS sg13g2_nand3_1
X_13433_ _13433_/Y _13433_/A _13435_/B _13444_/C VDD VSS sg13g2_nor3_1
X_10645_ _14889_/D _14889_/Q _10643_/C _10644_/Y VDD VSS sg13g2_a21oi_1
XFILLER_9_147 VDD VSS sg13g2_decap_8
XFILLER_155_811 VDD VSS sg13g2_decap_8
XFILLER_10_861 VDD VSS sg13g2_decap_8
XFILLER_155_833 VDD VSS sg13g2_decap_4
X_13364_ _13435_/A _13396_/C _13364_/B VDD VSS sg13g2_nand2_1
X_10576_ _10584_/C _14870_/Q _10647_/C _10576_/C _10576_/D VDD VSS sg13g2_and4_1
X_15103_ _15103_/Q clkload68/A _15103_/D _15103_/RESET_B VDD VSS sg13g2_dfrbpq_1
X_12315_ _12315_/Y _12311_/Y _12312_/Y _12314_/Y _12313_/Y _12317_/B VDD VSS sg13g2_a221oi_1
XFILLER_6_854 VDD VSS sg13g2_decap_8
XFILLER_170_803 VDD VSS sg13g2_decap_8
X_13295_ _13295_/Y _07672_/X _15053_/Q _13294_/Y VDD VSS sg13g2_a21oi_1
XFILLER_138_1007 VDD VSS sg13g2_decap_8
XFILLER_154_376 VDD VSS sg13g2_decap_8
XFILLER_155_899 VDD VSS sg13g2_decap_8
XFILLER_5_364 VDD VSS sg13g2_decap_8
XFILLER_138_1029 VDD VSS sg13g2_fill_1
X_15034_ _15034_/Q clkload52/A _15034_/D _15034_/RESET_B VDD VSS sg13g2_dfrbpq_1
X_12246_ _12246_/X _12246_/A _12246_/B VDD VSS sg13g2_and2_1
XFILLER_47_7 VDD VSS sg13g2_decap_8
XFILLER_29_1324 VDD VSS sg13g2_decap_8
XFILLER_155_1343 VDD VSS sg13g2_fill_2
XFILLER_64_1226 VDD VSS sg13g2_decap_8
XFILLER_155_1354 VDD VSS sg13g2_fill_1
XFILLER_69_817 VDD VSS sg13g2_decap_8
X_12177_ _12177_/Y _12257_/A1 _14486_/Q VDD VSS sg13g2_nand2b_1
XFILLER_111_925 VDD VSS sg13g2_decap_8
XFILLER_150_571 VDD VSS sg13g2_fill_1
XFILLER_151_1218 VDD VSS sg13g2_fill_2
X_11128_ _11128_/Y _11128_/A _11128_/B VDD VSS sg13g2_nand2_1
XFILLER_96_647 VDD VSS sg13g2_decap_8
XFILLER_7_1120 VDD VSS sg13g2_decap_8
XFILLER_1_581 VDD VSS sg13g2_decap_8
XFILLER_3_77 VDD VSS sg13g2_decap_8
X_13783__2396 _13783_/RESET_B VDD VSS sg13g2_tiehi
XFILLER_49_541 VDD VSS sg13g2_decap_8
X_11059_ _11118_/A _11202_/A _11078_/B VDD VSS sg13g2_xnor2_1
XFILLER_67_91 VDD VSS sg13g2_decap_8
XFILLER_97_1013 VDD VSS sg13g2_decap_4
XFILLER_7_1197 VDD VSS sg13g2_decap_8
XFILLER_49_596 VDD VSS sg13g2_fill_1
XFILLER_37_736 VDD VSS sg13g2_decap_8
X_14734__1445 _14734_/RESET_B VDD VSS sg13g2_tiehi
XFILLER_97_1024 VDD VSS sg13g2_decap_8
XFILLER_92_842 VDD VSS sg13g2_decap_8
XFILLER_76_393 VDD VSS sg13g2_fill_2
XFILLER_149_1114 VDD VSS sg13g2_decap_8
XFILLER_149_1147 VDD VSS sg13g2_decap_8
X_14818_ _14818_/Q _14886_/CLK _14818_/D _14818_/RESET_B VDD VSS sg13g2_dfrbpq_1
XFILLER_92_886 VDD VSS sg13g2_fill_2
XFILLER_92_897 VDD VSS sg13g2_fill_2
XFILLER_18_994 VDD VSS sg13g2_decap_8
XFILLER_33_931 VDD VSS sg13g2_fill_2
X_14749_ _14749_/Q clkload71/A _14749_/D _14749_/RESET_B VDD VSS sg13g2_dfrbpq_1
XFILLER_60_761 VDD VSS sg13g2_fill_2
X_08270_ _08270_/Y _08270_/A _08270_/B _08270_/C VDD VSS sg13g2_nand3_1
X_13675__2522 _13675_/RESET_B VDD VSS sg13g2_tiehi
XFILLER_32_485 VDD VSS sg13g2_fill_2
XFILLER_20_658 VDD VSS sg13g2_decap_8
XFILLER_158_671 VDD VSS sg13g2_decap_8
XFILLER_34_1063 VDD VSS sg13g2_decap_4
XFILLER_73_0 VDD VSS sg13g2_decap_8
XFILLER_146_855 VDD VSS sg13g2_fill_1
XFILLER_145_332 VDD VSS sg13g2_fill_1
XFILLER_146_866 VDD VSS sg13g2_decap_8
XFILLER_106_708 VDD VSS sg13g2_decap_4
XFILLER_133_505 VDD VSS sg13g2_fill_1
XFILLER_172_140 VDD VSS sg13g2_decap_8
XFILLER_105_207 VDD VSS sg13g2_decap_4
XFILLER_121_1099 VDD VSS sg13g2_fill_2
XFILLER_12_1372 VDD VSS sg13g2_decap_8
XFILLER_160_302 VDD VSS sg13g2_decap_8
XFILLER_114_763 VDD VSS sg13g2_fill_1
XFILLER_99_452 VDD VSS sg13g2_decap_4
XFILLER_113_240 VDD VSS sg13g2_decap_8
XFILLER_160_379 VDD VSS sg13g2_decap_8
XFILLER_82_1348 VDD VSS sg13g2_decap_8
XFILLER_59_305 VDD VSS sg13g2_decap_4
XFILLER_102_925 VDD VSS sg13g2_decap_8
Xfanout148 _09338_/A0 _10168_/A1 VDD VSS sg13g2_buf_1
XFILLER_59_338 VDD VSS sg13g2_decap_8
Xfanout159 _10099_/A0 _09967_/A1 VDD VSS sg13g2_buf_1
X_07985_ _13290_/B _07985_/A _07985_/B _07985_/C _07985_/D VDD VSS sg13g2_nand4_1
XFILLER_47_28 VDD VSS sg13g2_decap_8
X_09724_ _14315_/D _09889_/A0 _14315_/Q _09730_/S VDD VSS sg13g2_mux2_1
XFILLER_86_157 VDD VSS sg13g2_decap_8
XFILLER_132_1151 VDD VSS sg13g2_decap_8
XFILLER_55_511 VDD VSS sg13g2_decap_8
X_09655_ _14248_/D _10151_/A1 _14248_/Q _09664_/S VDD VSS sg13g2_mux2_1
XFILLER_27_224 VDD VSS sg13g2_decap_8
XFILLER_103_23 VDD VSS sg13g2_fill_2
X_08606_ _08606_/Y _08282_/Y _08625_/A _08605_/X VDD VSS sg13g2_o21ai_1
X_09586_ _14183_/D _14183_/Q _10083_/A0 _09596_/S VDD VSS sg13g2_mux2_1
XFILLER_43_739 VDD VSS sg13g2_decap_8
X_08537_ _08537_/X _08541_/B _07812_/B _07818_/B _07821_/B _13509_/A1 _13510_/A1 VDD
+ VSS sg13g2_mux4_1
XFILLER_151_7 VDD VSS sg13g2_decap_8
XFILLER_23_441 VDD VSS sg13g2_decap_8
XFILLER_168_413 VDD VSS sg13g2_decap_8
XFILLER_169_947 VDD VSS sg13g2_decap_8
X_08468_ _08469_/B _08452_/C _08301_/X _08034_/Y VDD VSS sg13g2_o21ai_1
XFILLER_11_658 VDD VSS sg13g2_decap_8
XFILLER_156_619 VDD VSS sg13g2_decap_8
XFILLER_52_1141 VDD VSS sg13g2_fill_1
X_14172__2007 _14172_/RESET_B VDD VSS sg13g2_tiehi
X_08399_ _08410_/C _08201_/A _08016_/Y _08676_/B2 VDD VSS sg13g2_o21ai_1
XFILLER_149_671 VDD VSS sg13g2_decap_8
XFILLER_109_524 VDD VSS sg13g2_decap_4
XFILLER_10_168 VDD VSS sg13g2_decap_8
X_10430_ _14832_/D _10434_/C _13141_/A _10430_/C VDD VSS sg13g2_nor3_1
XFILLER_52_1174 VDD VSS sg13g2_decap_8
XFILLER_12_42 VDD VSS sg13g2_decap_8
XFILLER_109_546 VDD VSS sg13g2_decap_8
XFILLER_164_641 VDD VSS sg13g2_fill_1
XFILLER_13_1169 VDD VSS sg13g2_decap_8
XFILLER_87_1226 VDD VSS sg13g2_fill_1
XFILLER_128_42 VDD VSS sg13g2_decap_8
XFILLER_163_140 VDD VSS sg13g2_decap_8
XFILLER_164_663 VDD VSS sg13g2_decap_8
X_10361_ _10361_/Y _14812_/Q _10359_/Y _10392_/B VDD VSS sg13g2_o21ai_1
X_12100_ _12101_/A _13748_/Q _14100_/Q _14452_/Q _14548_/Q _12100_/S0 _12091_/C VDD
+ VSS sg13g2_mux4_1
XFILLER_87_1259 VDD VSS sg13g2_decap_8
XFILLER_2_301 VDD VSS sg13g2_decap_8
XFILLER_174_1218 VDD VSS sg13g2_decap_8
XFILLER_152_858 VDD VSS sg13g2_fill_1
X_13080_ _13080_/Y _13067_/C _13076_/Y _13079_/Y VDD VSS sg13g2_a21oi_1
XFILLER_174_1229 VDD VSS sg13g2_fill_2
X_10292_ _14791_/D _10306_/B _10292_/B _10292_/C VDD VSS sg13g2_nor3_1
XFILLER_152_869 VDD VSS sg13g2_fill_2
XFILLER_88_57 VDD VSS sg13g2_decap_4
XFILLER_3_868 VDD VSS sg13g2_decap_8
X_12031_ _12031_/Y _12235_/A _14418_/Q _12026_/C VDD VSS sg13g2_a21oi_1
XFILLER_137_1040 VDD VSS sg13g2_decap_8
XFILLER_132_560 VDD VSS sg13g2_fill_1
XFILLER_2_378 VDD VSS sg13g2_decap_8
XFILLER_77_113 VDD VSS sg13g2_decap_4
XFILLER_144_63 VDD VSS sg13g2_fill_1
XFILLER_120_755 VDD VSS sg13g2_decap_8
XFILLER_66_809 VDD VSS sg13g2_fill_2
Xfanout671 _11056_/B1 _07702_/X VDD VSS sg13g2_buf_1
XFILLER_77_157 VDD VSS sg13g2_fill_1
XFILLER_24_1232 VDD VSS sg13g2_decap_8
X_14203__1976 _14203_/RESET_B VDD VSS sg13g2_tiehi
XFILLER_120_788 VDD VSS sg13g2_fill_1
Xfanout682 _11664_/A _11458_/A VDD VSS sg13g2_buf_1
XFILLER_19_714 VDD VSS sg13g2_decap_8
X_13982_ _13982_/Q _14686_/CLK _13982_/D _13982_/RESET_B VDD VSS sg13g2_dfrbpq_1
Xfanout693 _12217_/A _12335_/B1 VDD VSS sg13g2_buf_1
XFILLER_4_1337 VDD VSS sg13g2_decap_8
XFILLER_18_224 VDD VSS sg13g2_decap_8
X_12933_ _12933_/Y _12933_/A _15062_/Q VDD VSS sg13g2_nand2_1
XFILLER_58_393 VDD VSS sg13g2_decap_8
XFILLER_74_853 VDD VSS sg13g2_decap_8
XFILLER_59_1339 VDD VSS sg13g2_fill_1
XFILLER_2_1050 VDD VSS sg13g2_decap_8
XFILLER_160_84 VDD VSS sg13g2_decap_8
X_12864_ _12864_/Y _14771_/Q _13275_/A2 _13140_/B2 VDD VSS sg13g2_o21ai_1
XFILLER_33_205 VDD VSS sg13g2_decap_8
XFILLER_61_525 VDD VSS sg13g2_decap_8
XFILLER_15_931 VDD VSS sg13g2_decap_8
X_13768__2411 _13768_/RESET_B VDD VSS sg13g2_tiehi
XFILLER_73_396 VDD VSS sg13g2_fill_2
X_14603_ _14603_/Q clkload0/A _14603_/D _14603_/RESET_B VDD VSS sg13g2_dfrbpq_1
X_11815_ _11815_/X _11815_/A _11815_/B VDD VSS sg13g2_and2_1
X_12795_ _12795_/Y _12997_/B _12899_/C _12997_/A VDD VSS sg13g2_o21ai_1
XFILLER_14_441 VDD VSS sg13g2_decap_8
XFILLER_42_750 VDD VSS sg13g2_decap_8
XFILLER_148_1180 VDD VSS sg13g2_decap_8
XFILLER_159_413 VDD VSS sg13g2_decap_8
X_14534_ _14534_/Q clkload2/A _14534_/D _14534_/RESET_B VDD VSS sg13g2_dfrbpq_1
X_11746_ _11747_/B _11743_/Y _11745_/Y _11625_/C VDD VSS sg13g2_a21oi_1
XFILLER_18_1036 VDD VSS sg13g2_decap_8
XFILLER_57_1096 VDD VSS sg13g2_decap_8
XFILLER_159_457 VDD VSS sg13g2_decap_4
XFILLER_144_1066 VDD VSS sg13g2_fill_1
XFILLER_144_1077 VDD VSS sg13g2_decap_8
XFILLER_35_1350 VDD VSS sg13g2_decap_8
XFILLER_105_1039 VDD VSS sg13g2_fill_1
X_14465_ _14465_/Q clkload31/A _14465_/D _14465_/RESET_B VDD VSS sg13g2_dfrbpq_1
X_11677_ _11677_/Y _11673_/Y _11674_/Y _11676_/Y _11675_/Y _12036_/B VDD VSS sg13g2_a221oi_1
XFILLER_70_1241 VDD VSS sg13g2_decap_8
XFILLER_30_967 VDD VSS sg13g2_fill_1
X_14148__2031 _14148_/RESET_B VDD VSS sg13g2_tiehi
X_13416_ _13416_/Y _08723_/A _13493_/A2 _15093_/Q VDD VSS sg13g2_o21ai_1
X_10628_ _10629_/D _14884_/Q _14883_/Q _14882_/Q _10651_/D VDD VSS sg13g2_and4_1
XFILLER_70_1274 VDD VSS sg13g2_decap_8
XFILLER_31_1225 VDD VSS sg13g2_decap_8
XFILLER_167_490 VDD VSS sg13g2_decap_8
X_14396_ _14396_/Q _14854_/CLK _14396_/D _14396_/RESET_B VDD VSS sg13g2_dfrbpq_1
XFILLER_155_641 VDD VSS sg13g2_fill_1
XFILLER_70_1296 VDD VSS sg13g2_decap_8
X_13347_ _13351_/C _13347_/A _15174_/D _15175_/D VDD VSS sg13g2_nand3_1
XFILLER_6_651 VDD VSS sg13g2_decap_8
X_10559_ _10561_/C _10566_/D _14861_/Q _14860_/Q _14855_/Q VDD VSS sg13g2_nand4_1
XFILLER_115_527 VDD VSS sg13g2_decap_4
XFILLER_155_696 VDD VSS sg13g2_decap_8
XFILLER_5_161 VDD VSS sg13g2_decap_8
X_13278_ _15052_/D _13271_/Y _13277_/Y _13021_/A VDD VSS sg13g2_a21oi_1
XFILLER_29_1121 VDD VSS sg13g2_decap_8
XFILLER_68_1181 VDD VSS sg13g2_decap_8
XFILLER_142_368 VDD VSS sg13g2_decap_8
X_15017_ _15017_/Q clkload33/A _15017_/D _15017_/RESET_B VDD VSS sg13g2_dfrbpq_1
X_12229_ _12231_/A _12229_/A _13664_/Q VDD VSS sg13g2_xor2_1
XFILLER_9_1204 VDD VSS sg13g2_decap_8
XFILLER_97_912 VDD VSS sg13g2_decap_4
X_13870__2309 _13870_/RESET_B VDD VSS sg13g2_tiehi
XFILLER_111_733 VDD VSS sg13g2_fill_1
XFILLER_64_1067 VDD VSS sg13g2_fill_2
XFILLER_69_658 VDD VSS sg13g2_decap_8
XFILLER_68_135 VDD VSS sg13g2_decap_8
XFILLER_29_1198 VDD VSS sg13g2_decap_8
XFILLER_151_1037 VDD VSS sg13g2_fill_2
XFILLER_97_989 VDD VSS sg13g2_fill_2
XFILLER_99_1119 VDD VSS sg13g2_fill_2
X_07770_ _08315_/A _08258_/C _14998_/Q VDD VSS sg13g2_nor2_1
XFILLER_83_127 VDD VSS sg13g2_decap_8
XFILLER_42_1376 VDD VSS sg13g2_decap_8
X_09440_ _14042_/D _09970_/A1 _14042_/Q _09440_/S VDD VSS sg13g2_mux2_1
XFILLER_92_661 VDD VSS sg13g2_decap_8
XFILLER_64_385 VDD VSS sg13g2_decap_8
XFILLER_18_791 VDD VSS sg13g2_decap_8
X_14358__1821 _14358_/RESET_B VDD VSS sg13g2_tiehi
X_09371_ _13975_/D _10166_/A1 _13975_/Q _09373_/S VDD VSS sg13g2_mux2_1
XFILLER_52_547 VDD VSS sg13g2_fill_2
XFILLER_24_238 VDD VSS sg13g2_decap_8
XFILLER_80_889 VDD VSS sg13g2_decap_8
X_08322_ _08322_/Y _08369_/B _08366_/D _08321_/Y VDD VSS sg13g2_o21ai_1
XFILLER_33_761 VDD VSS sg13g2_decap_4
XFILLER_75_1196 VDD VSS sg13g2_fill_2
X_14988__2599 _14988_/RESET_B VDD VSS sg13g2_tiehi
XFILLER_21_945 VDD VSS sg13g2_decap_8
X_08253_ _08253_/X _11483_/A _11461_/A _11526_/A _11502_/A _08253_/S0 _08079_/S VDD
+ VSS sg13g2_mux4_1
XFILLER_159_980 VDD VSS sg13g2_fill_1
XFILLER_165_427 VDD VSS sg13g2_decap_8
XFILLER_20_455 VDD VSS sg13g2_decap_8
XFILLER_118_321 VDD VSS sg13g2_fill_1
X_08184_ _08184_/Y _13427_/C _07920_/Y _08183_/Y VDD VSS sg13g2_a21oi_1
XFILLER_10_1309 VDD VSS sg13g2_decap_8
XFILLER_119_877 VDD VSS sg13g2_fill_2
XFILLER_118_365 VDD VSS sg13g2_decap_8
XFILLER_145_162 VDD VSS sg13g2_decap_8
XFILLER_133_313 VDD VSS sg13g2_decap_8
XFILLER_161_622 VDD VSS sg13g2_decap_8
XFILLER_118_398 VDD VSS sg13g2_fill_2
XFILLER_133_324 VDD VSS sg13g2_fill_1
XFILLER_133_335 VDD VSS sg13g2_decap_8
X_15245__3013 _15245_/RESET_B VDD VSS sg13g2_tiehi
XFILLER_82_1101 VDD VSS sg13g2_fill_2
XFILLER_160_154 VDD VSS sg13g2_decap_8
XFILLER_47_1232 VDD VSS sg13g2_fill_1
XFILLER_102_711 VDD VSS sg13g2_decap_8
X_14460__1719 _14460_/RESET_B VDD VSS sg13g2_tiehi
X_13846__2333 _13846_/RESET_B VDD VSS sg13g2_tiehi
XFILLER_0_849 VDD VSS sg13g2_decap_8
XFILLER_43_1118 VDD VSS sg13g2_fill_2
XFILLER_173_1295 VDD VSS sg13g2_decap_8
XFILLER_134_1257 VDD VSS sg13g2_fill_1
X_07968_ _07969_/D _08641_/A _07966_/Y _07967_/Y VDD VSS sg13g2_a21oi_1
XFILLER_87_488 VDD VSS sg13g2_decap_8
X_09707_ _09739_/S _09740_/B _09707_/B _09707_/C VDD VSS sg13g2_or3_1
X_07899_ _08073_/B _07903_/B _08063_/A VDD VSS sg13g2_nor2_1
XFILLER_74_37 VDD VSS sg13g2_fill_1
XFILLER_28_555 VDD VSS sg13g2_decap_8
XFILLER_55_352 VDD VSS sg13g2_decap_4
XFILLER_16_728 VDD VSS sg13g2_decap_8
X_09638_ _14234_/D _09772_/A1 _14234_/Q _09638_/S VDD VSS sg13g2_mux2_1
XFILLER_130_21 VDD VSS sg13g2_decap_8
XFILLER_83_694 VDD VSS sg13g2_fill_2
XFILLER_15_238 VDD VSS sg13g2_decap_8
XFILLER_167_1066 VDD VSS sg13g2_decap_8
X_09569_ _14167_/D _10099_/A0 _14167_/Q _09571_/S VDD VSS sg13g2_mux2_1
XFILLER_58_1350 VDD VSS sg13g2_decap_4
XFILLER_128_1039 VDD VSS sg13g2_decap_8
XFILLER_90_14 VDD VSS sg13g2_decap_8
XFILLER_19_1323 VDD VSS sg13g2_decap_8
X_11600_ _11601_/A _13958_/Q _13990_/Q _14022_/Q _14054_/Q _11993_/S0 _11996_/S1 VDD
+ VSS sg13g2_mux4_1
XFILLER_93_1263 VDD VSS sg13g2_decap_8
XFILLER_70_366 VDD VSS sg13g2_decap_8
XFILLER_54_1214 VDD VSS sg13g2_decap_8
XFILLER_168_210 VDD VSS sg13g2_decap_8
XFILLER_58_1383 VDD VSS sg13g2_fill_1
X_12580_ _12580_/X _12572_/X _12576_/X _12571_/X _12575_/X _12663_/S0 _12663_/S1 VDD
+ VSS sg13g2_mux4_1
XFILLER_12_945 VDD VSS sg13g2_decap_8
XFILLER_169_766 VDD VSS sg13g2_decap_8
X_11531_ _11532_/B _11531_/A _14212_/Q VDD VSS sg13g2_nand2_1
XFILLER_54_1269 VDD VSS sg13g2_fill_2
XFILLER_169_799 VDD VSS sg13g2_decap_8
XFILLER_11_455 VDD VSS sg13g2_decap_8
XFILLER_128_107 VDD VSS sg13g2_fill_2
XFILLER_156_416 VDD VSS sg13g2_decap_8
XFILLER_168_287 VDD VSS sg13g2_decap_8
XFILLER_8_938 VDD VSS sg13g2_decap_8
XFILLER_23_63 VDD VSS sg13g2_decap_8
X_14250_ _14250_/Q clkload12/A _14250_/D _14250_/RESET_B VDD VSS sg13g2_dfrbpq_1
X_11462_ _11463_/C _11454_/A _13688_/Q _11430_/B _11430_/A _11427_/X VDD VSS sg13g2_a221oi_1
XFILLER_139_63 VDD VSS sg13g2_decap_8
XFILLER_165_950 VDD VSS sg13g2_decap_8
XFILLER_7_448 VDD VSS sg13g2_decap_8
X_13201_ _13202_/B _14919_/Q _13668_/Q _13189_/X VDD VSS sg13g2_a21oi_1
X_10413_ _10422_/D _14827_/Q _10413_/B _10414_/D VDD VSS sg13g2_and3_1
XFILLER_87_1012 VDD VSS sg13g2_fill_2
XFILLER_104_1083 VDD VSS sg13g2_decap_8
X_14181_ _14181_/Q _14725_/CLK _14181_/D _14181_/RESET_B VDD VSS sg13g2_dfrbpq_1
XFILLER_99_45 VDD VSS sg13g2_decap_8
X_11393_ _11393_/X _11388_/Y _11389_/Y _11745_/B VDD VSS sg13g2_a21o_1
XFILLER_137_685 VDD VSS sg13g2_decap_8
XFILLER_139_1102 VDD VSS sg13g2_decap_8
X_13132_ _13146_/B _13132_/A _13133_/C VDD VSS sg13g2_nand2_1
X_10344_ _10347_/C _14808_/Q _10343_/B VDD VSS sg13g2_nor2b_1
X_15099__2775 _15099_/RESET_B VDD VSS sg13g2_tiehi
XFILLER_125_869 VDD VSS sg13g2_decap_8
XFILLER_87_1078 VDD VSS sg13g2_decap_8
XFILLER_152_666 VDD VSS sg13g2_decap_8
XFILLER_174_1037 VDD VSS sg13g2_decap_8
XFILLER_3_0 VDD VSS sg13g2_decap_8
XFILLER_140_828 VDD VSS sg13g2_fill_2
X_13063_ _13078_/A _13066_/C _13063_/B VDD VSS sg13g2_nand2b_1
XFILLER_3_665 VDD VSS sg13g2_decap_8
XFILLER_152_688 VDD VSS sg13g2_fill_2
X_10275_ _14786_/D _14786_/Q _10305_/A _10274_/Y VDD VSS sg13g2_a21oi_1
XFILLER_133_880 VDD VSS sg13g2_decap_4
XFILLER_140_839 VDD VSS sg13g2_decap_8
XFILLER_152_1302 VDD VSS sg13g2_decap_4
XFILLER_155_84 VDD VSS sg13g2_decap_8
Xfanout1400 _12709_/A1 _12765_/A1 VDD VSS sg13g2_buf_1
X_12014_ _12014_/X _13842_/Q _13874_/Q _12014_/S VDD VSS sg13g2_mux2_1
XFILLER_2_175 VDD VSS sg13g2_decap_8
X_14436__1743 _14436_/RESET_B VDD VSS sg13g2_tiehi
Xfanout1411 _13600_/C _13398_/B VDD VSS sg13g2_buf_1
XFILLER_152_1335 VDD VSS sg13g2_fill_2
XFILLER_94_904 VDD VSS sg13g2_decap_8
XFILLER_61_1229 VDD VSS sg13g2_decap_8
X_14910__2724 _14910_/RESET_B VDD VSS sg13g2_tiehi
X_15219__2987 _15219_/RESET_B VDD VSS sg13g2_tiehi
Xfanout490 _08667_/A1 _08424_/A1 VDD VSS sg13g2_buf_1
XFILLER_8_1281 VDD VSS sg13g2_decap_8
XFILLER_19_511 VDD VSS sg13g2_decap_8
XFILLER_111_1010 VDD VSS sg13g2_decap_8
X_13692__2488 _13692_/RESET_B VDD VSS sg13g2_tiehi
XFILLER_4_1134 VDD VSS sg13g2_decap_8
XFILLER_150_1070 VDD VSS sg13g2_decap_8
X_13965_ _13965_/Q clkload4/A _13965_/D _13965_/RESET_B VDD VSS sg13g2_dfrbpq_1
XFILLER_58_190 VDD VSS sg13g2_decap_4
XFILLER_47_864 VDD VSS sg13g2_decap_8
XFILLER_62_801 VDD VSS sg13g2_decap_8
XFILLER_0_56 VDD VSS sg13g2_decap_8
X_12916_ _12916_/Y _14838_/Q _07728_/B _12895_/B _14870_/Q VDD VSS sg13g2_a22oi_1
XFILLER_19_588 VDD VSS sg13g2_decap_8
X_13896_ _13896_/Q _14728_/CLK _13896_/D _13896_/RESET_B VDD VSS sg13g2_dfrbpq_1
X_14943__2658 _14943_/RESET_B VDD VSS sg13g2_tiehi
X_12847_ _12847_/X _14897_/Q _13690_/Q VDD VSS sg13g2_and2_1
XFILLER_159_210 VDD VSS sg13g2_decap_8
XFILLER_9_21 VDD VSS sg13g2_decap_8
X_12778_ _15019_/D _12778_/A _12778_/B VDD VSS sg13g2_nor2_1
XFILLER_148_906 VDD VSS sg13g2_fill_1
XFILLER_72_1347 VDD VSS sg13g2_decap_8
XFILLER_148_917 VDD VSS sg13g2_decap_8
XFILLER_42_591 VDD VSS sg13g2_decap_8
XFILLER_33_1309 VDD VSS sg13g2_decap_8
XFILLER_148_928 VDD VSS sg13g2_fill_2
X_14517_ _14517_/Q clkload18/A _14517_/D _14517_/RESET_B VDD VSS sg13g2_dfrbpq_1
X_11729_ _11729_/Y _15209_/Q _15208_/Q _11728_/Y VDD VSS sg13g2_o21ai_1
XFILLER_119_118 VDD VSS sg13g2_fill_1
XFILLER_159_287 VDD VSS sg13g2_decap_8
X_13924__2255 _13924_/RESET_B VDD VSS sg13g2_tiehi
X_14684__1495 _14684_/RESET_B VDD VSS sg13g2_tiehi
XFILLER_9_98 VDD VSS sg13g2_decap_8
XFILLER_70_1060 VDD VSS sg13g2_decap_4
X_14448_ _14448_/Q _14672_/CLK _14448_/D _14448_/RESET_B VDD VSS sg13g2_dfrbpq_1
XFILLER_80_91 VDD VSS sg13g2_decap_8
XFILLER_127_140 VDD VSS sg13g2_fill_1
XFILLER_122_1183 VDD VSS sg13g2_decap_8
X_14379_ _14379_/Q clkload4/A _14379_/D _14379_/RESET_B VDD VSS sg13g2_dfrbpq_1
XFILLER_128_696 VDD VSS sg13g2_fill_1
XFILLER_155_471 VDD VSS sg13g2_decap_8
XFILLER_157_1202 VDD VSS sg13g2_decap_8
XFILLER_31_1099 VDD VSS sg13g2_decap_8
XFILLER_115_335 VDD VSS sg13g2_decap_8
X_15121__2717 _15121_/RESET_B VDD VSS sg13g2_tiehi
XFILLER_116_869 VDD VSS sg13g2_decap_8
XFILLER_170_441 VDD VSS sg13g2_decap_8
XFILLER_171_975 VDD VSS sg13g2_decap_8
XFILLER_143_677 VDD VSS sg13g2_decap_8
XFILLER_157_1279 VDD VSS sg13g2_decap_8
Xhold3018 _10213_/B input37/X VDD VSS sg13g2_dlygate4sd3_1
X_08940_ _08940_/X _08939_/X _12203_/A _08940_/S VDD VSS sg13g2_mux2_1
XFILLER_9_1001 VDD VSS sg13g2_decap_8
Xhold3029 hold3029/X input29/X VDD VSS sg13g2_dlygate4sd3_1
XFILLER_69_400 VDD VSS sg13g2_fill_2
XFILLER_36_0 VDD VSS sg13g2_decap_8
X_08871_ _08871_/X _08870_/X _11570_/A _08891_/S VDD VSS sg13g2_mux2_1
XFILLER_111_541 VDD VSS sg13g2_fill_1
X_07822_ _08527_/B _07822_/A _07822_/B VDD VSS sg13g2_nor2_1
XFILLER_9_1078 VDD VSS sg13g2_decap_8
XFILLER_111_574 VDD VSS sg13g2_decap_8
XFILLER_29_319 VDD VSS sg13g2_decap_8
X_07753_ _15206_/D _10797_/C _07753_/B _07754_/B _10869_/A VDD VSS sg13g2_and4_1
XFILLER_37_341 VDD VSS sg13g2_decap_8
XFILLER_37_352 VDD VSS sg13g2_fill_2
XFILLER_53_812 VDD VSS sg13g2_decap_8
X_07684_ _07684_/Y _11241_/A _07684_/B _08831_/B VDD VSS sg13g2_nand3_1
XFILLER_65_683 VDD VSS sg13g2_decap_8
XFILLER_38_897 VDD VSS sg13g2_decap_8
XFILLER_65_694 VDD VSS sg13g2_fill_2
XFILLER_37_385 VDD VSS sg13g2_decap_8
XFILLER_64_171 VDD VSS sg13g2_decap_8
X_09423_ _14025_/D _09953_/A1 _14025_/Q _09439_/S VDD VSS sg13g2_mux2_1
XFILLER_53_856 VDD VSS sg13g2_decap_8
XFILLER_80_653 VDD VSS sg13g2_decap_8
XFILLER_164_1228 VDD VSS sg13g2_decap_8
X_09354_ _13958_/D _09950_/A1 _13958_/Q _09365_/S VDD VSS sg13g2_mux2_1
XFILLER_100_35 VDD VSS sg13g2_decap_8
XFILLER_127_1050 VDD VSS sg13g2_decap_8
XFILLER_139_906 VDD VSS sg13g2_fill_2
X_08305_ _08305_/Y _07994_/X _08304_/Y _08674_/B1 VDD VSS sg13g2_a21oi_1
XFILLER_33_591 VDD VSS sg13g2_decap_8
XFILLER_21_742 VDD VSS sg13g2_decap_8
X_09285_ _13893_/D _13893_/Q _09318_/A0 _09297_/S VDD VSS sg13g2_mux2_1
XFILLER_60_28 VDD VSS sg13g2_decap_8
XFILLER_20_252 VDD VSS sg13g2_decap_8
XFILLER_165_224 VDD VSS sg13g2_decap_8
X_14514__1665 _14514_/RESET_B VDD VSS sg13g2_tiehi
X_08236_ _08236_/X _08151_/X _08235_/X _08254_/S VDD VSS sg13g2_mux2_1
XFILLER_166_758 VDD VSS sg13g2_fill_2
XFILLER_14_1253 VDD VSS sg13g2_decap_8
XFILLER_101_1212 VDD VSS sg13g2_decap_8
XFILLER_153_408 VDD VSS sg13g2_fill_1
XFILLER_10_1106 VDD VSS sg13g2_decap_8
XFILLER_119_674 VDD VSS sg13g2_fill_1
X_08167_ _08167_/X _08177_/S _08167_/B VDD VSS sg13g2_or2_1
XFILLER_114_7 VDD VSS sg13g2_decap_8
XFILLER_174_780 VDD VSS sg13g2_fill_1
XFILLER_146_482 VDD VSS sg13g2_fill_2
XFILLER_162_931 VDD VSS sg13g2_decap_8
X_14768__2945 _14768_/RESET_B VDD VSS sg13g2_tiehi
XFILLER_118_184 VDD VSS sg13g2_decap_8
XFILLER_133_110 VDD VSS sg13g2_decap_8
XFILLER_134_633 VDD VSS sg13g2_decap_8
XFILLER_162_942 VDD VSS sg13g2_decap_8
XFILLER_49_1316 VDD VSS sg13g2_decap_8
XFILLER_107_858 VDD VSS sg13g2_decap_8
X_08098_ _08098_/Y _08103_/A _08098_/B VDD VSS sg13g2_nand2_1
XFILLER_109_88 VDD VSS sg13g2_fill_1
XFILLER_69_37 VDD VSS sg13g2_fill_1
XFILLER_0_602 VDD VSS sg13g2_decap_8
XFILLER_122_839 VDD VSS sg13g2_fill_2
XFILLER_79_219 VDD VSS sg13g2_decap_8
XFILLER_125_21 VDD VSS sg13g2_decap_8
X_10060_ _14641_/D _10127_/A0 _14641_/Q _10060_/S VDD VSS sg13g2_mux2_1
XFILLER_134_1021 VDD VSS sg13g2_fill_1
X_15069__2867 _15069_/RESET_B VDD VSS sg13g2_tiehi
XFILLER_102_552 VDD VSS sg13g2_decap_4
XFILLER_47_1095 VDD VSS sg13g2_decap_4
XFILLER_0_679 VDD VSS sg13g2_decap_8
XFILLER_85_14 VDD VSS sg13g2_decap_4
XFILLER_87_274 VDD VSS sg13g2_decap_8
XFILLER_125_98 VDD VSS sg13g2_decap_8
XFILLER_130_894 VDD VSS sg13g2_decap_8
XFILLER_48_639 VDD VSS sg13g2_fill_1
XFILLER_76_959 VDD VSS sg13g2_decap_4
XFILLER_60_1240 VDD VSS sg13g2_fill_1
XFILLER_169_1106 VDD VSS sg13g2_decap_8
XFILLER_60_1284 VDD VSS sg13g2_decap_8
XFILLER_95_1303 VDD VSS sg13g2_fill_2
XFILLER_44_801 VDD VSS sg13g2_decap_8
XFILLER_21_1246 VDD VSS sg13g2_decap_8
XFILLER_18_63 VDD VSS sg13g2_decap_8
XFILLER_44_812 VDD VSS sg13g2_fill_1
X_13750_ _13750_/Q clkload26/A _13750_/D _13750_/RESET_B VDD VSS sg13g2_dfrbpq_1
X_10962_ _11004_/B _14759_/Q _11015_/C VDD VSS sg13g2_xor2_1
XFILLER_16_525 VDD VSS sg13g2_decap_8
XFILLER_55_160 VDD VSS sg13g2_decap_4
XFILLER_71_620 VDD VSS sg13g2_decap_8
XFILLER_71_631 VDD VSS sg13g2_fill_1
X_12701_ _12701_/X _13844_/Q _13876_/Q _13908_/Q _13940_/Q _12785_/S0 _12785_/S1 VDD
+ VSS sg13g2_mux4_1
XFILLER_43_333 VDD VSS sg13g2_decap_8
X_13681_ _13681_/Q clkload56/A _13681_/D _13681_/RESET_B VDD VSS sg13g2_dfrbpq_1
X_10893_ _10893_/X _10893_/A _10893_/B VDD VSS sg13g2_and2_1
XFILLER_19_1120 VDD VSS sg13g2_decap_8
X_12632_ _12632_/X _13839_/Q _13871_/Q _13903_/Q _13935_/Q _12645_/S0 _12645_/S1 VDD
+ VSS sg13g2_mux4_1
XFILLER_58_1191 VDD VSS sg13g2_fill_2
XFILLER_54_1033 VDD VSS sg13g2_decap_8
XFILLER_140_0 VDD VSS sg13g2_decap_8
XFILLER_70_196 VDD VSS sg13g2_decap_8
XFILLER_12_742 VDD VSS sg13g2_decap_8
XFILLER_34_84 VDD VSS sg13g2_decap_8
XFILLER_106_1123 VDD VSS sg13g2_decap_8
XFILLER_169_574 VDD VSS sg13g2_decap_8
X_12563_ _12563_/X _14122_/Q _14154_/Q _14186_/Q _14218_/Q _12614_/S0 _12614_/S1 VDD
+ VSS sg13g2_mux4_1
XFILLER_106_1134 VDD VSS sg13g2_fill_2
XFILLER_141_1014 VDD VSS sg13g2_decap_8
XFILLER_141_1025 VDD VSS sg13g2_fill_1
XFILLER_19_1197 VDD VSS sg13g2_decap_8
XFILLER_11_252 VDD VSS sg13g2_decap_8
XFILLER_156_213 VDD VSS sg13g2_decap_8
XFILLER_157_747 VDD VSS sg13g2_decap_8
X_14302_ _14302_/Q clkload38/A _14302_/D _14302_/RESET_B VDD VSS sg13g2_dfrbpq_1
X_11514_ _11514_/X _13955_/Q _13987_/Q _14019_/Q _14051_/Q _12140_/S0 _12140_/S1 VDD
+ VSS sg13g2_mux4_1
XFILLER_8_735 VDD VSS sg13g2_decap_8
XFILLER_89_1107 VDD VSS sg13g2_decap_8
X_12494_ _12494_/X _13957_/Q _13989_/Q _14021_/Q _14053_/Q _12655_/S0 _12655_/S1 VDD
+ VSS sg13g2_mux4_1
XFILLER_7_245 VDD VSS sg13g2_decap_8
XFILLER_172_706 VDD VSS sg13g2_fill_1
X_14233_ _14233_/Q _14681_/CLK _14233_/D _14233_/RESET_B VDD VSS sg13g2_dfrbpq_1
X_11445_ _11448_/C _11445_/A _11446_/A _11445_/C VDD VSS sg13g2_nand3_1
XFILLER_165_791 VDD VSS sg13g2_decap_8
X_14164_ _14164_/Q _14516_/CLK _14164_/D _14164_/RESET_B VDD VSS sg13g2_dfrbpq_1
X_11376_ _11376_/X _13950_/Q _13982_/Q _14014_/Q _14046_/Q _11821_/S0 _11374_/C VDD
+ VSS sg13g2_mux4_1
XFILLER_4_952 VDD VSS sg13g2_decap_8
XFILLER_124_143 VDD VSS sg13g2_decap_4
XFILLER_140_603 VDD VSS sg13g2_decap_8
X_13115_ _13116_/C _14913_/Q _13674_/Q _13088_/X VDD VSS sg13g2_o21ai_1
X_14669__1510 _14669_/RESET_B VDD VSS sg13g2_tiehi
X_10327_ _10336_/D _10342_/A _10327_/B _10327_/C _10345_/C VDD VSS sg13g2_and4_1
XFILLER_124_165 VDD VSS sg13g2_decap_8
X_14095_ _14095_/Q _14607_/CLK _14095_/D _14095_/RESET_B VDD VSS sg13g2_dfrbpq_1
XFILLER_3_462 VDD VSS sg13g2_decap_8
XFILLER_65_1140 VDD VSS sg13g2_decap_4
X_13046_ _13046_/Y _13050_/C _15061_/Q VDD VSS sg13g2_nor2b_1
X_10258_ _10262_/B _14779_/Q _14780_/Q _14781_/Q _10258_/D VDD VSS sg13g2_nand4_1
X_14098__2081 _14098_/RESET_B VDD VSS sg13g2_tiehi
Xfanout1230 _12334_/C _12221_/B1 VDD VSS sg13g2_buf_1
XFILLER_78_252 VDD VSS sg13g2_fill_1
XFILLER_6_1218 VDD VSS sg13g2_decap_8
XFILLER_65_1195 VDD VSS sg13g2_fill_1
XFILLER_152_1154 VDD VSS sg13g2_decap_8
Xfanout1241 _12237_/C _12308_/C VDD VSS sg13g2_buf_1
X_14813__2900 _14813_/RESET_B VDD VSS sg13g2_tiehi
XFILLER_26_1168 VDD VSS sg13g2_decap_8
Xfanout1252 _07654_/A _11760_/C VDD VSS sg13g2_buf_1
X_10189_ _15195_/D hold3077/X _15195_/Q _13479_/S VDD VSS sg13g2_mux2_1
XFILLER_93_200 VDD VSS sg13g2_decap_8
XFILLER_120_371 VDD VSS sg13g2_decap_4
Xfanout1263 _11805_/C _11899_/S1 VDD VSS sg13g2_buf_1
Xfanout1274 _12319_/B1 _12215_/S1 VDD VSS sg13g2_buf_1
Xfanout1285 _12286_/S1 _12288_/S1 VDD VSS sg13g2_buf_1
Xfanout1296 _11996_/S0 _11852_/S0 VDD VSS sg13g2_buf_1
X_14997_ _14997_/Q clkload32/A _14997_/D _14997_/RESET_B VDD VSS sg13g2_dfrbpq_1
XFILLER_93_255 VDD VSS sg13g2_decap_8
XFILLER_81_406 VDD VSS sg13g2_decap_8
XFILLER_75_970 VDD VSS sg13g2_fill_2
XFILLER_81_417 VDD VSS sg13g2_decap_8
X_13948_ _13948_/Q clkload40/A _13948_/D _13948_/RESET_B VDD VSS sg13g2_dfrbpq_1
X_15037__2550 _15037_/RESET_B VDD VSS sg13g2_tiehi
X_15150__2657 _15150_/RESET_B VDD VSS sg13g2_tiehi
XFILLER_75_992 VDD VSS sg13g2_decap_8
XFILLER_34_300 VDD VSS sg13g2_fill_1
XFILLER_19_385 VDD VSS sg13g2_decap_8
XFILLER_35_856 VDD VSS sg13g2_decap_4
XFILLER_61_130 VDD VSS sg13g2_decap_8
X_13879_ _13879_/Q clkload34/A _13879_/D _13879_/RESET_B VDD VSS sg13g2_dfrbpq_1
XFILLER_62_664 VDD VSS sg13g2_decap_8
X_15244__3012 _15244_/RESET_B VDD VSS sg13g2_tiehi
XFILLER_34_366 VDD VSS sg13g2_fill_2
XFILLER_37_1220 VDD VSS sg13g2_fill_1
XFILLER_76_1280 VDD VSS sg13g2_decap_8
XFILLER_22_539 VDD VSS sg13g2_decap_8
XFILLER_163_1272 VDD VSS sg13g2_fill_1
XFILLER_163_1283 VDD VSS sg13g2_decap_4
XFILLER_148_758 VDD VSS sg13g2_fill_2
X_09070_ _09070_/Y _09111_/A1 _09066_/Y _09069_/X VDD VSS sg13g2_o21ai_1
X_14887__2770 _14887_/RESET_B VDD VSS sg13g2_tiehi
XFILLER_124_1289 VDD VSS sg13g2_decap_4
X_08021_ _08021_/Y _08021_/A _08103_/A VDD VSS sg13g2_nand2_1
XFILLER_116_611 VDD VSS sg13g2_decap_8
XFILLER_144_920 VDD VSS sg13g2_fill_2
XFILLER_162_238 VDD VSS sg13g2_decap_8
X_15062__1431 _15062_/RESET_B VDD VSS sg13g2_tiehi
XFILLER_116_666 VDD VSS sg13g2_decap_4
X_09972_ _14555_/D _10104_/A0 _14555_/Q _09997_/S VDD VSS sg13g2_mux2_1
XFILLER_131_636 VDD VSS sg13g2_fill_1
XFILLER_83_1251 VDD VSS sg13g2_fill_1
XFILLER_135_1330 VDD VSS sg13g2_decap_8
XFILLER_170_1210 VDD VSS sg13g2_fill_1
X_08923_ _13713_/D _16875_/A _08922_/X _08932_/S VDD VSS sg13g2_mux2_1
XFILLER_48_1382 VDD VSS sg13g2_fill_2
XFILLER_135_1341 VDD VSS sg13g2_fill_2
X_08854_ _08854_/X _08853_/X _07910_/B _08860_/S VDD VSS sg13g2_mux2_1
XFILLER_29_105 VDD VSS sg13g2_fill_2
X_07805_ _08476_/A _07949_/C _07805_/B VDD VSS sg13g2_nand2b_1
X_08785_ _08785_/Y _07720_/C _14758_/Q _10201_/A1 _07719_/X VDD VSS sg13g2_a22oi_1
XFILLER_85_778 VDD VSS sg13g2_decap_8
XFILLER_55_28 VDD VSS sg13g2_decap_8
XFILLER_26_801 VDD VSS sg13g2_decap_8
X_07736_ _13284_/B _07744_/B _15124_/Q VDD VSS sg13g2_nand2_1
XFILLER_77_1011 VDD VSS sg13g2_fill_1
XFILLER_25_300 VDD VSS sg13g2_decap_4
XFILLER_72_439 VDD VSS sg13g2_decap_4
XFILLER_38_694 VDD VSS sg13g2_decap_8
XFILLER_26_834 VDD VSS sg13g2_decap_8
XFILLER_168_1150 VDD VSS sg13g2_decap_4
XFILLER_77_1044 VDD VSS sg13g2_fill_2
X_07667_ _07667_/Y _13293_/A _15055_/Q _13283_/A VDD VSS sg13g2_nor3_1
XFILLER_81_962 VDD VSS sg13g2_decap_8
X_13796__2383 _13796_/RESET_B VDD VSS sg13g2_tiehi
XFILLER_77_1088 VDD VSS sg13g2_decap_8
X_09406_ _14009_/D _10101_/A0 _14009_/Q _09406_/S VDD VSS sg13g2_mux2_1
XFILLER_40_303 VDD VSS sg13g2_decap_8
XFILLER_13_539 VDD VSS sg13g2_decap_8
XFILLER_55_1331 VDD VSS sg13g2_fill_1
XFILLER_41_859 VDD VSS sg13g2_decap_4
XFILLER_139_703 VDD VSS sg13g2_fill_2
X_14747__1432 _14747_/RESET_B VDD VSS sg13g2_tiehi
X_09337_ _13944_/D _10100_/A0 _13944_/Q _09338_/S VDD VSS sg13g2_mux2_1
XFILLER_40_358 VDD VSS sg13g2_decap_8
XFILLER_166_511 VDD VSS sg13g2_decap_8
XFILLER_55_1375 VDD VSS sg13g2_decap_4
XFILLER_16_1337 VDD VSS sg13g2_decap_8
X_09268_ _13877_/D _13877_/Q _10164_/A1 _09272_/S VDD VSS sg13g2_mux2_1
X_14030__2149 _14030_/RESET_B VDD VSS sg13g2_tiehi
X_15218__2986 _15218_/RESET_B VDD VSS sg13g2_tiehi
XFILLER_14_1050 VDD VSS sg13g2_decap_8
X_08219_ _08247_/B _08219_/A _13545_/A VDD VSS sg13g2_and2_1
XFILLER_166_588 VDD VSS sg13g2_decap_8
X_09199_ _13815_/D _13815_/Q _10166_/A1 wire378/X VDD VSS sg13g2_mux2_1
XFILLER_101_1031 VDD VSS sg13g2_decap_8
XFILLER_147_780 VDD VSS sg13g2_fill_2
X_11230_ _11230_/X _11228_/X _11229_/X _12092_/C VDD VSS sg13g2_mux2_1
XFILLER_5_749 VDD VSS sg13g2_decap_8
XFILLER_20_42 VDD VSS sg13g2_decap_8
XFILLER_88_1184 VDD VSS sg13g2_decap_8
XFILLER_4_259 VDD VSS sg13g2_decap_8
XFILLER_84_1026 VDD VSS sg13g2_decap_8
XFILLER_49_1146 VDD VSS sg13g2_decap_8
XFILLER_136_42 VDD VSS sg13g2_decap_8
X_11161_ _11161_/X _11161_/A _11191_/A VDD VSS sg13g2_and2_1
X_10112_ _14690_/D _10145_/A1 _14690_/Q _10134_/S VDD VSS sg13g2_mux2_1
XFILLER_171_1029 VDD VSS sg13g2_decap_4
XFILLER_121_135 VDD VSS sg13g2_decap_4
X_11092_ _11095_/A _11092_/A _11118_/C VDD VSS sg13g2_nor2b_1
XFILLER_1_966 VDD VSS sg13g2_decap_8
XFILLER_150_989 VDD VSS sg13g2_fill_1
X_14920_ _14920_/Q clkload54/A _14920_/D _14920_/RESET_B VDD VSS sg13g2_dfrbpq_1
X_10043_ _14624_/D _10043_/A0 _14624_/Q _10064_/S VDD VSS sg13g2_mux2_1
XFILLER_0_476 VDD VSS sg13g2_decap_8
XFILLER_88_583 VDD VSS sg13g2_fill_1
XFILLER_103_894 VDD VSS sg13g2_decap_8
XFILLER_49_959 VDD VSS sg13g2_decap_8
XFILLER_29_84 VDD VSS sg13g2_decap_8
XFILLER_152_63 VDD VSS sg13g2_decap_8
X_14851_ _14851_/Q clkload48/A _14851_/D _14851_/RESET_B VDD VSS sg13g2_dfrbpq_1
XFILLER_64_907 VDD VSS sg13g2_decap_8
XFILLER_48_469 VDD VSS sg13g2_decap_8
XFILLER_91_715 VDD VSS sg13g2_decap_4
XFILLER_25_1190 VDD VSS sg13g2_decap_8
X_13802_ _13802_/Q _14730_/CLK _13802_/D _13802_/RESET_B VDD VSS sg13g2_dfrbpq_1
XFILLER_75_277 VDD VSS sg13g2_fill_1
XFILLER_60_1092 VDD VSS sg13g2_decap_8
XFILLER_21_1043 VDD VSS sg13g2_decap_8
XFILLER_17_812 VDD VSS sg13g2_decap_8
XFILLER_57_992 VDD VSS sg13g2_decap_8
X_14782_ _14782_/Q _14894_/CLK _14782_/D _14782_/RESET_B VDD VSS sg13g2_dfrbpq_1
XFILLER_91_748 VDD VSS sg13g2_fill_2
XFILLER_5_1295 VDD VSS sg13g2_decap_8
X_11994_ _11994_/X _14705_/Q _14737_/Q _13777_/Q _13809_/Q _11996_/S0 _11996_/S1 VDD
+ VSS sg13g2_mux4_1
XFILLER_91_759 VDD VSS sg13g2_decap_4
XFILLER_16_322 VDD VSS sg13g2_decap_8
XFILLER_56_491 VDD VSS sg13g2_fill_2
XFILLER_44_631 VDD VSS sg13g2_decap_8
XFILLER_1_1148 VDD VSS sg13g2_decap_8
X_13733_ _13733_/Q clkload5/A _13733_/D _13733_/RESET_B VDD VSS sg13g2_dfrbpq_1
X_10945_ _10945_/Y _10945_/A _10945_/B VDD VSS sg13g2_nor2_1
XFILLER_17_889 VDD VSS sg13g2_decap_8
XFILLER_147_1245 VDD VSS sg13g2_fill_2
X_14240__1939 _14240_/RESET_B VDD VSS sg13g2_tiehi
X_14386__1793 _14386_/RESET_B VDD VSS sg13g2_tiehi
XFILLER_32_837 VDD VSS sg13g2_decap_8
XFILLER_16_399 VDD VSS sg13g2_decap_8
X_13664_ _13664_/Q clkload64/A _13664_/D _13664_/RESET_B VDD VSS sg13g2_dfrbpq_1
XFILLER_43_174 VDD VSS sg13g2_decap_8
XFILLER_143_1109 VDD VSS sg13g2_decap_4
X_10876_ _10923_/D _10876_/A _10897_/B _10897_/A _10876_/D VDD VSS sg13g2_or4_1
X_12615_ _12615_/X _14382_/Q _14414_/Q _14478_/Q _14510_/Q _12617_/S0 _12617_/S1 VDD
+ VSS sg13g2_mux4_1
XFILLER_169_371 VDD VSS sg13g2_decap_8
X_13595_ _13595_/Y _13600_/A _13508_/C _15164_/Q VDD VSS sg13g2_a21oi_1
X_12546_ _12546_/X _14249_/Q _14281_/Q _14313_/Q _14345_/Q _12546_/S0 _12546_/S1 VDD
+ VSS sg13g2_mux4_1
XFILLER_8_532 VDD VSS sg13g2_decap_8
XFILLER_77_7 VDD VSS sg13g2_decap_8
XFILLER_129_257 VDD VSS sg13g2_decap_8
X_14006__2173 _14006_/RESET_B VDD VSS sg13g2_tiehi
X_12477_ _12477_/X _14564_/Q _14596_/Q _14628_/Q _14660_/Q _12727_/S0 _12727_/S1 VDD
+ VSS sg13g2_mux4_1
XFILLER_32_1172 VDD VSS sg13g2_decap_8
XANTENNA_4 _09037_/X VDD VSS sg13g2_antennanp
XFILLER_144_238 VDD VSS sg13g2_decap_8
XFILLER_172_547 VDD VSS sg13g2_decap_8
X_14216_ _14216_/Q _14310_/CLK _14216_/D _14216_/RESET_B VDD VSS sg13g2_dfrbpq_1
X_11428_ _11430_/A _11428_/A _13689_/Q VDD VSS sg13g2_xor2_1
X_15196_ _15196_/Q clkload66/A _15196_/D _15196_/RESET_B VDD VSS sg13g2_dfrbpq_1
XFILLER_6_77 VDD VSS sg13g2_decap_8
X_14147_ _14147_/Q _14659_/CLK _14147_/D _14147_/RESET_B VDD VSS sg13g2_dfrbpq_1
X_11359_ _11359_/Y _11359_/A _11875_/B VDD VSS sg13g2_nand2_1
XFILLER_98_325 VDD VSS sg13g2_decap_8
XFILLER_113_636 VDD VSS sg13g2_decap_8
XFILLER_154_1227 VDD VSS sg13g2_decap_8
XFILLER_140_433 VDD VSS sg13g2_decap_4
XFILLER_112_146 VDD VSS sg13g2_decap_8
X_14078_ _14078_/Q clkload36/A _14078_/D _14078_/RESET_B VDD VSS sg13g2_dfrbpq_1
XFILLER_98_369 VDD VSS sg13g2_decap_8
XFILLER_117_1060 VDD VSS sg13g2_decap_8
X_13029_ _13029_/Y _14813_/Q _13051_/B _07727_/B _14845_/Q _13207_/C1 VDD VSS sg13g2_a221oi_1
XFILLER_6_1015 VDD VSS sg13g2_decap_8
XFILLER_140_499 VDD VSS sg13g2_decap_8
XFILLER_79_594 VDD VSS sg13g2_decap_4
Xfanout1060 _08635_/S1 _08686_/S1 VDD VSS sg13g2_buf_1
Xfanout1071 _13521_/A _14990_/Q VDD VSS sg13g2_buf_1
XFILLER_66_233 VDD VSS sg13g2_decap_4
Xfanout1082 _13517_/A _08137_/S0 VDD VSS sg13g2_buf_1
Xfanout1093 _08686_/A3 _12203_/A VDD VSS sg13g2_buf_1
XFILLER_66_255 VDD VSS sg13g2_decap_8
XFILLER_43_1290 VDD VSS sg13g2_decap_8
X_08570_ _08570_/Y _08494_/Y _08574_/D _08569_/Y VDD VSS sg13g2_a21oi_1
XFILLER_54_428 VDD VSS sg13g2_decap_8
XFILLER_26_119 VDD VSS sg13g2_decap_8
XFILLER_19_182 VDD VSS sg13g2_decap_8
XFILLER_63_951 VDD VSS sg13g2_fill_2
XFILLER_78_1364 VDD VSS sg13g2_decap_8
XFILLER_39_1337 VDD VSS sg13g2_decap_8
XFILLER_165_1356 VDD VSS sg13g2_fill_2
XFILLER_165_1367 VDD VSS sg13g2_decap_8
X_14216__1963 _14216_/RESET_B VDD VSS sg13g2_tiehi
XFILLER_165_1378 VDD VSS sg13g2_fill_2
XFILLER_22_336 VDD VSS sg13g2_decap_8
XFILLER_167_308 VDD VSS sg13g2_decap_8
Xclkbuf_leaf_111_clk_i clkload15/A clkbuf_5_7__f_clk_i/X VDD VSS sg13g2_buf_8
XFILLER_50_656 VDD VSS sg13g2_fill_1
X_09122_ _09125_/B _14919_/Q _09117_/C VDD VSS sg13g2_nor2b_1
XFILLER_37_1094 VDD VSS sg13g2_decap_8
XFILLER_148_544 VDD VSS sg13g2_decap_8
X_09053_ _09053_/Y _15233_/Q _09100_/B VDD VSS sg13g2_nand2b_1
XFILLER_135_216 VDD VSS sg13g2_decap_8
XFILLER_163_525 VDD VSS sg13g2_decap_8
XFILLER_135_227 VDD VSS sg13g2_fill_2
Xclkbuf_leaf_126_clk_i clkload4/A clkbuf_leaf_3_clk_i/A VDD VSS sg13g2_buf_8
X_08004_ _08004_/Y wire660/X _08174_/A VDD VSS sg13g2_nor2b_1
XFILLER_85_1302 VDD VSS sg13g2_decap_8
XFILLER_11_1267 VDD VSS sg13g2_decap_8
XFILLER_104_614 VDD VSS sg13g2_decap_4
XFILLER_116_474 VDD VSS sg13g2_decap_8
XFILLER_144_783 VDD VSS sg13g2_decap_4
XFILLER_132_934 VDD VSS sg13g2_decap_4
XFILLER_104_647 VDD VSS sg13g2_fill_1
X_09955_ _14539_/D _14539_/Q _10121_/A0 _09961_/S VDD VSS sg13g2_mux2_1
XFILLER_103_168 VDD VSS sg13g2_fill_2
X_13704__2475 _13704_/RESET_B VDD VSS sg13g2_tiehi
XFILLER_58_712 VDD VSS sg13g2_fill_1
XFILLER_106_56 VDD VSS sg13g2_decap_8
X_08906_ _08906_/Y _10776_/C _10781_/B _15040_/Q VDD VSS sg13g2_nand3_1
XFILLER_44_1043 VDD VSS sg13g2_fill_1
XFILLER_131_1002 VDD VSS sg13g2_fill_1
XFILLER_44_1054 VDD VSS sg13g2_fill_1
XFILLER_135_1171 VDD VSS sg13g2_decap_8
X_09886_ _14472_/D _10151_/A1 _14472_/Q _09895_/S VDD VSS sg13g2_mux2_1
XFILLER_100_831 VDD VSS sg13g2_decap_8
XFILLER_131_1013 VDD VSS sg13g2_fill_1
X_08837_ _08837_/X _10793_/A _10697_/B VDD VSS sg13g2_and2_1
XFILLER_18_609 VDD VSS sg13g2_decap_8
XFILLER_73_704 VDD VSS sg13g2_fill_2
XFILLER_58_789 VDD VSS sg13g2_decap_8
XFILLER_22_1352 VDD VSS sg13g2_decap_8
XFILLER_17_119 VDD VSS sg13g2_decap_8
X_08768_ _13674_/D _08728_/Y _08767_/Y _08766_/Y VDD VSS sg13g2_a21oi_1
XFILLER_73_759 VDD VSS sg13g2_decap_8
XFILLER_54_940 VDD VSS sg13g2_decap_4
X_07719_ _07719_/X _07720_/A _11288_/A VDD VSS sg13g2_or2_1
XFILLER_26_653 VDD VSS sg13g2_decap_8
XFILLER_122_88 VDD VSS sg13g2_decap_8
XFILLER_122_99 VDD VSS sg13g2_fill_2
X_08699_ _08699_/Y _08698_/X _08697_/Y _08696_/Y _08695_/Y VDD VSS sg13g2_a22oi_1
XFILLER_14_826 VDD VSS sg13g2_decap_8
XFILLER_41_612 VDD VSS sg13g2_fill_2
X_10730_ _10730_/Y _13064_/A _11048_/B VDD VSS sg13g2_nand2_1
XFILLER_0_1192 VDD VSS sg13g2_decap_8
XFILLER_13_336 VDD VSS sg13g2_decap_8
XFILLER_15_42 VDD VSS sg13g2_decap_8
XFILLER_25_196 VDD VSS sg13g2_decap_8
XFILLER_158_319 VDD VSS sg13g2_decap_8
X_10661_ _14892_/D _10661_/A _10661_/B _10661_/C VDD VSS sg13g2_nor3_1
XFILLER_139_511 VDD VSS sg13g2_fill_2
XFILLER_167_820 VDD VSS sg13g2_fill_2
XFILLER_9_329 VDD VSS sg13g2_decap_8
XFILLER_41_689 VDD VSS sg13g2_fill_1
XFILLER_16_1134 VDD VSS sg13g2_decap_8
X_12400_ _12400_/Y _12400_/A _12400_/B VDD VSS sg13g2_nand2_1
X_13380_ _13380_/Y _08723_/A _13307_/B _15080_/Q VDD VSS sg13g2_o21ai_1
X_10592_ _14874_/D _10599_/A _10592_/B _10607_/C VDD VSS sg13g2_nor3_1
XFILLER_107_1284 VDD VSS sg13g2_decap_8
XFILLER_127_706 VDD VSS sg13g2_decap_8
XFILLER_90_1096 VDD VSS sg13g2_decap_8
XFILLER_107_1295 VDD VSS sg13g2_fill_2
XFILLER_139_577 VDD VSS sg13g2_decap_8
X_12331_ _12331_/X _12324_/B _12330_/X _12329_/Y VDD VSS sg13g2_a21o_1
XFILLER_166_385 VDD VSS sg13g2_decap_8
XFILLER_31_63 VDD VSS sg13g2_decap_8
XFILLER_108_942 VDD VSS sg13g2_decap_8
X_15050_ _15050_/Q clkload52/A _15050_/D _15050_/RESET_B VDD VSS sg13g2_dfrbpq_1
X_12262_ _12263_/B _12251_/Y _12253_/X _11957_/A VDD VSS sg13g2_o21ai_1
XFILLER_5_546 VDD VSS sg13g2_decap_8
XFILLER_147_63 VDD VSS sg13g2_decap_8
XFILLER_147_74 VDD VSS sg13g2_fill_1
XFILLER_103_0 VDD VSS sg13g2_decap_8
X_14001_ _14001_/Q _14737_/CLK _14001_/D _14001_/RESET_B VDD VSS sg13g2_dfrbpq_1
X_11213_ _11213_/X _11212_/X _11878_/B1 _11329_/B1 VDD VSS sg13g2_a21o_1
XFILLER_141_219 VDD VSS sg13g2_decap_8
XFILLER_134_260 VDD VSS sg13g2_decap_8
X_12193_ _12193_/Y _12192_/Y _12182_/Y _12174_/Y _12164_/Y _12223_/A VDD VSS sg13g2_a221oi_1
Xclkbuf_leaf_90_clk_i _14894_/CLK clkbuf_leaf_92_clk_i/A VDD VSS sg13g2_buf_8
Xoutput41 mem_axi_araddr[12] _16865_/A VDD VSS sg13g2_buf_1
Xoutput52 mem_axi_araddr[23] _16876_/A VDD VSS sg13g2_buf_1
X_15243__3011 _15243_/RESET_B VDD VSS sg13g2_tiehi
X_11144_ _11144_/Y _11145_/A _11164_/B VDD VSS sg13g2_nor2_1
Xoutput63 mem_axi_araddr[4] _16857_/A VDD VSS sg13g2_buf_1
Xoutput74 mem_axi_awaddr[13] _16866_/X VDD VSS sg13g2_buf_1
Xoutput85 mem_axi_awaddr[24] _16877_/X VDD VSS sg13g2_buf_1
XFILLER_7_1302 VDD VSS sg13g2_decap_8
XFILLER_1_763 VDD VSS sg13g2_decap_8
XFILLER_122_477 VDD VSS sg13g2_decap_8
Xoutput96 mem_axi_awaddr[5] _16858_/X VDD VSS sg13g2_buf_1
XFILLER_95_317 VDD VSS sg13g2_decap_8
X_11075_ _11118_/B _11125_/A _11097_/A VDD VSS sg13g2_xnor2_1
XFILLER_49_723 VDD VSS sg13g2_decap_4
XFILLER_0_273 VDD VSS sg13g2_decap_8
XFILLER_163_84 VDD VSS sg13g2_decap_8
XFILLER_49_745 VDD VSS sg13g2_decap_4
XFILLER_48_211 VDD VSS sg13g2_decap_8
XFILLER_88_391 VDD VSS sg13g2_decap_8
XFILLER_27_1285 VDD VSS sg13g2_decap_8
X_14903_ _14903_/Q _15213_/CLK _14903_/D _14903_/RESET_B VDD VSS sg13g2_dfrbpq_1
X_10026_ _14608_/D _10092_/A0 _14608_/Q _10036_/S VDD VSS sg13g2_mux2_1
XFILLER_7_1379 VDD VSS sg13g2_fill_1
XFILLER_37_929 VDD VSS sg13g2_decap_8
XFILLER_64_726 VDD VSS sg13g2_decap_8
XFILLER_48_277 VDD VSS sg13g2_decap_8
X_14834_ _14834_/Q _15064_/CLK _14834_/D _14834_/RESET_B VDD VSS sg13g2_dfrbpq_1
XFILLER_76_597 VDD VSS sg13g2_decap_8
X_14473__1706 _14473_/RESET_B VDD VSS sg13g2_tiehi
XFILLER_5_1092 VDD VSS sg13g2_decap_8
XFILLER_56_93 VDD VSS sg13g2_fill_2
X_13859__2320 _13859_/RESET_B VDD VSS sg13g2_tiehi
X_14765_ _14765_/Q clkload71/A _14765_/D _14765_/RESET_B VDD VSS sg13g2_dfrbpq_1
X_11977_ _11977_/X _14915_/Q _11792_/B _11976_/Y VDD VSS sg13g2_a21o_1
XFILLER_72_770 VDD VSS sg13g2_fill_2
XFILLER_44_472 VDD VSS sg13g2_decap_8
XFILLER_17_686 VDD VSS sg13g2_decap_8
X_13716_ _16878_/A clkload41/A _13716_/D _13716_/RESET_B VDD VSS sg13g2_dfrbpq_1
XFILLER_32_623 VDD VSS sg13g2_decap_8
XFILLER_147_1053 VDD VSS sg13g2_decap_8
X_10928_ _14936_/D _10927_/Y _10926_/X _10914_/Y VDD VSS sg13g2_o21ai_1
X_14696_ _14696_/Q _14728_/CLK _14696_/D _14696_/RESET_B VDD VSS sg13g2_dfrbpq_1
XFILLER_16_196 VDD VSS sg13g2_decap_8
XFILLER_72_70 VDD VSS sg13g2_decap_8
XFILLER_34_1201 VDD VSS sg13g2_fill_2
X_13647_ _14750_/D _08721_/X _14750_/Q _13654_/S VDD VSS sg13g2_mux2_1
X_10859_ _10859_/Y _10898_/B1 _10857_/Y _10858_/Y VDD VSS sg13g2_a21oi_1
XFILLER_158_842 VDD VSS sg13g2_fill_2
Xclkbuf_leaf_43_clk_i _14721_/CLK clkbuf_leaf_43_clk_i/A VDD VSS sg13g2_buf_8
XFILLER_121_1204 VDD VSS sg13g2_fill_2
XFILLER_160_1253 VDD VSS sg13g2_decap_8
X_13578_ _13578_/Y _13578_/A _13584_/B VDD VSS sg13g2_nor2_1
XFILLER_157_352 VDD VSS sg13g2_decap_8
XFILLER_118_728 VDD VSS sg13g2_fill_1
XFILLER_121_1237 VDD VSS sg13g2_decap_4
XFILLER_160_1286 VDD VSS sg13g2_fill_2
X_12529_ _12529_/X _14120_/Q _14152_/Q _14184_/Q _14216_/Q _12674_/S0 _12674_/S1 VDD
+ VSS sg13g2_mux4_1
XFILLER_9_896 VDD VSS sg13g2_decap_8
XFILLER_117_238 VDD VSS sg13g2_decap_4
XFILLER_133_709 VDD VSS sg13g2_decap_8
X_15248_ _15248_/Q clkload58/A _15248_/D _15248_/RESET_B VDD VSS sg13g2_dfrbpq_1
XFILLER_173_878 VDD VSS sg13g2_fill_2
XFILLER_119_1100 VDD VSS sg13g2_fill_2
Xclkbuf_leaf_58_clk_i clkload70/A clkbuf_leaf_61_clk_i/A VDD VSS sg13g2_buf_8
XFILLER_141_720 VDD VSS sg13g2_decap_4
X_13961__2218 _13961_/RESET_B VDD VSS sg13g2_tiehi
X_15179_ _15179_/Q clkload66/A _15179_/D _15179_/RESET_B VDD VSS sg13g2_dfrbpq_1
XFILLER_153_591 VDD VSS sg13g2_decap_8
XFILLER_114_967 VDD VSS sg13g2_fill_2
XFILLER_98_133 VDD VSS sg13g2_decap_8
XFILLER_154_1035 VDD VSS sg13g2_fill_2
Xfanout308 _10156_/S _10163_/S VDD VSS sg13g2_buf_1
Xfanout319 _09969_/S wire320/X VDD VSS sg13g2_buf_1
XFILLER_99_678 VDD VSS sg13g2_decap_4
XFILLER_67_1098 VDD VSS sg13g2_decap_8
XFILLER_59_509 VDD VSS sg13g2_fill_2
XFILLER_114_989 VDD VSS sg13g2_decap_8
XFILLER_115_1008 VDD VSS sg13g2_decap_8
XFILLER_154_1068 VDD VSS sg13g2_decap_8
XFILLER_86_317 VDD VSS sg13g2_decap_8
X_09740_ _09769_/S _09938_/D _09740_/B VDD VSS sg13g2_nor2_1
XFILLER_101_639 VDD VSS sg13g2_decap_8
XFILLER_80_1243 VDD VSS sg13g2_decap_8
.ends
